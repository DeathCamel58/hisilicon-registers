`ifndef EHI3516DV300_PMC_RDL
`define EHI3516DV300_PMC_RDL
regfile eHI3516DV300_PMC {
    name = "Power management controller (PMC)";
    desc = "Power management controller (PMC). 4 registers extracted programmatically from the Hi3516D V300 Professional Smart IP Camera SoC data sheet (Issue 01, 2019-09-12); chapter 3.10.2.3, table 3-18. Field names, bit ranges, access types and reset values are taken from the register tables; reset values are the data sheet total reset values split onto the fields (per-field values where the table has them). Label: PROVEN. Hardware not verified here (no board).";
    reg {
        name = "PWR_CTRL0";
        desc = "PWR_CTRL0 is PWR control register 0. PWR_CTRL0 (offset 0x000, total reset 0x0001_0160; PROVEN: Hi3516D V300 data sheet, PDF page 258, section 3.10.2.3).";
        field {
            name = "reserved";
            desc = "Reserved";
            sw = r; hw = na;
            reset = 0x0;
        } reserved_31_29[31:29];
        field {
            name = "high_adj_startup_en";
            desc = "Effective time adjustment control of the startup pin
- 0: controlled by the high_adj_startup_time register
- 1: fixed at 200 ms";
            sw = rw; hw = r;
            reset = 0x0;
        } high_adj_startup_en[28:28];
        field {
            name = "high_adj_startup_time";
            desc = "Effective time adjustment value of the startup pin (unit: 100 ms). The effective value is the configured value plus 1.";
            sw = rw; hw = r;
            reset = 0x1;
        } high_adj_startup_time[27:20];
        field {
            name = "reserved";
            desc = "Reserved";
            sw = r; hw = na;
            reset = 0x0;
        } reserved_19_17[19:17];
        field {
            name = "high_adj_button_en";
            desc = "Effective time adjustment control of the button pin
- 0: controlled by the high_adj_button_time register
- 1: fixed at 200 ms";
            sw = rw; hw = r;
            reset = 0x0;
        } high_adj_button_en[16:16];
        field {
            name = "high_adj_button_time";
            desc = "Effective time adjustment value of the button pin (unit: 100 ms). The effective value is the configured value plus 1.";
            sw = rw; hw = r;
            reset = 0x1;
        } high_adj_button_time[15:8];
        field {
            name = "gpio_at_pmc_enable";
            desc = "Enable of GPIO pin multiplexing for the PMC domain
- 0: disabled
- 1: enabled";
            sw = rw; hw = r;
            reset = 0x0;
        } gpio_at_pmc_enable[7:7];
        field {
            name = "wakeup_mask";
            desc = "Wakeup mask
- 0: not masked
- 1: masked";
            sw = rw; hw = r;
            reset = 0x1;
        } wakeup_mask[6:6];
        field {
            name = "rtc_int_mask";
            desc = "RTC interrupt wakeup mask
- 0: not masked
- 1: masked";
            sw = rw; hw = r;
            reset = 0x1;
        } rtc_int_mask[5:5];
        field {
            name = "wakeup_act_mode";
            desc = "Wakeup valid mode select
- 00: active on the rising edge
- 01: active on the falling edge
- 10: active high
- 11: active low";
            sw = rw; hw = r;
            reset = 0x0;
        } wakeup_act_mode[4:3];
        field {
            name = "pwr_pen";
            desc = "pwr_pen0 output control
- 0: Output 0.
- 1: Output 1.";
            sw = rw; hw = r;
            reset = 0x0;
        } pwr_pen[2:2];
        field {
            name = "start_powerdown";
            desc = "Power-down process start";
            sw = w; hw = r;
            reset = 0x0;
        } start_powerdown[1:1];
        field {
            name = "reserved";
            desc = "Reserved";
            sw = r; hw = na;
            reset = 0x0;
        } reserved_0_0[0:0];
    } PWR_CTRL0 @ 0x0;
    reg {
        name = "PWR_CTRL1";
        desc = "PWR_CTRL1 is PWR control register 1. PWR_CTRL1 (offset 0x004, total reset 0x1010_1010; PROVEN: Hi3516D V300 data sheet, PDF page 259, section 3.10.2.3).";
        field {
            name = "Powertimingparameter3Unit:mspwr_td30:invalid1:valid";
            desc = "";
            sw = rw; hw = r;
            reset = 0x10;
        } Powertimingparameter3Unit_mspwr_td30_invalid1_valid[31:24];
        field {
            name = "Powertimingparameter1Unit:mspwr_td20:invalid1:valid";
            desc = "";
            sw = rw; hw = r;
            reset = 0x10;
        } Powertimingparameter1Unit_mspwr_td20_invalid1_valid[23:16];
        field {
            name = "Powertimingparameter1Unit:mspwr_td10:invalid1:valid";
            desc = "";
            sw = rw; hw = r;
            reset = 0x10;
        } Powertimingparameter1Unit_mspwr_td10_invalid1_valid[15:8];
        field {
            name = "Powertimingparameter0Unit:mspwr_td00:invalid1:valid";
            desc = "";
            sw = rw; hw = r;
            reset = 0x10;
        } Powertimingparameter0Unit_mspwr_td00_invalid1_valid[7:0];
    } PWR_CTRL1 @ 0x4;
    reg {
        name = "PWR_STATUS";
        desc = "PWR_STATUS is a PWR status register. PWR_STATUS (offset 0x008, total reset 0x0000_0000; PROVEN: Hi3516D V300 data sheet, PDF page 260, section 3.10.2.3).";
        field {
            name = "reserved";
            desc = "Reserved";
            sw = r; hw = na;
            reset = 0x0;
        } reserved_31_9[31:9];
        field {
            name = "wakeup_in";
            desc = "Input of the PWR_WAKEUP pin";
            sw = r; hw = w;
            reset = 0x0;
        } wakeup_in[8:8];
        field {
            name = "button_in";
            desc = "Input of the PWR_BUTTON pin";
            sw = r; hw = w;
            reset = 0x0;
        } button_in[7:7];
        field {
            name = "wakeup_source";
            desc = "Wakeup source bit0: WAKEUP bit1: reserved bit2: STARTUP bit3: BUTTON bit4: RTC";
            sw = r; hw = w;
            reset = 0x0;
        } wakeup_source[6:2];
        field {
            name = "reserved";
            desc = "Reserved";
            sw = r; hw = na;
            reset = 0x0;
        } reserved_1_1[1:1];
        field {
            name = "reserved";
            desc = "Reserved";
            sw = r; hw = na;
            reset = 0x0;
        } reserved_0_0[0:0];
    } PWR_STATUS @ 0x8;
    reg {
        name = "PWR_PD_SEL";
        desc = "PWR_PD_SEL is a power-off sequence control register. PWR_PD_SEL (offset 0x00C, total reset 0x0000_0000; PROVEN: Hi3516D V300 data sheet, PDF page 260, section 3.10.2.3).";
        field {
            name = "reserved";
            desc = "Reserved";
            sw = r; hw = na;
            reset = 0x0;
        } reserved_31_3[31:3];
        field {
            name = "pd_seq_mode_sel";
            desc = "Power-off sequence select
- 0: mode 1. The power-off sequence is SEQ0 -> SEQ1.
- 1: mode 2. The power-off sequence is SEQ1 -> SEQ0.

Other values: reserved";
            sw = rw; hw = r;
            reset = 0x0;
        } pd_seq_mode_sel[2:0];
    } PWR_PD_SEL @ 0xc;
};

`endif
