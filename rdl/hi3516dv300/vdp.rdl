`ifndef EHI3516DV300_VDP_RDL
`define EHI3516DV300_VDP_RDL
regfile eHI3516DV300_VDP {
    name = "Video display processor (VDP)";
    desc = "Video display processor (VDP). 123 registers extracted programmatically from the Hi3516D V300 Professional Smart IP Camera SoC data sheet (Issue 01, 2019-09-12); chapter 9.2.6, table 9-5. Field names, bit ranges, access types and reset values are taken from the register tables; reset values are the data sheet total reset values split onto the fields (per-field values where the table has them). Label: PROVEN. Hardware not verified here (no board).";
    reg {
        name = "VOCTRL";
        desc = "VOCTRL is a VDP control register. VOCTRL (offset 0x0000, total reset 0x0000_0000; PROVEN: Hi3516D V300 data sheet, PDF page 557, section 9.2.6).";
        field {
            name = "vo_ck_gt_en";
            desc = "VDP clock gating enable, that is, low power consumption mode
- 0: disabled
- 1: enabled";
            sw = rw; hw = r;
            reset = 0x0;
        } vo_ck_gt_en[31:31];
        field {
            name = "reserved";
            desc = "Reserved";
            sw = r; hw = na;
            reset = 0x0;
        } reserved_30_0[30:0];
    } VOCTRL @ 0x0;
    reg {
        name = "VOINTSTA";
        desc = "VOINTSTA is a VDP interrupt status register. VOINTSTA (offset 0x0004, total reset 0x0000_0044; PROVEN: Hi3516D V300 data sheet, PDF page 557, section 9.2.6).";
        field {
            name = "reserved";
            desc = "Reserved";
            sw = r; hw = na;
            reset = 0x0;
        } reserved_31_4[31:4];
        field {
            name = "dhd0uf_int";
            desc = "HD0 low-bandwidth alarm interrupt
- 0: No interrupt is reported.
- 1: An interrupt is reported.";
            sw = r; hw = w;
            reset = 0x0;
        } dhd0uf_int[3:3];
        field {
            name = "reserved";
            desc = "Reserved";
            sw = r; hw = na;
            reset = 0x1;
        } reserved_2_2[2:2];
        field {
            name = "reserved";
            desc = "Reserved";
            sw = r; hw = na;
            reset = 0x0;
        } reserved_1_1[1:1];
        field {
            name = "dhd0vtthd1_int";
            desc = "HD0 vertical timing interrupt 1
- 0: No interrupt is reported.
- 1: An interrupt is reported.";
            sw = r; hw = w;
            reset = 0x0;
        } dhd0vtthd1_int[0:0];
    } VOINTSTA @ 0x4;
    reg {
        name = "VOMSKINTSTA";
        desc = "VOMSKINTSTA is a VO masked interrupt status register. Writing 1 clears this register. VOMSKINTSTA (offset 0x0008, total reset 0x0000_0000; PROVEN: Hi3516D V300 data sheet, PDF page 558, section 9.2.6).";
        field {
            name = "reserved";
            desc = "Reserved";
            sw = r; hw = na;
            reset = 0x0;
        } reserved_31_4[31:4];
        field {
            name = "dhd0uf_clr";
            desc = "HD0 low-bandwidth alarm interrupt
- 0: No interrupt is reported.
- 1: An interrupt is reported. (data sheet access type WC)";
            sw = rw; hw = r; onwrite = woclr;
            reset = 0x0;
        } dhd0uf_clr[3:3];
        field {
            name = "reserved";
            desc = "Reserved";
            sw = r; hw = na;
            reset = 0x0;
        } reserved_2_2[2:2];
        field {
            name = "reserved";
            desc = "Reserved";
            sw = r; hw = na;
            reset = 0x0;
        } reserved_1_1[1:1];
        field {
            name = "dhd0vtthd1_clr";
            desc = "HD0 vertical timing interrupt 1
- 0: No interrupt is reported.
- 1: An interrupt is reported. (data sheet access type WC)";
            sw = rw; hw = r; onwrite = woclr;
            reset = 0x0;
        } dhd0vtthd1_clr[0:0];
    } VOMSKINTSTA @ 0x8;
    reg {
        name = "VOINTMSK";
        desc = "VOINTMSK is a VDP interrupt mask register. It corresponds to VOINTSTA. When the corresponding bit is set to 1, the interrupt is enabled; when the corresponding bit is set to 0, the interrupt is masked. VOINTMSK (offset 0x000C, total reset 0x0000_0000; PROVEN: Hi3516D V300 data sheet, PDF page 558, section 9.2.6).";
        field {
            name = "reserved";
            desc = "Reserved";
            sw = r; hw = na;
            reset = 0x0;
        } reserved_31_4[31:4];
        field {
            name = "dhd0uf_intmask";
            desc = "Mask for the HD0 low-bandwidth alarm";
            sw = rw; hw = r;
            reset = 0x0;
        } dhd0uf_intmask[3:3];
        field {
            name = "reserved";
            desc = "Reserved";
            sw = r; hw = na;
            reset = 0x0;
        } reserved_2_2[2:2];
        field {
            name = "reserved";
            desc = "Reserved";
            sw = r; hw = na;
            reset = 0x0;
        } reserved_1_1[1:1];
        field {
            name = "dhd0vtthd1_intmask";
            desc = "Mask for the HD0 vertical timing interrupt 1
- 0: masked
- 1: enabled";
            sw = rw; hw = r;
            reset = 0x0;
        } dhd0vtthd1_intmask[0:0];
    } VOINTMSK @ 0xc;
    reg {
        name = "VOINTSTA1";
        desc = "VOINTSTA1 is a VDP interrupt status register 1. VOINTSTA1 (offset 0x0014, total reset 0x0000_0044; PROVEN: Hi3516D V300 data sheet, PDF page 559, section 9.2.6).";
        field {
            name = "reserved";
            desc = "Reserved";
            sw = r; hw = na;
            reset = 0x0;
        } reserved_31_4[31:4];
        field {
            name = "dhd0uf_int";
            desc = "HD0 low-bandwidth alarm interrupt
- 0: No interrupt is reported.
- 1: An interrupt is reported.";
            sw = r; hw = w;
            reset = 0x0;
        } dhd0uf_int[3:3];
        field {
            name = "reserved";
            desc = "Reserved";
            sw = r; hw = na;
            reset = 0x1;
        } reserved_2_2[2:2];
        field {
            name = "reserved";
            desc = "Reserved";
            sw = r; hw = na;
            reset = 0x0;
        } reserved_1_1[1:1];
        field {
            name = "dhd0vtthd1_int";
            desc = "HD0 vertical timing interrupt 1
- 0: No interrupt is reported.
- 1: An interrupt is reported.";
            sw = r; hw = w;
            reset = 0x0;
        } dhd0vtthd1_int[0:0];
    } VOINTSTA1 @ 0x14;
    reg {
        name = "VOMSKINTSTA1";
        desc = "VOMSKINTSTA1 is a VDP masked offline interrupt status register 1. Writing 1 clears this register. VOMSKINTSTA1 (offset 0x0018, total reset 0x0000_0000; PROVEN: Hi3516D V300 data sheet, PDF page 559, section 9.2.6).";
        field {
            name = "reserved";
            desc = "Reserved";
            sw = r; hw = na;
            reset = 0x0;
        } reserved_31_4[31:4];
        field {
            name = "dhd0uf_clr";
            desc = "HD0 low-bandwidth alarm interrupt
- 0: No interrupt is reported.
- 1: An interrupt is reported. (data sheet access type WC)";
            sw = rw; hw = r; onwrite = woclr;
            reset = 0x0;
        } dhd0uf_clr[3:3];
        field {
            name = "reserved";
            desc = "Reserved";
            sw = r; hw = na;
            reset = 0x0;
        } reserved_2_2[2:2];
        field {
            name = "reserved";
            desc = "Reserved";
            sw = r; hw = na;
            reset = 0x0;
        } reserved_1_1[1:1];
        field {
            name = "dhd0vtthd1_clr";
            desc = "HD0 vertical timing interrupt 1
- 0: No interrupt is reported.
- 1: An interrupt is reported. (data sheet access type WC)";
            sw = rw; hw = r; onwrite = woclr;
            reset = 0x0;
        } dhd0vtthd1_clr[0:0];
    } VOMSKINTSTA1 @ 0x18;
    reg {
        name = "VOINTMSK1";
        desc = "VOINTMSK1 is a VDP interrupt mask register 1. It corresponds to VOINTSTA. VOINTMSK1 (offset 0x001C, total reset 0x0000_0000; PROVEN: Hi3516D V300 data sheet, PDF page 560, section 9.2.6).";
        field {
            name = "reserved";
            desc = "Reserved";
            sw = r; hw = na;
            reset = 0x0;
        } reserved_31_4[31:4];
        field {
            name = "dhd0uf_intmask";
            desc = "Mask for the HD0 low-bandwidth alarm interrupt
- 0: masked
- 1: enabled";
            sw = rw; hw = r;
            reset = 0x0;
        } dhd0uf_intmask[3:3];
        field {
            name = "reserved";
            desc = "Reserved";
            sw = r; hw = na;
            reset = 0x0;
        } reserved_2_2[2:2];
        field {
            name = "reserved";
            desc = "Reserved";
            sw = r; hw = na;
            reset = 0x0;
        } reserved_1_1[1:1];
        field {
            name = "dhd0vtthd1_intmask";
            desc = "Mask for the HD0 vertical timing interrupt 1
- 0: masked
- 1: enabled";
            sw = rw; hw = r;
            reset = 0x0;
        } dhd0vtthd1_intmask[0:0];
    } VOINTMSK1 @ 0x1c;
    reg {
        name = "CBM_BKG1";
        desc = "CBM_BKG1 is a CBM mixer 1 overlay background color register. CBM_BKG1 (offset 0x0300, total reset 0x0000_0000; PROVEN: Hi3516D V300 data sheet, PDF page 560, section 9.2.6).";
        field {
            name = "reserved";
            desc = "Reserved";
            sw = r; hw = na;
            reset = 0x0;
        } reserved_31_30[31:30];
        field {
            name = "cbm_bkgy1";
            desc = "Overlay background color of CBM mixer 1, Y component";
            sw = rw; hw = r;
            reset = 0x0;
        } cbm_bkgy1[29:20];
        field {
            name = "cbm_bkgcb1";
            desc = "Overlay background color of CBM mixer 1, Cb component";
            sw = rw; hw = r;
            reset = 0x0;
        } cbm_bkgcb1[19:10];
        field {
            name = "cbm_bkgcr1";
            desc = "Overlay background color of CBM mixer 1, Cr component";
            sw = rw; hw = r;
            reset = 0x0;
        } cbm_bkgcr1[9:0];
    } CBM_BKG1 @ 0x300;
    reg {
        name = "CBM_MIX1";
        desc = "CBM_MIX2 is a CBM mixer 1 priority configuration register (instant register). The register configuration takes effect only when the vsync signal is valid. mixer_prio_x is overlay layer priority x. CBM_MIX1 (offset 0x0308, total reset 0x0000_0001; PROVEN: Hi3516D V300 data sheet, PDF page 561, section 9.2.6).";
        field {
            name = "reserved";
            desc = "Reserved";
            sw = r; hw = na;
            reset = 0x0;
        } reserved_31_8[31:8];
        field {
            name = "mixer_prio1";
            desc = "Drive layer of CBM mixer 1 with priority 1
- 0x0: no drive layer
- 0x1: V0
- 0x2: G0

Other values: reserved";
            sw = rw; hw = r;
            reset = 0x0;
        } mixer_prio1[7:4];
        field {
            name = "mixer_prio0";
            desc = "Drive layer of CBM mixer 1 with priority 0
- 0x0: no drive layer
- 0x1: V0
- 0x2: G0

Other values: reserved";
            sw = rw; hw = r;
            reset = 0x1;
        } mixer_prio0[3:0];
    } CBM_MIX1 @ 0x308;
    reg {
        name = "V0_CTRL";
        desc = "V0_CTRL is a V0 configuration register (non-instant register). V0_CTRL (offset 0x1000, total reset 0x4000_00FF; PROVEN: Hi3516D V300 data sheet, PDF page 561, section 9.2.6).";
        field {
            name = "surface_en";
            desc = "Surface enable (non-instant)
- 0: disabled
- 1: enabled";
            sw = rw; hw = r;
            reset = 0x0;
        } surface_en[31:31];
        field {
            name = "reserved";
            desc = "Reserved";
            sw = r; hw = na;
            reset = 0x1;
        } reserved_30_30[30:30];
        field {
            name = "reserved";
            desc = "Reserved";
            sw = r; hw = na;
            reset = 0x0;
        } reserved_29_8[29:8];
        field {
            name = "galpha";
            desc = "Overlay global alpha value. The value ranges from 0 to 255. The value 255 indicates opaque, and the value 0 indicates completely transparent.";
            sw = rw; hw = r;
            reset = 0xff;
        } galpha[7:0];
    } V0_CTRL @ 0x1000;
    reg {
        name = "V0_UPD";
        desc = "V0_UPD is a V0 channel update enable register. V0_UPD (offset 0x1004, total reset 0x0000_0000; PROVEN: Hi3516D V300 data sheet, PDF page 562, section 9.2.6).";
        field {
            name = "reserved";
            desc = "Reserved";
            sw = r; hw = na;
            reset = 0x0;
        } reserved_31_1[31:1];
        field {
            name = "regup";
            desc = "Surface register update. After the registers at this layer are configured, the registers are updated when the value 1 is written to this bit. After the registers are updated, this bit is automatically cleared by the hardware. (data sheet access type WC)";
            sw = rw; hw = r; onwrite = woclr;
            reset = 0x0;
        } regup[0:0];
    } V0_UPD @ 0x1004;
    reg {
        name = "V0_0RESO_READ";
        desc = "V0_0RESO_READ is a V0 output resolution read register. V0_0RESO_READ (offset 0x1008, total reset 0x0000_0000; PROVEN: Hi3516D V300 data sheet, PDF page 562, section 9.2.6).";
        field {
            name = "oh";
            desc = "Height (in lines). The configured value is the actual height minus 1. The frame height is referenced and its unit is line.";
            sw = r; hw = w;
            reset = 0x0;
        } oh[31:16];
        field {
            name = "ow";
            desc = "Width (in pixels). The configured value is the actual width minus 1. The frame width is referenced and its unit is column.";
            sw = r; hw = w;
            reset = 0x0;
        } ow[15:0];
    } V0_0RESO_READ @ 0x1008;
    reg {
        name = "V0_DFPOS";
        desc = "V0_DFPOS is a V0 surface first position (in the display window) register (non-instant register). The unit of the position is pixel. V0_DFPOS (offset 0x1080, total reset 0x0000_0000; PROVEN: Hi3516D V300 data sheet, PDF page 562, section 9.2.6).";
        field {
            name = "disp_yfpos";
            desc = "Start coordinates of the display row The frame height is referenced and its unit is line.";
            sw = rw; hw = r;
            reset = 0x0;
        } disp_yfpos[31:16];
        field {
            name = "disp_xfpos";
            desc = "Start coordinates of the display column The frame width is referenced and its unit is column.";
            sw = rw; hw = r;
            reset = 0x0;
        } disp_xfpos[15:0];
    } V0_DFPOS @ 0x1080;
    reg {
        name = "V0_DLPOS";
        desc = "V0_DLPOS is a V0 surface last position (in the display window) register (non-instant register). The unit of the position is pixel. V0_DLPOS (offset 0x1084, total reset 0x0000_0000; PROVEN: Hi3516D V300 data sheet, PDF page 563, section 9.2.6).";
        field {
            name = "disp_ylpos";
            desc = "End coordinates of the display row The frame height is referenced and its unit is line.";
            sw = rw; hw = r;
            reset = 0x0;
        } disp_ylpos[31:16];
        field {
            name = "disp_xlpos";
            desc = "End coordinates of the display column The frame width is referenced and its unit is column.";
            sw = rw; hw = r;
            reset = 0x0;
        } disp_xlpos[15:0];
    } V0_DLPOS @ 0x1084;
    reg {
        name = "V0_VFPOS";
        desc = "V0_VFPOS is a V0 surface content first position (in the display window) register (non-instant register). The unit of the position is pixel. V0_VFPOS (offset 0x1088, total reset 0x0000_0000; PROVEN: Hi3516D V300 data sheet, PDF page 563, section 9.2.6).";
        field {
            name = "video_yfpos";
            desc = "Start coordinates of the video row The frame height is referenced and its unit is line.";
            sw = rw; hw = r;
            reset = 0x0;
        } video_yfpos[31:16];
        field {
            name = "video_xfpos";
            desc = "Start coordinates of the video column The frame width is referenced and its unit is column.";
            sw = rw; hw = r;
            reset = 0x0;
        } video_xfpos[15:0];
    } V0_VFPOS @ 0x1088;
    reg {
        name = "V0_VLPOS";
        desc = "V0_VLPOS is a V0 surface content last position (in the display window) register (non-instant register). The unit of the position is pixel. V0_VLPOS (offset 0x108C, total reset 0x0000_0000; PROVEN: Hi3516D V300 data sheet, PDF page 563, section 9.2.6).";
        field {
            name = "video_ylpos";
            desc = "End coordinates of the video row The frame height is referenced and its unit is line.";
            sw = rw; hw = r;
            reset = 0x0;
        } video_ylpos[31:16];
        field {
            name = "video_xlpos";
            desc = "End coordinates of the video column The frame width is referenced and its unit is column.";
            sw = rw; hw = r;
            reset = 0x0;
        } video_xlpos[15:0];
    } V0_VLPOS @ 0x108c;
    reg {
        name = "V0_BK";
        desc = "V0_BK is a surface background color register. V0_BK (offset 0x1090, total reset 0x0000_0000; PROVEN: Hi3516D V300 data sheet, PDF page 564, section 9.2.6).";
        field {
            name = "reserved";
            desc = "Reserved";
            sw = r; hw = na;
            reset = 0x0;
        } reserved_31_30[31:30];
        field {
            name = "vbk_y";
            desc = "Y component";
            sw = rw; hw = r;
            reset = 0x0;
        } vbk_y[29:20];
        field {
            name = "vbk_cb";
            desc = "Cb component";
            sw = rw; hw = r;
            reset = 0x0;
        } vbk_cb[19:10];
        field {
            name = "vbk_cr";
            desc = "Cr component";
            sw = rw; hw = r;
            reset = 0x0;
        } vbk_cr[9:0];
    } V0_BK @ 0x1090;
    reg {
        name = "V0_ALPHA";
        desc = "V0_ALPHA is a surface background filling color alpha register. V0_ALPHA (offset 0x1094, total reset 0x0000_0000; PROVEN: Hi3516D V300 data sheet, PDF page 564, section 9.2.6).";
        field {
            name = "reserved";
            desc = "Reserved";
            sw = r; hw = na;
            reset = 0x0;
        } reserved_31_8[31:8];
        field {
            name = "vbk_alpha";
            desc = "Level 0–255 of the surface background filling color";
            sw = rw; hw = r;
            reset = 0x0;
        } vbk_alpha[7:0];
    } V0_ALPHA @ 0x1094;
    reg {
        name = "V0_RIMWIDTH";
        desc = "V0_RIMWIDTH is a V0 RIM width register (non-instant register). V0_RIMWIDTH (offset 0x10A0, total reset 0x0000_0000; PROVEN: Hi3516D V300 data sheet, PDF page 564, section 9.2.6).";
        field {
            name = "reserved";
            desc = "Reserved";
            sw = r; hw = na;
            reset = 0x0;
        } reserved_31_5[31:5];
        field {
            name = "v0_rim_width";
            desc = "Thickness of all the region rims";
            sw = rw; hw = r;
            reset = 0x0;
        } v0_rim_width[4:0];
    } V0_RIMWIDTH @ 0x10a0;
    reg {
        name = "V0_RIMCOL0";
        desc = "V0_RIMCOL0 is a V0 rim color 0 register (non-instant register) at the video layer. V0_RIMCOL0 (offset 0x10A4, total reset 0x0000_0000; PROVEN: Hi3516D V300 data sheet, PDF page 564, section 9.2.6).";
        field {
            name = "reserved";
            desc = "Reserved";
            sw = r; hw = na;
            reset = 0x0;
        } reserved_31_30[31:30];
        field {
            name = "v0_rim_y0";
            desc = "Rim color 0, R component";
            sw = rw; hw = r;
            reset = 0x0;
        } v0_rim_y0[29:20];
        field {
            name = "v0_rim_u0";
            desc = "Rim color 0, G component";
            sw = rw; hw = r;
            reset = 0x0;
        } v0_rim_u0[19:10];
        field {
            name = "v0_rim_v0";
            desc = "Rim color 0, B component";
            sw = rw; hw = r;
            reset = 0x0;
        } v0_rim_v0[9:0];
    } V0_RIMCOL0 @ 0x10a4;
    reg {
        name = "V0_RIMCOL1";
        desc = "V0_RIMCOL1 is a V0 rim color 1 register (non-instant register) at the video layer. V0_RIMCOL1 (offset 0x10A8, total reset 0x0000_0000; PROVEN: Hi3516D V300 data sheet, PDF page 565, section 9.2.6).";
        field {
            name = "reserved";
            desc = "Reserved";
            sw = r; hw = na;
            reset = 0x0;
        } reserved_31_30[31:30];
        field {
            name = "v0_rim_y1";
            desc = "Rim color 1, R component";
            sw = rw; hw = r;
            reset = 0x0;
        } v0_rim_y1[29:20];
        field {
            name = "v0_rim_u1";
            desc = "Rim color 1, G component";
            sw = rw; hw = r;
            reset = 0x0;
        } v0_rim_u1[19:10];
        field {
            name = "v0_rim_v1";
            desc = "Rim color 1, B component";
            sw = rw; hw = r;
            reset = 0x0;
        } v0_rim_v1[9:0];
    } V0_RIMCOL1 @ 0x10a8;
    reg {
        name = "V0_HIPP_CSC_CTRL";
        desc = "V0_HIPP_CSC_CTRL is a CSC control register. V0_HIPP_CSC_CTRL (offset 0x1200, total reset 0x0000_0000; PROVEN: Hi3516D V300 data sheet, PDF page 565, section 9.2.6).";
        field {
            name = "reserved";
            desc = "Reserved";
            sw = r; hw = na;
            reset = 0x0;
        } reserved_31_1[31:1];
        field {
            name = "hipp_csc_en";
            desc = "HIPP CSC enable
- 0: disabled
- 1: enabled";
            sw = rw; hw = r;
            reset = 0x0;
        } hipp_csc_en[0:0];
    } V0_HIPP_CSC_CTRL @ 0x1200;
    reg {
        name = "V0_HIPP_CSC_COEF00";
        desc = "V0_HIPP_CSC_COEF00 is CSC coefficient register 00. V0_HIPP_CSC_COEF00 (offset 0x1204, total reset 0x0000_0000; PROVEN: Hi3516D V300 data sheet, PDF page 565, section 9.2.6).";
        field {
            name = "reserved";
            desc = "Reserved";
            sw = r; hw = na;
            reset = 0x0;
        } reserved_31_16[31:16];
        field {
            name = "hipp_csc_coef00";
            desc = "Signed bit, s1.14";
            sw = rw; hw = r;
            reset = 0x0;
        } hipp_csc_coef00[15:0];
    } V0_HIPP_CSC_COEF00 @ 0x1204;
    reg {
        name = "V0_HIPP_CSC_COEF01";
        desc = "V0_HIPP_CSC_COEF01 is CSC coefficient register 01. V0_HIPP_CSC_COEF01 (offset 0x1208, total reset 0x0000_0000; PROVEN: Hi3516D V300 data sheet, PDF page 566, section 9.2.6).";
        field {
            name = "reserved";
            desc = "Reserved";
            sw = r; hw = na;
            reset = 0x0;
        } reserved_31_16[31:16];
        field {
            name = "hipp_csc_coef01";
            desc = "Signed bit, s1.14";
            sw = rw; hw = r;
            reset = 0x0;
        } hipp_csc_coef01[15:0];
    } V0_HIPP_CSC_COEF01 @ 0x1208;
    reg {
        name = "V0_HIPP_CSC_COEF02";
        desc = "V0_HIPP_CSC_COEF02 is CSC coefficient register 02. V0_HIPP_CSC_COEF02 (offset 0x120C, total reset 0x0000_0000; PROVEN: Hi3516D V300 data sheet, PDF page 566, section 9.2.6).";
        field {
            name = "reserved";
            desc = "Reserved";
            sw = r; hw = na;
            reset = 0x0;
        } reserved_31_16[31:16];
        field {
            name = "hipp_csc_coef02";
            desc = "Signed bit, s1.14";
            sw = rw; hw = r;
            reset = 0x0;
        } hipp_csc_coef02[15:0];
    } V0_HIPP_CSC_COEF02 @ 0x120c;
    reg {
        name = "V0_HIPP_CSC_COEF10";
        desc = "V0_HIPP_CSC_COEF10 is CSC coefficient register 10. V0_HIPP_CSC_COEF10 (offset 0x1210, total reset 0x0000_0000; PROVEN: Hi3516D V300 data sheet, PDF page 566, section 9.2.6).";
        field {
            name = "reserved";
            desc = "Reserved";
            sw = r; hw = na;
            reset = 0x0;
        } reserved_31_16[31:16];
        field {
            name = "hipp_csc_coef10";
            desc = "Signed bit, s1.14";
            sw = rw; hw = r;
            reset = 0x0;
        } hipp_csc_coef10[15:0];
    } V0_HIPP_CSC_COEF10 @ 0x1210;
    reg {
        name = "V0_HIPP_CSC_COEF11";
        desc = "V0_HIPP_CSC_COEF11 is CSC coefficient register 11. V0_HIPP_CSC_COEF11 (offset 0x1214, total reset 0x0000_0000; PROVEN: Hi3516D V300 data sheet, PDF page 566, section 9.2.6).";
        field {
            name = "reserved";
            desc = "Reserved";
            sw = r; hw = na;
            reset = 0x0;
        } reserved_31_16[31:16];
        field {
            name = "hipp_csc_coef11";
            desc = "Signed bit, s1.14";
            sw = rw; hw = r;
            reset = 0x0;
        } hipp_csc_coef11[15:0];
    } V0_HIPP_CSC_COEF11 @ 0x1214;
    reg {
        name = "V0_HIPP_CSC_COEF12";
        desc = "V0_HIPP_CSC_COEF12 is CSC coefficient register 12. V0_HIPP_CSC_COEF12 (offset 0x1218, total reset 0x0000_0000; PROVEN: Hi3516D V300 data sheet, PDF page 567, section 9.2.6).";
        field {
            name = "reserved";
            desc = "Reserved";
            sw = r; hw = na;
            reset = 0x0;
        } reserved_31_16[31:16];
        field {
            name = "hipp_csc_coef12";
            desc = "Signed bit, s1.14";
            sw = rw; hw = r;
            reset = 0x0;
        } hipp_csc_coef12[15:0];
    } V0_HIPP_CSC_COEF12 @ 0x1218;
    reg {
        name = "V0_HIPP_CSC_COEF20";
        desc = "V0_HIPP_CSC_COEF20 is CSC coefficient register 20. V0_HIPP_CSC_COEF20 (offset 0x121C, total reset 0x0000_0000; PROVEN: Hi3516D V300 data sheet, PDF page 567, section 9.2.6).";
        field {
            name = "reserved";
            desc = "Reserved";
            sw = r; hw = na;
            reset = 0x0;
        } reserved_31_16[31:16];
        field {
            name = "hipp_csc_coef20";
            desc = "Signed bit, s1.14";
            sw = rw; hw = r;
            reset = 0x0;
        } hipp_csc_coef20[15:0];
    } V0_HIPP_CSC_COEF20 @ 0x121c;
    reg {
        name = "V0_HIPP_CSC_COEF21";
        desc = "V0_HIPP_CSC_COEF21 is CSC coefficient register 21. V0_HIPP_CSC_COEF21 (offset 0x1220, total reset 0x0000_0000; PROVEN: Hi3516D V300 data sheet, PDF page 567, section 9.2.6).";
        field {
            name = "reserved";
            desc = "Reserved";
            sw = r; hw = na;
            reset = 0x0;
        } reserved_31_16[31:16];
        field {
            name = "hipp_csc_coef21";
            desc = "Signed bit, s1.14";
            sw = rw; hw = r;
            reset = 0x0;
        } hipp_csc_coef21[15:0];
    } V0_HIPP_CSC_COEF21 @ 0x1220;
    reg {
        name = "V0_HIPP_CSC_COEF22";
        desc = "V0_HIPP_CSC_COEF22 is CSC coefficient register 22. V0_HIPP_CSC_COEF22 (offset 0x1224, total reset 0x0000_0000; PROVEN: Hi3516D V300 data sheet, PDF page 567, section 9.2.6).";
        field {
            name = "reserved";
            desc = "Reserved";
            sw = r; hw = na;
            reset = 0x0;
        } reserved_31_16[31:16];
        field {
            name = "hipp_csc_coef22";
            desc = "Signed bit, s1.14";
            sw = rw; hw = r;
            reset = 0x0;
        } hipp_csc_coef22[15:0];
    } V0_HIPP_CSC_COEF22 @ 0x1224;
    reg {
        name = "V0_HIPP_CSC_SCALE";
        desc = "V0_HIPP_CSC_SCALE is a CSC precision register. V0_HIPP_CSC_SCALE (offset 0x1228, total reset 0x0000_0000; PROVEN: Hi3516D V300 data sheet, PDF page 568, section 9.2.6).";
        field {
            name = "reserved";
            desc = "Reserved";
            sw = r; hw = na;
            reset = 0x0;
        } reserved_31_4[31:4];
        field {
            name = "hipp_csc_scale";
            desc = "Unsigned number u4.0";
            sw = rw; hw = r;
            reset = 0x0;
        } hipp_csc_scale[3:0];
    } V0_HIPP_CSC_SCALE @ 0x1228;
    reg {
        name = "V0_HIPP_CSC_IDC0";
        desc = "V0_HIPP_CSC_IDC0 is CSC input DC component register 0. V0_HIPP_CSC_IDC0 (offset 0x122C, total reset 0x0000_0000; PROVEN: Hi3516D V300 data sheet, PDF page 568, section 9.2.6).";
        field {
            name = "reserved";
            desc = "Reserved";
            sw = r; hw = na;
            reset = 0x0;
        } reserved_31_11[31:11];
        field {
            name = "hipp_csc_idc0";
            desc = "HIPP CSC input DC component register 0, signed bit s10.0";
            sw = rw; hw = r;
            reset = 0x0;
        } hipp_csc_idc0[10:0];
    } V0_HIPP_CSC_IDC0 @ 0x122c;
    reg {
        name = "V0_HIPP_CSC_IDC1";
        desc = "V0_HIPP_CSC_IDC1 is CSC input DC component register 1. V0_HIPP_CSC_IDC1 (offset 0x1230, total reset 0x0000_0000; PROVEN: Hi3516D V300 data sheet, PDF page 568, section 9.2.6).";
        field {
            name = "reserved";
            desc = "Reserved";
            sw = r; hw = na;
            reset = 0x0;
        } reserved_31_11[31:11];
        field {
            name = "hipp_csc_idc1";
            desc = "HIPP CSC input DC component register 1, signed bit s10.0";
            sw = rw; hw = r;
            reset = 0x0;
        } hipp_csc_idc1[10:0];
    } V0_HIPP_CSC_IDC1 @ 0x1230;
    reg {
        name = "V0_HIPP_CSC_IDC2";
        desc = "V0_HIPP_CSC_IDC2 is CSC input DC component register 2. V0_HIPP_CSC_IDC2 (offset 0x1234, total reset 0x0000_0000; PROVEN: Hi3516D V300 data sheet, PDF page 568, section 9.2.6).";
        field {
            name = "reserved";
            desc = "Reserved";
            sw = r; hw = na;
            reset = 0x0;
        } reserved_31_11[31:11];
        field {
            name = "hipp_csc_idc2";
            desc = "HIPP CSC input DC component register 2, signed bit s10.0";
            sw = rw; hw = r;
            reset = 0x0;
        } hipp_csc_idc2[10:0];
    } V0_HIPP_CSC_IDC2 @ 0x1234;
    reg {
        name = "V0_HIPP_CSC_ODC0";
        desc = "V0_HIPP_CSC_ODC0 is CSC output DC component register 0. V0_HIPP_CSC_ODC0 (offset 0x1238, total reset 0x0000_0000; PROVEN: Hi3516D V300 data sheet, PDF page 569, section 9.2.6).";
        field {
            name = "reserved";
            desc = "Reserved";
            sw = r; hw = na;
            reset = 0x0;
        } reserved_31_11[31:11];
        field {
            name = "hipp_csc_odc0";
            desc = "HIPP CSC output DC component register 0, signed bit s10.0";
            sw = rw; hw = r;
            reset = 0x0;
        } hipp_csc_odc0[10:0];
    } V0_HIPP_CSC_ODC0 @ 0x1238;
    reg {
        name = "V0_HIPP_CSC_ODC1";
        desc = "V0_HIPP_CSC_ODC1 is CSC output DC component register 1. V0_HIPP_CSC_ODC1 (offset 0x123C, total reset 0x0000_0000; PROVEN: Hi3516D V300 data sheet, PDF page 569, section 9.2.6).";
        field {
            name = "reserved";
            desc = "Reserved";
            sw = r; hw = na;
            reset = 0x0;
        } reserved_31_11[31:11];
        field {
            name = "hipp_csc_odc1";
            desc = "HIPP CSC output DC component register 1, signed bit s10.0";
            sw = rw; hw = r;
            reset = 0x0;
        } hipp_csc_odc1[10:0];
    } V0_HIPP_CSC_ODC1 @ 0x123c;
    reg {
        name = "V0_HIPP_CSC_ODC2";
        desc = "V0_HIPP_CSC_ODC2 is CSC output DC component register 2. V0_HIPP_CSC_ODC2 (offset 0x1240, total reset 0x0000_0000; PROVEN: Hi3516D V300 data sheet, PDF page 569, section 9.2.6).";
        field {
            name = "reserved";
            desc = "Reserved";
            sw = r; hw = na;
            reset = 0x0;
        } reserved_31_11[31:11];
        field {
            name = "hipp_csc_odc2";
            desc = "HIPP CSC output DC component register 2, signed bit s10.0";
            sw = rw; hw = r;
            reset = 0x0;
        } hipp_csc_odc2[10:0];
    } V0_HIPP_CSC_ODC2 @ 0x1240;
    reg {
        name = "V0_HIPP_CSC_MIN_Y";
        desc = "V0_HIPP_CSC_MIN_Y is a CSC minimum CLIP value register for the Y component. V0_HIPP_CSC_MIN_Y (offset 0x1244, total reset 0x0000_0000; PROVEN: Hi3516D V300 data sheet, PDF page 569, section 9.2.6).";
        field {
            name = "reserved";
            desc = "Reserved";
            sw = r; hw = na;
            reset = 0x0;
        } reserved_31_10[31:10];
        field {
            name = "hipp_csc_min_y";
            desc = "Unsigned number, u10.0";
            sw = rw; hw = r;
            reset = 0x0;
        } hipp_csc_min_y[9:0];
    } V0_HIPP_CSC_MIN_Y @ 0x1244;
    reg {
        name = "V0_HIPP_CSC_MIN_C";
        desc = "V0_HIPP_CSC_MIN_C is a CSC minimum CLIP value register for the C component. V0_HIPP_CSC_MIN_C (offset 0x1248, total reset 0x0000_0000; PROVEN: Hi3516D V300 data sheet, PDF page 570, section 9.2.6).";
        field {
            name = "reserved";
            desc = "Reserved";
            sw = r; hw = na;
            reset = 0x0;
        } reserved_31_10[31:10];
        field {
            name = "hipp_csc_min_c";
            desc = "Unsigned number, u10.0";
            sw = rw; hw = r;
            reset = 0x0;
        } hipp_csc_min_c[9:0];
    } V0_HIPP_CSC_MIN_C @ 0x1248;
    reg {
        name = "V0_HIPP_CSC_MAX_Y";
        desc = "V0_HIPP_CSC_MAX_Y is a CSC maximum CLIP value register for the Y component. V0_HIPP_CSC_MAX_Y (offset 0x124C, total reset 0x0000_0000; PROVEN: Hi3516D V300 data sheet, PDF page 570, section 9.2.6).";
        field {
            name = "reserved";
            desc = "Reserved";
            sw = r; hw = na;
            reset = 0x0;
        } reserved_31_10[31:10];
        field {
            name = "hipp_csc_max_y";
            desc = "Unsigned number, u10.0";
            sw = rw; hw = r;
            reset = 0x0;
        } hipp_csc_max_y[9:0];
    } V0_HIPP_CSC_MAX_Y @ 0x124c;
    reg {
        name = "V0_HIPP_CSC_MAX_C";
        desc = "V0_HIPP_CSC_MAX_C is a CSC maximum CLIP value register for the C component. V0_HIPP_CSC_MAX_C (offset 0x1250, total reset 0x0000_0000; PROVEN: Hi3516D V300 data sheet, PDF page 570, section 9.2.6).";
        field {
            name = "reserved";
            desc = "Reserved";
            sw = r; hw = na;
            reset = 0x0;
        } reserved_31_10[31:10];
        field {
            name = "hipp_csc_max_c";
            desc = "Unsigned number, u10.0";
            sw = rw; hw = r;
            reset = 0x0;
        } hipp_csc_max_c[9:0];
    } V0_HIPP_CSC_MAX_C @ 0x1250;
    reg {
        name = "V0_CVFIR_VINFO";
        desc = "V0_CVFIR_VINFO is a V0 vertical luminance offset register (non-instant register). It is used for \"pan and scan\". V0_CVFIR_VINFO (offset 0x1400, total reset 0x0000_0000; PROVEN: Hi3516D V300 data sheet, PDF page 570, section 9.2.6).";
        field {
            name = "reserved";
            desc = "Reserved";
            sw = r; hw = na;
            reset = 0x0;
        } reserved_31_19[31:19];
        field {
            name = "out_pro";
            desc = "Vertical scaling in progressive or interlaced output mode
- 0: interlaced
- 1: progressive";
            sw = rw; hw = r;
            reset = 0x0;
        } out_pro[18:18];
        field {
            name = "reserved";
            desc = "Data format of vertical scaling output
- 00: 420
- 01: 422
- 10: 444
- 11: reserved";
            sw = rw; hw = r;
            reset = 0x0;
        } reserved_17_16[17:16];
        field {
            name = "out_height";
            desc = "Vertical luminance single-eye output height.";
            sw = rw; hw = r;
            reset = 0x0;
        } out_height[15:0];
    } V0_CVFIR_VINFO @ 0x1400;
    reg {
        name = "V0_CVFIR_VSP";
        desc = "V0_CVFIR_VSP is a vertical scaling parameter configuration register (non-instant register). Scaling ratio = Input width/Output width V0_CVFIR_VSP (offset 0x1404, total reset 0x0000_1000; PROVEN: Hi3516D V300 data sheet, PDF page 571, section 9.2.6).";
        field {
            name = "reserved";
            desc = "Reserved";
            sw = r; hw = na;
            reset = 0x0;
        } reserved_31_31[31:31];
        field {
            name = "cvfir_en";
            desc = "Vertical chrominance scaling enable
- 0: disabled
- 1: enabled";
            sw = rw; hw = r;
            reset = 0x0;
        } cvfir_en[30:30];
        field {
            name = "reserved";
            desc = "Reserved";
            sw = r; hw = na;
            reset = 0x0;
        } reserved_29_29[29:29];
        field {
            name = "cvmid_en";
            desc = "Median filtering enable for vertical chrominance scaling. This bit is invalid when chfir_en is invalid.
- 0: disabled
- 1: enabled";
            sw = rw; hw = r;
            reset = 0x0;
        } cvmid_en[28:28];
        field {
            name = "reserved";
            desc = "Reserved";
            sw = r; hw = na;
            reset = 0x0;
        } reserved_27_27[27:27];
        field {
            name = "reserved";
            desc = "Reserved";
            sw = r; hw = na;
            reset = 0x0;
        } reserved_26_26[26:26];
        field {
            name = "cvfir_mode";
            desc = "Vertical chrominance scaling mode
- 0: replication mode (filtering disabled)
- 1: filtering mode (filtering enabled)";
            sw = rw; hw = r;
            reset = 0x0;
        } cvfir_mode[25:25];
        field {
            name = "reserved";
            desc = "Reserved";
            sw = r; hw = na;
            reset = 0x0;
        } reserved_24_16[24:16];
        field {
            name = "reserved";
            desc = "Reserved";
            sw = r; hw = na;
            reset = 0x1000;
        } reserved_15_0[15:0];
    } V0_CVFIR_VSP @ 0x1404;
    reg {
        name = "V0_HFIR_CTRL";
        desc = "V0_HFIR_CTRL is a V0 HFIR control register. V0_HFIR_CTRL (offset 0x1500, total reset 0x0000_0000; PROVEN: Hi3516D V300 data sheet, PDF page 572, section 9.2.6).";
        field {
            name = "reserved";
            desc = "Reserved";
            sw = r; hw = na;
            reset = 0x0;
        } reserved_31_3[31:3];
        field {
            name = "hfir_mode";
            desc = "Horizontal chrominance HFIR mode
- 00: reserved
- 01: chrominance IFIR replication mode
- 10: bilinear interpolation
- 11: 6-tap FIR";
            sw = rw; hw = r;
            reset = 0x0;
        } hfir_mode[2:1];
        field {
            name = "reserved";
            desc = "Reserved";
            sw = r; hw = na;
            reset = 0x0;
        } reserved_0_0[0:0];
    } V0_HFIR_CTRL @ 0x1500;
    reg {
        name = "V0_HFIRCOEF01";
        desc = "V0_HFIRCOEF01 is a V0 HFIR filtering coefficient 0/1 register. V0_HFIRCOEF01 (offset 0x1504, total reset 0x0000_0000; PROVEN: Hi3516D V300 data sheet, PDF page 572, section 9.2.6).";
        field {
            name = "reserved";
            desc = "Reserved";
            sw = r; hw = na;
            reset = 0x0;
        } reserved_31_26[31:26];
        field {
            name = "coef1";
            desc = "HFIR filtering coefficient 1";
            sw = rw; hw = r;
            reset = 0x0;
        } coef1[25:16];
        field {
            name = "reserved";
            desc = "Reserved";
            sw = r; hw = na;
            reset = 0x0;
        } reserved_15_10[15:10];
        field {
            name = "coef0";
            desc = "HFIR filtering coefficient 0";
            sw = rw; hw = r;
            reset = 0x0;
        } coef0[9:0];
    } V0_HFIRCOEF01 @ 0x1504;
    reg {
        name = "V0_HFIRCOEF23";
        desc = "V0_HFIRCOEF23 is a V0 HFIR filtering coefficient 2/3 register. V0_HFIRCOEF23 (offset 0x1508, total reset 0x0000_0000; PROVEN: Hi3516D V300 data sheet, PDF page 572, section 9.2.6).";
        field {
            name = "reserved";
            desc = "Reserved";
            sw = r; hw = na;
            reset = 0x0;
        } reserved_31_26[31:26];
        field {
            name = "coef3";
            desc = "HFIR filtering coefficient 3";
            sw = rw; hw = r;
            reset = 0x0;
        } coef3[25:16];
        field {
            name = "reserved";
            desc = "Reserved";
            sw = r; hw = na;
            reset = 0x0;
        } reserved_15_10[15:10];
        field {
            name = "coef2";
            desc = "HFIR filtering coefficient 2";
            sw = rw; hw = r;
            reset = 0x0;
        } coef2[9:0];
    } V0_HFIRCOEF23 @ 0x1508;
    reg {
        name = "V0_HFIRCOEF45";
        desc = "V0_HFIRCOEF45 is a V0 HFIR filtering coefficient 4/5 register. V0_HFIRCOEF45 (offset 0x150C, total reset 0x0000_0000; PROVEN: Hi3516D V300 data sheet, PDF page 573, section 9.2.6).";
        field {
            name = "reserved";
            desc = "Reserved";
            sw = r; hw = na;
            reset = 0x0;
        } reserved_31_26[31:26];
        field {
            name = "coef5";
            desc = "HFIR filtering coefficient 5";
            sw = rw; hw = r;
            reset = 0x0;
        } coef5[25:16];
        field {
            name = "reserved";
            desc = "Reserved";
            sw = r; hw = na;
            reset = 0x0;
        } reserved_15_10[15:10];
        field {
            name = "coef4";
            desc = "HFIR filtering coefficient 4";
            sw = rw; hw = r;
            reset = 0x0;
        } coef4[9:0];
    } V0_HFIRCOEF45 @ 0x150c;
    reg {
        name = "V0_HFIRCOEF67";
        desc = "V0_HFIRCOEF67 is a V0 HFIR filtering coefficient 6/7 register. V0_HFIRCOEF67 (offset 0x1510, total reset 0x0000_0000; PROVEN: Hi3516D V300 data sheet, PDF page 573, section 9.2.6).";
        field {
            name = "reserved";
            desc = "Reserved";
            sw = r; hw = na;
            reset = 0x0;
        } reserved_31_26[31:26];
        field {
            name = "coef7";
            desc = "HFIR filtering coefficient 7";
            sw = rw; hw = r;
            reset = 0x0;
        } coef7[25:16];
        field {
            name = "reserved";
            desc = "Reserved";
            sw = r; hw = na;
            reset = 0x0;
        } reserved_15_10[15:10];
        field {
            name = "coef6";
            desc = "HFIR filtering coefficient 6";
            sw = rw; hw = r;
            reset = 0x0;
        } coef6[9:0];
    } V0_HFIRCOEF67 @ 0x1510;
    reg {
        name = "G0_CTRL";
        desc = "G0_CTRL is a G0 configuration register (non-instant register). G0_CTRL (offset 0x7000, total reset 0x4000_00FF; PROVEN: Hi3516D V300 data sheet, PDF page 573, section 9.2.6).";
        field {
            name = "surface_en";
            desc = "Surface enable (non-instant)
- 0: disabled
- 1: enabled";
            sw = rw; hw = r;
            reset = 0x0;
        } surface_en[31:31];
        field {
            name = "reserved";
            desc = "Reserved";
            sw = r; hw = w;
            reset = 0x1;
        } reserved_30_30[30:30];
        field {
            name = "reserved";
            desc = "Reserved";
            sw = r; hw = w;
            reset = 0x0;
        } reserved_29_8[29:8];
        field {
            name = "galpha";
            desc = "Overlay global alpha value. The value ranges from 0 to 255. The value 255 indicates opaque, and the value 0 indicates completely transparent.";
            sw = rw; hw = r;
            reset = 0xff;
        } galpha[7:0];
    } G0_CTRL @ 0x7000;
    reg {
        name = "G0_UPD";
        desc = "G0_UPD is a G0 update enable register. G0_UPD (offset 0x7004, total reset 0x0000_0000; PROVEN: Hi3516D V300 data sheet, PDF page 574, section 9.2.6).";
        field {
            name = "reserved";
            desc = "Reserved";
            sw = r; hw = na;
            reset = 0x0;
        } reserved_31_1[31:1];
        field {
            name = "regup";
            desc = "Surface register update. After the registers at this layer are configured, the registers are updated when the value 1 is written to this bit. After updates, this bit is automatically cleared by the hardware. (data sheet access type WC)";
            sw = rw; hw = r; onwrite = woclr;
            reset = 0x0;
        } regup[0:0];
    } G0_UPD @ 0x7004;
    reg {
        name = "G0_0RESO_READ";
        desc = "G0_0RESO_READ is a G0 output resolution register. G0_0RESO_READ (offset 0x700C, total reset 0x0000_077F; PROVEN: Hi3516D V300 data sheet, PDF page 574, section 9.2.6).";
        field {
            name = "oh";
            desc = "Height (in lines). The configured value is the actual height minus 1. The frame height is referenced and its unit is line.";
            sw = r; hw = w;
            reset = 0x0;
        } oh[31:16];
        field {
            name = "ow";
            desc = "Width (in pixels). The configured value is the actual width minus 1. The frame width is referenced and its unit is column.";
            sw = r; hw = w;
            reset = 0x77f;
        } ow[15:0];
    } G0_0RESO_READ @ 0x700c;
    reg {
        name = "G0_DFPOS";
        desc = "G0_DFPOS is a G0 surface first position (in the display window) register (non-instant register). The unit of the position is pixel. G0_DFPOS (offset 0x7080, total reset 0x0000_0000; PROVEN: Hi3516D V300 data sheet, PDF page 574, section 9.2.6).";
        field {
            name = "disp_yfpos";
            desc = "Start coordinates of the display row The frame height is referenced and its unit is line.";
            sw = rw; hw = r;
            reset = 0x0;
        } disp_yfpos[31:16];
        field {
            name = "disp_xfpos";
            desc = "Start coordinates of the display column The frame width is referenced and its unit is column.";
            sw = rw; hw = r;
            reset = 0x0;
        } disp_xfpos[15:0];
    } G0_DFPOS @ 0x7080;
    reg {
        name = "G0_DLPOS";
        desc = "G0_DLPOS is a G0 surface last position (in the display window) register (non-instant register). The position unit is pixel. G0_DLPOS (offset 0x7084, total reset 0x0000_0000; PROVEN: Hi3516D V300 data sheet, PDF page 575, section 9.2.6).";
        field {
            name = "disp_ylpos";
            desc = "End coordinates of the display row The frame height is referenced and its unit is line.";
            sw = rw; hw = r;
            reset = 0x0;
        } disp_ylpos[31:16];
        field {
            name = "disp_xlpos";
            desc = "End coordinates of the display column The frame width is referenced and its unit is column.";
            sw = rw; hw = r;
            reset = 0x0;
        } disp_xlpos[15:0];
    } G0_DLPOS @ 0x7084;
    reg {
        name = "G0_VFPOS";
        desc = "G0_VFPOS is a G0 surface content first position (in the display window) register (non-instant register). The unit of the position is pixel. G0_VFPOS (offset 0x7088, total reset 0x0000_0000; PROVEN: Hi3516D V300 data sheet, PDF page 575, section 9.2.6).";
        field {
            name = "video_yfpos";
            desc = "Start coordinates of the video row The frame height is referenced and its unit is line.";
            sw = rw; hw = r;
            reset = 0x0;
        } video_yfpos[31:16];
        field {
            name = "video_xfpos";
            desc = "Start coordinates of the video column The frame width is referenced and its unit is column.";
            sw = rw; hw = r;
            reset = 0x0;
        } video_xfpos[15:0];
    } G0_VFPOS @ 0x7088;
    reg {
        name = "G0_VLPOS";
        desc = "G0_VLPOS is a G0 surface content end position (in the display window) register (non-instant register). The unit of the position is pixel. G0_VLPOS (offset 0x708C, total reset 0x0000_0000; PROVEN: Hi3516D V300 data sheet, PDF page 575, section 9.2.6).";
        field {
            name = "video_ylpos";
            desc = "End coordinates of the video row The frame height is referenced and its unit is line.";
            sw = rw; hw = r;
            reset = 0x0;
        } video_ylpos[31:16];
        field {
            name = "video_xlpos";
            desc = "End coordinates of the video column The frame width is referenced and its unit is column.";
            sw = rw; hw = r;
            reset = 0x0;
        } video_xlpos[15:0];
    } G0_VLPOS @ 0x708c;
    reg {
        name = "G0_BK";
        desc = "G0_BK is a G0 background color register. G0_BK (offset 0x7090, total reset 0x0000_0000; PROVEN: Hi3516D V300 data sheet, PDF page 576, section 9.2.6).";
        field {
            name = "reserved";
            desc = "Reserved";
            sw = r; hw = na;
            reset = 0x0;
        } reserved_31_30[31:30];
        field {
            name = "vbk_y";
            desc = "Y component";
            sw = rw; hw = r;
            reset = 0x0;
        } vbk_y[29:20];
        field {
            name = "vbk_cb";
            desc = "Cb component";
            sw = rw; hw = r;
            reset = 0x0;
        } vbk_cb[19:10];
        field {
            name = "vbk_cr";
            desc = "Cr component";
            sw = rw; hw = r;
            reset = 0x0;
        } vbk_cr[9:0];
    } G0_BK @ 0x7090;
    reg {
        name = "G0_ALPHA";
        desc = "G0_ALPHA is a G0 background filling color alpha register. G0_ALPHA (offset 0x7094, total reset 0x0000_0000; PROVEN: Hi3516D V300 data sheet, PDF page 576, section 9.2.6).";
        field {
            name = "reserved";
            desc = "Reserved";
            sw = r; hw = na;
            reset = 0x0;
        } reserved_31_8[31:8];
        field {
            name = "vbk_alpha";
            desc = "Level 0–255 of the background filling color of the graphics layer";
            sw = rw; hw = r;
            reset = 0x0;
        } vbk_alpha[7:0];
    } G0_ALPHA @ 0x7094;
    reg {
        name = "G0_HIPP_CSC_CTRL";
        desc = "G0_HIPP_CSC_CTRL is a CSC control register. G0_HIPP_CSC_CTRL (offset 0x7100, total reset 0x0000_0000; PROVEN: Hi3516D V300 data sheet, PDF page 576, section 9.2.6).";
        field {
            name = "reserved";
            desc = "Reserved";
            sw = r; hw = na;
            reset = 0x0;
        } reserved_31_1[31:1];
        field {
            name = "hipp_csc_en";
            desc = "HIPP CSC enable
- 0: disabled
- 1: enabled";
            sw = rw; hw = r;
            reset = 0x0;
        } hipp_csc_en[0:0];
    } G0_HIPP_CSC_CTRL @ 0x7100;
    reg {
        name = "G0_HIPP_CSC_COEF00";
        desc = "G0_HIPP_CSC_COEF00 is CSC coefficient register 00. G0_HIPP_CSC_COEF00 (offset 0x7104, total reset 0x0000_0000; PROVEN: Hi3516D V300 data sheet, PDF page 576, section 9.2.6).";
        field {
            name = "reserved";
            desc = "Reserved";
            sw = r; hw = na;
            reset = 0x0;
        } reserved_31_16[31:16];
        field {
            name = "hipp_csc_coef00";
            desc = "CSC coefficient register 00 Signed bit s1.14";
            sw = rw; hw = r;
            reset = 0x0;
        } hipp_csc_coef00[15:0];
    } G0_HIPP_CSC_COEF00 @ 0x7104;
    reg {
        name = "G0_HIPP_CSC_COEF01";
        desc = "G0_HIPP_CSC_COEF01 is CSC coefficient register 01. G0_HIPP_CSC_COEF01 (offset 0x7108, total reset 0x0000_0000; PROVEN: Hi3516D V300 data sheet, PDF page 577, section 9.2.6).";
        field {
            name = "reserved";
            desc = "Reserved";
            sw = r; hw = na;
            reset = 0x0;
        } reserved_31_16[31:16];
        field {
            name = "hipp_csc_coef01";
            desc = "CSC coefficient register 01 Signed bit s1.14";
            sw = rw; hw = r;
            reset = 0x0;
        } hipp_csc_coef01[15:0];
    } G0_HIPP_CSC_COEF01 @ 0x7108;
    reg {
        name = "G0_HIPP_CSC_COEF02";
        desc = "G0_HIPP_CSC_COEF02 is CSC coefficient register 02. G0_HIPP_CSC_COEF02 (offset 0x710C, total reset 0x0000_0000; PROVEN: Hi3516D V300 data sheet, PDF page 577, section 9.2.6).";
        field {
            name = "reserved";
            desc = "Reserved";
            sw = r; hw = na;
            reset = 0x0;
        } reserved_31_16[31:16];
        field {
            name = "hipp_csc_coef02";
            desc = "CSC coefficient register 02 Signed bit, s1.14";
            sw = rw; hw = r;
            reset = 0x0;
        } hipp_csc_coef02[15:0];
    } G0_HIPP_CSC_COEF02 @ 0x710c;
    reg {
        name = "G0_HIPP_CSC_COEF10";
        desc = "G0_HIPP_CSC_COEF10 is CSC coefficient register 10. G0_HIPP_CSC_COEF10 (offset 0x7110, total reset 0x0000_0000; PROVEN: Hi3516D V300 data sheet, PDF page 577, section 9.2.6).";
        field {
            name = "reserved";
            desc = "Reserved";
            sw = r; hw = na;
            reset = 0x0;
        } reserved_31_16[31:16];
        field {
            name = "hipp_csc_coef10";
            desc = "CSC coefficient register 10 Signed bit, s1.14";
            sw = rw; hw = r;
            reset = 0x0;
        } hipp_csc_coef10[15:0];
    } G0_HIPP_CSC_COEF10 @ 0x7110;
    reg {
        name = "G0_HIPP_CSC_COEF11";
        desc = "G0_HIPP_CSC_COEF11 is CSC coefficient register 11. G0_HIPP_CSC_COEF11 (offset 0x7114, total reset 0x0000_0000; PROVEN: Hi3516D V300 data sheet, PDF page 578, section 9.2.6).";
        field {
            name = "reserved";
            desc = "Reserved";
            sw = r; hw = na;
            reset = 0x0;
        } reserved_31_16[31:16];
        field {
            name = "hipp_csc_coef11";
            desc = "CSC coefficient register 11 Signed bit, s1.14";
            sw = rw; hw = r;
            reset = 0x0;
        } hipp_csc_coef11[15:0];
    } G0_HIPP_CSC_COEF11 @ 0x7114;
    reg {
        name = "G0_HIPP_CSC_COEF12";
        desc = "G0_HIPP_CSC_COEF12 is CSC coefficient register 12. G0_HIPP_CSC_COEF12 (offset 0x7118, total reset 0x0000_0000; PROVEN: Hi3516D V300 data sheet, PDF page 578, section 9.2.6).";
        field {
            name = "reserved";
            desc = "Reserved";
            sw = r; hw = na;
            reset = 0x0;
        } reserved_31_16[31:16];
        field {
            name = "hipp_csc_coef12";
            desc = "CSC coefficient register 12 Signed bit, s1.14";
            sw = rw; hw = r;
            reset = 0x0;
        } hipp_csc_coef12[15:0];
    } G0_HIPP_CSC_COEF12 @ 0x7118;
    reg {
        name = "G0_HIPP_CSC_COEF20";
        desc = "G0_HIPP_CSC_COEF20 is CSC coefficient register 20. G0_HIPP_CSC_COEF20 (offset 0x711C, total reset 0x0000_0000; PROVEN: Hi3516D V300 data sheet, PDF page 578, section 9.2.6).";
        field {
            name = "reserved";
            desc = "Reserved";
            sw = r; hw = na;
            reset = 0x0;
        } reserved_31_16[31:16];
        field {
            name = "hipp_csc_coef20";
            desc = "CSC coefficient register 20 Signed bit, s1.14";
            sw = rw; hw = r;
            reset = 0x0;
        } hipp_csc_coef20[15:0];
    } G0_HIPP_CSC_COEF20 @ 0x711c;
    reg {
        name = "G0_HIPP_CSC_COEF21";
        desc = "G0_HIPP_CSC_COEF21 is CSC coefficient register 21. G0_HIPP_CSC_COEF21 (offset 0x7120, total reset 0x0000_0000; PROVEN: Hi3516D V300 data sheet, PDF page 578, section 9.2.6).";
        field {
            name = "reserved";
            desc = "Reserved";
            sw = r; hw = na;
            reset = 0x0;
        } reserved_31_16[31:16];
        field {
            name = "hipp_csc_coef21";
            desc = "CSC coefficient register 21";
            sw = rw; hw = r;
            reset = 0x0;
        } hipp_csc_coef21[15:0];
    } G0_HIPP_CSC_COEF21 @ 0x7120;
    reg {
        name = "G0_HIPP_CSC_COEF22";
        desc = "G0_HIPP_CSC_COEF22 is CSC coefficient register 22. G0_HIPP_CSC_COEF22 (offset 0x7124, total reset 0x0000_0000; PROVEN: Hi3516D V300 data sheet, PDF page 579, section 9.2.6).";
        field {
            name = "reserved";
            desc = "Reserved";
            sw = r; hw = na;
            reset = 0x0;
        } reserved_31_16[31:16];
        field {
            name = "hipp_csc_coef22";
            desc = "CSC coefficient register 22 Signed bit, s1.14";
            sw = rw; hw = r;
            reset = 0x0;
        } hipp_csc_coef22[15:0];
    } G0_HIPP_CSC_COEF22 @ 0x7124;
    reg {
        name = "G0_HIPP_CSC_SCALE";
        desc = "G0_HIPP_CSC_SCALE is a CSC precision register. G0_HIPP_CSC_SCALE (offset 0x7128, total reset 0x0000_0000; PROVEN: Hi3516D V300 data sheet, PDF page 579, section 9.2.6).";
        field {
            name = "reserved";
            desc = "Reserved";
            sw = r; hw = na;
            reset = 0x0;
        } reserved_31_4[31:4];
        field {
            name = "hipp_csc_scale";
            desc = "CSC precision register Unsigned number, u4.0";
            sw = rw; hw = r;
            reset = 0x0;
        } hipp_csc_scale[3:0];
    } G0_HIPP_CSC_SCALE @ 0x7128;
    reg {
        name = "G0_HIPP_CSC_IDC0";
        desc = "G0_HIPP_CSC_IDC0 is CSC input DC component register 0. G0_HIPP_CSC_IDC0 (offset 0x712C, total reset 0x0000_0000; PROVEN: Hi3516D V300 data sheet, PDF page 579, section 9.2.6).";
        field {
            name = "reserved";
            desc = "Reserved";
            sw = r; hw = na;
            reset = 0x0;
        } reserved_31_11[31:11];
        field {
            name = "hipp_csc_idc0";
            desc = "HIPP CSC input DC component register 0, signed bit s10.0";
            sw = rw; hw = r;
            reset = 0x0;
        } hipp_csc_idc0[10:0];
    } G0_HIPP_CSC_IDC0 @ 0x712c;
    reg {
        name = "G0_HIPP_CSC_IDC1";
        desc = "G0_HIPP_CSC_IDC1 is CSC input DC component register 1. G0_HIPP_CSC_IDC1 (offset 0x7130, total reset 0x0000_0000; PROVEN: Hi3516D V300 data sheet, PDF page 579, section 9.2.6).";
        field {
            name = "reserved";
            desc = "Reserved";
            sw = r; hw = na;
            reset = 0x0;
        } reserved_31_11[31:11];
        field {
            name = "hipp_csc_idc1";
            desc = "HIPP CSC input DC component register 1, signed bit s10.0";
            sw = rw; hw = r;
            reset = 0x0;
        } hipp_csc_idc1[10:0];
    } G0_HIPP_CSC_IDC1 @ 0x7130;
    reg {
        name = "G0_HIPP_CSC_IDC2";
        desc = "G0_HIPP_CSC_IDC2 is CSC input DC component register 2. G0_HIPP_CSC_IDC2 (offset 0x7134, total reset 0x0000_0000; PROVEN: Hi3516D V300 data sheet, PDF page 580, section 9.2.6).";
        field {
            name = "reserved";
            desc = "Reserved";
            sw = r; hw = na;
            reset = 0x0;
        } reserved_31_11[31:11];
        field {
            name = "hipp_csc_idc2";
            desc = "HIPP CSC input DC component register 2, signed bit s10.0";
            sw = rw; hw = r;
            reset = 0x0;
        } hipp_csc_idc2[10:0];
    } G0_HIPP_CSC_IDC2 @ 0x7134;
    reg {
        name = "G0_HIPP_CSC_ODC0";
        desc = "G0_HIPP_CSC_ODC0 is CSC output DC component register 0. G0_HIPP_CSC_ODC0 (offset 0x7138, total reset 0x0000_0000; PROVEN: Hi3516D V300 data sheet, PDF page 580, section 9.2.6).";
        field {
            name = "reserved";
            desc = "Reserved";
            sw = r; hw = na;
            reset = 0x0;
        } reserved_31_11[31:11];
        field {
            name = "hipp_csc_odc0";
            desc = "HIPP CSC output DC component register 0, signed bit s10.0";
            sw = rw; hw = r;
            reset = 0x0;
        } hipp_csc_odc0[10:0];
    } G0_HIPP_CSC_ODC0 @ 0x7138;
    reg {
        name = "G0_HIPP_CSC_ODC1";
        desc = "G0_HIPP_CSC_ODC1 is CSC output DC component register 1. G0_HIPP_CSC_ODC1 (offset 0x713C, total reset 0x0000_0000; PROVEN: Hi3516D V300 data sheet, PDF page 580, section 9.2.6).";
        field {
            name = "reserved";
            desc = "Reserved";
            sw = r; hw = na;
            reset = 0x0;
        } reserved_31_11[31:11];
        field {
            name = "hipp_csc_odc1";
            desc = "HIPP CSC output DC component register 1, signed bit s10.0";
            sw = rw; hw = r;
            reset = 0x0;
        } hipp_csc_odc1[10:0];
    } G0_HIPP_CSC_ODC1 @ 0x713c;
    reg {
        name = "G0_HIPP_CSC_ODC2";
        desc = "G0_HIPP_CSC_ODC2 is CSC output DC component register 2. G0_HIPP_CSC_ODC2 (offset 0x7140, total reset 0x0000_0000; PROVEN: Hi3516D V300 data sheet, PDF page 581, section 9.2.6).";
        field {
            name = "reserved";
            desc = "Reserved";
            sw = r; hw = na;
            reset = 0x0;
        } reserved_31_11[31:11];
        field {
            name = "hipp_csc_odc2";
            desc = "HIPP CSC output DC component register 2, signed bit s10.0";
            sw = rw; hw = r;
            reset = 0x0;
        } hipp_csc_odc2[10:0];
    } G0_HIPP_CSC_ODC2 @ 0x7140;
    reg {
        name = "G0_HIPP_CSC_MIN_Y";
        desc = "G0_HIPP_CSC_MIN_Y is a CSC minimum CLIP value register for the Y component. G0_HIPP_CSC_MIN_Y (offset 0x7144, total reset 0x0000_0000; PROVEN: Hi3516D V300 data sheet, PDF page 581, section 9.2.6).";
        field {
            name = "reserved";
            desc = "Reserved";
            sw = r; hw = na;
            reset = 0x0;
        } reserved_31_10[31:10];
        field {
            name = "hipp_csc_min_y";
            desc = "CSC minimum CLIP value register for the Y component Unsigned number, u10.0";
            sw = rw; hw = r;
            reset = 0x0;
        } hipp_csc_min_y[9:0];
    } G0_HIPP_CSC_MIN_Y @ 0x7144;
    reg {
        name = "G0_HIPP_CSC_MIN_C";
        desc = "G0_HIPP_CSC_MIN_C is a CSC minimum CLIP value register for the C component. G0_HIPP_CSC_MIN_C (offset 0x7148, total reset 0x0000_0000; PROVEN: Hi3516D V300 data sheet, PDF page 581, section 9.2.6).";
        field {
            name = "reserved";
            desc = "Reserved";
            sw = r; hw = na;
            reset = 0x0;
        } reserved_31_10[31:10];
        field {
            name = "hipp_csc_min_c";
            desc = "CSC minimum CLIP value register for the C component Unsigned number, u10.0";
            sw = rw; hw = r;
            reset = 0x0;
        } hipp_csc_min_c[9:0];
    } G0_HIPP_CSC_MIN_C @ 0x7148;
    reg {
        name = "G0_HIPP_CSC_MAX_Y";
        desc = "G0_HIPP_CSC_MAX_Y is a CSC maximum CLIP value register for the Y component. G0_HIPP_CSC_MAX_Y (offset 0x714C, total reset 0x0000_0000; PROVEN: Hi3516D V300 data sheet, PDF page 581, section 9.2.6).";
        field {
            name = "reserved";
            desc = "Reserved";
            sw = r; hw = na;
            reset = 0x0;
        } reserved_31_10[31:10];
        field {
            name = "hipp_csc_max_y";
            desc = "CSC maximum CLIP value register for the Y component Unsigned number, u10.0";
            sw = rw; hw = r;
            reset = 0x0;
        } hipp_csc_max_y[9:0];
    } G0_HIPP_CSC_MAX_Y @ 0x714c;
    reg {
        name = "G0_HIPP_CSC_MAX_C";
        desc = "G0_HIPP_CSC_MAX_C is CSC maximum CLIP value register for the C component. G0_HIPP_CSC_MAX_C (offset 0x7150, total reset 0x0000_0000; PROVEN: Hi3516D V300 data sheet, PDF page 582, section 9.2.6).";
        field {
            name = "reserved";
            desc = "Reserved";
            sw = r; hw = na;
            reset = 0x0;
        } reserved_31_10[31:10];
        field {
            name = "hipp_csc_max_c";
            desc = "CSC maximum CLIP value register for the C component Unsigned number, u10.0";
            sw = rw; hw = r;
            reset = 0x0;
        } hipp_csc_max_c[9:0];
    } G0_HIPP_CSC_MAX_C @ 0x7150;
    reg {
        name = "G0_ZME_HINFO";
        desc = "G0_ZME_HINFO is a G0 horizontal luminance offset register (non-instant register). It is used for \"pan and scan\". G0_ZME_HINFO (offset 0x7300, total reset 0x0000_0000; PROVEN: Hi3516D V300 data sheet, PDF page 582, section 9.2.6).";
        field {
            name = "reserved";
            desc = "Reserved";
            sw = r; hw = na;
            reset = 0x0;
        } reserved_31_16[31:16];
        field {
            name = "out_width";
            desc = "Horizontal single-eye output width";
            sw = rw; hw = r;
            reset = 0x0;
        } out_width[15:0];
    } G0_ZME_HINFO @ 0x7300;
    reg {
        name = "G0_ZME_HSP";
        desc = "G0_ZME_HSP is a G0 horizontal scaling parameter configuration register (non-instant register). Scaling ratio = Input width/Output width G0_ZME_HSP (offset 0x7304, total reset 0x0010_0000; PROVEN: Hi3516D V300 data sheet, PDF page 582, section 9.2.6).";
        field {
            name = "hfir_en";
            desc = "Horizontal luminance scaling enable
- 0: disabled
- 1: enabled";
            sw = rw; hw = r;
            reset = 0x0;
        } hfir_en[31:31];
        field {
            name = "ahfir_mid_en";
            desc = "Median filtering enable for alpha value horizontal scaling. This bit is invalid when hfir_en is invalid.
- 0: disabled
- 1: enabled";
            sw = rw; hw = r;
            reset = 0x0;
        } ahfir_mid_en[30:30];
        field {
            name = "lhfir_mid_en";
            desc = "Median filtering enable for horizontal scaling.";
            sw = rw; hw = r;
            reset = 0x0;
        } lhfir_mid_en[29:29];
        field {
            name = "chfir_mid_en";
            desc = "Median filtering enable for horizontal scaling. This bit is invalid when hfir_en is invalid.
- 0: disabled
- 1: enabled";
            sw = rw; hw = r;
            reset = 0x0;
        } chfir_mid_en[28:28];
        field {
            name = "reserved";
            desc = "Reserved";
            sw = r; hw = na;
            reset = 0x0;
        } reserved_27_27[27:27];
        field {
            name = "lhfir_mode";
            desc = "Horizontal luminance and chrominance scaling mode
- 0: replication mode (filtering disabled)
- 1: filtering mode (filtering enabled)";
            sw = rw; hw = r;
            reset = 0x0;
        } lhfir_mode[26:26];
        field {
            name = "ahfir_mode";
            desc = "Horizontal alpha value scaling mode
- 0: replication mode (filtering disabled)
- 1: filtering mode (filtering enabled), using the same filtering mode as Y component";
            sw = rw; hw = r;
            reset = 0x0;
        } ahfir_mode[25:25];
        field {
            name = "reserved";
            desc = "Reserved";
            sw = r; hw = na;
            reset = 0x0;
        } reserved_24_24[24:24];
        field {
            name = "hratio";
            desc = "Horizontal scaling ratio, in (u, 4, 20) format";
            sw = rw; hw = r;
            reset = 0x100000;
        } hratio[23:0];
    } G0_ZME_HSP @ 0x7304;
    reg {
        name = "G0_ZME_VINFO";
        desc = "G0_ZME_VINFO is a G0 vertical luminance offset register (non-instant register). It is used for \"pan and scan\". G0_ZME_VINFO (offset 0x7380, total reset 0x0000_0000; PROVEN: Hi3516D V300 data sheet, PDF page 583, section 9.2.6).";
        field {
            name = "reserved";
            desc = "Reserved";
            sw = r; hw = na;
            reset = 0x0;
        } reserved_31_19[31:19];
        field {
            name = "out_pro";
            desc = "Vertical scaling in progressive or interlaced output mode
- 0: interlaced
- 1: progressive";
            sw = rw; hw = r;
            reset = 0x0;
        } out_pro[18:18];
        field {
            name = "reserved";
            desc = "Reserved";
            sw = r; hw = na;
            reset = 0x0;
        } reserved_17_16[17:16];
        field {
            name = "out_height";
            desc = "Vertical luminance single-eye output height";
            sw = rw; hw = r;
            reset = 0x0;
        } out_height[15:0];
    } G0_ZME_VINFO @ 0x7380;
    reg {
        name = "G0_ZME_VSP";
        desc = "G0_ZME_VSP is a G0 vertical scaling parameter configuration register (non-instant register). Scaling ratio = Input width/Output width G0_ZME_VSP (offset 0x7384, total reset 0x0000_1000; PROVEN: Hi3516D V300 data sheet, PDF page 584, section 9.2.6).";
        field {
            name = "vfir_en";
            desc = "Vertical luminance scaling enable
- 0: disabled
- 1: enabled";
            sw = rw; hw = r;
            reset = 0x0;
        } vfir_en[31:31];
        field {
            name = "avfir_mid_en";
            desc = "Median filtering enable for alpha value vertical scaling
- 0: disabled
- 1: enabled";
            sw = rw; hw = r;
            reset = 0x0;
        } avfir_mid_en[30:30];
        field {
            name = "lvfir_mid_en";
            desc = "Median filtering enable for vertical luminance scaling
- 0: disabled
- 1: enabled";
            sw = rw; hw = r;
            reset = 0x0;
        } lvfir_mid_en[29:29];
        field {
            name = "cvfir_mid_en";
            desc = "Median filtering enable for vertical chrominance scaling
- 0: disabled
- 1: enabled";
            sw = rw; hw = r;
            reset = 0x0;
        } cvfir_mid_en[28:28];
        field {
            name = "reserved";
            desc = "Reserved";
            sw = r; hw = na;
            reset = 0x0;
        } reserved_27_27[27:27];
        field {
            name = "lvfir_mode";
            desc = "Vertical luminance and chrominance scaling mode
- 0: replication mode (filtering disabled)
- 1: filtering mode (filtering enabled)";
            sw = rw; hw = r;
            reset = 0x0;
        } lvfir_mode[26:26];
        field {
            name = "vafir_mode";
            desc = "Vertical alpha value scaling mode
- 0: replication mode (filtering disabled)
- 1: filtering mode (filtering enabled), using the same filtering mode as Y component";
            sw = rw; hw = r;
            reset = 0x0;
        } vafir_mode[25:25];
        field {
            name = "reserved";
            desc = "Reserved";
            sw = r; hw = na;
            reset = 0x0;
        } reserved_24_16[24:16];
        field {
            name = "vratio";
            desc = "Vertical scaling ratio, in (u, 4, 12) format";
            sw = rw; hw = r;
            reset = 0x1000;
        } vratio[15:0];
    } G0_ZME_VSP @ 0x7384;
    reg {
        name = "DHD0_CTRL";
        desc = "DHD0_CTRL is a DHD0 global control register. You must configure all bits of this register before configuring DHD0_CTRL.regup. Otherwise, the configuration does not take effect. DHD0_CTRL (offset 0xD000, total reset 0x0000_0000; PROVEN: Hi3516D V300 data sheet, PDF page 584, section 9.2.6).";
        field {
            name = "intf_en";
            desc = "Display interface enable";
            sw = rw; hw = r;
            reset = 0x0;
        } intf_en[31:31];
        field {
            name = "cbar_en";
            desc = "Color bar enable. The color bar is output over the interface when this field is enabled.
- 0: disabled
- 1: enabled";
            sw = rw; hw = r;
            reset = 0x0;
        } cbar_en[30:30];
        field {
            name = "cbar_sel";
            desc = "Color space select for the output color bar (instant)
- 0: VGA
- 1: YPbPr";
            sw = rw; hw = r;
            reset = 0x0;
        } cbar_sel[29:29];
        field {
            name = "reserved";
            desc = "Reserved";
            sw = r; hw = na;
            reset = 0x0;
        } reserved_28_1[28:1];
        field {
            name = "regup";
            desc = "DHD0 register update. After the registers at this layer are configured, the registers are updated when the value 1 is written to this bit. After the registers are updated, this bit is automatically cleared by the hardware. (data sheet access type WC)";
            sw = rw; hw = r; onwrite = woclr;
            reset = 0x0;
        } regup[0:0];
    } DHD0_CTRL @ 0xd000;
    reg {
        name = "DHD0_VSYNC1";
        desc = "DHD0_VSYNC1 is a DHD0 vertical timing control register. In interlaced output mode, this register indicates top field vertical sync timing. In progressive output mode, this register indicates frame vertical sync timing. This register is a non-instant register. DHD0_VSYNC1 (offset 0xD004, total reset 0x0028_0437; PROVEN: Hi3516D V300 data sheet, PDF page 585, section 9.2.6).";
        field {
            name = "vbb";
            desc = "In interlaced output mode: top vertical back blanking (TVBB) In progressive output mode: vertical back blanking (VBB) + vertical pulse width (VPW)";
            sw = rw; hw = r;
            reset = 0x28;
        } vbb[31:16];
        field {
            name = "vact";
            desc = "In interlaced output mode: height of an active image on the top field In progressive output mode: height of an active image in a frame. The configured value is the actual value minus 1.";
            sw = rw; hw = r;
            reset = 0x437;
        } vact[15:0];
    } DHD0_VSYNC1 @ 0xd004;
    reg {
        name = "DHD0_VSYNC2";
        desc = "DHD0_VSYNC2 is a DHD0 vertical timing control register. In interlaced output mode, this register indicates top field vertical sync timing. In progressive output mode, this register indicates frame vertical sync timing. This register is a non-instant register. DHD0_VSYNC2 (offset 0xD008, total reset 0x0000_0003; PROVEN: Hi3516D V300 data sheet, PDF page 585, section 9.2.6).";
        field {
            name = "reserved";
            desc = "Reserved";
            sw = r; hw = na;
            reset = 0x0;
        } reserved_31_16[31:16];
        field {
            name = "vfb";
            desc = "In interlaced output mode: top vertical front blanking (TVFB) In progressive output mode: vertical front blanking (VFB)";
            sw = rw; hw = r;
            reset = 0x3;
        } vfb[15:0];
    } DHD0_VSYNC2 @ 0xd008;
    reg {
        name = "DHD0_HSYNC1";
        desc = "DHD0_HSYNC1 is a DHD0 horizontal timing control register 1 (non-instant register). The register has the horizontal sync function in interlaced or progressive output mode. DHD0_HSYNC1 (offset 0xD00C, total reset 0x00BF_077F; PROVEN: Hi3516D V300 data sheet, PDF page 586, section 9.2.6).";
        field {
            name = "hbb";
            desc = "Horizontal back blanking (HBB), in pixels";
            sw = rw; hw = r;
            reset = 0xbf;
        } hbb[31:16];
        field {
            name = "hact";
            desc = "Number of horizontal pixels in an active region";
            sw = rw; hw = r;
            reset = 0x77f;
        } hact[15:0];
    } DHD0_HSYNC1 @ 0xd00c;
    reg {
        name = "DHD0_HSYNC2";
        desc = "DHD0_HSYNC2 is a DHD0 horizontal timing control register 2 (non-instant register). The register has the horizontal sync function in interlaced or progressive output mode. DHD0_HSYNC2 (offset 0xD010, total reset 0x0000_0057; PROVEN: Hi3516D V300 data sheet, PDF page 586, section 9.2.6).";
        field {
            name = "hmid";
            desc = "Active pixel for the bottom field vertical sync (active video region)";
            sw = rw; hw = r;
            reset = 0x0;
        } hmid[31:16];
        field {
            name = "hfb";
            desc = "HFB, in pixels";
            sw = rw; hw = r;
            reset = 0x57;
        } hfb[15:0];
    } DHD0_HSYNC2 @ 0xd010;
    reg {
        name = "DHD0_VPLUS1";
        desc = "DHD0_VPLUS1 is a DHD0 bottom field vertical timing control register in interlaced output mode (non-instant register). DHD0_VPLUS1 (offset 0xD014, total reset 0x0000_0000; PROVEN: Hi3516D V300 data sheet, PDF page 586, section 9.2.6).";
        field {
            name = "bvbb";
            desc = "Bottom vertical back blanking (BVBB) + VPW in interlaced output mode";
            sw = rw; hw = r;
            reset = 0x0;
        } bvbb[31:16];
        field {
            name = "bvact";
            desc = "Height of an active image in the bottom field";
            sw = rw; hw = r;
            reset = 0x0;
        } bvact[15:0];
    } DHD0_VPLUS1 @ 0xd014;
    reg {
        name = "DHD0_VPLUS2";
        desc = "DHD0_VPLUS2 is a DHD0 bottom field vertical timing control register in interlaced output mode (non-instant register). DHD0_VPLUS2 (offset 0xD018, total reset 0x0000_0000; PROVEN: Hi3516D V300 data sheet, PDF page 587, section 9.2.6).";
        field {
            name = "reserved";
            desc = "Reserved";
            sw = r; hw = na;
            reset = 0x0;
        } reserved_31_16[31:16];
        field {
            name = "bvfb";
            desc = "Bottom vertical front blanking (BVFB) in interlaced output mode";
            sw = rw; hw = r;
            reset = 0x0;
        } bvfb[15:0];
    } DHD0_VPLUS2 @ 0xd018;
    reg {
        name = "DHD0_PWR";
        desc = "DHD0_PWR is a sync signal pulse width register (non-instant register). DHD0_PWR (offset 0xD01C, total reset 0x0804_002B; PROVEN: Hi3516D V300 data sheet, PDF page 587, section 9.2.6).";
        field {
            name = "reserved";
            desc = "Reserved";
            sw = r; hw = na;
            reset = 0x0;
        } reserved_31_29[31:29];
        field {
            name = "multichn_en";
            desc = "DHD0 interface output mode select register
- 00: four pixels per cycle
- 00: one pixel per cycle
- 00: two pixels per cycle
- 11: three pixels per cycle";
            sw = rw; hw = r;
            reset = 0x1;
        } multichn_en[28:27];
        field {
            name = "reserved";
            desc = "Reserved";
            sw = r; hw = w;
            reset = 0x0;
        } reserved_26_24[26:24];
        field {
            name = "vpw";
            desc = "VPW. The configured value is the actual value minus 1.";
            sw = rw; hw = r;
            reset = 0x4;
        } vpw[23:16];
        field {
            name = "hpw";
            desc = "Horizontal pulse width (HPW). The configured value is the actual value minus 1.";
            sw = rw; hw = r;
            reset = 0x2b;
        } hpw[15:0];
    } DHD0_PWR @ 0xd01c;
    reg {
        name = "DHD0_VTTHD";
        desc = "DHD0_VTTHD is a vertical timing threshold register (instant register). It can be used to set two thresholds for generating two interrupts separately. DHD0_VTTHD (offset 0xD024, total reset 0x0001_0001; PROVEN: Hi3516D V300 data sheet, PDF page 587, section 9.2.6).";
        field {
            name = "thd2_mode";
            desc = "Mode of generating threshold 2 interrupts
- 0: frame mode. The threshold count is by frame.
- 1: field mode. The threshold count is by field during interlaced displaying.";
            sw = rw; hw = r;
            reset = 0x0;
        } thd2_mode[31:31];
        field {
            name = "reserved";
            desc = "Reserved";
            sw = r; hw = na;
            reset = 0x0;
        } reserved_30_29[30:29];
        field {
            name = "vtmgthd2";
            desc = "Vertical timing threshold 2. When the vertical timing counter reaches this threshold, the VOINTSTA[dhdvtthd2_int] interrupt is triggered";
            sw = rw; hw = r;
            reset = 0x1;
        } vtmgthd2[28:16];
        field {
            name = "thd1_mode";
            desc = "Mode of generating threshold 1 interrupts
- 0: frame mode. The threshold count is by frame.
- 1: field mode. The threshold count is by field during interlaced displaying.";
            sw = rw; hw = r;
            reset = 0x0;
        } thd1_mode[15:15];
        field {
            name = "reserved";
            desc = "Reserved";
            sw = r; hw = na;
            reset = 0x0;
        } reserved_14_13[14:13];
        field {
            name = "vtmgthd1";
            desc = "Vertical timing threshold 1. When the vertical timing counter reaches this threshold, the VOINTSTA[dhdvtthd_int1] interrupt is triggered.";
            sw = rw; hw = r;
            reset = 0x1;
        } vtmgthd1[12:0];
    } DHD0_VTTHD @ 0xd024;
    reg {
        name = "DHD0_PARATHD";
        desc = "DHD0_PARATHD is a PARA coefficient update point threshold register. DHD0_PARATHD (offset 0xD028, total reset 0x0000_0002; PROVEN: Hi3516D V300 data sheet, PDF page 588, section 9.2.6).";
        field {
            name = "dfs_en";
            desc = "DFS enable control
- 0: disabled
- 1: enabled";
            sw = rw; hw = r;
            reset = 0x0;
        } dfs_en[31:31];
        field {
            name = "reserved";
            desc = "Reserved";
            sw = r; hw = na;
            reset = 0x0;
        } reserved_30_8[30:8];
        field {
            name = "para_thd";
            desc = "PARA coefficient update point threshold. It indicates the line where the update point occurs after the blanking interval. The line number starts from 0.";
            sw = rw; hw = r;
            reset = 0x2;
        } para_thd[7:0];
    } DHD0_PARATHD @ 0xd028;
    reg {
        name = "DHD0_START_POS";
        desc = "DHD0_START_POS is a DHD0 start signal start position register. DHD0_START_POS (offset 0xD030, total reset 0x00A3_030A; PROVEN: Hi3516D V300 data sheet, PDF page 589, section 9.2.6).";
        field {
            name = "reserved";
            desc = "Reserved";
            sw = r; hw = na;
            reset = 0xa;
        } reserved_31_20[31:20];
        field {
            name = "reserved";
            desc = "Reserved";
            sw = r; hw = na;
            reset = 0x3;
        } reserved_19_16[19:16];
        field {
            name = "timing_start_pos";
            desc = "Line where the timing_gen state machine starts to work before the active region";
            sw = rw; hw = r;
            reset = 0x3;
        } timing_start_pos[15:8];
        field {
            name = "start_pos";
            desc = "Line where the start signal is generated after the blanking interval. The line number starts from 0.";
            sw = rw; hw = r;
            reset = 0xa;
        } start_pos[7:0];
    } DHD0_START_POS @ 0xd030;
    reg {
        name = "DHD0_STATE";
        desc = "DHD0_STATE is a DHD0 status register. DHD0_STATE (offset 0xD088, total reset 0x0100_0006; PROVEN: Hi3516D V300 data sheet, PDF page 589, section 9.2.6).";
        field {
            name = "reserved";
            desc = "Reserved";
            sw = r; hw = na;
            reset = 0x0;
        } reserved_31_25[31:25];
        field {
            name = "reserved";
            desc = "Reserved";
            sw = r; hw = na;
            reset = 0x1;
        } reserved_24_24[24:24];
        field {
            name = "count_int";
            desc = "DHD0 interrupt count. The count value is increased by 1 each time a vertical timing interrupt is reported.";
            sw = r; hw = w;
            reset = 0x0;
        } count_int[23:16];
        field {
            name = "vcnt";
            desc = "DHD0 active display lines count, starting from 0. The line from vertical front blank to vertical back blank is the start line 0.";
            sw = r; hw = w;
            reset = 0x0;
        } vcnt[15:3];
        field {
            name = "bottom_field";
            desc = "DHD0 top/bottom field indicator
- 0: top field
- 1: bottom field";
            sw = r; hw = w;
            reset = 0x1;
        } bottom_field[2:2];
        field {
            name = "vblank";
            desc = "DHD0 blanking interval indicator
- 0: active region
- 1: blanking interval";
            sw = r; hw = w;
            reset = 0x1;
        } vblank[1:1];
        field {
            name = "vback_blank";
            desc = "DHD0 back blanking interval indicator
- 0: non-back blanking interval
- 1: back blanking interval";
            sw = r; hw = w;
            reset = 0x0;
        } vback_blank[0:0];
    } DHD0_STATE @ 0xd088;
    reg {
        name = "VO_MUX";
        desc = "VO_MUX is a VO interface multiplexing register. VO_MUX (offset 0xD090, total reset 0x0000_0000; PROVEN: Hi3516D V300 data sheet, PDF page 589, section 9.2.6).";
        field {
            name = "digital_sel";
            desc = "Digital interface data select. The default value is 00.
- 00: BT.1120
- 01: BT.656
- 10: LCD

Other values: reserved";
            sw = rw; hw = r;
            reset = 0x0;
        } digital_sel[31:28];
        field {
            name = "reserved";
            desc = "Reserved";
            sw = r; hw = na;
            reset = 0x0;
        } reserved_27_12[27:12];
        field {
            name = "bt_sel";
            desc = "BT.1120/BT.656 data select
- 0: DHD0 BT.1120/BT.656 (default)
- 1: reserved";
            sw = rw; hw = r;
            reset = 0x0;
        } bt_sel[11:8];
        field {
            name = "lcd_sel";
            desc = "LCD data select
- 0: DHD0 LCD (default)
- 1:reserved";
            sw = rw; hw = r;
            reset = 0x0;
        } lcd_sel[7:4];
        field {
            name = "mipi_sel";
            desc = "MIPI data select
- 00: DHD0 MIPI (default)
- 01: reserved
- 10: DHD0 MIPI 420";
            sw = rw; hw = r;
            reset = 0x0;
        } mipi_sel[3:0];
    } VO_MUX @ 0xd090;
    reg {
        name = "INTF0_DITHER_CTRL";
        desc = "INTF0_DITHER_CTRL is a dither control register. INTF0_DITHER_CTRL (offset 0xD0B0, total reset 0x0000_1500; PROVEN: Hi3516D V300 data sheet, PDF page 590, section 9.2.6).";
        field {
            name = "reserved";
            desc = "Reserved";
            sw = r; hw = na;
            reset = 0x0;
        } reserved_31_13[31:13];
        field {
            name = "o_data_width_dither";
            desc = "Data width of the output pixel
- 000: 5
- 001: 6
- 010: 7
- 011: 8
- 100: 9
- 101: 10";
            sw = rw; hw = r;
            reset = 0x5;
        } o_data_width_dither[12:10];
        field {
            name = "i_data_width_dither";
            desc = "Data width of the input pixel
- 000: 8
- 001: 9
- 010: 10
- 011: 11";
            sw = rw; hw = r;
            reset = 0x2;
        } i_data_width_dither[9:7];
        field {
            name = "dither_round_unlim";
            desc = "Round-off enable register for pixels beyond the threshold limit range
- 0: disabled
- 1: enable";
            sw = rw; hw = r;
            reset = 0x0;
        } dither_round_unlim[6:6];
        field {
            name = "dither_en";
            desc = "Dither enable select
- 0: disabled and directly bypassed
- 1: enabled";
            sw = rw; hw = r;
            reset = 0x0;
        } dither_en[5:5];
        field {
            name = "dither_mode";
            desc = "Dither output mode select
- 0: 12 bits-> 10 bits output. Lower bits are lost.
- 1: 12 bits-> 8 bits output. Lower bits are lost.";
            sw = rw; hw = r;
            reset = 0x0;
        } dither_mode[4:4];
        field {
            name = "dither_round";
            desc = "Dither round-off enable register
- 0: disabled
- 1: enable";
            sw = rw; hw = r;
            reset = 0x0;
        } dither_round[3:3];
        field {
            name = "dither_domain_mode";
            desc = "Dither time domain and spatial domain mode register
- 0: spatial domain
- 1: combination of time domain and spatial domain";
            sw = rw; hw = r;
            reset = 0x0;
        } dither_domain_mode[2:2];
        field {
            name = "dither_tap_mode";
            desc = "Dither cycle configuration
- 00: The cycle is 7.
- 01: The cycle is 15.
- 10: The cycle is 23.
- 11: The cycle is 31.";
            sw = rw; hw = r;
            reset = 0x0;
        } dither_tap_mode[1:0];
    } INTF0_DITHER_CTRL @ 0xd0b0;
    reg {
        name = "INTF_BT_CTRL";
        desc = "INTF_BT_CTRL is a BT interface channel configuration register. INTF_BT_CTRL (offset 0xD200, total reset 0x0000_0000; PROVEN: Hi3516D V300 data sheet, PDF page 591, section 9.2.6).";
        field {
            name = "reserved";
            desc = "Reserved";
            sw = r; hw = na;
            reset = 0x0;
        } reserved_31_25[31:25];
        field {
            name = "yc_mode";
            desc = "BT.1120 Y/C output sequence
- 0: Y -> C from the MSB to the LSB
- 1: C -> Y from the MSB to the LSB (data sheet access type WR)";
            sw = rw; hw = r;
            reset = 0x0;
        } yc_mode[24:24];
        field {
            name = "reserved";
            desc = "Reserved";
            sw = r; hw = na;
            reset = 0x0;
        } reserved_23_0[23:0];
    } INTF_BT_CTRL @ 0xd200;
    reg {
        name = "INTF_BT_UPD";
        desc = "INTF_BT_UPD is an INTF_BT update register. INTF_BT_UPD (offset 0xD204, total reset 0x0000_0000; PROVEN: Hi3516D V300 data sheet, PDF page 592, section 9.2.6).";
        field {
            name = "reserved";
            desc = "Reserved";
            sw = r; hw = na;
            reset = 0x0;
        } reserved_31_1[31:1];
        field {
            name = "regup";
            desc = "Update register. After the registers at this layer are configured, the registers are updated when the value 1 is written to this bit. After updates, this bit is automatically cleared by the hardware. (data sheet access type WC)";
            sw = rw; hw = r; onwrite = woclr;
            reset = 0x0;
        } regup[0:0];
    } INTF_BT_UPD @ 0xd204;
    reg {
        name = "INTF_BT_SYNC_INV";
        desc = "INTF_BT_SYNC_INV is a sync signal polarity configuration register in external sync timing output mode. The setting of this register takes effect immediately after configuration, that is, the polarity of the corresponding sync signal is immediately affected. INTF_BT_SYNC_INV (offset 0xD208, total reset 0x0000_0000; PROVEN: Hi3516D V300 data sheet, PDF page 592, section 9.2.6).";
        field {
            name = "reserved";
            desc = "Reserved";
            sw = r; hw = na;
            reset = 0x0;
        } reserved_31_4[31:4];
        field {
            name = "f_inv";
            desc = "Output phase inversion enable for the odd/even field indicator signal (instant)
- 0: disabled
- 1: enabled";
            sw = rw; hw = r;
            reset = 0x0;
        } f_inv[3:3];
        field {
            name = "vs_inv";
            desc = "Output phase inversion enable for the vertical sync pulse (instant)
- 0: disabled
- 1: enabled";
            sw = rw; hw = r;
            reset = 0x0;
        } vs_inv[2:2];
        field {
            name = "hs_inv";
            desc = "Output phase inversion enable for the horizontal sync pulse (instant)
- 0: disabled
- 1: enabled";
            sw = rw; hw = r;
            reset = 0x0;
        } hs_inv[1:1];
        field {
            name = "dv_inv";
            desc = "Output phase inversion enable for the data validity signal (instant)
- 0: disabled
- 1: enabled";
            sw = rw; hw = r;
            reset = 0x0;
        } dv_inv[0:0];
    } INTF_BT_SYNC_INV @ 0xd208;
    reg {
        name = "BT_CLIP0_L";
        desc = "BT_CLIP0_L is a BT.1120 clip lowest threshold register (instant register). BT_CLIP0_L (offset 0xD210, total reset 0x0000_0000; PROVEN: Hi3516D V300 data sheet, PDF page 593, section 9.2.6).";
        field {
            name = "clip_en";
            desc = "Clip enable
- 0: disabled
- 1: enabled";
            sw = rw; hw = r;
            reset = 0x0;
        } clip_en[31:31];
        field {
            name = "reserved";
            desc = "Reserved";
            sw = r; hw = na;
            reset = 0x0;
        } reserved_30_30[30:30];
        field {
            name = "clip_cl2";
            desc = "Lowest threshold Y/R of component 2, unsigned integer";
            sw = rw; hw = r;
            reset = 0x0;
        } clip_cl2[29:20];
        field {
            name = "clip_cl1";
            desc = "Lowest threshold Cb/G of component 1, unsigned integer";
            sw = rw; hw = r;
            reset = 0x0;
        } clip_cl1[19:10];
        field {
            name = "clip_cl0";
            desc = "Lowest threshold Cr/B of component 0, unsigned integer";
            sw = rw; hw = r;
            reset = 0x0;
        } clip_cl0[9:0];
    } BT_CLIP0_L @ 0xd210;
    reg {
        name = "BT_CLIP0_H";
        desc = "BT_CLIP0_H is a BT.1120 clip highest threshold register (instant register). BT_CLIP0_H (offset 0xD214, total reset 0x3FFF_FFFF; PROVEN: Hi3516D V300 data sheet, PDF page 593, section 9.2.6).";
        field {
            name = "reserved";
            desc = "Reserved";
            sw = r; hw = na;
            reset = 0x0;
        } reserved_31_30[31:30];
        field {
            name = "clip_ch2";
            desc = "Highest threshold Y/R of component 2, unsigned integer";
            sw = rw; hw = r;
            reset = 0x3ff;
        } clip_ch2[29:20];
        field {
            name = "clip_ch1";
            desc = "Highest threshold Cb/G of component 1, unsigned integer";
            sw = rw; hw = r;
            reset = 0x3ff;
        } clip_ch1[19:10];
        field {
            name = "clip_ch0";
            desc = "Highest threshold Cr/B of component 0, unsigned integer";
            sw = rw; hw = r;
            reset = 0x3ff;
        } clip_ch0[9:0];
    } BT_CLIP0_H @ 0xd214;
    reg {
        name = "INTF_LCD_CTRL";
        desc = "INTF_LCD_CTRL is an interface channel configuration register. INTF_LCD_CTRL (offset 0xD300, total reset 0x0000_0000; PROVEN: Hi3516D V300 data sheet, PDF page 593, section 9.2.6).";
        field {
            name = "reserved";
            desc = "Reserved";
            sw = r; hw = na;
            reset = 0x0;
        } reserved_31_31[31:31];
        field {
            name = "reserved";
            desc = "Reserved";
            sw = r; hw = na;
            reset = 0x0;
        } reserved_30_30[30:30];
        field {
            name = "lcd_serial_mode";
            desc = "LCD mode
- 0: parallel mode
- 1: serial mode";
            sw = rw; hw = r;
            reset = 0x0;
        } lcd_serial_mode[29:29];
        field {
            name = "lcd_serial_perd";
            desc = "Number of output single-pixel clock cycles in serial LCD mode
- 0: 3
- 1: 4";
            sw = rw; hw = r;
            reset = 0x0;
        } lcd_serial_perd[28:28];
        field {
            name = "lcd_parallel_order";
            desc = "LCD parallel output sequence
- 0: RGB
- 1: BGR";
            sw = rw; hw = r;
            reset = 0x0;
        } lcd_parallel_order[27:27];
        field {
            name = "lcd_data_inv";
            desc = "Inversion of the LCD output bits
- 0: Bits 15−0 are from upper bits to lower bits.
- 1: Bits 0−15 are from upper bits to lower bits.";
            sw = rw; hw = r;
            reset = 0x0;
        } lcd_data_inv[26:26];
        field {
            name = "lcd_parallel_mode";
            desc = "LCD parallel output mode
- 0: RGB565
- 1: RGB888";
            sw = rw; hw = r;
            reset = 0x0;
        } lcd_parallel_mode[25:25];
        field {
            name = "reserved";
            desc = "Reserved";
            sw = r; hw = na;
            reset = 0x0;
        } reserved_24_0[24:0];
    } INTF_LCD_CTRL @ 0xd300;
    reg {
        name = "INTF_LCD_UPD";
        desc = "INTF_LCD_UPD is an INTF_LCD update register. INTF_LCD_UPD (offset 0xD304, total reset 0x0000_0000; PROVEN: Hi3516D V300 data sheet, PDF page 594, section 9.2.6).";
        field {
            name = "reserved";
            desc = "Reserved";
            sw = r; hw = na;
            reset = 0x0;
        } reserved_31_1[31:1];
        field {
            name = "regup";
            desc = "Update register. After the registers at this layer are configured, the registers are updated when the value 1 is written to this bit. After updates, this bit is automatically cleared by the hardware. (data sheet access type WC)";
            sw = rw; hw = r; onwrite = woclr;
            reset = 0x0;
        } regup[0:0];
    } INTF_LCD_UPD @ 0xd304;
    reg {
        name = "INTF_LCD_SYNC_INV";
        desc = "INTF_LCD_SYNC_INV is a sync signal polarity configuration register in LCD external sync timing input mode. The setting of this register takes effect immediately after configuration, that is, the polarity of the corresponding sync signal is immediately affected. INTF_LCD_SYNC_INV (offset 0xD308, total reset 0x0000_0000; PROVEN: Hi3516D V300 data sheet, PDF page 594, section 9.2.6).";
        field {
            name = "reserved";
            desc = "Reserved";
            sw = r; hw = na;
            reset = 0x0;
        } reserved_31_4[31:4];
        field {
            name = "f_inv";
            desc = "Output phase inversion enable for the odd/even field indicator signal (instant)
- 0: disabled
- 1: enabled";
            sw = rw; hw = r;
            reset = 0x0;
        } f_inv[3:3];
        field {
            name = "vs_inv";
            desc = "Output phase inversion enable for the vertical sync pulse (instant)
- 0: disabled
- 1: enabled";
            sw = rw; hw = r;
            reset = 0x0;
        } vs_inv[2:2];
        field {
            name = "hs_inv";
            desc = "Output phase inversion enable for the horizontal sync pulse (instant)
- 0: disabled
- 1: enabled";
            sw = rw; hw = r;
            reset = 0x0;
        } hs_inv[1:1];
        field {
            name = "dv_inv";
            desc = "Output phase inversion enable for the data validity signal (instant)
- 0: disabled
- 1: enabled";
            sw = rw; hw = r;
            reset = 0x0;
        } dv_inv[0:0];
    } INTF_LCD_SYNC_INV @ 0xd308;
    reg {
        name = "MAC_OUTSTANDING";
        desc = "MAC_OUTSTANDING is an outstanding register. MAC_OUTSTANDING (offset 0x10000, total reset 0x0000_007F; PROVEN: Hi3516D V300 data sheet, PDF page 595, section 9.2.6).";
        field {
            name = "reserved";
            desc = "Reserved";
            sw = r; hw = na;
            reset = 0x0;
        } reserved_31_8[31:8];
        field {
            name = "mstr0_woutstanding";
            desc = "Master 0 write outstanding";
            sw = rw; hw = r;
            reset = 0x7;
        } mstr0_woutstanding[7:4];
        field {
            name = "mstr0_routstanding";
            desc = "Master 0 read outstanding";
            sw = rw; hw = r;
            reset = 0xf;
        } mstr0_routstanding[3:0];
    } MAC_OUTSTANDING @ 0x10000;
    reg {
        name = "VID_READ_CTRL";
        desc = "VID_READ_CTRL is a VID FDR read control register (non-instant register). VID_READ_CTRL (offset 0x10200, total reset 0x0002_0000; PROVEN: Hi3516D V300 data sheet, PDF page 595, section 9.2.6).";
        field {
            name = "reserved";
            desc = "Reserved";
            sw = r; hw = na;
            reset = 0x40;
        } reserved_31_7[31:7];
        field {
            name = "lm_rmode";
            desc = "Chrominance read mode register
- 0: The read mode is bound to the interface.
- 1: The data is read in progressive mode.
- 2: The top field is read in interlaced mode.
- 3: The bottom field is read in interlaced mode. 4–7: reserved";
            sw = rw; hw = r;
            reset = 0x0;
        } lm_rmode[6:4];
        field {
            name = "reserved";
            desc = "Reserved";
            sw = r; hw = na;
            reset = 0x0;
        } reserved_3_3[3:3];
        field {
            name = "chm_rmode";
            desc = "Chrominance read mode register
- 0: The read mode is bound to the interface.
- 1: The data is read in progressive mode.
- 2: The top field is read in interlaced mode.
- 3: The bottom field is read in interlaced mode. 4–7: reserved";
            sw = rw; hw = r;
            reset = 0x0;
        } chm_rmode[2:0];
    } VID_READ_CTRL @ 0x10200;
    reg {
        name = "VID_OUT_CTRL";
        desc = "VID_OUT_CTRL is a VID FDR output control register (non-instant register). VID_OUT_CTRL (offset 0x10210, total reset 0x0000_0000; PROVEN: Hi3516D V300 data sheet, PDF page 596, section 9.2.6).";
        field {
            name = "reserved";
            desc = "Reserved";
            sw = r; hw = na;
            reset = 0x0;
        } reserved_31_5[31:5];
        field {
            name = "uv_order_en";
            desc = "UV sequence register of the input YUV data format
- 0: U for upper bits
- 1: V for upper bits";
            sw = rw; hw = r;
            reset = 0x0;
        } uv_order_en[4:4];
        field {
            name = "reserved";
            desc = "Reserved";
            sw = r; hw = w;
            reset = 0x0;
        } reserved_3_0[3:0];
    } VID_OUT_CTRL @ 0x10210;
    reg {
        name = "VID_SRC_INFO";
        desc = "VID_SRC_INFO is a VID FDR input picture attribute register (non-instant register). VID_SRC_INFO (offset 0x10240, total reset 0x0000_0000; PROVEN: Hi3516D V300 data sheet, PDF page 596, section 9.2.6).";
        field {
            name = "reserved";
            desc = "Reserved";
            sw = r; hw = na;
            reset = 0x0;
        } reserved_31_21[31:21];
        field {
            name = "dcmp_en";
            desc = "Input picture compression mode
- 0: uncompressed
- 1: compressed";
            sw = rw; hw = r;
            reset = 0x0;
        } dcmp_en[20:20];
        field {
            name = "reserved";
            desc = "Reserved";
            sw = r; hw = na;
            reset = 0x0;
        } reserved_19_5[19:5];
        field {
            name = "data_fmt";
            desc = "Input data format
- 00: linear
- 01: tile
- 10: PKG
- 11: reserved (equivalent to 0)";
            sw = rw; hw = r;
            reset = 0x0;
        } data_fmt[4:3];
        field {
            name = "data_type";
            desc = "Input data type
- 000: reserved. The default value is YUV422.
- 001: YUV400
- 010: YUV420
- 011: YUV422
- 100: YUV444
- 101: RGB888
- 110: ARGB8888

Other values: reserved (equivalent to 0)";
            sw = rw; hw = r;
            reset = 0x0;
        } data_type[2:0];
    } VID_SRC_INFO @ 0x10240;
    reg {
        name = "VID_SRC_RESO";
        desc = "VID_SRC_RESO is an original picture resolution register (non-instant register). VID_SRC_RESO (offset 0x10244, total reset 0x0000_0000; PROVEN: Hi3516D V300 data sheet, PDF page 597, section 9.2.6).";
        field {
            name = "src_h";
            desc = "Height (in lines). The configured value is the actual height minus 1. The frame height is referenced and its unit is line.";
            sw = rw; hw = r;
            reset = 0x0;
        } src_h[31:16];
        field {
            name = "src_w";
            desc = "Width (in pixels). The configured value is the actual width minus 1.";
            sw = rw; hw = r;
            reset = 0x0;
        } src_w[15:0];
    } VID_SRC_RESO @ 0x10244;
    reg {
        name = "VID_SRC_CROP";
        desc = "VID_SRC_CROP is an original picture crop register (non-instant register). VID_SRC_CROP (offset 0x10248, total reset 0x0000_0000; PROVEN: Hi3516D V300 data sheet, PDF page 597, section 9.2.6).";
        field {
            name = "Heightsrc_crop_yactual";
            desc = "(in lines). The configured value is the crop value.";
            sw = rw; hw = r;
            reset = 0x0;
        } Heightsrc_crop_yactual[31:16];
        field {
            name = "Widthsrc_crop_xactual";
            desc = "(in pixels). The configured value is the crop value.";
            sw = rw; hw = r;
            reset = 0x0;
        } Widthsrc_crop_xactual[15:0];
    } VID_SRC_CROP @ 0x10248;
    reg {
        name = "VID_IN_RESO";
        desc = "VID_IN_RESO is a VID input picture resolution register (non-instant register). VID_IN_RESO (offset 0x1024C, total reset 0x0000_0000; PROVEN: Hi3516D V300 data sheet, PDF page 598, section 9.2.6).";
        field {
            name = "ireso_h";
            desc = "Height (in lines). The configured value is the actual height minus 1. The frame height is referenced and its unit is line.";
            sw = rw; hw = r;
            reset = 0x0;
        } ireso_h[31:16];
        field {
            name = "ireso_w";
            desc = "Width (in pixels). The configured value is the actual width minus 1.";
            sw = rw; hw = r;
            reset = 0x0;
        } ireso_w[15:0];
    } VID_IN_RESO @ 0x1024c;
    reg {
        name = "ICE_V3R2_SEG_DCMP_GLB_INFO";
        desc = "ICE_V3R2_SEG_DCMP_GLB_INFO is a decompression control register. ICE_V3R2_SEG_DCMP_GLB_INFO (offset 0x10380, total reset 0x0000_0005; PROVEN: Hi3516D V300 data sheet, PDF page 598, section 9.2.6).";
        field {
            name = "reserved";
            desc = "Reserved";
            sw = r; hw = na;
            reset = 0x0;
        } reserved_31_3[31:3];
        field {
            name = "cmp_mode";
            desc = "Compression mode
- 0: compression
- 1: raw mode";
            sw = rw; hw = r;
            reset = 0x1;
        } cmp_mode[2:2];
        field {
            name = "is_lossless";
            desc = "Whether lossless compression is enabled
- 0: No. Lossy compression mode with fixed bandwidth is enabled.
- 1: Yes.";
            sw = rw; hw = r;
            reset = 0x0;
        } is_lossless[1:1];
        field {
            name = "ice_en";
            desc = "Compression enable
- 0: disabled
- 1: enabled";
            sw = rw; hw = r;
            reset = 0x1;
        } ice_en[0:0];
    } ICE_V3R2_SEG_DCMP_GLB_INFO @ 0x10380;
    reg {
        name = "ICE_V3R2_SEG_DCMP_GLB_INFO_CHM";
        desc = "ICE_V3R2_SEG_DCMP_GLB_INFO_CHM is a decompression control register. ICE_V3R2_SEG_DCMP_GLB_INFO_CHM (offset 0x103C0, total reset 0x0000_0005; PROVEN: Hi3516D V300 data sheet, PDF page 598, section 9.2.6).";
        field {
            name = "reserved";
            desc = "Reserved";
            sw = r; hw = na;
            reset = 0x0;
        } reserved_31_3[31:3];
        field {
            name = "cmp_mode";
            desc = "Compression mode
- 0: compression";
            sw = rw; hw = r;
            reset = 0x1;
        } cmp_mode[2:2];
        field {
            name = "is_lossless";
            desc = "Whether lossless compression is enabled
- 0: No. Lossy compression mode with fixed bandwidth is enabled.
- 1: Yes.";
            sw = rw; hw = r;
            reset = 0x0;
        } is_lossless[1:1];
        field {
            name = "ice_en";
            desc = "Compression enable
- 0: disabled
- 1: enabled";
            sw = rw; hw = r;
            reset = 0x1;
        } ice_en[0:0];
    } ICE_V3R2_SEG_DCMP_GLB_INFO_CHM @ 0x103c0;
    reg {
        name = "GFX_OUT_CTRL";
        desc = "GFX_OUT_CTRL is a GFX FDR output control register (non-instant register). GFX_OUT_CTRL (offset 0x10E08, total reset 0x0000_0000; PROVEN: Hi3516D V300 data sheet, PDF page 599, section 9.2.6).";
        field {
            name = "reserved";
            desc = "Reserved";
            sw = r; hw = na;
            reset = 0x0;
        } reserved_31_11[31:11];
        field {
            name = "premulti_en";
            desc = "GFX premultiplication enable register
- 0: enabled
- 1: disabled";
            sw = rw; hw = r;
            reset = 0x0;
        } premulti_en[10:10];
        field {
            name = "bitext";
            desc = "Bit extend mode of the input bitmap
- 00: extend 0s to lower bits
- 10: extend the value of the MSB to a lower bit
- 11: extend the values of upper bits to lower bits";
            sw = rw; hw = r;
            reset = 0x0;
        } bitext[9:8];
        field {
            name = "reserved";
            desc = "Reserved";
            sw = r; hw = na;
            reset = 0x0;
        } reserved_7_6[7:6];
        field {
            name = "key_en";
            desc = "Colorkey enable
- 0: disabled
- 1: enabled";
            sw = rw; hw = r;
            reset = 0x0;
        } key_en[5:5];
        field {
            name = "key_mode";
            desc = "Colorkey mode
- 0: The color is regarded as the colorkey when the following condition is met: Keymin ≤

Pixel ≤ Keymax
- 1: The color is regarded as the colorkey when either of the following conditions is met: Pixel ≤ Keymin or Pixel ≥ Keymax";
            sw = rw; hw = r;
            reset = 0x0;
        } key_mode[4:4];
        field {
            name = "reserved";
            desc = "Reserved";
            sw = r; hw = na;
            reset = 0x0;
        } reserved_3_2[3:2];
        field {
            name = "palpha_en";
            desc = "Pixel alpha enable
- 0: disabled
- 1: enabled";
            sw = rw; hw = r;
            reset = 0x0;
        } palpha_en[1:1];
        field {
            name = "palpha_range";
            desc = "Alpha range select of the pixel
- 0: The alpha range of the pixel is 0–128.
- 1: The alpha range of the pixel is 0–255.";
            sw = rw; hw = r;
            reset = 0x0;
        } palpha_range[0:0];
    } GFX_OUT_CTRL @ 0x10e08;
    reg {
        name = "GFX_1555_ALPHA";
        desc = "GFX_1555_ALPHA is an alpha value register in ARGB1555 format (non-instant register). GFX_1555_ALPHA (offset 0x10E28, total reset 0x0000_0000; PROVEN: Hi3516D V300 data sheet, PDF page 600, section 9.2.6).";
        field {
            name = "reserved";
            desc = "Reserved";
            sw = r; hw = na;
            reset = 0x0;
        } reserved_31_16[31:16];
        field {
            name = "alpha_1";
            desc = "Alpha1 value. When the data format is alphaRGB1555 and the alpha value is 1, the alpha1 value is used.";
            sw = rw; hw = r;
            reset = 0x0;
        } alpha_1[15:8];
        field {
            name = "alpha_0";
            desc = "Alpha0 value. When the data format is alphaRGB1555 and the alpha value is 1, the alpha0 value is used.";
            sw = rw; hw = r;
            reset = 0x0;
        } alpha_0[7:0];
    } GFX_1555_ALPHA @ 0x10e28;
    reg {
        name = "GFX_SRC_INFO";
        desc = "GFX_SRC_INFO is a GFX FDR original picture attribute register (non-instant register). GFX_SRC_INFO (offset 0x10E40, total reset 0x0000_0000; PROVEN: Hi3516D V300 data sheet, PDF page 600, section 9.2.6).";
        field {
            name = "reserved";
            desc = "Reserved";
            sw = r; hw = na;
            reset = 0x0;
        } reserved_31_21[31:21];
        field {
            name = "dcmp_en";
            desc = "Input picture compression mode
- 0: uncompressed
- 1: compressed";
            sw = rw; hw = r;
            reset = 0x0;
        } dcmp_en[20:20];
        field {
            name = "reserved";
            desc = "Reserved";
            sw = r; hw = w;
            reset = 0x0;
        } reserved_19_8[19:8];
        field {
            name = "ifmt";
            desc = "Input data format
- 0x00: CLUT 1 bpp
- 0x10: CLUT 2 bpp
- 0x20: CLUT 4 bpp
- 0x30: CLUT 8 bpp
- 0x38: ACLUT44
- 0x40: RGB444";
            sw = rw; hw = r;
            reset = 0x0;
        } ifmt[7:0];
    } GFX_SRC_INFO @ 0x10e40;
    reg {
        name = "GFX_SRC_RESO";
        desc = "GFX_SRC_RESO is an original picture resolution register (non-instant register). GFX_SRC_RESO (offset 0x10E44, total reset 0x0000_0000; PROVEN: Hi3516D V300 data sheet, PDF page 601, section 9.2.6).";
        field {
            name = "src_h";
            desc = "Height (in lines). The configured value is the actual height minus 1. The frame height is referenced and its unit is line.";
            sw = rw; hw = r;
            reset = 0x0;
        } src_h[31:16];
        field {
            name = "src_w";
            desc = "Width (in pixels). The configured value is the actual width minus 1.";
            sw = rw; hw = r;
            reset = 0x0;
        } src_w[15:0];
    } GFX_SRC_RESO @ 0x10e44;
    reg {
        name = "GFX_SRC_CROP";
        desc = "GFX_SRC_CROP is an original picture crop register (non-instant register). GFX_SRC_CROP (offset 0x10E48, total reset 0x0000_0000; PROVEN: Hi3516D V300 data sheet, PDF page 601, section 9.2.6).";
        field {
            name = "src_crop_y";
            desc = "Height (in lines). The configured value is the crop value of the upper original picture.";
            sw = rw; hw = r;
            reset = 0x0;
        } src_crop_y[31:16];
        field {
            name = "src_crop_x";
            desc = "Width (in pixels). The configured value is the crop value of the left original picture. (The original coordinate offset function is implemented by this register.)";
            sw = rw; hw = r;
            reset = 0x0;
        } src_crop_x[15:0];
    } GFX_SRC_CROP @ 0x10e48;
    reg {
        name = "GFX_IRESO";
        desc = "GFX_IRESO is an input resolution register (non-instant register). GFX_IRESO (offset 0x10E4C, total reset 0x0000_0000; PROVEN: Hi3516D V300 data sheet, PDF page 602, section 9.2.6).";
        field {
            name = "ireso_h";
            desc = "Height (in lines). The configured value is the actual height minus 1. Note: The actual layer height must be an even number.";
            sw = rw; hw = r;
            reset = 0x0;
        } ireso_h[31:16];
        field {
            name = "ireso_w";
            desc = "Width (in pixels). The configured value is the actual width minus 1. Note: The actual layer width must be an even number.";
            sw = rw; hw = r;
            reset = 0x0;
        } ireso_w[15:0];
    } GFX_IRESO @ 0x10e4c;
    reg {
        name = "GFX_CKEY_MAX";
        desc = "GFX_CKEY_MAX is a maximum colorkey register (non-instant register). GFX_CKEY_MAX (offset 0x10F00, total reset 0x0000_0000; PROVEN: Hi3516D V300 data sheet, PDF page 602, section 9.2.6).";
        field {
            name = "reserved";
            desc = "Reserved";
            sw = r; hw = na;
            reset = 0x0;
        } reserved_31_24[31:24];
        field {
            name = "key_r_max";
            desc = "Maximum value of the color key R component";
            sw = rw; hw = r;
            reset = 0x0;
        } key_r_max[23:16];
        field {
            name = "key_g_max";
            desc = "Maximum value of the color key G component";
            sw = rw; hw = r;
            reset = 0x0;
        } key_g_max[15:8];
        field {
            name = "key_b_max";
            desc = "Maximum value of the color key B component";
            sw = rw; hw = r;
            reset = 0x0;
        } key_b_max[7:0];
    } GFX_CKEY_MAX @ 0x10f00;
    reg {
        name = "GFX_CKEY_MIN";
        desc = "GFX_CKEY_MIN is a minimum colorkey register (non-instant register). GFX_CKEY_MIN (offset 0x10F04, total reset 0x0000_0000; PROVEN: Hi3516D V300 data sheet, PDF page 602, section 9.2.6).";
        field {
            name = "reserved";
            desc = "Reserved";
            sw = r; hw = na;
            reset = 0x0;
        } reserved_31_24[31:24];
        field {
            name = "key_r_min";
            desc = "Minimum value of the color key R component";
            sw = rw; hw = r;
            reset = 0x0;
        } key_r_min[23:16];
        field {
            name = "key_g_min";
            desc = "Minimum value of the color key G component";
            sw = rw; hw = r;
            reset = 0x0;
        } key_g_min[15:8];
        field {
            name = "key_b_min";
            desc = "Minimum value of the color key B component";
            sw = rw; hw = r;
            reset = 0x0;
        } key_b_min[7:0];
    } GFX_CKEY_MIN @ 0x10f04;
    reg {
        name = "GFX_CKEY_MASK";
        desc = "GFX_CKEY_MASK is a masked colorkey register (non-instant register). The value 1 indicates that the bit corresponding to a pixel is retained during colorkey comparison; the value 0 indicates that the bit corresponding to a pixel is forcibly set to 0 during color comparison no matter whether the bit is 0 or 1. GFX_CKEY_MASK (offset 0x10F08, total reset 0x00FF_FFFF; PROVEN: Hi3516D V300 data sheet, PDF page 603, section 9.2.6).";
        field {
            name = "reserved";
            desc = "Reserved";
            sw = r; hw = na;
            reset = 0x0;
        } reserved_31_24[31:24];
        field {
            name = "key_r_msk";
            desc = "R component of the masked colorkey";
            sw = rw; hw = r;
            reset = 0xff;
        } key_r_msk[23:16];
        field {
            name = "key_g_msk";
            desc = "G component of the masked colorkey";
            sw = rw; hw = r;
            reset = 0xff;
        } key_g_msk[15:8];
        field {
            name = "key_b_msk";
            desc = "B component of the masked colorkey";
            sw = rw; hw = r;
            reset = 0xff;
        } key_b_msk[7:0];
    } GFX_CKEY_MASK @ 0x10f08;
};

`endif
