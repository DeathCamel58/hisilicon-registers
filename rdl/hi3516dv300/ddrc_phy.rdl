`ifndef EHI3516DV300_DDRC_PHY_RDL
`define EHI3516DV300_DDRC_PHY_RDL
regfile eHI3516DV300_DDRC_PHY {
    name = "DDRC DDR PHY";
    desc = "DDRC DDR PHY. 11 registers extracted programmatically from the Hi3516D V300 Professional Smart IP Camera SoC data sheet (Issue 01, 2019-09-12); chapter 4.1.9, table 4-10. Field names, bit ranges, access types and reset values are taken from the register tables; reset values are the data sheet total reset values split onto the fields (per-field values where the table has them). Label: PROVEN. Hardware not verified here (no board).";
    reg {
        name = "DRAMTIMER0";
        desc = "DRAMTIMER0 is DDR PHY timing parameter register 0. DRAMTIMER0 (offset 0x030, total reset 0x0000_0000; PROVEN: Hi3516D V300 data sheet, PDF page 341, section 4.1.9.2).";
        field {
            name = "t_rc";
            desc = "Number of wait cycles from an ACT bank command to the next ACT bank command Unit: 4xnCK";
            sw = rw; hw = r;
            reset = 0x0;
        } t_rc[31:26];
        field {
            name = "t_rrd";
            desc = "Number of wait cycles from ACT bank A to ACT bank B Unit: 4xnCK";
            sw = rw; hw = r;
            reset = 0x0;
        } t_rrd[25:22];
        field {
            name = "t_ras";
            desc = "Number of wait cycles from the ACT bank command to the PRE command Unit: 4xnCK";
            sw = rw; hw = r;
            reset = 0x0;
        } t_ras[21:16];
        field {
            name = "t_rcd";
            desc = "Number of wait cycles from the ACT bank command to the read or write command Unit: 8xnCK";
            sw = rw; hw = r;
            reset = 0x0;
        } t_rcd[15:12];
        field {
            name = "t_rp";
            desc = "Number of wait cycles for the PRE command (PRE period) Unit: 8xnCK";
            sw = rw; hw = r;
            reset = 0x0;
        } t_rp[11:8];
        field {
            name = "t_wtr";
            desc = "Number of wait cycles for the last write data in the write operation to the read command (write-to-read) Unit: 4xnCK";
            sw = rw; hw = r;
            reset = 0x0;
        } t_wtr[7:4];
        field {
            name = "t_rtp";
            desc = "Wait delay from the read command to the PRE command Unit: 16xnCK";
            sw = rw; hw = r;
            reset = 0x0;
        } t_rtp[3:0];
    } DRAMTIMER0 @ 0x30;
    reg {
        name = "DRAMTIMER1";
        desc = "DRAMTIMER1 is DDR PHY timing parameter register 1. DRAMTIMER1 (offset 0x034, total reset 0x0000_0000; PROVEN: Hi3516D V300 data sheet, PDF page 342, section 4.1.9.2).";
        field {
            name = "reserved";
            desc = "Reserved";
            sw = r; hw = w;
            reset = 0x0;
        } reserved_31_30[31:30];
        field {
            name = "t_rtw";
            desc = "Delay from the last read data command to the first write data command Unit: 1xnCK";
            sw = rw; hw = r;
            reset = 0x0;
        } t_rtw[29:25];
        field {
            name = "t_rfc";
            desc = "Number of wait cycles from the auto-refresh command cycle (AREF period) or auto-refresh (AREF) to the ACT command Unit: 2xnCK";
            sw = rw; hw = r;
            reset = 0x0;
        } t_rfc[24:16];
        field {
            name = "reserved";
            desc = "Reserved";
            sw = r; hw = w;
            reset = 0x0;
        } reserved_15_15[15:15];
        field {
            name = "t_faw";
            desc = "Number of clock cycles for four consecutive activation commands Unit: 4xnCK";
            sw = rw; hw = r;
            reset = 0x0;
        } t_faw[14:9];
        field {
            name = "t_mod";
            desc = "Delay from the MRS command to ODT and ZQCL validity";
            sw = rw; hw = r;
            reset = 0x0;
        } t_mod[8:4];
        field {
            name = "t_mrd";
            desc = "Number of wait cycles for the LMR command";
            sw = rw; hw = r;
            reset = 0x0;
        } t_mrd[3:0];
    } DRAMTIMER1 @ 0x34;
    reg {
        name = "DRAMTIMER2";
        desc = "DRAMTIMER2 is DDR PHY timing parameter register 2. DRAMTIMER2 (offset 0x038, total reset 0x0000_0000; PROVEN: Hi3516D V300 data sheet, PDF page 343, section 4.1.9.2).";
        field {
            name = "t_ccd";
            desc = "Number of wait cycles from a read command to the next read command, or from a write command to the next write command
- 0 = BL/2
- 1 = BL/2 + 1

Unit: 1xnCK";
            sw = rw; hw = r;
            reset = 0x0;
        } t_ccd[31:31];
        field {
            name = "reserved";
            desc = "Reserved";
            sw = r; hw = w;
            reset = 0x0;
        } reserved_30_30[30:30];
        field {
            name = "t_dllk";
            desc = "DLL locking period Unit:1xnCK";
            sw = rw; hw = r;
            reset = 0x0;
        } t_dllk[29:20];
        field {
            name = "t_cke";
            desc = "Minimum cycle of retaining CKE validity Unit:4xnCK";
            sw = rw; hw = r;
            reset = 0x0;
        } t_cke[19:16];
        field {
            name = "reserved";
            desc = "Reserved";
            sw = r; hw = w;
            reset = 0x0;
        } reserved_15_15[15:15];
        field {
            name = "t_xp";
            desc = "Exit delay of the power-down mode The value must be greater than or equal to 2. Unit: 2xnCK";
            sw = rw; hw = r;
            reset = 0x0;
        } t_xp[14:10];
        field {
            name = "t_xs";
            desc = "Exit delay of the self-refresh mode Unit: 1xnCK";
            sw = rw; hw = r;
            reset = 0x0;
        } t_xs[9:0];
    } DRAMTIMER2 @ 0x38;
    reg {
        name = "DRAMTIMER3";
        desc = "DRAMTIMER3 is DDR PHY timing parameter register 3. DRAMTIMER3 (offset 0x03C, total reset 0x0210_0200; PROVEN: Hi3516D V300 data sheet, PDF page 343, section 4.1.9.2).";
        field {
            name = "t_wr";
            desc = "Number of wait cycles of write recovery Unit: 4xnCK";
            sw = rw; hw = r;
            reset = 0x0;
        } t_wr[31:28];
        field {
            name = "tdshtrain";
            desc = "VREF training timing parameter Unit: 1xdfi_clk";
            sw = rw; hw = r;
            reset = 0x2;
        } tdshtrain[27:24];
        field {
            name = "t_init5";
            desc = "Delay parameter of LPDDR device initialization Unit: 1xnCK";
            sw = rw; hw = r;
            reset = 0x400;
        } t_init5[23:10];
        field {
            name = "t_zcal";
            desc = "Number of wait cycles from ZQ calibration to valid command Unit: 2xnCK";
            sw = rw; hw = r;
            reset = 0x200;
        } t_zcal[9:0];
    } DRAMTIMER3 @ 0x3c;
    reg {
        name = "DRAMTIMER4";
        desc = "DRAMTIMER4 is DDR PHY timing parameter register 4. DRAMTIMER4 (offset 0x040, total reset 0x5034_0000; PROVEN: Hi3516D V300 data sheet, PDF page 344, section 4.1.9.2).";
        field {
            name = "t_ccd_ddr4";
            desc = "Number of delay cycles from a read command to the next read command and from a write command to the next write command in the same bank group of DDR4. The corresponding SDRAM timing parameter is t_ccd_l. Unit: 1xnCK";
            sw = rw; hw = r;
            reset = 0x5;
        } t_ccd_ddr4[31:28];
        field {
            name = "t_odton";
            desc = "Number of wait cycles for enabling ODT Unit: 1xnCK";
            sw = rw; hw = r;
            reset = 0x0;
        } t_odton[27:24];
        field {
            name = "reserved";
            desc = "Reserved";
            sw = r; hw = w;
            reset = 0x0;
        } reserved_23_23[23:23];
        field {
            name = "t_vref";
            desc = "Number of wait cycles for updating the VREF (DQ) Unit: 1xdfi_clk";
            sw = rw; hw = r;
            reset = 0x3;
        } t_vref[22:20];
        field {
            name = "t_ccd_s";
            desc = "Number of delay cycles from a read command to the next read command and from a write command to the next write command in different bank groups of DDR4 Unit: 1xnCK";
            sw = rw; hw = r;
            reset = 0x4;
        } t_ccd_s[19:16];
        field {
            name = "t_odt";
            desc = "Number of valid clock cycles of ODT Unit: 1xnCK";
            sw = rw; hw = r;
            reset = 0x0;
        } t_odt[15:12];
        field {
            name = "t_wlo";
            desc = "Number of wait cycles of the output result in write leveling mode Unit: 4xnCK";
            sw = rw; hw = r;
            reset = 0x0;
        } t_wlo[11:7];
        field {
            name = "t_wr_ext";
            desc = "Extension bit of the register used for configuring the t_wr timing parameter";
            sw = rw; hw = r;
            reset = 0x0;
        } t_wr_ext[6:6];
        field {
            name = "t_wlmrd";
            desc = "Number of wait cycles from entering write leveling mode to the first DQS or DQS# rising edge Unit: 1nCK";
            sw = rw; hw = r;
            reset = 0x0;
        } t_wlmrd[5:0];
    } DRAMTIMER4 @ 0x40;
    reg {
        name = "MODEREG01";
        desc = "MODEREG01 is the register for configuring the SDRAM mode. MODEREG01 (offset 0x0064, total reset 0x0000_0000; PROVEN: Hi3516D V300 data sheet, PDF page 345, section 4.1.9.2).";
        field {
            name = "mr1";
            desc = "Mode register 1";
            sw = rw; hw = r;
            reset = 0x0;
        } mr1[31:16];
        field {
            name = "mr0";
            desc = "Mode register 0";
            sw = rw; hw = r;
            reset = 0x0;
        } mr0[15:0];
    } MODEREG01 @ 0x64;
    reg {
        name = "MODEREG23";
        desc = "MODEREG23 is the register for configuring the SDRAM mode. MODEREG23 (offset 0x0068, total reset 0xFF0A_0000; PROVEN: Hi3516D V300 data sheet, PDF page 345, section 4.1.9.2).";
        field {
            name = "mr3";
            desc = "Mode register 3";
            sw = rw; hw = r;
            reset = 0xff0a;
        } mr3[31:16];
        field {
            name = "mr2";
            desc = "Mode register 2";
            sw = rw; hw = r;
            reset = 0x0;
        } mr2[15:0];
    } MODEREG23 @ 0x68;
    reg {
        name = "MISC";
        desc = "MISC is the control register with miscellaneous functions. MISC (offset 0x0070, total reset 0x0814_0000; PROVEN: Hi3516D V300 data sheet, PDF page 346, section 4.1.9.2).";
        field {
            name = "reserved";
            desc = "Reserved";
            sw = r; hw = w;
            reset = 0x0;
        } reserved_31_30[31:30];
        field {
            name = "swapwl_en";
            desc = "Swap selection of write leveling
- 000: no swap
- 001: swap 1
- 010: swap 2
- 011: swap 3
- 100: swap 4";
            sw = rw; hw = r;
            reset = 0x1;
        } swapwl_en[29:27];
        field {
            name = "swapdm_en";
            desc = "Swap selection of the DM bus
- 00: no swap
- 01: swap 1";
            sw = rw; hw = r;
            reset = 0x0;
        } swapdm_en[26:25];
        field {
            name = "reserved";
            desc = "Reserved";
            sw = r; hw = na;
            reset = 0x0;
        } reserved_24_24[24:24];
        field {
            name = "reserved";
            desc = "Reserved";
            sw = r; hw = na;
            reset = 0x0;
        } reserved_23_23[23:23];
        field {
            name = "swap_en";
            desc = "Swap selection of the DQ bus
- 000: no swap
- 001: swap 1
- 010: swap 2
- 011: swap 3
- 100: swap 4
- 105: swap 5";
            sw = rw; hw = r;
            reset = 0x1;
        } swap_en[22:20];
        field {
            name = "cfg_dlyupd";
            desc = "When this parameter is set to 1, the delay parameters configured by any other register are immediately applied to the DDRPHY.";
            sw = rw; hw = r;
            reset = 0x0;
        } cfg_dlyupd[19:19];
        field {
            name = "addr_delay";
            desc = "A 1T delay is added to the address or command bus.";
            sw = rw; hw = r;
            reset = 0x1;
        } addr_delay[18:18];
        field {
            name = "addr_toggle";
            desc = "When this parameter is set to 1, the address bus is switched in each clock cycle.";
            sw = rw; hw = r;
            reset = 0x0;
        } addr_toggle[17:17];
        field {
            name = "scramb_en";
            desc = "Data scrambling enable
- 1: enabled
- 0: disabled";
            sw = rw; hw = r;
            reset = 0x0;
        } scramb_en[16:16];
        field {
            name = "cfg_rl";
            desc = "Read delay parameter of the DDR PHY DDR4: CL + AL - 4";
            sw = rw; hw = r;
            reset = 0x0;
        } cfg_rl[15:8];
        field {
            name = "cfg_wl";
            desc = "Write delay parameter of the DDR PHY. DDR4: CWL + AL - 1";
            sw = rw; hw = r;
            reset = 0x0;
        } cfg_wl[7:0];
    } MISC @ 0x70;
    reg {
        name = "DRAMTIMER5";
        desc = "DRAMTIMER5 is DDR PHY timing parameter register 5. DRAMTIMER5 (offset 0x0BC, total reset 0x0000_0000; PROVEN: Hi3516D V300 data sheet, PDF page 345, section 4.1.9.2).";
        field {
            name = "reserved";
            desc = "Reserved";
            sw = r; hw = w;
            reset = 0x0;
        } reserved_31_12[31:12];
        field {
            name = "t_odton_h";
            desc = "Upper 4 extension bits of the t_odton timing parameter";
            sw = rw; hw = r;
            reset = 0x0;
        } t_odton_h[11:8];
        field {
            name = "t_wl";
            desc = "Number of write delay cycles For the DDR4 SDRAM, set the parameter to the sum of CWL and AL values. Unit: 1xnCK";
            sw = rw; hw = r;
            reset = 0x0;
        } t_wl[7:0];
    } DRAMTIMER5 @ 0xbc;
    reg {
        name = "MODEREG45";
        desc = "MODEREG45 is the register for configuring the SDRAM mode. MODEREG45 (offset 0x00E0, total reset 0x0000_0000; PROVEN: Hi3516D V300 data sheet, PDF page 345, section 4.1.9.2).";
        field {
            name = "mr5";
            desc = "Mode register 5";
            sw = rw; hw = r;
            reset = 0x0;
        } mr5[31:16];
        field {
            name = "mr4";
            desc = "Mode register 4";
            sw = rw; hw = r;
            reset = 0x0;
        } mr4[15:0];
    } MODEREG45 @ 0xe0;
    reg {
        name = "MODEREG67";
        desc = "MODEREG67 is the register for configuring the SDRAM mode. MODEREG67 (offset 0x00E4, total reset 0x0000_0000; PROVEN: Hi3516D V300 data sheet, PDF page 346, section 4.1.9.2).";
        field {
            name = "mr7";
            desc = "Mode register 7";
            sw = rw; hw = r;
            reset = 0x0;
        } mr7[31:16];
        field {
            name = "mr6";
            desc = "Mode register 6";
            sw = rw; hw = r;
            reset = 0x0;
        } mr6[15:0];
    } MODEREG67 @ 0xe4;
};

`endif
