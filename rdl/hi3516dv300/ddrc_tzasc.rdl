`ifndef EHI3516DV300_DDRC_TZASC_RDL
`define EHI3516DV300_DDRC_TZASC_RDL
regfile eHI3516DV300_DDRC_TZASC {
    name = "DDRC TZASC (TrustZone address space controller)";
    desc = "DDRC TZASC (TrustZone address space controller). 24 registers extracted programmatically from the Hi3516D V300 Professional Smart IP Camera SoC data sheet (Issue 01, 2019-09-12); chapter 4.1.6, table 4-6. Field names, bit ranges, access types and reset values are taken from the register tables; reset values are the data sheet total reset values split onto the fields (per-field values where the table has them). Label: PROVEN. Hardware not verified here (no board).";
    reg {
        name = "SEC_BYPASS";
        desc = "SEC_BYPASS is the security function enable register. SEC_BYPASS (offset 0x004, total reset 0x0000_0005; PROVEN: Hi3516D V300 data sheet, PDF page 292, section 4.1.6.2).";
        field {
            name = "reserved";
            desc = "Reserved";
            sw = r; hw = na;
            reset = 0x0;
        } reserved_31_8[31:8];
        field {
            name = "bypass";
            desc = "Security module bypass enable 8'b10100101: The security module is bypassed. Other values: The security module is enabled. Locking condition: The sucure_boot_lock signal has been pulled up once and ld_bypass is set to 1.";
            sw = rw; hw = r;
            reset = 0x5;
        } bypass[7:0];
    } SEC_BYPASS @ 0x4;
    reg {
        name = "SEC_LOCKDOWN_SELECT";
        desc = "SEC_LOCKDOWN_SELECT is the configuration register for the locking security attribute. SEC_LOCKDOWN_SELECT (offset 0x008, total reset 0x0000_0000; PROVEN: Hi3516D V300 data sheet, PDF page 293, section 4.1.6.2).";
        field {
            name = "reserved";
            desc = "Reserved";
            sw = r; hw = na;
            reset = 0x0;
        } reserved_31_24[31:24];
        field {
            name = "ld_rgns_sel";
            desc = "Regions whose configuration registers are locked to be read-only If this bit is set to N, registers of N + 1 consecutive regions from the most significant bit (MSB) are selected. For example, When this bit is set to 5, registers of region 15–10 are selected. (Assume that there are 16 regions in total, that is, no_of_rgns is 16.) If the value of this bit is greater than the total number of regions (rgn no_of_rgns), all regions are selected. If a certain region is selected, the following configuration registers in the region are locked to be read-only: – SEC_rgn_MAP – SEC_rgn_ATTRIB – SEC_MID_WR – SEC_MID_RD Locking condition: The sucure_boot_lock signal has been pulled up once and ld_rgn_register is set to 1.";
            sw = rw; hw = r;
            reset = 0x0;
        } ld_rgns_sel[23:16];
        field {
            name = "reserved";
            desc = "Reserved";
            sw = r; hw = na;
            reset = 0x0;
        } reserved_15_13[15:13];
        field {
            name = "ld_sec_master_type0";
            desc = "Whether to lock the SEC_MASTER_TYPE0 register to be read-only
- 0: No.
- 1: Yes.

Locking condition: The sucure_boot_lock signal has been pulled up once.";
            sw = rw; hw = r;
            reset = 0x0;
        } ld_sec_master_type0[12:12];
        field {
            name = "ld_sec_share_rgn_srart_addr";
            desc = "Whether to lock the SEC_MASTER_TYPE1 register to be read-only
- 0: No.
- 1: Yes.

Locking condition: The sucure_boot_lock signal has been pulled up once.";
            sw = rw; hw = r;
            reset = 0x0;
        } ld_sec_share_rgn_srart_addr[11:11];
        field {
            name = "ld_sec_master_type0";
            desc = "Whether to lock the SEC_SHARE_RGN_START_ADDR0–3 registers to be read-only";
            sw = rw; hw = r;
            reset = 0x0;
        } ld_sec_master_type0_2[10:10];
        field {
            name = "ld_sec_share_rgn_end_addr";
            desc = "Whether to lock the SEC_SHARE_RGN_END_ADDR0–3 registers to be read-only
- 0: No.
- 1: Yes.

Locking condition: The sucure_boot_lock signal has been pulled up once.";
            sw = rw; hw = r;
            reset = 0x0;
        } ld_sec_share_rgn_end_addr[9:9];
        field {
            name = "ld_sec_share_rgn_en";
            desc = "Whether to lock the SEC_SHARE_RGN_EN0–3 registers to be read-only
- 0: No.
- 1: Yes.

Locking condition: The sucure_boot_lock signal has been pulled up once.";
            sw = rw; hw = r;
            reset = 0x0;
        } ld_sec_share_rgn_en[8:8];
        field {
            name = "reserved";
            desc = "Reserved";
            sw = r; hw = na;
            reset = 0x0;
        } reserved_7_5[7:5];
        field {
            name = "ld_bypass";
            desc = "Whether to lock the SEC_BYPASS register to be read-only
- 0: No.
- 1: Yes.

Locking condition: The sucure_boot_lock signal has been pulled up once.";
            sw = rw; hw = r;
            reset = 0x0;
        } ld_bypass[4:4];
        field {
            name = "ld_mid_wr";
            desc = "Whether to lock the SEC_MID_WR register in the selected region to be read-only
- 0: No.
- 1: Yes.

Locking condition: The sucure_boot_lock signal has been pulled up once.";
            sw = rw; hw = r;
            reset = 0x0;
        } ld_mid_wr[3:3];
        field {
            name = "ld_mid_rd";
            desc = "Whether to lock the SEC_MID_RD register in the selected region to be read-only
- 0: No.
- 1: Yes.

Locking condition: The sucure_boot_lock signal has been pulled up once.";
            sw = rw; hw = r;
            reset = 0x0;
        } ld_mid_rd[2:2];
        field {
            name = "ld_rgn_attrib";
            desc = "Whether to lock the SEC_REGION_ATTRIB register in the selected region to be read-only
- 0: No.
- 1: Yes.

Locking condition: The sucure_boot_lock signal";
            sw = rw; hw = r;
            reset = 0x0;
        } ld_rgn_attrib[1:1];
        field {
            name = "ld_rgn_map";
            desc = "Whether to lock the SEC_REGION_MAP register in the selected region to be read-only
- 0: No.
- 1: Yes.

Locking condition: The sucure_boot_lock signal has been pulled up once.";
            sw = rw; hw = r;
            reset = 0x0;
        } ld_rgn_map[0:0];
    } SEC_LOCKDOWN_SELECT @ 0x8;
    reg {
        name = "SEC_INT_MSK_WMID";
        desc = "SEC_INT_MSK_WMID is the write MID interrupt mask register. SEC_INT_MSK_WMID (offset 0x018, total reset 0x0000_0000; PROVEN: Hi3516D V300 data sheet, PDF page 295, section 4.1.6.2).";
        field {
            name = "int_msk_wr_mid";
            desc = "This bit is used to mask the report and information records of the write interrupt of the master device based on the MID. Setting bit[0] to 1 masks the interrupt corresponding to write MID 0. The same rule applies to other bits.";
            sw = rw; hw = r;
            reset = 0x0;
        } int_msk_wr_mid[31:0];
    } SEC_INT_MSK_WMID @ 0x18;
    reg {
        name = "SEC_INT_MSK_RMID";
        desc = "SEC_INT_MSK_RMID is the read MID interrupt mask register. SEC_INT_MSK_RMID (offset 0x01C, total reset 0x0000_0000; PROVEN: Hi3516D V300 data sheet, PDF page 295, section 4.1.6.2).";
        field {
            name = "int_msk_rd_mid";
            desc = "This bit is used to mask the report and information records of the read interrupt of the master device based on the MID. Setting bit[0] to 1 masks the interrupt corresponding to read MID 0.";
            sw = rw; hw = r;
            reset = 0x0;
        } int_msk_rd_mid[31:0];
    } SEC_INT_MSK_RMID @ 0x1c;
    reg {
        name = "SEC_INT_EN";
        desc = "SEC_INT_EN is the interrupt enable register. SEC_INT_EN (offset 0x020, total reset 0x0000_0001; PROVEN: Hi3516D V300 data sheet, PDF page 295, section 4.1.6.2).";
        field {
            name = "reserved";
            desc = "Reserved";
            sw = r; hw = na;
            reset = 0x0;
        } reserved_31_1[31:1];
        field {
            name = "int_en";
            desc = "Interrupts enable
- 0: disabled
- 1: enabled

This bit is used to disable the interrupt output only. The interrupt status and unauthorized command information are recorded in the registers.";
            sw = rw; hw = r;
            reset = 0x1;
        } int_en[0:0];
    } SEC_INT_EN @ 0x20;
    reg {
        name = "SEC_INT_STATUS";
        desc = "SEC_INT_STATUS is the interrupt status register. SEC_INT_STATUS (offset 0x024, total reset 0x0000_0000; PROVEN: Hi3516D V300 data sheet, PDF page 296, section 4.1.6.2).";
        field {
            name = "reserved";
            desc = "Flag of repeated interrupt generation
- 0: The interrupt is not generated or is generated only once.
- 1: The interrupt is repeatedly generated.";
            sw = r; hw = na;
            reset = 0x0;
        } reserved_31_2[31:2];
        field {
            name = "overrun";
            desc = "Interrupt status flag
- 0: No interrupt is generated.
- 1: An interrupt is generated.

The AXI_INT_STATUS register of the AXI_IF module can be used to identify the interrupt source (the specific SEC module of the AXI port).";
            sw = r; hw = w;
            reset = 0x0;
        } overrun[1:1];
        field {
            name = "status";
            desc = "Flag of repeated interrupt generation
- 0: The interrupt is not generated or is generated only once.
- 1: The interrupt is repeatedly generated.";
            sw = r; hw = w;
            reset = 0x0;
        } status[0:0];
    } SEC_INT_STATUS @ 0x24;
    reg {
        name = "SEC_INT_CLEAR";
        desc = "SEC_INT_CLEAR is the interrupt clear register. SEC_INT_CLEAR (offset 0x028, total reset 0x0000_0000; PROVEN: Hi3516D V300 data sheet, PDF page 296, section 4.1.6.2).";
        field {
            name = "clear";
            desc = "You can clear the interrupt status register int_status by writing any value to this bit.";
            sw = w; hw = r;
            reset = 0x0;
        } clear[31:0];
    } SEC_INT_CLEAR @ 0x28;
    reg {
        name = "SEC_FAIL_CMD_INF_0";
        desc = "SEC_FAIL_CMD_INF_ 0 is register 0 for the information recorded about first unauthorized command. SEC_FAIL_CMD_INF_0 (offset 0x080, total reset 0x0000_0000; PROVEN: Hi3516D V300 data sheet, PDF page 297, section 4.1.6.2).";
        field {
            name = "address_low";
            desc = "Lower 32 bits of the address of the first unauthorized command before the interrupt status is cleared";
            sw = r; hw = w;
            reset = 0x0;
        } address_low[31:0];
    } SEC_FAIL_CMD_INF_0 @ 0x80;
    reg {
        name = "SEC_FAIL_CMD_INF_1";
        desc = "SEC_FAIL_CMD_INF_1 is register 1 for the information recorded about first unauthorized command. SEC_FAIL_CMD_INF_1 (offset 0x084, total reset 0x0000_0000; PROVEN: Hi3516D V300 data sheet, PDF page 297, section 4.1.6.2).";
        field {
            name = "reserved";
            desc = "Reserved";
            sw = r; hw = na;
            reset = 0x0;
        } reserved_31_21[31:21];
        field {
            name = "access_type";
            desc = "Reserved";
            sw = r; hw = w;
            reset = 0x0;
        } access_type[20:20];
        field {
            name = "reserved";
            desc = "Read/write mode information of the first unauthorized command before the interrupt status is cleared
- 0: read access
- 1: write access";
            sw = r; hw = na;
            reset = 0x0;
        } reserved_19_18[19:18];
        field {
            name = "status";
            desc = "Reserved";
            sw = r; hw = w;
            reset = 0x0;
        } status[17:17];
        field {
            name = "status";
            desc = "Security mode information of the first unauthorized command before the interrupt status is cleared
- 0: secure access
- 1: non-secure access";
            sw = r; hw = w;
            reset = 0x0;
        } status_2[16:16];
        field {
            name = "reserved";
            desc = "Privilege mode information of the first unauthorized command before the interrupt status is cleared
- 0: unprivileged access
- 1: privileged access";
            sw = r; hw = na;
            reset = 0x0;
        } reserved_15_8[15:8];
        field {
            name = "status";
            desc = "Reserved";
            sw = r; hw = w;
            reset = 0x0;
        } status_3[7:0];
    } SEC_FAIL_CMD_INF_1 @ 0x84;
    reg {
        name = "SEC_FAIL_CMD_INF_2";
        desc = "SEC_FAIL_CMD_INF_2 is register 2 for the information recorded about first unauthorized command. SEC_FAIL_CMD_INF_2 (offset 0x088, total reset 0x0000_0000; PROVEN: Hi3516D V300 data sheet, PDF page 298, section 4.1.6.2).";
        field {
            name = "Mid";
            desc = "MID of the first unauthorized command before the interrupt status is cleared";
            sw = r; hw = w;
            reset = 0x0;
        } Mid[31:24];
        field {
            name = "Id";
            desc = "ID of the first unauthorized command before the interrupt status is cleared";
            sw = r; hw = w;
            reset = 0x0;
        } Id[23:0];
    } SEC_FAIL_CMD_INF_2 @ 0x88;
    reg {
        name = "SEC_MASTER_TYPE1_EXT";
        desc = "SEC_MASTER_TYPE1_EXT is the write command authentication type register 1 for the master device. (for the upper 32 MIDs) SEC_MASTER_TYPE1_EXT (offset 0x21C, total reset 0x0000_0000; PROVEN: Hi3516D V300 data sheet, PDF page 301, section 4.1.6.2).";
        field {
            name = "master_type1_ext";
            desc = "master_type[n]
- 0: The secure write (MID = n) is permitted to access a non-sharing address region that permits secure write.
- 1: The secure write (MID = n) is permitted to access a non-sharing address region that permits secure write but does not permit non-secure read.";
            sw = rw; hw = r;
            reset = 0x0;
        } master_type1_ext[31:0];
    } SEC_MASTER_TYPE1_EXT @ 0x21c;
    reg {
        name = "SEC_MASTER_TYPE1";
        desc = "SEC_MASTER_TYPE1 is the write command authentication type register 1 for the master device. SEC_MASTER_TYPE1 (offset 0x310, total reset 0x0000_0000; PROVEN: Hi3516D V300 data sheet, PDF page 301, section 4.1.6.2).";
        field {
            name = "master_type1";
            desc = "master_type[n]
- 0: The secure write (MID = n) is permitted to access a non-sharing address region that permits secure write.
- 1: The secure write (MID = n) is permitted to access a non-sharing address region that permits secure write but does not permit";
            sw = rw; hw = r;
            reset = 0x0;
        } master_type1[31:0];
    } SEC_MASTER_TYPE1 @ 0x310;
    reg {
        name = "SEC_INT_MSK_WMID_EXT";
        desc = "SEC_INT_MSK_WMID_EXT is the interrupt mask register for the write MID (for the upper 32 MIDs). SEC_INT_MSK_WMID_EXT (offset 0x330, total reset 0x0000_0000; PROVEN: Hi3516D V300 data sheet, PDF page 302, section 4.1.6.2).";
        field {
            name = "int_msk_wr_mid_ext";
            desc = "These bits are used to mask the report and information records of the write interrupt of the master device based on the MID. Bit[0]: Writing 1 masks the interrupt corresponding to write MID 0. The same rule applies to other bits.";
            sw = rw; hw = r;
            reset = 0x0;
        } int_msk_wr_mid_ext[31:0];
    } SEC_INT_MSK_WMID_EXT @ 0x330;
    reg {
        name = "SEC_INT_MSK_RMID_EXT";
        desc = "SEC_INT_MSK_RMID_EXT is the interrupt mask register for the read MID (for the upper 32 MIDs). SEC_INT_MSK_RMID_EXT (offset 0x334, total reset 0x0000_0000; PROVEN: Hi3516D V300 data sheet, PDF page 302, section 4.1.6.2).";
        field {
            name = "int_msk_rd_mid_ext";
            desc = "These bits are used to mask the report and information records of the write interrupt of the master device based on the MID. Bit[0]: Writing 1 masks the interrupt corresponding to write MID 0. The same rule applies to other bits.";
            sw = rw; hw = r;
            reset = 0x0;
        } int_msk_rd_mid_ext[31:0];
    } SEC_INT_MSK_RMID_EXT @ 0x334;
    reg {
        name = "SEC_ITCRG";
        desc = "SEC_ITCRG is the integration test control register. SEC_ITCRG (offset 0x3C0, total reset 0x0000_0000; PROVEN: Hi3516D V300 data sheet, PDF page 302, section 4.1.6.2).";
        field {
            name = "reserved";
            desc = "Reserved";
            sw = r; hw = na;
            reset = 0x0;
        } reserved_31_1[31:1];
        field {
            name = "int_test_en";
            desc = "Interrupt test enable
- 0: disabled";
            sw = rw; hw = r;
            reset = 0x0;
        } int_test_en[0:0];
    } SEC_ITCRG @ 0x3c0;
    reg {
        name = "SEC_ITIP";
        desc = "SEC_ITIP is the integration test input register. SEC_ITIP (offset 0x3C4, total reset 0x0000_0000; PROVEN: Hi3516D V300 data sheet, PDF page 303, section 4.1.6.2).";
        field {
            name = "reserved";
            desc = "Reserved";
            sw = r; hw = na;
            reset = 0x0;
        } reserved_31_1[31:1];
        field {
            name = "itip_secure_boot_lock";
            desc = "Protection lock status flag for the register
- 0: not locked
- 0: locked";
            sw = r; hw = w;
            reset = 0x0;
        } itip_secure_boot_lock[0:0];
    } SEC_ITIP @ 0x3c4;
    reg {
        name = "SEC_ITOP";
        desc = "SEC_ITOP is the integration test write register. SEC_ITOP (offset 0x3C8, total reset 0x0000_0000; PROVEN: Hi3516D V300 data sheet, PDF page 303, section 4.1.6.2).";
        field {
            name = "reserved";
            desc = "Reserved";
            sw = r; hw = na;
            reset = 0x0;
        } reserved_31_1[31:1];
        field {
            name = "itop_int";
            desc = "Interrupt status configuration
- 0: low level
- 1: high level

This register is valid only when the interrupt test is enabled. In this case, the normal interrupts generated inside the module are ignored.";
            sw = r; hw = w;
            reset = 0x0;
        } itop_int[0:0];
    } SEC_ITOP @ 0x3c8;
    regfile {
        name = "SEC_RGN";
        desc = "Registers of the data sheet tables whose offset contains the variable sec_regions (sec_regions = 0 to 15): instance i of the array starts at 0x100 + i x 0x10. ";
        reg {
            name = "SEC_RGN_MAP";
            desc = "SEC_RGN_MAP is the address region mapping register. SEC_RGN_MAP (offset 0x100+0x10 x sec_regions, total reset 0x0000_0000; PROVEN: Hi3516D V300 data sheet, PDF page 298, section 4.1.6.2). Per-instance register (sec_regions = 0 to 15): modelled inside the regfile array of its variable.";
            field {
                name = "rgn_en";
                desc = "Region enable
- 0: disabled
- 1: enabled

Region 0 is enabled by default and cannot be configured.";
                sw = rw; hw = r;
                reset = 0x0;
            } rgn_en[31:31];
            field {
                name = "reserved";
                desc = "Reserved";
                sw = r; hw = na;
                reset = 0x0;
            } reserved_30_24[30:24];
            field {
                name = "rgn_base_addr";
                desc = "Bit[31:16] of the start address of each region (upper bits) Region 0 cannot be configured. Region 0 covers the entire address space.";
                sw = rw; hw = r;
                reset = 0x0;
            } rgn_base_addr[23:0];
        } SEC_RGN_MAP @ 0x0;
        reg {
            name = "SEC_RGN_ATTRIB";
            desc = "SEC_RGN_ATTRIB is the configuration register for the permission attributes of each address region. SEC_RGN_ATTRIB (offset 0x104+0x10 x sec_regions, total reset 0x0000_0000; PROVEN: Hi3516D V300 data sheet, PDF page 298, section 4.1.6.2). Per-instance register (sec_regions = 0 to 15): modelled inside the regfile array of its variable.";
            field {
                name = "reserved";
                desc = "Reserved";
                sw = r; hw = na;
                reset = 0x0;
            } reserved_31_10[31:10];
            field {
                name = "Mid_inv";
                desc = "MID match permission inversion
- 0: The access permission can be obtained only";
                sw = rw; hw = r;
                reset = 0x0;
            } Mid_inv[9:9];
            field {
                name = "Mid_en";
                desc = "MID match enable.
- 0: disabled
- 1: enabled";
                sw = rw; hw = r;
                reset = 0x0;
            } Mid_en[8:8];
            field {
                name = "reserved";
                desc = "Reserved";
                sw = r; hw = na;
                reset = 0x0;
            } reserved_7_5[7:5];
            field {
                name = "security_inv";
                desc = "Security permission inversion enable
- 0: disabled (If a region allows non-secure read/write, secure read/write must be allowed as well.)
- 1: enabled (The non-secure read/write permission and secure read/write permission are independent of each other and need to be set separately.)";
                sw = rw; hw = r;
                reset = 0x0;
            } security_inv[4:4];
            field {
                name = "sp";
                desc = "Security permission attribute of the current region. sp[3]: secure read attribute sp[2]: secure write attribute sp[1]: non-secure read attribute sp[0]: non-secure write attribute If sp[n] is set to 0, the access is forbidden. If sp[n] is set to 1, the access is allowed.";
                sw = rw; hw = r;
                reset = 0x0;
            } sp[3:0];
        } SEC_RGN_ATTRIB @ 0x4;
        reg {
            name = "SEC_MID_WR";
            desc = "SEC_MID_WR is the MID and mask match register for the write command. SEC_MID_WR (offset 0x108+0x10 x sec_regions, total reset 0xffff_ffff; PROVEN: Hi3516D V300 data sheet, PDF page 299, section 4.1.6.2). Per-instance register (sec_regions = 0 to 15): modelled inside the regfile array of its variable.";
            field {
                name = "mid_sel_wr";
                desc = "Bit matching select for the MID (write command)
- 0: unsuccessful matching when the lower six bits of the MID of the write command are n
- 1: successful matching when the lower six bits of the MID of the write command are n";
                sw = rw; hw = r;
                reset = 0xffffffff;
            } mid_sel_wr[31:0];
        } SEC_MID_WR @ 0x8;
        reg {
            name = "SEC_MID_RD";
            desc = "SEC_MID_RD is the MID and mask match register for the read command. SEC_MID_RD (offset 0x10C+0x10 x sec_regions, total reset 0xffff_ffff; PROVEN: Hi3516D V300 data sheet, PDF page 300, section 4.1.6.2). Per-instance register (sec_regions = 0 to 15): modelled inside the regfile array of its variable.";
            field {
                name = "mid_sel_rd";
                desc = "Bit matching select for the MID (read command)
- 0: unsuccessful matching when the lower six bits of the MID of the read command are n
- 1: successful matching when the lower six bits of the MID of the read command are n";
                sw = rw; hw = r;
                reset = 0xffffffff;
            } mid_sel_rd[31:0];
        } SEC_MID_RD @ 0xc;
    } SEC_RGN[16] @ 0x100 += 0x10;
    reg {
        name = "SEC_RGN_MAP_EXT";
        desc = "SEC_RGN_MAP_EXT is the MID and mask match register for the read command. (for the upper 32 MIDs) SEC_RGN_MAP_EXT (offset 0x200+0x10 x sec_regions, total reset 0x0000_0000; PROVEN: Hi3516D V300 data sheet, PDF page 300, section 4.1.6.2). Offset corrected to 0x200+0x10 x sec_regions: the detail table of this register says 0x204+0x10 x sec_regions, the register summary table lists 0x200+0x10 x sec_regions. Per-instance register (sec_regions = 0 to 15): modelled inside the regfile array of its variable.";
        field {
            name = "reserved";
            desc = "Reserved";
            sw = r; hw = na;
            reset = 0x0;
        } reserved_31_24[31:24];
        field {
            name = "rgn_rgn_size";
            desc = "Size of the current region = n x 64 KB Region 0 cannot be configured. Region 0 covers the entire address space by default. The size configured for each region plus the start address of the region cannot exceed the total address space.";
            sw = rw; hw = r;
            reset = 0x0;
        } rgn_rgn_size[23:0];
    } SEC_RGN_MAP_EXT_0 @ 0x200;
    reg {
        name = "SEC_RGN_MAP_EXT";
        desc = "SEC_RGN_MAP_EXT is the MID and mask match register for the read command. (for the upper 32 MIDs) SEC_RGN_MAP_EXT (offset 0x200+0x10 x sec_regions, total reset 0x0000_0000; PROVEN: Hi3516D V300 data sheet, PDF page 300, section 4.1.6.2). Offset corrected to 0x200+0x10 x sec_regions: the detail table of this register says 0x204+0x10 x sec_regions, the register summary table lists 0x200+0x10 x sec_regions. Per-instance register (sec_regions = 0 to 15): modelled inside the regfile array of its variable.";
        field {
            name = "reserved";
            desc = "Reserved";
            sw = r; hw = na;
            reset = 0x0;
        } reserved_31_24[31:24];
        field {
            name = "rgn_rgn_size";
            desc = "Size of the current region = n x 64 KB Region 0 cannot be configured. Region 0 covers the entire address space by default. The size configured for each region plus the start address of the region cannot exceed the total address space.";
            sw = rw; hw = r;
            reset = 0x0;
        } rgn_rgn_size[23:0];
    } SEC_RGN_MAP_EXT_1 @ 0x210;
    reg {
        name = "SEC_RGN_MAP_EXT";
        desc = "SEC_RGN_MAP_EXT is the MID and mask match register for the read command. (for the upper 32 MIDs) SEC_RGN_MAP_EXT (offset 0x200+0x10 x sec_regions, total reset 0x0000_0000; PROVEN: Hi3516D V300 data sheet, PDF page 300, section 4.1.6.2). Offset corrected to 0x200+0x10 x sec_regions: the detail table of this register says 0x204+0x10 x sec_regions, the register summary table lists 0x200+0x10 x sec_regions. Per-instance register (sec_regions = 0 to 15): modelled inside the regfile array of its variable.";
        field {
            name = "reserved";
            desc = "Reserved";
            sw = r; hw = na;
            reset = 0x0;
        } reserved_31_24[31:24];
        field {
            name = "rgn_rgn_size";
            desc = "Size of the current region = n x 64 KB Region 0 cannot be configured. Region 0 covers the entire address space by default. The size configured for each region plus the start address of the region cannot exceed the total address space.";
            sw = rw; hw = r;
            reset = 0x0;
        } rgn_rgn_size[23:0];
    } SEC_RGN_MAP_EXT_2 @ 0x220;
    reg {
        name = "SEC_RGN_MAP_EXT";
        desc = "SEC_RGN_MAP_EXT is the MID and mask match register for the read command. (for the upper 32 MIDs) SEC_RGN_MAP_EXT (offset 0x200+0x10 x sec_regions, total reset 0x0000_0000; PROVEN: Hi3516D V300 data sheet, PDF page 300, section 4.1.6.2). Offset corrected to 0x200+0x10 x sec_regions: the detail table of this register says 0x204+0x10 x sec_regions, the register summary table lists 0x200+0x10 x sec_regions. Per-instance register (sec_regions = 0 to 15): modelled inside the regfile array of its variable.";
        field {
            name = "reserved";
            desc = "Reserved";
            sw = r; hw = na;
            reset = 0x0;
        } reserved_31_24[31:24];
        field {
            name = "rgn_rgn_size";
            desc = "Size of the current region = n x 64 KB Region 0 cannot be configured. Region 0 covers the entire address space by default. The size configured for each region plus the start address of the region cannot exceed the total address space.";
            sw = rw; hw = r;
            reset = 0x0;
        } rgn_rgn_size[23:0];
    } SEC_RGN_MAP_EXT_3 @ 0x230;
    reg {
        name = "SEC_RGN_MAP_EXT";
        desc = "SEC_RGN_MAP_EXT is the MID and mask match register for the read command. (for the upper 32 MIDs) SEC_RGN_MAP_EXT (offset 0x200+0x10 x sec_regions, total reset 0x0000_0000; PROVEN: Hi3516D V300 data sheet, PDF page 300, section 4.1.6.2). Offset corrected to 0x200+0x10 x sec_regions: the detail table of this register says 0x204+0x10 x sec_regions, the register summary table lists 0x200+0x10 x sec_regions. Per-instance register (sec_regions = 0 to 15): modelled inside the regfile array of its variable.";
        field {
            name = "reserved";
            desc = "Reserved";
            sw = r; hw = na;
            reset = 0x0;
        } reserved_31_24[31:24];
        field {
            name = "rgn_rgn_size";
            desc = "Size of the current region = n x 64 KB Region 0 cannot be configured. Region 0 covers the entire address space by default. The size configured for each region plus the start address of the region cannot exceed the total address space.";
            sw = rw; hw = r;
            reset = 0x0;
        } rgn_rgn_size[23:0];
    } SEC_RGN_MAP_EXT_4 @ 0x240;
    reg {
        name = "SEC_RGN_MAP_EXT";
        desc = "SEC_RGN_MAP_EXT is the MID and mask match register for the read command. (for the upper 32 MIDs) SEC_RGN_MAP_EXT (offset 0x200+0x10 x sec_regions, total reset 0x0000_0000; PROVEN: Hi3516D V300 data sheet, PDF page 300, section 4.1.6.2). Offset corrected to 0x200+0x10 x sec_regions: the detail table of this register says 0x204+0x10 x sec_regions, the register summary table lists 0x200+0x10 x sec_regions. Per-instance register (sec_regions = 0 to 15): modelled inside the regfile array of its variable.";
        field {
            name = "reserved";
            desc = "Reserved";
            sw = r; hw = na;
            reset = 0x0;
        } reserved_31_24[31:24];
        field {
            name = "rgn_rgn_size";
            desc = "Size of the current region = n x 64 KB Region 0 cannot be configured. Region 0 covers the entire address space by default. The size configured for each region plus the start address of the region cannot exceed the total address space.";
            sw = rw; hw = r;
            reset = 0x0;
        } rgn_rgn_size[23:0];
    } SEC_RGN_MAP_EXT_5 @ 0x250;
    reg {
        name = "SEC_RGN_MAP_EXT";
        desc = "SEC_RGN_MAP_EXT is the MID and mask match register for the read command. (for the upper 32 MIDs) SEC_RGN_MAP_EXT (offset 0x200+0x10 x sec_regions, total reset 0x0000_0000; PROVEN: Hi3516D V300 data sheet, PDF page 300, section 4.1.6.2). Offset corrected to 0x200+0x10 x sec_regions: the detail table of this register says 0x204+0x10 x sec_regions, the register summary table lists 0x200+0x10 x sec_regions. Per-instance register (sec_regions = 0 to 15): modelled inside the regfile array of its variable.";
        field {
            name = "reserved";
            desc = "Reserved";
            sw = r; hw = na;
            reset = 0x0;
        } reserved_31_24[31:24];
        field {
            name = "rgn_rgn_size";
            desc = "Size of the current region = n x 64 KB Region 0 cannot be configured. Region 0 covers the entire address space by default. The size configured for each region plus the start address of the region cannot exceed the total address space.";
            sw = rw; hw = r;
            reset = 0x0;
        } rgn_rgn_size[23:0];
    } SEC_RGN_MAP_EXT_6 @ 0x260;
    reg {
        name = "SEC_RGN_MAP_EXT";
        desc = "SEC_RGN_MAP_EXT is the MID and mask match register for the read command. (for the upper 32 MIDs) SEC_RGN_MAP_EXT (offset 0x200+0x10 x sec_regions, total reset 0x0000_0000; PROVEN: Hi3516D V300 data sheet, PDF page 300, section 4.1.6.2). Offset corrected to 0x200+0x10 x sec_regions: the detail table of this register says 0x204+0x10 x sec_regions, the register summary table lists 0x200+0x10 x sec_regions. Per-instance register (sec_regions = 0 to 15): modelled inside the regfile array of its variable.";
        field {
            name = "reserved";
            desc = "Reserved";
            sw = r; hw = na;
            reset = 0x0;
        } reserved_31_24[31:24];
        field {
            name = "rgn_rgn_size";
            desc = "Size of the current region = n x 64 KB Region 0 cannot be configured. Region 0 covers the entire address space by default. The size configured for each region plus the start address of the region cannot exceed the total address space.";
            sw = rw; hw = r;
            reset = 0x0;
        } rgn_rgn_size[23:0];
    } SEC_RGN_MAP_EXT_7 @ 0x270;
    reg {
        name = "SEC_RGN_MAP_EXT";
        desc = "SEC_RGN_MAP_EXT is the MID and mask match register for the read command. (for the upper 32 MIDs) SEC_RGN_MAP_EXT (offset 0x200+0x10 x sec_regions, total reset 0x0000_0000; PROVEN: Hi3516D V300 data sheet, PDF page 300, section 4.1.6.2). Offset corrected to 0x200+0x10 x sec_regions: the detail table of this register says 0x204+0x10 x sec_regions, the register summary table lists 0x200+0x10 x sec_regions. Per-instance register (sec_regions = 0 to 15): modelled inside the regfile array of its variable.";
        field {
            name = "reserved";
            desc = "Reserved";
            sw = r; hw = na;
            reset = 0x0;
        } reserved_31_24[31:24];
        field {
            name = "rgn_rgn_size";
            desc = "Size of the current region = n x 64 KB Region 0 cannot be configured. Region 0 covers the entire address space by default. The size configured for each region plus the start address of the region cannot exceed the total address space.";
            sw = rw; hw = r;
            reset = 0x0;
        } rgn_rgn_size[23:0];
    } SEC_RGN_MAP_EXT_8 @ 0x280;
    reg {
        name = "SEC_RGN_MAP_EXT";
        desc = "SEC_RGN_MAP_EXT is the MID and mask match register for the read command. (for the upper 32 MIDs) SEC_RGN_MAP_EXT (offset 0x200+0x10 x sec_regions, total reset 0x0000_0000; PROVEN: Hi3516D V300 data sheet, PDF page 300, section 4.1.6.2). Offset corrected to 0x200+0x10 x sec_regions: the detail table of this register says 0x204+0x10 x sec_regions, the register summary table lists 0x200+0x10 x sec_regions. Per-instance register (sec_regions = 0 to 15): modelled inside the regfile array of its variable.";
        field {
            name = "reserved";
            desc = "Reserved";
            sw = r; hw = na;
            reset = 0x0;
        } reserved_31_24[31:24];
        field {
            name = "rgn_rgn_size";
            desc = "Size of the current region = n x 64 KB Region 0 cannot be configured. Region 0 covers the entire address space by default. The size configured for each region plus the start address of the region cannot exceed the total address space.";
            sw = rw; hw = r;
            reset = 0x0;
        } rgn_rgn_size[23:0];
    } SEC_RGN_MAP_EXT_9 @ 0x290;
    reg {
        name = "SEC_RGN_MAP_EXT";
        desc = "SEC_RGN_MAP_EXT is the MID and mask match register for the read command. (for the upper 32 MIDs) SEC_RGN_MAP_EXT (offset 0x200+0x10 x sec_regions, total reset 0x0000_0000; PROVEN: Hi3516D V300 data sheet, PDF page 300, section 4.1.6.2). Offset corrected to 0x200+0x10 x sec_regions: the detail table of this register says 0x204+0x10 x sec_regions, the register summary table lists 0x200+0x10 x sec_regions. Per-instance register (sec_regions = 0 to 15): modelled inside the regfile array of its variable.";
        field {
            name = "reserved";
            desc = "Reserved";
            sw = r; hw = na;
            reset = 0x0;
        } reserved_31_24[31:24];
        field {
            name = "rgn_rgn_size";
            desc = "Size of the current region = n x 64 KB Region 0 cannot be configured. Region 0 covers the entire address space by default. The size configured for each region plus the start address of the region cannot exceed the total address space.";
            sw = rw; hw = r;
            reset = 0x0;
        } rgn_rgn_size[23:0];
    } SEC_RGN_MAP_EXT_10 @ 0x2a0;
    reg {
        name = "SEC_RGN_MAP_EXT";
        desc = "SEC_RGN_MAP_EXT is the MID and mask match register for the read command. (for the upper 32 MIDs) SEC_RGN_MAP_EXT (offset 0x200+0x10 x sec_regions, total reset 0x0000_0000; PROVEN: Hi3516D V300 data sheet, PDF page 300, section 4.1.6.2). Offset corrected to 0x200+0x10 x sec_regions: the detail table of this register says 0x204+0x10 x sec_regions, the register summary table lists 0x200+0x10 x sec_regions. Per-instance register (sec_regions = 0 to 15): modelled inside the regfile array of its variable.";
        field {
            name = "reserved";
            desc = "Reserved";
            sw = r; hw = na;
            reset = 0x0;
        } reserved_31_24[31:24];
        field {
            name = "rgn_rgn_size";
            desc = "Size of the current region = n x 64 KB Region 0 cannot be configured. Region 0 covers the entire address space by default. The size configured for each region plus the start address of the region cannot exceed the total address space.";
            sw = rw; hw = r;
            reset = 0x0;
        } rgn_rgn_size[23:0];
    } SEC_RGN_MAP_EXT_11 @ 0x2b0;
    reg {
        name = "SEC_RGN_MAP_EXT";
        desc = "SEC_RGN_MAP_EXT is the MID and mask match register for the read command. (for the upper 32 MIDs) SEC_RGN_MAP_EXT (offset 0x200+0x10 x sec_regions, total reset 0x0000_0000; PROVEN: Hi3516D V300 data sheet, PDF page 300, section 4.1.6.2). Offset corrected to 0x200+0x10 x sec_regions: the detail table of this register says 0x204+0x10 x sec_regions, the register summary table lists 0x200+0x10 x sec_regions. Per-instance register (sec_regions = 0 to 15): modelled inside the regfile array of its variable.";
        field {
            name = "reserved";
            desc = "Reserved";
            sw = r; hw = na;
            reset = 0x0;
        } reserved_31_24[31:24];
        field {
            name = "rgn_rgn_size";
            desc = "Size of the current region = n x 64 KB Region 0 cannot be configured. Region 0 covers the entire address space by default. The size configured for each region plus the start address of the region cannot exceed the total address space.";
            sw = rw; hw = r;
            reset = 0x0;
        } rgn_rgn_size[23:0];
    } SEC_RGN_MAP_EXT_12 @ 0x2c0;
    reg {
        name = "SEC_RGN_MAP_EXT";
        desc = "SEC_RGN_MAP_EXT is the MID and mask match register for the read command. (for the upper 32 MIDs) SEC_RGN_MAP_EXT (offset 0x200+0x10 x sec_regions, total reset 0x0000_0000; PROVEN: Hi3516D V300 data sheet, PDF page 300, section 4.1.6.2). Offset corrected to 0x200+0x10 x sec_regions: the detail table of this register says 0x204+0x10 x sec_regions, the register summary table lists 0x200+0x10 x sec_regions. Per-instance register (sec_regions = 0 to 15): modelled inside the regfile array of its variable.";
        field {
            name = "reserved";
            desc = "Reserved";
            sw = r; hw = na;
            reset = 0x0;
        } reserved_31_24[31:24];
        field {
            name = "rgn_rgn_size";
            desc = "Size of the current region = n x 64 KB Region 0 cannot be configured. Region 0 covers the entire address space by default. The size configured for each region plus the start address of the region cannot exceed the total address space.";
            sw = rw; hw = r;
            reset = 0x0;
        } rgn_rgn_size[23:0];
    } SEC_RGN_MAP_EXT_13 @ 0x2d0;
    reg {
        name = "SEC_RGN_MAP_EXT";
        desc = "SEC_RGN_MAP_EXT is the MID and mask match register for the read command. (for the upper 32 MIDs) SEC_RGN_MAP_EXT (offset 0x200+0x10 x sec_regions, total reset 0x0000_0000; PROVEN: Hi3516D V300 data sheet, PDF page 300, section 4.1.6.2). Offset corrected to 0x200+0x10 x sec_regions: the detail table of this register says 0x204+0x10 x sec_regions, the register summary table lists 0x200+0x10 x sec_regions. Per-instance register (sec_regions = 0 to 15): modelled inside the regfile array of its variable.";
        field {
            name = "reserved";
            desc = "Reserved";
            sw = r; hw = na;
            reset = 0x0;
        } reserved_31_24[31:24];
        field {
            name = "rgn_rgn_size";
            desc = "Size of the current region = n x 64 KB Region 0 cannot be configured. Region 0 covers the entire address space by default. The size configured for each region plus the start address of the region cannot exceed the total address space.";
            sw = rw; hw = r;
            reset = 0x0;
        } rgn_rgn_size[23:0];
    } SEC_RGN_MAP_EXT_14 @ 0x2e0;
    reg {
        name = "SEC_RGN_MAP_EXT";
        desc = "SEC_RGN_MAP_EXT is the MID and mask match register for the read command. (for the upper 32 MIDs) SEC_RGN_MAP_EXT (offset 0x200+0x10 x sec_regions, total reset 0x0000_0000; PROVEN: Hi3516D V300 data sheet, PDF page 300, section 4.1.6.2). Offset corrected to 0x200+0x10 x sec_regions: the detail table of this register says 0x204+0x10 x sec_regions, the register summary table lists 0x200+0x10 x sec_regions. Per-instance register (sec_regions = 0 to 15): modelled inside the regfile array of its variable.";
        field {
            name = "reserved";
            desc = "Reserved";
            sw = r; hw = na;
            reset = 0x0;
        } reserved_31_24[31:24];
        field {
            name = "rgn_rgn_size";
            desc = "Size of the current region = n x 64 KB Region 0 cannot be configured. Region 0 covers the entire address space by default. The size configured for each region plus the start address of the region cannot exceed the total address space.";
            sw = rw; hw = r;
            reset = 0x0;
        } rgn_rgn_size[23:0];
    } SEC_RGN_MAP_EXT_15 @ 0x2f0;
    reg {
        name = "SEC_MID_WR_EXT";
        desc = "SEC_MID_WR_EXT is the MID and mask match register for the write command. (for upper 32 MIDs) SEC_MID_WR_EXT (offset 0x204+0x10 x sec_regions, total reset 0xffff_ffff; PROVEN: Hi3516D V300 data sheet, PDF page 300, section 4.1.6.2). Per-instance register (sec_regions = 0 to 15): modelled inside the regfile array of its variable.";
        field {
            name = "mid_sel_wr";
            desc = "Bit matching select for the MID (write command)
- 0: unsuccessful matching when the lower six bits of the MID of the write command are n
- 1: successful matching when the lower six bits of the MID of the write command are n";
            sw = rw; hw = r;
            reset = 0xffffffff;
        } mid_sel_wr[31:0];
    } SEC_MID_WR_EXT_0 @ 0x204;
    reg {
        name = "SEC_MID_WR_EXT";
        desc = "SEC_MID_WR_EXT is the MID and mask match register for the write command. (for upper 32 MIDs) SEC_MID_WR_EXT (offset 0x204+0x10 x sec_regions, total reset 0xffff_ffff; PROVEN: Hi3516D V300 data sheet, PDF page 300, section 4.1.6.2). Per-instance register (sec_regions = 0 to 15): modelled inside the regfile array of its variable.";
        field {
            name = "mid_sel_wr";
            desc = "Bit matching select for the MID (write command)
- 0: unsuccessful matching when the lower six bits of the MID of the write command are n
- 1: successful matching when the lower six bits of the MID of the write command are n";
            sw = rw; hw = r;
            reset = 0xffffffff;
        } mid_sel_wr[31:0];
    } SEC_MID_WR_EXT_1 @ 0x214;
    reg {
        name = "SEC_MID_WR_EXT";
        desc = "SEC_MID_WR_EXT is the MID and mask match register for the write command. (for upper 32 MIDs) SEC_MID_WR_EXT (offset 0x204+0x10 x sec_regions, total reset 0xffff_ffff; PROVEN: Hi3516D V300 data sheet, PDF page 300, section 4.1.6.2). Per-instance register (sec_regions = 0 to 15): modelled inside the regfile array of its variable.";
        field {
            name = "mid_sel_wr";
            desc = "Bit matching select for the MID (write command)
- 0: unsuccessful matching when the lower six bits of the MID of the write command are n
- 1: successful matching when the lower six bits of the MID of the write command are n";
            sw = rw; hw = r;
            reset = 0xffffffff;
        } mid_sel_wr[31:0];
    } SEC_MID_WR_EXT_2 @ 0x224;
    reg {
        name = "SEC_MID_WR_EXT";
        desc = "SEC_MID_WR_EXT is the MID and mask match register for the write command. (for upper 32 MIDs) SEC_MID_WR_EXT (offset 0x204+0x10 x sec_regions, total reset 0xffff_ffff; PROVEN: Hi3516D V300 data sheet, PDF page 300, section 4.1.6.2). Per-instance register (sec_regions = 0 to 15): modelled inside the regfile array of its variable.";
        field {
            name = "mid_sel_wr";
            desc = "Bit matching select for the MID (write command)
- 0: unsuccessful matching when the lower six bits of the MID of the write command are n
- 1: successful matching when the lower six bits of the MID of the write command are n";
            sw = rw; hw = r;
            reset = 0xffffffff;
        } mid_sel_wr[31:0];
    } SEC_MID_WR_EXT_3 @ 0x234;
    reg {
        name = "SEC_MID_WR_EXT";
        desc = "SEC_MID_WR_EXT is the MID and mask match register for the write command. (for upper 32 MIDs) SEC_MID_WR_EXT (offset 0x204+0x10 x sec_regions, total reset 0xffff_ffff; PROVEN: Hi3516D V300 data sheet, PDF page 300, section 4.1.6.2). Per-instance register (sec_regions = 0 to 15): modelled inside the regfile array of its variable.";
        field {
            name = "mid_sel_wr";
            desc = "Bit matching select for the MID (write command)
- 0: unsuccessful matching when the lower six bits of the MID of the write command are n
- 1: successful matching when the lower six bits of the MID of the write command are n";
            sw = rw; hw = r;
            reset = 0xffffffff;
        } mid_sel_wr[31:0];
    } SEC_MID_WR_EXT_4 @ 0x244;
    reg {
        name = "SEC_MID_WR_EXT";
        desc = "SEC_MID_WR_EXT is the MID and mask match register for the write command. (for upper 32 MIDs) SEC_MID_WR_EXT (offset 0x204+0x10 x sec_regions, total reset 0xffff_ffff; PROVEN: Hi3516D V300 data sheet, PDF page 300, section 4.1.6.2). Per-instance register (sec_regions = 0 to 15): modelled inside the regfile array of its variable.";
        field {
            name = "mid_sel_wr";
            desc = "Bit matching select for the MID (write command)
- 0: unsuccessful matching when the lower six bits of the MID of the write command are n
- 1: successful matching when the lower six bits of the MID of the write command are n";
            sw = rw; hw = r;
            reset = 0xffffffff;
        } mid_sel_wr[31:0];
    } SEC_MID_WR_EXT_5 @ 0x254;
    reg {
        name = "SEC_MID_WR_EXT";
        desc = "SEC_MID_WR_EXT is the MID and mask match register for the write command. (for upper 32 MIDs) SEC_MID_WR_EXT (offset 0x204+0x10 x sec_regions, total reset 0xffff_ffff; PROVEN: Hi3516D V300 data sheet, PDF page 300, section 4.1.6.2). Per-instance register (sec_regions = 0 to 15): modelled inside the regfile array of its variable.";
        field {
            name = "mid_sel_wr";
            desc = "Bit matching select for the MID (write command)
- 0: unsuccessful matching when the lower six bits of the MID of the write command are n
- 1: successful matching when the lower six bits of the MID of the write command are n";
            sw = rw; hw = r;
            reset = 0xffffffff;
        } mid_sel_wr[31:0];
    } SEC_MID_WR_EXT_6 @ 0x264;
    reg {
        name = "SEC_MID_WR_EXT";
        desc = "SEC_MID_WR_EXT is the MID and mask match register for the write command. (for upper 32 MIDs) SEC_MID_WR_EXT (offset 0x204+0x10 x sec_regions, total reset 0xffff_ffff; PROVEN: Hi3516D V300 data sheet, PDF page 300, section 4.1.6.2). Per-instance register (sec_regions = 0 to 15): modelled inside the regfile array of its variable.";
        field {
            name = "mid_sel_wr";
            desc = "Bit matching select for the MID (write command)
- 0: unsuccessful matching when the lower six bits of the MID of the write command are n
- 1: successful matching when the lower six bits of the MID of the write command are n";
            sw = rw; hw = r;
            reset = 0xffffffff;
        } mid_sel_wr[31:0];
    } SEC_MID_WR_EXT_7 @ 0x274;
    reg {
        name = "SEC_MID_WR_EXT";
        desc = "SEC_MID_WR_EXT is the MID and mask match register for the write command. (for upper 32 MIDs) SEC_MID_WR_EXT (offset 0x204+0x10 x sec_regions, total reset 0xffff_ffff; PROVEN: Hi3516D V300 data sheet, PDF page 300, section 4.1.6.2). Per-instance register (sec_regions = 0 to 15): modelled inside the regfile array of its variable.";
        field {
            name = "mid_sel_wr";
            desc = "Bit matching select for the MID (write command)
- 0: unsuccessful matching when the lower six bits of the MID of the write command are n
- 1: successful matching when the lower six bits of the MID of the write command are n";
            sw = rw; hw = r;
            reset = 0xffffffff;
        } mid_sel_wr[31:0];
    } SEC_MID_WR_EXT_8 @ 0x284;
    reg {
        name = "SEC_MID_WR_EXT";
        desc = "SEC_MID_WR_EXT is the MID and mask match register for the write command. (for upper 32 MIDs) SEC_MID_WR_EXT (offset 0x204+0x10 x sec_regions, total reset 0xffff_ffff; PROVEN: Hi3516D V300 data sheet, PDF page 300, section 4.1.6.2). Per-instance register (sec_regions = 0 to 15): modelled inside the regfile array of its variable.";
        field {
            name = "mid_sel_wr";
            desc = "Bit matching select for the MID (write command)
- 0: unsuccessful matching when the lower six bits of the MID of the write command are n
- 1: successful matching when the lower six bits of the MID of the write command are n";
            sw = rw; hw = r;
            reset = 0xffffffff;
        } mid_sel_wr[31:0];
    } SEC_MID_WR_EXT_9 @ 0x294;
    reg {
        name = "SEC_MID_WR_EXT";
        desc = "SEC_MID_WR_EXT is the MID and mask match register for the write command. (for upper 32 MIDs) SEC_MID_WR_EXT (offset 0x204+0x10 x sec_regions, total reset 0xffff_ffff; PROVEN: Hi3516D V300 data sheet, PDF page 300, section 4.1.6.2). Per-instance register (sec_regions = 0 to 15): modelled inside the regfile array of its variable.";
        field {
            name = "mid_sel_wr";
            desc = "Bit matching select for the MID (write command)
- 0: unsuccessful matching when the lower six bits of the MID of the write command are n
- 1: successful matching when the lower six bits of the MID of the write command are n";
            sw = rw; hw = r;
            reset = 0xffffffff;
        } mid_sel_wr[31:0];
    } SEC_MID_WR_EXT_10 @ 0x2a4;
    reg {
        name = "SEC_MID_WR_EXT";
        desc = "SEC_MID_WR_EXT is the MID and mask match register for the write command. (for upper 32 MIDs) SEC_MID_WR_EXT (offset 0x204+0x10 x sec_regions, total reset 0xffff_ffff; PROVEN: Hi3516D V300 data sheet, PDF page 300, section 4.1.6.2). Per-instance register (sec_regions = 0 to 15): modelled inside the regfile array of its variable.";
        field {
            name = "mid_sel_wr";
            desc = "Bit matching select for the MID (write command)
- 0: unsuccessful matching when the lower six bits of the MID of the write command are n
- 1: successful matching when the lower six bits of the MID of the write command are n";
            sw = rw; hw = r;
            reset = 0xffffffff;
        } mid_sel_wr[31:0];
    } SEC_MID_WR_EXT_11 @ 0x2b4;
    reg {
        name = "SEC_MID_WR_EXT";
        desc = "SEC_MID_WR_EXT is the MID and mask match register for the write command. (for upper 32 MIDs) SEC_MID_WR_EXT (offset 0x204+0x10 x sec_regions, total reset 0xffff_ffff; PROVEN: Hi3516D V300 data sheet, PDF page 300, section 4.1.6.2). Per-instance register (sec_regions = 0 to 15): modelled inside the regfile array of its variable.";
        field {
            name = "mid_sel_wr";
            desc = "Bit matching select for the MID (write command)
- 0: unsuccessful matching when the lower six bits of the MID of the write command are n
- 1: successful matching when the lower six bits of the MID of the write command are n";
            sw = rw; hw = r;
            reset = 0xffffffff;
        } mid_sel_wr[31:0];
    } SEC_MID_WR_EXT_12 @ 0x2c4;
    reg {
        name = "SEC_MID_WR_EXT";
        desc = "SEC_MID_WR_EXT is the MID and mask match register for the write command. (for upper 32 MIDs) SEC_MID_WR_EXT (offset 0x204+0x10 x sec_regions, total reset 0xffff_ffff; PROVEN: Hi3516D V300 data sheet, PDF page 300, section 4.1.6.2). Per-instance register (sec_regions = 0 to 15): modelled inside the regfile array of its variable.";
        field {
            name = "mid_sel_wr";
            desc = "Bit matching select for the MID (write command)
- 0: unsuccessful matching when the lower six bits of the MID of the write command are n
- 1: successful matching when the lower six bits of the MID of the write command are n";
            sw = rw; hw = r;
            reset = 0xffffffff;
        } mid_sel_wr[31:0];
    } SEC_MID_WR_EXT_13 @ 0x2d4;
    reg {
        name = "SEC_MID_WR_EXT";
        desc = "SEC_MID_WR_EXT is the MID and mask match register for the write command. (for upper 32 MIDs) SEC_MID_WR_EXT (offset 0x204+0x10 x sec_regions, total reset 0xffff_ffff; PROVEN: Hi3516D V300 data sheet, PDF page 300, section 4.1.6.2). Per-instance register (sec_regions = 0 to 15): modelled inside the regfile array of its variable.";
        field {
            name = "mid_sel_wr";
            desc = "Bit matching select for the MID (write command)
- 0: unsuccessful matching when the lower six bits of the MID of the write command are n
- 1: successful matching when the lower six bits of the MID of the write command are n";
            sw = rw; hw = r;
            reset = 0xffffffff;
        } mid_sel_wr[31:0];
    } SEC_MID_WR_EXT_14 @ 0x2e4;
    reg {
        name = "SEC_MID_WR_EXT";
        desc = "SEC_MID_WR_EXT is the MID and mask match register for the write command. (for upper 32 MIDs) SEC_MID_WR_EXT (offset 0x204+0x10 x sec_regions, total reset 0xffff_ffff; PROVEN: Hi3516D V300 data sheet, PDF page 300, section 4.1.6.2). Per-instance register (sec_regions = 0 to 15): modelled inside the regfile array of its variable.";
        field {
            name = "mid_sel_wr";
            desc = "Bit matching select for the MID (write command)
- 0: unsuccessful matching when the lower six bits of the MID of the write command are n
- 1: successful matching when the lower six bits of the MID of the write command are n";
            sw = rw; hw = r;
            reset = 0xffffffff;
        } mid_sel_wr[31:0];
    } SEC_MID_WR_EXT_15 @ 0x2f4;
    reg {
        name = "SEC_MID_RD_EXT";
        desc = "SEC_MID_RD_EXT is the MID and mask match register for the read command. (for the upper 32 MIDs) SEC_MID_RD_EXT (offset 0x208+0x10 x sec_regions, total reset 0xffff_ffff; PROVEN: Hi3516D V300 data sheet, PDF page 301, section 4.1.6.2). Per-instance register (sec_regions = 0 to 15): modelled inside the regfile array of its variable.";
        field {
            name = "mid_sel_rd";
            desc = "Bit matching select for the MID (read command)
- 0: unsuccessful matching when the lower six bits of the MID of the read command are n
- 1: successful matching when the lower six bits of the MID of the read command are n";
            sw = rw; hw = r;
            reset = 0xffffffff;
        } mid_sel_rd[31:0];
    } SEC_MID_RD_EXT_0 @ 0x208;
    reg {
        name = "SEC_MID_RD_EXT";
        desc = "SEC_MID_RD_EXT is the MID and mask match register for the read command. (for the upper 32 MIDs) SEC_MID_RD_EXT (offset 0x208+0x10 x sec_regions, total reset 0xffff_ffff; PROVEN: Hi3516D V300 data sheet, PDF page 301, section 4.1.6.2). Per-instance register (sec_regions = 0 to 15): modelled inside the regfile array of its variable.";
        field {
            name = "mid_sel_rd";
            desc = "Bit matching select for the MID (read command)
- 0: unsuccessful matching when the lower six bits of the MID of the read command are n
- 1: successful matching when the lower six bits of the MID of the read command are n";
            sw = rw; hw = r;
            reset = 0xffffffff;
        } mid_sel_rd[31:0];
    } SEC_MID_RD_EXT_1 @ 0x218;
    reg {
        name = "SEC_MID_RD_EXT";
        desc = "SEC_MID_RD_EXT is the MID and mask match register for the read command. (for the upper 32 MIDs) SEC_MID_RD_EXT (offset 0x208+0x10 x sec_regions, total reset 0xffff_ffff; PROVEN: Hi3516D V300 data sheet, PDF page 301, section 4.1.6.2). Per-instance register (sec_regions = 0 to 15): modelled inside the regfile array of its variable.";
        field {
            name = "mid_sel_rd";
            desc = "Bit matching select for the MID (read command)
- 0: unsuccessful matching when the lower six bits of the MID of the read command are n
- 1: successful matching when the lower six bits of the MID of the read command are n";
            sw = rw; hw = r;
            reset = 0xffffffff;
        } mid_sel_rd[31:0];
    } SEC_MID_RD_EXT_2 @ 0x228;
    reg {
        name = "SEC_MID_RD_EXT";
        desc = "SEC_MID_RD_EXT is the MID and mask match register for the read command. (for the upper 32 MIDs) SEC_MID_RD_EXT (offset 0x208+0x10 x sec_regions, total reset 0xffff_ffff; PROVEN: Hi3516D V300 data sheet, PDF page 301, section 4.1.6.2). Per-instance register (sec_regions = 0 to 15): modelled inside the regfile array of its variable.";
        field {
            name = "mid_sel_rd";
            desc = "Bit matching select for the MID (read command)
- 0: unsuccessful matching when the lower six bits of the MID of the read command are n
- 1: successful matching when the lower six bits of the MID of the read command are n";
            sw = rw; hw = r;
            reset = 0xffffffff;
        } mid_sel_rd[31:0];
    } SEC_MID_RD_EXT_3 @ 0x238;
    reg {
        name = "SEC_MID_RD_EXT";
        desc = "SEC_MID_RD_EXT is the MID and mask match register for the read command. (for the upper 32 MIDs) SEC_MID_RD_EXT (offset 0x208+0x10 x sec_regions, total reset 0xffff_ffff; PROVEN: Hi3516D V300 data sheet, PDF page 301, section 4.1.6.2). Per-instance register (sec_regions = 0 to 15): modelled inside the regfile array of its variable.";
        field {
            name = "mid_sel_rd";
            desc = "Bit matching select for the MID (read command)
- 0: unsuccessful matching when the lower six bits of the MID of the read command are n
- 1: successful matching when the lower six bits of the MID of the read command are n";
            sw = rw; hw = r;
            reset = 0xffffffff;
        } mid_sel_rd[31:0];
    } SEC_MID_RD_EXT_4 @ 0x248;
    reg {
        name = "SEC_MID_RD_EXT";
        desc = "SEC_MID_RD_EXT is the MID and mask match register for the read command. (for the upper 32 MIDs) SEC_MID_RD_EXT (offset 0x208+0x10 x sec_regions, total reset 0xffff_ffff; PROVEN: Hi3516D V300 data sheet, PDF page 301, section 4.1.6.2). Per-instance register (sec_regions = 0 to 15): modelled inside the regfile array of its variable.";
        field {
            name = "mid_sel_rd";
            desc = "Bit matching select for the MID (read command)
- 0: unsuccessful matching when the lower six bits of the MID of the read command are n
- 1: successful matching when the lower six bits of the MID of the read command are n";
            sw = rw; hw = r;
            reset = 0xffffffff;
        } mid_sel_rd[31:0];
    } SEC_MID_RD_EXT_5 @ 0x258;
    reg {
        name = "SEC_MID_RD_EXT";
        desc = "SEC_MID_RD_EXT is the MID and mask match register for the read command. (for the upper 32 MIDs) SEC_MID_RD_EXT (offset 0x208+0x10 x sec_regions, total reset 0xffff_ffff; PROVEN: Hi3516D V300 data sheet, PDF page 301, section 4.1.6.2). Per-instance register (sec_regions = 0 to 15): modelled inside the regfile array of its variable.";
        field {
            name = "mid_sel_rd";
            desc = "Bit matching select for the MID (read command)
- 0: unsuccessful matching when the lower six bits of the MID of the read command are n
- 1: successful matching when the lower six bits of the MID of the read command are n";
            sw = rw; hw = r;
            reset = 0xffffffff;
        } mid_sel_rd[31:0];
    } SEC_MID_RD_EXT_6 @ 0x268;
    reg {
        name = "SEC_MID_RD_EXT";
        desc = "SEC_MID_RD_EXT is the MID and mask match register for the read command. (for the upper 32 MIDs) SEC_MID_RD_EXT (offset 0x208+0x10 x sec_regions, total reset 0xffff_ffff; PROVEN: Hi3516D V300 data sheet, PDF page 301, section 4.1.6.2). Per-instance register (sec_regions = 0 to 15): modelled inside the regfile array of its variable.";
        field {
            name = "mid_sel_rd";
            desc = "Bit matching select for the MID (read command)
- 0: unsuccessful matching when the lower six bits of the MID of the read command are n
- 1: successful matching when the lower six bits of the MID of the read command are n";
            sw = rw; hw = r;
            reset = 0xffffffff;
        } mid_sel_rd[31:0];
    } SEC_MID_RD_EXT_7 @ 0x278;
    reg {
        name = "SEC_MID_RD_EXT";
        desc = "SEC_MID_RD_EXT is the MID and mask match register for the read command. (for the upper 32 MIDs) SEC_MID_RD_EXT (offset 0x208+0x10 x sec_regions, total reset 0xffff_ffff; PROVEN: Hi3516D V300 data sheet, PDF page 301, section 4.1.6.2). Per-instance register (sec_regions = 0 to 15): modelled inside the regfile array of its variable.";
        field {
            name = "mid_sel_rd";
            desc = "Bit matching select for the MID (read command)
- 0: unsuccessful matching when the lower six bits of the MID of the read command are n
- 1: successful matching when the lower six bits of the MID of the read command are n";
            sw = rw; hw = r;
            reset = 0xffffffff;
        } mid_sel_rd[31:0];
    } SEC_MID_RD_EXT_8 @ 0x288;
    reg {
        name = "SEC_MID_RD_EXT";
        desc = "SEC_MID_RD_EXT is the MID and mask match register for the read command. (for the upper 32 MIDs) SEC_MID_RD_EXT (offset 0x208+0x10 x sec_regions, total reset 0xffff_ffff; PROVEN: Hi3516D V300 data sheet, PDF page 301, section 4.1.6.2). Per-instance register (sec_regions = 0 to 15): modelled inside the regfile array of its variable.";
        field {
            name = "mid_sel_rd";
            desc = "Bit matching select for the MID (read command)
- 0: unsuccessful matching when the lower six bits of the MID of the read command are n
- 1: successful matching when the lower six bits of the MID of the read command are n";
            sw = rw; hw = r;
            reset = 0xffffffff;
        } mid_sel_rd[31:0];
    } SEC_MID_RD_EXT_9 @ 0x298;
    reg {
        name = "SEC_MID_RD_EXT";
        desc = "SEC_MID_RD_EXT is the MID and mask match register for the read command. (for the upper 32 MIDs) SEC_MID_RD_EXT (offset 0x208+0x10 x sec_regions, total reset 0xffff_ffff; PROVEN: Hi3516D V300 data sheet, PDF page 301, section 4.1.6.2). Per-instance register (sec_regions = 0 to 15): modelled inside the regfile array of its variable.";
        field {
            name = "mid_sel_rd";
            desc = "Bit matching select for the MID (read command)
- 0: unsuccessful matching when the lower six bits of the MID of the read command are n
- 1: successful matching when the lower six bits of the MID of the read command are n";
            sw = rw; hw = r;
            reset = 0xffffffff;
        } mid_sel_rd[31:0];
    } SEC_MID_RD_EXT_10 @ 0x2a8;
    reg {
        name = "SEC_MID_RD_EXT";
        desc = "SEC_MID_RD_EXT is the MID and mask match register for the read command. (for the upper 32 MIDs) SEC_MID_RD_EXT (offset 0x208+0x10 x sec_regions, total reset 0xffff_ffff; PROVEN: Hi3516D V300 data sheet, PDF page 301, section 4.1.6.2). Per-instance register (sec_regions = 0 to 15): modelled inside the regfile array of its variable.";
        field {
            name = "mid_sel_rd";
            desc = "Bit matching select for the MID (read command)
- 0: unsuccessful matching when the lower six bits of the MID of the read command are n
- 1: successful matching when the lower six bits of the MID of the read command are n";
            sw = rw; hw = r;
            reset = 0xffffffff;
        } mid_sel_rd[31:0];
    } SEC_MID_RD_EXT_11 @ 0x2b8;
    reg {
        name = "SEC_MID_RD_EXT";
        desc = "SEC_MID_RD_EXT is the MID and mask match register for the read command. (for the upper 32 MIDs) SEC_MID_RD_EXT (offset 0x208+0x10 x sec_regions, total reset 0xffff_ffff; PROVEN: Hi3516D V300 data sheet, PDF page 301, section 4.1.6.2). Per-instance register (sec_regions = 0 to 15): modelled inside the regfile array of its variable.";
        field {
            name = "mid_sel_rd";
            desc = "Bit matching select for the MID (read command)
- 0: unsuccessful matching when the lower six bits of the MID of the read command are n
- 1: successful matching when the lower six bits of the MID of the read command are n";
            sw = rw; hw = r;
            reset = 0xffffffff;
        } mid_sel_rd[31:0];
    } SEC_MID_RD_EXT_12 @ 0x2c8;
    reg {
        name = "SEC_MID_RD_EXT";
        desc = "SEC_MID_RD_EXT is the MID and mask match register for the read command. (for the upper 32 MIDs) SEC_MID_RD_EXT (offset 0x208+0x10 x sec_regions, total reset 0xffff_ffff; PROVEN: Hi3516D V300 data sheet, PDF page 301, section 4.1.6.2). Per-instance register (sec_regions = 0 to 15): modelled inside the regfile array of its variable.";
        field {
            name = "mid_sel_rd";
            desc = "Bit matching select for the MID (read command)
- 0: unsuccessful matching when the lower six bits of the MID of the read command are n
- 1: successful matching when the lower six bits of the MID of the read command are n";
            sw = rw; hw = r;
            reset = 0xffffffff;
        } mid_sel_rd[31:0];
    } SEC_MID_RD_EXT_13 @ 0x2d8;
    reg {
        name = "SEC_MID_RD_EXT";
        desc = "SEC_MID_RD_EXT is the MID and mask match register for the read command. (for the upper 32 MIDs) SEC_MID_RD_EXT (offset 0x208+0x10 x sec_regions, total reset 0xffff_ffff; PROVEN: Hi3516D V300 data sheet, PDF page 301, section 4.1.6.2). Per-instance register (sec_regions = 0 to 15): modelled inside the regfile array of its variable.";
        field {
            name = "mid_sel_rd";
            desc = "Bit matching select for the MID (read command)
- 0: unsuccessful matching when the lower six bits of the MID of the read command are n
- 1: successful matching when the lower six bits of the MID of the read command are n";
            sw = rw; hw = r;
            reset = 0xffffffff;
        } mid_sel_rd[31:0];
    } SEC_MID_RD_EXT_14 @ 0x2e8;
    reg {
        name = "SEC_MID_RD_EXT";
        desc = "SEC_MID_RD_EXT is the MID and mask match register for the read command. (for the upper 32 MIDs) SEC_MID_RD_EXT (offset 0x208+0x10 x sec_regions, total reset 0xffff_ffff; PROVEN: Hi3516D V300 data sheet, PDF page 301, section 4.1.6.2). Per-instance register (sec_regions = 0 to 15): modelled inside the regfile array of its variable.";
        field {
            name = "mid_sel_rd";
            desc = "Bit matching select for the MID (read command)
- 0: unsuccessful matching when the lower six bits of the MID of the read command are n
- 1: successful matching when the lower six bits of the MID of the read command are n";
            sw = rw; hw = r;
            reset = 0xffffffff;
        } mid_sel_rd[31:0];
    } SEC_MID_RD_EXT_15 @ 0x2f8;
};

`endif
