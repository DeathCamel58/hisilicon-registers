`ifndef EHI3516DV300_VICAP_RDL
`define EHI3516DV300_VICAP_RDL
regfile eHI3516DV300_VICAP {
    name = "Video capture (VICAP)";
    desc = "Video capture (VICAP). 90 registers extracted programmatically from the Hi3516D V300 Professional Smart IP Camera SoC data sheet (Issue 01, 2019-09-12); chapter 9.1.6, table 9-4. Field names, bit ranges, access types and reset values are taken from the register tables; reset values are the data sheet total reset values split onto the fields (per-field values where the table has them). Label: PROVEN. Hardware not verified here (no board).";
    reg {
        name = "WK_MODE";
        desc = "WK_MODE is the global operating mode configuration register. WK_MODE (offset 0x0000, total reset 0x0000_0003; PROVEN: Hi3516D V300 data sheet, PDF page 506, section 9.1.6).";
        field {
            name = "reserved";
            desc = "Reserved";
            sw = r; hw = na;
            reset = 0x0;
        } reserved_31_2[31:2];
        field {
            name = "reserved";
            desc = "Reserved";
            sw = r; hw = na;
            reset = 0x1;
        } reserved_1_1[1:1];
        field {
            name = "power_mode";
            desc = "Clock mode
- 0: The low-power mode is disabled.";
            sw = rw; hw = r;
            reset = 0x1;
        } power_mode[0:0];
    } WK_MODE @ 0x0;
    reg {
        name = "AXI_CFG";
        desc = "AXI_CFG is the bus configuration register. AXI_CFG (offset 0x0010, total reset 0x0000_0000; PROVEN: Hi3516D V300 data sheet, PDF page 507, section 9.1.6).";
        field {
            name = "reserved";
            desc = "Reserved";
            sw = r; hw = na;
            reset = 0x0;
        } reserved_31_8[31:8];
        field {
            name = "w_outstanding";
            desc = "Number of write request outstandings Value range: [0,7]";
            sw = rw; hw = r;
            reset = 0x0;
        } w_outstanding[7:4];
        field {
            name = "reserved";
            desc = "Reserved";
            sw = r; hw = na;
            reset = 0x0;
        } reserved_3_0[3:0];
    } AXI_CFG @ 0x10;
    reg {
        name = "AXI_WR_PROT";
        desc = "AXI_WR_PROT is the security attribute register for the AXI bus write channel. AXI_WR_PROT (offset 0x001C, total reset 0x0000_0000; PROVEN: Hi3516D V300 data sheet, PDF page 507, section 9.1.6).";
        field {
            name = "reserved";
            desc = "Reserved";
            sw = r; hw = na;
            reset = 0x0;
        } reserved_31_12[31:12];
        field {
            name = "Isp3_stt_prot";
            desc = "Security attribute of ISP 3 STT channel
- 0: secure
- 1: non-secure";
            sw = rw; hw = r;
            reset = 0x0;
        } Isp3_stt_prot[11:11];
        field {
            name = "Isp2_stt_prot";
            desc = "Security attribute of ISP 2 STT channel
- 0: secure
- 1: non-secure";
            sw = rw; hw = r;
            reset = 0x0;
        } Isp2_stt_prot[10:10];
        field {
            name = "isp1_stt_prot";
            desc = "Security attribute of ISP 1 STT channel
- 0: secure
- 1: non-secure";
            sw = rw; hw = r;
            reset = 0x0;
        } isp1_stt_prot[9:9];
        field {
            name = "isp0_stt_prot";
            desc = "Security attribute of ISP 0 STT channel
- 0: secure
- 1: non-secure";
            sw = rw; hw = r;
            reset = 0x0;
        } isp0_stt_prot[8:8];
        field {
            name = "reserved";
            desc = "Reserved";
            sw = r; hw = na;
            reset = 0x0;
        } reserved_7_4[7:4];
        field {
            name = "ch3_prot";
            desc = "Security attribute of channel 3
- 0: secure
- 1: non-secure";
            sw = rw; hw = r;
            reset = 0x0;
        } ch3_prot[3:3];
        field {
            name = "ch2_prot";
            desc = "Security attribute of channel 2
- 0: secure
- 1: non-secure";
            sw = rw; hw = r;
            reset = 0x0;
        } ch2_prot[2:2];
        field {
            name = "ch1_prot";
            desc = "Security attribute of channel 1
- 0: secure
- 1: non-secure";
            sw = rw; hw = r;
            reset = 0x0;
        } ch1_prot[1:1];
        field {
            name = "ch0_prot";
            desc = "Security attribute of channel 0
- 0: secure
- 1: non-secure";
            sw = rw; hw = r;
            reset = 0x0;
        } ch0_prot[0:0];
    } AXI_WR_PROT @ 0x1c;
    reg {
        name = "CMUX_SEL";
        desc = "CMUX_SEL is the CMUX channel select register. CMUX_SEL (offset 0x0050, total reset 0x0054_3210; PROVEN: Hi3516D V300 data sheet, PDF page 508, section 9.1.6).";
        field {
            name = "reserved";
            desc = "Reserved";
            sw = r; hw = na;
            reset = 0x54;
        } reserved_31_16[31:16];
        field {
            name = "chn3_sel";
            desc = "Channel 3 select configuration register
- 0x0: port 0 input data
- 0x1: port 1 input data

Other values: reserved";
            sw = rw; hw = r;
            reset = 0x3;
        } chn3_sel[15:12];
        field {
            name = "chn2_sel";
            desc = "Channel 2 select configuration register
- 0x0: port 0 input data
- 0x1: port 1 input data

Other values: reserved";
            sw = rw; hw = r;
            reset = 0x2;
        } chn2_sel[11:8];
        field {
            name = "chn1_sel";
            desc = "Channel 1 select configuration register
- 0x0: port 0 input data
- 0x1: port 1 input data

Other values: reserved";
            sw = rw; hw = r;
            reset = 0x1;
        } chn1_sel[7:4];
        field {
            name = "chn0_sel";
            desc = "Channel 0 select configuration register
- 0x0: port 0 input data
- 0x1: port 1 input data

Other values: reserved";
            sw = rw; hw = r;
            reset = 0x0;
        } chn0_sel[3:0];
    } CMUX_SEL @ 0x50;
    reg {
        name = "CMUX_ID_CFG";
        desc = "CMUX_ID_CFG is the CMUX frame ID select register. CMUX_ID_CFG (offset 0x0054, total reset 0x00FF_FFFF; PROVEN: Hi3516D V300 data sheet, PDF page 509, section 9.1.6).";
        field {
            name = "reserved";
            desc = "Reserved";
            sw = r; hw = na;
            reset = 0x0;
        } reserved_31_24[31:24];
        field {
            name = "reserved";
            desc = "Reserved";
            sw = r; hw = na;
            reset = 0xff;
        } reserved_23_16[23:16];
        field {
            name = "chn3_id";
            desc = "Channel 3 ID select register
- 0: Data with this ID is filtered.
- 1: Data with this ID is received. bit[0]: Channel RX enable for data with the ID 0 bit[1]: Channel RX enable for data with the ID 1 bit[2]: Channel RX enable for data with the ID 2 bit[3]: Channel RX enable for data with the ID 3";
            sw = rw; hw = r;
            reset = 0xf;
        } chn3_id[15:12];
        field {
            name = "chn2_id";
            desc = "Channel 2 ID select register
- 0: Data with this ID is filtered.
- 1: Data with this ID is received. bit[0]: Channel RX enable for data with the ID 0 bit[1]: Channel RX enable for data with the ID 1 bit[2]: Channel RX enable for data with the ID 2 bit[3]: Channel RX enable for data with the ID 3";
            sw = rw; hw = r;
            reset = 0xf;
        } chn2_id[11:8];
        field {
            name = "chn1_id";
            desc = "Channel 1 ID select register
- 0: Data with this ID is filtered.
- 1: Data with this ID is received. bit[0]: Channel RX enable for data with the ID 0 bit[1]: Channel RX enable for data with the ID 1 bit[2]: Channel RX enable for data with the ID 2 bit[3]: Channel RX enable for data with the ID 3";
            sw = rw; hw = r;
            reset = 0xf;
        } chn1_id[7:4];
        field {
            name = "chn0_id";
            desc = "Channel 0 ID select register
- 0: Data with this ID is filtered.
- 1: Data with this ID is received. bit[0]: Channel RX enable for data with the ID 0";
            sw = rw; hw = r;
            reset = 0xf;
        } chn0_id[3:0];
    } CMUX_ID_CFG @ 0x54;
    reg {
        name = "ISP_MODE";
        desc = "ISP_MODE is the ISP mode select register. ISP_MODE (offset 0x0058, total reset 0x0000_0000; PROVEN: Hi3516D V300 data sheet, PDF page 510, section 9.1.6).";
        field {
            name = "reserved";
            desc = "Reserved";
            sw = r; hw = na;
            reset = 0x0;
        } reserved_31_20[31:20];
        field {
            name = "Isp3_in_yuv_mode";
            desc = "ISP 3 mode select configuration register
- 0: Raw data is input.
- 1: YUV data is input.";
            sw = rw; hw = r;
            reset = 0x0;
        } Isp3_in_yuv_mode[19:19];
        field {
            name = "Isp2_in_yuv_mode";
            desc = "ISP 2 mode select configuration register
- 0: Raw data is input.
- 1: YUV data is input.";
            sw = rw; hw = r;
            reset = 0x0;
        } Isp2_in_yuv_mode[18:18];
        field {
            name = "isp1_in_yuv_mode";
            desc = "ISP 1 mode select configuration register
- 0: Raw data is input.
- 1: YUV data is input.";
            sw = rw; hw = r;
            reset = 0x0;
        } isp1_in_yuv_mode[17:17];
        field {
            name = "isp0_in_yuv_mode";
            desc = "ISP 0 mode select configuration register
- 0: Raw data is input.
- 1: YUV data is input.";
            sw = rw; hw = r;
            reset = 0x0;
        } isp0_in_yuv_mode[16:16];
        field {
            name = "reserved";
            desc = "Reserved";
            sw = r; hw = na;
            reset = 0x0;
        } reserved_15_4[15:4];
        field {
            name = "Isp3_mode";
            desc = "ISP 3 mode select configuration register
- 0: Data is processed by the ISP.
- 1: Data is bypassed by the ISP.";
            sw = rw; hw = r;
            reset = 0x0;
        } Isp3_mode[3:3];
        field {
            name = "Isp2_mode";
            desc = "ISP 2 mode select configuration register
- 0: Data is processed by the ISP.
- 1: Data is bypassed by the ISP.";
            sw = rw; hw = r;
            reset = 0x0;
        } Isp2_mode[2:2];
        field {
            name = "isp1_mode";
            desc = "ISP 1 mode select configuration register
- 0: Data is processed by the ISP.
- 1: Data is bypassed by the ISP.";
            sw = rw; hw = r;
            reset = 0x0;
        } isp1_mode[1:1];
        field {
            name = "isp0_mode";
            desc = "ISP 0 mode select configuration register";
            sw = rw; hw = r;
            reset = 0x0;
        } isp0_mode[0:0];
    } ISP_MODE @ 0x58;
    reg {
        name = "VICAP_INT";
        desc = "VICAP_INT is the interrupt status register. VICAP_INT (offset 0x00F0, total reset 0x0000_0000; PROVEN: Hi3516D V300 data sheet, PDF page 511, section 9.1.6).";
        field {
            name = "reserved";
            desc = "Reserved";
            sw = r; hw = na;
            reset = 0x0;
        } reserved_31_27[31:27];
        field {
            name = "int_dbg";
            desc = "System bus exception interrupt indicator
- 0: No interrupt is generated.
- 1: An interrupt is generated.";
            sw = r; hw = w;
            reset = 0x0;
        } int_dbg[26:26];
        field {
            name = "reserved";
            desc = "Reserved";
            sw = r; hw = na;
            reset = 0x0;
        } reserved_25_20[25:20];
        field {
            name = "int_isp3";
            desc = "ISP 3 interrupt indicator
- 0: No interrupt is generated.
- 1: An interrupt is generated.";
            sw = r; hw = w;
            reset = 0x0;
        } int_isp3[19:19];
        field {
            name = "int_isp2";
            desc = "ISP 2 interrupt indicator
- 0: No interrupt is generated.
- 1: An interrupt is generated.";
            sw = r; hw = w;
            reset = 0x0;
        } int_isp2[18:18];
        field {
            name = "int_isp1";
            desc = "ISP 1 interrupt indicator
- 0: No interrupt is generated.
- 1: An interrupt is generated.";
            sw = r; hw = w;
            reset = 0x0;
        } int_isp1[17:17];
        field {
            name = "int_isp0";
            desc = "ISP 0 interrupt indicator
- 0: No interrupt is generated.
- 1: An interrupt is generated.";
            sw = r; hw = w;
            reset = 0x0;
        } int_isp0[16:16];
        field {
            name = "reserved";
            desc = "Reserved";
            sw = r; hw = na;
            reset = 0x0;
        } reserved_15_12[15:12];
        field {
            name = "int_ch3";
            desc = "Channel 3 interrupt indicator
- 0: No interrupt is generated.
- 1: An interrupt is generated.";
            sw = r; hw = w;
            reset = 0x0;
        } int_ch3[11:11];
        field {
            name = "int_ch2";
            desc = "Channel 2 interrupt indicator
- 0: No interrupt is generated.
- 1: An interrupt is generated.";
            sw = r; hw = w;
            reset = 0x0;
        } int_ch2[10:10];
        field {
            name = "int_ch1";
            desc = "Channel 1 interrupt indicator
- 0: No interrupt is generated.
- 1: An interrupt is generated.";
            sw = r; hw = w;
            reset = 0x0;
        } int_ch1[9:9];
        field {
            name = "int_ch0";
            desc = "Channel 0 interrupt indicator
- 0: No interrupt is generated.
- 1: An interrupt is generated.";
            sw = r; hw = w;
            reset = 0x0;
        } int_ch0[8:8];
        field {
            name = "reserved";
            desc = "Reserved";
            sw = r; hw = na;
            reset = 0x0;
        } reserved_7_2[7:2];
        field {
            name = "int_pt1";
            desc = "Port 1 interrupt indicator
- 0: No interrupt is generated.
- 1: An interrupt is generated.";
            sw = r; hw = w;
            reset = 0x0;
        } int_pt1[1:1];
        field {
            name = "int_pt0";
            desc = "Port 0 interrupt indicator
- 0: No interrupt is generated.
- 1: An interrupt is generated.";
            sw = r; hw = w;
            reset = 0x0;
        } int_pt0[0:0];
    } VICAP_INT @ 0xf0;
    reg {
        name = "VICAP_INT_MASK";
        desc = "VICAP_INT_MASK is the interrupt mask register. VICAP_INT_MASK (offset 0x00F8, total reset 0x0000_0000; PROVEN: Hi3516D V300 data sheet, PDF page 512, section 9.1.6).";
        field {
            name = "reserved";
            desc = "Reserved";
            sw = r; hw = na;
            reset = 0x0;
        } reserved_31_27[31:27];
        field {
            name = "mask_dbg";
            desc = "System bus exception interrupt enable
- 0: The interrupt is masked.
- 1: The interrupt is enabled.";
            sw = rw; hw = r;
            reset = 0x0;
        } mask_dbg[26:26];
        field {
            name = "reserved";
            desc = "Reserved";
            sw = r; hw = na;
            reset = 0x0;
        } reserved_25_20[25:20];
        field {
            name = "mask_isp3";
            desc = "ISP 3 interrupt enable
- 0: The interrupt is masked.
- 1: The interrupt is enabled.";
            sw = rw; hw = r;
            reset = 0x0;
        } mask_isp3[19:19];
        field {
            name = "mask_isp2";
            desc = "ISP 2 interrupt enable
- 0: The interrupt is masked.
- 1: The interrupt is enabled.";
            sw = rw; hw = r;
            reset = 0x0;
        } mask_isp2[18:18];
        field {
            name = "mask_isp1";
            desc = "ISP 1 interrupt enable
- 0: The interrupt is masked.
- 1: The interrupt is enabled.";
            sw = rw; hw = r;
            reset = 0x0;
        } mask_isp1[17:17];
        field {
            name = "mask_isp0";
            desc = "ISP 0 interrupt enable
- 0: The interrupt is masked.
- 1: The interrupt is enabled.";
            sw = rw; hw = r;
            reset = 0x0;
        } mask_isp0[16:16];
        field {
            name = "reserved";
            desc = "Reserved";
            sw = rw; hw = r;
            reset = 0x0;
        } reserved_15_12[15:12];
        field {
            name = "mask_ch3";
            desc = "Channel 3 interrupt enable";
            sw = rw; hw = r;
            reset = 0x0;
        } mask_ch3[11:11];
        field {
            name = "mask_ch2";
            desc = "Channel 2 interrupt enable
- 0: The interrupt is masked.
- 1: The interrupt is enabled.";
            sw = rw; hw = r;
            reset = 0x0;
        } mask_ch2[10:10];
        field {
            name = "mask_ch1";
            desc = "Channel 1 interrupt enable
- 0: The interrupt is masked.
- 1: The interrupt is enabled.";
            sw = rw; hw = r;
            reset = 0x0;
        } mask_ch1[9:9];
        field {
            name = "mask_ch0";
            desc = "Channel 0 interrupt enable
- 0: The interrupt is masked.
- 1: The interrupt is enabled.";
            sw = rw; hw = r;
            reset = 0x0;
        } mask_ch0[8:8];
        field {
            name = "reserved";
            desc = "Reserved";
            sw = r; hw = na;
            reset = 0x0;
        } reserved_7_2[7:2];
        field {
            name = "mask_pt1";
            desc = "Port 1 interrupt enable
- 0: The interrupt is masked.
- 1: The interrupt is enabled.";
            sw = rw; hw = r;
            reset = 0x0;
        } mask_pt1[1:1];
        field {
            name = "mask_pt0";
            desc = "Port 0 interrupt enable
- 0: The interrupt is masked.
- 1: The interrupt is enabled.";
            sw = rw; hw = r;
            reset = 0x0;
        } mask_pt0[0:0];
    } VICAP_INT_MASK @ 0xf8;
    reg {
        name = "SLAVE0_MODE_CFG";
        desc = "SLAVE0_MODE_CFG is the sensor 0 slave mode configuration register. SLAVE0_MODE_CFG (offset 0x0100, total reset 0x0000_0000; PROVEN: Hi3516D V300 data sheet, PDF page 513, section 9.1.6).";
        field {
            name = "slave0_vs_enable";
            desc = "Vsync output enable
- 0: disabled
- 1: enabled";
            sw = rw; hw = r;
            reset = 0x0;
        } slave0_vs_enable[31:31];
        field {
            name = "slave0_hs_enable";
            desc = "Hsync output enable
- 0: disabled
- 1: enabled";
            sw = rw; hw = r;
            reset = 0x0;
        } slave0_hs_enable[30:30];
        field {
            name = "slave0_vs_out_enable";
            desc = "VS_OUT output enable
- 0: disabled
- 1: enabled";
            sw = rw; hw = r;
            reset = 0x0;
        } slave0_vs_out_enable[29:29];
        field {
            name = "reserved";
            desc = "Reserved";
            sw = r; hw = na;
            reset = 0x0;
        } reserved_28_18[28:18];
        field {
            name = "slave0_vs_inv";
            desc = "Vsync output polarity
- 0: active high
- 1: active low";
            sw = rw; hw = r;
            reset = 0x0;
        } slave0_vs_inv[17:17];
        field {
            name = "slave0_hs_inv";
            desc = "Hsync output polarity
- 0: active high
- 1: active low";
            sw = rw; hw = r;
            reset = 0x0;
        } slave0_hs_inv[16:16];
        field {
            name = "slave0_vs_out_inv";
            desc = "VS_OUT output polarity
- 0: active high
- 1: active low";
            sw = rw; hw = r;
            reset = 0x0;
        } slave0_vs_out_inv[15:15];
        field {
            name = "slave0_vs_mux";
            desc = "VS/VS_OUT output signal switchover enable
- 0: disabled
- 1: enabled";
            sw = rw; hw = r;
            reset = 0x0;
        } slave0_vs_mux[14:14];
        field {
            name = "reserved";
            desc = "Reserved";
            sw = r; hw = na;
            reset = 0x0;
        } reserved_13_1[13:1];
        field {
            name = "slave0_update_mode";
            desc = "Update mode select
- 0: immediate update mode
- 1: frame update mode";
            sw = rw; hw = r;
            reset = 0x0;
        } slave0_update_mode[0:0];
    } SLAVE0_MODE_CFG @ 0x100;
    reg {
        name = "SLAVE0_MODE_VS_TIME_H";
        desc = "SLAVE0_MODE_VS_TIME_H is the Vsync output cycle configuration register in sensor 0 slave mode. SLAVE0_MODE_VS_TIME_H (offset 0x0104, total reset 0x0000_0000; PROVEN: Hi3516D V300 data sheet, PDF page 514, section 9.1.6).";
        field {
            name = "slave0_vs_time_h";
            desc = "";
            sw = rw; hw = r;
            reset = 0x0;
        } slave0_vs_time_h[31:0];
    } SLAVE0_MODE_VS_TIME_H @ 0x104;
    reg {
        name = "SLAVE0_MODE_VS_TIME_L";
        desc = "SLAVE0_MODE_VS_TIME_L is the Vsync output cycle configuration register in sensor 0 slave mode. SLAVE0_MODE_VS_TIME_L (offset 0x0108, total reset 0x0000_0000; PROVEN: Hi3516D V300 data sheet, PDF page 514, section 9.1.6).";
        field {
            name = "slave0_vs_time_l";
            desc = "";
            sw = rw; hw = r;
            reset = 0x0;
        } slave0_vs_time_l[31:0];
    } SLAVE0_MODE_VS_TIME_L @ 0x108;
    reg {
        name = "SLAVE0_MODE_HS_TIME";
        desc = "SLAVE0_MODE_HS_TIME is the Hsync (HS) output cycle configuration register in sensor 0 slave mode. SLAVE0_MODE_HS_TIME (offset 0x010C, total reset 0x0000_0000; PROVEN: Hi3516D V300 data sheet, PDF page 515, section 9.1.6).";
        field {
            name = "slave0_hs_time";
            desc = "";
            sw = rw; hw = r;
            reset = 0x0;
        } slave0_hs_time[31:0];
    } SLAVE0_MODE_HS_TIME @ 0x10c;
    reg {
        name = "SLAVE0_MODE_VS_OUT_TIME_H";
        desc = "SLAVE0_MODE_VS_OUT_TIME_H is the Vsync _OUT output cycle configuration register in sensor 0 slave mode. SLAVE0_MODE_VS_OUT_TIME_H (offset 0x0110, total reset 0x0000_0000; PROVEN: Hi3516D V300 data sheet, PDF page 515, section 9.1.6).";
        field {
            name = "slave0_vs_out_time_h";
            desc = "VS_OUT output cycle configuration (unit: working clock cycle of the sensor)";
            sw = rw; hw = r;
            reset = 0x0;
        } slave0_vs_out_time_h[31:0];
    } SLAVE0_MODE_VS_OUT_TIME_H @ 0x110;
    reg {
        name = "SLAVE0_MODE_VS_OUT_TIME_L";
        desc = "SLAVE0_MODE_VS_OUT_TIME_L is the Vsync _OUT output cycle configuration register in sensor 0 slave mode. SLAVE0_MODE_VS_OUT_TIME_L (offset 0x0114, total reset 0x0000_0000; PROVEN: Hi3516D V300 data sheet, PDF page 515, section 9.1.6).";
        field {
            name = "slave0_vs_out_time_l";
            desc = "VS_OUT output cycle configuration (unit: working clock cycle of the sensor)";
            sw = rw; hw = r;
            reset = 0x0;
        } slave0_vs_out_time_l[31:0];
    } SLAVE0_MODE_VS_OUT_TIME_L @ 0x114;
    reg {
        name = "SLAVE0_MODE_VS_CYC_H";
        desc = "SLAVE0_MODE_VS_CYC_H is the Vsync output pulse validity signal duration configuration register in sensor 0 slave mode SLAVE0_MODE_VS_CYC_H (offset 0x0118, total reset 0x0000_0000; PROVEN: Hi3516D V300 data sheet, PDF page 515, section 9.1.6).";
        field {
            name = "slave0_vs_cyc_h";
            desc = "Duration configuration of the Vsync output validity signal (unit: working clock cycle of the sensor)";
            sw = rw; hw = r;
            reset = 0x0;
        } slave0_vs_cyc_h[31:0];
    } SLAVE0_MODE_VS_CYC_H @ 0x118;
    reg {
        name = "SLAVE0_MODE_VS_CYC_L";
        desc = "SLAVE0_MODE_VS_CYC_L is the Vsync output pulse validity signal duration configuration register in sensor 0 slave mode. SLAVE0_MODE_VS_CYC_L (offset 0x011C, total reset 0x0000_0000; PROVEN: Hi3516D V300 data sheet, PDF page 516, section 9.1.6).";
        field {
            name = "slave0_vs_cyc_l";
            desc = "Duration configuration of the Vsync output validity signal (unit: working clock cycle of the sensor)";
            sw = rw; hw = r;
            reset = 0x0;
        } slave0_vs_cyc_l[31:0];
    } SLAVE0_MODE_VS_CYC_L @ 0x11c;
    reg {
        name = "SLAVE0_MODE_HS_CYC";
        desc = "SLAVE0_MODE_HS_CYC is the Hsync output pulse validity signal duration configuration register in sensor 0 slave mode SLAVE0_MODE_HS_CYC (offset 0x0120, total reset 0x0000_0000; PROVEN: Hi3516D V300 data sheet, PDF page 516, section 9.1.6).";
        field {
            name = "slave0_hs_cyc";
            desc = "Duration configuration of the Hsync output validity signal (unit: working clock cycle of the sensor)";
            sw = rw; hw = r;
            reset = 0x0;
        } slave0_hs_cyc[31:0];
    } SLAVE0_MODE_HS_CYC @ 0x120;
    reg {
        name = "SLAVE0_MODE_VS_OUT_CYC_H";
        desc = "SLAVE0_MODE_VS_OUT_CYC_H is the Vsync _OUT output pulse validity signal duration configuration register in sensor 0 slave mode. SLAVE0_MODE_VS_OUT_CYC_H (offset 0x0124, total reset 0x0000_0000; PROVEN: Hi3516D V300 data sheet, PDF page 516, section 9.1.6).";
        field {
            name = "slave0_vs_out_cyc_h";
            desc = "Duration configuration of the Vsync _OUT output validity signal (unit: working clock cycle of the sensor)";
            sw = rw; hw = r;
            reset = 0x0;
        } slave0_vs_out_cyc_h[31:0];
    } SLAVE0_MODE_VS_OUT_CYC_H @ 0x124;
    reg {
        name = "SLAVE0_MODE_VS_OUT_CYC_L";
        desc = "SLAVE0_MODE_VS_OUT_CYC_L is the Vsync _OUT output pulse validity signal duration configuration register in sensor 0 slave mode. SLAVE0_MODE_VS_OUT_CYC_L (offset 0x0128, total reset 0x0000_0000; PROVEN: Hi3516D V300 data sheet, PDF page 516, section 9.1.6).";
        field {
            name = "slave0_vs_out_cyc_l";
            desc = "Duration configuration of the Vsync _OUT output validity signal (unit: working clock cycle of the sensor)";
            sw = rw; hw = r;
            reset = 0x0;
        } slave0_vs_out_cyc_l[31:0];
    } SLAVE0_MODE_VS_OUT_CYC_L @ 0x128;
    reg {
        name = "SLAVE0_MODE_HS_DLY_CYC";
        desc = "SLAVE0_MODE_HS_DLY_CYC is the Hsync pulse output relative to Vsync pulse delay cycle configuration register in sensor 0 slave mode. SLAVE0_MODE_HS_DLY_CYC (offset 0x012C, total reset 0x0000_0000; PROVEN: Hi3516D V300 data sheet, PDF page 517, section 9.1.6).";
        field {
            name = "slave0_hs_dly_cyc";
            desc = "Hsync pulse output relative to Vsync pulse delay cycle configuration (unit: working clock cycle of the sensor)";
            sw = rw; hw = r;
            reset = 0x0;
        } slave0_hs_dly_cyc[31:0];
    } SLAVE0_MODE_HS_DLY_CYC @ 0x12c;
    reg {
        name = "SLAVE0_MODE_VS_OUT_DLY_CYC_H";
        desc = "SLAVE0_MODE_VS_OUT_DLY_CYC_H is the Vsync _OUT pulse output relative to Vsync pulse delay cycle configuration register in sensor 0 slave mode. SLAVE0_MODE_VS_OUT_DLY_CYC_H (offset 0x0130, total reset 0x0000_0000; PROVEN: Hi3516D V300 data sheet, PDF page 517, section 9.1.6).";
        field {
            name = "slave0_vs_out_dly_cyc_h";
            desc = "VS_OUT pulse output relative to Vsync pulse delay cycle configuration (unit: working clock cycle of the sensor)";
            sw = rw; hw = r;
            reset = 0x0;
        } slave0_vs_out_dly_cyc_h[31:0];
    } SLAVE0_MODE_VS_OUT_DLY_CYC_H @ 0x130;
    reg {
        name = "SLAVE0_MODE_VS_OUT_DLY_CYC_L";
        desc = "SLAVE0_MODE_VS_OUT_DLY_CYC_L is the Vsync _OUT pulse output relative to Vsync pulse delay cycle configuration register in sensor 0 slave mode. SLAVE0_MODE_VS_OUT_DLY_CYC_L (offset 0x0134, total reset 0x0000_0000; PROVEN: Hi3516D V300 data sheet, PDF page 517, section 9.1.6).";
        field {
            name = "slave0_vs_out_dly_cyc_l";
            desc = "VS_OUT pulse output relative to Vsync pulse delay cycle configuration (unit: working clock cycle of the sensor)";
            sw = rw; hw = r;
            reset = 0x0;
        } slave0_vs_out_dly_cyc_l[31:0];
    } SLAVE0_MODE_VS_OUT_DLY_CYC_L @ 0x134;
    reg {
        name = "SLAVE_MODE_SYN";
        desc = "SLAVE_MODE_SYN is the sensor synchronization signal, active on the rising edge. SLAVE_MODE_SYN (offset 0x01FC, total reset 0x0000_0000; PROVEN: Hi3516D V300 data sheet, PDF page 518, section 9.1.6).";
        field {
            name = "reserved";
            desc = "Reserved";
            sw = r; hw = na;
            reset = 0x0;
        } reserved_31_2[31:2];
        field {
            name = "sensor1_sync";
            desc = "Sensor 1 sync signal";
            sw = rw; hw = r;
            reset = 0x0;
        } sensor1_sync[1:1];
        field {
            name = "sensor0_sync";
            desc = "Sensor 0 sync signal";
            sw = rw; hw = r;
            reset = 0x0;
        } sensor0_sync[0:0];
    } SLAVE_MODE_SYN @ 0x1fc;
    reg {
        name = "ONLINE0_CFG";
        desc = "ONLINE0_CFG is the online channel 0 control register. ONLINE0_CFG (offset 0x0200, total reset 0x0000_0003; PROVEN: Hi3516D V300 data sheet, PDF page 518, section 9.1.6).";
        field {
            name = "online0_en";
            desc = "Online output enable
- 0: disabled
- 1: enabled";
            sw = rw; hw = r;
            reset = 0x0;
        } online0_en[31:31];
        field {
            name = "reserved";
            desc = "Reserved";
            sw = r; hw = na;
            reset = 0x0;
        } reserved_30_2[30:2];
        field {
            name = "online0_vsync_mode";
            desc = "Whether to delay the Vsync signal
- 0: not processed
- 1: processed";
            sw = rw; hw = r;
            reset = 0x1;
        } online0_vsync_mode[1:1];
        field {
            name = "online0_hsync_mode";
            desc = "Whether to delay the Hsync signal
- 0: not processed
- 1: processed";
            sw = rw; hw = r;
            reset = 0x1;
        } online0_hsync_mode[0:0];
    } ONLINE0_CFG @ 0x200;
    reg {
        name = "ONLINE0_SIZE";
        desc = "ONLINE0_SIZE is the online 0 output active area size register. ONLINE0_SIZE (offset 0x02AC, total reset 0x0000_0000; PROVEN: Hi3516D V300 data sheet, PDF page 518, section 9.1.6).";
        field {
            name = "online0_height";
            desc = "Height of the active image";
            sw = r; hw = w;
            reset = 0x0;
        } online0_height[31:16];
        field {
            name = "online0_width";
            desc = "Width of the active image";
            sw = r; hw = w;
            reset = 0x0;
        } online0_width[15:0];
    } ONLINE0_SIZE @ 0x2ac;
    reg {
        name = "VICAP_AXI0_WR_ERROR";
        desc = "VICAP_AXI0_WR_ERROR is the AXI 0 write error status register. VICAP_AXI0_WR_ERROR (offset 0x0FE4, total reset 0x0000_0000; PROVEN: Hi3516D V300 data sheet, PDF page 519, section 9.1.6).";
        field {
            name = "reserved";
            desc = "Reserved";
            sw = r; hw = na;
            reset = 0x0;
        } reserved_31_26[31:26];
        field {
            name = "Isp3_stt_bus_err";
            desc = "Invalid access error of ISP 3 STT channel Writing 1 clears this bit. (data sheet access type WC)";
            sw = rw; hw = r; onwrite = woclr;
            reset = 0x0;
        } Isp3_stt_bus_err[25:25];
        field {
            name = "isp2_stt_bus_err";
            desc = "Invalid access error of ISP 2 STT channel Writing 1 clears this bit. (data sheet access type WC)";
            sw = rw; hw = r; onwrite = woclr;
            reset = 0x0;
        } isp2_stt_bus_err[24:24];
        field {
            name = "isp1_stt_bus_err";
            desc = "Invalid access error of ISP 1 STT channel Writing 1 clears this bit. (data sheet access type WC)";
            sw = rw; hw = r; onwrite = woclr;
            reset = 0x0;
        } isp1_stt_bus_err[23:23];
        field {
            name = "isp0_stt_bus_err";
            desc = "Invalid access error of ISP 0 STT channel Writing 1 clears this bit. (data sheet access type WC)";
            sw = rw; hw = r; onwrite = woclr;
            reset = 0x0;
        } isp0_stt_bus_err[22:22];
        field {
            name = "reserved";
            desc = "Reserved";
            sw = r; hw = na;
            reset = 0x0;
        } reserved_21_7[21:7];
        field {
            name = "ch2_y_bus_err";
            desc = "Invalid access error of CH3_Y channel Writing 1 clears this bit. (data sheet access type WC)";
            sw = rw; hw = r; onwrite = woclr;
            reset = 0x0;
        } ch2_y_bus_err[6:6];
        field {
            name = "ch2_c_bus_err";
            desc = "Invalid access error of CH2_C channel Writing 1 clears this bit. (data sheet access type WC)";
            sw = rw; hw = r; onwrite = woclr;
            reset = 0x0;
        } ch2_c_bus_err[5:5];
        field {
            name = "ch2_y_bus_err";
            desc = "Invalid access error of CH2_Y channel Writing 1 clears this bit. (data sheet access type WC)";
            sw = rw; hw = r; onwrite = woclr;
            reset = 0x0;
        } ch2_y_bus_err_2[4:4];
        field {
            name = "reserved";
            desc = "Reserved";
            sw = r; hw = na;
            reset = 0x0;
        } reserved_3_3[3:3];
        field {
            name = "ch1_y_bus_err";
            desc = "Invalid access error of CH1_Y channel Writing 1 clears this bit. (data sheet access type WC)";
            sw = rw; hw = r; onwrite = woclr;
            reset = 0x0;
        } ch1_y_bus_err[2:2];
        field {
            name = "reserved";
            desc = "Reserved";
            sw = r; hw = na;
            reset = 0x0;
        } reserved_1_1[1:1];
        field {
            name = "ch0_y_bus_err";
            desc = "Invalid access error of CH0_Y channel Writing 1 clears this bit. (data sheet access type WC)";
            sw = rw; hw = r; onwrite = woclr;
            reset = 0x0;
        } ch0_y_bus_err[0:0];
    } VICAP_AXI0_WR_ERROR @ 0xfe4;
    reg {
        name = "VICAP_DBG_INT";
        desc = "VICAP_DBG_INT is the system abnormal interrupt status register. VICAP_DBG_INT (offset 0x0FF0, total reset 0x0000_0000; PROVEN: Hi3516D V300 data sheet, PDF page 519, section 9.1.6).";
        field {
            name = "reserved";
            desc = "Reserved";
            sw = r; hw = na;
            reset = 0x0;
        } reserved_31_2[31:2];
        field {
            name = "apb_bus_err";
            desc = " (data sheet access type WC)";
            sw = rw; hw = r; onwrite = woclr;
            reset = 0x0;
        } apb_bus_err[1:1];
        field {
            name = "axi_bus_err";
            desc = " (data sheet access type WC)";
            sw = rw; hw = r; onwrite = woclr;
            reset = 0x0;
        } axi_bus_err[0:0];
    } VICAP_DBG_INT @ 0xff0;
    reg {
        name = "VICAP_DBG_INT_MASK";
        desc = "VICAP_DBG_INT_MASK is the system abnormal mask status register. VICAP_DBG_INT_MASK (offset 0x0FF8, total reset 0x0000_0000; PROVEN: Hi3516D V300 data sheet, PDF page 520, section 9.1.6).";
        field {
            name = "reserved";
            desc = "Reserved";
            sw = r; hw = na;
            reset = 0x0;
        } reserved_31_2[31:2];
        field {
            name = "apb_bus_err_mask";
            desc = "Interrupt enable for APB invalid access error
- 0: disabled
- 1: enabled";
            sw = rw; hw = r;
            reset = 0x0;
        } apb_bus_err_mask[1:1];
        field {
            name = "axi_bus_err_mask";
            desc = "Interrupt enable for AXI invalid access error
- 0: disabled
- 1: enabled";
            sw = rw; hw = r;
            reset = 0x0;
        } axi_bus_err_mask[0:0];
    } VICAP_DBG_INT_MASK @ 0xff8;
    regfile {
        name = "PT";
        desc = "Registers of the data sheet tables whose offset contains the variable PT_N (PT_N = 0 to 1): instance i of the array starts at 0x1000 + i x 0x100. ";
        reg {
            name = "PT_INTF_MOD";
            desc = "PT_INTF_MOD is the interface mode register. PT_INTF_MOD (offset 0x1000 + PT_N x 0x100, total reset 0x0000_0000; PROVEN: Hi3516D V300 data sheet, PDF page 520, section 9.1.6). Per-instance register (PT_N = 0 to 1): modelled inside the regfile array of its variable.";
            field {
                name = "pt_enable";
                desc = "Port enable
- 0: disabled
- 1: enabled";
                sw = rw; hw = r;
                reset = 0x0;
            } pt_enable[31:31];
            field {
                name = "reserved";
                desc = "Reserved";
                sw = rw; hw = r;
                reset = 0x0;
            } reserved_30_1[30:1];
            field {
                name = "pt_mode";
                desc = "Timing mode
- 0: external sync mode
- 1: internal sync";
                sw = rw; hw = r;
                reset = 0x0;
            } pt_mode[0:0];
        } PT_INTF_MOD @ 0x0;
        reg {
            name = "PT_OFFSET0";
            desc = "PT_OFFSET0 is the component 0 offset register. PT_OFFSET0 (offset 0x1010 + PT_N x 0x100, total reset 0xFFF0_0000; PROVEN: Hi3516D V300 data sheet, PDF page 521, section 9.1.6). Per-instance register (PT_N = 0 to 1): modelled inside the regfile array of its variable.";
            field {
                name = "offset0_mask";
                desc = "Component 0 mask";
                sw = rw; hw = r;
                reset = 0xfff0;
            } offset0_mask[31:16];
            field {
                name = "offset0_rev";
                desc = "Whether the data line is reversed
- 0: No.
- 1: Yes.";
                sw = rw; hw = r;
                reset = 0x0;
            } offset0_rev[15:15];
            field {
                name = "reserved";
                desc = "Reserved";
                sw = r; hw = na;
                reset = 0x0;
            } reserved_14_6[14:6];
            field {
                name = "offset0";
                desc = "Component 0 offset";
                sw = rw; hw = r;
                reset = 0x0;
            } offset0[5:0];
        } PT_OFFSET0 @ 0x10;
        reg {
            name = "PT_OFFSET1";
            desc = "PT_OFFSET1 is the component 1 offset register. PT_OFFSET1 (offset 0x1014 + PT_N x 0x100, total reset 0xFFF0_0010; PROVEN: Hi3516D V300 data sheet, PDF page 521, section 9.1.6). Per-instance register (PT_N = 0 to 1): modelled inside the regfile array of its variable.";
            field {
                name = "offset1_mask";
                desc = "Component 1 mask";
                sw = rw; hw = r;
                reset = 0xfff0;
            } offset1_mask[31:16];
            field {
                name = "offset1_rev";
                desc = "Whether the data line is reversed
- 0: No.
- 1: Yes.";
                sw = rw; hw = r;
                reset = 0x0;
            } offset1_rev[15:15];
            field {
                name = "reserved";
                desc = "Reserved";
                sw = r; hw = na;
                reset = 0x0;
            } reserved_14_6[14:6];
            field {
                name = "offset1";
                desc = "Component 1 offset";
                sw = rw; hw = r;
                reset = 0x10;
            } offset1[5:0];
        } PT_OFFSET1 @ 0x14;
        reg {
            name = "PT_OFFSET2";
            desc = "PT_OFFSET2 is the component 2 offset register. PT_OFFSET2 (offset 0x1018 + PT_N x 0x100, total reset 0xFFF0_0020; PROVEN: Hi3516D V300 data sheet, PDF page 521, section 9.1.6). Per-instance register (PT_N = 0 to 1): modelled inside the regfile array of its variable.";
            field {
                name = "offset2_mask";
                desc = "Component 2 mask";
                sw = rw; hw = r;
                reset = 0xfff0;
            } offset2_mask[31:16];
            field {
                name = "offset2_rev";
                desc = "Whether the data line is reversed
- 0: No.
- 1: Yes.";
                sw = rw; hw = r;
                reset = 0x0;
            } offset2_rev[15:15];
            field {
                name = "reserved";
                desc = "Reserved";
                sw = r; hw = na;
                reset = 0x0;
            } reserved_14_6[14:6];
            field {
                name = "offset2";
                desc = "Component 2 offset";
                sw = rw; hw = r;
                reset = 0x20;
            } offset2[5:0];
        } PT_OFFSET2 @ 0x18;
        reg {
            name = "PT_BT656_CFG";
            desc = "PT_BT656_CFG is the BT.656 configuration register. PT_BT656_CFG (offset 0x1020 + PT_N x 0x100, total reset 0x0000_0303; PROVEN: Hi3516D V300 data sheet, PDF page 522, section 9.1.6). Per-instance register (PT_N = 0 to 1): modelled inside the regfile array of its variable.";
            field {
                name = "bt656_enable";
                desc = "BT.656 enable
- 0: disabled
- 1: enabled";
                sw = rw; hw = r;
                reset = 0x0;
            } bt656_enable[31:31];
            field {
                name = "reserved";
                desc = "Reserved";
                sw = r; hw = na;
                reset = 0x0;
            } reserved_30_11[30:11];
            field {
                name = "bt656_field_inv";
                desc = "Field inversion control
- 0: not inverted
- 1: inverted";
                sw = rw; hw = r;
                reset = 0x0;
            } bt656_field_inv[10:10];
            field {
                name = "bt656_vsync_inv";
                desc = "Vsync inversion control
- 0: not inverted
- 1: inverted";
                sw = rw; hw = r;
                reset = 0x1;
            } bt656_vsync_inv[9:9];
            field {
                name = "bt656_hsync_inv";
                desc = "Hsync inversion control
- 0: not inverted
- 1: inverted";
                sw = rw; hw = r;
                reset = 0x1;
            } bt656_hsync_inv[8:8];
            field {
                name = "reserved";
                desc = "Reserved";
                sw = r; hw = na;
                reset = 0x0;
            } reserved_7_4[7:4];
            field {
                name = "bt656_mode";
                desc = "Mode select. bt656_mode[0]
- 0: Hsync is not an active signal.
- 1: Hsync is the active signal. bt656_mode[1]
- 0: The Hsync output is active low.
- 1: The Hsync output is active high. bt656_mode[3:2]
- 00: Component 0 is parsed.
- 01: Component 1 is parsed.
- 10: Component 2 is parsed.
- 11: reserved";
                sw = rw; hw = r;
                reset = 0x3;
            } bt656_mode[3:0];
        } PT_BT656_CFG @ 0x20;
        reg {
            name = "PT_UNIFY_TIMING_CFG";
            desc = "PT_UNIFY_TIMING_CFG is the timing configuration register. PT_UNIFY_TIMING_CFG (offset 0x1038 + PT_N x 0x100, total reset 0x0000_0000; PROVEN: Hi3516D V300 data sheet, PDF page 523, section 9.1.6). Per-instance register (PT_N = 0 to 1): modelled inside the regfile array of its variable.";
            field {
                name = "reserved";
                desc = "Reserved";
                sw = r; hw = na;
                reset = 0x0;
            } reserved_31_27[31:27];
            field {
                name = "unify_field_inv";
                desc = "Field inversion (level-1 field processing).
- 0: not inverted
- 1: inverted";
                sw = rw; hw = r;
                reset = 0x0;
            } unify_field_inv[26:26];
            field {
                name = "unify_field_sel";
                desc = "Field source select (level-0 field processing).
- 00: input field
- 01: input Vsync
- 10: detected based on the relationship between

Vsync and Hsync
- 11: fixed at 0";
                sw = rw; hw = r;
                reset = 0x0;
            } unify_field_sel[25:24];
            field {
                name = "reserved";
                desc = "Reserved";
                sw = r; hw = na;
                reset = 0x0;
            } reserved_23_21[23:21];
            field {
                name = "unify_vsync_mode";
                desc = "Vsync processing mode (level-2 Vsync processing).
- 00: not processed
- 01: detect the rising edge
- 10: detect the rising edge and falling edge
- 11: reserved";
                sw = rw; hw = r;
                reset = 0x0;
            } unify_vsync_mode[20:19];
            field {
                name = "unify_vsync_inv";
                desc = "Vsync inversion (level-1 Vsync processing).
- 0: not inverted
- 1: inverted";
                sw = rw; hw = r;
                reset = 0x0;
            } unify_vsync_inv[18:18];
            field {
                name = "unify_vsync_sel";
                desc = "Vsync source select (level-0 Vsync processing).
- 00: input Vsync
- 01: input field
- 10: fixed at 0
- 11: reserved";
                sw = rw; hw = r;
                reset = 0x0;
            } unify_vsync_sel[17:16];
            field {
                name = "reserved";
                desc = "Reserved";
                sw = r; hw = na;
                reset = 0x0;
            } reserved_15_15[15:15];
            field {
                name = "unify_hsync_mode";
                desc = "Hsync processing mode (level-3 Hsync processing).
- 0: not processed
- 1: detect the rising edge";
                sw = rw; hw = r;
                reset = 0x0;
            } unify_hsync_mode[14:13];
            field {
                name = "unify_hsync_and";
                desc = "Whether Hsync is operated with the result of level-1 Vsync processing (level-2 Hsync processing).";
                sw = rw; hw = r;
                reset = 0x0;
            } unify_hsync_and[12:11];
            field {
                name = "unify_hsync_inv";
                desc = "Hsync inversion (level-1 Hsync processing).
- 0: not inverted
- 1: inverted";
                sw = rw; hw = r;
                reset = 0x0;
            } unify_hsync_inv[10:10];
            field {
                name = "unify_hsync_sel";
                desc = "Hsync source select (level-0 Hsync processing).
- 00: input Hsync
- 01: input DE
- 10: fixed at 0
- 11: reserved";
                sw = rw; hw = r;
                reset = 0x0;
            } unify_hsync_sel[9:8];
            field {
                name = "reserved";
                desc = "Reserved";
                sw = r; hw = na;
                reset = 0x0;
            } reserved_7_3[7:3];
            field {
                name = "unify_de_inv";
                desc = "de inversion (level-1 de processing).
- 0: not inverted
- 1: inverted";
                sw = rw; hw = r;
                reset = 0x0;
            } unify_de_inv[2:2];
            field {
                name = "unify_de_sel";
                desc = "de source select (level-0 de processing).
- 00: input DE
- 01: result of level-2 Hsync processing
- 10: fixed at 1
- 11: fixed at 0";
                sw = rw; hw = r;
                reset = 0x0;
            } unify_de_sel[1:0];
        } PT_UNIFY_TIMING_CFG @ 0x38;
        reg {
            name = "PT_GEN_TIMING_CFG";
            desc = "PT_GEN_TIMING_CFG is the timing recovery module configuration register. PT_GEN_TIMING_CFG (offset 0x103C + PT_N x 0x100, total reset 0x4000_0006; PROVEN: Hi3516D V300 data sheet, PDF page 524, section 9.1.6). Per-instance register (PT_N = 0 to 1): modelled inside the regfile array of its variable.";
            field {
                name = "gen_enable";
                desc = "";
                sw = rw; hw = r;
                reset = 0x0;
            } gen_enable[31:31];
            field {
                name = "gen_mode";
                desc = "";
                sw = rw; hw = r;
                reset = 0x1;
            } gen_mode[30:30];
            field {
                name = "reserved";
                desc = "Reserved";
                sw = r; hw = na;
                reset = 0x0;
            } reserved_29_3[29:3];
            field {
                name = "gen_vsync_mode";
                desc = "Vsync recovery.
- 0: not recovered
- 1: recovered";
                sw = rw; hw = r;
                reset = 0x1;
            } gen_vsync_mode[2:2];
            field {
                name = "gen_hsync_mode";
                desc = "Hsync recovery.
- 0: not recovered
- 1: recovered";
                sw = rw; hw = r;
                reset = 0x1;
            } gen_hsync_mode[1:1];
            field {
                name = "reserved";
                desc = "Reserved";
                sw = r; hw = na;
                reset = 0x0;
            } reserved_0_0[0:0];
        } PT_GEN_TIMING_CFG @ 0x3c;
        reg {
            name = "PT_UNIFY_DATA_CFG";
            desc = "PT_UNIFY_DATA_CFG is the data configuration register. PT_UNIFY_DATA_CFG (offset 0x1040 + PT_N x 0x100, total reset 0x0000_0000; PROVEN: Hi3516D V300 data sheet, PDF page 525, section 9.1.6). Per-instance register (PT_N = 0 to 1): modelled inside the regfile array of its variable.";
            field {
                name = "unify_data_enable";
                desc = "Data separation enable
- 0: disabled
- 1: enabled";
                sw = rw; hw = r;
                reset = 0x0;
            } unify_data_enable[31:31];
            field {
                name = "reserved";
                desc = "Reserved";
                sw = r; hw = na;
                reset = 0x0;
            } reserved_30_4[30:4];
            field {
                name = "unify_data_uv_seq";
                desc = "CbCr sequence
- 0: CbCr
- 1: CrCb";
                sw = rw; hw = r;
                reset = 0x0;
            } unify_data_uv_seq[3:3];
            field {
                name = "unify_data_yc_seq";
                desc = "YC sequence
- 0: CY
- 1: YC";
                sw = rw; hw = r;
                reset = 0x0;
            } unify_data_yc_seq[2:2];
            field {
                name = "unify_data_comp_num";
                desc = "Data component select
- 00: component 1
- 01: component 2
- 10: component 3
- 11: reserved";
                sw = rw; hw = r;
                reset = 0x0;
            } unify_data_comp_num[1:0];
        } PT_UNIFY_DATA_CFG @ 0x40;
        reg {
            name = "PT_GEN_DATA_CFG";
            desc = "PT_GEN_DATA_CFG is the data generation module configuration register. PT_GEN_DATA_CFG (offset 0x1044 + PT_N x 0x100, total reset 0x0000_00E9; PROVEN: Hi3516D V300 data sheet, PDF page 525, section 9.1.6). Per-instance register (PT_N = 0 to 1): modelled inside the regfile array of its variable.";
            field {
                name = "gen_data_enable";
                desc = "Data generation enable Data is generated based on the data generation parameter.
- 0: disabled
- 1: enabled";
                sw = rw; hw = r;
                reset = 0x0;
            } gen_data_enable[31:31];
            field {
                name = "reserved";
                desc = "Reserved";
                sw = r; hw = na;
                reset = 0x0;
            } reserved_30_8[30:8];
            field {
                name = "gen_data0_move";
                desc = "Whether data 0 increases progressively
- 0: No.
- 1: Yes.";
                sw = rw; hw = r;
                reset = 0x1;
            } gen_data0_move[7:7];
            field {
                name = "gen_data1_move";
                desc = "Whether data 1 increases progressively
- 0: No.
- 1: Yes.";
                sw = rw; hw = r;
                reset = 0x1;
            } gen_data1_move[6:6];
            field {
                name = "gen_data2_move";
                desc = "Whether data 2 increases progressively
- 0: No.
- 1: Yes.";
                sw = rw; hw = r;
                reset = 0x1;
            } gen_data2_move[5:5];
            field {
                name = "gen_data_vsync_reset";
                desc = "Whether to reset data based on the Vsync signal
- 0: No.
- 1: Yes.";
                sw = rw; hw = r;
                reset = 0x0;
            } gen_data_vsync_reset[4:4];
            field {
                name = "gen_data_hsync_reset";
                desc = "Whether to reset data based on the Hsync signal
- 0: No.
- 1: Yes.";
                sw = rw; hw = r;
                reset = 0x1;
            } gen_data_hsync_reset[3:3];
            field {
                name = "gen_data_vsync_move";
                desc = "Whether data is incremented progressively based on the Vsync signal
- 0: No.
- 1: Yes.";
                sw = rw; hw = r;
                reset = 0x0;
            } gen_data_vsync_move[2:2];
            field {
                name = "gen_data_hsync_move";
                desc = "Whether data is incremented progressively based on the Hsync signal
- 0: No.
- 1: Yes.";
                sw = rw; hw = r;
                reset = 0x0;
            } gen_data_hsync_move[1:1];
            field {
                name = "gen_data_de_move";
                desc = "Whether data is incremented progressively based on the de signal
- 0: No.
- 1: Yes.";
                sw = rw; hw = r;
                reset = 0x1;
            } gen_data_de_move[0:0];
        } PT_GEN_DATA_CFG @ 0x44;
        reg {
            name = "PT_GEN_DATA_COEF";
            desc = "PT_GEN_DATA_COEF is the data generation module coefficient register. PT_GEN_DATA_COEF (offset 0x1048 + PT_N x 0x100, total reset 0x0100_0100; PROVEN: Hi3516D V300 data sheet, PDF page 527, section 9.1.6). Per-instance register (PT_N = 0 to 1): modelled inside the regfile array of its variable.";
            field {
                name = "inc_frame";
                desc = "Incremental value between data frames The incremental values are accumulated in the upper 8 bits of data.";
                sw = rw; hw = r;
                reset = 0x1;
            } inc_frame[31:24];
            field {
                name = "step_frame";
                desc = "Interval for data frame increment The configured value is the actual value minus 1. The value 0 indicates the increment by frame.";
                sw = rw; hw = r;
                reset = 0x0;
            } step_frame[23:16];
            field {
                name = "inc_space";
                desc = "Incremental value between data pixels The incremental values are accumulated in the upper 10 bits of data.";
                sw = rw; hw = r;
                reset = 0x1;
            } inc_space[15:8];
            field {
                name = "step_space";
                desc = "Interval for data pixel increment The value 0 indicates the increment by pixel.";
                sw = rw; hw = r;
                reset = 0x0;
            } step_space[7:0];
        } PT_GEN_DATA_COEF @ 0x48;
        reg {
            name = "PT_GEN_DATA_INIT";
            desc = "PT_GEN_DATA_INIT is the data generation initial value configuration register. PT_GEN_DATA_INIT (offset 0x104C + PT_N x 0x100, total reset 0x0000_0000; PROVEN: Hi3516D V300 data sheet, PDF page 527, section 9.1.6). Per-instance register (PT_N = 0 to 1): modelled inside the regfile array of its variable.";
            field {
                name = "reserved";
                desc = "Reserved";
                sw = r; hw = na;
                reset = 0x0;
            } reserved_31_24[31:24];
            field {
                name = "data2";
                desc = "Initial V/B value";
                sw = rw; hw = r;
                reset = 0x0;
            } data2[23:16];
            field {
                name = "data1";
                desc = "Initial U/G value";
                sw = rw; hw = r;
                reset = 0x0;
            } data1[15:8];
            field {
                name = "data0";
                desc = "Initial Y/R value";
                sw = rw; hw = r;
                reset = 0x0;
            } data0[7:0];
        } PT_GEN_DATA_INIT @ 0x4c;
        reg {
            name = "PT_YUV444_CFG";
            desc = "PT_YUV444_CFG is the YUV444 configuration register. PT_YUV444_CFG (offset 0x1050 + PT_N x 0x100, total reset 0x0000_0000; PROVEN: Hi3516D V300 data sheet, PDF page 527, section 9.1.6). Per-instance register (PT_N = 0 to 1): modelled inside the regfile array of its variable.";
            field {
                name = "yuv44_enable";
                desc = "YUV enable for converting YUV422 signals into YUV444 signals.
- 0: disabled
- 1: enabled";
                sw = rw; hw = r;
                reset = 0x0;
            } yuv44_enable[31:31];
            field {
                name = "reserved";
                desc = "Reserved";
                sw = r; hw = na;
                reset = 0x0;
            } reserved_30_0[30:0];
        } PT_YUV444_CFG @ 0x50;
        reg {
            name = "PT_FSTART_DLY";
            desc = "PT_FSTART_DLY is the port fstart interrupt delay register. PT_FSTART_DLY (offset 0x1060 + PT_N x 0x100, total reset 0x0000_0000; PROVEN: Hi3516D V300 data sheet, PDF page 528, section 9.1.6). Per-instance register (PT_N = 0 to 1): modelled inside the regfile array of its variable.";
            field {
                name = "pt_fstart_dly";
                desc = "";
                sw = rw; hw = r;
                reset = 0x0;
            } pt_fstart_dly[31:0];
        } PT_FSTART_DLY @ 0x60;
        reg {
            name = "PT_FSTART_H_DLY";
            desc = "PT_FSTART_H_DLY is the port fstart interrupt horizontal delay register. PT_FSTART_H_DLY (offset 0x1064 + PT_N x 0x100, total reset 0x0000_0000; PROVEN: Hi3516D V300 data sheet, PDF page 528, section 9.1.6). Per-instance register (PT_N = 0 to 1): modelled inside the regfile array of its variable.";
            field {
                name = "fstart_h_dly";
                desc = "fstart interrupt line delay time, in the unit of line number of the active area.";
                sw = rw; hw = r;
                reset = 0x0;
            } fstart_h_dly[31:16];
            field {
                name = "reserved";
                desc = "Reserved";
                sw = rw; hw = r;
                reset = 0x0;
            } reserved_15_4[15:4];
            field {
                name = "fstart_h_dly_id";
                desc = "Count frame ID. Bit[0]: Counting is triggered by the timing whose ID is 0. Bit[1]: Counting is triggered by the timing whose ID is 1. Bit[2]: Counting is triggered by the timing whose ID is 2. Bit[3]: Counting is triggered by the timing whose ID is 3.";
                sw = rw; hw = r;
                reset = 0x0;
            } fstart_h_dly_id[3:0];
        } PT_FSTART_H_DLY @ 0x64;
        reg {
            name = "PT_INTF_HFB";
            desc = "PT_INTF_HFB is the horizontal front blanking width register. PT_INTF_HFB (offset 0x1080 + PT_N x 0x100, total reset 0x0000_0058; PROVEN: Hi3516D V300 data sheet, PDF page 528, section 9.1.6). Per-instance register (PT_N = 0 to 1): modelled inside the regfile array of its variable.";
            field {
                name = "reserved";
                desc = "Reserved";
                sw = r; hw = na;
                reset = 0x0;
            } reserved_31_16[31:16];
            field {
                name = "hfb";
                desc = "Width of the horizontal front blanking interval (unit: working clock cycle)";
                sw = rw; hw = r;
                reset = 0x58;
            } hfb[15:0];
        } PT_INTF_HFB @ 0x80;
        reg {
            name = "PT_INTF_HACT";
            desc = "PT_INTF_HACT is the horizontal active area width register. PT_INTF_HACT (offset 0x1084 + PT_N x 0x100, total reset 0x0000_0780; PROVEN: Hi3516D V300 data sheet, PDF page 529, section 9.1.6). Per-instance register (PT_N = 0 to 1): modelled inside the regfile array of its variable.";
            field {
                name = "hact";
                desc = "";
                sw = rw; hw = r;
                reset = 0x780;
            } hact[31:0];
        } PT_INTF_HACT @ 0x84;
        reg {
            name = "PT_INTF_HBB";
            desc = "PT_INTF_HBB is the horizontal back blanking width register. PT_INTF_HBB (offset 0x1088 + PT_N x 0x100, total reset 0x0000_00C0; PROVEN: Hi3516D V300 data sheet, PDF page 529, section 9.1.6). Per-instance register (PT_N = 0 to 1): modelled inside the regfile array of its variable.";
            field {
                name = "reserved";
                desc = "Reserved";
                sw = r; hw = na;
                reset = 0x0;
            } reserved_31_16[31:16];
            field {
                name = "hbb";
                desc = "Width of the horizontal back blanking interval (unit: working clock cycle)";
                sw = rw; hw = r;
                reset = 0xc0;
            } hbb[15:0];
        } PT_INTF_HBB @ 0x88;
        reg {
            name = "PT_INTF_VFB";
            desc = "PT_INTF_VFB is the vertical front blanking width register. PT_INTF_VFB (offset 0x108C + PT_N x 0x100, total reset 0x0000_0004; PROVEN: Hi3516D V300 data sheet, PDF page 529, section 9.1.6). Per-instance register (PT_N = 0 to 1): modelled inside the regfile array of its variable.";
            field {
                name = "reserved";
                desc = "Reserved";
                sw = r; hw = na;
                reset = 0x0;
            } reserved_31_16[31:16];
            field {
                name = "vfb";
                desc = "Width of the vertical front blanking interval (unit: working clock cycle)";
                sw = rw; hw = r;
                reset = 0x4;
            } vfb[15:0];
        } PT_INTF_VFB @ 0x8c;
        reg {
            name = "PT_INTF_VACT";
            desc = "PT_INTF_VACT is the vertical active area width register. PT_INTF_VACT (offset 0x1090 + PT_N x 0x100, total reset 0x0000_0438; PROVEN: Hi3516D V300 data sheet, PDF page 529, section 9.1.6). Per-instance register (PT_N = 0 to 1): modelled inside the regfile array of its variable.";
            field {
                name = "reserved";
                desc = "Reserved";
                sw = r; hw = na;
                reset = 0x0;
            } reserved_31_16[31:16];
            field {
                name = "vact";
                desc = "Width of the vertical active area (unit: working clock cycle)";
                sw = rw; hw = r;
                reset = 0x438;
            } vact[15:0];
        } PT_INTF_VACT @ 0x90;
        reg {
            name = "PT_INTF_VBB";
            desc = "PT_INTF_VBB is the vertical back blanking width register. PT_INTF_VBB (offset 0x1094 + PT_N x 0x100, total reset 0x0000_0029; PROVEN: Hi3516D V300 data sheet, PDF page 530, section 9.1.6). Per-instance register (PT_N = 0 to 1): modelled inside the regfile array of its variable.";
            field {
                name = "reserved";
                desc = "Reserved";
                sw = r; hw = na;
                reset = 0x0;
            } reserved_31_16[31:16];
            field {
                name = "vbb";
                desc = "Width of the vertical back blanking interval (unit: working clock cycle)";
                sw = rw; hw = r;
                reset = 0x29;
            } vbb[15:0];
        } PT_INTF_VBB @ 0x94;
        reg {
            name = "PT_INTF_VBFB";
            desc = "PT_INTF_VBFB is the vertical bottom front blanking width register. PT_INTF_VBFB (offset 0x1098 + PT_N x 0x100, total reset 0x0000_0004; PROVEN: Hi3516D V300 data sheet, PDF page 530, section 9.1.6). Per-instance register (PT_N = 0 to 1): modelled inside the regfile array of its variable.";
            field {
                name = "reserved";
                desc = "Reserved";
                sw = r; hw = na;
                reset = 0x0;
            } reserved_31_16[31:16];
            field {
                name = "vbfb";
                desc = "Width of the vertical bottom front blanking interval (unit: working clock cycle)";
                sw = rw; hw = r;
                reset = 0x4;
            } vbfb[15:0];
        } PT_INTF_VBFB @ 0x98;
        reg {
            name = "PT_INTF_VBACT";
            desc = "PT_INTF_VBACT is the vertical bottom active area width register. PT_INTF_VBACT (offset 0x109C + PT_N x 0x100, total reset 0x0000_0438; PROVEN: Hi3516D V300 data sheet, PDF page 530, section 9.1.6). Per-instance register (PT_N = 0 to 1): modelled inside the regfile array of its variable.";
            field {
                name = "reserved";
                desc = "Reserved";
                sw = r; hw = na;
                reset = 0x0;
            } reserved_31_16[31:16];
            field {
                name = "vbact";
                desc = "Width of the vertical bottom active area (unit: working clock cycle)";
                sw = rw; hw = r;
                reset = 0x438;
            } vbact[15:0];
        } PT_INTF_VBACT @ 0x9c;
        reg {
            name = "PT_INTF_VBBB";
            desc = "PT_INTF_VBBB is the vertical bottom back blanking width register. PT_INTF_VBBB (offset 0x10A0 + PT_N x 0x100, total reset 0x0000_0029; PROVEN: Hi3516D V300 data sheet, PDF page 531, section 9.1.6). Per-instance register (PT_N = 0 to 1): modelled inside the regfile array of its variable.";
            field {
                name = "reserved";
                desc = "Reserved";
                sw = r; hw = na;
                reset = 0x0;
            } reserved_31_16[31:16];
            field {
                name = "vbbb";
                desc = "Width of the vertical bottom back blanking interval (unit: working clock cycle)";
                sw = rw; hw = r;
                reset = 0x29;
            } vbbb[15:0];
        } PT_INTF_VBBB @ 0xa0;
        reg {
            name = "PT_ID_CFG";
            desc = "PT_ID_CFG is the ID configuration register. PT_ID_CFG (offset 0x10A4 + PT_N x 0x100, total reset 0x0000_0000; PROVEN: Hi3516D V300 data sheet, PDF page 531, section 9.1.6). Per-instance register (PT_N = 0 to 1): modelled inside the regfile array of its variable.";
            field {
                name = "id_enable";
                desc = "ID generation enable
- 0: disabled
- 1: enabled";
                sw = rw; hw = r;
                reset = 0x0;
            } id_enable[31:31];
            field {
                name = "id_mode";
                desc = "ID generation mode
- 0: automatic mode (the ID automatically increases for each frame)
- 1: non-automatic mode (the ID depends on the configured value)";
                sw = rw; hw = r;
                reset = 0x0;
            } id_mode[30:30];
            field {
                name = "id_reset";
                desc = "In automatic mode, setting this field to 1 restores the ID of the next frame to the initial value. This field is automatically cleared after restoration.";
                sw = w; hw = r;
                reset = 0x0;
            } id_reset[29:29];
            field {
                name = "reserved";
                desc = "Reserved";
                sw = r; hw = na;
                reset = 0x0;
            } reserved_28_4[28:4];
            field {
                name = "id_max";
                desc = "Maximum ID in automatic mode";
                sw = rw; hw = r;
                reset = 0x0;
            } id_max[3:2];
            field {
                name = "id";
                desc = "Initial ID in automatic mode or generated ID in non-automatic mode";
                sw = rw; hw = r;
                reset = 0x0;
            } id[1:0];
        } PT_ID_CFG @ 0xa4;
        reg {
            name = "PT_FLASH_CFG";
            desc = "PT_FLASH_CFG is the flash configuration register. PT_FLASH_CFG (offset 0x10C0 + PT_N x 0x100, total reset 0x1000_0000; PROVEN: Hi3516D V300 data sheet, PDF page 531, section 9.1.6). Per-instance register (PT_N = 0 to 1): modelled inside the regfile array of its variable.";
            field {
                name = "id_sel";
                desc = "Trigger frame ID.
- 0001: triggered by using the start of frame (SOF) interrupt whose ID is 0
- 0010: triggered by using the SOF interrupt whose ID is 1
- 0100: triggered by using the SOF interrupt whose ID is 2
- 1000: triggered by using the SOF interrupt whose ID is 3

Other values: reserved";
                sw = rw; hw = r;
                reset = 0x1;
            } id_sel[31:28];
            field {
                name = "reserved";
                desc = "Reserved";
                sw = r; hw = na;
                reset = 0x0;
            } reserved_27_19[27:19];
            field {
                name = "shutter_times";
                desc = "Shutter pulse times.
- 0: twice
- 1: once";
                sw = rw; hw = r;
                reset = 0x0;
            } shutter_times[18:18];
            field {
                name = "shutter_phase";
                desc = "Shutter signal reverse.
- 0: not inverted
- 1: inverted";
                sw = rw; hw = r;
                reset = 0x0;
            } shutter_phase[17:17];
            field {
                name = "shutter_en";
                desc = "Shutter trigger enable This field is automatically cleared.
- 0: disabled
- 1: enabled";
                sw = w; hw = r;
                reset = 0x0;
            } shutter_en[16:16];
            field {
                name = "reserved";
                desc = "Reserved";
                sw = r; hw = na;
                reset = 0x0;
            } reserved_15_2[15:2];
            field {
                name = "flash_phase";
                desc = "Flash signal reverse.
- 0: not inverted
- 1: inverted";
                sw = rw; hw = r;
                reset = 0x0;
            } flash_phase[1:1];
            field {
                name = "flash_en";
                desc = "Flash trigger enable This field is automatically cleared.
- 0: disabled
- 1: enabled";
                sw = w; hw = r;
                reset = 0x0;
            } flash_en[0:0];
        } PT_FLASH_CFG @ 0xc0;
        reg {
            name = "PT_FLASH_CYC0";
            desc = "PT_FLASH_CYC0 is the flash timing 0 width register. PT_FLASH_CYC0 (offset 0x10C4 + PT_N x 0x100, total reset 0x0000_0000; PROVEN: Hi3516D V300 data sheet, PDF page 532, section 9.1.6). Per-instance register (PT_N = 0 to 1): modelled inside the regfile array of its variable.";
            field {
                name = "pt_flash_cyc0";
                desc = "Flash timing 0 duration (unit: port clock) The configured value is the actual value minus 1.";
                sw = rw; hw = r;
                reset = 0x0;
            } pt_flash_cyc0[31:0];
        } PT_FLASH_CYC0 @ 0xc4;
        reg {
            name = "PT_FLASH_CYC1";
            desc = "PT_FLASH_CYC1 is the flash timing 1 width register. PT_FLASH_CYC1 (offset 0x10C8 + PT_N x 0x100, total reset 0x0000_0000; PROVEN: Hi3516D V300 data sheet, PDF page 533, section 9.1.6). Per-instance register (PT_N = 0 to 1): modelled inside the regfile array of its variable.";
            field {
                name = "pt_flash_cyc1";
                desc = "Flash timing 1 duration (unit: port clock) The configured value is the actual value minus 1.";
                sw = rw; hw = r;
                reset = 0x0;
            } pt_flash_cyc1[31:0];
        } PT_FLASH_CYC1 @ 0xc8;
        reg {
            name = "PT_SHUTTER_CYC0";
            desc = "PT_SHUTTER_CYC0 is the shutter timing 0 width register. PT_SHUTTER_CYC0 (offset 0x10D0 + PT_N x 0x100, total reset 0x0000_0000; PROVEN: Hi3516D V300 data sheet, PDF page 533, section 9.1.6). Per-instance register (PT_N = 0 to 1): modelled inside the regfile array of its variable.";
            field {
                name = "pt_shutter_cyc0";
                desc = "Shutter timing 0 duration (unit: port clock) The configured value is the actual value minus 1.";
                sw = rw; hw = r;
                reset = 0x0;
            } pt_shutter_cyc0[31:0];
        } PT_SHUTTER_CYC0 @ 0xd0;
        reg {
            name = "PT_SHUTTER_CYC1";
            desc = "PT_SHUTTER_CYC1 is the shutter timing 1 width register. PT_SHUTTER_CYC1 (offset 0x10D4 + PT_N x 0x100, total reset 0x0000_0000; PROVEN: Hi3516D V300 data sheet, PDF page 533, section 9.1.6). Per-instance register (PT_N = 0 to 1): modelled inside the regfile array of its variable.";
            field {
                name = "pt_shutter_cyc1";
                desc = "Shutter timing 1 duration (unit: port clock) The configured value is the actual value minus 1.";
                sw = rw; hw = r;
                reset = 0x0;
            } pt_shutter_cyc1[31:0];
        } PT_SHUTTER_CYC1 @ 0xd4;
        reg {
            name = "PT_SHUTTER_CYC2";
            desc = "PT_SHUTTER_CYC2 is the shutter timing 2 width register. PT_SHUTTER_CYC2 (offset 0x10D8 + PT_N x 0x100, total reset 0x0000_0000; PROVEN: Hi3516D V300 data sheet, PDF page 534, section 9.1.6). Per-instance register (PT_N = 0 to 1): modelled inside the regfile array of its variable.";
            field {
                name = "pt_shutter_cyc2";
                desc = "Shutter timing 2 duration (unit: port clock) The configured value is the actual value minus 1.";
                sw = rw; hw = r;
                reset = 0x0;
            } pt_shutter_cyc2[31:0];
        } PT_SHUTTER_CYC2 @ 0xd8;
        reg {
            name = "PT_SHUTTER_CYC3";
            desc = "PT_SHUTTER_CYC3 is the shutter timing 3 width register. PT_SHUTTER_CYC3 (offset 0x10DC + PT_N x 0x100, total reset 0x0000_0000; PROVEN: Hi3516D V300 data sheet, PDF page 534, section 9.1.6). Per-instance register (PT_N = 0 to 1): modelled inside the regfile array of its variable.";
            field {
                name = "pt_shutter_cyc3";
                desc = "Shutter timing 3 duration (unit: port clock) The configured value is the actual value minus 1.";
                sw = rw; hw = r;
                reset = 0x0;
            } pt_shutter_cyc3[31:0];
        } PT_SHUTTER_CYC3 @ 0xdc;
        reg {
            name = "PT_STATUS";
            desc = "PT_STATUS is the port status register. PT_STATUS (offset 0x10E0 + PT_N x 0x100, total reset 0x0000_0000; PROVEN: Hi3516D V300 data sheet, PDF page 534, section 9.1.6). Per-instance register (PT_N = 0 to 1): modelled inside the regfile array of its variable.";
            field {
                name = "reserved";
                desc = "Reserved";
                sw = r; hw = na;
                reset = 0x0;
            } reserved_31_6[31:6];
            field {
                name = "pt_status_id";
                desc = "Port output ID";
                sw = r; hw = w;
                reset = 0x0;
            } pt_status_id[5:4];
            field {
                name = "pt_status_field";
                desc = "Field output over the port";
                sw = r; hw = w;
                reset = 0x0;
            } pt_status_field[3:3];
            field {
                name = "pt_status_vsync";
                desc = "Vsync signal over the port";
                sw = r; hw = w;
                reset = 0x0;
            } pt_status_vsync[2:2];
            field {
                name = "pt_status_hsync";
                desc = "Hsync signal over the port";
                sw = r; hw = w;
                reset = 0x0;
            } pt_status_hsync[1:1];
            field {
                name = "pt_status_de";
                desc = "de signal output over the port";
                sw = r; hw = w;
                reset = 0x0;
            } pt_status_de[0:0];
        } PT_STATUS @ 0xe0;
        reg {
            name = "PT_BT656_STATUS";
            desc = "PT_BT656_STATUS is the BT.656 status register. PT_BT656_STATUS (offset 0x10E4 + PT_N x 0x100, total reset 0x0000_0000; PROVEN: Hi3516D V300 data sheet, PDF page 534, section 9.1.6). Per-instance register (PT_N = 0 to 1): modelled inside the regfile array of its variable.";
            field {
                name = "reserved";
                desc = "Reserved";
                sw = r; hw = na;
                reset = 0x0;
            } reserved_31_16[31:16];
            field {
                name = "pt_bt656_seav";
                desc = "Sync code";
                sw = r; hw = w;
                reset = 0x0;
            } pt_bt656_seav[15:8];
            field {
                name = "reserved";
                desc = "Reserved";
                sw = r; hw = na;
                reset = 0x0;
            } reserved_7_0[7:0];
        } PT_BT656_STATUS @ 0xe4;
        reg {
            name = "PT_SIZE";
            desc = "PT_SIZE is the input image active area size indicator register PT_SIZE (offset 0x10EC + PT_N x 0x100, total reset 0x0000_0000; PROVEN: Hi3516D V300 data sheet, PDF page 535, section 9.1.6). Per-instance register (PT_N = 0 to 1): modelled inside the regfile array of its variable.";
            field {
                name = "pt_height";
                desc = "Height of the active area of the image";
                sw = r; hw = w;
                reset = 0x0;
            } pt_height[31:16];
            field {
                name = "pt_width";
                desc = "Width of the active area of the image";
                sw = r; hw = w;
                reset = 0x0;
            } pt_width[15:0];
        } PT_SIZE @ 0xec;
        reg {
            name = "PT_INT";
            desc = "PT_INT is the port interrupt indicator register. PT_INT (offset 0x10F0 + PT_N x 0x100, total reset 0x0000_0000; PROVEN: Hi3516D V300 data sheet, PDF page 535, section 9.1.6). Per-instance register (PT_N = 0 to 1): modelled inside the regfile array of its variable.";
            field {
                name = "reserved";
                desc = "Reserved";
                sw = r; hw = na;
                reset = 0x0;
            } reserved_31_4[31:4];
            field {
                name = "pt_fstart_h_dly";
                desc = "Interrupt status of the field/frame start line delay Writing 1 clears this bit.
- 0: No interrupt is generated.
- 1: An interrupt is generated. (data sheet access type WC)";
                sw = rw; hw = r; onwrite = woclr;
                reset = 0x0;
            } pt_fstart_h_dly[3:3];
            field {
                name = "pt_height_err";
                desc = "Interrupt status of the image height change Writing 1 clears this bit.
- 0: No interrupt is generated.
- 1: An interrupt is generated. (data sheet access type WC)";
                sw = rw; hw = r; onwrite = woclr;
                reset = 0x0;
            } pt_height_err[2:2];
            field {
                name = "pt_width_err";
                desc = "Interrupt status of the image width change Writing 1 clears this bit.
- 0: No interrupt is generated.
- 1: An interrupt is generated. (data sheet access type WC)";
                sw = rw; hw = r; onwrite = woclr;
                reset = 0x0;
            } pt_width_err[1:1];
            field {
                name = "pt_fstart";
                desc = "Interrupt status of the field/frame start Writing 1 clears this bit.
- 0: No interrupt is generated.
- 1: An interrupt is generated. (data sheet access type WC)";
                sw = rw; hw = r; onwrite = woclr;
                reset = 0x0;
            } pt_fstart[0:0];
        } PT_INT @ 0xf0;
        reg {
            name = "PT_INT_MASK";
            desc = "PT_INT_MASK is the port interrupt mask register. PT_INT_MASK (offset 0x10F8 + PT_N x 0x100, total reset 0x0000_0000; PROVEN: Hi3516D V300 data sheet, PDF page 536, section 9.1.6). Per-instance register (PT_N = 0 to 1): modelled inside the regfile array of its variable.";
            field {
                name = "reserved";
                desc = "Reserved";
                sw = r; hw = na;
                reset = 0x0;
            } reserved_31_4[31:4];
            field {
                name = "pt_mask_fstart_h_dly";
                desc = "Frame/Field start line delay interrupt enable
- 0: The interrupt is masked.
- 1: The interrupt is enabled.";
                sw = rw; hw = r;
                reset = 0x0;
            } pt_mask_fstart_h_dly[3:3];
            field {
                name = "pt_mask_height_err";
                desc = "Image height change interrupt enable
- 0: The interrupt is masked.
- 1: The interrupt is enabled.";
                sw = rw; hw = r;
                reset = 0x0;
            } pt_mask_height_err[2:2];
            field {
                name = "pt_mask_width_err";
                desc = "Image width change interrupt enable
- 0: The interrupt is masked.
- 1: The interrupt is enabled.";
                sw = rw; hw = r;
                reset = 0x0;
            } pt_mask_width_err[1:1];
            field {
                name = "pt_mask_fstart";
                desc = "Frame/Field start interrupt enable
- 0: The interrupt is masked.
- 1: The interrupt is enabled.";
                sw = rw; hw = r;
                reset = 0x0;
            } pt_mask_fstart[0:0];
        } PT_INT_MASK @ 0xf8;
    } PT[2] @ 0x1000 += 0x100;
    regfile {
        name = "CH";
        desc = "Registers of the data sheet tables whose offset contains the variable CH_N (CH_N = 0 to 3): instance i of the array starts at 0x10000 + i x 0x1000. ";
        reg {
            name = "CH_CTRL";
            desc = "CH_CTRL is the channel control register. CH_CTRL (offset 0x10000 + CH_N x 0x1000, total reset 0x0002_0000; PROVEN: Hi3516D V300 data sheet, PDF page 536, section 9.1.6). Per-instance register (CH_N = 0 to 3): modelled inside the regfile array of its variable.";
            field {
                name = "ch_enable";
                desc = "Channel enable
- 0: disabled
- 1: enabled";
                sw = rw; hw = r;
                reset = 0x0;
            } ch_enable[31:31];
            field {
                name = "ch_reg_newer_mode";
                desc = "Enable mode control
- 0: output when the reg_new register is valid and the module is enabled
- 1: output when the module is enabled";
                sw = rw; hw = r;
                reset = 0x0;
            } ch_reg_newer_mode[30:30];
            field {
                name = "reserved";
                desc = "Reserved";
                sw = r; hw = na;
                reset = 0x0;
            } reserved_29_18[29:18];
            field {
                name = "ch_finish_mode";
                desc = "Finish interrupt report time control
- 0: reported immediately
- 1: reported at the start of the next frame";
                sw = rw; hw = r;
                reset = 0x1;
            } ch_finish_mode[17:17];
            field {
                name = "reserved";
                desc = "Reserved";
                sw = r; hw = na;
                reset = 0x0;
            } reserved_16_0[16:0];
        } CH_CTRL @ 0x0;
        reg {
            name = "CH_REG_NEWER";
            desc = "CH_REG_NEWER is the channel update register. CH_REG_NEWER (offset 0x10004 + CH_N x 0x1000, total reset 0x0000_0000; PROVEN: Hi3516D V300 data sheet, PDF page 537, section 9.1.6). Per-instance register (CH_N = 0 to 3): modelled inside the regfile array of its variable.";
            field {
                name = "reserved";
                desc = "Reserved";
                sw = r; hw = na;
                reset = 0x0;
            } reserved_31_1[31:1];
            field {
                name = "ch_reg_newer";
                desc = "Channel update register This bit is automatically cleared for each frame.";
                sw = rw; hw = r;
                reset = 0x0;
            } ch_reg_newer[0:0];
        } CH_REG_NEWER @ 0x4;
        reg {
            name = "CH_DLY_CFG";
            desc = "CH_DLY_CFG is the channel input image start interrupt delay configuration register. CH_DLY_CFG (offset 0x10034 + CH_N x 0x1000, total reset 0x0010_0000; PROVEN: Hi3516D V300 data sheet, PDF page 537, section 9.1.6). Per-instance register (CH_N = 0 to 3): modelled inside the regfile array of its variable.";
            field {
                name = "ch_v_dly_cfg";
                desc = "Vertical row delay";
                sw = rw; hw = r;
                reset = 0x10;
            } ch_v_dly_cfg[31:16];
            field {
                name = "reserved";
                desc = "Reserved";
                sw = r; hw = na;
                reset = 0x0;
            } reserved_15_0[15:0];
        } CH_DLY_CFG @ 0x34;
        reg {
            name = "CH_CROP_CFG";
            desc = "CH_CROP_CFG is the channel crop enable register. CH_CROP_CFG (offset 0x10040 + CH_N x 0x1000, total reset 0x0000_0000; PROVEN: Hi3516D V300 data sheet, PDF page 537, section 9.1.6). Per-instance register (CH_N = 0 to 3): modelled inside the regfile array of its variable.";
            field {
                name = "reserved";
                desc = "Reserved";
                sw = r; hw = na;
                reset = 0x0;
            } reserved_31_1[31:1];
            field {
                name = "ch_crop_n0_en";
                desc = "Region 0 enable
- 0: disabled
- 1: enabled";
                sw = rw; hw = r;
                reset = 0x0;
            } ch_crop_n0_en[0:0];
        } CH_CROP_CFG @ 0x40;
        reg {
            name = "CH_CROP0_START";
            desc = "CH_CROP0_START is the channel region 0 crop start position register. CH_CROP0_START (offset 0x10044 + CH_N x 0x1000, total reset 0x0000_0000; PROVEN: Hi3516D V300 data sheet, PDF page 537, section 9.1.6). Per-instance register (CH_N = 0 to 3): modelled inside the regfile array of its variable.";
            field {
                name = "ch_crop_y_start";
                desc = "Start row for obtaining the image";
                sw = rw; hw = r;
                reset = 0x0;
            } ch_crop_y_start[31:16];
            field {
                name = "ch_crop_x_start";
                desc = "Start pixel for obtaining the image";
                sw = rw; hw = r;
                reset = 0x0;
            } ch_crop_x_start[15:0];
        } CH_CROP0_START @ 0x44;
        reg {
            name = "CH_CROP0_SIZE";
            desc = "CH_CROP0_SIZE is the region 0 crop size configuration register. CH_CROP0_SIZE (offset 0x10048 + CH_N x 0x1000, total reset 0x0000_0000; PROVEN: Hi3516D V300 data sheet, PDF page 538, section 9.1.6). Per-instance register (CH_N = 0 to 3): modelled inside the regfile array of its variable.";
            field {
                name = "ch_crop_height";
                desc = "Height of the obtained image (unit: row) The configured value is the actual value minus 1.";
                sw = rw; hw = r;
                reset = 0x0;
            } ch_crop_height[31:16];
            field {
                name = "ch_crop_width";
                desc = "Width of the obtained image (unit: pixel) The configured value is the actual value minus 1.";
                sw = rw; hw = r;
                reset = 0x0;
            } ch_crop_width[15:0];
        } CH_CROP0_SIZE @ 0x48;
        reg {
            name = "CH_SKIP_Y_CFG";
            desc = "CH_SKIP_Y_CFG is the channel Y component skip configuration register. CH_SKIP_Y_CFG (offset 0x10050 + CH_N x 0x1000, total reset 0xFFFF_FFFF; PROVEN: Hi3516D V300 data sheet, PDF page 538, section 9.1.6). Per-instance register (CH_N = 0 to 3): modelled inside the regfile array of its variable.";
            field {
                name = "ch_skipy_cfg";
                desc = "Skip configuration";
                sw = rw; hw = r;
                reset = 0xffffffff;
            } ch_skipy_cfg[31:0];
        } CH_SKIP_Y_CFG @ 0x50;
        reg {
            name = "CH_SKIP_C_CFG";
            desc = "CH_SKIP_C_CFG is the channel C component skip configuration register. CH_SKIP_C_CFG (offset 0x10058 + CH_N x 0x1000, total reset 0xFFFF_FFFF; PROVEN: Hi3516D V300 data sheet, PDF page 538, section 9.1.6). Per-instance register (CH_N = 0 to 3): modelled inside the regfile array of its variable.";
            field {
                name = "ch_skipc_cfg";
                desc = "Skip configuration";
                sw = rw; hw = r;
                reset = 0xffffffff;
            } ch_skipc_cfg[31:0];
        } CH_SKIP_C_CFG @ 0x58;
        reg {
            name = "CH_WCH_Y_CFG";
            desc = "CH_WCH_Y_CFG is the Y component configuration register. CH_WCH_Y_CFG (offset 0x10080 + CH_N x 0x1000, total reset 0x0000_0000; PROVEN: Hi3516D V300 data sheet, PDF page 538, section 9.1.6). Per-instance register (CH_N = 0 to 3): modelled inside the regfile array of its variable.";
            field {
                name = "wch_y_enable";
                desc = "Channel write enable
- 0: disabled
- 1: enabled";
                sw = rw; hw = r;
                reset = 0x0;
            } wch_y_enable[31:31];
            field {
                name = "reserved";
                desc = "Reserved";
                sw = r; hw = na;
                reset = 0x0;
            } reserved_30_29[30:29];
            field {
                name = "wch_y_wrap_line";
                desc = "Number of winding buffer lines in the write channel";
                sw = rw; hw = r;
                reset = 0x0;
            } wch_y_wrap_line[28:15];
            field {
                name = "wch_y_wrap_en";
                desc = "Winding buffer enable register of the write channel
- 0: disabled
- 1: enabled";
                sw = rw; hw = r;
                reset = 0x0;
            } wch_y_wrap_en[14:14];
            field {
                name = "wch_y_cmp_mode";
                desc = "Compression mode select
- 0: frame-based compression
- 1: line-based compression";
                sw = rw; hw = r;
                reset = 0x0;
            } wch_y_cmp_mode[13:13];
            field {
                name = "wch_y_cmp_en";
                desc = "DES channel compression enable
- 0: disabled
- 1: enabled";
                sw = rw; hw = r;
                reset = 0x0;
            } wch_y_cmp_en[12:12];
            field {
                name = "reserved";
                desc = "Reserved";
                sw = rw; hw = r;
                reset = 0x0;
            } reserved_11_6[11:6];
            field {
                name = "wch_y_bit_width";
                desc = "Data bit width
- 0x08: 8 bits
- 0x0A: 10 bits
- 0x0C: 12 bits
- 0x0E: 14 bits
- 0x10: 16 bits

Other values: reserved";
                sw = rw; hw = r;
                reset = 0x0;
            } wch_y_bit_width[5:0];
        } CH_WCH_Y_CFG @ 0x80;
        reg {
            name = "CH_WCH_Y_SIZE";
            desc = "CH_WCH_Y_SIZE is the Y component storage size register for the WCH module. CH_WCH_Y_SIZE (offset 0x10084 + CH_N x 0x1000, total reset 0x0000_0000; PROVEN: Hi3516D V300 data sheet, PDF page 539, section 9.1.6). Per-instance register (CH_N = 0 to 3): modelled inside the regfile array of its variable.";
            field {
                name = "wch_y_height";
                desc = "Height of the stored image (unit: row) The configured value is the actual value minus 1.";
                sw = rw; hw = r;
                reset = 0x0;
            } wch_y_height[31:16];
            field {
                name = "wch_y_width";
                desc = "Width of the stored image (unit: pixel) The configured value is the actual value minus 1.";
                sw = rw; hw = r;
                reset = 0x0;
            } wch_y_width[15:0];
        } CH_WCH_Y_SIZE @ 0x84;
        reg {
            name = "CH_WCH_Y_FADDR_L";
            desc = "CH_WCH_Y_FADDR_L is the lower 32 bits register of the Y component storage base address in the WCH module. CH_WCH_Y_FADDR_L (offset 0x10094 + CH_N x 0x1000, total reset 0x0000_0000; PROVEN: Hi3516D V300 data sheet, PDF page 540, section 9.1.6). Per-instance register (CH_N = 0 to 3): modelled inside the regfile array of its variable.";
            field {
                name = "wch_y_faddr_l";
                desc = "";
                sw = rw; hw = r;
                reset = 0x0;
            } wch_y_faddr_l[31:0];
        } CH_WCH_Y_FADDR_L @ 0x94;
        reg {
            name = "CH_WCH_Y_STRIDE";
            desc = "CH_WCH_Y_STRIDE is the Y component stride register in the WCH module. CH_WCH_Y_STRIDE (offset 0x100A0 + CH_N x 0x1000, total reset 0x0000_0000; PROVEN: Hi3516D V300 data sheet, PDF page 540, section 9.1.6). Per-instance register (CH_N = 0 to 3): modelled inside the regfile array of its variable.";
            field {
                name = "reserved";
                desc = "Reserved";
                sw = r; hw = na;
                reset = 0x0;
            } reserved_31_16[31:16];
            field {
                name = "wch_y_stride";
                desc = "Stride of the Y component stored in an image, in the unit of byte";
                sw = rw; hw = r;
                reset = 0x0;
            } wch_y_stride[15:0];
        } CH_WCH_Y_STRIDE @ 0xa0;
        reg {
            name = "CH_WCH_C_CFG";
            desc = "CH_WCH_C_CFG is the C component configuration register in the WCH module. CH_WCH_C_CFG (offset 0x100B0 + CH_N x 0x1000, total reset 0x0000_0000; PROVEN: Hi3516D V300 data sheet, PDF page 540, section 9.1.6). Per-instance register (CH_N = 0 to 3): modelled inside the regfile array of its variable.";
            field {
                name = "wch_c_enable";
                desc = "CH write channel enable
- 0: disabled
- 1: enabled";
                sw = rw; hw = r;
                reset = 0x0;
            } wch_c_enable[31:31];
            field {
                name = "reserved";
                desc = "Reserved";
                sw = r; hw = na;
                reset = 0x0;
            } reserved_30_6[30:6];
            field {
                name = "wch_c_bit_width";
                desc = "Data bit width
- 0x08: 8 bits
- 0x0A: 10 bits
- 0x0C: 12 bits
- 0x0E: 14 bits
- 0x10: 16 bits

Other values: reserved";
                sw = rw; hw = r;
                reset = 0x0;
            } wch_c_bit_width[5:0];
        } CH_WCH_C_CFG @ 0xb0;
        reg {
            name = "CH_WCH_C_SIZE";
            desc = "CH_WCH_C_SIZE is the C component storage size register in the WCH module. CH_WCH_C_SIZE (offset 0x100B4 + CH_N x 0x1000, total reset 0x0000_0000; PROVEN: Hi3516D V300 data sheet, PDF page 541, section 9.1.6). Per-instance register (CH_N = 0 to 3): modelled inside the regfile array of its variable.";
            field {
                name = "wch_c_height";
                desc = "Height of the stored image (unit: row) The configured value is the actual value minus 1.";
                sw = rw; hw = r;
                reset = 0x0;
            } wch_c_height[31:16];
            field {
                name = "wch_c_width";
                desc = "Width of the stored image (unit: pixel) The configured value is the actual value minus 1.";
                sw = rw; hw = r;
                reset = 0x0;
            } wch_c_width[15:0];
        } CH_WCH_C_SIZE @ 0xb4;
        reg {
            name = "CH_WCH_C_FADDR_L";
            desc = "CH_WCH_C_FADDR_L is the lower 32 bits register of the C component storage base address in the WCH module. CH_WCH_C_FADDR_L (offset 0x100C4 + CH_N x 0x1000, total reset 0x0000_0000; PROVEN: Hi3516D V300 data sheet, PDF page 541, section 9.1.6). Per-instance register (CH_N = 0 to 3): modelled inside the regfile array of its variable.";
            field {
                name = "wch_c_faddr_l";
                desc = "";
                sw = rw; hw = r;
                reset = 0x0;
            } wch_c_faddr_l[31:0];
        } CH_WCH_C_FADDR_L @ 0xc4;
        reg {
            name = "CH_WCH_C_STRIDE";
            desc = "CH_WCH_C_STRIDE is the C component stride register in the WCH module. CH_WCH_C_STRIDE (offset 0x100D0 + CH_N x 0x1000, total reset 0x0000_0000; PROVEN: Hi3516D V300 data sheet, PDF page 541, section 9.1.6). Per-instance register (CH_N = 0 to 3): modelled inside the regfile array of its variable.";
            field {
                name = "reserved";
                desc = "Reserved";
                sw = r; hw = na;
                reset = 0x0;
            } reserved_31_16[31:16];
            field {
                name = "wch_c_stride";
                desc = "Stride of the C component of image storage (in bytes)";
                sw = rw; hw = r;
                reset = 0x0;
            } wch_c_stride[15:0];
        } CH_WCH_C_STRIDE @ 0xd0;
        reg {
            name = "CH_Y_ACT_SIZE";
            desc = "CH_Y_ACT_SIZE is the output image active area size indicator register of the luminance channel. CH_Y_ACT_SIZE (offset 0x100E8 + CH_N x 0x1000, total reset 0x0000_0000; PROVEN: Hi3516D V300 data sheet, PDF page 541, section 9.1.6). Per-instance register (CH_N = 0 to 3): modelled inside the regfile array of its variable.";
            field {
                name = "ch_y_height_act";
                desc = "";
                sw = r; hw = w;
                reset = 0x0;
            } ch_y_height_act[31:16];
            field {
                name = "ch_y_width_act";
                desc = "";
                sw = r; hw = w;
                reset = 0x0;
            } ch_y_width_act[15:0];
        } CH_Y_ACT_SIZE @ 0xe8;
        reg {
            name = "CH_C_ACT_SIZE";
            desc = "CH_C_ACT_SIZE is the output image active area size indicator register of the chrominance channel. CH_C_ACT_SIZE (offset 0x100EC + CH_N x 0x1000, total reset 0x0000_0000; PROVEN: Hi3516D V300 data sheet, PDF page 542, section 9.1.6). Per-instance register (CH_N = 0 to 3): modelled inside the regfile array of its variable.";
            field {
                name = "ch_c_height_act";
                desc = "";
                sw = r; hw = w;
                reset = 0x0;
            } ch_c_height_act[31:16];
            field {
                name = "ch_c_width_act";
                desc = "";
                sw = r; hw = w;
                reset = 0x0;
            } ch_c_width_act[15:0];
        } CH_C_ACT_SIZE @ 0xec;
        reg {
            name = "CH_INT";
            desc = "CH_INT is the channel raw interrupt register. CH_INT (offset 0x100F0 + CH_N x 0x1000, total reset 0x0000_0000; PROVEN: Hi3516D V300 data sheet, PDF page 542, section 9.1.6). Per-instance register (CH_N = 0 to 3): modelled inside the regfile array of its variable.";
            field {
                name = "reserved";
                desc = "Reserved";
                sw = r; hw = na;
                reset = 0x0;
            } reserved_31_17[31:17];
            field {
                name = "ch_stt_ae_finish";
                desc = "Status of the AE statistics completion interrupt Writing 1 clears this bit.
- 0: No interrupt is generated.
- 1: An interrupt is generated. (data sheet access type WC)";
                sw = rw; hw = r; onwrite = woclr;
                reset = 0x0;
            } ch_stt_ae_finish[16:16];
            field {
                name = "ch_int_fstart_dly";
                desc = "Interrupt status of the frame/field start after delay Writing 1 clears this bit.
- 0: No interrupt is generated.
- 1: An interrupt is generated. (data sheet access type WC)";
                sw = rw; hw = r; onwrite = woclr;
                reset = 0x0;
            } ch_int_fstart_dly[15:15];
            field {
                name = "reserved";
                desc = "Reserved";
                sw = r; hw = na;
                reset = 0x0;
            } reserved_14_5[14:5];
            field {
                name = "ch_int_update_cfg";
                desc = "Interrupt status of the register update Writing 1 clears this bit.
- 0: No interrupt is generated.
- 1: An interrupt is generated. (data sheet access type WC)";
                sw = rw; hw = r; onwrite = woclr;
                reset = 0x0;
            } ch_int_update_cfg[4:4];
            field {
                name = "ch_int_field_throw";
                desc = "Interrupt status of the frame/field loss Writing 1 clears this bit.
- 0: No interrupt is generated.
- 1: An interrupt is generated. (data sheet access type WC)";
                sw = rw; hw = r; onwrite = woclr;
                reset = 0x0;
            } ch_int_field_throw[3:3];
            field {
                name = "ch_int_buf_ovf";
                desc = "Interrupt status of the internal FIFO overflow error Writing 1 clears this bit.
- 0: No interrupt is generated.
- 1: An interrupt is generated. (data sheet access type WC)";
                sw = rw; hw = r; onwrite = woclr;
                reset = 0x0;
            } ch_int_buf_ovf[2:2];
            field {
                name = "ch_int_cc_int";
                desc = "Interrupt status of the obtaining completion Writing 1 clears this bit.
- 0: No interrupt is generated.
- 1: An interrupt is generated. (data sheet access type WC)";
                sw = rw; hw = r; onwrite = woclr;
                reset = 0x0;
            } ch_int_cc_int[1:1];
            field {
                name = "ch_int_fstart";
                desc = "Interrupt status of the field/frame start Writing 1 clears this bit.
- 0: No interrupt is generated.
- 1: An interrupt is generated. (data sheet access type WC)";
                sw = rw; hw = r; onwrite = woclr;
                reset = 0x0;
            } ch_int_fstart[0:0];
        } CH_INT @ 0xf0;
        reg {
            name = "CH_INT_MASK";
            desc = "CH_INT_MASK is the channel interrupt mask register. CH_INT_MASK (offset 0x100F8 + CH_N x 0x1000, total reset 0x0000_0000; PROVEN: Hi3516D V300 data sheet, PDF page 543, section 9.1.6). Per-instance register (CH_N = 0 to 3): modelled inside the regfile array of its variable.";
            field {
                name = "reserved";
                desc = "Reserved";
                sw = r; hw = na;
                reset = 0x0;
            } reserved_31_17[31:17];
            field {
                name = "mask_stt_ae_finish";
                desc = "Interrupt enable for the AE statistics completion
- 0: The interrupt is masked.
- 1: The interrupt is enabled.";
                sw = rw; hw = r;
                reset = 0x0;
            } mask_stt_ae_finish[16:16];
            field {
                name = "mask_fstart_dly";
                desc = "Delayed field/frame start interrupt enable
- 0: The interrupt is masked.
- 1: The interrupt is enabled.";
                sw = rw; hw = r;
                reset = 0x0;
            } mask_fstart_dly[15:15];
            field {
                name = "reserved";
                desc = "Reserved";
                sw = r; hw = na;
                reset = 0x0;
            } reserved_14_5[14:5];
            field {
                name = "mask_update_cfg";
                desc = "Register update interrupt enable
- 0: The interrupt is masked.
- 1: The interrupt is enabled.";
                sw = rw; hw = r;
                reset = 0x0;
            } mask_update_cfg[4:4];
            field {
                name = "mask_field_throw";
                desc = "Field/Frame loss interrupt enable";
                sw = rw; hw = r;
                reset = 0x0;
            } mask_field_throw[3:3];
            field {
                name = "mask_buf_ovf";
                desc = "Internal FIFO overflow error interrupt enable
- 0: The interrupt is masked.
- 1: The interrupt is enabled.";
                sw = rw; hw = r;
                reset = 0x0;
            } mask_buf_ovf[2:2];
            field {
                name = "mask_cc_int";
                desc = "Capture completion interrupt enable
- 0: The interrupt is masked.
- 1: The interrupt is enabled.";
                sw = rw; hw = r;
                reset = 0x0;
            } mask_cc_int[1:1];
            field {
                name = "mask_fstart";
                desc = "Field/Frame start interrupt enable
- 0: The interrupt is masked.
- 1: The interrupt is enabled.";
                sw = rw; hw = r;
                reset = 0x0;
            } mask_fstart[0:0];
        } CH_INT_MASK @ 0xf8;
        reg {
            name = "CH_WCH_STT_CFG";
            desc = "CH_WCH_STT_CFG is the ISP statistics write configuration register. CH_WCH_STT_CFG (offset 0x10200 + CH_N x 0x1000, total reset 0x0000_0000; PROVEN: Hi3516D V300 data sheet, PDF page 544, section 9.1.6). Per-instance register (CH_N = 0 to 3): modelled inside the regfile array of its variable.";
            field {
                name = "reserved";
                desc = "Reserved";
                sw = r; hw = na;
                reset = 0x0;
            } reserved_31_31[31:31];
            field {
                name = "ch_wch_stt_32b_align";
                desc = "32-byte alignment enable of the STT write channel
- 0: disabled
- 1: enabled";
                sw = rw; hw = r;
                reset = 0x0;
            } ch_wch_stt_32b_align[30:30];
            field {
                name = "reserved";
                desc = "Reserved";
                sw = r; hw = na;
                reset = 0x0;
            } reserved_29_0[29:0];
        } CH_WCH_STT_CFG @ 0x200;
        reg {
            name = "CH_WCH_STT_AE_HIST_ADDR_L";
            desc = "CH_WCH_STT_ADDR_L is the lower 32 bits register of the ISP statistics storage base address. CH_WCH_STT_AE_HIST_ADDR_L (offset 0x10208 + CH_N x 0x1000, total reset 0x0000_0000; PROVEN: Hi3516D V300 data sheet, PDF page 544, section 9.1.6). Per-instance register (CH_N = 0 to 3): modelled inside the regfile array of its variable.";
            field {
                name = "ch_wch_stt_ae_hist_addr_l";
                desc = "Lower 32 bits of the ISP AE_HIST statistics storage base address (supported only by channel 0/1/2/3)";
                sw = rw; hw = r;
                reset = 0x0;
            } ch_wch_stt_ae_hist_addr_l[31:0];
        } CH_WCH_STT_AE_HIST_ADDR_L @ 0x208;
        reg {
            name = "CH_WCH_STT_AE_AVER_R_GR_ADDR_L";
            desc = "CH_WCH_STT_ADDR_L is the lower 32 bits register of the ISP statistics storage base address. CH_WCH_STT_AE_AVER_R_GR_ADDR_L (offset 0x10210 + CH_N x 0x1000, total reset 0x0000_0000; PROVEN: Hi3516D V300 data sheet, PDF page 545, section 9.1.6). Per-instance register (CH_N = 0 to 3): modelled inside the regfile array of its variable.";
            field {
                name = "ch_wch_stt_ae_aver_r_gr_addr_l";
                desc = "Lower 32 bits of the ISP AE_AVER_R_GR statistics storage base address (supported only by channel 0/1/2/3)";
                sw = rw; hw = r;
                reset = 0x0;
            } ch_wch_stt_ae_aver_r_gr_addr_l[31:0];
        } CH_WCH_STT_AE_AVER_R_GR_ADDR_L @ 0x210;
        reg {
            name = "CH_WCH_STT_AE_AVER_GB_B_ADDR_L";
            desc = "CH_WCH_STT_ADDR_L is the lower 32 bits register of the ISP statistics storage base address. CH_WCH_STT_AE_AVER_GB_B_ADDR_L (offset 0x10218 + CH_N x 0x1000, total reset 0x0000_0000; PROVEN: Hi3516D V300 data sheet, PDF page 545, section 9.1.6). Per-instance register (CH_N = 0 to 3): modelled inside the regfile array of its variable.";
            field {
                name = "ch_wch_stt_ae_aver_gb_b_addr_l";
                desc = "Lower 32 bits of the ISP AE_AVER_GB_B statistics storage base address (supported only by channel 0/1/2/3)";
                sw = rw; hw = r;
                reset = 0x0;
            } ch_wch_stt_ae_aver_gb_b_addr_l[31:0];
        } CH_WCH_STT_AE_AVER_GB_B_ADDR_L @ 0x218;
        reg {
            name = "CH_WCH_STT_AF_STAT_H1_ADDR_L";
            desc = "CH_WCH_STT_ADDR_L is the lower 32 bits register of the ISP statistics storage base address. CH_WCH_STT_AF_STAT_H1_ADDR_L (offset 0x10220 + CH_N x 0x1000, total reset 0x0000_0000; PROVEN: Hi3516D V300 data sheet, PDF page 545, section 9.1.6). Per-instance register (CH_N = 0 to 3): modelled inside the regfile array of its variable.";
            field {
                name = "ch_wch_stt_af_stat_h1_addr_l";
                desc = "Lower 32 bits of the ISP AF_STAT_H1 statistics storage base address (supported only by channel 0/1/2/3)";
                sw = rw; hw = r;
                reset = 0x0;
            } ch_wch_stt_af_stat_h1_addr_l[31:0];
        } CH_WCH_STT_AF_STAT_H1_ADDR_L @ 0x220;
        reg {
            name = "CH_WCH_STT_AF_STAT_H2_ADDR_L";
            desc = "CH_WCH_STT_ADDR_L is the lower 32 bits register of the ISP statistics storage base address. CH_WCH_STT_AF_STAT_H2_ADDR_L (offset 0x10228 + CH_N x 0x1000, total reset 0x0000_0000; PROVEN: Hi3516D V300 data sheet, PDF page 545, section 9.1.6). Per-instance register (CH_N = 0 to 3): modelled inside the regfile array of its variable.";
            field {
                name = "ch_wch_stt_af_stat_h2_addr_l";
                desc = "Lower 32 bits of the ISP AF_STAT_H2 statistics storage base address (supported only by channel 0/1/2/3)";
                sw = rw; hw = r;
                reset = 0x0;
            } ch_wch_stt_af_stat_h2_addr_l[31:0];
        } CH_WCH_STT_AF_STAT_H2_ADDR_L @ 0x228;
    } CH[4] @ 0x10000 += 0x1000;
};

`endif
