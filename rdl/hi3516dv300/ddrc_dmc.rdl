`ifndef EHI3516DV300_DDRC_DMC_RDL
`define EHI3516DV300_DDRC_DMC_RDL
regfile eHI3516DV300_DDRC_DMC {
    name = "DDRC DMC module";
    desc = "DDRC DMC module. 22 registers extracted programmatically from the Hi3516D V300 Professional Smart IP Camera SoC data sheet (Issue 01, 2019-09-12); chapter 4.1.8, table 4-9. Field names, bit ranges, access types and reset values are taken from the register tables; reset values are the data sheet total reset values split onto the fields (per-field values where the table has them). Label: PROVEN. Hardware not verified here (no board).";
    reg {
        name = "DDRC_CTRL_SREF";
        desc = "DDRC_CTRL_SREF is the DDR SDRAM self-refresh control register. DDRC_CTRL_SREF (offset 0x000, total reset 0x0000_0001; PROVEN: Hi3516D V300 data sheet, PDF page 321, section 4.1.8.2).";
        field {
            name = "reserved";
            desc = "Reserved";
            sw = r; hw = w;
            reset = 0x0;
        } reserved_31_2[31:2];
        field {
            name = "sref_done";
            desc = "DDR PHY self-refresh done
- 0: normal operating mode
- 1: The transition from 0 to 1 indicates that the DDR PHY completes all required operations after exiting the self-refresh status and the DMC can accept new requests.";
            sw = rw; hw = r;
            reset = 0x0;
        } sref_done[1:1];
        field {
            name = "sref_req";
            desc = "SDRAM self-refresh request
- 0: exit the self-refresh status
- 1: enter the self-refresh status";
            sw = rw; hw = r;
            reset = 0x1;
        } sref_req[0:0];
    } DDRC_CTRL_SREF @ 0x0;
    reg {
        name = "DDRC_CFG_SREF";
        desc = "DDRC_CFG_SREF is the DDRC self-refresh configuration register. DDRC_CFG_SREF (offset 0x020, total reset 0x0000_0000; PROVEN: Hi3516D V300 data sheet, PDF page 322, section 4.1.8.2).";
        field {
            name = "asref_en";
            desc = "SDRAM automatic self-refresh enable
- 0: disabled
- 1: enabled

Each rank corresponds to one control bit. The rank automatically enters the self-refresh status only when DDRC_CFG_PD[PD_EN] and the asref_en corresponding to the rank are valid. This function is not supported in this version.";
            sw = r; hw = w;
            reset = 0x0;
        } asref_en[31:16];
        field {
            name = "sref_arefnum";
            desc = "Number of self-refresh operations initiated after DDR4 SDRAM exits the self-refresh status during the dynamic frequency selection (DFS) process
- 0x0: No self-refresh operation is initiated. 0x1–0xF: n";
            sw = rw; hw = r;
            reset = 0x0;
        } sref_arefnum[15:12];
        field {
            name = "reserved";
            desc = "Reserved";
            sw = r; hw = w;
            reset = 0x0;
        } reserved_11_9[11:9];
        field {
            name = "clk_switch";
            desc = "DDRC low-power clock switch. Whether to back press AXI interface command when the DDRC enters the low-power status (DDR SDRAM self-refresh)
- 0: The interface commands are not back pressed, and an error is returned directly.
- 1: The interface commands are back pressed, and the original command is executed after the clock is switched.";
            sw = rw; hw = r;
            reset = 0x0;
        } clk_switch[8:8];
        field {
            name = "reserved";
            desc = "Reserved";
            sw = r; hw = w;
            reset = 0x0;
        } reserved_7_5[7:5];
        field {
            name = "sref_odis";
            desc = "Output disable for the DDR SDRAM command and data I/O in self-refresh mode
- 0: enabled
- 1: disabled

The configuration is a static configuration. It is recommended that this bit be set to 1 to disable the output of the DDR SDRAM command and data I/O after the DDR SDRAM enters the self-refresh status. It is recommended that this bit be set to 0 to enable the output of the DDR SDRAM command and data I/O before the DDR SDRAM exits the self-refresh status.";
            sw = rw; hw = r;
            reset = 0x0;
        } sref_odis[4:4];
        field {
            name = "reserved";
            desc = "Reserved";
            sw = r; hw = w;
            reset = 0x0;
        } reserved_3_2[3:2];
        field {
            name = "asref_fast_wakeup";
            desc = "Enable/disable of the AUTO SELFREFRESH fast wakeup
- 0: enabled
- 1: disabled";
            sw = rw; hw = r;
            reset = 0x0;
        } asref_fast_wakeup[1:1];
        field {
            name = "sref_cc";
            desc = "SDRAM clock control in self-refresh mode
- 0: The SDRAM clock is enabled.
- 1: The SDRAM clock is disabled.";
            sw = rw; hw = r;
            reset = 0x0;
        } sref_cc[0:0];
    } DDRC_CFG_SREF @ 0x20;
    reg {
        name = "DDRC_CFG_PD";
        desc = "DDRC_CFG_PD is the DDR SDRAM power-down status register. DDRC_CFG_PD (offset 0x028, total reset 0x0000_0000; PROVEN: Hi3516D V300 data sheet, PDF page 323, section 4.1.8.2).";
        field {
            name = "asref_prd";
            desc = "SDRAM self-refresh cycle. When the DDRC does not receive any command in consecutive asref_prd cycles, it forces the SDRAM to enter the self-refresh status. When a command is received, the DDRC forces the SDRAM to exit the self-refresh status. 0x0–0xFFF: (n x 16) clock cycles This field is valid only when asref_en is 1.";
            sw = r; hw = w;
            reset = 0x0;
        } asref_prd[31:20];
        field {
            name = "t_clk_cke";
            desc = "Relationship between CLK and CKE 0x0–0x7: Delay relative to CKE when the DDR PHY disables the DDR SDRAM clock. The delay is related to the DDR PHY. This field can be set to 0 when the clock is disabled.";
            sw = rw; hw = r;
            reset = 0x0;
        } t_clk_cke[19:16];
        field {
            name = "pd_prd";
            desc = "SDRAM power-down cycle. When the DDRC does not receive any command in consecutive pd_prd cycles, it forces the SDRAM to enter the power-down status. When a command is received, the DDRC forces the SDRAM to exit the power-down status.
- 0x00: not enter the power-down status 0x01–0xFFF: n clock cycles

This field is valid only when pd_en is 1.";
            sw = rw; hw = r;
            reset = 0x0;
        } pd_prd[15:4];
        field {
            name = "reserved";
            desc = "Reserved";
            sw = r; hw = w;
            reset = 0x0;
        } reserved_3_3[3:3];
        field {
            name = "reserved";
            desc = "Reserved";
            sw = r; hw = w;
            reset = 0x0;
        } reserved_2_2[2:2];
        field {
            name = "pd_ac";
            desc = "SDRAM address command dynamic disable";
            sw = rw; hw = r;
            reset = 0x0;
        } pd_ac[1:1];
        field {
            name = "pd_en";
            desc = "Automatic power-down enable for the SDRAM
- 1: enabled
- 0: disabled";
            sw = rw; hw = r;
            reset = 0x0;
        } pd_en[0:0];
    } DDRC_CFG_PD @ 0x28;
    reg {
        name = "DDRC_CFG_AREF";
        desc = "DDRC_CFG_AREF is the DDRC auto-refresh mode register. DDRC_CFG_AREF (offset 0x02C, total reset 0x0000_0000; PROVEN: Hi3516D V300 data sheet, PDF page 324, section 4.1.8.2).";
        field {
            name = "reserved";
            desc = "Reserved";
            sw = r; hw = w;
            reset = 0x0;
        } reserved_31_16[31:16];
        field {
            name = "aref_alarm_num";
            desc = "The auto-refresh command is forcibly transmitted if a specific number of auto-refresh commands cannot be transmitted. 0x0–0xFF: lack of (n + 1) auto-refresh commands Only one auto-refresh command is considered when n is 255 because the upper bits are lost after the bits of the 8-bit counter are carried. In optimization mode (when aref_opt is 1), an alarm is generated when the number of postponed commands is greater than or equal to 15.";
            sw = rw; hw = r;
            reset = 0x0;
        } aref_alarm_num[15:8];
        field {
            name = "reserved";
            desc = "Reserved";
            sw = r; hw = na;
            reset = 0x0;
        } reserved_7_5[7:5];
        field {
            name = "aref_alarm_en";
            desc = "Auto-refresh loss alarm enable (AREF function)
- 0: disabled
- 1: enabled";
            sw = rw; hw = r;
            reset = 0x0;
        } aref_alarm_en[4:4];
        field {
            name = "aref_dual_rank";
            desc = "REF command transmit mode select
- 0: The REF commands are transmitted to only one rank each time.
- 1: The REF commands are transmitted to two";
            sw = rw; hw = r;
            reset = 0x0;
        } aref_dual_rank[3:3];
        field {
            name = "aref_opt";
            desc = "Auto-refresh optimization enable
- 0: disabled
- 1: enabled

When this function is enabled, it is recommended that aref_mode be set to 00. The DMC dynamically detects whether the DDR SDRAM is idle during each auto-refresh. If the DDR SDRAM is idle, the AREF commands are transmitted; otherwise, the DMC waits until nine AREF cycles are reached. Then the DMC forcibly terminates the DDR SDRAM access and inserts AREF commands.";
            sw = rw; hw = r;
            reset = 0x0;
        } aref_opt[2:2];
        field {
            name = "aref_mode";
            desc = "Auto-refresh mode
- 00: An auto-refresh operation is performed every one tREFI cycle.
- 01: Three auto-refresh operations are performed every four tREFI cycles.
- 10: Four auto-refresh operations are performed every five tREFI cycles.
- 11: Eight auto-refresh operations are performed every nine tREFI cycles.

Optimized auto-refresh mode
- 00: The maximum number of postponed commands is 1.
- 01: The maximum number of postponed commands is 2.
- 10: The maximum number of postponed commands is 4.
- 11: The maximum number of postponed commands is 8.";
            sw = rw; hw = r;
            reset = 0x0;
        } aref_mode[1:0];
    } DDRC_CFG_AREF @ 0x2c;
    reg {
        name = "DDRC_CFG_WORKMODE";
        desc = "DDRC_CFG_WORKMODE is the DDRC operating mode register. DDRC_CFG_WORKMODE (offset 0x040, total reset 0x0000_0000; PROVEN: Hi3516D V300 data sheet, PDF page 325, section 4.1.8.2).";
        field {
            name = "reserved";
            desc = "Reserved";
            sw = r; hw = w;
            reset = 0x0;
        } reserved_31_15[31:15];
        field {
            name = "wr_intlv_en";
            desc = "DMC burst write interpolation enable
- 0: disabled";
            sw = rw; hw = r;
            reset = 0x0;
        } wr_intlv_en[14:14];
        field {
            name = "hdr_mode";
            desc = "DDR PHY interface (DFI) mode select
- 0: SDR mode
- 1: HDR mode

The chip supports only the HDR mode.";
            sw = rw; hw = r;
            reset = 0x0;
        } hdr_mode[13:13];
        field {
            name = "read_mode";
            desc = "DDRC read mode
- 0: associated read mode
- 1: delay read mode

The associated read mode is a mode in which the DDRC samples data based on the data valid signal from the PHY. The delay read mode is a mode in which the DDRC samples the data from the PHY after the internal delay of the DDRC.";
            sw = rw; hw = r;
            reset = 0x0;
        } read_mode[12:12];
        field {
            name = "addr_mode";
            desc = "DDR SDRAM address line reverse mode select
- 00: The address is set to all 1s when the DDR is idle.
- 01: The status of the previous command is retained when the DDR SDRAM is idle.
- 10: The status opposite to the previous status is restored when the DDR SDRAM is idle.
- 11: reserved";
            sw = rw; hw = r;
            reset = 0x0;
        } addr_mode[11:10];
        field {
            name = "intlv_en";
            desc = "DMC burst read interleaving enable
- 0: disabled
- 1: enabled

In DDR4 mode, the performance is best when this field is set to 1. In other modes, it is recommended that this field be set to 0.";
            sw = rw; hw = r;
            reset = 0x0;
        } intlv_en[9:9];
        field {
            name = "reserved";
            desc = "Reserved";
            sw = r; hw = w;
            reset = 0x0;
        } reserved_8_5[8:5];
        field {
            name = "apre_en";
            desc = "Auto-precharge enable
- 0: disabled
- 1: enabled";
            sw = rw; hw = r;
            reset = 0x0;
        } apre_en[4:4];
        field {
            name = "func_clkon";
            desc = "Functional module clock enable
- 0: The clock is internally controlled.
- 1: The clock is forcibly enabled.";
            sw = rw; hw = r;
            reset = 0x0;
        } func_clkon[3:3];
        field {
            name = "data_clkon";
            desc = "Data channel clock enable";
            sw = rw; hw = r;
            reset = 0x0;
        } data_clkon[2:2];
        field {
            name = "cmd_clkon";
            desc = "Command channel clock enable
- 0: The clock is internally controlled.
- 1: The clock is forcibly enabled.";
            sw = rw; hw = r;
            reset = 0x0;
        } cmd_clkon[1:1];
        field {
            name = "clk_ratio";
            desc = "Operating mode of the DDRC
- 0: The ratio of the DDRC frequency to the

PHY frequency is 1:1.
- 1: The ratio of the frequency of the DDRC to the frequency of the PHY is 1:2.

This field is fixed at 1 in this version.";
            sw = rw; hw = r;
            reset = 0x0;
        } clk_ratio[0:0];
    } DDRC_CFG_WORKMODE @ 0x40;
    reg {
        name = "DDRC_CFG_WORKMODE2";
        desc = "DDRC_CFG_WORKMODE2 is the DDRC operating mode register. DDRC_CFG_WORKMODE2 (offset 0x044, total reset 0x0000_0000; PROVEN: Hi3516D V300 data sheet, PDF page 327, section 4.1.8.2).";
        field {
            name = "reserved";
            desc = "Reserved";
            sw = r; hw = w;
            reset = 0x0;
        } reserved_31_16[31:16];
        field {
            name = "rank_disable";
            desc = "Rank disable
- 0: normal operating mode
- 1: The auto-refresh/power-down/self-refresh function of a rank is disabled.";
            sw = rw; hw = r;
            reset = 0x0;
        } rank_disable[15:0];
    } DDRC_CFG_WORKMODE2 @ 0x44;
    reg {
        name = "DDRC_CFG_DDRMODE";
        desc = "DDRC_CFG_DDRMODE is the DDRC operating mode register. DDRC_CFG_DDRMODE (offset 0x050, total reset 0x0000_0000; PROVEN: Hi3516D V300 data sheet, PDF page 327, section 4.1.8.2).";
        field {
            name = "reserved";
            desc = "Reserved";
            sw = r; hw = na;
            reset = 0x0;
        } reserved_31_31[31:31];
        field {
            name = "bank_mode";
            desc = "Bank interleaving mode For 8-bit bus width:
- 000: 8-byte banks are interleaved.
- 001: 16-byte banks are interleaved. …
- 111: 1 KB banks are interleaved.";
            sw = rw; hw = r;
            reset = 0x0;
        } bank_mode[30:28];
        field {
            name = "reserved";
            desc = "Reserved";
            sw = r; hw = na;
            reset = 0x0;
        } reserved_27_26[27:26];
        field {
            name = "bank_xor";
            desc = "Scrambling enable for the bank address and row address
- 00: disabled
- 01: The bank address and offset address 0 are scrambled.
- 10: The bank address and offset address 1 are scrambled.
- 11: The bank address and offset address 2 are scrambled.";
            sw = rw; hw = r;
            reset = 0x0;
        } bank_xor[25:24];
        field {
            name = "asref_zqc_en";
            desc = "SDRAM ZQ enable when the ASREF exits.
- 0: disabled
- 1: enabled";
            sw = rw; hw = r;
            reset = 0x0;
        } asref_zqc_en[23:23];
        field {
            name = "sref_zqc_en";
            desc = "SDRAM ZQ enable when the SREF exits.
- 0: disabled
- 1: enabled

This field is valid only for the DDR4 SDRAM and is set to 0 by default. In addition, the value of this field cannot be dynamically changed during the self-refresh exit process.";
            sw = rw; hw = r;
            reset = 0x0;
        } sref_zqc_en[22:22];
        field {
            name = "rank";
            desc = "Number of DDRC ranks
- 00: 1
- 01: 2
- 10: 3
- 11: 4

When the number of external DDR SDRAM ranks is greater than 4, this field is used to control four groups of ranks (0–3, 4–7, 8–11, and 12–16).";
            sw = rw; hw = r;
            reset = 0x0;
        } rank[21:20];
        field {
            name = "rank_mode";
            desc = "Rank interleaving mode
- 00: single rank mode
- 01: DIMM interleaving mode
- 10: Two ranks are interleaved.
- 11: Four ranks are interleaved.

Multiple ranks can be interleaved only when the configuration of these ranks is the same; otherwise, unpredictable errors may occur.";
            sw = rw; hw = r;
            reset = 0x0;
        } rank_mode[19:18];
        field {
            name = "odt_on";
            desc = "Whether the ODT signal output to the SDRAM is fixed
- 0: The signal is automatically controlled by the DDRC.
- 1: The output is fixed at the wodt configuration of rank 0.";
            sw = rw; hw = r;
            reset = 0x0;
        } odt_on[17:17];
        field {
            name = "zqc_en";
            desc = "AREF ZQ command enable
- 0: disabled
- 1: enabled";
            sw = rw; hw = r;
            reset = 0x0;
        } zqc_en[16:16];
        field {
            name = "reserved";
            desc = "Reserved";
            sw = r; hw = na;
            reset = 0x0;
        } reserved_15_15[15:15];
        field {
            name = "scramb_en";
            desc = "Data scrambling enable (The scrambling code is generated by using the address, and exclusive ORed with the data to reduce synchronous inversion).
- 0: disabled
- 1: enabled";
            sw = rw; hw = r;
            reset = 0x0;
        } scramb_en[14:14];
        field {
            name = "reserved";
            desc = "Reserved";
            sw = r; hw = na;
            reset = 0x0;
        } reserved_13_13[13:13];
        field {
            name = "reserved";
            desc = "Reserved";
            sw = r; hw = na;
            reset = 0x0;
        } reserved_12_12[12:12];
        field {
            name = "reserved";
            desc = "Reserved. This bit must be fixed at 1'b0.";
            sw = r; hw = w;
            reset = 0x0;
        } reserved_11_11[11:11];
        field {
            name = "rd_2t_pre";
            desc = "DDR4 SDRAM read 2T preamble enable
- 0: disabled
- 1: enabled";
            sw = rw; hw = r;
            reset = 0x0;
        } rd_2t_pre[10:10];
        field {
            name = "wr_2t_pre";
            desc = "DDR4 SDRAM write 2T preamble enable
- 0: disabled
- 1: enabled";
            sw = rw; hw = r;
            reset = 0x0;
        } wr_2t_pre[9:9];
        field {
            name = "brstlen";
            desc = "Burst length of the DDRC When brstlen2 is set to 0:
- 0: BL4
- 1: BL8

When brstlen2 is set to 1:
- 0: BL16
- 1: BL32

The burst length of the DDR4 SDRAM can be set to only burst 8. The burst length is related to the clock ratio of the DMC to the PHY. The burst length is BLx/n (x indicates the burst type, that is, 4, 8, 16, or 32. n indicates that the clock ratio of the DMC to the PHY is 1:n). For example, when the clock ratio is
- 1:2, to set the DDRC burst length to BL32, set brstlen to 0 and brstlen2 to 1.";
            sw = rw; hw = r;
            reset = 0x0;
        } brstlen[8:8];
        field {
            name = "reserved";
            desc = "Reserved";
            sw = r; hw = na;
            reset = 0x0;
        } reserved_7_7[7:7];
        field {
            name = "reserved";
            desc = "Reserved";
            sw = r; hw = na;
            reset = 0x0;
        } reserved_6_6[6:6];
        field {
            name = "mem_width";
            desc = "Bit width of the storage data bus
- 00: 8 bits
- 01: 16 bits
- 10: 32 bits
- 11: 64 bits";
            sw = rw; hw = r;
            reset = 0x0;
        } mem_width[5:4];
        field {
            name = "dram_type";
            desc = "External memory type
- 0110: DDR3 SDRAM
- 0111: DDR4 SDRAM

Other values: reserved";
            sw = rw; hw = r;
            reset = 0x0;
        } dram_type[3:0];
    } DDRC_CFG_DDRMODE @ 0x50;
    reg {
        name = "DDRC_CFG_SCRAMB";
        desc = "DDRC_CFG_SCRAMB is the DDR SDRAM data scrambling configuration register. DDRC_CFG_SCRAMB (offset 0x058, total reset 0x0000_0000; PROVEN: Hi3516D V300 data sheet, PDF page 330, section 4.1.8.2).";
        field {
            name = "reserved";
            desc = "Reserved";
            sw = r; hw = na;
            reset = 0x0;
        } reserved_31_19[31:19];
        field {
            name = "dbi_low_act";
            desc = "DBI active level
- 0: active high
- 1: active low";
            sw = rw; hw = r;
            reset = 0x0;
        } dbi_low_act[18:18];
        field {
            name = "rd_dbi_en";
            desc = "Read DBI enable
- 0: disabled
- 1: enabled";
            sw = rw; hw = r;
            reset = 0x0;
        } rd_dbi_en[17:17];
        field {
            name = "wr_dbi_en";
            desc = "Read DBI enable
- 0: disabled
- 1: enabled";
            sw = rw; hw = r;
            reset = 0x0;
        } wr_dbi_en[16:16];
        field {
            name = "reserved";
            desc = "Reserved";
            sw = r; hw = na;
            reset = 0x0;
        } reserved_15_5[15:5];
        field {
            name = "scramb_seed_type";
            desc = "Address mode for scrambling
- 0: Use the CS and BA for scrambling.
- 1: Use the CS, BA, and lower bits of the row address for scrambling.";
            sw = rw; hw = r;
            reset = 0x0;
        } scramb_seed_type[4:4];
        field {
            name = "reserved";
            desc = "Reserved";
            sw = r; hw = na;
            reset = 0x0;
        } reserved_3_3[3:3];
        field {
            name = "scramb_seed_sort";
            desc = "Address arrangement mode for scrambling
- 000: CS_BA_COL arrangement
- 001: CS_COL_BA arrangement
- 010: COL_CS_BA arrangement
- 011: COL_BA_CS arrangement
- 100: BA_CS_COL arrangement
- 101: BA_COL_CS arrangement

Other values: reserved";
            sw = rw; hw = r;
            reset = 0x0;
        } scramb_seed_sort[2:0];
    } DDRC_CFG_SCRAMB @ 0x58;
    reg {
        name = "DDRC_CFG_RNKVOLn";
        desc = "DDRC_CFG_RNKVOLn is the DDRC-controlled DDR SDRAM capacity configuration register. DDRC_CFG_RNKVOLn (offset 0x060, total reset 0x0000_0022; PROVEN: Hi3516D V300 data sheet, PDF page 331, section 4.1.8.2).";
        field {
            name = "reserved";
            desc = "Reserved";
            sw = r; hw = w;
            reset = 0x0;
        } reserved_31_17[31:17];
        field {
            name = "mem_x4";
            desc = "4-bit external component combination mode
- 0: 8-/16-/32-bit external components are combined.
- 1: 4-bit external components are combined.";
            sw = rw; hw = r;
            reset = 0x0;
        } mem_x4[16:16];
        field {
            name = "reserved";
            desc = "Reserved";
            sw = r; hw = w;
            reset = 0x0;
        } reserved_15_14[15:14];
        field {
            name = "mem_map";
            desc = "Address translation mode of the SDRAM
- 00: {Rank, Row, Ba, Col, DW} =

AXI_Address
- 01: {Rank, Ba, Row, Col, DW}=

AXI_Address
- 10: {Rank, Row, Ba, Col, cs, Col, DW}=

AXI_Address
- 11: {Rank, Ba, Row, Col, cs, Col, DW}=

AXI_Address This parameter can be set to 10 or 11 only when DDRC_CONFIG1[dual_ch] is valid. When there are multiple ranks, the configuration must be the same for each rank. This field must be set to 00 in the current version.";
            sw = rw; hw = r;
            reset = 0x0;
        } mem_map[13:12];
        field {
            name = "mem_bankgroup";
            desc = "Number of bank groups in a single SDRAM
- 00: 1 bank group
- 01: 2 bank groups
- 10: 4 bank groups
- 11: reserved

This field is valid only in DDR4 mode.";
            sw = rw; hw = r;
            reset = 0x0;
        } mem_bankgroup[11:10];
        field {
            name = "mem_bank";
            desc = "Number of banks of a single SDRAM
- 00: 4 banks
- 01: 8 banks
- 10:16 banks
- 11: reserved";
            sw = rw; hw = r;
            reset = 0x0;
        } mem_bank[9:8];
        field {
            name = "reserved";
            desc = "Reserved";
            sw = r; hw = w;
            reset = 0x0;
        } reserved_7_7[7:7];
        field {
            name = "mem_row";
            desc = "Bit width of the row address of a single SDRAM
- 000: 11 bits
- 001: 12 bits
- 010: 13 bits
- 011: 14 bits
- 100: 15 bits
- 101: 16 bits

Other values: reserved";
            sw = rw; hw = r;
            reset = 0x2;
        } mem_row[6:4];
        field {
            name = "reserved";
            desc = "Reserved";
            sw = r; hw = w;
            reset = 0x0;
        } reserved_3_3[3:3];
        field {
            name = "mem_col";
            desc = "Bit width of the column address of a single";
            sw = rw; hw = r;
            reset = 0x2;
        } mem_col[2:0];
    } DDRC_CFG_RNKVOLn @ 0x60;
    reg {
        name = "DDRC_CFG_ODT";
        desc = "DDRC_CFG_ODT is the DDR SDRAM ODT configuration register. DDRC_CFG_ODT (offset 0x0A0, total reset 0x0000_0000; PROVEN: Hi3516D V300 data sheet, PDF page 333, section 4.1.8.2).";
        field {
            name = "rodt";
            desc = "ODT read enable for other RANKs when the current RANK transmits the read command
- 0: disabled
- 1: enabled";
            sw = rw; hw = r;
            reset = 0x0;
        } rodt[31:16];
        field {
            name = "wodt";
            desc = "ODT write enable for other RANKs when the current RANK transmits the write command
- 0: disabled
- 1: enabled";
            sw = rw; hw = r;
            reset = 0x0;
        } wodt[15:0];
    } DDRC_CFG_ODT @ 0xa0;
    reg {
        name = "DDRC_CFG_TIMING0";
        desc = "DDRC_CFG_TIMING0 is DDRC timing parameter register 0. DDRC_CFG_TIMING0 (offset 0x100, total reset 0xFFFF_FF3F; PROVEN: Hi3516D V300 data sheet, PDF page 333, section 4.1.8.2).";
        field {
            name = "tmrd";
            desc = "Number of wait cycles for the load mode register (LMR) command. The value is tMRD for the DDR4 SDRAM 0x0–0x1: 1 clock cycle 0x2–0xF: n clock cycles";
            sw = rw; hw = r;
            reset = 0xf;
        } tmrd[31:28];
        field {
            name = "trrd";
            desc = "Number of wait cycles from ACT bank A to ACT bank B 0x0–0x1: 1 clock cycle 0x2–0xF: n clock cycles";
            sw = rw; hw = r;
            reset = 0xf;
        } trrd[27:24];
        field {
            name = "trp_pb";
            desc = "Number of wait cycles for the disable";
            sw = rw; hw = r;
            reset = 0x1f;
        } trp_pb[23:19];
        field {
            name = "trcd";
            desc = "Number of wait cycles from the ACT bank command to the read or write command 0x0–0x3: 3 clock cycles 0x4–0xF: n clock cycles";
            sw = rw; hw = r;
            reset = 0x1f;
        } trcd[18:14];
        field {
            name = "trc";
            desc = "Number of wait cycles from an ACT bank command to the next ACT bank command 0x00–0x01: 1 clock cycle 0x02–0x3F: n clock cycles";
            sw = rw; hw = r;
            reset = 0x3f;
        } trc[13:8];
        field {
            name = "reserved";
            desc = "Reserved";
            sw = r; hw = w;
            reset = 0x0;
        } reserved_7_6[7:6];
        field {
            name = "tras";
            desc = "Number of wait cycles from the ACT bank command to the disable command (PRE) 0x0–0x1: 1 clock cycle 0x2–0xF: n clock cycles Others: Reserved";
            sw = rw; hw = r;
            reset = 0x3f;
        } tras[5:0];
    } DDRC_CFG_TIMING0 @ 0x100;
    reg {
        name = "DDRC_CFG_TIMING1";
        desc = "DDRC_CFG_TIMING1 is DDRC timing parameter register 1. DDRC_CFG_TIMING1 (offset 0x104, total reset 0xFF22_15FF; PROVEN: Hi3516D V300 data sheet, PDF page 334, section 4.1.8.2).";
        field {
            name = "tsre";
            desc = "Number of wait cycles from the self-refresh exit command to the read command
- 0x0: reserved 0x01–0xFF: (n x 4) clock cycles

This field is set to the larger value between tXSDLL and tXS for the DDR4 SDRAM.";
            sw = rw; hw = r;
            reset = 0xff;
        } tsre[31:24];
        field {
            name = "trtw";
            desc = "Delay from the last read data command to the first write data command 0x0–0x1: 1 clock cycle 0x2–0xF: (n + 1) clock cycles The field value depends on the latency of the board, package, and I/O.";
            sw = rw; hw = r;
            reset = 0x2;
        } trtw[23:20];
        field {
            name = "reserved";
            desc = "Reserved";
            sw = r; hw = na;
            reset = 0x0;
        } reserved_19_19[19:19];
        field {
            name = "reserved";
            desc = "Reserved";
            sw = r; hw = na;
            reset = 0x0;
        } reserved_18_14[18:14];
        field {
            name = "twl";
            desc = "Number of wait cycles from the write command to the write data command 0x0–0x1: 1 clock cycle 0x2–0xF: n clock cycles For example, 0x3 indicates three clock cycles.";
            sw = rw; hw = r;
            reset = 0x4;
        } twl[13:8];
        field {
            name = "reserved";
            desc = "Reserved";
            sw = r; hw = w;
            reset = 0x0;
        } reserved_7_6[7:6];
        field {
            name = "tcl";
            desc = "Column address strobe (CAS) latency from the read command to the read data operation 0x0–0x1: 1 clock cycle 0x2–0xF: n clock cycles";
            sw = rw; hw = r;
            reset = 0x3f;
        } tcl[5:0];
    } DDRC_CFG_TIMING1 @ 0x104;
    reg {
        name = "DDRC_CFG_TIMING2";
        desc = "DDRC_CFG_TIMING2 is DDRC timing parameter register 2. DDRC_CFG_TIMING2 (offset 0x108, total reset 0xF303_F000; PROVEN: Hi3516D V300 data sheet, PDF page 335, section 4.1.8.2).";
        field {
            name = "tcke";
            desc = "Minimum cycle of retaining the self-refresh mode
- 0x0: reserved 0x1–0xF: n clock cycles

The field value must be the maximum value among tCKESR, tCKSRE, tCKSRX, and tCKE.";
            sw = rw; hw = r;
            reset = 0xf;
        } tcke[31:28];
        field {
            name = "twtr";
            desc = "Number of wait cycles for the last write data to the write-to-read command 0x0–0x1: 1 clock cycle 0x2–0xF: n clock cycles For example, 0x3 indicates three clock cycles.";
            sw = rw; hw = r;
            reset = 0x3;
        } twtr[27:24];
        field {
            name = "reserved";
            desc = "Reserved";
            sw = r; hw = na;
            reset = 0x3f;
        } reserved_23_18[23:18];
        field {
            name = "tfaw";
            desc = "Number of clock cycles for four consecutive activation commands 0x00–0x3F: n clock cycles For example, 0x14 indicates 20 clock cycles.";
            sw = rw; hw = r;
            reset = 0x3f;
        } tfaw[17:12];
        field {
            name = "reserved";
            desc = "Reserved";
            sw = r; hw = na;
            reset = 0x0;
        } reserved_11_11[11:11];
        field {
            name = "taref";
            desc = "Number of auto-refresh cycles
- 0x000: forbidden 0x001–0x7FF: The auto-refresh cycle of the

SDRAM is (16 x n) clock cycles.";
            sw = rw; hw = r;
            reset = 0x0;
        } taref[10:0];
    } DDRC_CFG_TIMING2 @ 0x108;
    reg {
        name = "DDRC_CFG_TIMING3";
        desc = "DDRC_CFG_TIMING3 is DDRC timing parameter register 3. DDRC_CFG_TIMING3 (offset 0x10C, total reset 0xFFFF_E0F2; PROVEN: Hi3516D V300 data sheet, PDF page 336, section 4.1.8.2).";
        field {
            name = "tzq_prd";
            desc = "Number of ZQCS command cycles
- 0x000: The ZQCS command is forbidden. 0x001–0x3FF: (n x 128) AREF cycles

The number of ZQCS command cycles is equal to (n x 128) taref clock cycles.";
            sw = rw; hw = r;
            reset = 0x3ff;
        } tzq_prd[31:22];
        field {
            name = "tzqinit";
            desc = "Number of ZQ initialization delay cycles 0x0–0x1FF: (n x 4) clock cycles The value needs to be set to the larger value between tZQINIT and tDLLK.";
            sw = rw; hw = r;
            reset = 0x1ff;
        } tzqinit[21:13];
        field {
            name = "taond";
            desc = "Number of ODT enable/disable cycles In DDR4 mode, this value is set to tWL – 2 (tWL is DDRC_CFG_TIMING1[twl]).";
            sw = rw; hw = r;
            reset = 0x0;
        } taond[12:8];
        field {
            name = "txard";
            desc = "Number of wait cycles of exiting the DDR SDRAM low-power mode 0x0–0xF: n clock cycles (in decimal) For example, 0x7 indicates seven clock cycles. The field value is the maximum value among tXP, tXARD, tXARDS, and tXS.";
            sw = rw; hw = r;
            reset = 0xf;
        } txard[7:4];
        field {
            name = "trtp";
            desc = "Wait delay from the read command to the disable command 0x0–0x2: 2 clock cycles 0x3–0xF: n clock cycles Trtp is calculated as follows: Trtp = AL + BL/2 + Max (trtp, 2) – 2";
            sw = rw; hw = r;
            reset = 0x2;
        } trtp[3:0];
    } DDRC_CFG_TIMING3 @ 0x10c;
    reg {
        name = "DDRC_CFG_TIMING4";
        desc = "DDRC_CFG_TIMING4 is DDRC timing parameter register 4. DDRC_CFG_TIMING4 (offset 0x110, total reset 0x01FF_2018; PROVEN: Hi3516D V300 data sheet, PDF page 337, section 4.1.8.2).";
        field {
            name = "reserved";
            desc = "Reserved";
            sw = r; hw = na;
            reset = 0x0;
        } reserved_31_25[31:25];
        field {
            name = "tmod";
            desc = "Delay from the MRS command to ODT and ZQCL validity 0x0–0x1: one clock cycle 0x2–0x1F: n clock cycles";
            sw = rw; hw = r;
            reset = 0x1f;
        } tmod[24:20];
        field {
            name = "reserved";
            desc = "Reserved";
            sw = r; hw = na;
            reset = 0xf2018;
        } reserved_19_0[19:0];
    } DDRC_CFG_TIMING4 @ 0x110;
    reg {
        name = "DDRC_CFG_TIMING5";
        desc = "DDRC_CFG_TIMING5 is DDRC timing parameter register 5. DDRC_CFG_TIMING5 (offset 0x114, total reset 0x1113_FF1F; PROVEN: Hi3516D V300 data sheet, PDF page 337, section 4.1.8.2).";
        field {
            name = "reserved";
            desc = "Reserved";
            sw = r; hw = na;
            reset = 0x1113;
        } reserved_31_16[31:16];
        field {
            name = "tzqcs";
            desc = "ZQCS calibration delay cycle 0x0–0xFF: (n x 2) clock cycles The field value must be greater than or equal to 10 because of the DMC design.";
            sw = rw; hw = r;
            reset = 0xff;
        } tzqcs[15:8];
        field {
            name = "reserved";
            desc = "Reserved";
            sw = r; hw = w;
            reset = 0x0;
        } reserved_7_5[7:5];
        field {
            name = "twr";
            desc = "Number of wait cycles of write recovery 0x0–0x1: one clock cycle 0x2–0x1F: n clock cycles When the DFS is required, tWR must be set based on the highest chip frequency that may be used. tWR cannot be changed when the DDR SDRAM frequency changes.";
            sw = rw; hw = r;
            reset = 0x1f;
        } twr[4:0];
    } DDRC_CFG_TIMING5 @ 0x114;
    reg {
        name = "DDRC_CFG_TIMING6";
        desc = "DDRC_CFG_TIMING6 is DDRC timing parameter register 6. DDRC_CFG_TIMING6 (offset 0x118, total reset 0x0000_00FF; PROVEN: Hi3516D V300 data sheet, PDF page 337, section 4.1.8.2).";
        field {
            name = "tccd_nsw";
            desc = "Minimum interval between two inconsecutive write operations when the 2T preamble or 2T postamble is enabled";
            sw = rw; hw = r;
            reset = 0x0;
        } tccd_nsw[31:28];
        field {
            name = "tccd_nsr";
            desc = "Minimum interval between two inconsecutive read operations when the 2T preamble or 2T postamble is enabled 0x0–0x1: one clock cycle 0x2–0xF: n clock cycles";
            sw = rw; hw = r;
            reset = 0x0;
        } tccd_nsr[27:24];
        field {
            name = "trrd_l";
            desc = "Number of trrd wait cycles between bank groups 0x0–0x1: one clock cycle 0x2–0xF: n clock cycles";
            sw = rw; hw = r;
            reset = 0x0;
        } trrd_l[23:20];
        field {
            name = "twtr_l";
            desc = "Number of twtr wait cycles between bank groups 0x0–0x1: one clock cycle 0x2–0xF: n clock cycles";
            sw = rw; hw = r;
            reset = 0x0;
        } twtr_l[19:16];
        field {
            name = "tccd_l";
            desc = "Number of tccd wait cycles between bank groups 0x0–0x1: one clock cycle 0x2–0xF: n clock cycles";
            sw = rw; hw = r;
            reset = 0x0;
        } tccd_l[15:12];
        field {
            name = "reserved";
            desc = "Reserved";
            sw = r; hw = w;
            reset = 0x0;
        } reserved_11_8[11:8];
        field {
            name = "tcksrx";
            desc = "tCKSRX for the DDR4. Number of advanced valid beats before the DDR SDRAM exits the self-refresh status 0x0–0x1: one clock cycle 0x2–0xF: n clock cycles";
            sw = rw; hw = r;
            reset = 0xf;
        } tcksrx[7:4];
        field {
            name = "tcksre";
            desc = "tCKSRE for the DDR4. Number of beats to be retained after the DDR SDRAM enters the self-refresh status 0x0–0x1: one clock cycle 0x2–0xF: n clock cycles";
            sw = rw; hw = r;
            reset = 0xf;
        } tcksre[3:0];
    } DDRC_CFG_TIMING6 @ 0x118;
    reg {
        name = "DDRC_CFG_TIMING7";
        desc = "DDRC_CFG_TIMING7 is DDRC timing parameter register 7. DDRC_CFG_TIMING7 (offset 0x11c, total reset 0x0000_0000; PROVEN: Hi3516D V300 data sheet, PDF page 338, section 4.1.8.2).";
        field {
            name = "reserved";
            desc = "Reserved";
            sw = r; hw = na;
            reset = 0x0;
        } reserved_31_28[31:28];
        field {
            name = "reserved";
            desc = "Reserved";
            sw = r; hw = na;
            reset = 0x0;
        } reserved_27_24[27:24];
        field {
            name = "dimm_trtr";
            desc = "Extra delay of read-to-read switching between DIMMs based on rnk_trtr, for matching the maximum skew";
            sw = rw; hw = r;
            reset = 0x0;
        } dimm_trtr[23:20];
        field {
            name = "dimm_twtw";
            desc = "Extra delay of write-to-write switching between DIMMs based on rnk_twtw, for matching the maximum skew between DIMMs";
            sw = rw; hw = r;
            reset = 0x0;
        } dimm_twtw[19:16];
        field {
            name = "rnk_trtr";
            desc = "Read-to-read delay between ranks";
            sw = rw; hw = r;
            reset = 0x0;
        } rnk_trtr[15:12];
        field {
            name = "rnk_twtw";
            desc = "Write-to-write delay between ranks";
            sw = rw; hw = r;
            reset = 0x0;
        } rnk_twtw[11:8];
        field {
            name = "rnk_trtw";
            desc = "Read-to-write delay between ranks";
            sw = rw; hw = r;
            reset = 0x0;
        } rnk_trtw[7:4];
        field {
            name = "rnk_twtr";
            desc = "Write-to-read delay between ranks";
            sw = rw; hw = r;
            reset = 0x0;
        } rnk_twtr[3:0];
    } DDRC_CFG_TIMING7 @ 0x11c;
    reg {
        name = "DDRC_CFG_TIMING8";
        desc = "DDRC_CFG_TIMING8 is DDRC timing parameter register 8. DDRC_CFG_TIMING8 (offset 0x120, total reset 0x0000_0000; PROVEN: Hi3516D V300 data sheet, PDF page 339, section 4.1.8.2).";
        field {
            name = "reserved";
            desc = "Reserved";
            sw = r; hw = na;
            reset = 0x0;
        } reserved_31_28[31:28];
        field {
            name = "trfc_ab";
            desc = "Number of wait cycles from the auto-refresh command cycle (AREF period) or auto-refresh (AREF) to the ACT command. This field value is set to max{trfc, tzqcs}.
- 0x00: Reserved 0x01–0x1FF: n clock cycles";
            sw = rw; hw = r;
            reset = 0x0;
        } trfc_ab[27:19];
        field {
            name = "trfc_pb";
            desc = "Time parameter of self-refresh cycle per bank";
            sw = rw; hw = r;
            reset = 0x0;
        } trfc_pb[18:10];
        field {
            name = "reserved";
            desc = "Reserved";
            sw = r; hw = na;
            reset = 0x0;
        } reserved_9_5[9:5];
        field {
            name = "trp_ab";
            desc = "Time parameter of the precharge command for all banks";
            sw = rw; hw = r;
            reset = 0x0;
        } trp_ab[4:0];
    } DDRC_CFG_TIMING8 @ 0x120;
    reg {
        name = "DDRC_CFG_BLDATA";
        desc = "DDRC_CFG_BLDATA is the DDRC pre-received write data configuration register. DDRC_CFG_BLDATA (offset 0x148, total reset 0x0000_0002; PROVEN: Hi3516D V300 data sheet, PDF page 339, section 4.1.8.2).";
        field {
            name = "reserved";
            desc = "Reserved";
            sw = r; hw = na;
            reset = 0x0;
        } reserved_31_4[31:4];
        field {
            name = "bl_data";
            desc = "Number of DMC data segments corresponding to each DDR SDRAM command in the current mode";
            sw = rw; hw = r;
            reset = 0x2;
        } bl_data[3:0];
    } DDRC_CFG_BLDATA @ 0x148;
    reg {
        name = "DDRC_CFG_DMCLVL";
        desc = "DDRC_CFG_DMCLVL is the DDRC command queue depth threshold configuration register. DDRC_CFG_DMCLVL (offset 0x14C, total reset 0x0000_0008; PROVEN: Hi3516D V300 data sheet, PDF page 340, section 4.1.8.2).";
        field {
            name = "reserved";
            desc = "Reserved";
            sw = r; hw = w;
            reset = 0x0;
        } reserved_31_13[31:13];
        field {
            name = "mbist_que_level";
            desc = "Number of command buffers started by the DMC when the MTEST or MCLR function is used
- 0x0: 1 0x1–0x10: 1–16. The maximum value is related to the code.";
            sw = rw; hw = r;
            reset = 0x0;
        } mbist_que_level[12:8];
        field {
            name = "reserved";
            desc = "Reserved";
            sw = r; hw = w;
            reset = 0x0;
        } reserved_7_5[7:5];
        field {
            name = "que_level";
            desc = "Depth of the command register FIFO in the DMC 0x1–0x10: depth of n commands Other values: reserved";
            sw = rw; hw = r;
            reset = 0x16;
        } que_level[4:0];
    } DDRC_CFG_DMCLVL @ 0x14c;
    reg {
        name = "DDRC_CFG_DDRPHY";
        desc = "DDRC_CFG_DDRPHY is the DDR SDRAM I/O configuration register. DDRC_CFG_DDRPHY (offset 0x200, total reset 0x001F_1000; PROVEN: Hi3516D V300 data sheet, PDF page 340, section 4.1.8.2).";
        field {
            name = "reserved";
            desc = "Reserved";
            sw = r; hw = w;
            reset = 0x0;
        } reserved_31_21[31:21];
        field {
            name = "wr_busy_dly";
            desc = "Gating enable for the data beat in the PHY The value of this field must be greater than (WL + 2). This field can be set to 0x1F in scenarios that do not have high requirements on power consumption.";
            sw = rw; hw = r;
            reset = 0x1f;
        } wr_busy_dly[20:16];
        field {
            name = "reserved";
            desc = "Reserved";
            sw = r; hw = w;
            reset = 0x0;
        } reserved_15_13[15:13];
        field {
            name = "phy_upden";
            desc = "Enable of the DDRC response to dfi_phyupd_en of the DDR PHY
- 0: disabled
- 1: enabled";
            sw = rw; hw = r;
            reset = 0x1;
        } phy_upden[12:12];
        field {
            name = "trdlat";
            desc = "Inherent delay of the DDR PHY 0x0–0xF: (n + 1) clock cycles";
            sw = rw; hw = r;
            reset = 0x0;
        } trdlat[11:8];
        field {
            name = "reserved";
            desc = "Reserved";
            sw = r; hw = w;
            reset = 0x0;
        } reserved_7_0[7:0];
    } DDRC_CFG_DDRPHY @ 0x200;
};

`endif
