`ifndef EHI3516DV300_ACODEC_RDL
`define EHI3516DV300_ACODEC_RDL
regfile eHI3516DV300_ACODEC {
    name = "Audio codec";
    desc = "Audio codec. 10 registers extracted programmatically from the Hi3516D V300 Professional Smart IP Camera SoC data sheet (Issue 01, 2019-09-12); chapter 11.2.4, table 11-2. Field names, bit ranges, access types and reset values are taken from the register tables; reset values are the data sheet total reset values split onto the fields (per-field values where the table has them). Label: PROVEN. Hardware not verified here (no board).";
    reg {
        name = "AUDIO_ANA_CTRL_0";
        desc = "AUDIO_ANA_CTRL_0 corresponds to AudioCodec analog registers 0–3. AUDIO_ANA_CTRL_0 (offset 0x0014, total reset 0x0405_78E1; PROVEN: Hi3516D V300 data sheet, PDF page 796, section 11.2.4).";
        field {
            name = "IBADJ_CTCM";
            desc = "Bias current of CTCM, MICBIAS, and LINEIN
- 0: 5 µA (recommended)
- 1: 10 µA";
            sw = rw; hw = r;
            reset = 0x0;
        } IBADJ_CTCM[31:31];
        field {
            name = "SEL_CLK_CHOP_LINEOUT_D";
            desc = "Chopper clock frequency select in lineout differential mode
- 00: 96 kHz
- 01: 192 kHz
- 10: 384 kHz
- 11: 768 kHz";
            sw = rw; hw = r;
            reset = 0x0;
        } SEL_CLK_CHOP_LINEOUT_D[30:29];
        field {
            name = "CTRL_CLK_DAC_PH";
            desc = "DAC working clock edge select (master clock frequency divided by 2)
- 0: rising edge
- 1: falling edge";
            sw = rw; hw = r;
            reset = 0x0;
        } CTRL_CLK_DAC_PH[28:28];
        field {
            name = "IBADJ_DAC";
            desc = "DAC bias current
- 00: 3 µA
- 01: 5 µA (recommended)
- 10: 7 µA";
            sw = rw; hw = r;
            reset = 0x1;
        } IBADJ_DAC[27:26];
        field {
            name = "reserved";
            desc = "Reserved";
            sw = r; hw = na;
            reset = 0x0;
        } reserved_25_24[25:24];
        field {
            name = "SEL_CLK_CHOP_DAC_VREF";
            desc = "DAC VREF chopper clock frequency select
- 00: 96 kHz
- 01: 192 kHz
- 10: 384 kHz
- 11: 768 kHz";
            sw = rw; hw = r;
            reset = 0x0;
        } SEL_CLK_CHOP_DAC_VREF[23:22];
        field {
            name = "reserved";
            desc = "Reserved";
            sw = r; hw = na;
            reset = 0x0;
        } reserved_21_21[21:21];
        field {
            name = "BYP_CHOP_DAC_VREF";
            desc = "DAC_VREF chopper enable
- 0: enabled
- 1: disabled";
            sw = rw; hw = r;
            reset = 0x0;
        } BYP_CHOP_DAC_VREF[20:20];
        field {
            name = "ANA_LOOP";
            desc = "Analog loopback enable control
- 0: normal mode (passing through the digital codec)
- 1: direct analog loopback from the analog

ADC to analog DAC";
            sw = rw; hw = r;
            reset = 0x0;
        } ANA_LOOP[19:19];
        field {
            name = "DACL_POP_EN";
            desc = "Left-channel POP circuit enable control
- 0: The pop tone removal function is disabled.
- 1: The pop tone removal function is enabled.

Note: DACR_POP_EN is set to 1 only when the POP process is suppressed during power- on and power-off. When the DAC channel works properly, DACR_POP_EN needs to be set to 0.";
            sw = rw; hw = r;
            reset = 0x1;
        } DACL_POP_EN[18:18];
        field {
            name = "reserved";
            desc = "Reserved";
            sw = r; hw = na;
            reset = 0x0;
        } reserved_17_17[17:17];
        field {
            name = "DACR_POP_EN";
            desc = "Right-channel POP circuit enable control
- 0: The pop tone removal function is disabled.
- 1: The pop tone removal function is enabled.

Note: DACR_POP_EN is set to 1 only when the POP process is suppressed during power- on and power-off. When the DAC channel works properly, DACR_POP_EN needs to be set to 0.";
            sw = rw; hw = r;
            reset = 0x1;
        } DACR_POP_EN[16:16];
        field {
            name = "reserved";
            desc = "Reserved";
            sw = r; hw = na;
            reset = 0x0;
        } reserved_15_15[15:15];
        field {
            name = "MUTE_DACR";
            desc = "Mute control for the right-channel DAC
- 0: The DAC works normally.
- 1: The analog circuit is muted.";
            sw = rw; hw = r;
            reset = 0x1;
        } MUTE_DACR[14:14];
        field {
            name = "MUTE_DACL";
            desc = "Mute control for the left-channel DAC
- 0: The DAC works normally.";
            sw = rw; hw = r;
            reset = 0x1;
        } MUTE_DACL[13:13];
        field {
            name = "PD_DACR";
            desc = "Power-on/off control for the right-channel DAC
- 0: The DAC works normally.
- 1: The DAC is powered off.";
            sw = rw; hw = r;
            reset = 0x1;
        } PD_DACR[12:12];
        field {
            name = "PD_DACL";
            desc = "Power-on/off control for the left-channel DAC
- 0: The DAC works normally.
- 1: The DAC is powered off.";
            sw = rw; hw = r;
            reset = 0x1;
        } PD_DACL[11:11];
        field {
            name = "reserved";
            desc = "Reserved";
            sw = rw; hw = r;
            reset = 0x0;
        } reserved_10_10[10:10];
        field {
            name = "PA_DACR_DFF";
            desc = "Power-on/off control for the right-channel DAC trigger
- 0: The DAC works normally.
- 1: The DAC is powered off.";
            sw = rw; hw = r;
            reset = 0x0;
        } PA_DACR_DFF[9:9];
        field {
            name = "PA_DACL_DFF";
            desc = "Power-on/off control for the left-channel DAC trigger
- 0: The DAC works normally.
- 1: The DAC is powered off.";
            sw = rw; hw = r;
            reset = 0x0;
        } PA_DACL_DFF[8:8];
        field {
            name = "PD_MICBIAS2";
            desc = "MICBIAS2 power-on/off control
- 0: The MICBIAS2 works normally.
- 1: The MICBIAS2 is powered off.";
            sw = rw; hw = r;
            reset = 0x1;
        } PD_MICBIAS2[7:7];
        field {
            name = "PD_IBIAS";
            desc = "Power-on/off control for the ADC RC coefficient correction circuit
- 0: The ADC RC coefficient correction circuit works normally.
- 1: The ADC RC coefficient correction circuit is powered off.";
            sw = rw; hw = r;
            reset = 0x1;
        } PD_IBIAS[6:6];
        field {
            name = "PD_MICBIAS1";
            desc = "MICBIAS1 power-on/off control
- 0: The MICBIAS1 works normally.
- 1: The MICBIAS1 is powered off.";
            sw = rw; hw = r;
            reset = 0x1;
        } PD_MICBIAS1[5:5];
        field {
            name = "reserved";
            desc = "Reserved";
            sw = r; hw = na;
            reset = 0x0;
        } reserved_4_2[4:2];
        field {
            name = "PDB_CTCM_IBIAS";
            desc = "CTCM_BUFFER bias current switch control
- 0: There is no external bias current.
- 1: The bias current is normal.";
            sw = rw; hw = r;
            reset = 0x0;
        } PDB_CTCM_IBIAS[1:1];
        field {
            name = "PD_VREF";
            desc = "VREF power-on/off control
- 0: The VREF works normally.
- 1: The VREF is powered off.";
            sw = rw; hw = r;
            reset = 0x1;
        } PD_VREF[0:0];
    } AUDIO_ANA_CTRL_0 @ 0x14;
    reg {
        name = "AUDIO_ANA_CTRL_1";
        desc = "AUDIO_ANA_CTRL_1 corresponds to AudioCodec analog registers 4–7. AUDIO_ANA_CTRL_1 (offset 0x0018, total reset 0x1102_0004; PROVEN: Hi3516D V300 data sheet, PDF page 799, section 11.2.4).";
        field {
            name = "ADC_DAC_RL_MIS_SELN";
            desc = "ADC feedback DAC load resistance select control (negative end)
- 0000: The load resistance increases by 15%.
- 0001: The load resistance increases by 14%.
- 0010: The load resistance increases by 13%.
- 0011: The load resistance increases by 12%.
- 0100: The load resistance increases by 11%.
- 0101: The load resistance increases by 10%.
- 0110: The load resistance increases by 9%.
- 0111: The load resistance increases by 8%.
- 1000: The load resistance increases by 7%.
- 1001: The load resistance increases by 6%.
- 1010: The load resistance increases by 5%.
- 1011: The load resistance increases by 4%.
- 1100: The load resistance increases by 3%.
- 1101: The load resistance increases by 2%.
- 1110: The load resistance increases by 1%.
- 1111: The load resistance remains unchanged.";
            sw = rw; hw = r;
            reset = 0x1;
        } ADC_DAC_RL_MIS_SELN[31:28];
        field {
            name = "ADC_DAC_RL_MIS_SELP";
            desc = "ADC feedback DAC load resistance select control (positive end)
- 0000: The load resistance increases by 15%.
- 0001: The load resistance increases by 14%.
- 0010: The load resistance increases by 13%.
- 0011: The load resistance increases by 12%.
- 0100: The load resistance increases by 11%.
- 0101: The load resistance increases by 10%.
- 0110: The load resistance increases by 9%.
- 0111: The load resistance increases by 8%.
- 1000: The load resistance increases by 7%.
- 1001: The load resistance increases by 6%.
- 1010: The load resistance increases by 5%.
- 1011: The load resistance increases by 4%.
- 1100: The load resistance increases by 3%.
- 1101: The load resistance increases by 2%.
- 1110: The load resistance increases by 1%.
- 1111: The load resistance remains unchanged.";
            sw = rw; hw = r;
            reset = 0x1;
        } ADC_DAC_RL_MIS_SELP[27:24];
        field {
            name = "LPGA_BOOST";
            desc = "Left-channel ADC boost enable
- 0: disabled
- 1: enabled";
            sw = rw; hw = r;
            reset = 0x0;
        } LPGA_BOOST[23:23];
        field {
            name = "RPGA_BOOST";
            desc = "Right-channel ADC boost enable
- 0: disabled
- 1: enabled";
            sw = rw; hw = r;
            reset = 0x0;
        } RPGA_BOOST[22:22];
        field {
            name = "ADC_DAC_IB_SEL";
            desc = "Feedback DAC current adjustment in the ADC
- 00: Reference resistance R = 90% x Rf
- 01: Reference resistance R = 95% x Rf
- 10: Reference resistance R = 100% x Rf
- 11: Reference resistance R = 105% x Rf";
            sw = rw; hw = r;
            reset = 0x0;
        } ADC_DAC_IB_SEL[21:20];
        field {
            name = "reserved";
            desc = "Reserved";
            sw = rw; hw = r;
            reset = 0x0;
        } reserved_19_18[19:18];
        field {
            name = "RX_CTCM_PD";
            desc = "Power-on/off control of the uplink channel CTCM_BUFFER
- 0: The CTCM_BUFFER works normally.
- 1: The CTCM_BUFFER is powered off.";
            sw = rw; hw = r;
            reset = 0x1;
        } RX_CTCM_PD[17:17];
        field {
            name = "reserved";
            desc = "Reserved";
            sw = r; hw = na;
            reset = 0x0;
        } reserved_16_16[16:16];
        field {
            name = "reserved";
            desc = "Reserved";
            sw = r; hw = na;
            reset = 0x0;
        } reserved_15_15[15:15];
        field {
            name = "PGA_RIN_MAN_EN";
            desc = "Enable signal for manually controlling the input resistance to float or connect to the common-mode voltage for the unselected channels of the LINEIN module
- 0: The manual control mode is disabled.
- 1: The manual control module is enabled.";
            sw = rw; hw = r;
            reset = 0x0;
        } PGA_RIN_MAN_EN[14:14];
        field {
            name = "PGA_RIN_MAN_FLOAT";
            desc = "When PGA_RIN_MAN_EN is high, this register is valid. It enables the pull-down I/O resistance of the six channels of the LINEIN module to float or connect to the common- mode voltage.
- 0: The common-mode voltage is connected.
- 1: The pull-down I/O resistance is floated.";
            sw = rw; hw = r;
            reset = 0x0;
        } PGA_RIN_MAN_FLOAT[13:8];
        field {
            name = "CTRL_MCLK_PH";
            desc = "IP working clock edge select
- 0: falling edge of the master clock
- 1: rising edge of the master clock";
            sw = rw; hw = r;
            reset = 0x0;
        } CTRL_MCLK_PH[7:7];
        field {
            name = "CTRL_CLK_ADCDAC_PH";
            desc = "Working clock edge select for the feedback DAC in the ADC
- 0: rising edge of the master clock of the feedback DAC
- 1: falling edge of the master clock of the";
            sw = rw; hw = r;
            reset = 0x0;
        } CTRL_CLK_ADCDAC_PH[6:6];
        field {
            name = "reserved";
            desc = "Reserved";
            sw = r; hw = na;
            reset = 0x0;
        } reserved_5_4[5:4];
        field {
            name = "IBADJ_ADC";
            desc = "ADC bias current
- 00: 3 µA
- 01: 5 µA (recommended)
- 10: 7 µA
- 11: 10 µA";
            sw = rw; hw = r;
            reset = 0x1;
        } IBADJ_ADC[3:2];
        field {
            name = "SEL_CLK_CHOP_CTCM";
            desc = "CTCM buffer chopper clock frequency select
- 0: 96 kHz
- 1: 192 kHz";
            sw = rw; hw = r;
            reset = 0x0;
        } SEL_CLK_CHOP_CTCM[1:1];
        field {
            name = "BYP_CHOP_CTCM";
            desc = "CTCM buffer chopper enable
- 0: enabled
- 1: disabled";
            sw = rw; hw = r;
            reset = 0x0;
        } BYP_CHOP_CTCM[0:0];
    } AUDIO_ANA_CTRL_1 @ 0x18;
    reg {
        name = "AUDIO_ANA_CTRL_2";
        desc = "AUDIO_ANA_CTRL_2 corresponds to AudioCodec analog registers 8–11. AUDIO_ANA_CTRL_2 (offset 0x001c, total reset 0x40C0_0013; PROVEN: Hi3516D V300 data sheet, PDF page 801, section 11.2.4).";
        field {
            name = "reserved";
            desc = "Reserved";
            sw = r; hw = na;
            reset = 0x0;
        } reserved_31_31[31:31];
        field {
            name = "PD_CTCM";
            desc = "Power-on/off control for the downstream CTCM
- 0: The downstream CTCM works properly.
- 1: The downstream CTCM is powered off.";
            sw = rw; hw = r;
            reset = 0x1;
        } PD_CTCM[30:30];
        field {
            name = "MICBIAS2_ADJ";
            desc = "MICBIAS2 output voltage select
- 000: 2.1 V
- 001: 2.2 V
- 010: 2.3 V
- 011: 2.4 V …
- 110: 2.7 V
- 111: 2.8 V";
            sw = rw; hw = r;
            reset = 0x0;
        } MICBIAS2_ADJ[29:27];
        field {
            name = "MICBIAS1_ADJ";
            desc = "MICBIAS1 output voltage select
- 000: 2.1 V
- 001: 2.2 V
- 010: 2.3 V";
            sw = rw; hw = r;
            reset = 0x0;
        } MICBIAS1_ADJ[26:24];
        field {
            name = "RST";
            desc = "Analog global reset signal of the codec
- 0: normal working
- 1: reset";
            sw = rw; hw = r;
            reset = 0x1;
        } RST[23:23];
        field {
            name = "VREF_SEL";
            desc = "VREF startup time control
- 00000: 0.38s …
- 00100: 1.543s …
- 11111: 10.7s";
            sw = rw; hw = r;
            reset = 0x10;
        } VREF_SEL[22:18];
        field {
            name = "VREF_FS";
            desc = "VREF power-on speed control
- 0: The VREF is powered on at a normal speed.
- 1: The VREF is powered on quickly.";
            sw = rw; hw = r;
            reset = 0x0;
        } VREF_FS[17:17];
        field {
            name = "reserved";
            desc = "Reserved";
            sw = r; hw = na;
            reset = 0x0;
        } reserved_16_16[16:16];
        field {
            name = "BYP_CHOPPER_LINEIN";
            desc = "Input PGA chopper enable
- 0: enabled
- 1: disabled";
            sw = rw; hw = r;
            reset = 0x0;
        } BYP_CHOPPER_LINEIN[15:15];
        field {
            name = "BYP_CHOPPER_ADC";
            desc = "Chopper enable for the ADC integrator operational amplifier
- 0: enabled
- 1: disabled";
            sw = rw; hw = r;
            reset = 0x0;
        } BYP_CHOPPER_ADC[14:14];
        field {
            name = "BYP_CHOP_CTCM_RX";
            desc = "Upstream CTCM chopper enable
- 0: enabled
- 1: disabled";
            sw = rw; hw = r;
            reset = 0x0;
        } BYP_CHOP_CTCM_RX[13:13];
        field {
            name = "reserved";
            desc = "Reserved";
            sw = rw; hw = r;
            reset = 0x0;
        } reserved_12_8[12:8];
        field {
            name = "ADCL_MODE_SEL";
            desc = "ADCL mode select
- 0: 6.144 MHz sampling rate
- 1: 4.096 MHz sampling rate";
            sw = rw; hw = r;
            reset = 0x0;
        } ADCL_MODE_SEL[7:7];
        field {
            name = "ADCR_MODE_SEL";
            desc = "ADCR mode select
- 0: 6.144 MHz sampling rate
- 1: 4.096 MHz sampling rate";
            sw = rw; hw = r;
            reset = 0x0;
        } ADCR_MODE_SEL[6:6];
        field {
            name = "ADC_VREF";
            desc = "Flash ADC reference voltage select for the ADC module
- 00: 0.5333 V";
            sw = rw; hw = r;
            reset = 0x1;
        } ADC_VREF[5:4];
        field {
            name = "LDO_SEL";
            desc = "LDO output voltage select
- 00: 1.0 V
- 01: 0.95 V
- 10: 0.9 V (recommended)
- 11: 0.85 V";
            sw = rw; hw = r;
            reset = 0x0;
        } LDO_SEL[3:2];
        field {
            name = "LDO_EN_BK";
            desc = "Backup reference voltage generation circuit (direct power voltage divider) enable for the LDO module
- 0: disabled
- 1: enabled";
            sw = rw; hw = r;
            reset = 0x1;
        } LDO_EN_BK[1:1];
        field {
            name = "LDO_PD";
            desc = "LDO power-on/off control
- 0: The LDO module works normally.
- 1: The LDO module is powered off.";
            sw = rw; hw = r;
            reset = 0x1;
        } LDO_PD[0:0];
    } AUDIO_ANA_CTRL_2 @ 0x1c;
    reg {
        name = "AUDIO_ANA_CTRL_3";
        desc = "AUDIO_ANA_CTRL_3 corresponds to AudioCodec analog registers 12–15. AUDIO_ANA_CTRL_3 (offset 0x0020, total reset 0x1111_FE00; PROVEN: Hi3516D V300 data sheet, PDF page 803, section 11.2.4).";
        field {
            name = "RPGA_SEL_09";
            desc = "Right-channel input PGA channel select
- 000: MIC differential input
- 001: MIC_R input
- 010: MIC_L input
- 011: LINEIN_R input
- 100: LINEIN_L input
- 101: LINEIN differential input

Other values: reserved";
            sw = rw; hw = r;
            reset = 0x0;
        } RPGA_SEL_09[31:29];
        field {
            name = "RPGA_GAIN_09";
            desc = "Right-channel input PGA gain select
- 00000: 0 dB
- 00001: 2 dB
- 00010: 4 dB
- 00011: 6 dB
- 00100: 8 dB
- 00101: 10 dB";
            sw = rw; hw = r;
            reset = 0x11;
        } RPGA_GAIN_09[28:24];
        field {
            name = "LPGA_SEL_09";
            desc = "Left-channel input PGA channel select
- 000: MIC differential input
- 001: MIC_L input
- 010: MIC_R input
- 011: LINEIN_R input
- 100: LINEIN_L input
- 101: LINEIN differential input

Other values: reserved";
            sw = rw; hw = r;
            reset = 0x0;
        } LPGA_SEL_09[23:21];
        field {
            name = "LPGA_GAIN_09";
            desc = "Left-channel input PGA gain select
- 00000: 0 dB
- 00001: 2 dB
- 00010: 4 dB
- 00011: 6 dB
- 00100: 8 dB
- 00101: 10 dB
- 00110: 12 dB
- 00111: 14 dB
- 01000: 16 dB
- 01001: 18 dB
- 01010: 20 dB
- 01011: 22 dB
- 01100: 24 dB
- 01101: 26 dB
- 01110: 28 dB
- 01111: 30 dB
- 10000: –1.6 dB

Other values: reserved";
            sw = rw; hw = r;
            reset = 0x11;
        } LPGA_GAIN_09[20:16];
        field {
            name = "ADCL_PD_09";
            desc = "Power-on/off control for the left-channel ADC
- 0: The left-channel ADC works normally.
- 1: The left-channel ADC is powered off.";
            sw = rw; hw = r;
            reset = 0x1;
        } ADCL_PD_09[15:15];
        field {
            name = "ADCR_PD_09";
            desc = "Power-on/off control for the right-channel ADC
- 0: The right-channel ADC works normally.
- 1: The right-channel ADC is powered off.";
            sw = rw; hw = r;
            reset = 0x1;
        } ADCR_PD_09[14:14];
        field {
            name = "LPGA_PD_09";
            desc = "Power-on/off control for the left-channel input PGA
- 0: The left-channel input PGA works normally.
- 1: The left-channel input PGA is powered off.";
            sw = rw; hw = r;
            reset = 0x1;
        } LPGA_PD_09[13:13];
        field {
            name = "RPGA_PD_09";
            desc = "Power-on/off control for the right-channel input PGA
- 0: The right-channel input PGA works normally.
- 1: The right-channel input PGA is powered off.";
            sw = rw; hw = r;
            reset = 0x1;
        } RPGA_PD_09[12:12];
        field {
            name = "PD_ADC_TUNE_09";
            desc = "Power-on/off control of the ADC RC tune module
- 0: The RC tune module works normally.
- 1: The RC tune module is powered off.";
            sw = rw; hw = r;
            reset = 0x1;
        } PD_ADC_TUNE_09[11:11];
        field {
            name = "LPGA_MUTE_09";
            desc = "Mute control for the left-channel input PGA
- 0: The left-channel input PGA works normally.
- 1: The left-channel input PGA is muted.";
            sw = rw; hw = r;
            reset = 0x1;
        } LPGA_MUTE_09[10:10];
        field {
            name = "RPGA_MUTE_09";
            desc = "Mute control for the right-channel input PGA
- 0: The right-channel input PGA works normally.
- 1: The right-channel input PGA is muted.";
            sw = rw; hw = r;
            reset = 0x1;
        } RPGA_MUTE_09[9:9];
        field {
            name = "reserved";
            desc = "Reserved";
            sw = r; hw = na;
            reset = 0x0;
        } reserved_8_8[8:8];
        field {
            name = "VREF_EXMODE";
            desc = "This bit takes effect when PD_VREF is set to 1.
- 0: Power-down (PD) is normal.
- 1: The external VREF is supported.";
            sw = rw; hw = r;
            reset = 0x0;
        } VREF_EXMODE[7:7];
        field {
            name = "POP_RAMPCLK_SEL";
            desc = "Working clock of the popramp circuit
- 00: 48 kHz
- 01: 24 kHz
- 10: 12 kHz";
            sw = rw; hw = r;
            reset = 0x0;
        } POP_RAMPCLK_SEL[6:5];
        field {
            name = "POP_RES_SEL";
            desc = "Resistance between the popfree circuit and main output
- 00: 100 ohms
- 01: 1 kohm
- 10: 10 kohms
- 11: 100 kohms";
            sw = rw; hw = r;
            reset = 0x0;
        } POP_RES_SEL[4:3];
        field {
            name = "DACL_POP_DIRECT";
            desc = "Ramp direction of the left-channel DAC POP circuit
- 0: The POP circuit connects to the GND through a pull-down resistor.
- 1: The POP circuit connects to the VCM through a pull-up resistor.";
            sw = rw; hw = r;
            reset = 0x0;
        } DACL_POP_DIRECT[2:2];
        field {
            name = "reserved";
            desc = "Reserved";
            sw = r; hw = na;
            reset = 0x0;
        } reserved_1_1[1:1];
        field {
            name = "DACR_POP_DIRECT";
            desc = "Ramp direction of the right-channel DAC POP circuit
- 0: The POP circuit connects to the GND through a pull-down resistor.
- 1: The POP circuit connects to the VCM through a pull-up resistor.";
            sw = rw; hw = r;
            reset = 0x0;
        } DACR_POP_DIRECT[0:0];
    } AUDIO_ANA_CTRL_3 @ 0x20;
    reg {
        name = "AUDIO_ANA_CTRL_4";
        desc = "AUDIO_ANA_CTRL_4 corresponds to AudioCodec analog registers 16–19. AUDIO_ANA_CTRL_4 (offset 0x0024, total reset 0x0000_105C; PROVEN: Hi3516D V300 data sheet, PDF page 806, section 11.2.4).";
        field {
            name = "reserved";
            desc = "Reserved";
            sw = r; hw = na;
            reset = 0x0;
        } reserved_31_16[31:16];
        field {
            name = "ADC_TUNE_09";
            desc = "Control code of the integral capacitance in the ADC. The code value is related to the corner of R and C.
- 0101: Both R and C values are tt corner.
- 1100: Both R and C values are ff corner.
- 0000: Both R and C values are ss corner.

Other values: reserved";
            sw = rw; hw = r;
            reset = 0x1;
        } ADC_TUNE_09[15:12];
        field {
            name = "ADC_TUNE_EN_09";
            desc = "ADC RC coefficient correction circuit working enable
- 0: The RC correction module is disabled.
- 1: The RC correction module starts to work.";
            sw = rw; hw = r;
            reset = 0x0;
        } ADC_TUNE_EN_09[11:11];
        field {
            name = "ADC_TUNE_SEL_09";
            desc = "ADC RC coefficient correction code source control
- 0: input from the register
- 1: output of the RC coefficient correction circuit";
            sw = rw; hw = r;
            reset = 0x0;
        } ADC_TUNE_SEL_09[10:10];
        field {
            name = "CTRL_CLK_ADC_PH_09";
            desc = "ADC working clock edge select (master clock frequency divided by 2)
- 0: rising edge
- 1: falling edge";
            sw = rw; hw = r;
            reset = 0x0;
        } CTRL_CLK_ADC_PH_09[9:9];
        field {
            name = "reserved";
            desc = "Reserved";
            sw = r; hw = na;
            reset = 0x0;
        } reserved_8_8[8:8];
        field {
            name = "PGA_CHOP_CLK_SEL_09";
            desc = "Chop clock frequency select for the LINEIN module
- 00: 48 kHz
- 01: 96 kHz
- 10: 192 kHz
- 11: 384 kHz";
            sw = rw; hw = r;
            reset = 0x1;
        } PGA_CHOP_CLK_SEL_09[7:6];
        field {
            name = "ADC_CHOP_CLK_SEL_09";
            desc = "Chop clock frequency select for the ADC module
- 00: 48 kHz
- 01: 96 kHz
- 10: 192 kHz
- 11: 384 kHz";
            sw = rw; hw = r;
            reset = 0x1;
        } ADC_CHOP_CLK_SEL_09[5:4];
        field {
            name = "ADC_CHOP_CLK_PHSEL_09";
            desc = "Chop clock phase select for the ADC module
- 0: same phase as the ADC working clock
- 1: reverse phase of the ADC working clock";
            sw = rw; hw = r;
            reset = 0x1;
        } ADC_CHOP_CLK_PHSEL_09[3:3];
        field {
            name = "ADC_THE_CLK_PHSEL_09";
            desc = "Thermometer code output phase select for the ADC module
- 0: same phase as the ADC working clock
- 1: reverse phase of the ADC working clock";
            sw = rw; hw = r;
            reset = 0x1;
        } ADC_THE_CLK_PHSEL_09[2:2];
        field {
            name = "ADC_BIN_CLK_PHSEL_09";
            desc = "Binary code output phase select for the ADC module
- 0: same phase as the ADC working clock
- 1: reverse phase of the ADC working clock";
            sw = rw; hw = r;
            reset = 0x0;
        } ADC_BIN_CLK_PHSEL_09[1:1];
        field {
            name = "ADC_DWA_BPS_09";
            desc = "ADC DWA module enable
- 0: enabled
- 1: disabled";
            sw = rw; hw = r;
            reset = 0x0;
        } ADC_DWA_BPS_09[0:0];
    } AUDIO_ANA_CTRL_4 @ 0x24;
    reg {
        name = "AUDIO_CTRL_REG_1";
        desc = "AUDIO_CTRL_REG_1 is AudioCodec control register 1. AUDIO_CTRL_REG_1 (offset 0x0030, total reset 0x00F3_5A4A; PROVEN: Hi3516D V300 data sheet, PDF page 808, section 11.2.4).";
        field {
            name = "dacl_rst_n";
            desc = "DACL reset
- 0: The reset is valid.
- 1: The reset is invalid.";
            sw = rw; hw = r;
            reset = 0x0;
        } dacl_rst_n[31:31];
        field {
            name = "dacr_rst_n";
            desc = "DACR reset
- 0: The reset is valid.
- 1: The reset is invalid.";
            sw = rw; hw = r;
            reset = 0x0;
        } dacr_rst_n[30:30];
        field {
            name = "adcl_rst_n";
            desc = "ADCL reset
- 0: The reset is valid.
- 1: The reset is invalid.";
            sw = rw; hw = r;
            reset = 0x0;
        } adcl_rst_n[29:29];
        field {
            name = "adcr_rst_n";
            desc = "ADCR reset
- 0: The reset is valid.
- 1: The reset is invalid.";
            sw = rw; hw = r;
            reset = 0x0;
        } adcr_rst_n[28:28];
        field {
            name = "dacl_en";
            desc = "DACL enable
- 0: disabled
- 1: enabled";
            sw = rw; hw = r;
            reset = 0x0;
        } dacl_en[27:27];
        field {
            name = "dacr_en";
            desc = "DACR enable
- 0: disabled
- 1: enabled";
            sw = rw; hw = r;
            reset = 0x0;
        } dacr_en[26:26];
        field {
            name = "adcl_en";
            desc = "ADCL enable
- 0: disabled
- 1: enabled";
            sw = rw; hw = r;
            reset = 0x0;
        } adcl_en[25:25];
        field {
            name = "adcr_en";
            desc = "ADCR enable
- 0: disabled
- 1: enabled";
            sw = rw; hw = r;
            reset = 0x0;
        } adcr_en[24:24];
        field {
            name = "i2s1_data_bits";
            desc = "Data interface width of I2S channel 1
- 00: 16 bits
- 01: 18 bits
- 10: 20 bits
- 11: 24 bits";
            sw = rw; hw = r;
            reset = 0x3;
        } i2s1_data_bits[23:22];
        field {
            name = "i2s2_data_bits";
            desc = "Data interface width of I2S channel 2
- 00: 16 bits
- 01: 18 bits
- 10: 20 bits";
            sw = rw; hw = r;
            reset = 0x3;
        } i2s2_data_bits[21:20];
        field {
            name = "dig_bypass";
            desc = "Digital part bypass control, which is used for the analog test
- 0: The digital part works properly.
- 1: The digital part is bypassed.";
            sw = rw; hw = r;
            reset = 0x0;
        } dig_bypass[19:19];
        field {
            name = "dig_loop";
            desc = "Digital loopback control
- 0: invalid
- 1: valid";
            sw = rw; hw = r;
            reset = 0x0;
        } dig_loop[18:18];
        field {
            name = "i2s1_fs_sel";
            desc = "Sampling rate of I2S channel 1
- 11000: mclk/512/2, which is selected when

MCLK is set to 1024 FS
- 11001: mclk/256/2, which is selected when

MCLK is set to 512 FS
- 11010: mclk/128/2, which is selected when

MCLK is set to 256 FS
- 11011: mclk/64/2, which is selected when

MCLK is set to 128 FS 111xx: mclk/32/2, which is selected when MCLK is set to 64 FS";
            sw = rw; hw = r;
            reset = 0x1a;
        } i2s1_fs_sel[17:13];
        field {
            name = "i2s2_fs_sel";
            desc = "Sampling rate of I2S channel 2
- 11000: mclk/512/2, which is selected when

MCLK is set to 1024 FS
- 11001: mclk/256/2, which is selected when

MCLK is set to 512 FS
- 11010: mclk/128/2, which is selected when

MCLK is set to 256 FS
- 11011: mclk/64/2, which is selected when

MCLK is set to 128 FS 111xx: mclk/32/2, which is selected when MCLK is set to 64 FS";
            sw = rw; hw = r;
            reset = 0x1a;
        } i2s2_fs_sel[12:8];
        field {
            name = "reserved";
            desc = "Reserved";
            sw = r; hw = na;
            reset = 0x4a;
        } reserved_7_0[7:0];
    } AUDIO_CTRL_REG_1 @ 0x30;
    reg {
        name = "AUDIO_DAC_REG_0";
        desc = "AUDIO_DAC_REG_0 is AudioCodec control register 2. AUDIO_DAC_REG_0 (offset 0x0034, total reset 0x0000_0001; PROVEN: Hi3516D V300 data sheet, PDF page 809, section 11.2.4).";
        field {
            name = "reserved";
            desc = "Reserved";
            sw = r; hw = na;
            reset = 0x0;
        } reserved_31_1[31:1];
        field {
            name = "32-bytealignmentenablefortheAXI0buswriteoperationaxi0_aline32_en0:Thealignmentoperationisnotperformed.0:Thealignmentoperationisperformed.";
            desc = "";
            sw = rw; hw = r;
            reset = 0x0;
        } r_32_bytealignmentenablefortheAXI0buswriteoperationaxi0_aline32_en0_Thealignmentoperationisnotperformed_0_Thealignmentoperationisperformed[0:0];
    } AUDIO_DAC_REG_0 @ 0x34;
    reg {
        name = "AUDIO_DAC_REG_1";
        desc = "AUDIO_DAC_REG_1 is AudioCodec control register 3. AUDIO_DAC_REG_1 (offset 0x0038, total reset 0x0606_2424; PROVEN: Hi3516D V300 data sheet, PDF page 810, section 11.2.4).";
        field {
            name = "dacl_mute";
            desc = "DACL digital mute control
- 0: The DACL works normally.
- 1: The DACL is muted.";
            sw = rw; hw = r;
            reset = 0x0;
        } dacl_mute[31:31];
        field {
            name = "dacl_vol";
            desc = "DACL digital volume control, which is not recommended. You are advised to use the digital volume adjustment function in the AIAO to control the digital volume output. The volume is calculated as follows: (6 − dacl_vol) dB When dacl_vol is 0x7F, the DACL is muted.
- 0x00: 6 dB
- 0x01: 5 dB
- 0x02: 4 dB …
- 0x7E: –120 dB
- 0x7F: muted";
            sw = rw; hw = r;
            reset = 0x6;
        } dacl_vol[30:24];
        field {
            name = "dacr_mute";
            desc = "DACR digital mute control
- 0: The DACR works normally.
- 1: The DACR is muted.";
            sw = rw; hw = r;
            reset = 0x0;
        } dacr_mute[23:23];
        field {
            name = "dacr_vol";
            desc = "DACR digital volume control, which is not recommended. You are advised to use the digital volume adjustment function in the AIAO to control the digital volume output. The volume is calculated as follows: (6 − dacr_vol x 1) dB When dacr_vol is 0x7F, the DACR is muted.
- 0x00: 6 dB
- 0x01: 5 dB
- 0x02: 4 dB …";
            sw = rw; hw = r;
            reset = 0x6;
        } dacr_vol[22:16];
        field {
            name = "dacr2dacl_en";
            desc = "DACR-to-DACL mixer enable
- 0: disabled
- 1: enabled";
            sw = rw; hw = r;
            reset = 0x0;
        } dacr2dacl_en[15:15];
        field {
            name = "dacr2dacl_vol";
            desc = "DACR-to-DACL volume control The volume is calculated as follows: (36 − dacr2dacl_vol) dB
- 00: 36 dB
- 01: 35 dB
- 02: 34 dB … 7E: –90 dB 7F: –91 dB";
            sw = rw; hw = r;
            reset = 0x24;
        } dacr2dacl_vol[14:8];
        field {
            name = "dacl2dacr_en";
            desc = "DACL-to-DACR mixer enable
- 0: disabled
- 1: enabled";
            sw = rw; hw = r;
            reset = 0x0;
        } dacl2dacr_en[7:7];
        field {
            name = "dacl2dacr_vol";
            desc = "DACL-to-DACR volume control The volume is calculated as follows: (36 − dacl2dacr_vol) dB
- 00: 36 dB
- 01: 35 dB
- 02: 34 dB … 7E: –90 dB 7F: –91 dB";
            sw = rw; hw = r;
            reset = 0x24;
        } dacl2dacr_vol[6:0];
    } AUDIO_DAC_REG_1 @ 0x38;
    reg {
        name = "AUDIO_ADC_REG_0";
        desc = "AUDIO_ADC_REG_0 is AudioCodec control register 4. AUDIO_ADC_REG_0 (offset 0x003c, total reset 0x1E1E_0001; PROVEN: Hi3516D V300 data sheet, PDF page 811, section 11.2.4).";
        field {
            name = "adcl_mute";
            desc = "ADCL digital mute control
- 0: unmuted
- 1: muted";
            sw = rw; hw = r;
            reset = 0x0;
        } adcl_mute[31:31];
        field {
            name = "adcl_vol";
            desc = "ADCL volume control bit, which is not recommended. You are advised to use codec ADC analog volume adjustment to control the";
            sw = rw; hw = r;
            reset = 0x1e;
        } adcl_vol[30:24];
        field {
            name = "adcr_mute";
            desc = "ADCR digital mute control
- 0: unmuted
- 1: muted";
            sw = rw; hw = r;
            reset = 0x0;
        } adcr_mute[23:23];
        field {
            name = "adcr_vol";
            desc = "ADCR volume control bit, which is not recommended. You are advised to use codec ADC analog volume adjustment to control the input volume. The volume is calculated as follows: (30 − adcr_vol) dB
- 00: 36 dB
- 01: 35 dB
- 02: 34 dB … 7E: –90 dB 7F: –91 dB";
            sw = rw; hw = r;
            reset = 0x1e;
        } adcr_vol[22:16];
        field {
            name = "adcl_hpf_en";
            desc = "ADCL high-pass filter enable
- 0: disabled
- 1: enabled";
            sw = rw; hw = r;
            reset = 0x0;
        } adcl_hpf_en[15:15];
        field {
            name = "adcr_hpf_en";
            desc = "ADCR high-pass filter enable
- 0: disabled
- 1: enabled";
            sw = rw; hw = r;
            reset = 0x0;
        } adcr_hpf_en[14:14];
        field {
            name = "reserved";
            desc = "Reserved";
            sw = rw; hw = r;
            reset = 0x0;
        } reserved_13_4[13:4];
        field {
            name = "adcl_i2ssel";
            desc = "ADCL I2S interface select (high priority)
- 0: I2S1
- 1: I2S2";
            sw = rw; hw = r;
            reset = 0x0;
        } adcl_i2ssel[3:3];
        field {
            name = "adcl_lrsel";
            desc = "ADCL channel data select
- 0: audio-left channel
- 1: audio-right channel";
            sw = rw; hw = r;
            reset = 0x0;
        } adcl_lrsel[2:2];
        field {
            name = "adcr_i2ssel";
            desc = "ADCR I2S interface select (low priority).
- 0: I2S1";
            sw = rw; hw = r;
            reset = 0x0;
        } adcr_i2ssel[1:1];
        field {
            name = "adcr_lrsel";
            desc = "ADCR channel data select
- 0: audio-left channel
- 1: audio-right channel";
            sw = rw; hw = r;
            reset = 0x1;
        } adcr_lrsel[0:0];
    } AUDIO_ADC_REG_0 @ 0x3c;
    reg {
        name = "ACODEC_REG18";
        desc = "ACODEC_REG18 is the I2S channel select control register, which does not support the soft reset. ACODEC_REG18 (offset 0x0048, total reset 0x0000_0008; PROVEN: Hi3516D V300 data sheet, PDF page 813, section 11.2.4).";
        field {
            name = "reserved";
            desc = "Reserved";
            sw = r; hw = na;
            reset = 0x0;
        } reserved_31_5[31:5];
        field {
            name = "audio_rx_bclk_sel";
            desc = "AudioCodec RX BCLK and WS source select
- 0: CRG0 clock
- 1: CRG8 clock. This mode is recommended.

In this mode, the audio TX and RX share the same clock, and the AIAO can perform digital loopback.";
            sw = rw; hw = r;
            reset = 0x0;
        } audio_rx_bclk_sel[4:4];
        field {
            name = "i2s_pad_mclk_sel";
            desc = "mclk select for the I2S interface
- 0: aiao_i2s_rx_mclk
- 1: aiao_i2s_tx_mclk";
            sw = rw; hw = r;
            reset = 0x1;
        } i2s_pad_mclk_sel[3:3];
        field {
            name = "audio_mclk_sel";
            desc = "mclk select for the AudioCodec
- 0: aiao_i2s_rx_mclk
- 1: aiao_i2s_tx_mclk";
            sw = rw; hw = r;
            reset = 0x0;
        } audio_mclk_sel[2:2];
        field {
            name = "i2s_pad_enable";
            desc = "Enable for the channel between the chip I2S interface and AIAO
- 0: The channel between the chip I2S interface and AIAO is disabled, and the chip I2S interface has no output.
- 1: The channel between the I2S interface of the chip and AIAO is enabled, and the chip I2S interface connects to the I2S interface of the

AIAO. Note: i2s_pad_enable and audio_enable cannot be 1 at the same time.";
            sw = rw; hw = r;
            reset = 0x0;
        } i2s_pad_enable[1:1];
        field {
            name = "audio_enable";
            desc = "Enable for the channel between the I2S interface of the internal AudioCodec and AIAO
- 0: The channel between the I2S interface of the internal AudioCodec and AIAO is disabled, and the I2S interface of the internal";
            sw = rw; hw = r;
            reset = 0x0;
        } audio_enable[0:0];
    } ACODEC_REG18 @ 0x48;
};

`endif
