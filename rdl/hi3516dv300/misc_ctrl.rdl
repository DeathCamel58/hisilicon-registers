`ifndef EHI3516DV300_MISC_CTRL_RDL
`define EHI3516DV300_MISC_CTRL_RDL
regfile eHI3516DV300_MISC_CTRL {
    name = "MISC control registers";
    desc = "MISC control registers. 55 registers extracted programmatically from the Hi3516D V300 Professional Smart IP Camera SoC data sheet (Issue 01, 2019-09-12); chapter 3.5.5, table 3-8. Field names, bit ranges, access types and reset values are taken from the register tables; reset values are the data sheet total reset values split onto the fields (per-field values where the table has them). Label: PROVEN. Hardware not verified here (no board).";
    reg {
        name = "MISC_CTRL0";
        desc = "MISC_CTRL0 is MSIC function select register 0. MISC_CTRL0 (offset 0x0000, total reset 0x0000_2000; PROVEN: Hi3516D V300 data sheet, PDF page 155, section 3.5.5).";
        field {
            name = "reserved";
            desc = "Reserved";
            sw = r; hw = na;
            reset = 0x0;
        } reserved_31_20[31:20];
        field {
            name = "test_clk_sel";
            desc = "Test clock source select
- 0x0: pll_test_out[0]
- 0x1: pll_test_out[1]
- 0x2: pll_test_out[2]
- 0x3: pll_test_out[3]
- 0x4: clk_24m
- 0x5: audiocodec_mclk
- 0x6: usb_phy_clk
- 0x7: mipitx_phy_lanebyte_clk
- 0x8: hdmitx_phy_tmds_clk
- 0x9: rtc_clk_out

Other values: reserved";
            sw = rw; hw = r;
            reset = 0x0;
        } test_clk_sel[19:16];
        field {
            name = "reserved";
            desc = "Reserved";
            sw = r; hw = na;
            reset = 0x0;
        } reserved_15_15[15:15];
        field {
            name = "jtag_on_sdio";
            desc = "JTAG signal multiplexing to the SDIO0 interface
- 0: The JTAG signal is multiplexed to the

JTAG_* pin.
- 1: The JTAG signal is multiplexed to the

SDIO0_* pin.";
            sw = rw; hw = r;
            reset = 0x0;
        } jtag_on_sdio[14:14];
        field {
            name = "vgs_bootram_mode";
            desc = "Enable of multiplexing the RAM of the VGS module as the BootRAM. Set this bit to 1 if the BootRAM is required, and set it to 0 if the VGS function is used.
- 0: disabled
- 1: enabled";
            sw = rw; hw = r;
            reset = 0x1;
        } vgs_bootram_mode[13:13];
        field {
            name = "emmc_fix_bypass";
            desc = "Logic enable for fixing the bug that the eMMC controller card cannot be identified
- 0: enabled
- 1: disabled";
            sw = rw; hw = r;
            reset = 0x0;
        } emmc_fix_bypass[12:12];
        field {
            name = "sdio1_fix_bypass";
            desc = "Logic enable for fixing the bug that the SDIO1 controller card cannot be identified
- 0: enabled";
            sw = rw; hw = r;
            reset = 0x0;
        } sdio1_fix_bypass[11:11];
        field {
            name = "sdio1_pd_mux_bypass";
            desc = "Logic enable for fixing the bug that the SDIO1 controller card turns powered down
- 0: enabled
- 1: disabled";
            sw = rw; hw = r;
            reset = 0x0;
        } sdio1_pd_mux_bypass[10:10];
        field {
            name = "reserved";
            desc = "Reserved";
            sw = r; hw = na;
            reset = 0x0;
        } reserved_9_7[9:7];
        field {
            name = "sdio0_carddetect_pol";
            desc = "Polarity control for the SDIO0 card detection signal
- 0: active low
- 1: active high";
            sw = rw; hw = r;
            reset = 0x0;
        } sdio0_carddetect_pol[6:6];
        field {
            name = "spi2_cs_pctrl";
            desc = "Polarity control of SPI2 chip select (CS)
- 0: active low
- 1: active high";
            sw = rw; hw = r;
            reset = 0x0;
        } spi2_cs_pctrl[5:5];
        field {
            name = "spi1_cs1_pctrl";
            desc = "Polarity control of SPI1 CS1
- 0: active low
- 1: active high";
            sw = rw; hw = r;
            reset = 0x0;
        } spi1_cs1_pctrl[4:4];
        field {
            name = "spi1_cs0_pctrl";
            desc = "Polarity control of SPI1 CS0
- 0: active low
- 1: active high";
            sw = rw; hw = r;
            reset = 0x0;
        } spi1_cs0_pctrl[3:3];
        field {
            name = "ssp1_cs_sel";
            desc = "CS select for the SPI1 signal output
- 0: SPI1_CSN0
- 1: SPI1_CSN1";
            sw = rw; hw = r;
            reset = 0x0;
        } ssp1_cs_sel[2:2];
        field {
            name = "spi_3wire_cs_pctrl";
            desc = "Polarity control of 3-wire SPI CS
- 0: active low
- 1: active high";
            sw = rw; hw = r;
            reset = 0x0;
        } spi_3wire_cs_pctrl[1:1];
        field {
            name = "spi0_cs_pctrl";
            desc = "Polarity control of SPI0 CS
- 0: active low
- 1: active high";
            sw = rw; hw = r;
            reset = 0x0;
        } spi0_cs_pctrl[0:0];
    } MISC_CTRL0 @ 0x0;
    reg {
        name = "MISC_CTRL1";
        desc = "MISC_CTRL1 is MISC function selection register 1. MISC_CTRL1 (offset 0x0004, total reset 0x0000_0000; PROVEN: Hi3516D V300 data sheet, PDF page 156, section 3.5.5).";
        field {
            name = "reserved";
            desc = "Reserved";
            sw = r; hw = na;
            reset = 0x0;
        } reserved_31_3[31:3];
        field {
            name = "sdio0_pswitch_ctrl_s";
            desc = "Control select of the SDIO0 power switch";
            sw = rw; hw = r;
            reset = 0x0;
        } sdio0_pswitch_ctrl_s[2:2];
        field {
            name = "sdio0_pswitch_sel";
            desc = "Output voltage select of the SDIO0 power switch
- 0: 3.3 V
- 1: 1.8 V";
            sw = rw; hw = r;
            reset = 0x0;
        } sdio0_pswitch_sel[1:1];
        field {
            name = "sdio0_pswitch_en";
            desc = "SDIO0 power switch enable
- 0: disabled
- 1: enabled

The control is valid only when sdio0_pswitch_ctrl_sel is set to 1.";
            sw = rw; hw = r;
            reset = 0x0;
        } sdio0_pswitch_en[0:0];
    } MISC_CTRL1 @ 0x4;
    reg {
        name = "MISC_CTRL3";
        desc = "MISC_CTRL3 is CPU control register 1. MISC_CTRL3 (offset 0x000C, total reset 0x0000_0000; PROVEN: Hi3516D V300 data sheet, PDF page 157, section 3.5.5).";
        field {
            name = "reserved";
            desc = "Reserved";
            sw = r; hw = na;
            reset = 0x0;
        } reserved_31_7[31:7];
        field {
            name = "a7_smpnamp";
            desc = "Symmetric multiprocessing (SMP) mode or asymmetric multiprocessing (AMP) mode indictor of Cortex-A7 Core 0 or Core 1 a7_smpnamp[0] indicates Core 0, and a7_smpnamp[1] indicates Core 1.
- 0: AMP mode
- 1: SMP mode";
            sw = r; hw = w;
            reset = 0x0;
        } a7_smpnamp[6:5];
        field {
            name = "a7_standbywfi_l2";
            desc = "WFI low-power state indicator of Cortex-A7 L2
- 0: not in the WFI low-power state
- 1: in the WFI low-power state";
            sw = r; hw = w;
            reset = 0x0;
        } a7_standbywfi_l2[4:4];
        field {
            name = "a7_standbywfi";
            desc = "WFI low-power state indicator of Cortex-A7 Core 0 or Core 1 a7_standbywfi[0] indicates the WFI state of Core 0, and a7_standbywfi[1] indicates the WFI state of Core 1.
- 0: not in the WFI low-power state
- 1: in the WFI low-power state";
            sw = r; hw = w;
            reset = 0x0;
        } a7_standbywfi[3:2];
        field {
            name = "a7_standbywfe";
            desc = "WFE low-power state indicator of Cortex-A7 Core 0 or Core 1 a7_standbywfe[0] indicates the WFE state of Core 0, and a7_standbywfe[1] indicates the";
            sw = r; hw = w;
            reset = 0x0;
        } a7_standbywfe[1:0];
    } MISC_CTRL3 @ 0xc;
    reg {
        name = "MISC_CTRL4";
        desc = "MISC_CTRL4 is RAM retention control register 0. MISC_CTRL4 (offset 0x0010, total reset 0x0000_000D; PROVEN: Hi3516D V300 data sheet, PDF page 158, section 3.5.5).";
        field {
            name = "reserved";
            desc = "Reserved";
            sw = r; hw = na;
            reset = 0x0;
        } reserved_31_4[31:4];
        field {
            name = "gzip_ram_clk_gate_en_bypass";
            desc = "RAM automatic clock gating control of the GZIP module
- 0: enabled
- 1: disabled. The RAM clock in the GZIP is always enabled.";
            sw = rw; hw = r;
            reset = 0x1;
        } gzip_ram_clk_gate_en_bypass[3:3];
        field {
            name = "vedu_ret1n_bypass";
            desc = "Automatic RAM retention function control of the VEDU module
- 0: enabled
- 1: disabled";
            sw = rw; hw = r;
            reset = 0x1;
        } vedu_ret1n_bypass[2:2];
        field {
            name = "bootrom_pgen";
            desc = "BootROM power supply control
- 0: powered up
- 1: powered down. In this case, the BootROM cannot work.";
            sw = rw; hw = r;
            reset = 0x0;
        } bootrom_pgen[1:1];
        field {
            name = "spacc_ret1n";
            desc = "RAM retention control of SPACC
- 0: SPACC RAM is in retention state.
- 1: SPACC RAM is in active state.

When the SPACC controller is disabled, set this bit to 0 to save power consumption.";
            sw = rw; hw = r;
            reset = 0x1;
        } spacc_ret1n[0:0];
    } MISC_CTRL4 @ 0x10;
    reg {
        name = "MISC_CTRL6";
        desc = "MISC_CTRL6 is VICAP or VDP mode control register 1. MISC_CTRL6 (offset 0x0018, total reset 0x0000_0000; PROVEN: Hi3516D V300 data sheet, PDF page 158, section 3.5.5).";
        field {
            name = "reserved";
            desc = "Reserved";
            sw = r; hw = na;
            reset = 0x0;
        } reserved_31_12[31:12];
        field {
            name = "vo_pdata_reverse";
            desc = "Bit inversion enable for the VDP parallel output
- 0: disabled";
            sw = rw; hw = r;
            reset = 0x0;
        } vo_pdata_reverse[11:11];
        field {
            name = "vo_pdata_mode";
            desc = "Mode select for the VDP parallel output
- 000: Parallel 24 bits of LCD data
- 001: Parallel 18 bits of LCD data
- 010: Parallel 16 bits of LCD data
- 011: Serial 8 bits of LCD data
- 100: Serial 6 bits of LCD data
- 101: BT.1120 mode
- 110: BT.656 mode

Other values: reserved";
            sw = rw; hw = r;
            reset = 0x0;
        } vo_pdata_mode[10:8];
        field {
            name = "viproc_vpss_online_mode";
            desc = "Operating mode select of the VIPROC-VPSS data channel
- 0: offline mode
- 1: online mode";
            sw = rw; hw = r;
            reset = 0x0;
        } viproc_vpss_online_mode[7:7];
        field {
            name = "vicap_viproc_online_mode";
            desc = "Operating mode select of the VICAP-VIPROC data channel
- 0: offline mode
- 1: online mode";
            sw = rw; hw = r;
            reset = 0x0;
        } vicap_viproc_online_mode[6:6];
        field {
            name = "vi_port1_input_sel";
            desc = "Video source select of VICAP port 1
- 0: MIPI channel 1
- 1: CMOS input";
            sw = rw; hw = r;
            reset = 0x0;
        } vi_port1_input_sel[5:5];
        field {
            name = "reserved";
            desc = "Reserved";
            sw = r; hw = na;
            reset = 0x0;
        } reserved_4_4[4:4];
        field {
            name = "mipirx1_work_mode";
            desc = "Mode select of MIPI RX channel 1
- 0: MIPI mode
- 1: LVDS mode";
            sw = rw; hw = r;
            reset = 0x0;
        } mipirx1_work_mode[3:2];
        field {
            name = "mipirx0_work_mode";
            desc = "Mode select of MIPI RX channel 0
- 0: MIPI mode
- 1: LVDS mode";
            sw = rw; hw = r;
            reset = 0x0;
        } mipirx0_work_mode[1:0];
    } MISC_CTRL6 @ 0x18;
    reg {
        name = "MISC_CTRL8";
        desc = "MISC_CTRL8 is USB 2.0 control register 0. MISC_CTRL8 (offset 0x0020, total reset 0x0004_00DF; PROVEN: Hi3516D V300 data sheet, PDF page 159, section 3.5.5).";
        field {
            name = "reserved";
            desc = "Reserved";
            sw = r; hw = na;
            reset = 0x0;
        } reserved_31_19[31:19];
        field {
            name = "usb2_fladj_30mhz_r";
            desc = "Horizontal synchronization (HS) clock jitter";
            sw = rw; hw = r;
            reset = 0x20;
        } usb2_fladj_30mhz_r[18:13];
        field {
            name = "usb2_dbg_addr";
            desc = "USB debug address";
            sw = rw; hw = r;
            reset = 0x0;
        } usb2_dbg_addr[12:9];
        field {
            name = "usb2_hub_port_perm_attach";
            desc = "Device attaching mode of the USB port
- 0: The device attached to the USB port is removable.
- 1: The device attached to the USB port is irremovable.";
            sw = rw; hw = r;
            reset = 0x0;
        } usb2_hub_port_perm_attach[8:8];
        field {
            name = "usb2_port_ovrcur_pol";
            desc = "Overcurrent protection polarity control of the USB port
- 0: active low
- 1: active high";
            sw = rw; hw = r;
            reset = 0x1;
        } usb2_port_ovrcur_pol[7:7];
        field {
            name = "usb2_port_pwren_pol";
            desc = "Power enable polarity control of the USB port
- 0: active low
- 1: active high";
            sw = rw; hw = r;
            reset = 0x1;
        } usb2_port_pwren_pol[6:6];
        field {
            name = "usb2_port_ovrcur_ctrl_en";
            desc = "Overcurrent protection enable of the USB port
- 0: disabled
- 1: enabled";
            sw = rw; hw = r;
            reset = 0x0;
        } usb2_port_ovrcur_ctrl_en[5:5];
        field {
            name = "usb2_port_pwr_ctrl_en";
            desc = "USB power supply enable
- 0: disabled
- 1: enabled (output by the USB 2.0 controller)";
            sw = rw; hw = r;
            reset = 0x1;
        } usb2_port_pwr_ctrl_en[4:4];
        field {
            name = "usb2_bus_filter_bypass";
            desc = "USB 2.0 bus filter bypass. These bits must be set to 4'b1111.";
            sw = rw; hw = r;
            reset = 0xf;
        } usb2_bus_filter_bypass[3:0];
    } MISC_CTRL8 @ 0x20;
    reg {
        name = "MISC_CTRL10";
        desc = "MISC_CTRL10 is DDR_CA control register 0. MISC_CTRL10 (offset 0x0028, total reset 0x0000_0000; PROVEN: Hi3516D V300 data sheet, PDF page 160, section 3.5.5).";
        field {
            name = "ddrca_random_l";
            desc = "Bits 31:0 of the random value of the DDR CA function";
            sw = rw; hw = r;
            reset = 0x0;
        } ddrca_random_l[31:0];
    } MISC_CTRL10 @ 0x28;
    reg {
        name = "MISC_CTRL11";
        desc = "MISC_CTRL11 is DDR_CA control register 1. MISC_CTRL11 (offset 0x002C, total reset 0x0000_0000; PROVEN: Hi3516D V300 data sheet, PDF page 160, section 3.5.5).";
        field {
            name = "ddrca_random_h";
            desc = "Bits 63:32 of the random value of the DDR CA function";
            sw = rw; hw = r;
            reset = 0x0;
        } ddrca_random_h[31:0];
    } MISC_CTRL11 @ 0x2c;
    reg {
        name = "MISC_CTRL12";
        desc = "MISC_CTRL12 is DDR_CA control register 2. MISC_CTRL12 (offset 0x0030, total reset 0x0000_0005; PROVEN: Hi3516D V300 data sheet, PDF page 161, section 3.5.5).";
        field {
            name = "reserved";
            desc = "Reserved";
            sw = r; hw = na;
            reset = 0x0;
        } reserved_31_5[31:5];
        field {
            name = "ddrca_update";
            desc = "Load enable of the DDR scrambling function. When this register changes from 0 to 1, the ddrca_en and ddrca_random parameters are loaded to the DDR controller.";
            sw = rw; hw = r;
            reset = 0x0;
        } ddrca_update[4:4];
        field {
            name = "ddrca_en";
            desc = "Mode of the DDR scrambling function
- 0x0: The MDDRCA function is enabled.
- 0x1: The output data is all 0s.
- 0x3: The output data is all 1s.
- 0x5: The MDDRCA function is bypassed.
- 0xD: The output data is all 1s.

Other values: reserved";
            sw = rw; hw = r;
            reset = 0x5;
        } ddrca_en[3:0];
    } MISC_CTRL12 @ 0x30;
    reg {
        name = "MISC_CTRL14";
        desc = "MISC_CTRL14 is bus priority control register 0. MISC_CTRL14 (offset 0x0038, total reset 0x0000_0000; PROVEN: Hi3516D V300 data sheet, PDF page 161, section 3.5.5).";
        field {
            name = "syscfg_timeout_en_m2";
            desc = "Timeout count enable of the SYSCFG bus M2 port
- 0: disabled
- 1: enabled";
            sw = rw; hw = r;
            reset = 0x0;
        } syscfg_timeout_en_m2[31:31];
        field {
            name = "syscfg_timeout_value_m2";
            desc = "Timeout count value of the SYSCFG bus M2 port Count value = syscfg_timeout_value_m2 x 2";
            sw = rw; hw = r;
            reset = 0x0;
        } syscfg_timeout_value_m2[30:16];
        field {
            name = "syscfg_timeout_en_m1";
            desc = "Timeout count enable of the SYSCFG bus M1 port
- 0: disabled";
            sw = rw; hw = r;
            reset = 0x0;
        } syscfg_timeout_en_m1[15:15];
        field {
            name = "syscfg_timeout_value_m1";
            desc = "Timeout count value of the SYSCFG bus M1 port Count value = syscfg_timeout_value_m1 x 2";
            sw = rw; hw = r;
            reset = 0x0;
        } syscfg_timeout_value_m1[14:0];
    } MISC_CTRL14 @ 0x38;
    reg {
        name = "MISC_CTRL15";
        desc = "MISC_CTRL15 is bus priority control register 1. MISC_CTRL15 (offset 0x003C, total reset 0x0000_0000; PROVEN: Hi3516D V300 data sheet, PDF page 162, section 3.5.5).";
        field {
            name = "reserved";
            desc = "Reserved";
            sw = r; hw = na;
            reset = 0x0;
        } reserved_31_31[31:31];
        field {
            name = "syscfg_priority_s6";
            desc = "Bus access priority of the SYSCFG bus S6 port The value 7 indicates the highest priority.";
            sw = rw; hw = r;
            reset = 0x0;
        } syscfg_priority_s6[30:28];
        field {
            name = "reserved";
            desc = "Reserved";
            sw = r; hw = na;
            reset = 0x0;
        } reserved_27_27[27:27];
        field {
            name = "syscfg_priority_s5";
            desc = "Bus access priority of the SYSCFG bus S5 port The value 7 indicates the highest priority.";
            sw = rw; hw = r;
            reset = 0x0;
        } syscfg_priority_s5[26:24];
        field {
            name = "reserved";
            desc = "Reserved";
            sw = r; hw = na;
            reset = 0x0;
        } reserved_23_23[23:23];
        field {
            name = "syscfg_priority_s4";
            desc = "Bus access priority of the SYSCFG bus S4 port The value 7 indicates the highest priority.";
            sw = rw; hw = r;
            reset = 0x0;
        } syscfg_priority_s4[22:20];
        field {
            name = "reserved";
            desc = "Reserved";
            sw = r; hw = na;
            reset = 0x0;
        } reserved_19_19[19:19];
        field {
            name = "syscfg_priority_s3";
            desc = "Bus access priority of the SYSCFG bus S3 port The value 7 indicates the highest priority.";
            sw = rw; hw = r;
            reset = 0x0;
        } syscfg_priority_s3[18:16];
        field {
            name = "reserved";
            desc = "Reserved";
            sw = r; hw = na;
            reset = 0x0;
        } reserved_15_15[15:15];
        field {
            name = "syscfg_priority_s2";
            desc = "Bus access priority of the SYSCFG bus S2 port The value 7 indicates the highest priority.";
            sw = rw; hw = r;
            reset = 0x0;
        } syscfg_priority_s2[14:12];
        field {
            name = "reserved";
            desc = "Reserved";
            sw = r; hw = na;
            reset = 0x0;
        } reserved_11_11[11:11];
        field {
            name = "syscfg_priority_s1";
            desc = "Bus access priority of the SYSCFG bus S1 port The value 7 indicates the highest priority.";
            sw = rw; hw = r;
            reset = 0x0;
        } syscfg_priority_s1[10:8];
        field {
            name = "reserved";
            desc = "Reserved";
            sw = r; hw = na;
            reset = 0x0;
        } reserved_7_7[7:7];
        field {
            name = "syscfg_port1_pri_in";
            desc = "Priority of the SYSCFG bus M2 port The value 7 indicates the highest priority.";
            sw = rw; hw = r;
            reset = 0x0;
        } syscfg_port1_pri_in[6:4];
        field {
            name = "reserved";
            desc = "Reserved";
            sw = r; hw = na;
            reset = 0x0;
        } reserved_3_3[3:3];
        field {
            name = "syscfg_port0_pri_in";
            desc = "Priority of the SYSCFG bus M1 port The value 7 indicates the highest priority.";
            sw = rw; hw = r;
            reset = 0x0;
        } syscfg_port0_pri_in[2:0];
    } MISC_CTRL15 @ 0x3c;
    reg {
        name = "MISC_CTRL16";
        desc = "MISC_CTRL16 is bus priority control register 2. MISC_CTRL16 (offset 0x0040, total reset 0x0000_0000; PROVEN: Hi3516D V300 data sheet, PDF page 163, section 3.5.5).";
        field {
            name = "sysdata_timeout_en_m2";
            desc = "Timeout count enable of the SYSDATA bus M2 port
- 0: disabled
- 1: enabled";
            sw = rw; hw = r;
            reset = 0x0;
        } sysdata_timeout_en_m2[31:31];
        field {
            name = "sysdata_timeout_value_m2";
            desc = "Timeout count value of the SYSDATA bus M2 port Count value = sysdata_timeout_value_m2 x 2";
            sw = rw; hw = r;
            reset = 0x0;
        } sysdata_timeout_value_m2[30:16];
        field {
            name = "sysdata_timeout_en_m1";
            desc = "Timeout count enable of the SYSDATA bus M1 port
- 0: disabled
- 1: enabled";
            sw = rw; hw = r;
            reset = 0x0;
        } sysdata_timeout_en_m1[15:15];
        field {
            name = "sysdata_timeout_value_m1";
            desc = "Timeout count of the SYSDATA bus M1 port Count value = sysdata_timeout_value_m1 x 2";
            sw = rw; hw = r;
            reset = 0x0;
        } sysdata_timeout_value_m1[14:0];
    } MISC_CTRL16 @ 0x40;
    reg {
        name = "MISC_CTRL17";
        desc = "MISC_CTRL17 is bus priority control register 4. MISC_CTRL17 (offset 0x0044, total reset 0x0000_0000; PROVEN: Hi3516D V300 data sheet, PDF page 163, section 3.5.5).";
        field {
            name = "reserved";
            desc = "Reserved";
            sw = r; hw = na;
            reset = 0x0;
        } reserved_31_15[31:15];
        field {
            name = "sysdata_priority_s2";
            desc = "Bus access priority of the SYSDATA bus S2 port The value 1 indicates the highest priority.";
            sw = rw; hw = r;
            reset = 0x0;
        } sysdata_priority_s2[14:12];
        field {
            name = "reserved";
            desc = "Reserved";
            sw = r; hw = na;
            reset = 0x0;
        } reserved_11_11[11:11];
        field {
            name = "sysdata_priority_s1";
            desc = "Bus access priority of the SYSDATA bus S1 port The value 1 indicates the highest priority.";
            sw = rw; hw = r;
            reset = 0x0;
        } sysdata_priority_s1[10:8];
        field {
            name = "reserved";
            desc = "Reserved";
            sw = r; hw = na;
            reset = 0x0;
        } reserved_7_7[7:7];
        field {
            name = "sysdata_port1_pri_in";
            desc = "Priority of the SYSDATA bus M2 port The value 7 indicates the highest priority.";
            sw = rw; hw = r;
            reset = 0x0;
        } sysdata_port1_pri_in[6:4];
        field {
            name = "reserved";
            desc = "Reserved";
            sw = r; hw = na;
            reset = 0x0;
        } reserved_3_3[3:3];
        field {
            name = "sysdata_port0_pri_in";
            desc = "Priority of the SYSDATA bus M1 port The value 7 indicates the highest priority.";
            sw = rw; hw = r;
            reset = 0x0;
        } sysdata_port0_pri_in[2:0];
    } MISC_CTRL17 @ 0x44;
    reg {
        name = "MISC_CTRL18";
        desc = "MISC_CTRL18 is bus priority control register 5. MISC_CTRL18 (offset 0x0048, total reset 0x0000_0000; PROVEN: Hi3516D V300 data sheet, PDF page 164, section 3.5.5).";
        field {
            name = "ahb1_timeout_en_m2";
            desc = "Timeout count enable of the AHB1 bus M2 port
- 0: disabled
- 1: enabled";
            sw = rw; hw = r;
            reset = 0x0;
        } ahb1_timeout_en_m2[31:31];
        field {
            name = "ahb1_timeout_value_m2";
            desc = "Timeout count value of the AHB1 bus M2 port Count value = ahb1_timeout_value_m2 x 2";
            sw = rw; hw = r;
            reset = 0x0;
        } ahb1_timeout_value_m2[30:16];
        field {
            name = "ahb1_timeout_en_m1";
            desc = "Timeout count enable of the AHB1 bus M1 port
- 0: disabled
- 1: enabled";
            sw = rw; hw = r;
            reset = 0x0;
        } ahb1_timeout_en_m1[15:15];
        field {
            name = "ahb1_timeout_value_m1";
            desc = "Timeout count value of the AHB1 bus M1 port Count value = ahb1_timeout_value_m1 x 2";
            sw = rw; hw = r;
            reset = 0x0;
        } ahb1_timeout_value_m1[14:0];
    } MISC_CTRL18 @ 0x48;
    reg {
        name = "MISC_CTRL19";
        desc = "MISC_CTRL19 is bus priority control register 6. MISC_CTRL19 (offset 0x004C, total reset 0x0000_0000; PROVEN: Hi3516D V300 data sheet, PDF page 164, section 3.5.5).";
        field {
            name = "reserved";
            desc = "Timeout count enable of the AHB1 bus M2 port
- 0: disabled
- 1: enabled";
            sw = r; hw = na;
            reset = 0x0;
        } reserved_31_16[31:16];
        field {
            name = "ahb1_timeout_en_m3";
            desc = "Timeout count enable of the AHB1 bus M3 port
- 0: disabled
- 1: enabled";
            sw = rw; hw = r;
            reset = 0x0;
        } ahb1_timeout_en_m3[15:15];
        field {
            name = "ahb1_timeout_value_m3";
            desc = "Timeout count value of the AHB1 bus M3 port Count value = ahb1_timeout_value_m3 x 2";
            sw = rw; hw = r;
            reset = 0x0;
        } ahb1_timeout_value_m3[14:0];
    } MISC_CTRL19 @ 0x4c;
    reg {
        name = "MISC_CTRL20";
        desc = "MISC_CTRL20 is bus priority control register 7. MISC_CTRL20 (offset 0x0050, total reset 0x0000_0234; PROVEN: Hi3516D V300 data sheet, PDF page 165, section 3.5.5).";
        field {
            name = "reserved";
            desc = "Reserved";
            sw = r; hw = na;
            reset = 0x0;
        } reserved_31_11[31:11];
        field {
            name = "ahb1_port2_pri_in";
            desc = "Priority of the AHB1 bus M3 port The value 7 indicates the highest priority.";
            sw = rw; hw = r;
            reset = 0x2;
        } ahb1_port2_pri_in[10:8];
        field {
            name = "reserved";
            desc = "Reserved";
            sw = r; hw = na;
            reset = 0x0;
        } reserved_7_7[7:7];
        field {
            name = "ahb1_port1_pri_in";
            desc = "Priority of the AHB1 bus M2 port The value 7 indicates the highest priority.";
            sw = rw; hw = r;
            reset = 0x3;
        } ahb1_port1_pri_in[6:4];
        field {
            name = "reserved";
            desc = "Reserved";
            sw = r; hw = na;
            reset = 0x0;
        } reserved_3_3[3:3];
        field {
            name = "ahb1_port0_pri_in";
            desc = "Priority of the AHB1 bus M1 port The value 7 indicates the highest priority.";
            sw = rw; hw = r;
            reset = 0x4;
        } ahb1_port0_pri_in[2:0];
    } MISC_CTRL20 @ 0x50;
    reg {
        name = "MISC_CTRL21";
        desc = "MISC_CTRL21 is bus priority control register 8. MISC_CTRL21 (offset 0x0054, total reset 0x0000_0000; PROVEN: Hi3516D V300 data sheet, PDF page 165, section 3.5.5).";
        field {
            name = "media0_timeout_en_m2";
            desc = "Timeout count enable of the MEDIA0 bus M2 port
- 0: disabled
- 1: enabled";
            sw = rw; hw = r;
            reset = 0x0;
        } media0_timeout_en_m2[31:31];
        field {
            name = "media0_timeout_value_m2";
            desc = "Timeout count value of the MEDIA0 bus M2 port Count value = media0_timeout_value_m2 x 2";
            sw = rw; hw = r;
            reset = 0x0;
        } media0_timeout_value_m2[30:16];
        field {
            name = "media0_timeout_en_m1";
            desc = "Timeout count enable of the MEDIA0 bus M1 port
0: disabled
1: enabled";
            sw = rw; hw = r;
            reset = 0x0;
        } media0_timeout_en_m1[15:15];
        field {
            name = "media0_timeout_value_m1";
            desc = "Timeout count value of the MEDIA0 bus M1 port
Count value = media0_timeout_value_m1 x 2";
            sw = rw; hw = r;
            reset = 0x0;
        } media0_timeout_value_m1[14:0];
    } MISC_CTRL21 @ 0x54;
    reg {
        name = "MISC_CTRL22";
        desc = "MISC_CTRL22 is bus priority control register 9. MISC_CTRL22 (offset 0x0058, total reset 0x0000_0034; PROVEN: Hi3516D V300 data sheet, PDF page 166, section 3.5.5).";
        field {
            name = "reserved";
            desc = "Reserved";
            sw = r; hw = na;
            reset = 0x0;
        } reserved_31_7[31:7];
        field {
            name = "media0_port1_pri_in";
            desc = "Priority of the MEIDA0 bus M2 port The value 7 indicates the highest priority.";
            sw = rw; hw = r;
            reset = 0x3;
        } media0_port1_pri_in[6:4];
        field {
            name = "reserved";
            desc = "Reserved";
            sw = r; hw = na;
            reset = 0x0;
        } reserved_3_3[3:3];
        field {
            name = "media0_port0_pri_in";
            desc = "Priority of the MEIDA0 bus M1 port The value 7 indicates the highest priority.";
            sw = rw; hw = r;
            reset = 0x4;
        } media0_port0_pri_in[2:0];
    } MISC_CTRL22 @ 0x58;
    reg {
        name = "MISC_CTRL23";
        desc = "MISC_CTRL23 is bus priority control register 10. MISC_CTRL23 (offset 0x005C, total reset 0x0000_0000; PROVEN: Hi3516D V300 data sheet, PDF page 166, section 3.5.5).";
        field {
            name = "media1_timeout_en_m2";
            desc = "Timeout count enable of the MEDIA1 bus M2 port
- 0: disabled
- 1: enabled";
            sw = rw; hw = r;
            reset = 0x0;
        } media1_timeout_en_m2[31:31];
        field {
            name = "media1_timeout_value_m2";
            desc = "Timeout count value of the MEDIA1 bus M2 port Count value = media1_timeout_value_m2 x 2";
            sw = rw; hw = r;
            reset = 0x0;
        } media1_timeout_value_m2[30:16];
        field {
            name = "media1_timeout_en_m1";
            desc = "Timeout count enable of the MEDIA1 bus M1 port
- 0: disabled
- 1: enabled";
            sw = rw; hw = r;
            reset = 0x0;
        } media1_timeout_en_m1[15:15];
        field {
            name = "media1_timeout_value_m1";
            desc = "Timeout count value of the MEDIA1 bus M1 port";
            sw = rw; hw = r;
            reset = 0x0;
        } media1_timeout_value_m1[14:0];
    } MISC_CTRL23 @ 0x5c;
    reg {
        name = "MISC_CTRL24";
        desc = "MISC_CTRL24 is bus priority control register 11. MISC_CTRL24 (offset 0x0060, total reset 0x0000_0034; PROVEN: Hi3516D V300 data sheet, PDF page 167, section 3.5.5).";
        field {
            name = "reserved";
            desc = "Reserved";
            sw = r; hw = na;
            reset = 0x0;
        } reserved_31_7[31:7];
        field {
            name = "media1_port1_pri_in";
            desc = "Priority of the MEDIA1 bus M2 port The value 7 indicates the highest priority.";
            sw = rw; hw = r;
            reset = 0x3;
        } media1_port1_pri_in[6:4];
        field {
            name = "reserved";
            desc = "Reserved";
            sw = r; hw = na;
            reset = 0x0;
        } reserved_3_3[3:3];
        field {
            name = "media1_port0_pri_in";
            desc = "Priority of the MEDIA1 bus M1 port The value 7 indicates the highest priority.";
            sw = rw; hw = r;
            reset = 0x4;
        } media1_port0_pri_in[2:0];
    } MISC_CTRL24 @ 0x60;
    reg {
        name = "MISC_CTRL25";
        desc = "MISC_CTRL25 is bus priority control register 12. MISC_CTRL25 (offset 0x0064, total reset 0x0000_0000; PROVEN: Hi3516D V300 data sheet, PDF page 167, section 3.5.5).";
        field {
            name = "media2_timeout_en_m2";
            desc = "Timeout count enable of the MEDIA2 bus M2 port
- 0: disabled
- 1: enabled";
            sw = rw; hw = r;
            reset = 0x0;
        } media2_timeout_en_m2[31:31];
        field {
            name = "media2_timeout_value_m2";
            desc = "Timeout count value of the MEDIA2 bus M2 port Count value = media2_timeout_value_m2 x 2";
            sw = rw; hw = r;
            reset = 0x0;
        } media2_timeout_value_m2[30:16];
        field {
            name = "media2_timeout_en_m1";
            desc = "Timeout count enable of the MEDIA2 bus M1 port
- 0: disabled
- 1: enabled";
            sw = rw; hw = r;
            reset = 0x0;
        } media2_timeout_en_m1[15:15];
        field {
            name = "media2_timeout_value_m1";
            desc = "Timeout count value of the MEDIA2 bus M1 port Count value = media2_timeout_value_m1 x 2";
            sw = rw; hw = r;
            reset = 0x0;
        } media2_timeout_value_m1[14:0];
    } MISC_CTRL25 @ 0x64;
    reg {
        name = "MISC_CTRL26";
        desc = "MISC_CTRL26 is bus priority control register 13. MISC_CTRL26 (offset 0x0068, total reset 0x0000_0000; PROVEN: Hi3516D V300 data sheet, PDF page 168, section 3.5.5).";
        field {
            name = "media2_timeout_en_m4";
            desc = "Timeout count enable of the MEDIA2 bus M4 port
- 0: disabled
- 1: enabled";
            sw = rw; hw = r;
            reset = 0x0;
        } media2_timeout_en_m4[31:31];
        field {
            name = "media2_timeout_value_m4";
            desc = "Timeout count value of the MEDIA2 bus M4 port Count value = media2_timeout_value_m4 x 2";
            sw = rw; hw = r;
            reset = 0x0;
        } media2_timeout_value_m4[30:16];
        field {
            name = "media2_timeout_en_m3";
            desc = "Timeout count enable of the MEDIA2 bus M3 port
- 0: disabled
- 1: enabled";
            sw = rw; hw = r;
            reset = 0x0;
        } media2_timeout_en_m3[15:15];
        field {
            name = "media2_timeout_value_m3";
            desc = "Timeout count value of the MEDIA2 bus M3 port Count value = media2_timeout_value_m3 x 2";
            sw = rw; hw = r;
            reset = 0x0;
        } media2_timeout_value_m3[14:0];
    } MISC_CTRL26 @ 0x68;
    reg {
        name = "MISC_CTRL27";
        desc = "MISC_CTRL27 is bus priority control register 14. MISC_CTRL27 (offset 0x006C, total reset 0x0000_0000; PROVEN: Hi3516D V300 data sheet, PDF page 168, section 3.5.5).";
        field {
            name = "media2_timeout_en_m6";
            desc = "Timeout count enable of the MEDIA2 bus M6 port
- 0: disabled
- 1: enabled";
            sw = rw; hw = r;
            reset = 0x0;
        } media2_timeout_en_m6[31:31];
        field {
            name = "media2_timeout_value_m6";
            desc = "Timeout count value of the MEDIA2 bus M6 port Count value = media2_timeout_value_m6 x 2";
            sw = rw; hw = r;
            reset = 0x0;
        } media2_timeout_value_m6[30:16];
        field {
            name = "media2_timeout_en_m5";
            desc = "Timeout count enable of the MEDIA2 bus M5 port
- 0: disabled
- 1: enabled";
            sw = rw; hw = r;
            reset = 0x0;
        } media2_timeout_en_m5[15:15];
        field {
            name = "media2_timeout_value_m5";
            desc = "Timeout count value of the MEDIA2 bus M5 port Count value = media2_timeout_value_m5 x 2";
            sw = rw; hw = r;
            reset = 0x0;
        } media2_timeout_value_m5[14:0];
    } MISC_CTRL27 @ 0x6c;
    reg {
        name = "MISC_CTRL28";
        desc = "MISC_CTRL28 is bus priority control register 15. MISC_CTRL28 (offset 0x0070, total reset 0x0000_1234; PROVEN: Hi3516D V300 data sheet, PDF page 169, section 3.5.5).";
        field {
            name = "reserved";
            desc = "Reserved";
            sw = r; hw = na;
            reset = 0x0;
        } reserved_31_27[31:27];
        field {
            name = "media2_port6_pri_in";
            desc = "Priority of the MEDIA2 bus M7 port The value 7 indicates the highest priority.";
            sw = rw; hw = r;
            reset = 0x0;
        } media2_port6_pri_in[26:24];
        field {
            name = "reserved";
            desc = "Reserved";
            sw = r; hw = na;
            reset = 0x0;
        } reserved_23_23[23:23];
        field {
            name = "media2_port5_pri_in";
            desc = "Priority of the MEDIA2 bus M6 port The value 7 indicates the highest priority.";
            sw = rw; hw = r;
            reset = 0x0;
        } media2_port5_pri_in[22:20];
        field {
            name = "reserved";
            desc = "Reserved";
            sw = r; hw = na;
            reset = 0x0;
        } reserved_19_19[19:19];
        field {
            name = "media2_port4_pri_in";
            desc = "Priority of the MEDIA2 bus M5 port The value 7 indicates the highest priority.";
            sw = rw; hw = r;
            reset = 0x0;
        } media2_port4_pri_in[18:16];
        field {
            name = "reserved";
            desc = "Reserved";
            sw = r; hw = na;
            reset = 0x0;
        } reserved_15_15[15:15];
        field {
            name = "media2_port3_pri_in";
            desc = "Priority of the MEDIA2 bus M4 port The value 7 indicates the highest priority.";
            sw = rw; hw = r;
            reset = 0x1;
        } media2_port3_pri_in[14:12];
        field {
            name = "reserved";
            desc = "Reserved";
            sw = r; hw = na;
            reset = 0x0;
        } reserved_11_11[11:11];
        field {
            name = "media2_port2_pri_in";
            desc = "Priority of the MEDIA2 bus M3 port The value 7 indicates the highest priority.";
            sw = rw; hw = r;
            reset = 0x2;
        } media2_port2_pri_in[10:8];
        field {
            name = "reserved";
            desc = "Reserved";
            sw = r; hw = na;
            reset = 0x0;
        } reserved_7_7[7:7];
        field {
            name = "media2_port1_pri_in";
            desc = "Priority of the MEDIA2 bus M2 port The value 7 indicates the highest priority.";
            sw = rw; hw = r;
            reset = 0x3;
        } media2_port1_pri_in[6:4];
        field {
            name = "reserved";
            desc = "Reserved";
            sw = r; hw = na;
            reset = 0x0;
        } reserved_3_3[3:3];
        field {
            name = "media2_port0_pri_in";
            desc = "Priority of the MEDIA2 bus M1 port The value 7 indicates the highest priority.";
            sw = rw; hw = r;
            reset = 0x4;
        } media2_port0_pri_in[2:0];
    } MISC_CTRL28 @ 0x70;
    reg {
        name = "MISC_CTRL29";
        desc = "MISC_CTRL29 is bus priority control register 16. MISC_CTRL29 (offset 0x0074, total reset 0x0000_0000; PROVEN: Hi3516D V300 data sheet, PDF page 169, section 3.5.5).";
        field {
            name = "vivo_timeout_en_m2";
            desc = "Timeout count enable of the VIVO bus M2 port";
            sw = rw; hw = r;
            reset = 0x0;
        } vivo_timeout_en_m2[31:31];
        field {
            name = "vivo_timeout_value_m2";
            desc = "Timeout count value of the VIVO bus M2 port Count value = vivo_timeout_value_m2 x 2";
            sw = rw; hw = r;
            reset = 0x0;
        } vivo_timeout_value_m2[30:16];
        field {
            name = "vivo_timeout_en_m1";
            desc = "Timeout count enable of the VIVO bus M1 port
- 0: disabled
- 1: enabled";
            sw = rw; hw = r;
            reset = 0x0;
        } vivo_timeout_en_m1[15:15];
        field {
            name = "vivo_timeout_value_m1";
            desc = "Timeout count value of the VIVO bus M1 port Count value = vivo_timeout_value_m1 x 2";
            sw = rw; hw = r;
            reset = 0x0;
        } vivo_timeout_value_m1[14:0];
    } MISC_CTRL29 @ 0x74;
    reg {
        name = "MISC_CTRL30";
        desc = "MISC_CTRL30 is bus priority control register 17. MISC_CTRL30 (offset 0x0078, total reset 0x0000_0000; PROVEN: Hi3516D V300 data sheet, PDF page 170, section 3.5.5).";
        field {
            name = "media2_timeout_en_m7";
            desc = "Timeout count enable of the MEDIA2 bus M7 port
- 0: disabled
- 1: enabled";
            sw = rw; hw = r;
            reset = 0x0;
        } media2_timeout_en_m7[31:31];
        field {
            name = "media2_timeout_value_m7";
            desc = "Timeout count value of the MEDIA2 bus M7 port Count value = media2_timeout_value_m7 x 2";
            sw = rw; hw = r;
            reset = 0x0;
        } media2_timeout_value_m7[30:16];
        field {
            name = "vivo_timeout_en_m3";
            desc = "Timeout count enable of the VIVO bus M3 port
- 0: disabled
- 1: enabled";
            sw = rw; hw = r;
            reset = 0x0;
        } vivo_timeout_en_m3[15:15];
        field {
            name = "vivo_timeout_value_m3";
            desc = "Timeout count value of the VIVO bus M3 port Count value = vivo_timeout_value_m3 x 2";
            sw = rw; hw = r;
            reset = 0x0;
        } vivo_timeout_value_m3[14:0];
    } MISC_CTRL30 @ 0x78;
    reg {
        name = "MISC_CTRL31";
        desc = "MISC_CTRL31 is bus priority control register 18. MISC_CTRL31 (offset 0x007C, total reset 0x0000_0234; PROVEN: Hi3516D V300 data sheet, PDF page 170, section 3.5.5).";
        field {
            name = "reserved";
            desc = "Reserved";
            sw = r; hw = na;
            reset = 0x0;
        } reserved_31_11[31:11];
        field {
            name = "vivo_port2_pri_in";
            desc = "Priority of the VIVO bus M3 port The value 7 indicates the highest priority.";
            sw = rw; hw = r;
            reset = 0x2;
        } vivo_port2_pri_in[10:8];
        field {
            name = "reserved";
            desc = "Reserved";
            sw = r; hw = na;
            reset = 0x0;
        } reserved_7_7[7:7];
        field {
            name = "vivo_port1_pri_in";
            desc = "Priority of the VIVO bus M2 port The value 7 indicates the highest priority.";
            sw = rw; hw = r;
            reset = 0x3;
        } vivo_port1_pri_in[6:4];
        field {
            name = "reserved";
            desc = "Reserved";
            sw = r; hw = na;
            reset = 0x0;
        } reserved_3_3[3:3];
        field {
            name = "vivo_port0_pri_in";
            desc = "Priority of the VIVO bus M1 port The value 7 indicates the highest priority.";
            sw = rw; hw = r;
            reset = 0x4;
        } vivo_port0_pri_in[2:0];
    } MISC_CTRL31 @ 0x7c;
    reg {
        name = "MISC_CTRL32";
        desc = "MISC_CTRL32 is MDDRC W QOS register 0. MISC_CTRL32 (offset 0x0080, total reset 0x0000_0000; PROVEN: Hi3516D V300 data sheet, PDF page 171, section 3.5.5).";
        field {
            name = "reserved";
            desc = "Reserved";
            sw = r; hw = na;
            reset = 0x0;
        } reserved_31_31[31:31];
        field {
            name = "nnie_l_w_qos";
            desc = "QOS group of the NNIE L write channel";
            sw = rw; hw = r;
            reset = 0x0;
        } nnie_l_w_qos[30:28];
        field {
            name = "reserved";
            desc = "Reserved";
            sw = r; hw = na;
            reset = 0x0;
        } reserved_27_27[27:27];
        field {
            name = "nnie_h_w_qos";
            desc = "QOS group of the NNIE H write channel";
            sw = rw; hw = r;
            reset = 0x0;
        } nnie_h_w_qos[26:24];
        field {
            name = "reserved";
            desc = "Reserved";
            sw = r; hw = na;
            reset = 0x0;
        } reserved_23_23[23:23];
        field {
            name = "gdc_w_qos";
            desc = "QOS group of the GDC write channel";
            sw = rw; hw = r;
            reset = 0x0;
        } gdc_w_qos[22:20];
        field {
            name = "reserved";
            desc = "Reserved";
            sw = r; hw = na;
            reset = 0x0;
        } reserved_19_19[19:19];
        field {
            name = "viproc_w_qos";
            desc = "QOS group of the VIPROC write channel";
            sw = rw; hw = r;
            reset = 0x0;
        } viproc_w_qos[18:16];
        field {
            name = "reserved";
            desc = "Reserved";
            sw = r; hw = na;
            reset = 0x0;
        } reserved_15_15[15:15];
        field {
            name = "vpss_w_qos";
            desc = "QOS group of the VPSS write channel";
            sw = rw; hw = r;
            reset = 0x0;
        } vpss_w_qos[14:12];
        field {
            name = "reserved";
            desc = "Reserved";
            sw = r; hw = na;
            reset = 0x0;
        } reserved_11_11[11:11];
        field {
            name = "aio_w_qos";
            desc = "QOS group of the AIAO write channel";
            sw = rw; hw = r;
            reset = 0x0;
        } aio_w_qos[10:8];
        field {
            name = "reserved";
            desc = "Reserved";
            sw = r; hw = na;
            reset = 0x0;
        } reserved_7_7[7:7];
        field {
            name = "vdp_w_qos";
            desc = "QOS group of the VDP write channel";
            sw = rw; hw = r;
            reset = 0x0;
        } vdp_w_qos[6:4];
        field {
            name = "reserved";
            desc = "Reserved";
            sw = r; hw = na;
            reset = 0x0;
        } reserved_3_3[3:3];
        field {
            name = "vicap_w_qos";
            desc = "QOS group of the VICAP write channel";
            sw = rw; hw = r;
            reset = 0x0;
        } vicap_w_qos[2:0];
    } MISC_CTRL32 @ 0x80;
    reg {
        name = "MISC_CTRL33";
        desc = "MISC_CTRL33 is MDDRC W QOS register 1. MISC_CTRL33 (offset 0x0084, total reset 0x0000_0000; PROVEN: Hi3516D V300 data sheet, PDF page 172, section 3.5.5).";
        field {
            name = "reserved";
            desc = "Reserved";
            sw = r; hw = na;
            reset = 0x0;
        } reserved_31_31[31:31];
        field {
            name = "scd_w_qos";
            desc = "QOS group of the SCD write channel";
            sw = rw; hw = r;
            reset = 0x0;
        } scd_w_qos[30:28];
        field {
            name = "reserved";
            desc = "Reserved";
            sw = r; hw = na;
            reset = 0x0;
        } reserved_27_27[27:27];
        field {
            name = "spacc_w_qos";
            desc = "QOS group of the SPACC write channel";
            sw = rw; hw = r;
            reset = 0x0;
        } spacc_w_qos[26:24];
        field {
            name = "reserved";
            desc = "Reserved";
            sw = r; hw = na;
            reset = 0x0;
        } reserved_23_23[23:23];
        field {
            name = "fmc_w_qos";
            desc = "QOS group of the FMC write channel";
            sw = rw; hw = r;
            reset = 0x0;
        } fmc_w_qos[22:20];
        field {
            name = "reserved";
            desc = "Reserved";
            sw = r; hw = na;
            reset = 0x0;
        } reserved_19_19[19:19];
        field {
            name = "emmc_w_qos";
            desc = "QOS group of the eMMC write channel";
            sw = rw; hw = r;
            reset = 0x0;
        } emmc_w_qos[18:16];
        field {
            name = "reserved";
            desc = "Reserved";
            sw = r; hw = na;
            reset = 0x0;
        } reserved_15_15[15:15];
        field {
            name = "sdio0_w_qos";
            desc = "QOS group of the SDIO0 write channel";
            sw = rw; hw = r;
            reset = 0x0;
        } sdio0_w_qos[14:12];
        field {
            name = "reserved";
            desc = "Reserved";
            sw = r; hw = na;
            reset = 0x0;
        } reserved_11_11[11:11];
        field {
            name = "dmac_w_qos";
            desc = "QOS group of the DMAC write channel";
            sw = rw; hw = r;
            reset = 0x0;
        } dmac_w_qos[10:8];
        field {
            name = "reserved";
            desc = "Reserved";
            sw = r; hw = na;
            reset = 0x0;
        } reserved_7_7[7:7];
        field {
            name = "usb_w_qos";
            desc = "QOS group of the USB write channel";
            sw = rw; hw = r;
            reset = 0x0;
        } usb_w_qos[6:4];
        field {
            name = "reserved";
            desc = "Reserved";
            sw = r; hw = na;
            reset = 0x0;
        } reserved_3_3[3:3];
        field {
            name = "eth_w_qos";
            desc = "QOS group of the ETH write channel";
            sw = rw; hw = r;
            reset = 0x0;
        } eth_w_qos[2:0];
    } MISC_CTRL33 @ 0x84;
    reg {
        name = "MISC_CTRL34";
        desc = "MISC_CTRL34 is MDDRC W QOS register 2. MISC_CTRL34 (offset 0x0088, total reset 0x0000_0000; PROVEN: Hi3516D V300 data sheet, PDF page 172, section 3.5.5).";
        field {
            name = "reserved";
            desc = "Reserved";
            sw = r; hw = na;
            reset = 0x0;
        } reserved_31_31[31:31];
        field {
            name = "ddrt_w_qos";
            desc = "QOS group of the DDRT write channel";
            sw = rw; hw = r;
            reset = 0x0;
        } ddrt_w_qos[30:28];
        field {
            name = "reserved";
            desc = "Reserved";
            sw = r; hw = na;
            reset = 0x0;
        } reserved_27_27[27:27];
        field {
            name = "gzip_w_qos";
            desc = "QOS group of the GZIP write channel";
            sw = rw; hw = r;
            reset = 0x0;
        } gzip_w_qos[26:24];
        field {
            name = "reserved";
            desc = "Reserved";
            sw = r; hw = na;
            reset = 0x0;
        } reserved_23_23[23:23];
        field {
            name = "tde_w_qos";
            desc = "QOS group of the TDE write channel";
            sw = rw; hw = r;
            reset = 0x0;
        } tde_w_qos[22:20];
        field {
            name = "reserved";
            desc = "Reserved";
            sw = r; hw = na;
            reset = 0x0;
        } reserved_19_19[19:19];
        field {
            name = "ive_w_qos";
            desc = "QOS group of the IVE write channel";
            sw = rw; hw = r;
            reset = 0x0;
        } ive_w_qos[18:16];
        field {
            name = "reserved";
            desc = "Reserved";
            sw = r; hw = na;
            reset = 0x0;
        } reserved_15_15[15:15];
        field {
            name = "jpge_w_qos";
            desc = "QOS group of the JPGE write channel";
            sw = rw; hw = r;
            reset = 0x0;
        } jpge_w_qos[14:12];
        field {
            name = "reserved";
            desc = "Reserved";
            sw = r; hw = na;
            reset = 0x0;
        } reserved_11_11[11:11];
        field {
            name = "vgs_w_qos";
            desc = "QOS group of the VGS write channel";
            sw = rw; hw = r;
            reset = 0x0;
        } vgs_w_qos[10:8];
        field {
            name = "reserved";
            desc = "Reserved";
            sw = r; hw = na;
            reset = 0x0;
        } reserved_7_7[7:7];
        field {
            name = "vedu_w_qos";
            desc = "QOS group of the VEDU write channel";
            sw = rw; hw = r;
            reset = 0x0;
        } vedu_w_qos[6:4];
        field {
            name = "reserved";
            desc = "Reserved";
            sw = r; hw = na;
            reset = 0x0;
        } reserved_3_3[3:3];
        field {
            name = "cpu_w_qos";
            desc = "QOS group of the CPU write channel";
            sw = rw; hw = r;
            reset = 0x0;
        } cpu_w_qos[2:0];
    } MISC_CTRL34 @ 0x88;
    reg {
        name = "MISC_CTRL35";
        desc = "MISC_CTRL35 is MDDRC W QOS register 3. MISC_CTRL35 (offset 0x008C, total reset 0x0000_0000; PROVEN: Hi3516D V300 data sheet, PDF page 173, section 3.5.5).";
        field {
            name = "reserved";
            desc = "Reserved";
            sw = r; hw = na;
            reset = 0x0;
        } reserved_31_7[31:7];
        field {
            name = "sdio1_w_qos";
            desc = "QOS group of the SDIO1 write channel";
            sw = rw; hw = r;
            reset = 0x0;
        } sdio1_w_qos[6:4];
        field {
            name = "reserved";
            desc = "Reserved";
            sw = r; hw = na;
            reset = 0x0;
        } reserved_3_3[3:3];
        field {
            name = "jpgd_w_qos";
            desc = "QOS group of the JPGD write channel";
            sw = rw; hw = r;
            reset = 0x0;
        } jpgd_w_qos[2:0];
    } MISC_CTRL35 @ 0x8c;
    reg {
        name = "MISC_CTRL36";
        desc = "MISC_CTRL36 is MDDRC R QOS register 0. MISC_CTRL36 (offset 0x0090, total reset 0x0000_0000; PROVEN: Hi3516D V300 data sheet, PDF page 173, section 3.5.5).";
        field {
            name = "reserved";
            desc = "Reserved";
            sw = r; hw = na;
            reset = 0x0;
        } reserved_31_31[31:31];
        field {
            name = "nnie_l_r_qos";
            desc = "QOS group of the NNIE L read channel";
            sw = rw; hw = r;
            reset = 0x0;
        } nnie_l_r_qos[30:28];
        field {
            name = "reserved";
            desc = "Reserved";
            sw = r; hw = na;
            reset = 0x0;
        } reserved_27_27[27:27];
        field {
            name = "nnie_h_r_qos";
            desc = "QOS group of the NNIE H read channel";
            sw = rw; hw = r;
            reset = 0x0;
        } nnie_h_r_qos[26:24];
        field {
            name = "reserved";
            desc = "Reserved";
            sw = r; hw = na;
            reset = 0x0;
        } reserved_23_23[23:23];
        field {
            name = "gdc_r_qos";
            desc = "QOS group of the GDC read channel";
            sw = rw; hw = r;
            reset = 0x0;
        } gdc_r_qos[22:20];
        field {
            name = "reserved";
            desc = "Reserved";
            sw = r; hw = na;
            reset = 0x0;
        } reserved_19_19[19:19];
        field {
            name = "viproc_r_qos";
            desc = "QOS group of the VIPROC read channel";
            sw = rw; hw = r;
            reset = 0x0;
        } viproc_r_qos[18:16];
        field {
            name = "reserved";
            desc = "Reserved";
            sw = r; hw = na;
            reset = 0x0;
        } reserved_15_15[15:15];
        field {
            name = "vpss_r_qos";
            desc = "QOS group of the VPSS read channel";
            sw = rw; hw = r;
            reset = 0x0;
        } vpss_r_qos[14:12];
        field {
            name = "reserved";
            desc = "Reserved";
            sw = r; hw = na;
            reset = 0x0;
        } reserved_11_11[11:11];
        field {
            name = "aio_r_qos";
            desc = "QOS group of the AIAO read channel";
            sw = rw; hw = r;
            reset = 0x0;
        } aio_r_qos[10:8];
        field {
            name = "reserved";
            desc = "Reserved";
            sw = r; hw = na;
            reset = 0x0;
        } reserved_7_7[7:7];
        field {
            name = "vdp_r_qos";
            desc = "QOS group of the VDP read channel";
            sw = rw; hw = r;
            reset = 0x0;
        } vdp_r_qos[6:4];
        field {
            name = "reserved";
            desc = "Reserved";
            sw = r; hw = na;
            reset = 0x0;
        } reserved_3_3[3:3];
        field {
            name = "vicap_r_qos";
            desc = "QOS group of the VICAP read channel";
            sw = rw; hw = r;
            reset = 0x0;
        } vicap_r_qos[2:0];
    } MISC_CTRL36 @ 0x90;
    reg {
        name = "MISC_CTRL37";
        desc = "MISC_CTRL37 is MDDRC R QOS register 1. MISC_CTRL37 (offset 0x0094, total reset 0x0000_0000; PROVEN: Hi3516D V300 data sheet, PDF page 174, section 3.5.5).";
        field {
            name = "reserved";
            desc = "Reserved";
            sw = r; hw = na;
            reset = 0x0;
        } reserved_31_31[31:31];
        field {
            name = "scd_r_qos";
            desc = "QOS group of the SCD read channel";
            sw = rw; hw = r;
            reset = 0x0;
        } scd_r_qos[30:28];
        field {
            name = "reserved";
            desc = "Reserved";
            sw = r; hw = na;
            reset = 0x0;
        } reserved_27_27[27:27];
        field {
            name = "spacc_r_qos";
            desc = "QOS group of the SPACC read channel";
            sw = rw; hw = r;
            reset = 0x0;
        } spacc_r_qos[26:24];
        field {
            name = "reserved";
            desc = "Reserved";
            sw = r; hw = na;
            reset = 0x0;
        } reserved_23_23[23:23];
        field {
            name = "fmc_r_qos";
            desc = "QOS group of the FMC read channel";
            sw = rw; hw = r;
            reset = 0x0;
        } fmc_r_qos[22:20];
        field {
            name = "reserved";
            desc = "Reserved";
            sw = r; hw = na;
            reset = 0x0;
        } reserved_19_19[19:19];
        field {
            name = "emmc_r_qos";
            desc = "QOS group of the eMMC read channel";
            sw = rw; hw = r;
            reset = 0x0;
        } emmc_r_qos[18:16];
        field {
            name = "reserved";
            desc = "Reserved";
            sw = r; hw = na;
            reset = 0x0;
        } reserved_15_15[15:15];
        field {
            name = "sdio0_r_qos";
            desc = "QOS group of the SDIO0 read channel";
            sw = rw; hw = r;
            reset = 0x0;
        } sdio0_r_qos[14:12];
        field {
            name = "reserved";
            desc = "Reserved";
            sw = r; hw = na;
            reset = 0x0;
        } reserved_11_11[11:11];
        field {
            name = "dmac_r_qos";
            desc = "QOS group of the DMAC read channel";
            sw = rw; hw = r;
            reset = 0x0;
        } dmac_r_qos[10:8];
        field {
            name = "reserved";
            desc = "Reserved";
            sw = r; hw = na;
            reset = 0x0;
        } reserved_7_7[7:7];
        field {
            name = "usb_r_qos";
            desc = "QOS group of the USB read channel";
            sw = rw; hw = r;
            reset = 0x0;
        } usb_r_qos[6:4];
        field {
            name = "reserved";
            desc = "Reserved";
            sw = r; hw = na;
            reset = 0x0;
        } reserved_3_3[3:3];
        field {
            name = "eth_r_qos";
            desc = "QOS group of the ETH read channel";
            sw = rw; hw = r;
            reset = 0x0;
        } eth_r_qos[2:0];
    } MISC_CTRL37 @ 0x94;
    reg {
        name = "MISC_CTRL38";
        desc = "MISC_CTRL38 is MDDRC R QOS register 2. MISC_CTRL38 (offset 0x0098, total reset 0x0000_0000; PROVEN: Hi3516D V300 data sheet, PDF page 175, section 3.5.5).";
        field {
            name = "reserved";
            desc = "Reserved";
            sw = r; hw = na;
            reset = 0x0;
        } reserved_31_31[31:31];
        field {
            name = "ddrt_r_qos";
            desc = "QOS group of the DDRT read channel";
            sw = rw; hw = r;
            reset = 0x0;
        } ddrt_r_qos[30:28];
        field {
            name = "reserved";
            desc = "Reserved";
            sw = r; hw = na;
            reset = 0x0;
        } reserved_27_27[27:27];
        field {
            name = "gzip_r_qos";
            desc = "QOS group of the GZIP read channel";
            sw = rw; hw = r;
            reset = 0x0;
        } gzip_r_qos[26:24];
        field {
            name = "reserved";
            desc = "Reserved";
            sw = r; hw = na;
            reset = 0x0;
        } reserved_23_23[23:23];
        field {
            name = "tde_r_qos";
            desc = "QOS group of the TDE read channel";
            sw = rw; hw = r;
            reset = 0x0;
        } tde_r_qos[22:20];
        field {
            name = "reserved";
            desc = "Reserved";
            sw = r; hw = na;
            reset = 0x0;
        } reserved_19_19[19:19];
        field {
            name = "ive_r_qos";
            desc = "QOS group of the IVE read channel";
            sw = rw; hw = r;
            reset = 0x0;
        } ive_r_qos[18:16];
        field {
            name = "reserved";
            desc = "Reserved";
            sw = r; hw = na;
            reset = 0x0;
        } reserved_15_15[15:15];
        field {
            name = "jpge_r_qos";
            desc = "QOS group of the JPGE read channel";
            sw = rw; hw = r;
            reset = 0x0;
        } jpge_r_qos[14:12];
        field {
            name = "reserved";
            desc = "Reserved";
            sw = r; hw = na;
            reset = 0x0;
        } reserved_11_11[11:11];
        field {
            name = "vgs_r_qos";
            desc = "QOS group of the VGS read channel";
            sw = rw; hw = r;
            reset = 0x0;
        } vgs_r_qos[10:8];
        field {
            name = "reserved";
            desc = "Reserved";
            sw = r; hw = na;
            reset = 0x0;
        } reserved_7_7[7:7];
        field {
            name = "vedu_r_qos";
            desc = "QOS group of the VEDU read channel";
            sw = rw; hw = r;
            reset = 0x0;
        } vedu_r_qos[6:4];
        field {
            name = "reserved";
            desc = "Reserved";
            sw = r; hw = na;
            reset = 0x0;
        } reserved_3_3[3:3];
        field {
            name = "cpu_r_qos";
            desc = "QOS group of the CPU read channel";
            sw = rw; hw = r;
            reset = 0x0;
        } cpu_r_qos[2:0];
    } MISC_CTRL38 @ 0x98;
    reg {
        name = "MISC_CTRL39";
        desc = "MISC_CTRL39 is MDDRC R QOS register 3. MISC_CTRL39 (offset 0x009C, total reset 0x0000_0000; PROVEN: Hi3516D V300 data sheet, PDF page 175, section 3.5.5).";
        field {
            name = "reserved";
            desc = "Reserved";
            sw = r; hw = na;
            reset = 0x0;
        } reserved_31_7[31:7];
        field {
            name = "sdio1_r_qos";
            desc = "QOS group of the SDIO1 read channel";
            sw = rw; hw = r;
            reset = 0x0;
        } sdio1_r_qos[6:4];
        field {
            name = "reserved";
            desc = "Reserved";
            sw = r; hw = na;
            reset = 0x0;
        } reserved_3_3[3:3];
        field {
            name = "jpgd_r_qos";
            desc = "QOS group of the JPGD read channel";
            sw = rw; hw = r;
            reset = 0x0;
        } jpgd_r_qos[2:0];
    } MISC_CTRL39 @ 0x9c;
    reg {
        name = "MISC_CTRL44";
        desc = "MISC_CTRL44 is the SVB control register. MISC_CTRL44 (offset 0x00B0, total reset 0x0000_0000; PROVEN: Hi3516D V300 data sheet, PDF page 176, section 3.5.5).";
        field {
            name = "reserved";
            desc = "Reserved";
            sw = r; hw = na;
            reset = 0x0;
        } reserved_31_26[31:26];
        field {
            name = "svb_pwm_duty";
            desc = "Number of high level times in a PWM period of the SVB output. The actual number is the configured value plus 1.";
            sw = rw; hw = r;
            reset = 0x0;
        } svb_pwm_duty[25:16];
        field {
            name = "reserved";
            desc = "Reserved";
            sw = r; hw = na;
            reset = 0x0;
        } reserved_15_14[15:14];
        field {
            name = "svb_pwm_period";
            desc = "PWM period of the SVB output. The actual number is the configured value plus 1.";
            sw = rw; hw = r;
            reset = 0x0;
        } svb_pwm_period[13:4];
        field {
            name = "reserved";
            desc = "Reserved";
            sw = r; hw = na;
            reset = 0x0;
        } reserved_3_3[3:3];
        field {
            name = "svb_pwm_load";
            desc = "Parameter load control of the SVB output. Writing 1 to this bit enables the parameters to take effect.";
            sw = w; hw = r;
            reset = 0x0;
        } svb_pwm_load[2:2];
        field {
            name = "svb_pwm_inv";
            desc = "Phase control of the SVB output
- 0: positive phase
- 1: inversed phase";
            sw = rw; hw = r;
            reset = 0x0;
        } svb_pwm_inv[1:1];
        field {
            name = "svb_pwm_enable";
            desc = "SVB enable
- 0: disabled
- 1: enabled";
            sw = rw; hw = r;
            reset = 0x0;
        } svb_pwm_enable[0:0];
    } MISC_CTRL44 @ 0xb0;
    reg {
        name = "MISC_CTRL45";
        desc = "MISC_CTRL45 is the temperature sensor (T-Sensor) control register. MISC_CTRL45 (offset 0x00B4, total reset 0x0000_0000; PROVEN: Hi3516D V300 data sheet, PDF page 176, section 3.5.5).";
        field {
            name = "tsensor_en";
            desc = "T-Sensor enable
- 0: disabled
- 1: enabled";
            sw = rw; hw = r;
            reset = 0x0;
        } tsensor_en[31:31];
        field {
            name = "tsensor_monitor_en";
            desc = "Cyclic temperature monitoring enable of the T-Sensor
- 0: single measurement mode
- 1: cyclic measurement mode";
            sw = rw; hw = r;
            reset = 0x0;
        } tsensor_monitor_en[30:30];
        field {
            name = "reserved";
            desc = "Reserved";
            sw = r; hw = na;
            reset = 0x0;
        } reserved_29_28[29:28];
        field {
            name = "tsensor_monitor_period";
            desc = "Cycle monitoring period of the T-Sensor. The timing reference is 2 ms.";
            sw = rw; hw = r;
            reset = 0x0;
        } tsensor_monitor_period[27:20];
        field {
            name = "tsensor_uplimit";
            desc = "Upper limit of the temperature";
            sw = rw; hw = r;
            reset = 0x0;
        } tsensor_uplimit[19:10];
        field {
            name = "tsensor_lowlimit";
            desc = "Lower limit of the temperature";
            sw = rw; hw = r;
            reset = 0x0;
        } tsensor_lowlimit[9:0];
    } MISC_CTRL45 @ 0xb4;
    reg {
        name = "MISC_CTRL46";
        desc = "MISC_CTRL46 is the T-Sensor status register. MISC_CTRL46 (offset 0x00B8, total reset 0x0000_0000; PROVEN: Hi3516D V300 data sheet, PDF page 177, section 3.5.5).";
        field {
            name = "reserved";
            desc = "Reserved";
            sw = r; hw = na;
            reset = 0x0;
        } reserved_31_6[31:6];
        field {
            name = "tsensor_vcalib1_en";
            desc = "VCALIB1 enable of the T-Sensor
- 0: disabled
- 1: enabled";
            sw = rw; hw = r;
            reset = 0x0;
        } tsensor_vcalib1_en[5:5];
        field {
            name = "tsensor_temp_calib";
            desc = "Calibration algorithm select of the T-Sensor
- 0: enabled
- 1: disabled";
            sw = rw; hw = r;
            reset = 0x0;
        } tsensor_temp_calib[4:4];
        field {
            name = "tsensor_temp_ct_sel";
            desc = "Time for the T-Sensor to convert the temperature code value
- 00: 0.512 ms
- 01: 1.024 ms
- 10: 0.256 ms
- 11: 2.048 ms";
            sw = rw; hw = r;
            reset = 0x0;
        } tsensor_temp_ct_sel[3:2];
        field {
            name = "tsensor_low_warning";
            desc = "Temperature underflow warning, active high";
            sw = r; hw = w;
            reset = 0x0;
        } tsensor_low_warning[1:1];
        field {
            name = "tsensor_up_warning";
            desc = "Temperature overflow warning, active high";
            sw = r; hw = w;
            reset = 0x0;
        } tsensor_up_warning[0:0];
    } MISC_CTRL46 @ 0xb8;
    reg {
        name = "MISC_CTRL47";
        desc = "MISC_CTRL47 is T-Sensor temperature record register 0. MISC_CTRL47 (offset 0x00BC, total reset 0x0000_0000; PROVEN: Hi3516D V300 data sheet, PDF page 177, section 3.5.5).";
        field {
            name = "reserved";
            desc = "Reserved";
            sw = r; hw = na;
            reset = 0x0;
        } reserved_31_26[31:26];
        field {
            name = "tsensor_result1";
            desc = "Temperature record value 1";
            sw = r; hw = w;
            reset = 0x0;
        } tsensor_result1[25:16];
        field {
            name = "reserved";
            desc = "Reserved";
            sw = r; hw = na;
            reset = 0x0;
        } reserved_15_10[15:10];
        field {
            name = "tsensor_result0";
            desc = "Temperature record value 0";
            sw = r; hw = w;
            reset = 0x0;
        } tsensor_result0[9:0];
    } MISC_CTRL47 @ 0xbc;
    reg {
        name = "MISC_CTRL48";
        desc = "MISC_CTRL48 is T-Sensor temperature record register 1. MISC_CTRL48 (offset 0x00C0, total reset 0x0000_0000; PROVEN: Hi3516D V300 data sheet, PDF page 178, section 3.5.5).";
        field {
            name = "reserved";
            desc = "Reserved";
            sw = r; hw = na;
            reset = 0x0;
        } reserved_31_26[31:26];
        field {
            name = "tsensor_result3";
            desc = "Temperature record value 3";
            sw = r; hw = w;
            reset = 0x0;
        } tsensor_result3[25:16];
        field {
            name = "reserved";
            desc = "Reserved";
            sw = r; hw = na;
            reset = 0x0;
        } reserved_15_10[15:10];
        field {
            name = "tsensor_result2";
            desc = "Temperature record value 2";
            sw = r; hw = w;
            reset = 0x0;
        } tsensor_result2[9:0];
    } MISC_CTRL48 @ 0xc0;
    reg {
        name = "MISC_CTRL49";
        desc = "MISC_CTRL49 is T-Sensor temperature record register 2. MISC_CTRL49 (offset 0x00C4, total reset 0x0000_0000; PROVEN: Hi3516D V300 data sheet, PDF page 178, section 3.5.5).";
        field {
            name = "reserved";
            desc = "Reserved";
            sw = r; hw = na;
            reset = 0x0;
        } reserved_31_26[31:26];
        field {
            name = "tsensor_result5";
            desc = "Temperature record value 5";
            sw = r; hw = w;
            reset = 0x0;
        } tsensor_result5[25:16];
        field {
            name = "reserved";
            desc = "Reserved";
            sw = r; hw = na;
            reset = 0x0;
        } reserved_15_10[15:10];
        field {
            name = "tsensor_result4";
            desc = "Temperature record value 4";
            sw = r; hw = w;
            reset = 0x0;
        } tsensor_result4[9:0];
    } MISC_CTRL49 @ 0xc4;
    reg {
        name = "MISC_CTRL50";
        desc = "MISC_CTRL50 is T-Sensor temperature record register 3. MISC_CTRL50 (offset 0x00C8, total reset 0x0000_0000; PROVEN: Hi3516D V300 data sheet, PDF page 178, section 3.5.5).";
        field {
            name = "reserved";
            desc = "Reserved";
            sw = r; hw = na;
            reset = 0x0;
        } reserved_31_26[31:26];
        field {
            name = "tsensor_result7";
            desc = "Temperature record value 7";
            sw = r; hw = w;
            reset = 0x0;
        } tsensor_result7[25:16];
        field {
            name = "reserved";
            desc = "Reserved";
            sw = r; hw = na;
            reset = 0x0;
        } reserved_15_10[15:10];
        field {
            name = "tsensor_result6";
            desc = "Temperature record value 6";
            sw = r; hw = w;
            reset = 0x0;
        } tsensor_result6[9:0];
    } MISC_CTRL50 @ 0xc8;
    reg {
        name = "MISC_CTRL51";
        desc = "MISC_CTRL51 is the update mode clear register. MISC_CTRL51 (offset 0x00CC, total reset 0x0000_0000; PROVEN: Hi3516D V300 data sheet, PDF page 178, section 3.5.5).";
        field {
            name = "reserved";
            desc = "Reserved";
            sw = r; hw = na;
            reset = 0x0;
        } reserved_31_1[31:1];
        field {
            name = "update_mode_clear";
            desc = "Writing 1 to this bit clears the update mode. This register is configured when the update is complete.";
            sw = w; hw = r;
            reset = 0x0;
        } update_mode_clear[0:0];
    } MISC_CTRL51 @ 0xcc;
    reg {
        name = "MISC_CTRL52";
        desc = "HPM_CTRL52 is HPM control register 0. MISC_CTRL52 (offset 0x00D0, total reset 0x0000_0000; PROVEN: Hi3516D V300 data sheet, PDF page 179, section 3.5.5).";
        field {
            name = "cpu_hpm_srst_req";
            desc = "CPU HPM reset request, active high.
- 0: reset deasserted
- 1: reset";
            sw = rw; hw = r;
            reset = 0x0;
        } cpu_hpm_srst_req[31:31];
        field {
            name = "cpu_hpm_monitor_en";
            desc = "CPU HPM cyclic monitoring enable.
- 0: single monitoring
- 1: cyclic monitoring";
            sw = rw; hw = r;
            reset = 0x0;
        } cpu_hpm_monitor_en[30:30];
        field {
            name = "cpu_hpm_en";
            desc = "CPU HPM measure enable
- 0: disabled
- 1: enabled";
            sw = rw; hw = r;
            reset = 0x0;
        } cpu_hpm_en[29:29];
        field {
            name = "reserved";
            desc = "Reserved";
            sw = r; hw = na;
            reset = 0x0;
        } reserved_28_16[28:16];
        field {
            name = "cpu_hpm_monitor_period";
            desc = "CPU HPM cyclic monitoring period. Monitoring period = core_hpm_monitor_period x 2.048 ms.";
            sw = rw; hw = r;
            reset = 0x0;
        } cpu_hpm_monitor_period[15:8];
        field {
            name = "reserved";
            desc = "Reserved";
            sw = r; hw = na;
            reset = 0x0;
        } reserved_7_6[7:6];
        field {
            name = "cpu_hpm_div";
            desc = "Frequency division ratio of the CPU HPM reference clock. The actual frequency divider is the configured value plus 1.";
            sw = rw; hw = r;
            reset = 0x0;
        } cpu_hpm_div[5:0];
    } MISC_CTRL52 @ 0xd0;
    reg {
        name = "MISC_CTRL53";
        desc = "MISC_CTRL53 is HPM control register 1. MISC_CTRL53 (offset 0x00D4, total reset 0x0000_0000; PROVEN: Hi3516D V300 data sheet, PDF page 179, section 3.5.5).";
        field {
            name = "reserved";
            desc = "Reserved";
            sw = r; hw = na;
            reset = 0x0;
        } reserved_31_24[31:24];
        field {
            name = "cpu_hpm_offset";
            desc = "CPU HPM offset value";
            sw = rw; hw = r;
            reset = 0x0;
        } cpu_hpm_offset[23:22];
        field {
            name = "cpu_hpm_shift";
            desc = "CPU HPM shift value";
            sw = rw; hw = r;
            reset = 0x0;
        } cpu_hpm_shift[21:20];
        field {
            name = "cpu_hpm_lowlimit";
            desc = "CPU HPM lower limit";
            sw = rw; hw = r;
            reset = 0x0;
        } cpu_hpm_lowlimit[19:10];
        field {
            name = "cpu_hpm_uplimit";
            desc = "CPU HPM upper limit";
            sw = rw; hw = r;
            reset = 0x0;
        } cpu_hpm_uplimit[9:0];
    } MISC_CTRL53 @ 0xd4;
    reg {
        name = "MISC_CTRL54";
        desc = "MISC_CTRL54 is HPM status register 0. MISC_CTRL54 (offset 0x00D8, total reset 0x0000_0000; PROVEN: Hi3516D V300 data sheet, PDF page 180, section 3.5.5).";
        field {
            name = "cpu_hpm_up_warning";
            desc = "CPU HPM overflow warning, active high";
            sw = r; hw = w;
            reset = 0x0;
        } cpu_hpm_up_warning[31:31];
        field {
            name = "cpu_hpm_low_warning";
            desc = "CPU HPM underflow warning, active high";
            sw = r; hw = w;
            reset = 0x0;
        } cpu_hpm_low_warning[30:30];
        field {
            name = "cpu_hpm_pc_valid";
            desc = "CPU HPM output validity indicator
- 0: invalid
- 1: valid";
            sw = r; hw = w;
            reset = 0x0;
        } cpu_hpm_pc_valid[29:29];
        field {
            name = "reserved";
            desc = "Reserved";
            sw = r; hw = na;
            reset = 0x0;
        } reserved_28_26[28:26];
        field {
            name = "cpu_hpm_pc_record1";
            desc = "CPU HPM original code pattern 1";
            sw = r; hw = w;
            reset = 0x0;
        } cpu_hpm_pc_record1[25:16];
        field {
            name = "reserved";
            desc = "Reserved";
            sw = r; hw = na;
            reset = 0x0;
        } reserved_15_10[15:10];
        field {
            name = "cpu_hpm_pc_record0";
            desc = "CPU HPM original code pattern 0";
            sw = r; hw = w;
            reset = 0x0;
        } cpu_hpm_pc_record0[9:0];
    } MISC_CTRL54 @ 0xd8;
    reg {
        name = "MISC_CTRL55";
        desc = "MISC_CTRL55 is HMS status register 1. MISC_CTRL55 (offset 0x00DC, total reset 0x0000_0000; PROVEN: Hi3516D V300 data sheet, PDF page 180, section 3.5.5).";
        field {
            name = "cpu_hpm_rcc";
            desc = "CPU HPM output with RCC code";
            sw = r; hw = w;
            reset = 0x0;
        } cpu_hpm_rcc[31:27];
        field {
            name = "reserved";
            desc = "Reserved";
            sw = r; hw = na;
            reset = 0x0;
        } reserved_26_26[26:26];
        field {
            name = "cpu_hpm_pc_record3";
            desc = "CPU HPM original code pattern 3";
            sw = r; hw = w;
            reset = 0x0;
        } cpu_hpm_pc_record3[25:16];
        field {
            name = "reserved";
            desc = "Reserved";
            sw = r; hw = na;
            reset = 0x0;
        } reserved_15_10[15:10];
        field {
            name = "cpu_hpm_pc_record2";
            desc = "CPU HPM original code pattern 2";
            sw = r; hw = w;
            reset = 0x0;
        } cpu_hpm_pc_record2[9:0];
    } MISC_CTRL55 @ 0xdc;
    reg {
        name = "MISC_CTRL56";
        desc = "SHPM_CTRL56 is the SHPM control register. MISC_CTRL56 (offset 0x00E0, total reset 0x0000_0000; PROVEN: Hi3516D V300 data sheet, PDF page 181, section 3.5.5).";
        field {
            name = "viproc_shpm_stat";
            desc = "SHPM state";
            sw = r; hw = w;
            reset = 0x0;
        } viproc_shpm_stat[31:16];
        field {
            name = "viproc_shpm_cfg";
            desc = "SHPM configuration";
            sw = rw; hw = r;
            reset = 0x0;
        } viproc_shpm_cfg[15:0];
    } MISC_CTRL56 @ 0xe0;
    reg {
        name = "MISC_CTRL57";
        desc = "MISC_CTRL57 is the DDRC lock register. MISC_CTRL57 (offset 0x0100, total reset 0x0000_0000; PROVEN: Hi3516D V300 data sheet, PDF page 181, section 3.5.5).";
        field {
            name = "reserved";
            desc = "Reserved";
            sw = r; hw = na;
            reset = 0x0;
        } reserved_31_6[31:6];
        field {
            name = "ddr_phy_write_lock";
            desc = "Lock control of the DDR PHY register
- 0: The DDR PHY register can be modified.
- 1: The DDR PHY register cannot be modified.";
            sw = rw; hw = r;
            reset = 0x0;
        } ddr_phy_write_lock[5:5];
        field {
            name = "ddr_qosbuf_write_lock";
            desc = "Lock control of the DDR QOSBUF register
- 0: The DDR QOSBUF register can be modified.
- 1: The DDR QOSBUF register cannot be modified.";
            sw = rw; hw = r;
            reset = 0x0;
        } ddr_qosbuf_write_lock[4:4];
        field {
            name = "ddr_addr_atrb_write_lock";
            desc = "Lock control of the DDR ADDR ATRB register
- 0: The DDR ADDR ATRB register can be modified.
- 1: The DDR ADDR ATRB register cannot be modified.";
            sw = rw; hw = r;
            reset = 0x0;
        } ddr_addr_atrb_write_lock[3:3];
        field {
            name = "ddr_dmc_write_lock";
            desc = "Lock control of the DDR DMC register
- 0: The DDR DMC register can be modified.
- 1: The DDR DMC register cannot be modified.";
            sw = rw; hw = r;
            reset = 0x0;
        } ddr_dmc_write_lock[2:2];
        field {
            name = "ddr_axiif_write_lock";
            desc = "Lock control of the DDR AXIIF register
- 0: The DDR AXIIF register can be modified.
- 1: The DDR AXIIF register cannot be modified.";
            sw = rw; hw = r;
            reset = 0x0;
        } ddr_axiif_write_lock[1:1];
        field {
            name = "ddr_secure_boot_loc";
            desc = "Lock control of the DDR secure boot register";
            sw = rw; hw = r;
            reset = 0x0;
        } ddr_secure_boot_loc[0:0];
    } MISC_CTRL57 @ 0x100;
    reg {
        name = "MISC_CTRL58";
        desc = "MISC_CTRL58 is secure access control register 0. MISC_CTRL58 (offset 0x0104, total reset 0x0000_0000; PROVEN: Hi3516D V300 data sheet, PDF page 182, section 3.5.5).";
        field {
            name = "fmc_mem_slv_sec_acc_disable";
            desc = "Secure access switch of the FMC MEM
- 0: enabled
- 1: disabled";
            sw = rw; hw = r;
            reset = 0x0;
        } fmc_mem_slv_sec_acc_disable[31:31];
        field {
            name = "fmc_reg_slv_sec_acc_disable";
            desc = "Secure access switch of the FMC register
- 0: enabled
- 1: disabled";
            sw = rw; hw = r;
            reset = 0x0;
        } fmc_reg_slv_sec_acc_disable[30:30];
        field {
            name = "emmc_slv_sec_acc_disable";
            desc = "Secure access switch of the eMMC register
- 0: enabled
- 1: disabled";
            sw = rw; hw = r;
            reset = 0x0;
        } emmc_slv_sec_acc_disable[29:29];
        field {
            name = "sdio0_slv_sec_acc_disable";
            desc = "Secure access switch of the SDIO0 register
- 0: enabled
- 1: disabled";
            sw = rw; hw = r;
            reset = 0x0;
        } sdio0_slv_sec_acc_disable[28:28];
        field {
            name = "usb2_slv_sec_acc_disable";
            desc = "Secure access switch of the USB 2.0 register
- 0: enabled
- 1: disabled";
            sw = rw; hw = r;
            reset = 0x0;
        } usb2_slv_sec_acc_disable[27:27];
        field {
            name = "bootram_slv_sec_acc_disable";
            desc = "Secure access switch of the BootROM or BootRAM
- 0: enabled
- 1: disabled";
            sw = rw; hw = r;
            reset = 0x0;
        } bootram_slv_sec_acc_disable[26:26];
        field {
            name = "scd_slv_sec_acc_disable";
            desc = "Secure access switch of the SCD register
- 0: enabled
- 1: disabled";
            sw = rw; hw = r;
            reset = 0x0;
        } scd_slv_sec_acc_disable[25:25];
        field {
            name = "sdio1_slv_sec_acc_disable";
            desc = "Secure access switch of the SDIO1 register
- 0: enabled
- 1: disabled";
            sw = rw; hw = r;
            reset = 0x0;
        } sdio1_slv_sec_acc_disable[24:24];
        field {
            name = "eth_slv_sec_acc_disable";
            desc = "Secure access switch of the ETH register";
            sw = rw; hw = r;
            reset = 0x0;
        } eth_slv_sec_acc_disable[23:23];
        field {
            name = "mipitx_slv_sec_acc_disable";
            desc = "Secure access switch of the MIPI TX register
- 0: enabled
- 1: disabled";
            sw = rw; hw = r;
            reset = 0x0;
        } mipitx_slv_sec_acc_disable[22:22];
        field {
            name = "jpgd_slv_sec_acc_disable";
            desc = "Secure access switch of the JPGD register
- 0: enabled
- 1: disabled";
            sw = rw; hw = r;
            reset = 0x0;
        } jpgd_slv_sec_acc_disable[21:21];
        field {
            name = "ddrt_slv_sec_acc_disable";
            desc = "Secure access switch of the DDRT register
- 0: enabled
- 1: disabled";
            sw = rw; hw = r;
            reset = 0x0;
        } ddrt_slv_sec_acc_disable[20:20];
        field {
            name = "gzip_slv_sec_acc_disable";
            desc = "Secure access switch of the GZIP register
- 0: enabled
- 1: disabled";
            sw = rw; hw = r;
            reset = 0x0;
        } gzip_slv_sec_acc_disable[19:19];
        field {
            name = "tde_slv_sec_acc_disable";
            desc = "Secure access switch of the TDE register
- 0: enabled
- 1: disabled";
            sw = rw; hw = r;
            reset = 0x0;
        } tde_slv_sec_acc_disable[18:18];
        field {
            name = "ive_slv_sec_acc_disable";
            desc = "Secure access switch of the IVE register
- 0: enabled
- 1: disabled";
            sw = rw; hw = r;
            reset = 0x0;
        } ive_slv_sec_acc_disable[17:17];
        field {
            name = "jpge_slv_sec_acc_disable";
            desc = "Secure access switch of the JPGE register
- 0: enabled
- 1: disabled";
            sw = rw; hw = r;
            reset = 0x0;
        } jpge_slv_sec_acc_disable[16:16];
        field {
            name = "vgs_slv_sec_acc_disable";
            desc = "Secure access switch of the VGS register
- 0: enabled
- 1: disabled";
            sw = rw; hw = r;
            reset = 0x0;
        } vgs_slv_sec_acc_disable[15:15];
        field {
            name = "powerctrl_slv_sec_acc_disable";
            desc = "Secure access switch of the power control register
- 0: enabled
- 1: disabled";
            sw = rw; hw = r;
            reset = 0x0;
        } powerctrl_slv_sec_acc_disable[14:14];
        field {
            name = "rtc_slv_sec_acc_disable";
            desc = "Secure access switch of the RTC register
- 0: enabled
- 1: disabled";
            sw = rw; hw = r;
            reset = 0x0;
        } rtc_slv_sec_acc_disable[13:13];
        field {
            name = "ddrsubsys_slv_sec_acc_disable";
            desc = "Secure access switch of the MDDRC register
- 0: enabled
- 1: disabled";
            sw = rw; hw = r;
            reset = 0x0;
        } ddrsubsys_slv_sec_acc_disable[12:12];
        field {
            name = "crg_slv_sec_acc_dis";
            desc = "Secure access switch of the CRG register";
            sw = rw; hw = r;
            reset = 0x0;
        } crg_slv_sec_acc_dis[11:11];
        field {
            name = "wdg1_slv_sec_acc_disable";
            desc = "Secure access switch of the WDG1 register
- 0: enabled
- 1: disabled";
            sw = rw; hw = r;
            reset = 0x0;
        } wdg1_slv_sec_acc_disable[10:10];
        field {
            name = "wdg0_slv_sec_acc_disable";
            desc = "Secure access switch of the WDG0 register
- 0: enabled
- 1: disabled";
            sw = rw; hw = r;
            reset = 0x0;
        } wdg0_slv_sec_acc_disable[9:9];
        field {
            name = "uart4_slv_sec_acc_disable";
            desc = "Secure access switch of the UART4 register
- 0: enabled
- 1: disabled";
            sw = rw; hw = r;
            reset = 0x0;
        } uart4_slv_sec_acc_disable[8:8];
        field {
            name = "uart3_slv_sec_acc_disable";
            desc = "Secure access switch of the UART3 register
- 0: enabled
- 1: disabled";
            sw = rw; hw = r;
            reset = 0x0;
        } uart3_slv_sec_acc_disable[7:7];
        field {
            name = "uart2_slv_sec_acc_disable";
            desc = "Secure access switch of the UART2 register
- 0: enabled
- 1: disabled";
            sw = rw; hw = r;
            reset = 0x0;
        } uart2_slv_sec_acc_disable[6:6];
        field {
            name = "uart1_slv_sec_acc_disable";
            desc = "Secure access switch of the UART1 register
- 0: enabled
- 1: disabled";
            sw = rw; hw = r;
            reset = 0x0;
        } uart1_slv_sec_acc_disable[5:5];
        field {
            name = "uart0_slv_sec_acc_disable";
            desc = "Secure access switch of the UART0 register
- 0: enabled
- 1: disabled";
            sw = rw; hw = r;
            reset = 0x0;
        } uart0_slv_sec_acc_disable[4:4];
        field {
            name = "timer67_slv_sec_acc_disable";
            desc = "Secure access switch of the Timer 6 or Timer 7 register
- 0: enabled
- 1: disabled";
            sw = rw; hw = r;
            reset = 0x0;
        } timer67_slv_sec_acc_disable[3:3];
        field {
            name = "timer45_slv_sec_acc_disable";
            desc = "Secure access switch of the Timer 4 or Timer 5 register
- 0: enabled
- 1: disabled";
            sw = rw; hw = r;
            reset = 0x0;
        } timer45_slv_sec_acc_disable[2:2];
        field {
            name = "timer23_slv_sec_acc_disable";
            desc = "Secure access switch of the Timer 2 or Timer 3 register
- 0: enabled
- 1: disabled";
            sw = rw; hw = r;
            reset = 0x0;
        } timer23_slv_sec_acc_disable[1:1];
        field {
            name = "timer01_slv_sec_acc_disable";
            desc = "Secure access switch of the Timer 0 or Timer 1 register
- 0: enabled";
            sw = rw; hw = r;
            reset = 0x0;
        } timer01_slv_sec_acc_disable[0:0];
    } MISC_CTRL58 @ 0x104;
    reg {
        name = "MISC_CTRL59";
        desc = "MISC_CTRL59 is secure access control register 1. MISC_CTRL59 (offset 0x0108, total reset 0x0000_0000; PROVEN: Hi3516D V300 data sheet, PDF page 185, section 3.5.5).";
        field {
            name = "reserved";
            desc = "Reserved";
            sw = r; hw = na;
            reset = 0x0;
        } reserved_31_18[31:18];
        field {
            name = "vedu_slv_sec_acc_disable";
            desc = "Secure access switch of the VEDU register
- 0: enabled
- 1: disabled";
            sw = rw; hw = r;
            reset = 0x0;
        } vedu_slv_sec_acc_disable[17:17];
        field {
            name = "gdc_slv_sec_acc_disable";
            desc = "Secure access switch of the GDC register
- 0: enabled
- 1: disabled";
            sw = rw; hw = r;
            reset = 0x0;
        } gdc_slv_sec_acc_disable[16:16];
        field {
            name = "nnie_slv_sec_acc_disable";
            desc = "Secure access switch of the NNIE register
- 0: enabled
- 1: disabled";
            sw = rw; hw = r;
            reset = 0x0;
        } nnie_slv_sec_acc_disable[15:15];
        field {
            name = "vpss_slv_sec_acc_disable";
            desc = "Secure access switch of the VPSS register
- 0: enabled
- 1: disabled";
            sw = rw; hw = r;
            reset = 0x0;
        } vpss_slv_sec_acc_disable[14:14];
        field {
            name = "viproc_slv_sec_acc_disable";
            desc = "Secure access switch of the VIPROC register
- 0: enabled
- 1: disabled";
            sw = rw; hw = r;
            reset = 0x0;
        } viproc_slv_sec_acc_disable[13:13];
        field {
            name = "audiocodec_slv_sec_acc_disable";
            desc = "Secure access switch of the audio codec register
- 0: enabled
- 1: disabled";
            sw = rw; hw = r;
            reset = 0x0;
        } audiocodec_slv_sec_acc_disable[12:12];
        field {
            name = "aio_slv_sec_acc_disable";
            desc = "Secure access switch of the AIAO register
- 0: enabled
- 1: disabled";
            sw = rw; hw = r;
            reset = 0x0;
        } aio_slv_sec_acc_disable[11:11];
        field {
            name = "hdmitx_slv_sec_acc_disable";
            desc = "Secure access switch of the HDMITX register
- 0: enabled
- 1: disabled";
            sw = rw; hw = r;
            reset = 0x0;
        } hdmitx_slv_sec_acc_disable[10:10];
        field {
            name = "vdp_slv_sec_acc_disable";
            desc = "Secure access switch of the VDP register
- 0: enabled
- 1: disabled";
            sw = rw; hw = r;
            reset = 0x0;
        } vdp_slv_sec_acc_disable[9:9];
        field {
            name = "mipirx_slv_sec_acc_disable";
            desc = "Secure access switch of the MIPI RX register
- 0: enabled
- 1: disabled";
            sw = rw; hw = r;
            reset = 0x0;
        } mipirx_slv_sec_acc_disable[8:8];
        field {
            name = "vicap_slv_sec_acc_disable";
            desc = "Secure access switch of the VICAP register
- 0: enabled
- 1: disabled";
            sw = rw; hw = r;
            reset = 0x0;
        } vicap_slv_sec_acc_disable[7:7];
        field {
            name = "klad_slv_sec_acc_disable";
            desc = "Secure access switch of the KLAD register
- 0: enabled
- 1: disabled";
            sw = rw; hw = r;
            reset = 0x0;
        } klad_slv_sec_acc_disable[6:6];
        field {
            name = "dmac_slv_sec_acc_disable";
            desc = "Secure access switch of the DMAC register
- 0: enabled
- 1: disabled";
            sw = rw; hw = r;
            reset = 0x0;
        } dmac_slv_sec_acc_disable[5:5];
        field {
            name = "otp_slv_sec_acc_disable";
            desc = "Secure access switch of the OTP register
- 0: enabled
- 1: disabled";
            sw = rw; hw = r;
            reset = 0x0;
        } otp_slv_sec_acc_disable[4:4];
        field {
            name = "trng_slv_sec_acc_disable";
            desc = "Secure access switch of the TRNG register
- 0: enabled
- 1: disabled";
            sw = rw; hw = r;
            reset = 0x0;
        } trng_slv_sec_acc_disable[3:3];
        field {
            name = "rsa1_slv_sec_acc_disable";
            desc = "Secure access switch of the RSA1 register
- 0: enabled
- 1: disabled";
            sw = rw; hw = r;
            reset = 0x0;
        } rsa1_slv_sec_acc_disable[2:2];
        field {
            name = "rsa0_slv_sec_acc_disable";
            desc = "Secure access switch of the RSA0 register
- 0: enabled
- 1: disabled";
            sw = rw; hw = r;
            reset = 0x0;
        } rsa0_slv_sec_acc_disable[1:1];
        field {
            name = "spacc_slv_sec_acc_disable";
            desc = "Secure access switch of the SPACC register
- 0: enabled
- 1: disabled";
            sw = rw; hw = r;
            reset = 0x0;
        } spacc_slv_sec_acc_disable[0:0];
    } MISC_CTRL59 @ 0x108;
    reg {
        name = "MISC_CTRL60";
        desc = "MISC_CTRL60 is secure access control register 2. MISC_CTRL60 (offset 0x010C, total reset 0x0000_0000; PROVEN: Hi3516D V300 data sheet, PDF page 186, section 3.5.5).";
        field {
            name = "reserved";
            desc = "Reserved";
            sw = r; hw = na;
            reset = 0x0;
        } reserved_31_23[31:23];
        field {
            name = "mipitx_slv_acc_ctrl";
            desc = "Secure access control mode of the MIPI TX";
            sw = rw; hw = r;
            reset = 0x0;
        } mipitx_slv_acc_ctrl[22:22];
        field {
            name = "jpgd_slv_acc_ctrl";
            desc = "Secure access control mode of the JPGD register
- 0: common secure access control
- 1: forcibly requiring that the JPGD register cannot be modified by the non-secure CPU";
            sw = rw; hw = r;
            reset = 0x0;
        } jpgd_slv_acc_ctrl[21:21];
        field {
            name = "ddrt_slv_acc_ctrl";
            desc = "Secure access control mode of the DDRT register
- 0: common secure access control
- 1: forcibly requiring that the DDRT register cannot be modified by the non-secure CPU";
            sw = rw; hw = r;
            reset = 0x0;
        } ddrt_slv_acc_ctrl[20:20];
        field {
            name = "gzip_slv_acc_ctrl";
            desc = "Secure access control mode of the GZIP register
- 0: common secure access control
- 1: forcibly requiring that the GZIP register cannot be modified by the non-secure CPU";
            sw = rw; hw = r;
            reset = 0x0;
        } gzip_slv_acc_ctrl[19:19];
        field {
            name = "tde_slv_acc_ctrl";
            desc = "Secure access control mode of the TDE register
- 0: common secure access control
- 1: forcibly requiring that the TDE register cannot be modified by the non-secure CPU";
            sw = rw; hw = r;
            reset = 0x0;
        } tde_slv_acc_ctrl[18:18];
        field {
            name = "ive_slv_acc_ctrl";
            desc = "Secure access control mode of the IVE register
- 0: common secure access control
- 1: forcibly requiring that the IVE register cannot be modified by the non-secure CPU";
            sw = rw; hw = r;
            reset = 0x0;
        } ive_slv_acc_ctrl[17:17];
        field {
            name = "jpge_slv_acc_ctrl";
            desc = "Secure access control mode of the JPGE register
- 0: common secure access control
- 1: forcibly requiring that the JPGE register cannot be modified by the non-secure CPU";
            sw = rw; hw = r;
            reset = 0x0;
        } jpge_slv_acc_ctrl[16:16];
        field {
            name = "vgs_slv_acc_ctrl";
            desc = "Secure access control mode of the VGS register
- 0: common secure access control
- 1: forcibly requiring that the VGS register cannot be modified by the non-secure CPU";
            sw = rw; hw = r;
            reset = 0x0;
        } vgs_slv_acc_ctrl[15:15];
        field {
            name = "powerctrl_slv_acc_ctrl";
            desc = "Secure access control mode of the power control register";
            sw = rw; hw = r;
            reset = 0x0;
        } powerctrl_slv_acc_ctrl[14:14];
        field {
            name = "rtc_slv_acc_ctrl";
            desc = "Secure access control mode of the RTC register
- 0: common secure access control
- 1: forcibly requiring that the RTC register cannot be modified by the non-secure CPU";
            sw = rw; hw = r;
            reset = 0x0;
        } rtc_slv_acc_ctrl[13:13];
        field {
            name = "ddrsubsys_slv_acc_ctrl";
            desc = "Secure access control mode of the MDDRC or DDRPHY register
- 0: common secure access control
- 1: forcibly requiring that the MDDRC or

DDRPHY register cannot be modified by the non-secure CPU";
            sw = rw; hw = r;
            reset = 0x0;
        } ddrsubsys_slv_acc_ctrl[12:12];
        field {
            name = "crg_slv_acc_ctrl";
            desc = "Secure access control mode of the CRG register
- 0: common secure access control
- 1: forcibly requiring that the CRG register cannot be modified by the non-secure CPU";
            sw = rw; hw = r;
            reset = 0x0;
        } crg_slv_acc_ctrl[11:11];
        field {
            name = "wdg1_slv_acc_ctrl";
            desc = "Secure access control mode of the WDG1 register
- 0: common secure access control
- 1: forcibly requiring that the WDG1 register cannot be modified by the non-secure CPU";
            sw = rw; hw = r;
            reset = 0x0;
        } wdg1_slv_acc_ctrl[10:10];
        field {
            name = "wdg0_slv_acc_ctrl";
            desc = "Secure access control mode of the WDG0 register
- 0: common secure access control
- 1: forcibly requiring that the WDG0 register cannot be modified by the non-secure CPU";
            sw = rw; hw = r;
            reset = 0x0;
        } wdg0_slv_acc_ctrl[9:9];
        field {
            name = "uart4_slv_acc_ctrl";
            desc = "Secure access control mode of the UART4 register
- 0: common secure access control
- 1: forcibly requiring that the UART4 register cannot be modified by the non-secure CPU";
            sw = rw; hw = r;
            reset = 0x0;
        } uart4_slv_acc_ctrl[8:8];
        field {
            name = "uart3_slv_acc_ctrl";
            desc = "Secure access control mode of the UART3 register
- 0: common secure access control
- 1: forcibly requiring that the UART4 register cannot be modified by the non-secure CPU";
            sw = rw; hw = r;
            reset = 0x0;
        } uart3_slv_acc_ctrl[7:7];
        field {
            name = "uart2_slv_acc_ctrl";
            desc = "Secure access control mode of the UART2 register";
            sw = rw; hw = r;
            reset = 0x0;
        } uart2_slv_acc_ctrl[6:6];
        field {
            name = "uart1_slv_acc_ctrl";
            desc = "Secure access control mode of the UART1 register
- 0: common secure access control
- 1: forcibly requiring that the UART1 register cannot be modified by the non-secure CPU";
            sw = rw; hw = r;
            reset = 0x0;
        } uart1_slv_acc_ctrl[5:5];
        field {
            name = "uart0_slv_acc_ctrl";
            desc = "Secure access control mode of the UART0 register
- 0: common secure access control
- 1: forcibly requiring that the UART0 register cannot be modified by the non-secure CPU";
            sw = rw; hw = r;
            reset = 0x0;
        } uart0_slv_acc_ctrl[4:4];
        field {
            name = "timer67_slv_acc_ctrl";
            desc = "Secure access control mode of the Timer 6 or Timer 7 register
- 0: common secure access control
- 1: forcibly requiring that the Timer 6 or Timer 7 register cannot be modified by the non-secure CPU";
            sw = rw; hw = r;
            reset = 0x0;
        } timer67_slv_acc_ctrl[3:3];
        field {
            name = "timer45_slv_acc_ctrl";
            desc = "Secure access control mode of the Timer 4 or Timer 5 register
- 0: common secure access control
- 1: forcibly requiring that the Timer 4 or Timer 5 register cannot be modified by the non-secure CPU";
            sw = rw; hw = r;
            reset = 0x0;
        } timer45_slv_acc_ctrl[2:2];
        field {
            name = "timer23_slv_acc_ctrl";
            desc = "Secure access control mode of the Timer 2 or Timer 3 register
- 0: common secure access control
- 1: forcibly requiring that the Timer 2 or Timer 3 register cannot be modified by the non-secure CPU";
            sw = rw; hw = r;
            reset = 0x0;
        } timer23_slv_acc_ctrl[1:1];
        field {
            name = "timer01_slv_acc_ctrl";
            desc = "Secure access control mode of the Timer 0 or Timer 1 register
- 0: common secure access control
- 1: forcibly requiring that the Timer 0 or Timer 1 register cannot be modified by the non-secure CPU";
            sw = rw; hw = r;
            reset = 0x0;
        } timer01_slv_acc_ctrl[0:0];
    } MISC_CTRL60 @ 0x10c;
    reg {
        name = "MISC_CTRL61";
        desc = "MISC_CTRL61 is secure access control register 3. MISC_CTRL61 (offset 0x0110, total reset 0x0000_0000; PROVEN: Hi3516D V300 data sheet, PDF page 189, section 3.5.5).";
        field {
            name = "reserved";
            desc = "Reserved";
            sw = r; hw = na;
            reset = 0x0;
        } reserved_31_18[31:18];
        field {
            name = "vedu_slv_acc_ctrl";
            desc = "Secure access control mode of the VEDU register
- 0: common secure access control
- 1: forcible requirement that the VEDU register cannot be modified by the non-secure CPU";
            sw = rw; hw = r;
            reset = 0x0;
        } vedu_slv_acc_ctrl[17:17];
        field {
            name = "gdc_slv_acc_ctrl";
            desc = "Secure access control mode of the GDC register
- 0: common secure access control
- 1: forcibly requiring that the GDC register cannot be modified by the non-secure CPU";
            sw = rw; hw = r;
            reset = 0x0;
        } gdc_slv_acc_ctrl[16:16];
        field {
            name = "nnie_slv_acc_ctrl";
            desc = "Secure access control mode of the NNIE register
- 0: common secure access control
- 1: forcibly requiring that the NNIE register cannot be modified by the non-secure CPU";
            sw = rw; hw = r;
            reset = 0x0;
        } nnie_slv_acc_ctrl[15:15];
        field {
            name = "vpss_slv_acc_ctrl";
            desc = "Secure access control mode of the VPSS register
- 0: common secure access control
- 1: forcibly requiring that the VPSS register cannot be modified by the non-secure CPU";
            sw = rw; hw = r;
            reset = 0x0;
        } vpss_slv_acc_ctrl[14:14];
        field {
            name = "viproc_slv_acc_ctrl";
            desc = "Secure access control mode of the VIPROC register
- 0: common secure access control
- 1: forcibly requiring that the VIPROC register cannot be modified by the non-secure CPU";
            sw = rw; hw = r;
            reset = 0x0;
        } viproc_slv_acc_ctrl[13:13];
        field {
            name = "audiocodec_slv_acc_ctrl";
            desc = "Secure access control mode of the audio codec register
- 0: common secure access control
- 1: forcibly requiring that the audio codec register cannot be modified by the non-secure

CPU";
            sw = rw; hw = r;
            reset = 0x0;
        } audiocodec_slv_acc_ctrl[12:12];
        field {
            name = "aio_slv_acc_ctrl";
            desc = "Secure access control mode of the AIAO register
- 0: common secure access control
- 1: forcibly requiring that the AIAO register cannot be modified by the non-secure CPU";
            sw = rw; hw = r;
            reset = 0x0;
        } aio_slv_acc_ctrl[11:11];
        field {
            name = "hdmitx_slv_acc_ctrl";
            desc = "Secure access control mode of the HDMITX register
- 0: common secure access control
- 1: forcibly requiring that the AIAO register";
            sw = rw; hw = r;
            reset = 0x0;
        } hdmitx_slv_acc_ctrl[10:10];
        field {
            name = "vdp_slv_acc_ctrl";
            desc = "Secure access control mode of the VDP register
- 0: common secure access control
- 1: forcibly requiring that the VDP register cannot be modified by the non-secure CPU";
            sw = rw; hw = r;
            reset = 0x0;
        } vdp_slv_acc_ctrl[9:9];
        field {
            name = "mipirx_slv_acc_ctrl";
            desc = "Secure access control mode of the MIPI RX register
- 0: common secure access control
- 1: forcibly requiring that the MIPI RX register cannot be modified by the non-secure CPU";
            sw = rw; hw = r;
            reset = 0x0;
        } mipirx_slv_acc_ctrl[8:8];
        field {
            name = "vicap_slv_acc_ctrl";
            desc = "Secure access control mode of the VICAP register
- 0: common secure access control
- 1: forcibly requiring that the VICAP register cannot be modified by the non-secure CPU";
            sw = rw; hw = r;
            reset = 0x0;
        } vicap_slv_acc_ctrl[7:7];
        field {
            name = "klad_slv_acc_ctrl";
            desc = "Secure access control mode of the KLAD register
- 0: common secure access control
- 1: forcibly requiring that the KLAD register cannot be modified by the non-secure CPU";
            sw = rw; hw = r;
            reset = 0x0;
        } klad_slv_acc_ctrl[6:6];
        field {
            name = "dmac_slv_acc_ctrl";
            desc = "Secure access control mode of the DMAC register
- 0: common secure access control
- 1: forcibly requiring that the DMAC register cannot be modified by the non-secure CPU";
            sw = rw; hw = r;
            reset = 0x0;
        } dmac_slv_acc_ctrl[5:5];
        field {
            name = "otp_slv_acc_ctrl";
            desc = "Secure access control mode of the OTP register
- 0: common secure access control
- 1: forcibly requiring that the OTP register cannot be modified by the non-secure CPU";
            sw = rw; hw = r;
            reset = 0x0;
        } otp_slv_acc_ctrl[4:4];
        field {
            name = "trng_slv_acc_ctrl";
            desc = "Secure access control mode of the TRNG register
- 0: common secure access control
- 1: forcibly requiring that the TRNG register cannot be modified by the non-secure CPU";
            sw = rw; hw = r;
            reset = 0x0;
        } trng_slv_acc_ctrl[3:3];
        field {
            name = "rsa1_slv_acc_ctrl";
            desc = "Secure access control mode of the RSA1 register
- 0: common secure access control
- 1: forcibly requiring that the RSA1 register cannot be modified by the non-secure CPU";
            sw = rw; hw = r;
            reset = 0x0;
        } rsa1_slv_acc_ctrl[2:2];
        field {
            name = "rsa0_slv_acc_ctrl";
            desc = "Secure access control mode of the RSA0 register
- 0: common secure access control
- 1: forcibly requiring that the RSA0 register cannot be modified by the non-secure CPU";
            sw = rw; hw = r;
            reset = 0x0;
        } rsa0_slv_acc_ctrl[1:1];
        field {
            name = "spacc_slv_acc_ctrl";
            desc = "Secure access control mode of the SPACC register
- 0: common secure access control
- 1: forcibly requiring that the SPACC register cannot be modified by the non-secure CPU";
            sw = rw; hw = r;
            reset = 0x0;
        } spacc_slv_acc_ctrl[0:0];
    } MISC_CTRL61 @ 0x110;
    reg {
        name = "MISC_CTRL62";
        desc = "MISC_CTRL62 is secure access control register 4. MISC_CTRL62 (offset 0x0114, total reset 0x0000_0000; PROVEN: Hi3516D V300 data sheet, PDF page 192, section 3.5.5).";
        field {
            name = "reserved";
            desc = "Reserved";
            sw = r; hw = na;
            reset = 0x0;
        } reserved_31_18[31:18];
        field {
            name = "fmc_mst_sec_acc";
            desc = "Access security attribute setting of the FMC master
- 0: secure access
- 1: non-secure access";
            sw = rw; hw = r;
            reset = 0x0;
        } fmc_mst_sec_acc[17:17];
        field {
            name = "emmc_mst_sec_acc";
            desc = "Access security attribute setting of the eMMC master
- 0: secure access
- 1: non-secure access";
            sw = rw; hw = r;
            reset = 0x0;
        } emmc_mst_sec_acc[16:16];
        field {
            name = "sdio1_mst_sec_acc";
            desc = "Access security attribute setting of the SDIO1 master
- 0: secure access
- 1: non-secure access";
            sw = rw; hw = r;
            reset = 0x0;
        } sdio1_mst_sec_acc[15:15];
        field {
            name = "scd_mst_sec_acc";
            desc = "Access security attribute setting of the SCD master
- 0: secure access
- 1: non-secure access";
            sw = rw; hw = r;
            reset = 0x0;
        } scd_mst_sec_acc[14:14];
        field {
            name = "sdio0_mst_sec_acc";
            desc = "Access security attribute setting of the SDIO0 master
- 0: secure access
- 1: non-secure access";
            sw = rw; hw = r;
            reset = 0x0;
        } sdio0_mst_sec_acc[13:13];
        field {
            name = "eth_mst_sec_acc";
            desc = "Access security attribute setting of the ETH";
            sw = rw; hw = r;
            reset = 0x0;
        } eth_mst_sec_acc[12:12];
        field {
            name = "aiao_mst_r_sec_acc";
            desc = "Security attribute setting of the AIAO master read operation
- 0: secure access
- 1: non-secure access";
            sw = rw; hw = r;
            reset = 0x0;
        } aiao_mst_r_sec_acc[11:11];
        field {
            name = "aiao_mst_w_sec_acc";
            desc = "Security attribute setting of the AIAO master write operation
- 0: secure access
- 1: non-secure access";
            sw = rw; hw = r;
            reset = 0x0;
        } aiao_mst_w_sec_acc[10:10];
        field {
            name = "jpgd_mst_r_sec_acc";
            desc = "Security attribute setting of the JPGD master read operation
- 0: secure access
- 1: non-secure access";
            sw = rw; hw = r;
            reset = 0x0;
        } jpgd_mst_r_sec_acc[9:9];
        field {
            name = "jpgd_mst_w_sec_acc";
            desc = "Security attribute setting of the JPGD master write operation
- 0: secure access
- 1: non-secure access";
            sw = rw; hw = r;
            reset = 0x0;
        } jpgd_mst_w_sec_acc[8:8];
        field {
            name = "usb2_mst_r_sec_acc";
            desc = "Security attribute setting of the USB master read operation
- 0: secure access
- 1: non-secure access";
            sw = rw; hw = r;
            reset = 0x0;
        } usb2_mst_r_sec_acc[7:7];
        field {
            name = "usb2_mst_w_sec_acc";
            desc = "Security attribute setting of the USB master write operation
- 0: secure access
- 1: non-secure access";
            sw = rw; hw = r;
            reset = 0x0;
        } usb2_mst_w_sec_acc[6:6];
        field {
            name = "gzip_mst_r_sec_acc";
            desc = "Security attribute setting of the GZIP master read operation
- 0: secure access
- 1: non-secure access";
            sw = rw; hw = r;
            reset = 0x0;
        } gzip_mst_r_sec_acc[5:5];
        field {
            name = "gzip_mst_w_sec_acc";
            desc = "Security attribute setting of the GZIP master write operation
- 0: secure access
- 1: non-secure access";
            sw = rw; hw = r;
            reset = 0x0;
        } gzip_mst_w_sec_acc[4:4];
        field {
            name = "tde_mst_r_sec_acc";
            desc = "Security attribute setting of the TDE master read operation
- 0: secure access
- 1: non-secure access";
            sw = rw; hw = r;
            reset = 0x0;
        } tde_mst_r_sec_acc[3:3];
        field {
            name = "tde_mst_w_sec_acc";
            desc = "Security attribute setting of the TDE master write operation
- 0: secure access
- 1: non-secure access";
            sw = rw; hw = r;
            reset = 0x0;
        } tde_mst_w_sec_acc[2:2];
        field {
            name = "ive_mst_r_sec_acc";
            desc = "Security attribute setting of the IVE master read operation
- 0: secure access
- 1: non-secure access";
            sw = rw; hw = r;
            reset = 0x0;
        } ive_mst_r_sec_acc[1:1];
        field {
            name = "ive_mst_w_sec_acc";
            desc = "Security attribute setting of the IVE master write operation
- 0: secure access
- 1: non-secure access";
            sw = rw; hw = r;
            reset = 0x0;
        } ive_mst_w_sec_acc[0:0];
    } MISC_CTRL62 @ 0x114;
    reg {
        name = "MISC_CTRL63";
        desc = "MISC_CTRL63 is secure access control register 5. MISC_CTRL63 (offset 0x0118, total reset 0x0000_0000; PROVEN: Hi3516D V300 data sheet, PDF page 194, section 3.5.5).";
        field {
            name = "reserved";
            desc = "Reserved";
            sw = r; hw = na;
            reset = 0x0;
        } reserved_31_2[31:2];
        field {
            name = "a7_cp15sdisable";
            desc = "Disabling modification of some CPU CP15 registers, active high";
            sw = rw; hw = r;
            reset = 0x0;
        } a7_cp15sdisable[1:0];
    } MISC_CTRL63 @ 0x118;
};

`endif
