`ifndef EHI3516DV300_USB2_PHY_RDL
`define EHI3516DV300_USB2_PHY_RDL
regfile eHI3516DV300_USB2_PHY {
    name = "USB 2.0 PHY";
    desc = "USB 2.0 PHY. 4 registers extracted programmatically from the Hi3516D V300 Professional Smart IP Camera SoC data sheet (Issue 01, 2019-09-12); chapter 12.8.5, table 12-29. Field names, bit ranges, access types and reset values are taken from the register tables; reset values are the data sheet total reset values split onto the fields (per-field values where the table has them). Label: PROVEN. Hardware not verified here (no board).";
    reg {
        name = "USB2_PHY_PRE_EMPHASIS_EN";
        desc = "USB2_PHY_PRE_EMPHASIS_EN is the USB 2.0 PHY pre-emphasis switch register. USB2_PHY_PRE_EMPHASIS_EN (offset 0x0000, total reset 0x0000_001F; PROVEN: Hi3516D V300 data sheet, PDF page 967, section 12.8.5).";
        field {
            name = "reserved";
            desc = "Reserved";
            sw = r; hw = na;
            reset = 0x3;
        } reserved_31_3[31:3];
        field {
            name = "usb2_phy_unchirp_emphasis_en";
            desc = "Pre-emphasis enable in non-chirp mode
- 0: disabled
- 1: enabled";
            sw = rw; hw = r;
            reset = 0x1;
        } usb2_phy_unchirp_emphasis_en[2:2];
        field {
            name = "usb2_phy_chirp_pre_emphasis_en";
            desc = "Pre-emphasis enable in chirp mode.
- 0: disabled
- 1: enabled";
            sw = rw; hw = r;
            reset = 0x1;
        } usb2_phy_chirp_pre_emphasis_en[1:1];
        field {
            name = "usb2_phy_sof_eop_pre_emphasis_en";
            desc = "SOF and EOP pre-emphasis enable
- 0: disabled
- 1: enabled";
            sw = rw; hw = r;
            reset = 0x1;
        } usb2_phy_sof_eop_pre_emphasis_en[0:0];
    } USB2_PHY_PRE_EMPHASIS_EN @ 0x0;
    reg {
        name = "USB2_PHY_EYE_HEIGHT_TUNING";
        desc = "USB2_PHY_EYE_HEIGHT_TUNING is the USB 2.0 PHY amplitude configuration register. USB2_PHY_EYE_HEIGHT_TUNING (offset 0x0008, total reset 0x0000_005C; PROVEN: Hi3516D V300 data sheet, PDF page 968, section 12.8.5).";
        field {
            name = "reserved";
            desc = "Reserved";
            sw = r; hw = na;
            reset = 0x0;
        } reserved_31_7[31:7];
        field {
            name = "usb2_phy_eye_height_tuning";
            desc = "The reference values of the amplitude configurations indicate a trend, but not the actual values.
- 000: 400 mV";
            sw = rw; hw = r;
            reset = 0x5;
        } usb2_phy_eye_height_tuning[6:4];
        field {
            name = "reserved";
            desc = "Reserved";
            sw = r; hw = na;
            reset = 0xc;
        } reserved_3_0[3:0];
    } USB2_PHY_EYE_HEIGHT_TUNING @ 0x8;
    reg {
        name = "USB2_PHY_PRE_EMPHASIS_STRENGTH";
        desc = "USB2_PHY_PRE_EMPHASIS_STRENGTH is the USB 2.0 PHY pre-emphasis strength configuration register. USB2_PHY_PRE_EMPHASIS_STRENGTH (offset 0x0014, total reset 0x0000_004C; PROVEN: Hi3516D V300 data sheet, PDF page 968, section 12.8.5).";
        field {
            name = "reserved";
            desc = "Reserved";
            sw = r; hw = na;
            reset = 0x2;
        } reserved_31_5[31:5];
        field {
            name = "usb2_phy_pre_emphasis_strength";
            desc = "Pre-emphasis strength
- 111: highest pre-emphasis strength
- 000: lowest pre-emphasis strength

The weights are 6:3:2 in descending order.";
            sw = rw; hw = r;
            reset = 0x3;
        } usb2_phy_pre_emphasis_strength[4:2];
        field {
            name = "reserved";
            desc = "Reserved";
            sw = r; hw = na;
            reset = 0x0;
        } reserved_1_0[1:0];
    } USB2_PHY_PRE_EMPHASIS_STRENGTH @ 0x14;
    reg {
        name = "USB2_SLEW_RATE_TUING";
        desc = "USB2_SLEW_RATE_TUING is the USB 2.0 PHY slew rate tuning register. USB2_SLEW_RATE_TUING (offset 0x0074, total reset 0x0000_001E; PROVEN: Hi3516D V300 data sheet, PDF page 969, section 12.8.5).";
        field {
            name = "reserved";
            desc = "Reserved";
            sw = r; hw = na;
            reset = 0x1;
        } reserved_31_4[31:4];
        field {
            name = "usb2_slew_rate_tuning";
            desc = "Eye pattern slew rate
- 001: lowest slew rate
- 111: highest slew rate";
            sw = rw; hw = r;
            reset = 0x7;
        } usb2_slew_rate_tuning[3:1];
        field {
            name = "reserved";
            desc = "Reserved";
            sw = r; hw = na;
            reset = 0x0;
        } reserved_0_0[0:0];
    } USB2_SLEW_RATE_TUING @ 0x74;
};

`endif
