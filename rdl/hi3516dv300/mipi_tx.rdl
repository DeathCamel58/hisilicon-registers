`ifndef EHI3516DV300_MIPI_TX_RDL
`define EHI3516DV300_MIPI_TX_RDL
regfile eHI3516DV300_MIPI_TX {
    name = "MIPI TX";
    desc = "MIPI TX. 43 registers extracted programmatically from the Hi3516D V300 Professional Smart IP Camera SoC data sheet (Issue 01, 2019-09-12); chapter 9.4.6, table 9-12. Field names, bit ranges, access types and reset values are taken from the register tables; reset values are the data sheet total reset values split onto the fields (per-field values where the table has them). Label: PROVEN. Hardware not verified here (no board).";
    reg {
        name = "PWR_UP";
        desc = "PWR_UP is the reset register. PWR_UP (offset 0x0004, total reset 0x0000_0000; PROVEN: Hi3516D V300 data sheet, PDF page 700, section 9.4.6).";
        field {
            name = "reserved";
            desc = "Reserved";
            sw = r; hw = na;
            reset = 0x0;
        } reserved_31_1[31:1];
        field {
            name = "pwr_up";
            desc = "Reset enable
- 0: reset
- 1: reset deasserted";
            sw = rw; hw = r;
            reset = 0x0;
        } pwr_up[0:0];
    } PWR_UP @ 0x4;
    reg {
        name = "CLKMGR_CFG";
        desc = "CLKMGR_CFG is the clock frequency division register. CLKMGR_CFG (offset 0x0008, total reset 0x0000_0000; PROVEN: Hi3516D V300 data sheet, PDF page 701, section 9.4.6).";
        field {
            name = "reserved";
            desc = "Reserved";
            sw = r; hw = na;
            reset = 0x0;
        } reserved_31_8[31:8];
        field {
            name = "tx_esc_clk_division";
            desc = "TX escape clock divider. The clock source is HSCLK. No clock is generated when the value is configured to 0 and 1.";
            sw = rw; hw = r;
            reset = 0x0;
        } tx_esc_clk_division[7:0];
    } CLKMGR_CFG @ 0x8;
    reg {
        name = "VCID";
        desc = "VCID is the virtual channel ID configuration register. VCID (offset 0x000C, total reset 0x0000_0000; PROVEN: Hi3516D V300 data sheet, PDF page 701, section 9.4.6).";
        field {
            name = "reserved";
            desc = "Reserved";
            sw = r; hw = na;
            reset = 0x0;
        } reserved_31_2[31:2];
        field {
            name = "vcid";
            desc = "Configured value of the virtual channel ID";
            sw = rw; hw = r;
            reset = 0x0;
        } vcid[1:0];
    } VCID @ 0xc;
    reg {
        name = "COLOR_CODING";
        desc = "COLOR_CODING is the data format configuration register. COLOR_CODING (offset 0x0010, total reset 0x0000_0000; PROVEN: Hi3516D V300 data sheet, PDF page 701, section 9.4.6).";
        field {
            name = "reserved";
            desc = "Reserved";
            sw = r; hw = na;
            reset = 0x0;
        } reserved_31_9[31:9];
        field {
            name = "loosely18_en";
            desc = "Loosely packed 18-bit format configuration enable
- 0: disabled
- 1: enabled";
            sw = rw; hw = r;
            reset = 0x0;
        } loosely18_en[8:8];
        field {
            name = "reserved";
            desc = "Reserved";
            sw = r; hw = na;
            reset = 0x0;
        } reserved_7_4[7:4];
        field {
            name = "color_coding";
            desc = "Data format configuration. 30-bit RGB and YCbCr formats are not supported in command mode.
- 0000: 16-bit DSI RGB
- 0001: 8-bit CSI YUV422
- 0010: 10-bit CSI YUV422
- 0011: 18-bit DSI RGB
- 0101: 24-bit DSI RGB
- 0110: 20-bit DSI YCbCr422
- 1000: 16-bit DSI YCbCr422
- 1001: 30-bit DSI RGB
- 1011: 12-bit DSI YCbCr420
- 1100: 8-bit CSI YCbCr420 legacy
- 1101: 8-bit CSI YCbCr420
- 1110: 10-bit CSI YCbCr420

Other values: reserved";
            sw = rw; hw = r;
            reset = 0x0;
        } color_coding[3:0];
    } COLOR_CODING @ 0x10;
    reg {
        name = "LP_CMD_TIM";
        desc = "LP_CMD_TIM is the available time configuration register of the LP command in video mode. LP_CMD_TIM (offset 0x0018, total reset 0x0000_0000; PROVEN: Hi3516D V300 data sheet, PDF page 702, section 9.4.6).";
        field {
            name = "reserved";
            desc = "Reserved";
            sw = r; hw = na;
            reset = 0x0;
        } reserved_31_24[31:24];
        field {
            name = "outvact_lpcmd_time";
            desc = "Maximum number of bytes of the LP command sent by the VSA, VBP, and VFP regions";
            sw = rw; hw = r;
            reset = 0x0;
        } outvact_lpcmd_time[23:16];
        field {
            name = "reserved";
            desc = "Reserved";
            sw = r; hw = na;
            reset = 0x0;
        } reserved_15_8[15:8];
        field {
            name = "invact_lpcmd_time";
            desc = "Maximum number of bytes of the LP command sent by the VACT region";
            sw = rw; hw = r;
            reset = 0x0;
        } invact_lpcmd_time[7:0];
    } LP_CMD_TIM @ 0x18;
    reg {
        name = "PCKHDL_CFG";
        desc = "PCKHDL_CFG is the packet parameter configuration register. PCKHDL_CFG (offset 0x002C, total reset 0x0000_0000; PROVEN: Hi3516D V300 data sheet, PDF page 702, section 9.4.6).";
        field {
            name = "reserved";
            desc = "Reserved";
            sw = r; hw = na;
            reset = 0x0;
        } reserved_31_5[31:5];
        field {
            name = "crc_rx_en";
            desc = "CRC RX enable
- 0: disabled
- 1: enabled";
            sw = rw; hw = r;
            reset = 0x0;
        } crc_rx_en[4:4];
        field {
            name = "ecc_rx_en";
            desc = "ECC RX enable
- 0: disabled
- 1: enabled";
            sw = rw; hw = r;
            reset = 0x0;
        } ecc_rx_en[3:3];
        field {
            name = "bta_en";
            desc = "Bus turn-around request enable
- 0: disabled
- 1: enabled";
            sw = rw; hw = r;
            reset = 0x0;
        } bta_en[2:2];
        field {
            name = "eotp_rx_en";
            desc = "EoTp RX enable
- 0: disabled
- 1: enabled";
            sw = rw; hw = r;
            reset = 0x0;
        } eotp_rx_en[1:1];
        field {
            name = "eotp_tx_en";
            desc = "EoTp TX enable
- 0: disabled
- 1: enabled";
            sw = rw; hw = r;
            reset = 0x0;
        } eotp_tx_en[0:0];
    } PCKHDL_CFG @ 0x2c;
    reg {
        name = "GEN_VCID";
        desc = "GEN_VCID is the virtual channel ID configuration register of the generic interface read data. GEN_VCID (offset 0x0030, total reset 0x0000_0000; PROVEN: Hi3516D V300 data sheet, PDF page 703, section 9.4.6).";
        field {
            name = "reserved";
            desc = "Reserved";
            sw = r; hw = na;
            reset = 0x0;
        } reserved_31_2[31:2];
        field {
            name = "gen_vcid_rx";
            desc = "Virtual channel ID of the generic interface read data";
            sw = rw; hw = r;
            reset = 0x0;
        } gen_vcid_rx[1:0];
    } GEN_VCID @ 0x30;
    reg {
        name = "MODE_CFG";
        desc = "MODE_CFG is the video or command mode selection register. MODE_CFG (offset 0x0034, total reset 0x0000_0000; PROVEN: Hi3516D V300 data sheet, PDF page 703, section 9.4.6).";
        field {
            name = "reserved";
            desc = "Reserved";
            sw = r; hw = na;
            reset = 0x0;
        } reserved_31_1[31:1];
        field {
            name = "cmd_video_mode";
            desc = "Video or command mode selection
- 0: video mode
- 1: command mode";
            sw = rw; hw = r;
            reset = 0x0;
        } cmd_video_mode[0:0];
    } MODE_CFG @ 0x34;
    reg {
        name = "VID_MODE_CFG";
        desc = "VID_MODE_CFG is the operation configuration register in video mode. VID_MODE_CFG (offset 0x0038, total reset 0x0000_0000; PROVEN: Hi3516D V300 data sheet, PDF page 704, section 9.4.6).";
        field {
            name = "reserved";
            desc = "Reserved";
            sw = r; hw = na;
            reset = 0x0;
        } reserved_31_25[31:25];
        field {
            name = "vpg_orientation";
            desc = "Color bar direction selection
- 0: vertical mode
- 1: horizontal mode";
            sw = rw; hw = r;
            reset = 0x0;
        } vpg_orientation[24:24];
        field {
            name = "reserved";
            desc = "Reserved";
            sw = r; hw = na;
            reset = 0x0;
        } reserved_23_21[23:21];
        field {
            name = "vpg_mode";
            desc = "Test pattern selection
- 0: color bar
- 1: BER pattern";
            sw = rw; hw = r;
            reset = 0x0;
        } vpg_mode[20:20];
        field {
            name = "reserved";
            desc = "Reserved";
            sw = r; hw = na;
            reset = 0x0;
        } reserved_19_17[19:17];
        field {
            name = "vpg_en";
            desc = "Test pattern enable in video mode
- 0: disabled
- 1: enabled";
            sw = rw; hw = r;
            reset = 0x0;
        } vpg_en[16:16];
        field {
            name = "lp_cmd_en";
            desc = "Command transmission enable in LP mode
- 0: disabled
- 1: enabled";
            sw = rw; hw = r;
            reset = 0x0;
        } lp_cmd_en[15:15];
        field {
            name = "frame_bta_ack_en";
            desc = "EOF ACK reply request enable
- 0: disabled
- 1: enabled";
            sw = rw; hw = r;
            reset = 0x0;
        } frame_bta_ack_en[14:14];
        field {
            name = "lp_hfp_en";
            desc = "LP status enable in the HFP region if time is sufficient
- 0: disabled
- 1: enabled";
            sw = rw; hw = r;
            reset = 0x0;
        } lp_hfp_en[13:13];
        field {
            name = "lp_hbp_en";
            desc = "LP status enable in the HBP region if time is sufficient
- 0: disabled
- 1: enabled";
            sw = rw; hw = r;
            reset = 0x0;
        } lp_hbp_en[12:12];
        field {
            name = "lp_vact_en";
            desc = "LP status enable in the VACT region if time is sufficient
- 0: disabled
- 1: enabled";
            sw = rw; hw = r;
            reset = 0x0;
        } lp_vact_en[11:11];
        field {
            name = "lp_vfp_en";
            desc = "LP status enable in the VFP region if time is sufficient
- 0: disabled";
            sw = rw; hw = r;
            reset = 0x0;
        } lp_vfp_en[10:10];
        field {
            name = "lp_vbp_en";
            desc = "LP status enable in the VBP region if time is sufficient
- 0: disabled
- 1: enabled";
            sw = rw; hw = r;
            reset = 0x0;
        } lp_vbp_en[9:9];
        field {
            name = "lp_vsa_en";
            desc = "LP status enable in the VSA region if time is sufficient
- 0: disabled
- 1: enabled";
            sw = rw; hw = r;
            reset = 0x0;
        } lp_vsa_en[8:8];
        field {
            name = "reserved";
            desc = "Reserved";
            sw = r; hw = na;
            reset = 0x0;
        } reserved_7_2[7:2];
        field {
            name = "vid_mode_type";
            desc = "TX type selection in video mode
- 00: non-burst with sync pulse
- 01: non-burst with sync events

Other values: burst mode";
            sw = rw; hw = r;
            reset = 0x0;
        } vid_mode_type[1:0];
    } VID_MODE_CFG @ 0x38;
    reg {
        name = "VID_PKT_SIZE";
        desc = "VID_PKT_SIZE is the packet size configuration register. VID_PKT_SIZE (offset 0x003C, total reset 0x0000_0000; PROVEN: Hi3516D V300 data sheet, PDF page 705, section 9.4.6).";
        field {
            name = "reserved";
            desc = "Reserved";
            sw = r; hw = na;
            reset = 0x0;
        } reserved_31_14[31:14];
        field {
            name = "vid_pkt_size";
            desc = "Packet size (unit: pixel)";
            sw = rw; hw = r;
            reset = 0x0;
        } vid_pkt_size[13:0];
    } VID_PKT_SIZE @ 0x3c;
    reg {
        name = "VID_NUM_CHUNKS";
        desc = "VID_NUM_CHUNKS is the chunk quantity configuration register in one line. VID_NUM_CHUNKS (offset 0x0040, total reset 0x0000_0000; PROVEN: Hi3516D V300 data sheet, PDF page 705, section 9.4.6).";
        field {
            name = "reserved";
            desc = "Reserved";
            sw = r; hw = na;
            reset = 0x0;
        } reserved_31_13[31:13];
        field {
            name = "vid_num_chunks";
            desc = "Number of chunks in a line. A chunk contains one data packet and one null packet. If the value is 0, a line contains only one data packet; if the value is 1, a line contains one data packet plus one null packet (when vid_null_size is greater than 0).";
            sw = rw; hw = r;
            reset = 0x0;
        } vid_num_chunks[12:0];
    } VID_NUM_CHUNKS @ 0x40;
    reg {
        name = "VID_NULL_SIZE";
        desc = "VID_NULL_SIZE is the null packet size configuration register. VID_NULL_SIZE (offset 0x0044, total reset 0x0000_0000; PROVEN: Hi3516D V300 data sheet, PDF page 706, section 9.4.6).";
        field {
            name = "reserved";
            desc = "Reserved";
            sw = r; hw = na;
            reset = 0x0;
        } reserved_31_13[31:13];
        field {
            name = "vid_null_size";
            desc = "Size of the null packet (unit: byte) If the value is 0, no null packet is sent.";
            sw = rw; hw = r;
            reset = 0x0;
        } vid_null_size[12:0];
    } VID_NULL_SIZE @ 0x44;
    reg {
        name = "VID_HSA_TIME";
        desc = "VID_HSA_TIME is the HSA time configuration register. VID_HSA_TIME (offset 0x0048, total reset 0x0000_0000; PROVEN: Hi3516D V300 data sheet, PDF page 706, section 9.4.6).";
        field {
            name = "reserved";
            desc = "Reserved";
            sw = r; hw = na;
            reset = 0x0;
        } reserved_31_12[31:12];
        field {
            name = "vid_hsa_time";
            desc = "HSA period (unit: HSCLK cycle)";
            sw = rw; hw = r;
            reset = 0x0;
        } vid_hsa_time[11:0];
    } VID_HSA_TIME @ 0x48;
    reg {
        name = "VID_HBP_TIME";
        desc = "VID_HBP_TIME is the HBP time configuration register. VID_HBP_TIME (offset 0x004C, total reset 0x0000_0000; PROVEN: Hi3516D V300 data sheet, PDF page 706, section 9.4.6).";
        field {
            name = "reserved";
            desc = "Reserved";
            sw = r; hw = na;
            reset = 0x0;
        } reserved_31_12[31:12];
        field {
            name = "vid_hbp_time";
            desc = "HBP period (unit: HSCLK cycle)";
            sw = rw; hw = r;
            reset = 0x0;
        } vid_hbp_time[11:0];
    } VID_HBP_TIME @ 0x4c;
    reg {
        name = "VID_HLINE_TIME";
        desc = "VID_HLINE_TIME is the HLINE time configuration register. VID_HLINE_TIME (offset 0x0050, total reset 0x0000_0000; PROVEN: Hi3516D V300 data sheet, PDF page 706, section 9.4.6).";
        field {
            name = "reserved";
            desc = "Reserved";
            sw = r; hw = na;
            reset = 0x0;
        } reserved_31_15[31:15];
        field {
            name = "vid_hline_time";
            desc = "Total period of a line, including HAS, HBP, HACT, and HFP (unit: HSCLK cycle)";
            sw = rw; hw = r;
            reset = 0x0;
        } vid_hline_time[14:0];
    } VID_HLINE_TIME @ 0x50;
    reg {
        name = "VID_VSA_LINES";
        desc = "VID_VSA_LINES is the VSA lines configuration register. VID_VSA_LINES (offset 0x0054, total reset 0x0000_0000; PROVEN: Hi3516D V300 data sheet, PDF page 707, section 9.4.6).";
        field {
            name = "reserved";
            desc = "Reserved";
            sw = r; hw = na;
            reset = 0x0;
        } reserved_31_10[31:10];
        field {
            name = "vsa_lines";
            desc = "Number of VSA lines";
            sw = rw; hw = r;
            reset = 0x0;
        } vsa_lines[9:0];
    } VID_VSA_LINES @ 0x54;
    reg {
        name = "VID_VBP_LINES";
        desc = "VID_VBP_LINES is the VBP lines configuration register. VID_VBP_LINES (offset 0x0058, total reset 0x0000_0000; PROVEN: Hi3516D V300 data sheet, PDF page 707, section 9.4.6).";
        field {
            name = "reserved";
            desc = "Reserved";
            sw = r; hw = na;
            reset = 0x0;
        } reserved_31_10[31:10];
        field {
            name = "vbp_lines";
            desc = "Number of VBP lines";
            sw = rw; hw = r;
            reset = 0x0;
        } vbp_lines[9:0];
    } VID_VBP_LINES @ 0x58;
    reg {
        name = "VID_VFP_LINES";
        desc = "VID_VFP_LINES is the VFP lines configuration register. VID_VFP_LINES (offset 0x005C, total reset 0x0000_0000; PROVEN: Hi3516D V300 data sheet, PDF page 707, section 9.4.6).";
        field {
            name = "reserved";
            desc = "Reserved";
            sw = r; hw = na;
            reset = 0x0;
        } reserved_31_10[31:10];
        field {
            name = "vfp_lines";
            desc = "Number of VFP lines";
            sw = rw; hw = r;
            reset = 0x0;
        } vfp_lines[9:0];
    } VID_VFP_LINES @ 0x5c;
    reg {
        name = "VID_VACTIVE_LINES";
        desc = "VID_VACTIVE_LINES is the VACTIVE lines configuration register. VID_VACTIVE_LINES (offset 0x0060, total reset 0x0000_0000; PROVEN: Hi3516D V300 data sheet, PDF page 707, section 9.4.6).";
        field {
            name = "reserved";
            desc = "Reserved";
            sw = r; hw = na;
            reset = 0x0;
        } reserved_31_14[31:14];
        field {
            name = "v_active_lines";
            desc = "Number of VACTIVE lines";
            sw = rw; hw = r;
            reset = 0x0;
        } v_active_lines[13:0];
    } VID_VACTIVE_LINES @ 0x60;
    reg {
        name = "EDPI_CMD_SIZE";
        desc = "EDPI_CMD_SIZE is the WMC size configuration register. EDPI_CMD_SIZE (offset 0x0064, total reset 0x0000_0000; PROVEN: Hi3516D V300 data sheet, PDF page 708, section 9.4.6).";
        field {
            name = "reserved";
            desc = "Reserved";
            sw = r; hw = na;
            reset = 0x0;
        } reserved_31_16[31:16];
        field {
            name = "edpi_allowed_cmd_size";
            desc = "Maximum size of the write memory command (unit: pixel)";
            sw = rw; hw = r;
            reset = 0x0;
        } edpi_allowed_cmd_size[15:0];
    } EDPI_CMD_SIZE @ 0x64;
    reg {
        name = "CMD_MODE_CFG";
        desc = "CMD_MODE_CFG is the command mode configuration register. CMD_MODE_CFG (offset 0x0068, total reset 0x0000_0000; PROVEN: Hi3516D V300 data sheet, PDF page 708, section 9.4.6).";
        field {
            name = "reserved";
            desc = "Reserved";
            sw = r; hw = na;
            reset = 0x0;
        } reserved_31_25[31:25];
        field {
            name = "max_rd_pkt_size";
            desc = "Transmission type of the maximum read packet size command
- 0: high speed
- 1: low power";
            sw = rw; hw = r;
            reset = 0x0;
        } max_rd_pkt_size[24:24];
        field {
            name = "reserved";
            desc = "Reserved";
            sw = r; hw = na;
            reset = 0x0;
        } reserved_23_20[23:20];
        field {
            name = "dcs_lw_tx";
            desc = "Transmission type of the DCS long write packet command
- 0: high speed
- 1: low power";
            sw = rw; hw = r;
            reset = 0x0;
        } dcs_lw_tx[19:19];
        field {
            name = "dcs_sr_0p_tx";
            desc = "Transmission type of the DCS short read packet with zero parameter command
- 0: high speed
- 1: low power";
            sw = rw; hw = r;
            reset = 0x0;
        } dcs_sr_0p_tx[18:18];
        field {
            name = "dcs_sw_1p_tx";
            desc = "Transmission type of the DCS short write packet with one parameter command
- 0: high speed
- 1: low power";
            sw = rw; hw = r;
            reset = 0x0;
        } dcs_sw_1p_tx[17:17];
        field {
            name = "dcs_sw_0p_tx";
            desc = "Transmission type of the DCS short write packet with zero parameter command
- 0: high speed
- 1: low power";
            sw = rw; hw = r;
            reset = 0x0;
        } dcs_sw_0p_tx[16:16];
        field {
            name = "reserved";
            desc = "Reserved";
            sw = r; hw = na;
            reset = 0x0;
        } reserved_15_15[15:15];
        field {
            name = "gen_lw_tx";
            desc = "Transmission type of the generic long write";
            sw = rw; hw = r;
            reset = 0x0;
        } gen_lw_tx[14:14];
        field {
            name = "gen_sr_2p_tx";
            desc = "Transmission type of the generic short read packet with two parameter command
- 0: high speed
- 1: low power";
            sw = rw; hw = r;
            reset = 0x0;
        } gen_sr_2p_tx[13:13];
        field {
            name = "gen_sr_1p_tx";
            desc = "Transmission type of the generic short read packet with one parameter command
- 0: high speed
- 1: low power";
            sw = rw; hw = r;
            reset = 0x0;
        } gen_sr_1p_tx[12:12];
        field {
            name = "gen_sr_0p_tx";
            desc = "Transmission type of the generic short read packet with zero parameter command
- 0: high speed
- 1: low power";
            sw = rw; hw = r;
            reset = 0x0;
        } gen_sr_0p_tx[11:11];
        field {
            name = "gen_sw_2p_tx";
            desc = "Transmission type of the generic short write packet with two parameter command
- 0: high speed
- 1: low power";
            sw = rw; hw = r;
            reset = 0x0;
        } gen_sw_2p_tx[10:10];
        field {
            name = "gen_sw_1p_tx";
            desc = "Transmission type of the generic short write packet with one parameter command
- 0: high speed
- 1: low power";
            sw = rw; hw = r;
            reset = 0x0;
        } gen_sw_1p_tx[9:9];
        field {
            name = "gen_sw_0p_tx";
            desc = "Transmission type of the generic short write packet with zero parameter command
- 0: high speed
- 1: low power";
            sw = rw; hw = r;
            reset = 0x0;
        } gen_sw_0p_tx[8:8];
        field {
            name = "reserved";
            desc = "Reserved";
            sw = r; hw = na;
            reset = 0x0;
        } reserved_7_0[7:0];
    } CMD_MODE_CFG @ 0x68;
    reg {
        name = "GEN_HDR";
        desc = "GEN_HDR is the generic interface header configuration register. GEN_HDR (offset 0x006C, total reset 0x0000_0000; PROVEN: Hi3516D V300 data sheet, PDF page 709, section 9.4.6).";
        field {
            name = "reserved";
            desc = "Reserved";
            sw = r; hw = na;
            reset = 0x0;
        } reserved_31_24[31:24];
        field {
            name = "gen_wc_msbyte";
            desc = "Setting higher bytes of the length of long packets or data 1 of short packets";
            sw = rw; hw = r;
            reset = 0x0;
        } gen_wc_msbyte[23:16];
        field {
            name = "gen_wc_lsbyte";
            desc = "Setting lower bytes of the length of long packets or data 0 of short packets";
            sw = rw; hw = r;
            reset = 0x0;
        } gen_wc_lsbyte[15:8];
        field {
            name = "gen_vc";
            desc = "Virtual channel ID of a packet";
            sw = rw; hw = r;
            reset = 0x0;
        } gen_vc[7:6];
        field {
            name = "gen_dt";
            desc = "Data type of a packet";
            sw = rw; hw = r;
            reset = 0x0;
        } gen_dt[5:0];
    } GEN_HDR @ 0x6c;
    reg {
        name = "GEN_PLD_DATA";
        desc = "GEN_PLD_DATA is the generic interface data register. GEN_PLD_DATA (offset 0x0070, total reset 0x0000_0000; PROVEN: Hi3516D V300 data sheet, PDF page 710, section 9.4.6).";
        field {
            name = "gen_pld_b4";
            desc = "Fourth byte of packet data";
            sw = rw; hw = r;
            reset = 0x0;
        } gen_pld_b4[31:24];
        field {
            name = "gen_pld_b3";
            desc = "Third byte of packet data";
            sw = rw; hw = r;
            reset = 0x0;
        } gen_pld_b3[23:16];
        field {
            name = "gen_pld_b2";
            desc = "Second byte of packet data";
            sw = rw; hw = r;
            reset = 0x0;
        } gen_pld_b2[15:8];
        field {
            name = "gen_pld_b1";
            desc = "First byte of packet data";
            sw = rw; hw = r;
            reset = 0x0;
        } gen_pld_b1[7:0];
    } GEN_PLD_DATA @ 0x70;
    reg {
        name = "CMD_PKT_STATUS";
        desc = "CMD_PKT_STATUS is the generic interface FIFO status register. CMD_PKT_STATUS (offset 0x0074, total reset 0x0000_0010; PROVEN: Hi3516D V300 data sheet, PDF page 710, section 9.4.6).";
        field {
            name = "reserved";
            desc = "Reserved";
            sw = r; hw = na;
            reset = 0x0;
        } reserved_31_7[31:7];
        field {
            name = "gen_rd_cmd_busy";
            desc = "Busy flag for the generic interface read
- 0: idle
- 1: busy";
            sw = rw; hw = r;
            reset = 0x0;
        } gen_rd_cmd_busy[6:6];
        field {
            name = "gen_pld_r_full";
            desc = "Full flag for the generic interface read FIFO
- 0: not full
- 1: full";
            sw = rw; hw = r;
            reset = 0x0;
        } gen_pld_r_full[5:5];
        field {
            name = "gen_pld_r_empty";
            desc = "Empty flag for the generic interface read FIFO
- 0: not empty
- 1: empty";
            sw = rw; hw = r;
            reset = 0x1;
        } gen_pld_r_empty[4:4];
        field {
            name = "gen_pld_w_full";
            desc = "Full flag for the generic interface write FIFO
- 0: not full
- 1: full";
            sw = rw; hw = r;
            reset = 0x0;
        } gen_pld_w_full[3:3];
        field {
            name = "EmptyflagforthegenericinterfacewriteFIFOgen_pld_w_empty0:notempty1:empty";
            desc = "";
            sw = rw; hw = r;
            reset = 0x0;
        } EmptyflagforthegenericinterfacewriteFIFOgen_pld_w_empty0_notempty1_empty[2:2];
        field {
            name = "FullflagforthegenericinterfacecommandFIFOgen_cmd_full0:notfull1:full";
            desc = "";
            sw = rw; hw = r;
            reset = 0x0;
        } FullflagforthegenericinterfacecommandFIFOgen_cmd_full0_notfull1_full[1:1];
        field {
            name = "EmptyflagforthegenericinterfacecommandFIFOgen_cmd_empty0:notempty1:empty";
            desc = "";
            sw = rw; hw = r;
            reset = 0x0;
        } EmptyflagforthegenericinterfacecommandFIFOgen_cmd_empty0_notempty1_empty[0:0];
    } CMD_PKT_STATUS @ 0x74;
    reg {
        name = "LP_WR_TO_CNT";
        desc = "LP_WR_TO_CNT is the LP write response timeout configuration register. LP_WR_TO_CNT (offset 0x0088, total reset 0x0000_0000; PROVEN: Hi3516D V300 data sheet, PDF page 711, section 9.4.6).";
        field {
            name = "reserved";
            desc = "Reserved";
            sw = r; hw = na;
            reset = 0x0;
        } reserved_31_16[31:16];
        field {
            name = "lp_wr_to_cnt";
            desc = "Wait time after LP sends the write command (unit: HSCLK)";
            sw = rw; hw = r;
            reset = 0x0;
        } lp_wr_to_cnt[15:0];
    } LP_WR_TO_CNT @ 0x88;
    reg {
        name = "BTA_TO_CNT";
        desc = "BTA_TO_CNT is the BTA reply timeout configuration register. BTA_TO_CNT (offset 0x008C, total reset 0x0000_0000; PROVEN: Hi3516D V300 data sheet, PDF page 711, section 9.4.6).";
        field {
            name = "reserved";
            desc = "Reserved";
            sw = r; hw = na;
            reset = 0x0;
        } reserved_31_16[31:16];
        field {
            name = "bta_to_cnt";
            desc = "Host wait time after Bus Turn-Around (unit: HSCLK)";
            sw = rw; hw = r;
            reset = 0x0;
        } bta_to_cnt[15:0];
    } BTA_TO_CNT @ 0x8c;
    reg {
        name = "LPCLK_CTRL";
        desc = "LPCLK_CTRL is the clock lane control register. LPCLK_CTRL (offset 0x0094, total reset 0x0000_0000; PROVEN: Hi3516D V300 data sheet, PDF page 711, section 9.4.6).";
        field {
            name = "reserved";
            desc = "Reserved";
            sw = r; hw = na;
            reset = 0x0;
        } reserved_31_2[31:2];
        field {
            name = "auto_clock";
            desc = "Auto turn-off enable of the clock when the lane idle is idle lane_ctrl
- 0: disabled
- 1: enabled";
            sw = rw; hw = r;
            reset = 0x0;
        } auto_clock[1:1];
        field {
            name = "phy_txrequestclkhs";
            desc = "HSCLK request enable
- 0: disabled
- 1: enabled";
            sw = rw; hw = r;
            reset = 0x0;
        } phy_txrequestclkhs[0:0];
    } LPCLK_CTRL @ 0x94;
    reg {
        name = "PHY_TMR_LPCLK_CFG";
        desc = "PHY_TMR_LPCLK_CFG is the clock lane HS and LP switchover time configuration register. PHY_TMR_LPCLK_CFG (offset 0x0098, total reset 0x0000_0000; PROVEN: Hi3516D V300 data sheet, PDF page 712, section 9.4.6).";
        field {
            name = "reserved";
            desc = "Reserved";
            sw = r; hw = na;
            reset = 0x0;
        } reserved_31_26[31:26];
        field {
            name = "phy_clkhs2lp_time";
            desc = "Time required for the clock lane to switch from the HS mode to the LP mode (unit: HSCLK)";
            sw = rw; hw = r;
            reset = 0x0;
        } phy_clkhs2lp_time[25:16];
        field {
            name = "reserved";
            desc = "Reserved";
            sw = r; hw = na;
            reset = 0x0;
        } reserved_15_10[15:10];
        field {
            name = "phy_clklp2hs_time";
            desc = "Time required for the clock lane to switch from the LP mode to the HS mode (unit: HSCLK)";
            sw = rw; hw = r;
            reset = 0x0;
        } phy_clklp2hs_time[9:0];
    } PHY_TMR_LPCLK_CFG @ 0x98;
    reg {
        name = "PHY_TMR_CFG";
        desc = "PHY_TMR_CFG is the data lane HS and LP switchover time configuration register. PHY_TMR_CFG (offset 0x009C, total reset 0x0000_0000; PROVEN: Hi3516D V300 data sheet, PDF page 712, section 9.4.6).";
        field {
            name = "reserved";
            desc = "Reserved";
            sw = r; hw = na;
            reset = 0x0;
        } reserved_31_26[31:26];
        field {
            name = "phy_hs2lp_time";
            desc = "Time required for the data lane to switch from the HS mode to the LP mode (unit: HSCLK)";
            sw = rw; hw = r;
            reset = 0x0;
        } phy_hs2lp_time[25:16];
        field {
            name = "reserved";
            desc = "Reserved";
            sw = r; hw = na;
            reset = 0x0;
        } reserved_15_10[15:10];
        field {
            name = "phy_lp2hs_time";
            desc = "Time required for the data lane to switch from the LP mode to the HS mode (unit: HSCLK)";
            sw = rw; hw = r;
            reset = 0x0;
        } phy_lp2hs_time[9:0];
    } PHY_TMR_CFG @ 0x9c;
    reg {
        name = "PHY_RSTZ";
        desc = "PHY_RSTZ is the PHY PLL and reset configuration register. PHY_RSTZ (offset 0x00A0, total reset 0x0000_0000; PROVEN: Hi3516D V300 data sheet, PDF page 713, section 9.4.6).";
        field {
            name = "reserved";
            desc = "Reserved";
            sw = r; hw = na;
            reset = 0x0;
        } reserved_31_4[31:4];
        field {
            name = "phy_forcepll";
            desc = "Enabling the PHY PLL in valid state
- 0: disabled
- 1: enabled";
            sw = rw; hw = r;
            reset = 0x0;
        } phy_forcepll[3:3];
        field {
            name = "phy_enableclk";
            desc = "PHY clock lane enable
- 0: disabled
- 1: enabled";
            sw = rw; hw = r;
            reset = 0x0;
        } phy_enableclk[2:2];
        field {
            name = "phy_rstz";
            desc = "PHY digital circuit reset enable
- 0: reset
- 1: reset deasserted";
            sw = rw; hw = r;
            reset = 0x0;
        } phy_rstz[1:1];
        field {
            name = "phy_shutdownz";
            desc = "PHY overall power-down enable
- 0: disabled
- 1: enabled";
            sw = rw; hw = r;
            reset = 0x0;
        } phy_shutdownz[0:0];
    } PHY_RSTZ @ 0xa0;
    reg {
        name = "PHY_IF_CFG";
        desc = "PHY_IF_CFG is the PHY interface configuration register. PHY_IF_CFG (offset 0x00A4, total reset 0x0000_0000; PROVEN: Hi3516D V300 data sheet, PDF page 713, section 9.4.6).";
        field {
            name = "reserved";
            desc = "Reserved";
            sw = r; hw = na;
            reset = 0x0;
        } reserved_31_16[31:16];
        field {
            name = "phy_stop_wait_time";
            desc = "Minimum wait time from entering the stop state to initiating HS transmission";
            sw = rw; hw = r;
            reset = 0x0;
        } phy_stop_wait_time[15:8];
        field {
            name = "reserved";
            desc = "Reserved";
            sw = r; hw = na;
            reset = 0x0;
        } reserved_7_2[7:2];
        field {
            name = "n_lanes";
            desc = "Number of data lanes
- 00: 1 lane (0)
- 01: 2 lanes (0, 1)
- 10: 3 lanes (0, 1, 2)
- 11: 4 lanes (0, 1, 2, 3)";
            sw = rw; hw = r;
            reset = 0x0;
        } n_lanes[1:0];
    } PHY_IF_CFG @ 0xa4;
    reg {
        name = "PHY_ULPS_CTRL";
        desc = "PHY_ULPS_CTRL is the PHY ULPS status configuration register. PHY_ULPS_CTRL (offset 0x00A8, total reset 0x0000_0000; PROVEN: Hi3516D V300 data sheet, PDF page 714, section 9.4.6).";
        field {
            name = "reserved";
            desc = "Reserved";
            sw = r; hw = na;
            reset = 0x0;
        } reserved_31_4[31:4];
        field {
            name = "phy_txexitulpslan";
            desc = "Enable the data lanes to exit the ULPS mode
- 0: disabled
- 1: enabled";
            sw = rw; hw = r;
            reset = 0x0;
        } phy_txexitulpslan[3:3];
        field {
            name = "phy_txrequlpslan";
            desc = "Request enable for data lanes to enter the ULPS mode
- 0: disabled
- 1: enabled";
            sw = rw; hw = r;
            reset = 0x0;
        } phy_txrequlpslan[2:2];
        field {
            name = "phy_txexitulpsclk";
            desc = "Enable the clock lane to exit the ULPS mode
- 0: disabled
- 1: enabled";
            sw = rw; hw = r;
            reset = 0x0;
        } phy_txexitulpsclk[1:1];
        field {
            name = "phy_txrequlpsclk";
            desc = "Request enable for clock lane to enter the ULPS mode
- 0: disabled
- 1: enabled";
            sw = rw; hw = r;
            reset = 0x0;
        } phy_txrequlpsclk[0:0];
    } PHY_ULPS_CTRL @ 0xa8;
    reg {
        name = "PHY_STATUS";
        desc = "PHY_STATE is the PHY status register. PHY_STATUS (offset 0x00B0, total reset 0x0000_0000; PROVEN: Hi3516D V300 data sheet, PDF page 714, section 9.4.6).";
        field {
            name = "reserved";
            desc = "Reserved";
            sw = r; hw = na;
            reset = 0x0;
        } reserved_31_13[31:13];
        field {
            name = "phy_ulpsactivenot3lane";
            desc = "PHY lane 3 ULPS status indicator
- 0: ULPS status
- 1: non-ULPS status";
            sw = r; hw = w;
            reset = 0x0;
        } phy_ulpsactivenot3lane[12:12];
        field {
            name = "phy_stopstate3lane";
            desc = "PHY lane 3 stop status indicator
- 0: stop status
- 1: non-stop status";
            sw = r; hw = w;
            reset = 0x0;
        } phy_stopstate3lane[11:11];
        field {
            name = "phy_ulpsactivenot2lane";
            desc = "PHY lane 2 ULPS status indicator
- 0: ULPS status
- 1: non-ULPS status";
            sw = r; hw = w;
            reset = 0x0;
        } phy_ulpsactivenot2lane[10:10];
        field {
            name = "phy_stopstate2lane";
            desc = "PHY lane 2 stop status indicator
- 0: stop status
- 1: non-stop status";
            sw = r; hw = w;
            reset = 0x0;
        } phy_stopstate2lane[9:9];
        field {
            name = "phy_ulpsactivenot1lane";
            desc = "PHY lane 1 ULPS status indicator
- 0: ULPS status
- 1: non-ULPS status";
            sw = r; hw = w;
            reset = 0x0;
        } phy_ulpsactivenot1lane[8:8];
        field {
            name = "phy_stopstate1lane";
            desc = "PHY lane 1 stop status indicator
- 0: stop status
- 1: non-stop status";
            sw = r; hw = w;
            reset = 0x0;
        } phy_stopstate1lane[7:7];
        field {
            name = "phy_rxulpsesc0lane";
            desc = "PHY lane 0 RX ULPS status indicator
- 0: ULPS status
- 1: non-ULPS status";
            sw = r; hw = w;
            reset = 0x0;
        } phy_rxulpsesc0lane[6:6];
        field {
            name = "phy_ulpsactivenot0lane";
            desc = "PHY lane 0 ULPS status indicator
- 0: ULPS status
- 1: non-ULPS status";
            sw = r; hw = w;
            reset = 0x0;
        } phy_ulpsactivenot0lane[5:5];
        field {
            name = "phy_stopstate0lane";
            desc = "PHY lane 0 stop status indicator
- 0: stop status
- 1: non-stop status";
            sw = r; hw = w;
            reset = 0x0;
        } phy_stopstate0lane[4:4];
        field {
            name = "phy_ulpsactivenotclk";
            desc = "PHY clock lane ULPS status indicator
- 0: ULPS status
- 1: non-ULPS status";
            sw = r; hw = w;
            reset = 0x0;
        } phy_ulpsactivenotclk[3:3];
        field {
            name = "phy_stopstateclocklane";
            desc = "PHY clock lane stop status indicator
- 0: stop status
- 1: non-stop status";
            sw = r; hw = w;
            reset = 0x0;
        } phy_stopstateclocklane[2:2];
        field {
            name = "phy_direction";
            desc = "PHY direction signal status
- 0: TX status
- 1: RX status";
            sw = r; hw = w;
            reset = 0x0;
        } phy_direction[1:1];
        field {
            name = "phy_lock";
            desc = "PHY lock signal status
- 0: The PHY PLL lock is invalid.
- 1: The PHY PLL lock is valid.";
            sw = r; hw = w;
            reset = 0x0;
        } phy_lock[0:0];
    } PHY_STATUS @ 0xb0;
    reg {
        name = "PHY_TST_CTRL0";
        desc = "PHY_TST_CTRL0 is the PHY configuration interface 0 register. PHY_TST_CTRL0 (offset 0x00B4, total reset 0x0000_0001; PROVEN: Hi3516D V300 data sheet, PDF page 715, section 9.4.6).";
        field {
            name = "reserved";
            desc = "Reserved";
            sw = r; hw = na;
            reset = 0x0;
        } reserved_31_2[31:2];
        field {
            name = "phy_testclk";
            desc = "PHY register configuration interface clock";
            sw = rw; hw = r;
            reset = 0x0;
        } phy_testclk[1:1];
        field {
            name = "phy_testclr";
            desc = "Whether to clear the configuration
- 0: No.
- 1: Yes.";
            sw = rw; hw = r;
            reset = 0x1;
        } phy_testclr[0:0];
    } PHY_TST_CTRL0 @ 0xb4;
    reg {
        name = "PHY_TST_CTRL1";
        desc = "PHY_TST_CTRL1 is the PHY configuration interface 1 register. PHY_TST_CTRL1 (offset 0x00B8, total reset 0x0000_0000; PROVEN: Hi3516D V300 data sheet, PDF page 716, section 9.4.6).";
        field {
            name = "reserved";
            desc = "Reserved";
            sw = r; hw = na;
            reset = 0x0;
        } reserved_31_17[31:17];
        field {
            name = "phy_testen";
            desc = "Testen signal control
- 0: collecting data on the rising edge of the test clock
- 1: collecting the address on the falling edge of the test clock";
            sw = rw; hw = r;
            reset = 0x0;
        } phy_testen[16:16];
        field {
            name = "phy_testdout";
            desc = "Output data of the PHY configuration interface";
            sw = r; hw = w;
            reset = 0x0;
        } phy_testdout[15:8];
        field {
            name = "phy_testdin";
            desc = "Input data of the PHY configuration interface";
            sw = rw; hw = r;
            reset = 0x0;
        } phy_testdin[7:0];
    } PHY_TST_CTRL1 @ 0xb8;
    reg {
        name = "INT_ST0";
        desc = "INT_ST0 is the interrupt status 0 register. INT_ST0 (offset 0x00BC, total reset 0x0000_0000; PROVEN: Hi3516D V300 data sheet, PDF page 716, section 9.4.6).";
        field {
            name = "reserved";
            desc = "Reserved";
            sw = r; hw = na;
            reset = 0x0;
        } reserved_31_21[31:21];
        field {
            name = "dphy_errors_4";
            desc = "Lane 0 LP 1 contention error interrupt. This bit is cleared when it is read.
- 0: No interrupt is generated.
- 1: An interrupt is generated. (data sheet access type RC)";
            sw = r; hw = w; onread = rclr;
            reset = 0x0;
        } dphy_errors_4[20:20];
        field {
            name = "dphy_errors_3";
            desc = "Lane 0 LP 0 contention error interrupt. This bit is cleared when it is read.
- 0: No interrupt is generated.
- 1: An interrupt is generated. (data sheet access type RC)";
            sw = r; hw = w; onread = rclr;
            reset = 0x0;
        } dphy_errors_3[19:19];
        field {
            name = "dphy_errors_2";
            desc = "Error status sequence detection interrupt. This bit is cleared when it is read.
- 0: No interrupt is generated.
- 1: An interrupt is generated. (data sheet access type RC)";
            sw = r; hw = w; onread = rclr;
            reset = 0x0;
        } dphy_errors_2[18:18];
        field {
            name = "dphy_errors_1";
            desc = "LP data transmission synchronization interrupt. When the number of data bits is not a multiple of 8, an interrupt is generated. The bits are cleared when they are read.
- 0: No interrupt is generated.
- 1: An interrupt is generated. (data sheet access type RC)";
            sw = r; hw = w; onread = rclr;
            reset = 0x0;
        } dphy_errors_1[17:17];
        field {
            name = "dphy_errors_0";
            desc = "Escape entry error interrupt. If an undefined command is received, an interrupt is reported. This bit is cleared when it is read.
- 0: No interrupt is generated.
- 1: An interrupt is generated. (data sheet access type RC)";
            sw = r; hw = w; onread = rclr;
            reset = 0x0;
        } dphy_errors_0[16:16];
        field {
            name = "ack_with_err_15";
            desc = "Protocol violation interrupt in the device error reporting. When the expected EoTp or BTA sequence after the read command is not received, an error is reported. This bit is cleared when it is read.
- 0: No interrupt is generated.
- 1: An interrupt is generated. (data sheet access type RC)";
            sw = r; hw = w; onread = rclr;
            reset = 0x0;
        } ack_with_err_15[15:15];
        field {
            name = "ack_with_err_14";
            desc = "The reserved bit in the device error reporting. This bit is cleared when it is read. (data sheet access type RC)";
            sw = r; hw = w; onread = rclr;
            reset = 0x0;
        } ack_with_err_14[14:14];
        field {
            name = "ack_with_err_13";
            desc = "Bit of the invalid transmission length in the device error reporting. When the received data length is inconsistent with the expected one, an error is reported. This bit is cleared when it is read.
- 0: No interrupt is generated.
- 1: An interrupt is generated. (data sheet access type RC)";
            sw = r; hw = w; onread = rclr;
            reset = 0x0;
        } ack_with_err_13[13:13];
        field {
            name = "ack_with_err_12";
            desc = "Bit indicating an invalid DSI VC ID in the device error reporting. When the device receives an unidentified ID, an error is reported. This bit is cleared when it is read.
- 0: No interrupt is generated.
- 1: An interrupt is generated. (data sheet access type RC)";
            sw = r; hw = w; onread = rclr;
            reset = 0x0;
        } ack_with_err_12[12:12];
        field {
            name = "ack_with_err_11";
            desc = "\"DSI Data Type Not Recognized\" bit in the device error reporting. When the device receives an unrecognized data type, an error is reported. This bit is cleared when it is read.
- 0: No interrupt is generated. (data sheet access type RC)";
            sw = r; hw = w; onread = rclr;
            reset = 0x0;
        } ack_with_err_11[11:11];
        field {
            name = "ack_with_err_10";
            desc = "\"Checksum Error\" bit in the device error reporting. When the received data has cyclic redundancy check (CRC) errors, an error is reported. This bit is cleared when it is read.
- 0: No interrupt is generated.
- 1: An interrupt is generated. (data sheet access type RC)";
            sw = r; hw = w; onread = rclr;
            reset = 0x0;
        } ack_with_err_10[10:10];
        field {
            name = "ack_with_err_9";
            desc = "Multi-bit ECC error in the device error reporting. When the device receives data which has multi-bit CRC errors, an error is reported. This bit is cleared when it is read.
- 0: No interrupt is generated.
- 1: An interrupt is generated. (data sheet access type RC)";
            sw = r; hw = w; onread = rclr;
            reset = 0x0;
        } ack_with_err_9[9:9];
        field {
            name = "ack_with_err_8";
            desc = "Single-bit ECC error in the device error reporting. When the device receives data which has single-bit CRC errors, an error is reported. This bit is cleared when it is read.
- 0: No interrupt is generated.
- 1: An interrupt is generated. (data sheet access type RC)";
            sw = r; hw = w; onread = rclr;
            reset = 0x0;
        } ack_with_err_8[8:8];
        field {
            name = "ack_with_err_7";
            desc = "Contention detected bit in the device error reporting. When the device has LP contention, an error is reported. This bit is cleared when it is read.
- 0: No interrupt is generated.
- 1: An interrupt is generated. (data sheet access type RC)";
            sw = r; hw = w; onread = rclr;
            reset = 0x0;
        } ack_with_err_7[7:7];
        field {
            name = "ack_with_err_6";
            desc = "False control error in the device error reporting. When the device receives incorrect status sequence, an error is reported. This bit is cleared when it is read.
- 0: No interrupt is generated.
- 1: An interrupt is generated. (data sheet access type RC)";
            sw = r; hw = w; onread = rclr;
            reset = 0x0;
        } ack_with_err_6[6:6];
        field {
            name = "ack_with_err_5";
            desc = "Peripheral timeout error bit in the device error reporting. When the device has timeout, an error is reported. This bit is cleared when it is read.
- 0: No interrupt is generated.
- 1: An interrupt is generated. (data sheet access type RC)";
            sw = r; hw = w; onread = rclr;
            reset = 0x0;
        } ack_with_err_5[5:5];
        field {
            name = "ack_with_err_4";
            desc = "\"Low-Power Transmit Sync Error\" bit in the device error reporting. In LP transmission mode, if the number of received bits is not a multiple of 8, an error is reported. This bit is cleared when it is read.
- 0: No interrupt is generated. (data sheet access type RC)";
            sw = r; hw = w; onread = rclr;
            reset = 0x0;
        } ack_with_err_4[4:4];
        field {
            name = "ack_with_err_3";
            desc = "\"Escape Mode Entry Command Error\" bit in the device error reporting. When the device receives an incorrect ESC command, an error is reported. This bit is cleared when it is read.
- 0: No interrupt is generated.
- 1: An interrupt is generated. (data sheet access type RC)";
            sw = r; hw = w; onread = rclr;
            reset = 0x0;
        } ack_with_err_3[3:3];
        field {
            name = "ack_with_err_2";
            desc = "\"EoT Sync Error\" bit in the device error reporting. When the device receives an incorrect EoT sequence, an error is reported. This bit is cleared when it is read.
- 0: No interrupt is generated.
- 1: An interrupt is generated. (data sheet access type RC)";
            sw = r; hw = w; onread = rclr;
            reset = 0x0;
        } ack_with_err_2[2:2];
        field {
            name = "ack_with_err_1";
            desc = "\"SoT Sync Error\" bit in the device error reporting. When the device receives an incorrect SoT sequence, an error is reported. This bit is cleared when it is read.
- 0: No interrupt is generated.
- 1: An interrupt is generated. (data sheet access type RC)";
            sw = r; hw = w; onread = rclr;
            reset = 0x0;
        } ack_with_err_1[1:1];
        field {
            name = "ack_with_err_0";
            desc = "\"SoT Error\" bit in the device error report. If the device can receive correct synchronization information after receiving an incorrect EoT sequence, an error is reported. This bit is cleared when it is read.
- 0: No interrupt is generated.
- 1: An interrupt is generated. (data sheet access type RC)";
            sw = r; hw = w; onread = rclr;
            reset = 0x0;
        } ack_with_err_0[0:0];
    } INT_ST0 @ 0xbc;
    reg {
        name = "INT_ST1";
        desc = "INT_ST1 is interrupt status 1 register. INT_ST1 (offset 0x00C0, total reset 0x0000_0000; PROVEN: Hi3516D V300 data sheet, PDF page 719, section 9.4.6).";
        field {
            name = "reserved";
            desc = "Reserved";
            sw = r; hw = na;
            reset = 0x0;
        } reserved_31_25[31:25];
        field {
            name = "hss_abnormal";
            desc = "Interrupt when the HSS packet is not transmitted at the packet start phase. This bit is cleared when it is read.
- 0: No interrupt is generated.
- 1: An interrupt is generated. (data sheet access type RC)";
            sw = r; hw = w; onread = rclr;
            reset = 0x0;
        } hss_abnormal[24:24];
        field {
            name = "rxtrigger_3";
            desc = "01100010 trigger interrupt. This bit is cleared when it is read. (data sheet access type RC)";
            sw = r; hw = w; onread = rclr;
            reset = 0x0;
        } rxtrigger_3[23:23];
        field {
            name = "rxtrigger_2";
            desc = "01011101 trigger interrupt. This bit is cleared when it is read.
- 0: No interrupt is generated.
- 1: An interrupt is generated. (data sheet access type RC)";
            sw = r; hw = w; onread = rclr;
            reset = 0x0;
        } rxtrigger_2[22:22];
        field {
            name = "rxtrigger_1";
            desc = "00100001 trigger interrupt. This bit is cleared when it is read.
- 0: No interrupt is generated.
- 1: An interrupt is generated. (data sheet access type RC)";
            sw = r; hw = w; onread = rclr;
            reset = 0x0;
        } rxtrigger_1[21:21];
        field {
            name = "rxtrigger_0";
            desc = "10100000 trigger interrupt. This bit is cleared when it is read.
- 0: No interrupt is generated.
- 1: An interrupt is generated. (data sheet access type RC)";
            sw = r; hw = w; onread = rclr;
            reset = 0x0;
        } rxtrigger_0[20:20];
        field {
            name = "reserved";
            desc = "Reserved";
            sw = r; hw = na;
            reset = 0x0;
        } reserved_19_17[19:17];
        field {
            name = "vsstart";
            desc = "Frame pulse interrupt. This bit is cleared when it is read.
- 0: No interrupt is generated.
- 1: An interrupt is generated. (data sheet access type RC)";
            sw = r; hw = w; onread = rclr;
            reset = 0x0;
        } vsstart[16:16];
        field {
            name = "reserved";
            desc = "Reserved";
            sw = r; hw = na;
            reset = 0x0;
        } reserved_15_13[15:13];
        field {
            name = "gen_pld_recev_err";
            desc = "RX FIFO full write error interrupt. This bit is cleared when it is read.
- 0: No interrupt is generated.
- 1: An interrupt is generated. (data sheet access type RC)";
            sw = r; hw = w; onread = rclr;
            reset = 0x0;
        } gen_pld_recev_err[12:12];
        field {
            name = "gen_pld_rd_err";
            desc = "RX FIFO empty read error interrupt. This bit is cleared when it is read.
- 0: No interrupt is generated.
- 1: An interrupt is generated. (data sheet access type RC)";
            sw = r; hw = w; onread = rclr;
            reset = 0x0;
        } gen_pld_rd_err[11:11];
        field {
            name = "gen_pld_send_err";
            desc = "Payload FIFO empty read error interrupt. This bit is cleared when it is read.
- 0: No interrupt is generated.
- 1: An interrupt is generated. (data sheet access type RC)";
            sw = r; hw = w; onread = rclr;
            reset = 0x0;
        } gen_pld_send_err[10:10];
        field {
            name = "gen_pld_wr_err";
            desc = "Payload FIFO full write error interrupt. This bit is cleared when it is read.
- 0: No interrupt is generated.
- 1: An interrupt is generated. (data sheet access type RC)";
            sw = r; hw = w; onread = rclr;
            reset = 0x0;
        } gen_pld_wr_err[9:9];
        field {
            name = "gen_cmd_wr_err";
            desc = "Command FIFO full write error interrupt. This bit is cleared when it is read.
- 0: No interrupt is generated. (data sheet access type RC)";
            sw = r; hw = w; onread = rclr;
            reset = 0x0;
        } gen_cmd_wr_err[8:8];
        field {
            name = "VideomodeFIFOfullwriteerrorinterrupt.Thisbitisclearedwhenitisread.dpi_pld_wr_err0:Nointerruptisgenerated.1:Aninterruptisgenerated.";
            desc = " (data sheet access type RC)";
            sw = r; hw = w; onread = rclr;
            reset = 0x0;
        } VideomodeFIFOfullwriteerrorinterrupt_Thisbitisclearedwhenitisread_dpi_pld_wr_err0_Nointerruptisgenerated_1_Aninterruptisgenerated[7:7];
        field {
            name = "EoTpRXerrorinterrupt.Thisbitisclearedwhenitisread.eopt_err0:Nointerruptisgenerated.1:Aninterruptisgenerated.";
            desc = " (data sheet access type RC)";
            sw = r; hw = w; onread = rclr;
            reset = 0x0;
        } EoTpRXerrorinterrupt_Thisbitisclearedwhenitisread_eopt_err0_Nointerruptisgenerated_1_Aninterruptisgenerated[6:6];
        field {
            name = "PacketsizeRXerrorinterrupt.Thisbitisclearedwhenitisread.pkt_size_err0:Nointerruptisgenerated.1:Aninterruptisgenerated.";
            desc = " (data sheet access type RC)";
            sw = r; hw = w; onread = rclr;
            reset = 0x0;
        } PacketsizeRXerrorinterrupt_Thisbitisclearedwhenitisread_pkt_size_err0_Nointerruptisgenerated_1_Aninterruptisgenerated[5:5];
        field {
            name = "RXdataCRCerrorinterrupt.Thisbitisclearedwhenitisread.crc_err0:Nointerruptisgenerated.1:Aninterruptisgenerated.";
            desc = " (data sheet access type RC)";
            sw = r; hw = w; onread = rclr;
            reset = 0x0;
        } RXdataCRCerrorinterrupt_Thisbitisclearedwhenitisread_crc_err0_Nointerruptisgenerated_1_Aninterruptisgenerated[4:4];
        field {
            name = "RXdataECCmulti-biterrorinterrupt.Thisbitisclearedwhenitisread.ecc_multi_err0:Nointerruptisgenerated.1:Aninterruptisgenerated.";
            desc = " (data sheet access type RC)";
            sw = r; hw = w; onread = rclr;
            reset = 0x0;
        } RXdataECCmulti_biterrorinterrupt_Thisbitisclearedwhenitisread_ecc_multi_err0_Nointerruptisgenerated_1_Aninterruptisgenerated[3:3];
        field {
            name = "RXdataECCsingle-biterrorinterrupt.Thisbitisclearedwhenitisread.ecc_single_err0:Nointerruptisgenerated.1:Aninterruptisgenerated.";
            desc = " (data sheet access type RC)";
            sw = r; hw = w; onread = rclr;
            reset = 0x0;
        } RXdataECCsingle_biterrorinterrupt_Thisbitisclearedwhenitisread_ecc_single_err0_Nointerruptisgenerated_1_Aninterruptisgenerated[2:2];
        field {
            name = "LPRXtimeouterrorinterrupt.Thisbitisclearedwhenitisread.to_lp_rx0:Nointerruptisgenerated.1:Aninterruptisgenerated.";
            desc = " (data sheet access type RC)";
            sw = r; hw = w; onread = rclr;
            reset = 0x0;
        } LPRXtimeouterrorinterrupt_Thisbitisclearedwhenitisread_to_lp_rx0_Nointerruptisgenerated_1_Aninterruptisgenerated[1:1];
        field {
            name = "LPTXtimeouterrorinterrupt.Thisbitisclearedwhenitisread.to_hs_tx0:Nointerruptisgenerated.1:Aninterruptisgenerated.";
            desc = " (data sheet access type RC)";
            sw = r; hw = w; onread = rclr;
            reset = 0x0;
        } LPTXtimeouterrorinterrupt_Thisbitisclearedwhenitisread_to_hs_tx0_Nointerruptisgenerated_1_Aninterruptisgenerated[0:0];
    } INT_ST1 @ 0xc0;
    reg {
        name = "INT_MSK0";
        desc = "INT_MSK0 is the interrupt 0 mask register. INT_MSK0 (offset 0x00C4, total reset 0x0000_0000; PROVEN: Hi3516D V300 data sheet, PDF page 721, section 9.4.6).";
        field {
            name = "reserved";
            desc = "Reserved";
            sw = r; hw = na;
            reset = 0x0;
        } reserved_31_21[31:21];
        field {
            name = "mask_dphy_errors_4";
            desc = "dphy_errors_4 interrupt mask enable
- 0: masked
- 1: enabled";
            sw = rw; hw = r;
            reset = 0x0;
        } mask_dphy_errors_4[20:20];
        field {
            name = "mask_dphy_errors_3";
            desc = "dphy_errors_3 interrupt mask enable
- 0: masked
- 1: enabled";
            sw = rw; hw = r;
            reset = 0x0;
        } mask_dphy_errors_3[19:19];
        field {
            name = "mask_dphy_errors_2";
            desc = "dphy_errors_2 interrupt mask enable
- 0: masked
- 1: enabled";
            sw = rw; hw = r;
            reset = 0x0;
        } mask_dphy_errors_2[18:18];
        field {
            name = "mask_dphy_errors_1";
            desc = "dphy_errors_1 interrupt mask enable
- 0: masked
- 1: enabled";
            sw = rw; hw = r;
            reset = 0x0;
        } mask_dphy_errors_1[17:17];
        field {
            name = "mask_dphy_errors_0";
            desc = "dphy_errors_0 interrupt mask enable
- 0: masked
- 1: enabled";
            sw = rw; hw = r;
            reset = 0x0;
        } mask_dphy_errors_0[16:16];
        field {
            name = "mask_ack_with_err_15";
            desc = "ack_with_err_15 interrupt mask enable
- 0: masked
- 1: enabled";
            sw = rw; hw = r;
            reset = 0x0;
        } mask_ack_with_err_15[15:15];
        field {
            name = "mask_ack_with_err_14";
            desc = "ack_with_err_14 interrupt mask enable
- 0: masked
- 1: enabled";
            sw = rw; hw = r;
            reset = 0x0;
        } mask_ack_with_err_14[14:14];
        field {
            name = "mask_ack_with_err_13";
            desc = "ack_with_err_13 interrupt mask enable
- 0: masked
- 1: enabled";
            sw = rw; hw = r;
            reset = 0x0;
        } mask_ack_with_err_13[13:13];
        field {
            name = "mask_ack_with_err_12";
            desc = "ack_with_err_12 interrupt mask enable
- 0: masked
- 1: enabled";
            sw = rw; hw = r;
            reset = 0x0;
        } mask_ack_with_err_12[12:12];
        field {
            name = "mask_ack_with_err_11";
            desc = "ack_with_err_11 interrupt mask enable
- 0: masked
- 1: enabled";
            sw = rw; hw = r;
            reset = 0x0;
        } mask_ack_with_err_11[11:11];
        field {
            name = "mask_ack_with_err_10";
            desc = "ack_with_err_10 interrupt mask enable
- 0: masked
- 1: enabled";
            sw = rw; hw = r;
            reset = 0x0;
        } mask_ack_with_err_10[10:10];
        field {
            name = "mask_ack_with_err_9";
            desc = "ack_with_err_9 interrupt mask enable
- 0: masked";
            sw = rw; hw = r;
            reset = 0x0;
        } mask_ack_with_err_9[9:9];
        field {
            name = "ack_with_err_8mask_ack_with_err_0:81:";
            desc = "interrupt mask enable masked enabled";
            sw = rw; hw = r;
            reset = 0x0;
        } ack_with_err_8mask_ack_with_err_0_81[8:8];
        field {
            name = "ack_with_err_7mask_ack_with_err_0:71:";
            desc = "interrupt mask enable masked enabled";
            sw = rw; hw = r;
            reset = 0x0;
        } ack_with_err_7mask_ack_with_err_0_71[7:7];
        field {
            name = "ack_with_err_6mask_ack_with_err_0:61:";
            desc = "interrupt mask enable masked enabled";
            sw = rw; hw = r;
            reset = 0x0;
        } ack_with_err_6mask_ack_with_err_0_61[6:6];
        field {
            name = "ack_with_err_5mask_ack_with_err_0:51:";
            desc = "interrupt mask enable masked enabled";
            sw = rw; hw = r;
            reset = 0x0;
        } ack_with_err_5mask_ack_with_err_0_51[5:5];
        field {
            name = "ack_with_err_4mask_ack_with_err_0:41:";
            desc = "interrupt mask enable masked enabled";
            sw = rw; hw = r;
            reset = 0x0;
        } ack_with_err_4mask_ack_with_err_0_41[4:4];
        field {
            name = "ack_with_err_3mask_ack_with_err_0:31:";
            desc = "interrupt mask enable masked enabled";
            sw = rw; hw = r;
            reset = 0x0;
        } ack_with_err_3mask_ack_with_err_0_31[3:3];
        field {
            name = "ack_with_err_2mask_ack_with_err_0:21:";
            desc = "interrupt mask enable masked enabled";
            sw = rw; hw = r;
            reset = 0x0;
        } ack_with_err_2mask_ack_with_err_0_21[2:2];
        field {
            name = "ack_with_err_1mask_ack_with_err_0:11:";
            desc = "interrupt mask enable masked enabled";
            sw = rw; hw = r;
            reset = 0x0;
        } ack_with_err_1mask_ack_with_err_0_11[1:1];
        field {
            name = "ack_with_err_0mask_ack_with_err_0:01:";
            desc = "interrupt mask enable masked enabled";
            sw = rw; hw = r;
            reset = 0x0;
        } ack_with_err_0mask_ack_with_err_0_01[0:0];
    } INT_MSK0 @ 0xc4;
    reg {
        name = "INT_MSK1";
        desc = "INT_MSK1 is the interrupt 1 mask register. INT_MSK1 (offset 0x00C8, total reset 0x0000_0000; PROVEN: Hi3516D V300 data sheet, PDF page 723, section 9.4.6).";
        field {
            name = "reserved";
            desc = "Reserved";
            sw = r; hw = na;
            reset = 0x0;
        } reserved_31_25[31:25];
        field {
            name = "mask_hss_abnormal";
            desc = "to_hs_tx interrupt mask or enable
- 0: masked
- 1: enabled";
            sw = rw; hw = r;
            reset = 0x0;
        } mask_hss_abnormal[24:24];
        field {
            name = "mask_trigger_3";
            desc = "01100010 trigger interrupt mask or enable
- 0: masked
- 1: enabled";
            sw = rw; hw = r;
            reset = 0x0;
        } mask_trigger_3[23:23];
        field {
            name = "mask_trigger_2";
            desc = "01011101 trigger interrupt mask or enable
- 0: masked
- 1: enabled";
            sw = rw; hw = r;
            reset = 0x0;
        } mask_trigger_2[22:22];
        field {
            name = "mask_trigger_1";
            desc = "00100001 trigger interrupt mask or enable
- 0: masked
- 1: enabled";
            sw = rw; hw = r;
            reset = 0x0;
        } mask_trigger_1[21:21];
        field {
            name = "mask_trigger_0";
            desc = "10100000 trigger interrupt mask or enable
- 0: masked
- 1: enabled";
            sw = rw; hw = r;
            reset = 0x0;
        } mask_trigger_0[20:20];
        field {
            name = "reserved";
            desc = "Reserved";
            sw = r; hw = na;
            reset = 0x0;
        } reserved_19_17[19:17];
        field {
            name = "mask_vsstart";
            desc = "Vsstart interrupt enable or mask
- 0: masked
- 1: enabled";
            sw = rw; hw = r;
            reset = 0x0;
        } mask_vsstart[16:16];
        field {
            name = "reserved";
            desc = "Reserved";
            sw = r; hw = na;
            reset = 0x0;
        } reserved_15_13[15:13];
        field {
            name = "mask_gen_pld_recev_err";
            desc = "gen_pld_recev_err interrupt mask or enable
- 0: masked
- 1: enabled";
            sw = rw; hw = r;
            reset = 0x0;
        } mask_gen_pld_recev_err[12:12];
        field {
            name = "mask_gen_pld_rd_err";
            desc = "gen_pld_rd_err interrupt mask or enable
- 0: masked
- 1: enabled";
            sw = rw; hw = r;
            reset = 0x0;
        } mask_gen_pld_rd_err[11:11];
        field {
            name = "mask_gen_pld_send_err";
            desc = "gen_pld_send_err interrupt mask or enable
- 0: masked
- 1: enabled";
            sw = rw; hw = r;
            reset = 0x0;
        } mask_gen_pld_send_err[10:10];
        field {
            name = "mask_gen_pld_wr_err";
            desc = "gen_pld_wr_err interrupt mask or enable
- 0: masked
- 1: enabled";
            sw = rw; hw = r;
            reset = 0x0;
        } mask_gen_pld_wr_err[9:9];
        field {
            name = "mask_gen_cmd_wr_err";
            desc = "gen_cmd_wr_err interrupt mask or enable
- 0: masked
- 1: enabled";
            sw = rw; hw = r;
            reset = 0x0;
        } mask_gen_cmd_wr_err[8:8];
        field {
            name = "mask_dpi_pld_wr_er";
            desc = "dpi_pld_wr_err interrupt mask or enable";
            sw = rw; hw = r;
            reset = 0x0;
        } mask_dpi_pld_wr_er[7:7];
        field {
            name = "mask_eopt_err";
            desc = "eopt_err interrupt mask or enable
- 0: masked
- 1: enabled";
            sw = rw; hw = r;
            reset = 0x0;
        } mask_eopt_err[6:6];
        field {
            name = "mask_pkt_size_err";
            desc = "pkt_size_err interrupt mask or enable
- 0: masked
- 1: enabled";
            sw = rw; hw = r;
            reset = 0x0;
        } mask_pkt_size_err[5:5];
        field {
            name = "mask_crc_err";
            desc = "crc_err interrupt mask or enable
- 0: masked
- 1: enabled";
            sw = rw; hw = r;
            reset = 0x0;
        } mask_crc_err[4:4];
        field {
            name = "mask_ecc_multi_err";
            desc = "ecc_multi_err interrupt mask or enable
- 0: masked
- 1: enabled";
            sw = rw; hw = r;
            reset = 0x0;
        } mask_ecc_multi_err[3:3];
        field {
            name = "mask_ecc_single_err";
            desc = "ecc_single_err interrupt mask or enable
- 0: masked
- 1: enabled";
            sw = rw; hw = r;
            reset = 0x0;
        } mask_ecc_single_err[2:2];
        field {
            name = "mask_to_lp_rx";
            desc = "to_lp_rx interrupt mask or enable
- 0: masked
- 1: enabled";
            sw = rw; hw = r;
            reset = 0x0;
        } mask_to_lp_rx[1:1];
        field {
            name = "mask_to_hs_tx";
            desc = "to_hs_tx interrupt mask or enable
- 0: masked
- 1: enabled";
            sw = rw; hw = r;
            reset = 0x0;
        } mask_to_hs_tx[0:0];
    } INT_MSK1 @ 0xc8;
    reg {
        name = "OPERATION_MODE";
        desc = "OPERATION_MODE is the operating mode control register. OPERATION_MODE (offset 0x0208, total reset 0x0000_0002; PROVEN: Hi3516D V300 data sheet, PDF page 725, section 9.4.6).";
        field {
            name = "input_en";
            desc = "Validity enable of input data in the upper-level module
- 0: disabled
- 1: enabled";
            sw = rw; hw = r;
            reset = 0x0;
        } input_en[31:31];
        field {
            name = "reserved";
            desc = "Reserved";
            sw = r; hw = na;
            reset = 0x0;
        } reserved_30_21[30:21];
        field {
            name = "hss_abnormal_rst";
            desc = "Whether to enable the automatic correction function when the HSS packet is not";
            sw = rw; hw = r;
            reset = 0x0;
        } hss_abnormal_rst[20:20];
        field {
            name = "reserved";
            desc = "Reserved";
            sw = r; hw = na;
            reset = 0x0;
        } reserved_19_19[19:19];
        field {
            name = "buf_clr_en";
            desc = "Buffer clear enable for each frame
- 0: disabled
- 1: enabled";
            sw = rw; hw = r;
            reset = 0x0;
        } buf_clr_en[18:18];
        field {
            name = "reserved";
            desc = "Reserved";
            sw = r; hw = na;
            reset = 0x0;
        } reserved_17_17[17:17];
        field {
            name = "read_empty_vsync_en";
            desc = "FIFO read empty enable for each frame
- 0: disabled
- 1: enabled";
            sw = rw; hw = r;
            reset = 0x0;
        } read_empty_vsync_en[16:16];
        field {
            name = "reserved";
            desc = "Reserved";
            sw = r; hw = na;
            reset = 0x0;
        } reserved_15_6[15:6];
        field {
            name = "init_skew_en";
            desc = "Initial skew enable
- 0: disabled
- 1: enabled";
            sw = rw; hw = r;
            reset = 0x0;
        } init_skew_en[5:5];
        field {
            name = "reserved";
            desc = "Reserved";
            sw = r; hw = na;
            reset = 0x0;
        } reserved_4_2[4:2];
        field {
            name = "mem_ck_en";
            desc = "Memory gating enable indicator
- 0: The memory gating is always enabled.
- 1: The memory gating is enabled when the memory is read or written, and is disabled when the memory is idle.";
            sw = rw; hw = r;
            reset = 0x1;
        } mem_ck_en[1:1];
        field {
            name = "reserved";
            desc = "Reserved";
            sw = r; hw = w;
            reset = 0x0;
        } reserved_0_0[0:0];
    } OPERATION_MODE @ 0x208;
    reg {
        name = "V_H_SEND";
        desc = "V_H_SEND is the TX width/height register. V_H_SEND (offset 0x0224, total reset 0x0000_0000; PROVEN: Hi3516D V300 data sheet, PDF page 726, section 9.4.6).";
        field {
            name = "v_send";
            desc = "TX height";
            sw = r; hw = w;
            reset = 0x0;
        } v_send[31:16];
        field {
            name = "h_send";
            desc = "TX width";
            sw = r; hw = w;
            reset = 0x0;
        } h_send[15:0];
    } V_H_SEND @ 0x224;
    reg {
        name = "DATATYPE0";
        desc = "DATATYPE0 is data type configuration register 0. DATATYPE0 (offset 0x0230, total reset 0x0111_213D; PROVEN: Hi3516D V300 data sheet, PDF page 726, section 9.4.6).";
        field {
            name = "reserved";
            desc = "Reserved";
            sw = r; hw = na;
            reset = 0x0;
        } reserved_31_30[31:30];
        field {
            name = "dt_vss";
            desc = "Data type of the SOF";
            sw = rw; hw = r;
            reset = 0x1;
        } dt_vss[29:24];
        field {
            name = "reserved";
            desc = "Reserved";
            sw = r; hw = na;
            reset = 0x0;
        } reserved_23_22[23:22];
        field {
            name = "dt_vse";
            desc = "Data type of the EOF";
            sw = rw; hw = r;
            reset = 0x11;
        } dt_vse[21:16];
        field {
            name = "reserved";
            desc = "Reserved";
            sw = r; hw = na;
            reset = 0x0;
        } reserved_15_14[15:14];
        field {
            name = "dt_hss";
            desc = "Data type of the start of a line";
            sw = rw; hw = r;
            reset = 0x21;
        } dt_hss[13:8];
        field {
            name = "reserved";
            desc = "Reserved";
            sw = r; hw = na;
            reset = 0x0;
        } reserved_7_6[7:6];
        field {
            name = "reserved";
            desc = "Reserved";
            sw = r; hw = w;
            reset = 0x3d;
        } reserved_5_0[5:0];
    } DATATYPE0 @ 0x230;
    reg {
        name = "CSI_CTRL";
        desc = "CSI_CTRL is the CSI timing configuration register. CSI_CTRL (offset 0x0238, total reset 0x0001_0100; PROVEN: Hi3516D V300 data sheet, PDF page 727, section 9.4.6).";
        field {
            name = "reserved";
            desc = "Reserved";
            sw = r; hw = na;
            reset = 0x0;
        } reserved_31_17[31:17];
        field {
            name = "reserved";
            desc = "Reserved";
            sw = r; hw = w;
            reset = 0x1;
        } reserved_16_16[16:16];
        field {
            name = "reserved";
            desc = "Reserved";
            sw = r; hw = na;
            reset = 0x0;
        } reserved_15_9[15:9];
        field {
            name = "reserved";
            desc = "Reserved";
            sw = r; hw = w;
            reset = 0x1;
        } reserved_8_8[8:8];
        field {
            name = "reserved";
            desc = "Reserved";
            sw = r; hw = na;
            reset = 0x0;
        } reserved_7_1[7:1];
        field {
            name = "csi_en";
            desc = "CSI timing enable
- 0: disabled
- 1: enabled";
            sw = rw; hw = r;
            reset = 0x0;
        } csi_en[0:0];
    } CSI_CTRL @ 0x238;
};

`endif
