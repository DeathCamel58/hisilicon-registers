`ifndef EHI3516DV300_SYS_CTRL_RDL
`define EHI3516DV300_SYS_CTRL_RDL
regfile eHI3516DV300_SYS_CTRL {
    name = "System controller (SC)";
    desc = "System controller (SC). 15 registers extracted programmatically from the Hi3516D V300 Professional Smart IP Camera SoC data sheet (Issue 01, 2019-09-12); chapter 3.5.3, table 3-7. Field names, bit ranges, access types and reset values are taken from the register tables; reset values are the data sheet total reset values split onto the fields (per-field values where the table has them). Label: PROVEN. Hardware not verified here (no board).";
    reg {
        name = "SC_CTRL";
        desc = "SC_CTRL is a system control register. It is used to specify the operations to be performed by the system. Write protection for this register can be enabled by configuring SC_LOCKEN. This register can be written only when write protection is disabled. SC_CTRL (offset 0x0000, total reset 0x0000_0200; PROVEN: Hi3516D V300 data sheet, PDF page 146, section 3.5.3).";
        field {
            name = "reserved";
            desc = "Reserved";
            sw = r; hw = na;
            reset = 0x0;
        } reserved_31_24[31:24];
        field {
            name = "timeren7ov";
            desc = "Timer 7 count clock select
- 0: 3 MHz clock
- 1: bus clock";
            sw = rw; hw = r;
            reset = 0x0;
        } timeren7ov[23:23];
        field {
            name = "timeren6ov";
            desc = "Timer 6 count clock select
- 0: 3 MHz clock
- 1: bus clock";
            sw = rw; hw = r;
            reset = 0x0;
        } timeren6ov[22:22];
        field {
            name = "timeren5ov";
            desc = "Timer 5 count clock select
- 0: 3 MHz clock
- 1: bus clock";
            sw = rw; hw = r;
            reset = 0x0;
        } timeren5ov[21:21];
        field {
            name = "timeren4ov";
            desc = "Timer 4 count clock select
- 0: 3 MHz clock
- 1: bus clock";
            sw = rw; hw = r;
            reset = 0x0;
        } timeren4ov[20:20];
        field {
            name = "timeren3ov";
            desc = "Timer 3 count clock select
- 0: 3 MHz clock
- 1: bus clock";
            sw = rw; hw = r;
            reset = 0x0;
        } timeren3ov[19:19];
        field {
            name = "timeren2ov";
            desc = "Timer 2 count clock select
- 0: 3 MHz clock
- 1: bus clock";
            sw = rw; hw = r;
            reset = 0x0;
        } timeren2ov[18:18];
        field {
            name = "timeren1ov";
            desc = "Timer 1 count clock select
- 0: 3 MHz clock
- 1: bus clock";
            sw = rw; hw = r;
            reset = 0x0;
        } timeren1ov[17:17];
        field {
            name = "timeren0ov";
            desc = "Timer 0 count clock select
- 0: 3 MHz clock
- 1: bus clock";
            sw = rw; hw = r;
            reset = 0x0;
        } timeren0ov[16:16];
        field {
            name = "reserved";
            desc = "Reserved";
            sw = r; hw = na;
            reset = 0x0;
        } reserved_15_10[15:10];
        field {
            name = "remapstat";
            desc = "Address remapping state
- 0: not in the remapping state
- 1: in the remapping state";
            sw = r; hw = w;
            reset = 0x1;
        } remapstat[9:9];
        field {
            name = "remapclear";
            desc = "Address remapping clear
- 0: The remapping state is retained.
- 1: The remapping state is cleared.

For details about the address mapping relationships before and after remapping is cleared, see section 1.3 \"Boot Mode\" and section";
            sw = rw; hw = r;
            reset = 0x0;
        } remapclear[8:8];
        field {
            name = "reserved";
            desc = "Reserved";
            sw = r; hw = na;
            reset = 0x0;
        } reserved_7_0[7:0];
    } SC_CTRL @ 0x0;
    reg {
        name = "SC_SYSRES";
        desc = "SC_SYSRES is a system soft reset register. When a value is written to this register, the system controller sends a system soft reset request to the reset module. Then the reset module resets the system. Write protection for this register can be enabled by configuring SC_LOCKEN. This register can be written only when write protection is disabled. SC_SYSRES (offset 0x0004, total reset 0x0000_0002; PROVEN: Hi3516D V300 data sheet, PDF page 147, section 3.5.3).";
        field {
            name = "softresreq";
            desc = "Writing any value to this register soft-resets the system.";
            sw = w; hw = r;
            reset = 0x2;
        } softresreq[31:0];
    } SC_SYSRES @ 0x4;
    reg {
        name = "SOFTINT";
        desc = "SOFTINT is a software interrupt register. SOFTINT (offset 0x001C, total reset 0x0000_0000; PROVEN: Hi3516D V300 data sheet, PDF page 148, section 3.5.3).";
        field {
            name = "reserved";
            desc = "Reserved";
            sw = r; hw = na;
            reset = 0x0;
        } reserved_31_1[31:1];
        field {
            name = "software_int";
            desc = "Writing 1 to this bit generates the software interrupt.";
            sw = rw; hw = r;
            reset = 0x0;
        } software_int[0:0];
    } SOFTINT @ 0x1c;
    reg {
        name = "SOFTTYPE";
        desc = "SOFTTYPE is a software interrupt vector register. SOFTTYPE (offset 0x0020, total reset 0x0000_0000; PROVEN: Hi3516D V300 data sheet, PDF page 148, section 3.5.3).";
        field {
            name = "software_int_vector";
            desc = "Software interrupt vector";
            sw = r; hw = na;
            reset = 0x0;
        } software_int_vector[31:0];
    } SOFTTYPE @ 0x20;
    reg {
        name = "PERISTAT";
        desc = "PERISTAT is a peripheral status register. PERISTAT (offset 0x0030, total reset 0x0000_0000; PROVEN: Hi3516D V300 data sheet, PDF page 148, section 3.5.3).";
        field {
            name = "reserved";
            desc = "Reserved";
            sw = r; hw = na;
            reset = 0x0;
        } reserved_31_19[31:19];
        field {
            name = "usb2_update_delay_time";
            desc = "USB update delay
- 00: 0 ms
- 01: 200 ms
- 10: 300 ms
- 11: 400 ms";
            sw = r; hw = w;
            reset = 0x0;
        } usb2_update_delay_time[18:17];
        field {
            name = "emmc_poweron_delay_time";
            desc = "eMMC power-on delay
- 00: 0 ms
- 01: 20 ms";
            sw = r; hw = w;
            reset = 0x0;
        } emmc_poweron_delay_time[16:15];
        field {
            name = "reserved";
            desc = "Reserved";
            sw = r; hw = w;
            reset = 0x0;
        } reserved_14_14[14:14];
        field {
            name = "emmc_pad_pu_disable";
            desc = "Flag indicating whether the internal pull-up resistor of the eMMC CMD or DATA I/O is disabled
- 0: The internal pull-up resistor is enabled.
- 1: The internal pull-up resistor is disabled.";
            sw = r; hw = w;
            reset = 0x0;
        } emmc_pad_pu_disable[13:13];
        field {
            name = "sdio_pad_pu_disable";
            desc = "Flag indicating whether the internal pull-up resistor of the SDIO0 CMD or DATA I/O is disabled
- 0: The internal pull-up resistor is enabled.
- 1: The internal pull-up resistor is disabled.";
            sw = r; hw = w;
            reset = 0x0;
        } sdio_pad_pu_disable[12:12];
        field {
            name = "boot_backup_enable";
            desc = "Boot backup enable
- 0: disabled
- 1: enabled";
            sw = r; hw = w;
            reset = 0x0;
        } boot_backup_enable[11:11];
        field {
            name = "emmc_boot_cksel";
            desc = "eMMC start frequency select
- 000: 25 MHz
- 001: 400 KHz
- 010: 50 MHz

Other values: reserved";
            sw = r; hw = w;
            reset = 0x0;
        } emmc_boot_cksel[10:8];
        field {
            name = "usb_phy_para_sel";
            desc = "USB PHY parameter configuration flag (reserved)";
            sw = r; hw = w;
            reset = 0x0;
        } usb_phy_para_sel[7:6];
        field {
            name = "update_from_usb_disable";
            desc = "USB update disable
- 0: enabled
- 1: disabled";
            sw = r; hw = w;
            reset = 0x0;
        } update_from_usb_disable[5:5];
        field {
            name = "update_from_sdio_disable";
            desc = "SDIO update disable
- 0: enabled
- 1: disabled";
            sw = r; hw = w;
            reset = 0x0;
        } update_from_sdio_disable[4:4];
        field {
            name = "jtag_ca_en";
            desc = "JTAG conditional access enable
- 0: disabled
- 1: enabled";
            sw = r; hw = w;
            reset = 0x0;
        } jtag_ca_en[3:3];
        field {
            name = "reserved";
            desc = "Reserved";
            sw = r; hw = w;
            reset = 0x0;
        } reserved_2_2[2:2];
        field {
            name = "ddrca_en";
            desc = "DDR scrambling enable
- 0: disabled
- 1: enabled";
            sw = r; hw = w;
            reset = 0x0;
        } ddrca_en[1:1];
        field {
            name = "sec_boot_mode";
            desc = "Secure boot mode
- 0: non-secure boot mode
- 1: secure boot mode";
            sw = r; hw = w;
            reset = 0x0;
        } sec_boot_mode[0:0];
    } PERISTAT @ 0x30;
    reg {
        name = "SC_LOCKEN";
        desc = "SC_LOCKEN is a lock register for the key system control registers. SC_LOCKEN (offset 0x0044, total reset 0x0000_0000; PROVEN: Hi3516D V300 data sheet, PDF page 149, section 3.5.3).";
        field {
            name = "scper_lockl";
            desc = "Lock register for the key system control registers. The key registers include SC_CTRL and SC_SYSRES. When 0x1ACC_E551 is written to SC_LOCKEN, the write permission for all registers is enabled; when any other value is written to SC_LOCKEN, the write permission is disabled. Reading this register returns the lock status but not the written value. 0x0000_0000: The write permission is enabled (unlocked). 0x0000_0001: The write permission is disabled (locked).";
            sw = rw; hw = r;
            reset = 0x0;
        } scper_lockl[31:0];
    } SC_LOCKEN @ 0x44;
    reg {
        name = "SYSSTAT";
        desc = "SYSSTAT is a system status register. SYSSTAT (offset 0x008C, total reset 0x0000_0000; PROVEN: Hi3516D V300 data sheet, PDF page 150, section 3.5.3).";
        field {
            name = "reserved";
            desc = "Reserved";
            sw = r; hw = na;
            reset = 0x0;
        } reserved_31_8[31:8];
        field {
            name = "sfc_addr_mode";
            desc = "Boot address mode of the SPI NOR flash (when sfc_device_mode is 0)
- 0: 3-byte mode
- 1: 4-byte mode

Boot mode of the SPI NAND flash (when sfc_device_mode is 1)
- 0: 1-wire boot mode
- 1: 4-wire boot mode";
            sw = r; hw = w;
            reset = 0x0;
        } sfc_addr_mode[7:7];
        field {
            name = "sfc_device_mode";
            desc = "SPI flash component type
- 0: SPI NOR flash
- 1: SPI NAND flash";
            sw = r; hw = w;
            reset = 0x0;
        } sfc_device_mode[6:6];
        field {
            name = "boot_sel";
            desc = "Boot mode
- 00: booting from the SPI NOR flash or SPI

NAND flash
- 01: booting from the eMMC
- 10: fast boot. The SPI NOR flash or SPI

NAND flash is burnt over the serial port.
- 11: fast boot. The eMMC is burnt over the serial port.";
            sw = r; hw = w;
            reset = 0x0;
        } boot_sel[5:4];
        field {
            name = "reserved";
            desc = "Reserved";
            sw = r; hw = w;
            reset = 0x0;
        } reserved_3_0[3:0];
    } SYSSTAT @ 0x8c;
    reg {
        name = "DIE_ID0";
        desc = "DIE_ID0 is a DIE ID0 register. DIE_ID0 (offset 0x0400, total reset 0x0000_0000; PROVEN: Hi3516D V300 data sheet, PDF page 151, section 3.5.3).";
        field {
            name = "die_id0";
            desc = "DIE_ID[31:0]";
            sw = r; hw = w;
            reset = 0x0;
        } die_id0[31:0];
    } DIE_ID0 @ 0x400;
    reg {
        name = "DIE_ID1";
        desc = "DIE_ID1 is a DIE ID1 register. DIE_ID1 (offset 0x0404, total reset 0x0000_0000; PROVEN: Hi3516D V300 data sheet, PDF page 151, section 3.5.3).";
        field {
            name = "die_id1";
            desc = "DIE_ID[63:32]";
            sw = r; hw = w;
            reset = 0x0;
        } die_id1[31:0];
    } DIE_ID1 @ 0x404;
    reg {
        name = "DIE_ID2";
        desc = "DIE_ID2 is a DIE ID2 register. DIE_ID2 (offset 0x0408, total reset 0x0000_0000; PROVEN: Hi3516D V300 data sheet, PDF page 151, section 3.5.3).";
        field {
            name = "die_id2";
            desc = "DIE_ID[95:64]";
            sw = r; hw = w;
            reset = 0x0;
        } die_id2[31:0];
    } DIE_ID2 @ 0x408;
    reg {
        name = "DIE_ID3";
        desc = "DIE_ID3 is a DIE ID3 register. DIE_ID3 (offset 0x040C, total reset 0x0000_0000; PROVEN: Hi3516D V300 data sheet, PDF page 151, section 3.5.3).";
        field {
            name = "die_id3";
            desc = "DIE_ID[127:96]";
            sw = r; hw = w;
            reset = 0x0;
        } die_id3[31:0];
    } DIE_ID3 @ 0x40c;
    reg {
        name = "DIE_ID4";
        desc = "DIE_ID4 is a DIE ID4 register. DIE_ID4 (offset 0x0410, total reset 0x0000_0000; PROVEN: Hi3516D V300 data sheet, PDF page 152, section 3.5.3).";
        field {
            name = "die_id4";
            desc = "DIE_ID[159:128]";
            sw = r; hw = w;
            reset = 0x0;
        } die_id4[31:0];
    } DIE_ID4 @ 0x410;
    reg {
        name = "DIE_ID5";
        desc = "DIE_ID5 is a DIE ID5 register. DIE_ID5 (offset 0x0414, total reset 0x0000_0000; PROVEN: Hi3516D V300 data sheet, PDF page 152, section 3.5.3).";
        field {
            name = "die_id5";
            desc = "DIE_ID[191:160]";
            sw = r; hw = w;
            reset = 0x0;
        } die_id5[31:0];
    } DIE_ID5 @ 0x414;
    reg {
        name = "CHIP_ID";
        desc = "CHIP_ID is a chip ID register. CHIP_ID (offset 0x0EE0, total reset 0x3516D300; PROVEN: Hi3516D V300 data sheet, PDF page 152, section 3.5.3).";
        field {
            name = "chip_id";
            desc = "CHIP_ID[31:0]";
            sw = r; hw = w;
            reset = 0x3516d300;
        } chip_id[31:0];
    } CHIP_ID @ 0xee0;
    reg {
        name = "VENDOR_ID";
        desc = "VENDOR_ID is a vendor ID register. VENDOR_ID (offset 0x0EEC, total reset 0x0000_0035; PROVEN: Hi3516D V300 data sheet, PDF page 152, section 3.5.3).";
        field {
            name = "vendor_id";
            desc = "Vendor ID. The fixed value is 0x35.";
            sw = r; hw = w;
            reset = 0x35;
        } vendor_id[31:0];
    } VENDOR_ID @ 0xeec;
};

`endif
