`ifndef EHI3516DV300_MIPI_TX_PHY_RDL
`define EHI3516DV300_MIPI_TX_PHY_RDL
regfile eHI3516DV300_MIPI_TX_PHY {
    name = "MIPI TX PHY (behind the MIPI TX interface)";
    desc = "MIPI TX PHY (behind the MIPI TX interface). 49 registers extracted programmatically from the Hi3516D V300 Professional Smart IP Camera SoC data sheet (Issue 01, 2019-09-12); chapter 9.4.8, table 9-13. Field names, bit ranges, access types and reset values are taken from the register tables; reset values are the data sheet total reset values split onto the fields (per-field values where the table has them). Label: PROVEN. Hardware not verified here (no board).";
    default regwidth = 8;
    default accesswidth = 8;
    reg {
        name = "LP_RX_EN";
        desc = "LP_RX_EN is the LP RX enable register. LP_RX_EN (offset 0x0F, total reset 0x01; PROVEN: Hi3516D V300 data sheet, PDF page 730, section 9.4.8).";
        field {
            name = "reserved";
            desc = "Reserved";
            sw = r; hw = na;
            reset = 0x0;
        } reserved_7_1[7:1];
        field {
            name = "lane0_rx_en";
            desc = "Lane 0 RX enable
- 0: disabled
- 1: enabled";
            sw = rw; hw = r;
            reset = 0x1;
        } lane0_rx_en[0:0];
    } LP_RX_EN @ 0xf;
    reg {
        name = "TLPX_CLK";
        desc = "TLPX_CLK is the Tlpx configuration register for a clock lane. TLPX_CLK (offset 0x10, total reset 0x01; PROVEN: Hi3516D V300 data sheet, PDF page 730, section 9.4.8).";
        field {
            name = "Tlpx-clk";
            desc = "Tlpx configuration for a clock lane, in hsclk cycles";
            sw = rw; hw = r;
            reset = 0x1;
        } Tlpx_clk[7:0];
    } TLPX_CLK @ 0x10;
    reg {
        name = "TCK_PREPARE";
        desc = "TCK_PREPARE is the Tck-prepare configuration register for a clock lane. TCK_PREPARE (offset 0x11, total reset 0x00; PROVEN: Hi3516D V300 data sheet, PDF page 730, section 9.4.8).";
        field {
            name = "Tck-prepare";
            desc = "Tck-prepare configuration for a clock lane, in hsclk cycles";
            sw = rw; hw = r;
            reset = 0x0;
        } Tck_prepare[7:0];
    } TCK_PREPARE @ 0x11;
    reg {
        name = "TCLK-ZERO";
        desc = "TCLK-ZERO is the Tclk-zero configuration register for a clock lane. TCLK-ZERO (offset 0x12, total reset 0x00; PROVEN: Hi3516D V300 data sheet, PDF page 730, section 9.4.8).";
        field {
            name = "Tclk-zero";
            desc = "Tclk-zero configuration for a clock lane, in hsclk cycles";
            sw = rw; hw = r;
            reset = 0x0;
        } Tclk_zero[7:0];
    } TCLK_ZERO @ 0x12;
    reg {
        name = "TCLK-TRAIL";
        desc = "TCLK-TRAIL is the Tclk-trail configuration register for a clock lane. TCLK-TRAIL (offset 0x13, total reset 0x0A; PROVEN: Hi3516D V300 data sheet, PDF page 731, section 9.4.8).";
        field {
            name = "Tclk-trail";
            desc = "Tclk-trail configuration for a clock lane, in hsclk cycles";
            sw = rw; hw = r;
            reset = 0xa;
        } Tclk_trail[7:0];
    } TCLK_TRAIL @ 0x13;
    reg {
        name = "TWAKEUP-CLK";
        desc = "TWAKEUP-CLK is the Twakeup configuration register for a clock lane. TWAKEUP-CLK (offset 0x14, total reset 0x20; PROVEN: Hi3516D V300 data sheet, PDF page 731, section 9.4.8).";
        field {
            name = "Twakeup-clk";
            desc = "Upper eight bits of Twakeup of a clock lane, {0x26[7:0], 3'h0}. The unit is cfg_clk cycles.";
            sw = rw; hw = r;
            reset = 0x20;
        } Twakeup_clk[7:0];
    } TWAKEUP_CLK @ 0x14;
    reg {
        name = "PRE_DELAY_HSCLK";
        desc = "PRE_DELAY_HSCLK is the HS clock valid delay configuration register. PRE_DELAY_HSCLK (offset 0x17, total reset 0x00; PROVEN: Hi3516D V300 data sheet, PDF page 731, section 9.4.8).";
        field {
            name = "pre_delay_hsclk";
            desc = "Delay duration from txrequesthsclk validity to the time when a clock lane enters the HS mode, in hsclk cycles";
            sw = rw; hw = r;
            reset = 0x0;
        } pre_delay_hsclk[7:0];
    } PRE_DELAY_HSCLK @ 0x17;
    reg {
        name = "POST_DELAY_HSCLK";
        desc = "POST_DELAY_HSCLK is the HS clock invalid delay configuration register. POST_DELAY_HSCLK (offset 0x18, total reset 0x20; PROVEN: Hi3516D V300 data sheet, PDF page 731, section 9.4.8).";
        field {
            name = "post_delay_hsclk";
            desc = "Delay duration from txrequesthsclk invalidity to the time when a clock lane exits the HS mode, in hsclk cycles";
            sw = rw; hw = r;
            reset = 0x20;
        } post_delay_hsclk[7:0];
    } POST_DELAY_HSCLK @ 0x18;
    reg {
        name = "TLPX_D0";
        desc = "TLPX_D0 is the Tlpx configuration register for data lane 0. TLPX_D0 (offset 0x20, total reset 0x01; PROVEN: Hi3516D V300 data sheet, PDF page 732, section 9.4.8).";
        field {
            name = "Tlpx-d0";
            desc = "Tlpx configuration for data lane 0, in hsclk cycles";
            sw = rw; hw = r;
            reset = 0x1;
        } Tlpx_d0[7:0];
    } TLPX_D0 @ 0x20;
    reg {
        name = "THS_PREPARE-D0";
        desc = "THS_PREPARE-D0 is the Ths-prepare configuration register for data lane 0. THS_PREPARE-D0 (offset 0x21, total reset 0x00; PROVEN: Hi3516D V300 data sheet, PDF page 732, section 9.4.8).";
        field {
            name = "Ths-prepare-d0";
            desc = "Tck-prepare configuration for data lane 0, in hsclk cycles";
            sw = rw; hw = r;
            reset = 0x0;
        } Ths_prepare_d0[7:0];
    } THS_PREPARE_D0 @ 0x21;
    reg {
        name = "THS-ZERO-D0";
        desc = "THS-ZERO-D0 is the Ths-zero configuration register for data lane 0. THS-ZERO-D0 (offset 0x22, total reset 0x00; PROVEN: Hi3516D V300 data sheet, PDF page 732, section 9.4.8).";
        field {
            name = "Ths-zero-d0";
            desc = "Ths-zero configuration for data lane 0, in hsclk cycles";
            sw = rw; hw = r;
            reset = 0x0;
        } Ths_zero_d0[7:0];
    } THS_ZERO_D0 @ 0x22;
    reg {
        name = "THS-TRAIL-D0";
        desc = "THS-TRAIL-D0 is the Ths-trail configuration register for data lane 0. THS-TRAIL-D0 (offset 0x23, total reset 0x08; PROVEN: Hi3516D V300 data sheet, PDF page 732, section 9.4.8).";
        field {
            name = "Ths-trail-d0";
            desc = "Ths-trail configuration for data lane 0, in hsclk cycles";
            sw = rw; hw = r;
            reset = 0x8;
        } Ths_trail_d0[7:0];
    } THS_TRAIL_D0 @ 0x23;
    reg {
        name = "TTA-GO-D0";
        desc = "TTA-GO-D0 is the Tta-go configuration register for data lane 0. TTA-GO-D0 (offset 0x24, total reset 0x03; PROVEN: Hi3516D V300 data sheet, PDF page 732, section 9.4.8).";
        field {
            name = "Tta-go-d0";
            desc = "Tta-go configuration for data lane 0, in txclkesc cycles";
            sw = rw; hw = r;
            reset = 0x3;
        } Tta_go_d0[7:0];
    } TTA_GO_D0 @ 0x24;
    reg {
        name = "TTA-GET-D0";
        desc = "TTA-GET-D0 is the Tta-get configuration register for data lane 0. TTA-GET-D0 (offset 0x25, total reset 0x04; PROVEN: Hi3516D V300 data sheet, PDF page 733, section 9.4.8).";
        field {
            name = "Tta-get-d0";
            desc = "Tta-get configuration for data lane 0, in txclkesc cycles";
            sw = rw; hw = r;
            reset = 0x4;
        } Tta_get_d0[7:0];
    } TTA_GET_D0 @ 0x25;
    reg {
        name = "TWAKEUP-D0";
        desc = "TWAKEUP-D0 is the Twakeup configuration register for data lane 0. TWAKEUP-D0 (offset 0x26, total reset 0x20; PROVEN: Hi3516D V300 data sheet, PDF page 733, section 9.4.8).";
        field {
            name = "Twakeup-d0";
            desc = "Upper eight bits of Twakeup of data lane 0, {0x38[7:0],3'h0}. The unit is cfg_clk cycles.";
            sw = rw; hw = r;
            reset = 0x20;
        } Twakeup_d0[7:0];
    } TWAKEUP_D0 @ 0x26;
    reg {
        name = "PRE_DELAY_D0HS";
        desc = "PRE_DELAY_D0HS is the HS valid delay configuration register for data lane 0. PRE_DELAY_D0HS (offset 0x28, total reset 0x10; PROVEN: Hi3516D V300 data sheet, PDF page 733, section 9.4.8).";
        field {
            name = "pre_delay_d0hs";
            desc = "Delay duration from the txrequesths_lane0 validity to the time when data lane 0 enters the HS mode, in hsclk cycles";
            sw = rw; hw = r;
            reset = 0x10;
        } pre_delay_d0hs[7:0];
    } PRE_DELAY_D0HS @ 0x28;
    reg {
        name = "POST_DELAY_D0HS";
        desc = "POST_DELAY_D0HS is the HS invalid delay configuration register for data lane 0. POST_DELAY_D0HS (offset 0x29, total reset 0x00; PROVEN: Hi3516D V300 data sheet, PDF page 733, section 9.4.8).";
        field {
            name = "post_delay_d0hs";
            desc = "Delay duration from the txrequesths_lane0";
            sw = rw; hw = r;
            reset = 0x0;
        } post_delay_d0hs[7:0];
    } POST_DELAY_D0HS @ 0x29;
    reg {
        name = "TLPX_D1";
        desc = "TLPX_D1 is the Tlpx configuration register for data lane 1. TLPX_D1 (offset 0x30, total reset 0x01; PROVEN: Hi3516D V300 data sheet, PDF page 734, section 9.4.8).";
        field {
            name = "Tlpx-d1";
            desc = "Tlpx configuration for data lane 1, in hsclk cycles";
            sw = rw; hw = r;
            reset = 0x1;
        } Tlpx_d1[7:0];
    } TLPX_D1 @ 0x30;
    reg {
        name = "THS_PREPARE-D1";
        desc = "THS_PREPARE-D1 is the Ths-prepare configuration register for data lane 1. THS_PREPARE-D1 (offset 0x31, total reset 0x00; PROVEN: Hi3516D V300 data sheet, PDF page 734, section 9.4.8).";
        field {
            name = "Ths-prepare-d1";
            desc = "Tck-prepare configuration for data lane 1, in hsclk cycles";
            sw = rw; hw = r;
            reset = 0x0;
        } Ths_prepare_d1[7:0];
    } THS_PREPARE_D1 @ 0x31;
    reg {
        name = "THS-ZERO-D1";
        desc = "THS-ZERO-D1 is the Ths-zero configuration register for data lane 1. THS-ZERO-D1 (offset 0x32, total reset 0x00; PROVEN: Hi3516D V300 data sheet, PDF page 734, section 9.4.8).";
        field {
            name = "Ths-zero-d1";
            desc = "Ths-zero configuration for data lane 1, in hsclk cycles";
            sw = rw; hw = r;
            reset = 0x0;
        } Ths_zero_d1[7:0];
    } THS_ZERO_D1 @ 0x32;
    reg {
        name = "THS-TRAIL-D1";
        desc = "THS-TRAIL-D1 is the Ths-trail configuration register for data lane 1. THS-TRAIL-D1 (offset 0x33, total reset 0x08; PROVEN: Hi3516D V300 data sheet, PDF page 734, section 9.4.8).";
        field {
            name = "Ths-trail-d1";
            desc = "Ths-trail configuration for data lane 1, in hsclk cycles";
            sw = rw; hw = r;
            reset = 0x8;
        } Ths_trail_d1[7:0];
    } THS_TRAIL_D1 @ 0x33;
    reg {
        name = "TTA-GO-D1";
        desc = "TTA-GO-D1 is the Tta-go configuration register for data lane 1. TTA-GO-D1 (offset 0x34, total reset 0x03; PROVEN: Hi3516D V300 data sheet, PDF page 735, section 9.4.8).";
        field {
            name = "Tta-go-d1";
            desc = "Tta-go configuration for data lane 1, in txclkesc cycles";
            sw = rw; hw = r;
            reset = 0x3;
        } Tta_go_d1[7:0];
    } TTA_GO_D1 @ 0x34;
    reg {
        name = "TTA-GET-D1";
        desc = "TTA-GET-D1 is the Tta-get configuration register for data lane 1. TTA-GET-D1 (offset 0x35, total reset 0x04; PROVEN: Hi3516D V300 data sheet, PDF page 735, section 9.4.8).";
        field {
            name = "Tta-get-d1";
            desc = "Tta-get configuration for data lane 1, in txclkesc cycles";
            sw = rw; hw = r;
            reset = 0x4;
        } Tta_get_d1[7:0];
    } TTA_GET_D1 @ 0x35;
    reg {
        name = "TWAKEUP-D1";
        desc = "TWAKEUP-D1 is the Twakeup configuration register for data lane 1. TWAKEUP-D1 (offset 0x36, total reset 0x20; PROVEN: Hi3516D V300 data sheet, PDF page 735, section 9.4.8).";
        field {
            name = "Twakeup-d1";
            desc = "Upper eight bits of Twakeup of data lane 1, {0x48[7:0],3'h0}. The unit is cfg_clk cycles.";
            sw = rw; hw = r;
            reset = 0x20;
        } Twakeup_d1[7:0];
    } TWAKEUP_D1 @ 0x36;
    reg {
        name = "PRE_DELAY_D1HS";
        desc = "PRE_DELAY_D1HS is the HS valid delay configuration register for data lane 1. PRE_DELAY_D1HS (offset 0x38, total reset 0x10; PROVEN: Hi3516D V300 data sheet, PDF page 735, section 9.4.8).";
        field {
            name = "pre_delay_d1hs";
            desc = "Delay duration from the txrequesths_lane1 validity to the time when data lane 1 enters the HS mode, in hsclk cycles";
            sw = rw; hw = r;
            reset = 0x10;
        } pre_delay_d1hs[7:0];
    } PRE_DELAY_D1HS @ 0x38;
    reg {
        name = "POST_DELAY_D1HS";
        desc = "POST_DELAY_D1HS is the HS invalid delay configuration register for data lane 1. POST_DELAY_D1HS (offset 0x39, total reset 0x00; PROVEN: Hi3516D V300 data sheet, PDF page 736, section 9.4.8).";
        field {
            name = "post_delay_d1hs";
            desc = "Delay duration from the txrequesths_lane1 invalidity to the time when data lane 1 exits the HS mode, in hsclk cycles";
            sw = rw; hw = r;
            reset = 0x0;
        } post_delay_d1hs[7:0];
    } POST_DELAY_D1HS @ 0x39;
    reg {
        name = "TLPX_D2";
        desc = "TLPX_D2 is the Tlpx configuration register for data lane 2. TLPX_D2 (offset 0x40, total reset 0x01; PROVEN: Hi3516D V300 data sheet, PDF page 736, section 9.4.8).";
        field {
            name = "Tlpx-d2";
            desc = "Tlpx configuration for data lane 2, in hsclk cycles";
            sw = rw; hw = r;
            reset = 0x1;
        } Tlpx_d2[7:0];
    } TLPX_D2 @ 0x40;
    reg {
        name = "THS_PREPARE-D2";
        desc = "THS_PREPARE-D2 is the Ths-prepare configuration register for data lane 2. THS_PREPARE-D2 (offset 0x41, total reset 0x00; PROVEN: Hi3516D V300 data sheet, PDF page 736, section 9.4.8).";
        field {
            name = "Ths-prepare-d2";
            desc = "Tck-prepare configuration for data lane 2, in hsclk cycles";
            sw = rw; hw = r;
            reset = 0x0;
        } Ths_prepare_d2[7:0];
    } THS_PREPARE_D2 @ 0x41;
    reg {
        name = "THS-ZERO-D2";
        desc = "THS-ZERO-D2 is the Ths-zero configuration register for data lane 2. THS-ZERO-D2 (offset 0x42, total reset 0x00; PROVEN: Hi3516D V300 data sheet, PDF page 736, section 9.4.8).";
        field {
            name = "Ths-zero-d2";
            desc = "Ths-zero configuration for data lane 2, in hsclk cycles";
            sw = rw; hw = r;
            reset = 0x0;
        } Ths_zero_d2[7:0];
    } THS_ZERO_D2 @ 0x42;
    reg {
        name = "THS-TRAIL-D2";
        desc = "THS-TRAIL-D2 is the Ths-trail configuration register for data lane 2. THS-TRAIL-D2 (offset 0x43, total reset 0x08; PROVEN: Hi3516D V300 data sheet, PDF page 736, section 9.4.8).";
        field {
            name = "Ths-trail-d2";
            desc = "Ths-trail configuration for data lane 2, in hsclk cycles";
            sw = rw; hw = r;
            reset = 0x8;
        } Ths_trail_d2[7:0];
    } THS_TRAIL_D2 @ 0x43;
    reg {
        name = "TTA-GO-D2";
        desc = "TTA-GO-D2 is the Tta-go configuration register for data lane 2. TTA-GO-D2 (offset 0x44, total reset 0x03; PROVEN: Hi3516D V300 data sheet, PDF page 737, section 9.4.8).";
        field {
            name = "Tta-go-d2";
            desc = "Tta-go configuration for data lane 2, in txclkesc cycles";
            sw = rw; hw = r;
            reset = 0x3;
        } Tta_go_d2[7:0];
    } TTA_GO_D2 @ 0x44;
    reg {
        name = "TTA-GET-D2";
        desc = "TTA-GET-D2 is the Tta-get configuration register for data lane 2. TTA-GET-D2 (offset 0x45, total reset 0x04; PROVEN: Hi3516D V300 data sheet, PDF page 737, section 9.4.8).";
        field {
            name = "Tta-get-d2";
            desc = "Tta-get configuration for data lane 2, in txclkesc cycles";
            sw = rw; hw = r;
            reset = 0x4;
        } Tta_get_d2[7:0];
    } TTA_GET_D2 @ 0x45;
    reg {
        name = "TWAKEUP-D2";
        desc = "TWAKEUP-D2 is the Twakeup configuration register for data lane 2. TWAKEUP-D2 (offset 0x46, total reset 0x20; PROVEN: Hi3516D V300 data sheet, PDF page 737, section 9.4.8).";
        field {
            name = "Twakeup-d2";
            desc = "Upper eight bits of Twakeup of data lane 2, {0x58[7:0],3'h0}. The unit is cfg_clk cycles.";
            sw = rw; hw = r;
            reset = 0x20;
        } Twakeup_d2[7:0];
    } TWAKEUP_D2 @ 0x46;
    reg {
        name = "PRE_DELAY_D2HS";
        desc = "PRE_DELAY_D2HS is the HS valid delay configuration register for data lane 2. PRE_DELAY_D2HS (offset 0x48, total reset 0x10; PROVEN: Hi3516D V300 data sheet, PDF page 737, section 9.4.8).";
        field {
            name = "pre_delay_d2hs";
            desc = "Delay duration from the txrequesths_lane2 validity to the time when data lane 2 enters the";
            sw = rw; hw = r;
            reset = 0x10;
        } pre_delay_d2hs[7:0];
    } PRE_DELAY_D2HS @ 0x48;
    reg {
        name = "POST_DELAY_D2HS";
        desc = "POST_DELAY_D2HS is the HS invalid delay configuration register for data lane 2. POST_DELAY_D2HS (offset 0x49, total reset 0x00; PROVEN: Hi3516D V300 data sheet, PDF page 738, section 9.4.8).";
        field {
            name = "post_delay_d2hs";
            desc = "Delay duration from the txrequesths_lane2 invalidity to the time when data lane 2 exits the HS mode, in hsclk cycles";
            sw = rw; hw = r;
            reset = 0x0;
        } post_delay_d2hs[7:0];
    } POST_DELAY_D2HS @ 0x49;
    reg {
        name = "TLPX_D3";
        desc = "TLPX_D3 is the Tlpx configuration register for data lane 3. TLPX_D3 (offset 0x50, total reset 0x01; PROVEN: Hi3516D V300 data sheet, PDF page 738, section 9.4.8).";
        field {
            name = "Tlpx-d3";
            desc = "Tlpx configuration for data lane 3, in hsclk cycles";
            sw = rw; hw = r;
            reset = 0x1;
        } Tlpx_d3[7:0];
    } TLPX_D3 @ 0x50;
    reg {
        name = "THS_PREPARE-D3";
        desc = "THS_PREPARE-D3 is the Ths-prepare configuration register for data lane 3. THS_PREPARE-D3 (offset 0x51, total reset 0x00; PROVEN: Hi3516D V300 data sheet, PDF page 738, section 9.4.8).";
        field {
            name = "Ths-prepare-d3";
            desc = "Tck-prepare configuration for data lane 3, in hsclk cycles";
            sw = rw; hw = r;
            reset = 0x0;
        } Ths_prepare_d3[7:0];
    } THS_PREPARE_D3 @ 0x51;
    reg {
        name = "THS-ZERO-D3";
        desc = "THS-ZERO-D3 is the Ths-zero configuration register for data lane 3. THS-ZERO-D3 (offset 0x52, total reset 0x00; PROVEN: Hi3516D V300 data sheet, PDF page 738, section 9.4.8).";
        field {
            name = "Ths-zero-d3";
            desc = "Ths-zero configuration for data lane 3, in hsclk cycles";
            sw = rw; hw = r;
            reset = 0x0;
        } Ths_zero_d3[7:0];
    } THS_ZERO_D3 @ 0x52;
    reg {
        name = "THS-TRAIL-D3";
        desc = "THS-TRAIL-D3 is the Ths-trail configuration register for data lane 3. THS-TRAIL-D3 (offset 0x53, total reset 0x08; PROVEN: Hi3516D V300 data sheet, PDF page 739, section 9.4.8).";
        field {
            name = "Ths-trail-d3";
            desc = "Ths-trail configuration for data lane 3, in hsclk cycles";
            sw = rw; hw = r;
            reset = 0x8;
        } Ths_trail_d3[7:0];
    } THS_TRAIL_D3 @ 0x53;
    reg {
        name = "TTA-GO-D3";
        desc = "TTA-GO-D3 is the Tta-go configuration register for data lane 3. TTA-GO-D3 (offset 0x54, total reset 0x03; PROVEN: Hi3516D V300 data sheet, PDF page 739, section 9.4.8).";
        field {
            name = "Tta-go-d3";
            desc = "Tta-go configuration for data lane 3, in txclkesc cycles";
            sw = rw; hw = r;
            reset = 0x3;
        } Tta_go_d3[7:0];
    } TTA_GO_D3 @ 0x54;
    reg {
        name = "TTA-GET-D3";
        desc = "TTA-GET-D3 is the Tta-get configuration register for data lane 3. TTA-GET-D3 (offset 0x55, total reset 0x04; PROVEN: Hi3516D V300 data sheet, PDF page 739, section 9.4.8).";
        field {
            name = "Tta-get-d3";
            desc = "Tta-get configuration for data lane 3, in txclkesc cycles";
            sw = rw; hw = r;
            reset = 0x4;
        } Tta_get_d3[7:0];
    } TTA_GET_D3 @ 0x55;
    reg {
        name = "TWAKEUP-D3";
        desc = "TWAKEUP-D3 is the Twakeup configuration register for data lane 3. TWAKEUP-D3 (offset 0x56, total reset 0x20; PROVEN: Hi3516D V300 data sheet, PDF page 739, section 9.4.8).";
        field {
            name = "Twakeup-d3";
            desc = "Upper eight bits of Twakeup of data lane 3, {0x68[7:0],3'h0}. The unit is cfg_clk cycles.";
            sw = rw; hw = r;
            reset = 0x20;
        } Twakeup_d3[7:0];
    } TWAKEUP_D3 @ 0x56;
    reg {
        name = "PRE_DELAY_D3HS";
        desc = "PRE_DELAY_D3HS is the HS valid delay configuration register for data lane 3. PRE_DELAY_D3HS (offset 0x58, total reset 0x10; PROVEN: Hi3516D V300 data sheet, PDF page 739, section 9.4.8).";
        field {
            name = "pre_delay_d3hs";
            desc = "Delay duration from the txrequesths_lane3 validity to the time when data lane 3 enters the HS mode, in hsclk cycles";
            sw = rw; hw = r;
            reset = 0x10;
        } pre_delay_d3hs[7:0];
    } PRE_DELAY_D3HS @ 0x58;
    reg {
        name = "POST_DELAY_D3HS";
        desc = "POST_DELAY_D3HS is the HS invalid delay configuration register for data lane 3. POST_DELAY_D3HS (offset 0x59, total reset 0x00; PROVEN: Hi3516D V300 data sheet, PDF page 740, section 9.4.8).";
        field {
            name = "post_delay_d3hs";
            desc = "Delay duration from the txrequesths_lane3 invalidity to the time when data lane 3 exits the HS mode, in hsclk cycles";
            sw = rw; hw = r;
            reset = 0x0;
        } post_delay_d3hs[7:0];
    } POST_DELAY_D3HS @ 0x59;
    reg {
        name = "PLL_SET0";
        desc = "PLL_SET0 is the PLL parameter 0 configuration register. PLL_SET0 (offset 0x60, total reset 0x0E; PROVEN: Hi3516D V300 data sheet, PDF page 740, section 9.4.8).";
        field {
            name = "reserved";
            desc = "Reserved";
            sw = r; hw = na;
            reset = 0x0;
        } reserved_7_4[7:4];
        field {
            name = "RG_HSTX_CKG_SEL";
            desc = "Frequency division multiple 0xx: The frequency is divided by 1 when the data rate ranges from 750 Mbit/s to 1000 Mbit/s.
- 100: The frequency is divided by 2 when the data rate ranges from 375 Mbit/s to 750

Mbit/s.
- 101: The frequency is divided by 4 when the data rate ranges from 188 Mbit/s to 375

Mbit/s.
- 110: The frequency is divided by 8 when the data rate ranges from 94 Mbit/s to 188 Mbit/s.
- 111: The frequency is divided by 16 when the data rate ranges from 47 Mbit/s to 94 Mbit/s.";
            sw = rw; hw = r;
            reset = 0x7;
        } RG_HSTX_CKG_SEL[3:1];
        field {
            name = "reserved";
            desc = "Reserved";
            sw = r; hw = na;
            reset = 0x0;
        } reserved_0_0[0:0];
    } PLL_SET0 @ 0x60;
    reg {
        name = "PLL_SET1";
        desc = "PLL_SET1 is the PLL parameter 1 configuration register. PLL_SET1 (offset 0x64, total reset 0x00; PROVEN: Hi3516D V300 data sheet, PDF page 741, section 9.4.8).";
        field {
            name = "RG_PLL_FBD_S";
            desc = "Feedback division configuration.It cannot be configured to be 0";
            sw = rw; hw = r;
            reset = 0x0;
        } RG_PLL_FBD_S[7:4];
        field {
            name = "reserved";
            desc = "Reserved";
            sw = r; hw = na;
            reset = 0x0;
        } reserved_3_3[3:3];
        field {
            name = "RG_PLL_EN_O";
            desc = "Value of RG_PLL_EN_O";
            sw = rw; hw = r;
            reset = 0x0;
        } RG_PLL_EN_O[2:2];
        field {
            name = "RG_PLL_BW";
            desc = "Value of RG_PLL_BW";
            sw = rw; hw = r;
            reset = 0x0;
        } RG_PLL_BW[1:1];
    } PLL_SET1 @ 0x64;
    reg {
        name = "PLL_SET2";
        desc = "PLL_SET2 is the PLL parameter 2 configuration register. PLL_SET2 (offset 0x65, total reset 0x22; PROVEN: Hi3516D V300 data sheet, PDF page 741, section 9.4.8).";
        field {
            name = "reserved";
            desc = "Reserved";
            sw = r; hw = na;
            reset = 0x0;
        } reserved_7_7[7:7];
        field {
            name = "RG_PLL_FBD_P";
            desc = "Value of RG_PLL_FBD_P";
            sw = rw; hw = r;
            reset = 0x22;
        } RG_PLL_FBD_P[6:0];
    } PLL_SET2 @ 0x65;
    reg {
        name = "PLL_SET4";
        desc = "PLL_SET4 is the PLL parameter 4 configuration register. PLL_SET4 (offset 0x66, total reset 0x01; PROVEN: Hi3516D V300 data sheet, PDF page 741, section 9.4.8).";
        field {
            name = "reserved";
            desc = "Reserved";
            sw = r; hw = na;
            reset = 0x0;
        } reserved_7_1[7:1];
        field {
            name = "RG_PLL_FBD_DIV1F";
            desc = "It must be configured as 0.";
            sw = rw; hw = r;
            reset = 0x1;
        } RG_PLL_FBD_DIV1F[0:0];
    } PLL_SET4 @ 0x66;
    reg {
        name = "PLL_SET5";
        desc = "PLL_SET5 is the PLL parameter 5 configuration register. PLL_SET5 (offset 0x67, total reset 0x01; PROVEN: Hi3516D V300 data sheet, PDF page 741, section 9.4.8).";
        field {
            name = "reserved";
            desc = "Reserved";
            sw = r; hw = w;
            reset = 0x0;
        } reserved_7_7[7:7];
        field {
            name = "RG_PLL_PRE_P";
            desc = "Value of RG_PLL_PRE_P Contents";
            sw = rw; hw = r;
            reset = 0x1;
        } RG_PLL_PRE_P[6:0];
    } PLL_SET5 @ 0x67;
};

`endif
