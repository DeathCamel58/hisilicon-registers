`ifndef HI3536D_DDRC_PHY_RDL
`define HI3536D_DDRC_PHY_RDL
regfile eHI3536D_DDRC_PHY {
    name = "DDR PHY registers, Hi3536D V100";
    desc = "DDR PHY registers of the Hi3536D V100 at base 0x1211C000. 8 registers extracted programmatically from the Hi3536D V100 data sheet (Issue 00B04, 2017-12-13, Table 4-8), register descriptions and field tables; reset values are the data sheet total reset values split onto the fields. Source: dl/research-hi3536 ReleaseDoc (unofficial copy of the HiSilicon SDK documentation; facts only). Field names, bit ranges, access types and reset values are exact; the free-text descriptions are attributed to fields from the PDF text layout (title sentence above the bit row, enumerations below) and can be shifted by one field where a sentence wraps: check the data sheet page when a description matters. Hardware not yet verified (no Hi3536D board on the bench).";
    reg {
        name = "DRAMTIMER0";
        desc = "DRAMTIMER0 (offset 0x30, total reset 0x00000000; PROVEN: Hi3536D V100 data sheet).";
        field {
            name = "t_rc";
            desc = "Activated to Activated on Same Bank Command Delay";
            sw = rw; hw = r;
            reset = 0x0;
        } t_rc[31:26];
        field {
            name = "t_rrd";
            desc = "Activated to Activated on Different Bank Command Delay";
            sw = rw; hw = r;
            reset = 0x0;
        } t_rrd[25:22];
        field {
            name = "t_ras";
            desc = "Activated to Precharge Command Delay";
            sw = rw; hw = r;
            reset = 0x0;
        } t_ras[21:16];
        field {
            name = "t_rcd";
            desc = "Activated to Read/Write Delay";
            sw = rw; hw = r;
            reset = 0x0;
        } t_rcd[15:12];
        field {
            name = "t_rp";
            desc = "Precharge Command Period";
            sw = rw; hw = r;
            reset = 0x0;
        } t_rp[11:8];
        field {
            name = "t_wtr";
            desc = "The unit is two clock cycles. Write to Read Command Delay";
            sw = rw; hw = r;
            reset = 0x0;
        } t_wtr[7:4];
        field {
            name = "t_rtp";
            desc = "Read to Precharge Command Delay";
            sw = rw; hw = r;
            reset = 0x0;
        } t_rtp[3:0];
    } DRAMTIMER0 @ 0x30;
    reg {
        name = "DRAMTIMER1";
        desc = "DRAMTIMER1 (offset 0x34, total reset 0x00000000; PROVEN: Hi3536D V100 data sheet).";
        field {
            name = "reserved_31_30";
            desc = "Reserved";
            sw = r; hw = w;
            reset = 0x0;
        } reserved_31_30[31:30];
        field {
            name = "t_rtw";
            desc = "Read to Write Command Delay";
            sw = rw; hw = r;
            reset = 0x0;
        } t_rtw[29:25];
        field {
            name = "t_rfc";
            desc = "Refresh to Refresh Command Delay";
            sw = rw; hw = r;
            reset = 0x0;
        } t_rfc[24:16];
        field {
            name = "reserved_15_15";
            desc = "Reserved";
            sw = r; hw = w;
            reset = 0x0;
        } reserved_15_15[15:15];
        field {
            name = "t_faw";
            desc = "Four Bank Activated Period";
            sw = rw; hw = r;
            reset = 0x0;
        } t_faw[14:9];
        field {
            name = "t_mod";
            desc = "Load Mode Register to Non Load Mode Register Command";
            sw = rw; hw = r;
            reset = 0x0;
        } t_mod[8:4];
        field {
            name = "t_mrd";
            desc = "Delay. This field is used as max(t_mod,t_mrd) in DDR3. Load Mode Register to Load Mode Register Command Delay";
            sw = rw; hw = r;
            reset = 0x0;
        } t_mrd[3:0];
    } DRAMTIMER1 @ 0x34;
    reg {
        name = "DRAMTIMER2";
        desc = "DRAMTIMER2 (offset 0x38, total reset 0x00000000; PROVEN: Hi3536D V100 data sheet).";
        field {
            name = "t_ccd";
            desc = "Read to Read and Write to Write Command Delay";
            sw = rw; hw = r;
            reset = 0x0;
        } t_ccd[31:31];
        field {
            name = "reserved_30_30";
            desc = "Reserved";
            sw = r; hw = w;
            reset = 0x0;
        } reserved_30_30[30:30];
        field {
            name = "t_dllk";
            desc = "DLL Lock time";
            sw = rw; hw = r;
            reset = 0x0;
        } t_dllk[29:20];
        field {
            name = "t_cke";
            desc = "CKE minimum pulse width";
            sw = rw; hw = r;
            reset = 0x0;
        } t_cke[19:16];
        field {
            name = "reserved_15_15";
            desc = "Reserved";
            sw = r; hw = w;
            reset = 0x0;
        } reserved_15_15[15:15];
        field {
            name = "t_xp";
            desc = "Power Down Exit Delay";
            sw = rw; hw = r;
            reset = 0x0;
        } t_xp[14:10];
        field {
            name = "t_xs";
            desc = "Self Refresh Exit Delay";
            sw = rw; hw = r;
            reset = 0x0;
        } t_xs[9:0];
    } DRAMTIMER2 @ 0x38;
    reg {
        name = "DRAMTIMER3";
        desc = "DRAMTIMER3 (offset 0x3C, total reset 0x00100200; PROVEN: Hi3536D V100 data sheet).";
        field {
            name = "t_wr";
            desc = "Write recovery cycle";
            sw = rw; hw = r;
            reset = 0x0;
        } t_wr[31:28];
        field {
            name = "t_wl";
            desc = "Write Command to Write Data Latency";
            sw = rw; hw = r;
            reset = 0x0;
        } t_wl[27:24];
        field {
            name = "t_init5";
            desc = "LPDDR Device Initialization Time. DDR3 not used.";
            sw = rw; hw = r;
            reset = 0x400;
        } t_init5[23:10];
        field {
            name = "t_zcal";
            desc = "ZQ Calibration to Command Delay.";
            sw = rw; hw = r;
            reset = 0x200;
        } t_zcal[9:0];
    } DRAMTIMER3 @ 0x3C;
    reg {
        name = "DRAMTIMER4";
        desc = "DRAMTIMER4 (offset 0x40, total reset 0x0000AA55; PROVEN: Hi3536D V100 data sheet).";
        field {
            name = "reserved_31_28";
            desc = "Reserved";
            sw = r; hw = w;
            reset = 0x0;
        } reserved_31_28[31:28];
        field {
            name = "t_odton";
            desc = "ODT turn-on latency (Number of cycles from write command to assert of ODT)";
            sw = rw; hw = r;
            reset = 0x0;
        } t_odton[27:24];
        field {
            name = "reserved_23_16";
            desc = "Reserved";
            sw = r; hw = w;
            reset = 0x0;
        } reserved_23_16[23:16];
        field {
            name = "t_odt";
            desc = "ODT valid cycles";
            sw = rw; hw = r;
            reset = 0xa;
        } t_odt[15:12];
        field {
            name = "t_wlo";
            desc = "Write Leveling Output Delay";
            sw = rw; hw = r;
            reset = 0x14;
        } t_wlo[11:7];
        field {
            name = "reserved_6_6";
            desc = "Reserved";
            sw = r; hw = na;
            reset = 0x1;
        } reserved_6_6[6:6];
        field {
            name = "t_wlmrd";
            desc = "Write Leveling Mode Programmed (Load Mode Register) to first DQS/DQS# rising edge delay";
            sw = rw; hw = r;
            reset = 0x15;
        } t_wlmrd[5:0];
    } DRAMTIMER4 @ 0x40;
    reg {
        name = "MODEREG01";
        desc = "MODEREG01 (offset 0x64, total reset 0x00000000; PROVEN: Hi3536D V100 data sheet).";
        field {
            name = "mr1";
            desc = "Mode Register 1";
            sw = rw; hw = r;
            reset = 0x0;
        } mr1[31:16];
        field {
            name = "mr0";
            desc = "Mode Register 0";
            sw = rw; hw = r;
            reset = 0x0;
        } mr0[15:0];
    } MODEREG01 @ 0x64;
    reg {
        name = "MODEREG23";
        desc = "MODEREG23 (offset 0x68, total reset 0x00000000; PROVEN: Hi3536D V100 data sheet).";
        field {
            name = "mr3";
            desc = "Mode Register 3";
            sw = rw; hw = r;
            reset = 0x0;
        } mr3[31:16];
        field {
            name = "mr2";
            desc = "Mode Register 2";
            sw = rw; hw = r;
            reset = 0x0;
        } mr2[15:0];
    } MODEREG23 @ 0x68;
    reg {
        name = "MISC";
        desc = "MISC (offset 0x70, total reset 0x00080000; PROVEN: Hi3536D V100 data sheet).";
        field {
            name = "swapdfibyte_en";
            desc = "Swap DFI Byte Lane 00: No Swap 01: Swap 000: No Swap 001: Swap 1";
            sw = rw; hw = r;
            reset = 0x0;
        } swapdfibyte_en[31:30];
        field {
            name = "swapwl_en";
            desc = "Swap Write Leveling Result 010: Swap 2 011: Swap 3 100: Swap 4";
            sw = rw; hw = r;
            reset = 0x0;
        } swapwl_en[29:27];
        field {
            name = "swapdm_en";
            desc = "Swap DM bus 00: No Swap 01: Swap 1 00: No Swap";
            sw = rw; hw = r;
            reset = 0x0;
        } swapdm_en[26:25];
        field {
            name = "swapaddr_en";
            desc = "Swap ADDRESS bus 01: Swap 1 10: Swap 2 000: No Swap 001: Swap 1";
            sw = rw; hw = r;
            reset = 0x0;
        } swapaddr_en[24:23];
        field {
            name = "swap_en";
            desc = "Swap DQ bus 010: Swap 2 011: Swap 3 100: Swap 4";
            sw = rw; hw = r;
            reset = 0x0;
        } swap_en[22:21];
        field {
            name = "cfg_dlyupd";
            desc = "When this bit is set to 1, the delay setting in registers will be applied to PHY immediately";
            sw = rw; hw = r;
            reset = 0x0;
        } cfg_dlyupd[20:20];
        field {
            name = "addr_delay";
            desc = "Add 1-T delay on address/command 000: No Swap 001: Swap 1";
            sw = rw; hw = r;
            reset = 0x1;
        } addr_delay[19:19];
        field {
            name = "swap_en_msb";
            desc = "Swap extended signal of DQ bus 010: Swap 2 011: Swap 3 100: Swap 4";
            sw = rw; hw = r;
            reset = 0x0;
        } swap_en_msb[18:18];
        field {
            name = "addr_toggle";
            desc = "Set this bit to 1 to toggle address bus every clock cycle";
            sw = rw; hw = r;
            reset = 0x0;
        } addr_toggle[17:17];
        field {
            name = "scramb_en";
            desc = "Data scrambler enable";
            sw = rw; hw = r;
            reset = 0x0;
        } scramb_en[16:16];
        field {
            name = "reserved_15_12";
            desc = "Set this bit to 1 to enable data scramble function Reserved";
            sw = r; hw = w;
            reset = 0x0;
        } reserved_15_12[15:12];
        field {
            name = "cfg_rl";
            desc = "PHY read latency.";
            sw = rw; hw = r;
            reset = 0x0;
        } cfg_rl[11:7];
        field {
            name = "reserved_6_5";
            desc = "This bit should be set to CL+AL-2. Reserved";
            sw = r; hw = w;
            reset = 0x0;
        } reserved_6_5[6:5];
        field {
            name = "cfg_wl";
            desc = "PHY write latency. This bit should be set to CWL+AL-1. 4.2 Flash Memory Controller 4.2.1 Overview The flash memory controller (FMC) provides memory controller interfaces for connecting to external SPI NAND flash or SPI NOR flash to access data. 4.2.2 Features The FMC has the following features:     Provides 4 KB+256 bytes on-chip buffer for improving the read speed.     Supports two CSs that can";
            sw = rw; hw = r;
            reset = 0x0;
        } cfg_wl[4:0];
    } MISC @ 0x70;
};

`endif
