`ifndef HI3536D_IO_CONFIG_RDL
`define HI3536D_IO_CONFIG_RDL

regfile eHI3536D_IO_CONFIG {
    name = "IO_CONFIG pin multiplexing (0x000) and pad control (0x800), Hi3536D V100";
    desc = "Pin multiplexing registers muxctrl_reg0..46 (0x120F0000 + 4 x n) and pad control registers padctrl_reg0..61 (0x120F0800 + 4 x n). Provenance: PROVEN for register names, addresses, default values, function lists and pad field layout (Hi3536D V100 pin-out workbook Hi3536DV100_PINOUT_EN.xlsx (HiSilicon release docs, sheets 3 (muxctrl_reg Description) and 4 (pad_ctrl_reg Description)), SDK documentation, unofficial copy kept local; facts only). INFERRED: the width of the mux select field (3 bits: the vendor device tree uses pinctrl-single function-mask 0x7; the workbook does not state it). Mux functions are numbered as in the workbook; values not listed are reserved. Pad registers: bit 8 pull-down enable, bit 7 slew (0 fast, 1 slow), bits 6:4 drive strength (the level table depends on the pad type, IO6_ has 8 levels, IO2_ 4 levels), other bits reserved. Hardware multiplexing outside these registers: JTAG pins are fixed when JTAG_EN=1, WDG_RSTN becomes SYS_RSTN_OUT when POR_ENABLE=1, and the power-on latch pins SFC_CLK (BOOTROM_SEL), GPIO3_7 (SFC_DEVICE_MODE) and MDCK (SFC_BOOT_MODE) are sampled at power-on (workbook sheet 5).";
    reg {
        name = "muxctrl_reg0";
        desc = "VGA_HS pin multiplexing register (VGA_HS, ball A18). Offset 0x000, default 0x0. PROVEN: pin-out workbook sheet 3. Function select: 0: GPIO2_4; 1: VGA_HS; Others: reserved";
        enum muxctrl_reg0_func_enum {
            F0 = 0 { name = "GPIO2_4"; };
            F1 = 1 { name = "VGA_HS"; };
        };
        field {
            name = "func";
            desc = "Pin function select (INFERRED 3-bit field)";
            sw = rw; hw = r;
            encode = muxctrl_reg0_func_enum;
            reset = 0x0;
        } func[2:0];
    } muxctrl_reg0 @ 0x0;
    reg {
        name = "muxctrl_reg1";
        desc = "VGA_VS pin multiplexing register (VGA_VS, ball A17). Offset 0x004, default 0x0. PROVEN: pin-out workbook sheet 3. Function select: 0: GPIO2_5; 1: VGA_VS; Others: reserved";
        enum muxctrl_reg1_func_enum {
            F0 = 0 { name = "GPIO2_5"; };
            F1 = 1 { name = "VGA_VS"; };
        };
        field {
            name = "func";
            desc = "Pin function select (INFERRED 3-bit field)";
            sw = rw; hw = r;
            encode = muxctrl_reg1_func_enum;
            reset = 0x0;
        } func[2:0];
    } muxctrl_reg1 @ 0x4;
    reg {
        name = "muxctrl_reg2";
        desc = "PWM_SVB_CORE pin multiplexing register (PWM_SVB_CORE, ball Y8). Offset 0x008, default 0x0. PROVEN: pin-out workbook sheet 3. Function select: 0: PWM_SVB_CORE; 1: GPIO2_6; Others: reserved";
        enum muxctrl_reg2_func_enum {
            F0 = 0 { name = "PWM_SVB_CORE"; };
            F1 = 1 { name = "GPIO2_6"; };
        };
        field {
            name = "func";
            desc = "Pin function select (INFERRED 3-bit field)";
            sw = rw; hw = r;
            encode = muxctrl_reg2_func_enum;
            reset = 0x0;
        } func[2:0];
    } muxctrl_reg2 @ 0x8;
    reg {
        name = "muxctrl_reg3";
        desc = "PWM_SVB_CPU pin multiplexing register (PWM_SVB_CPU, ball W8). Offset 0x00C, default 0x0. PROVEN: pin-out workbook sheet 3. Function select: 0: PWM_SVB_CPU; 1: GPIO2_7; Others: reserved";
        enum muxctrl_reg3_func_enum {
            F0 = 0 { name = "PWM_SVB_CPU"; };
            F1 = 1 { name = "GPIO2_7"; };
        };
        field {
            name = "func";
            desc = "Pin function select (INFERRED 3-bit field)";
            sw = rw; hw = r;
            encode = muxctrl_reg3_func_enum;
            reset = 0x0;
        } func[2:0];
    } muxctrl_reg3 @ 0xC;
    reg {
        name = "muxctrl_reg4";
        desc = "PWM_FREE pin multiplexing register (PWM_FREE, ball V8). Offset 0x010, default 0x0. PROVEN: pin-out workbook sheet 3. Function select: 0: GPIO5_7; 1: PWM_FREE; Others: reserved";
        enum muxctrl_reg4_func_enum {
            F0 = 0 { name = "GPIO5_7"; };
            F1 = 1 { name = "PWM_FREE"; };
        };
        field {
            name = "func";
            desc = "Pin function select (INFERRED 3-bit field)";
            sw = rw; hw = r;
            encode = muxctrl_reg4_func_enum;
            reset = 0x0;
        } func[2:0];
    } muxctrl_reg4 @ 0x10;
    reg {
        name = "muxctrl_reg5";
        desc = "I2C_SDA pin multiplexing register (I2C_SDA, ball J19). Offset 0x014, default 0x0. PROVEN: pin-out workbook sheet 3. Function select: 0: GPIO3_0; 1: I2C_SDA; Others: reserved";
        enum muxctrl_reg5_func_enum {
            F0 = 0 { name = "GPIO3_0"; };
            F1 = 1 { name = "I2C_SDA"; };
        };
        field {
            name = "func";
            desc = "Pin function select (INFERRED 3-bit field)";
            sw = rw; hw = r;
            encode = muxctrl_reg5_func_enum;
            reset = 0x0;
        } func[2:0];
    } muxctrl_reg5 @ 0x14;
    reg {
        name = "muxctrl_reg6";
        desc = "I2C_SCL pin multiplexing register (I2C_SCL, ball J18). Offset 0x018, default 0x0. PROVEN: pin-out workbook sheet 3. Function select: 0: GPIO3_1; 1: I2C_SCL; Others: reserved";
        enum muxctrl_reg6_func_enum {
            F0 = 0 { name = "GPIO3_1"; };
            F1 = 1 { name = "I2C_SCL"; };
        };
        field {
            name = "func";
            desc = "Pin function select (INFERRED 3-bit field)";
            sw = rw; hw = r;
            encode = muxctrl_reg6_func_enum;
            reset = 0x0;
        } func[2:0];
    } muxctrl_reg6 @ 0x18;
    reg {
        name = "muxctrl_reg7";
        desc = "UART1_RXD pin multiplexing register (UART1_RXD, ball A4). Offset 0x01C, default 0x0. PROVEN: pin-out workbook sheet 3. Function select: 0: GPIO4_0; 1: UART1_RXD; Others: reserved";
        enum muxctrl_reg7_func_enum {
            F0 = 0 { name = "GPIO4_0"; };
            F1 = 1 { name = "UART1_RXD"; };
        };
        field {
            name = "func";
            desc = "Pin function select (INFERRED 3-bit field)";
            sw = rw; hw = r;
            encode = muxctrl_reg7_func_enum;
            reset = 0x0;
        } func[2:0];
    } muxctrl_reg7 @ 0x1C;
    reg {
        name = "muxctrl_reg8";
        desc = "UART1_TXD pin multiplexing register (UART1_TXD, ball B5). Offset 0x020, default 0x0. PROVEN: pin-out workbook sheet 3. Function select: 0: GPIO4_1; 1: UART1_TXD; Others: reserved";
        enum muxctrl_reg8_func_enum {
            F0 = 0 { name = "GPIO4_1"; };
            F1 = 1 { name = "UART1_TXD"; };
        };
        field {
            name = "func";
            desc = "Pin function select (INFERRED 3-bit field)";
            sw = rw; hw = r;
            encode = muxctrl_reg8_func_enum;
            reset = 0x0;
        } func[2:0];
    } muxctrl_reg8 @ 0x20;
    reg {
        name = "muxctrl_reg9";
        desc = "UART1_RTSN pin multiplexing register (UART1_RTSN, ball B6). Offset 0x024, default 0x0. PROVEN: pin-out workbook sheet 3. Function select: 0: GPIO4_2; 1: UART1_RTSN; Others: reserved";
        enum muxctrl_reg9_func_enum {
            F0 = 0 { name = "GPIO4_2"; };
            F1 = 1 { name = "UART1_RTSN"; };
        };
        field {
            name = "func";
            desc = "Pin function select (INFERRED 3-bit field)";
            sw = rw; hw = r;
            encode = muxctrl_reg9_func_enum;
            reset = 0x0;
        } func[2:0];
    } muxctrl_reg9 @ 0x24;
    reg {
        name = "muxctrl_reg10";
        desc = "UART1_CTSN pin multiplexing register (UART1_CTSN, ball A5). Offset 0x028, default 0x0. PROVEN: pin-out workbook sheet 3. Function select: 0: GPIO4_3; 1: UART1_CTSN; Others: reserved";
        enum muxctrl_reg10_func_enum {
            F0 = 0 { name = "GPIO4_3"; };
            F1 = 1 { name = "UART1_CTSN"; };
        };
        field {
            name = "func";
            desc = "Pin function select (INFERRED 3-bit field)";
            sw = rw; hw = r;
            encode = muxctrl_reg10_func_enum;
            reset = 0x0;
        } func[2:0];
    } muxctrl_reg10 @ 0x28;
    reg {
        name = "muxctrl_reg11";
        desc = "UART2_RXD pin multiplexing register (UART2_RXD, ball U7). Offset 0x02C, default 0x0. PROVEN: pin-out workbook sheet 3. Function select: 0: GPIO4_4; 1: UART2_RXD; Others: reserved";
        enum muxctrl_reg11_func_enum {
            F0 = 0 { name = "GPIO4_4"; };
            F1 = 1 { name = "UART2_RXD"; };
        };
        field {
            name = "func";
            desc = "Pin function select (INFERRED 3-bit field)";
            sw = rw; hw = r;
            encode = muxctrl_reg11_func_enum;
            reset = 0x0;
        } func[2:0];
    } muxctrl_reg11 @ 0x2C;
    reg {
        name = "muxctrl_reg12";
        desc = "UART2_TXD pin multiplexing register (UART2_TXD, ball U6). Offset 0x030, default 0x0. PROVEN: pin-out workbook sheet 3. Function select: 0: GPIO4_5; 1: UART2_TXD; Others: reserved";
        enum muxctrl_reg12_func_enum {
            F0 = 0 { name = "GPIO4_5"; };
            F1 = 1 { name = "UART2_TXD"; };
        };
        field {
            name = "func";
            desc = "Pin function select (INFERRED 3-bit field)";
            sw = rw; hw = r;
            encode = muxctrl_reg12_func_enum;
            reset = 0x0;
        } func[2:0];
    } muxctrl_reg12 @ 0x30;
    reg {
        name = "muxctrl_reg13";
        desc = "ETH_LINK_LED pin multiplexing register (ETH_LINK_LED, ball H19). Offset 0x034, default 0x0. PROVEN: pin-out workbook sheet 3. Function select: 0: GPIO4_6; 1: ETH_LINK_LED; Others: reserved";
        enum muxctrl_reg13_func_enum {
            F0 = 0 { name = "GPIO4_6"; };
            F1 = 1 { name = "ETH_LINK_LED"; };
        };
        field {
            name = "func";
            desc = "Pin function select (INFERRED 3-bit field)";
            sw = rw; hw = r;
            encode = muxctrl_reg13_func_enum;
            reset = 0x0;
        } func[2:0];
    } muxctrl_reg13 @ 0x34;
    reg {
        name = "muxctrl_reg14";
        desc = "ETH_SPD_LED pin multiplexing register (ETH_SPD_LED, ball J20). Offset 0x038, default 0x0. PROVEN: pin-out workbook sheet 3. Function select: 0: GPIO4_7; 1: ETH_SPD_LED; Others: reserved";
        enum muxctrl_reg14_func_enum {
            F0 = 0 { name = "GPIO4_7"; };
            F1 = 1 { name = "ETH_SPD_LED"; };
        };
        field {
            name = "func";
            desc = "Pin function select (INFERRED 3-bit field)";
            sw = rw; hw = r;
            encode = muxctrl_reg14_func_enum;
            reset = 0x0;
        } func[2:0];
    } muxctrl_reg14 @ 0x38;
    reg {
        name = "muxctrl_reg15";
        desc = "IR_IN pin multiplexing register (IR_IN, ball W5). Offset 0x03C, default 0x0. PROVEN: pin-out workbook sheet 3. Function select: 0: GPIO3_2; 1: IR_IN; Others: reserved";
        enum muxctrl_reg15_func_enum {
            F0 = 0 { name = "GPIO3_2"; };
            F1 = 1 { name = "IR_IN"; };
        };
        field {
            name = "func";
            desc = "Pin function select (INFERRED 3-bit field)";
            sw = rw; hw = r;
            encode = muxctrl_reg15_func_enum;
            reset = 0x0;
        } func[2:0];
    } muxctrl_reg15 @ 0x3C;
    reg {
        name = "muxctrl_reg16";
        desc = "JTAG_TRSTN pin multiplexing register (JTAG_TRSTN, ball V6). Offset 0x040, default 0x0. PROVEN: pin-out workbook sheet 3. Function select: 0: GPIO5_0; 3: I2S_SD_RX; Others: reserved";
        enum muxctrl_reg16_func_enum {
            F0 = 0 { name = "GPIO5_0"; };
            F3 = 3 { name = "I2S_SD_RX"; };
        };
        field {
            name = "func";
            desc = "Pin function select (INFERRED 3-bit field)";
            sw = rw; hw = r;
            encode = muxctrl_reg16_func_enum;
            reset = 0x0;
        } func[2:0];
    } muxctrl_reg16 @ 0x40;
    reg {
        name = "muxctrl_reg17";
        desc = "JTAG_TCK pin multiplexing register (JTAG_TCK, ball V7). Offset 0x044, default 0x0. PROVEN: pin-out workbook sheet 3. Function select: 0: GPIO5_1; 3: I2S_MCLK; Others: reserved";
        enum muxctrl_reg17_func_enum {
            F0 = 0 { name = "GPIO5_1"; };
            F3 = 3 { name = "I2S_MCLK"; };
        };
        field {
            name = "func";
            desc = "Pin function select (INFERRED 3-bit field)";
            sw = rw; hw = r;
            encode = muxctrl_reg17_func_enum;
            reset = 0x0;
        } func[2:0];
    } muxctrl_reg17 @ 0x44;
    reg {
        name = "muxctrl_reg18";
        desc = "JTAG_TMS pin multiplexing register (JTAG_TMS, ball Y6). Offset 0x048, default 0x0. PROVEN: pin-out workbook sheet 3. Function select: 0: GPIO5_2; 3: I2S_WS; Others: reserved";
        enum muxctrl_reg18_func_enum {
            F0 = 0 { name = "GPIO5_2"; };
            F3 = 3 { name = "I2S_WS"; };
        };
        field {
            name = "func";
            desc = "Pin function select (INFERRED 3-bit field)";
            sw = rw; hw = r;
            encode = muxctrl_reg18_func_enum;
            reset = 0x0;
        } func[2:0];
    } muxctrl_reg18 @ 0x48;
    reg {
        name = "muxctrl_reg19";
        desc = "JTAG_TDO pin multiplexing register (JTAG_TDO, ball W7). Offset 0x04C, default 0x0. PROVEN: pin-out workbook sheet 3. Function select: 0: GPIO5_3; 3: I2S_BCLK; Others: reserved";
        enum muxctrl_reg19_func_enum {
            F0 = 0 { name = "GPIO5_3"; };
            F3 = 3 { name = "I2S_BCLK"; };
        };
        field {
            name = "func";
            desc = "Pin function select (INFERRED 3-bit field)";
            sw = rw; hw = r;
            encode = muxctrl_reg19_func_enum;
            reset = 0x0;
        } func[2:0];
    } muxctrl_reg19 @ 0x4C;
    reg {
        name = "muxctrl_reg20";
        desc = "JTAG_TDI pin multiplexing register (JTAG_TDI, ball W6). Offset 0x050, default 0x0. PROVEN: pin-out workbook sheet 3. Function select: 0: GPIO5_4; 3: I2S_SD_TX; Others: reserved";
        enum muxctrl_reg20_func_enum {
            F0 = 0 { name = "GPIO5_4"; };
            F3 = 3 { name = "I2S_SD_TX"; };
        };
        field {
            name = "func";
            desc = "Pin function select (INFERRED 3-bit field)";
            sw = rw; hw = r;
            encode = muxctrl_reg20_func_enum;
            reset = 0x0;
        } func[2:0];
    } muxctrl_reg20 @ 0x50;
    reg {
        name = "muxctrl_reg21";
        desc = "USB2_PWREN0 pin multiplexing register (USB2_PWREN0, ball C7). Offset 0x054, default 0x0. PROVEN: pin-out workbook sheet 3. Function select: 0: GPIO5_5; 1: USB2_PWREN0; Others: reserved";
        enum muxctrl_reg21_func_enum {
            F0 = 0 { name = "GPIO5_5"; };
            F1 = 1 { name = "USB2_PWREN0"; };
        };
        field {
            name = "func";
            desc = "Pin function select (INFERRED 3-bit field)";
            sw = rw; hw = r;
            encode = muxctrl_reg21_func_enum;
            reset = 0x0;
        } func[2:0];
    } muxctrl_reg21 @ 0x54;
    reg {
        name = "muxctrl_reg22";
        desc = "USB2_PWREN1 pin multiplexing register (USB2_PWREN1, ball B7). Offset 0x058, default 0x0. PROVEN: pin-out workbook sheet 3. Function select: 0: GPIO5_6; 1: USB2_PWREN1; Others: reserved";
        enum muxctrl_reg22_func_enum {
            F0 = 0 { name = "GPIO5_6"; };
            F1 = 1 { name = "USB2_PWREN1"; };
        };
        field {
            name = "func";
            desc = "Pin function select (INFERRED 3-bit field)";
            sw = rw; hw = r;
            encode = muxctrl_reg22_func_enum;
            reset = 0x0;
        } func[2:0];
    } muxctrl_reg22 @ 0x58;
    reg {
        name = "muxctrl_reg23";
        desc = "HDMI_HOTPLUG pin multiplexing register (HDMI_HOTPLUG, ball C15). Offset 0x05C, default 0x0. PROVEN: pin-out workbook sheet 3. Function select: 0: GPIO3_3; 1: HDMI_HOTPLUG; Others: reserved";
        enum muxctrl_reg23_func_enum {
            F0 = 0 { name = "GPIO3_3"; };
            F1 = 1 { name = "HDMI_HOTPLUG"; };
        };
        field {
            name = "func";
            desc = "Pin function select (INFERRED 3-bit field)";
            sw = rw; hw = r;
            encode = muxctrl_reg23_func_enum;
            reset = 0x0;
        } func[2:0];
    } muxctrl_reg23 @ 0x5C;
    reg {
        name = "muxctrl_reg24";
        desc = "HDMI_SDA pin multiplexing register (HDMI_SDA, ball C16). Offset 0x060, default 0x0. PROVEN: pin-out workbook sheet 3. Function select: 0: GPIO3_4; 1: HDMI_SDA; Others: reserved";
        enum muxctrl_reg24_func_enum {
            F0 = 0 { name = "GPIO3_4"; };
            F1 = 1 { name = "HDMI_SDA"; };
        };
        field {
            name = "func";
            desc = "Pin function select (INFERRED 3-bit field)";
            sw = rw; hw = r;
            encode = muxctrl_reg24_func_enum;
            reset = 0x0;
        } func[2:0];
    } muxctrl_reg24 @ 0x60;
    reg {
        name = "muxctrl_reg25";
        desc = "HDMI_SCL pin multiplexing register (HDMI_SCL, ball B16). Offset 0x064, default 0x0. PROVEN: pin-out workbook sheet 3. Function select: 0: GPIO3_5; 1: HDMI_SCL; Others: reserved";
        enum muxctrl_reg25_func_enum {
            F0 = 0 { name = "GPIO3_5"; };
            F1 = 1 { name = "HDMI_SCL"; };
        };
        field {
            name = "func";
            desc = "Pin function select (INFERRED 3-bit field)";
            sw = rw; hw = r;
            encode = muxctrl_reg25_func_enum;
            reset = 0x0;
        } func[2:0];
    } muxctrl_reg25 @ 0x64;
    reg {
        name = "muxctrl_reg26";
        desc = "SATA_LED_N pin multiplexing register (SATA_LED_N, ball U14). Offset 0x068, default 0x0. PROVEN: pin-out workbook sheet 3. Function select: 0: GPIO3_6; 1: SATA_LED_N; Others: reserved";
        enum muxctrl_reg26_func_enum {
            F0 = 0 { name = "GPIO3_6"; };
            F1 = 1 { name = "SATA_LED_N"; };
        };
        field {
            name = "func";
            desc = "Pin function select (INFERRED 3-bit field)";
            sw = rw; hw = r;
            encode = muxctrl_reg26_func_enum;
            reset = 0x0;
        } func[2:0];
    } muxctrl_reg26 @ 0x68;
    reg {
        name = "muxctrl_reg27";
        desc = "GPIO0_0 pin multiplexing register (GPIO0_0, ball N19). Offset 0x06C, default 0x0. PROVEN: pin-out workbook sheet 3. Function select: 0: GPIO0_0; 1: MII_RXDV; Others: reserved";
        enum muxctrl_reg27_func_enum {
            F0 = 0 { name = "GPIO0_0"; };
            F1 = 1 { name = "MII_RXDV"; };
        };
        field {
            name = "func";
            desc = "Pin function select (INFERRED 3-bit field)";
            sw = rw; hw = r;
            encode = muxctrl_reg27_func_enum;
            reset = 0x0;
        } func[2:0];
    } muxctrl_reg27 @ 0x6C;
    reg {
        name = "muxctrl_reg28";
        desc = "GPIO0_1 pin multiplexing register (GPIO0_1, ball R19). Offset 0x070, default 0x0. PROVEN: pin-out workbook sheet 3. Function select: 0: GPIO0_1; 1: MII_RXD3; 2: I2S_WS; Others: reserved";
        enum muxctrl_reg28_func_enum {
            F0 = 0 { name = "GPIO0_1"; };
            F1 = 1 { name = "MII_RXD3"; };
            F2 = 2 { name = "I2S_WS"; };
        };
        field {
            name = "func";
            desc = "Pin function select (INFERRED 3-bit field)";
            sw = rw; hw = r;
            encode = muxctrl_reg28_func_enum;
            reset = 0x0;
        } func[2:0];
    } muxctrl_reg28 @ 0x70;
    reg {
        name = "muxctrl_reg29";
        desc = "GPIO0_2 pin multiplexing register (GPIO0_2, ball P18). Offset 0x074, default 0x0. PROVEN: pin-out workbook sheet 3. Function select: 0: GPIO0_2; 1: MII_RXD2; Others: reserved";
        enum muxctrl_reg29_func_enum {
            F0 = 0 { name = "GPIO0_2"; };
            F1 = 1 { name = "MII_RXD2"; };
        };
        field {
            name = "func";
            desc = "Pin function select (INFERRED 3-bit field)";
            sw = rw; hw = r;
            encode = muxctrl_reg29_func_enum;
            reset = 0x0;
        } func[2:0];
    } muxctrl_reg29 @ 0x74;
    reg {
        name = "muxctrl_reg30";
        desc = "GPIO0_3 pin multiplexing register (GPIO0_3, ball P19). Offset 0x078, default 0x0. PROVEN: pin-out workbook sheet 3. Function select: 0: GPIO0_3; 1: MII_RXD1; 2: I2S_BCLK; Others: reserved";
        enum muxctrl_reg30_func_enum {
            F0 = 0 { name = "GPIO0_3"; };
            F1 = 1 { name = "MII_RXD1"; };
            F2 = 2 { name = "I2S_BCLK"; };
        };
        field {
            name = "func";
            desc = "Pin function select (INFERRED 3-bit field)";
            sw = rw; hw = r;
            encode = muxctrl_reg30_func_enum;
            reset = 0x0;
        } func[2:0];
    } muxctrl_reg30 @ 0x78;
    reg {
        name = "muxctrl_reg31";
        desc = "GPIO0_4 pin multiplexing register (GPIO0_4, ball P20). Offset 0x07C, default 0x0. PROVEN: pin-out workbook sheet 3. Function select: 0: GPIO0_4; 1: MII_RXD0; 2: I2S_MCLK; Others: reserved";
        enum muxctrl_reg31_func_enum {
            F0 = 0 { name = "GPIO0_4"; };
            F1 = 1 { name = "MII_RXD0"; };
            F2 = 2 { name = "I2S_MCLK"; };
        };
        field {
            name = "func";
            desc = "Pin function select (INFERRED 3-bit field)";
            sw = rw; hw = r;
            encode = muxctrl_reg31_func_enum;
            reset = 0x0;
        } func[2:0];
    } muxctrl_reg31 @ 0x7C;
    reg {
        name = "muxctrl_reg32";
        desc = "GPIO0_5 pin multiplexing register (GPIO0_5, ball R18). Offset 0x080, default 0x0. PROVEN: pin-out workbook sheet 3. Function select: 0: GPIO0_5; 1: MII_RXCK; Others: reserved";
        enum muxctrl_reg32_func_enum {
            F0 = 0 { name = "GPIO0_5"; };
            F1 = 1 { name = "MII_RXCK"; };
        };
        field {
            name = "func";
            desc = "Pin function select (INFERRED 3-bit field)";
            sw = rw; hw = r;
            encode = muxctrl_reg32_func_enum;
            reset = 0x0;
        } func[2:0];
    } muxctrl_reg32 @ 0x80;
    reg {
        name = "muxctrl_reg33";
        desc = "GPIO0_6 pin multiplexing register (GPIO0_6, ball V20). Offset 0x084, default 0x0. PROVEN: pin-out workbook sheet 3. Function select: 0: GPIO0_6; 1: MII_TXEN; Others: reserved";
        enum muxctrl_reg33_func_enum {
            F0 = 0 { name = "GPIO0_6"; };
            F1 = 1 { name = "MII_TXEN"; };
        };
        field {
            name = "func";
            desc = "Pin function select (INFERRED 3-bit field)";
            sw = rw; hw = r;
            encode = muxctrl_reg33_func_enum;
            reset = 0x0;
        } func[2:0];
    } muxctrl_reg33 @ 0x84;
    reg {
        name = "muxctrl_reg34";
        desc = "GPIO0_7 pin multiplexing register (GPIO0_7, ball U18). Offset 0x088, default 0x0. PROVEN: pin-out workbook sheet 3. Function select: 0: GPIO0_7; 1: MII_TXD3; Others: reserved";
        enum muxctrl_reg34_func_enum {
            F0 = 0 { name = "GPIO0_7"; };
            F1 = 1 { name = "MII_TXD3"; };
        };
        field {
            name = "func";
            desc = "Pin function select (INFERRED 3-bit field)";
            sw = rw; hw = r;
            encode = muxctrl_reg34_func_enum;
            reset = 0x0;
        } func[2:0];
    } muxctrl_reg34 @ 0x88;
    reg {
        name = "muxctrl_reg35";
        desc = "GPIO1_0 pin multiplexing register (GPIO1_0, ball U19). Offset 0x08C, default 0x0. PROVEN: pin-out workbook sheet 3. Function select: 0: GPIO1_0; 1: MII_TXD2; Others: reserved";
        enum muxctrl_reg35_func_enum {
            F0 = 0 { name = "GPIO1_0"; };
            F1 = 1 { name = "MII_TXD2"; };
        };
        field {
            name = "func";
            desc = "Pin function select (INFERRED 3-bit field)";
            sw = rw; hw = r;
            encode = muxctrl_reg35_func_enum;
            reset = 0x0;
        } func[2:0];
    } muxctrl_reg35 @ 0x8C;
    reg {
        name = "muxctrl_reg36";
        desc = "GPIO1_1 pin multiplexing register (GPIO1_1, ball T18). Offset 0x090, default 0x0. PROVEN: pin-out workbook sheet 3. Function select: 0: GPIO1_1; 1: MII_TXD1; 2: I2S_SD_RX; Others: reserved";
        enum muxctrl_reg36_func_enum {
            F0 = 0 { name = "GPIO1_1"; };
            F1 = 1 { name = "MII_TXD1"; };
            F2 = 2 { name = "I2S_SD_RX"; };
        };
        field {
            name = "func";
            desc = "Pin function select (INFERRED 3-bit field)";
            sw = rw; hw = r;
            encode = muxctrl_reg36_func_enum;
            reset = 0x0;
        } func[2:0];
    } muxctrl_reg36 @ 0x90;
    reg {
        name = "muxctrl_reg37";
        desc = "GPIO1_2 pin multiplexing register (GPIO1_2, ball T19). Offset 0x094, default 0x0. PROVEN: pin-out workbook sheet 3. Function select: 0: GPIO1_2; 1: MII_TXD0; 2: I2S_SD_TX; Others: reserved";
        enum muxctrl_reg37_func_enum {
            F0 = 0 { name = "GPIO1_2"; };
            F1 = 1 { name = "MII_TXD0"; };
            F2 = 2 { name = "I2S_SD_TX"; };
        };
        field {
            name = "func";
            desc = "Pin function select (INFERRED 3-bit field)";
            sw = rw; hw = r;
            encode = muxctrl_reg37_func_enum;
            reset = 0x0;
        } func[2:0];
    } muxctrl_reg37 @ 0x94;
    reg {
        name = "muxctrl_reg38";
        desc = "GPIO1_3 pin multiplexing register (GPIO1_3, ball T20). Offset 0x098, default 0x0. PROVEN: pin-out workbook sheet 3. Function select: 0: GPIO1_3; 1: MII_TXCK; 2: RMII_CLK; Others: reserved";
        enum muxctrl_reg38_func_enum {
            F0 = 0 { name = "GPIO1_3"; };
            F1 = 1 { name = "MII_TXCK"; };
            F2 = 2 { name = "RMII_CLK"; };
        };
        field {
            name = "func";
            desc = "Pin function select (INFERRED 3-bit field)";
            sw = rw; hw = r;
            encode = muxctrl_reg38_func_enum;
            reset = 0x0;
        } func[2:0];
    } muxctrl_reg38 @ 0x98;
    reg {
        name = "muxctrl_reg39";
        desc = "GPIO1_4 pin multiplexing register (GPIO1_4, ball Y19). Offset 0x09C, default 0x0. PROVEN: pin-out workbook sheet 3. Function select: 0: GPIO1_4; 1: MII_CRS; Others: reserved";
        enum muxctrl_reg39_func_enum {
            F0 = 0 { name = "GPIO1_4"; };
            F1 = 1 { name = "MII_CRS"; };
        };
        field {
            name = "func";
            desc = "Pin function select (INFERRED 3-bit field)";
            sw = rw; hw = r;
            encode = muxctrl_reg39_func_enum;
            reset = 0x0;
        } func[2:0];
    } muxctrl_reg39 @ 0x9C;
    reg {
        name = "muxctrl_reg40";
        desc = "GPIO1_5 pin multiplexing register (GPIO1_5, ball V18). Offset 0x0A0, default 0x0. PROVEN: pin-out workbook sheet 3. Function select: 0: GPIO1_5; 1: MII_COL; Others: reserved";
        enum muxctrl_reg40_func_enum {
            F0 = 0 { name = "GPIO1_5"; };
            F1 = 1 { name = "MII_COL"; };
        };
        field {
            name = "func";
            desc = "Pin function select (INFERRED 3-bit field)";
            sw = rw; hw = r;
            encode = muxctrl_reg40_func_enum;
            reset = 0x0;
        } func[2:0];
    } muxctrl_reg40 @ 0xA0;
    reg {
        name = "muxctrl_reg41";
        desc = "GPIO1_6 pin multiplexing register (GPIO1_6, ball V17). Offset 0x0A4, default 0x0. PROVEN: pin-out workbook sheet 3. Function select: 0: GPIO1_6; 1: MII_RXER; Others: reserved";
        enum muxctrl_reg41_func_enum {
            F0 = 0 { name = "GPIO1_6"; };
            F1 = 1 { name = "MII_RXER"; };
        };
        field {
            name = "func";
            desc = "Pin function select (INFERRED 3-bit field)";
            sw = rw; hw = r;
            encode = muxctrl_reg41_func_enum;
            reset = 0x0;
        } func[2:0];
    } muxctrl_reg41 @ 0xA4;
    reg {
        name = "muxctrl_reg42";
        desc = "GPIO1_7 pin multiplexing register (GPIO1_7, ball W17). Offset 0x0A8, default 0x0. PROVEN: pin-out workbook sheet 3. Function select: 0: GPIO1_7; 1: MII_TXER; Others: reserved";
        enum muxctrl_reg42_func_enum {
            F0 = 0 { name = "GPIO1_7"; };
            F1 = 1 { name = "MII_TXER"; };
        };
        field {
            name = "func";
            desc = "Pin function select (INFERRED 3-bit field)";
            sw = rw; hw = r;
            encode = muxctrl_reg42_func_enum;
            reset = 0x0;
        } func[2:0];
    } muxctrl_reg42 @ 0xA8;
    reg {
        name = "muxctrl_reg43";
        desc = "GPIO2_0 pin multiplexing register (GPIO2_0, ball W18). Offset 0x0AC, default 0x0. PROVEN: pin-out workbook sheet 3. Function select: 0: TEST_CLK; 1: EPHY_CLK; 2: GPIO2_0; Others: reserved";
        enum muxctrl_reg43_func_enum {
            F0 = 0 { name = "TEST_CLK"; };
            F1 = 1 { name = "EPHY_CLK"; };
            F2 = 2 { name = "GPIO2_0"; };
        };
        field {
            name = "func";
            desc = "Pin function select (INFERRED 3-bit field)";
            sw = rw; hw = r;
            encode = muxctrl_reg43_func_enum;
            reset = 0x0;
        } func[2:0];
    } muxctrl_reg43 @ 0xAC;
    reg {
        name = "muxctrl_reg44";
        desc = "GPIO2_1 pin multiplexing register (GPIO2_1, ball V19). Offset 0x0B0, default 0x0. PROVEN: pin-out workbook sheet 3. Function select: 0: GPIO2_1; 1: EPHY_RSTN; Others: reserved";
        enum muxctrl_reg44_func_enum {
            F0 = 0 { name = "GPIO2_1"; };
            F1 = 1 { name = "EPHY_RSTN"; };
        };
        field {
            name = "func";
            desc = "Pin function select (INFERRED 3-bit field)";
            sw = rw; hw = r;
            encode = muxctrl_reg44_func_enum;
            reset = 0x0;
        } func[2:0];
    } muxctrl_reg44 @ 0xB0;
    reg {
        name = "muxctrl_reg45";
        desc = "MDCK pin multiplexing register (MDCK, ball W20). Offset 0x0B4, default 0x0. PROVEN: pin-out workbook sheet 3. Function select: 0: GPIO2_2; 1: MDCK; Others: reserved";
        enum muxctrl_reg45_func_enum {
            F0 = 0 { name = "GPIO2_2"; };
            F1 = 1 { name = "MDCK"; };
        };
        field {
            name = "func";
            desc = "Pin function select (INFERRED 3-bit field)";
            sw = rw; hw = r;
            encode = muxctrl_reg45_func_enum;
            reset = 0x0;
        } func[2:0];
    } muxctrl_reg45 @ 0xB4;
    reg {
        name = "muxctrl_reg46";
        desc = "MDIO pin multiplexing register (MDIO, ball W19). Offset 0x0B8, default 0x0. PROVEN: pin-out workbook sheet 3. Function select: 0: GPIO2_3; 1: MDIO; Others: reserved";
        enum muxctrl_reg46_func_enum {
            F0 = 0 { name = "GPIO2_3"; };
            F1 = 1 { name = "MDIO"; };
        };
        field {
            name = "func";
            desc = "Pin function select (INFERRED 3-bit field)";
            sw = rw; hw = r;
            encode = muxctrl_reg46_func_enum;
            reset = 0x0;
        } func[2:0];
    } muxctrl_reg46 @ 0xB8;
    reg {
        name = "padctrl_reg0";
        desc = "VGA_HS pin drive capability register (VGA_HS, ball A18). Offset 0x800, default 0xF0. PROVEN: pin-out workbook sheet 4.";
        field { name = "pull_down_en"; desc = "Pull-down resistor enable: 0 disabled, 1 enabled"; sw = rw; hw = r; reset = 0x0; } pull_down_en[8:8];
        field { name = "slew"; desc = "Level conversion speed: 0 fast edge, 1 slow edge"; sw = rw; hw = r; reset = 0x1; } slew[7:7];
        field { name = "drive"; desc = "VGA_HS pin drive capability:; 000: IO6_ level 8; 001: IO6_ level 7; 010: IO6_ level 6; 011: IO6_ level 5; 100: IO6_ level 4; 101: IO6_ level 3; 110: IO6_ level 2; 111: IO6_ level 1"; sw = rw; hw = r; reset = 0x7; } drive[6:4];
    } padctrl_reg0 @ 0x800;
    reg {
        name = "padctrl_reg1";
        desc = "VGA_VS pin drive capability register (VGA_VS, ball A17). Offset 0x804, default 0xF0. PROVEN: pin-out workbook sheet 4.";
        field { name = "pull_down_en"; desc = "Pull-down resistor enable: 0 disabled, 1 enabled"; sw = rw; hw = r; reset = 0x0; } pull_down_en[8:8];
        field { name = "slew"; desc = "Level conversion speed: 0 fast edge, 1 slow edge"; sw = rw; hw = r; reset = 0x1; } slew[7:7];
        field { name = "drive"; desc = "VGA_VS pin drive capability:; 000: IO6_ level 8; 001: IO6_ level 7; 010: IO6_ level 6; 011: IO6_ level 5; 100: IO6_ level 4; 101: IO6_ level 3; 110: IO6_ level 2; 111: IO6_ level 1"; sw = rw; hw = r; reset = 0x7; } drive[6:4];
    } padctrl_reg1 @ 0x804;
    reg {
        name = "padctrl_reg2";
        desc = "PWM_SVB_CORE pin drive capability register (PWM_SVB_CORE, ball Y8). Offset 0x808, default 0xB0. PROVEN: pin-out workbook sheet 4.";
        field { name = "pull_down_en"; desc = "Pull-down resistor enable: 0 disabled, 1 enabled"; sw = rw; hw = r; reset = 0x0; } pull_down_en[8:8];
        field { name = "slew"; desc = "Level conversion speed: 0 fast edge, 1 slow edge"; sw = rw; hw = r; reset = 0x1; } slew[7:7];
        field { name = "drive"; desc = "PWM_SVB_CORE pin drive capability:; 000: IO2_ level 1; 001: IO2_ level 2; 010: IO2_ level 3; 011: IO2_ level 4"; sw = rw; hw = r; reset = 0x3; } drive[6:4];
    } padctrl_reg2 @ 0x808;
    reg {
        name = "padctrl_reg3";
        desc = "PWM_SVB_CPU pin drive capability register (PWM_SVB_CPU, ball W8). Offset 0x80C, default 0xB0. PROVEN: pin-out workbook sheet 4.";
        field { name = "pull_down_en"; desc = "Pull-down resistor enable: 0 disabled, 1 enabled"; sw = rw; hw = r; reset = 0x0; } pull_down_en[8:8];
        field { name = "slew"; desc = "Level conversion speed: 0 fast edge, 1 slow edge"; sw = rw; hw = r; reset = 0x1; } slew[7:7];
        field { name = "drive"; desc = "PWM_SVB_CPU pin drive capability:; 000: IO2_ level 1; 001: IO2_ level 2; 010: IO2_ level 3; 011: IO2_ level 4"; sw = rw; hw = r; reset = 0x3; } drive[6:4];
    } padctrl_reg3 @ 0x80C;
    reg {
        name = "padctrl_reg4";
        desc = "PWM_FREE pin drive capability register (PWM_FREE, ball V8). Offset 0x810, default 0xB0. PROVEN: pin-out workbook sheet 4.";
        field { name = "pull_down_en"; desc = "Pull-down resistor enable: 0 disabled, 1 enabled"; sw = rw; hw = r; reset = 0x0; } pull_down_en[8:8];
        field { name = "slew"; desc = "Level conversion speed: 0 fast edge, 1 slow edge"; sw = rw; hw = r; reset = 0x1; } slew[7:7];
        field { name = "drive"; desc = "PWM_FREE pin drive capability:; 000: IO2_ level 1; 001: IO2_ level 2; 010: IO2_ level 3; 011: IO2_ level 4"; sw = rw; hw = r; reset = 0x3; } drive[6:4];
    } padctrl_reg4 @ 0x810;
    reg {
        name = "padctrl_reg5";
        desc = "I2C_SDA pin drive capability register (I2C_SDA, ball J19). Offset 0x814, default 0xB0. PROVEN: pin-out workbook sheet 4.";
        field { name = "pull_down_en"; desc = "Pull-down resistor enable: 0 disabled, 1 enabled"; sw = rw; hw = r; reset = 0x0; } pull_down_en[8:8];
        field { name = "slew"; desc = "Level conversion speed: 0 fast edge, 1 slow edge"; sw = rw; hw = r; reset = 0x1; } slew[7:7];
        field { name = "drive"; desc = "I2C_SDA pin drive capability:; 000: IO2_ level 1; 001: IO2_ level 2; 010: IO2_ level 3; 011: IO2_ level 4"; sw = rw; hw = r; reset = 0x3; } drive[6:4];
    } padctrl_reg5 @ 0x814;
    reg {
        name = "padctrl_reg6";
        desc = "I2C_SCL pin drive capability register (I2C_SCL, ball J18). Offset 0x818, default 0xB0. PROVEN: pin-out workbook sheet 4.";
        field { name = "pull_down_en"; desc = "Pull-down resistor enable: 0 disabled, 1 enabled"; sw = rw; hw = r; reset = 0x0; } pull_down_en[8:8];
        field { name = "slew"; desc = "Level conversion speed: 0 fast edge, 1 slow edge"; sw = rw; hw = r; reset = 0x1; } slew[7:7];
        field { name = "drive"; desc = "I2C_SCL pin drive capability:; 000: IO2_ level 1; 001: IO2_ level 2; 010: IO2_ level 3; 011: IO2_ level 4"; sw = rw; hw = r; reset = 0x3; } drive[6:4];
    } padctrl_reg6 @ 0x818;
    reg {
        name = "padctrl_reg7";
        desc = "UART0_RXD pin drive capability register (UART0_RXD, ball W10). Offset 0x81C, default 0x2B0. PROVEN: pin-out workbook sheet 4.";
        field { name = "pull_down_en"; desc = "Pull-down resistor enable: 0 disabled, 1 enabled"; sw = rw; hw = r; reset = 0x0; } pull_down_en[8:8];
        field { name = "slew"; desc = "Level conversion speed: 0 fast edge, 1 slow edge"; sw = rw; hw = r; reset = 0x1; } slew[7:7];
        field { name = "drive"; desc = "UART0_RXD pin drive capability:; 000: IO2_ level 1; 001: IO2_ level 2; 010: IO2_ level 3; 011: IO2_ level 4"; sw = rw; hw = r; reset = 0x3; } drive[6:4];
    } padctrl_reg7 @ 0x81C;
    reg {
        name = "padctrl_reg8";
        desc = "UART0_TXD pin drive capability register (UART0_TXD, ball Y10). Offset 0x820, default 0xB0. PROVEN: pin-out workbook sheet 4.";
        field { name = "pull_down_en"; desc = "Pull-down resistor enable: 0 disabled, 1 enabled"; sw = rw; hw = r; reset = 0x0; } pull_down_en[8:8];
        field { name = "slew"; desc = "Level conversion speed: 0 fast edge, 1 slow edge"; sw = rw; hw = r; reset = 0x1; } slew[7:7];
        field { name = "drive"; desc = "UART0_TXD pin drive capability:; 000: IO2_ level 1; 001: IO2_ level 2; 010: IO2_ level 3; 011: IO2_ level 4"; sw = rw; hw = r; reset = 0x3; } drive[6:4];
    } padctrl_reg8 @ 0x820;
    reg {
        name = "padctrl_reg9";
        desc = "UART1_RXD pin drive capability register (UART1_RXD, ball A4). Offset 0x824, default 0x2B0. PROVEN: pin-out workbook sheet 4.";
        field { name = "pull_down_en"; desc = "Pull-down resistor enable: 0 disabled, 1 enabled"; sw = rw; hw = r; reset = 0x0; } pull_down_en[8:8];
        field { name = "slew"; desc = "Level conversion speed: 0 fast edge, 1 slow edge"; sw = rw; hw = r; reset = 0x1; } slew[7:7];
        field { name = "drive"; desc = "UART1_RXD pin drive capability:; 000: IO2_ level 1; 001: IO2_ level 2; 010: IO2_ level 3; 011: IO2_ level 4"; sw = rw; hw = r; reset = 0x3; } drive[6:4];
    } padctrl_reg9 @ 0x824;
    reg {
        name = "padctrl_reg10";
        desc = "UART1_TXD pin drive capability register (UART1_TXD, ball B5). Offset 0x828, default 0xB0. PROVEN: pin-out workbook sheet 4.";
        field { name = "pull_down_en"; desc = "Pull-down resistor enable: 0 disabled, 1 enabled"; sw = rw; hw = r; reset = 0x0; } pull_down_en[8:8];
        field { name = "slew"; desc = "Level conversion speed: 0 fast edge, 1 slow edge"; sw = rw; hw = r; reset = 0x1; } slew[7:7];
        field { name = "drive"; desc = "UART1_TXD pin drive capability:; 000: IO2_ level 1; 001: IO2_ level 2; 010: IO2_ level 3; 011: IO2_ level 4"; sw = rw; hw = r; reset = 0x3; } drive[6:4];
    } padctrl_reg10 @ 0x828;
    reg {
        name = "padctrl_reg11";
        desc = "UART1_RTSN pin drive capability register (UART1_RTSN, ball B6). Offset 0x82C, default 0xB0. PROVEN: pin-out workbook sheet 4.";
        field { name = "pull_down_en"; desc = "Pull-down resistor enable: 0 disabled, 1 enabled"; sw = rw; hw = r; reset = 0x0; } pull_down_en[8:8];
        field { name = "slew"; desc = "Level conversion speed: 0 fast edge, 1 slow edge"; sw = rw; hw = r; reset = 0x1; } slew[7:7];
        field { name = "drive"; desc = "UART1_RTSN pin drive capability:; 000: IO2_ level 1; 001: IO2_ level 2; 010: IO2_ level 3; 011: IO2_ level 4"; sw = rw; hw = r; reset = 0x3; } drive[6:4];
    } padctrl_reg11 @ 0x82C;
    reg {
        name = "padctrl_reg12";
        desc = "UART1_CTSN pin drive capability register (UART1_CTSN, ball A5). Offset 0x830, default 0xB0. PROVEN: pin-out workbook sheet 4.";
        field { name = "pull_down_en"; desc = "Pull-down resistor enable: 0 disabled, 1 enabled"; sw = rw; hw = r; reset = 0x0; } pull_down_en[8:8];
        field { name = "slew"; desc = "Level conversion speed: 0 fast edge, 1 slow edge"; sw = rw; hw = r; reset = 0x1; } slew[7:7];
        field { name = "drive"; desc = "UART1_CTSN pin drive capability:; 000: IO2_ level 1; 001: IO2_ level 2; 010: IO2_ level 3; 011: IO2_ level 4"; sw = rw; hw = r; reset = 0x3; } drive[6:4];
    } padctrl_reg12 @ 0x830;
    reg {
        name = "padctrl_reg13";
        desc = "UART2_RXD pin drive capability register (UART2_RXD, ball U7). Offset 0x834, default 0x2B0. PROVEN: pin-out workbook sheet 4.";
        field { name = "pull_down_en"; desc = "Pull-down resistor enable: 0 disabled, 1 enabled"; sw = rw; hw = r; reset = 0x0; } pull_down_en[8:8];
        field { name = "slew"; desc = "Level conversion speed: 0 fast edge, 1 slow edge"; sw = rw; hw = r; reset = 0x1; } slew[7:7];
        field { name = "drive"; desc = "UART2_RXD pin drive capability:; 000: IO2_ level 1; 001: IO2_ level 2; 010: IO2_ level 3; 011: IO2_ level 4"; sw = rw; hw = r; reset = 0x3; } drive[6:4];
    } padctrl_reg13 @ 0x834;
    reg {
        name = "padctrl_reg14";
        desc = "UART2_TXD pin drive capability register (UART2_TXD, ball U6). Offset 0x838, default 0xB0. PROVEN: pin-out workbook sheet 4.";
        field { name = "pull_down_en"; desc = "Pull-down resistor enable: 0 disabled, 1 enabled"; sw = rw; hw = r; reset = 0x0; } pull_down_en[8:8];
        field { name = "slew"; desc = "Level conversion speed: 0 fast edge, 1 slow edge"; sw = rw; hw = r; reset = 0x1; } slew[7:7];
        field { name = "drive"; desc = "UART2_TXD pin drive capability:; 000: IO2_ level 1; 001: IO2_ level 2; 010: IO2_ level 3; 011: IO2_ level 4"; sw = rw; hw = r; reset = 0x3; } drive[6:4];
    } padctrl_reg14 @ 0x838;
    reg {
        name = "padctrl_reg15";
        desc = "ETH_LINK_LED pin drive capability register (ETH_LINK_LED, ball H19). Offset 0x83C, default 0xB0. PROVEN: pin-out workbook sheet 4.";
        field { name = "pull_down_en"; desc = "Pull-down resistor enable: 0 disabled, 1 enabled"; sw = rw; hw = r; reset = 0x0; } pull_down_en[8:8];
        field { name = "slew"; desc = "Level conversion speed: 0 fast edge, 1 slow edge"; sw = rw; hw = r; reset = 0x1; } slew[7:7];
        field { name = "drive"; desc = "ETH_LINK_LED pin drive capability:; 000: IO2_ level 1; 001: IO2_ level 2; 010: IO2_ level 3; 011: IO2_ level 4"; sw = rw; hw = r; reset = 0x3; } drive[6:4];
    } padctrl_reg15 @ 0x83C;
    reg {
        name = "padctrl_reg16";
        desc = "ETH_SPD_LED pin drive capability register (ETH_SPD_LED, ball J20). Offset 0x840, default 0xB0. PROVEN: pin-out workbook sheet 4.";
        field { name = "pull_down_en"; desc = "Pull-down resistor enable: 0 disabled, 1 enabled"; sw = rw; hw = r; reset = 0x0; } pull_down_en[8:8];
        field { name = "slew"; desc = "Level conversion speed: 0 fast edge, 1 slow edge"; sw = rw; hw = r; reset = 0x1; } slew[7:7];
        field { name = "drive"; desc = "ETH_SPD_LED pin drive capability:; 000: IO2_ level 1; 001: IO2_ level 2; 010: IO2_ level 3; 011: IO2_ level 4"; sw = rw; hw = r; reset = 0x3; } drive[6:4];
    } padctrl_reg16 @ 0x840;
    reg {
        name = "padctrl_reg17";
        desc = "IR_IN pin drive capability register (IR_IN, ball W5). Offset 0x844, default 0x2B0. PROVEN: pin-out workbook sheet 4.";
        field { name = "pull_down_en"; desc = "Pull-down resistor enable: 0 disabled, 1 enabled"; sw = rw; hw = r; reset = 0x0; } pull_down_en[8:8];
        field { name = "slew"; desc = "Level conversion speed: 0 fast edge, 1 slow edge"; sw = rw; hw = r; reset = 0x1; } slew[7:7];
        field { name = "drive"; desc = "IR_IN pin drive capability:; 000: IO2_ level 1; 001: IO2_ level 2; 010: IO2_ level 3; 011: IO2_ level 4"; sw = rw; hw = r; reset = 0x3; } drive[6:4];
    } padctrl_reg17 @ 0x844;
    reg {
        name = "padctrl_reg18";
        desc = "SFC_MOSI_IO0 pin drive capability register (SFC_MOSI_IO0, ball W13). Offset 0x848, default 0xB0. PROVEN: pin-out workbook sheet 4.";
        field { name = "pull_down_en"; desc = "Pull-down resistor enable: 0 disabled, 1 enabled"; sw = rw; hw = r; reset = 0x0; } pull_down_en[8:8];
        field { name = "slew"; desc = "Level conversion speed: 0 fast edge, 1 slow edge"; sw = rw; hw = r; reset = 0x1; } slew[7:7];
        field { name = "drive"; desc = "SFC_MOSI_IO0 pin drive capability:; 000: IO2_ level 1; 001: IO2_ level 2; 010: IO2_ level 3; 011: IO2_ level 4"; sw = rw; hw = r; reset = 0x3; } drive[6:4];
    } padctrl_reg18 @ 0x848;
    reg {
        name = "padctrl_reg19";
        desc = "SFC_WP_IO2 pin drive capability register (SFC_WP_IO2, ball W11). Offset 0x84C, default 0xB0. PROVEN: pin-out workbook sheet 4.";
        field { name = "pull_down_en"; desc = "Pull-down resistor enable: 0 disabled, 1 enabled"; sw = rw; hw = r; reset = 0x0; } pull_down_en[8:8];
        field { name = "slew"; desc = "Level conversion speed: 0 fast edge, 1 slow edge"; sw = rw; hw = r; reset = 0x1; } slew[7:7];
        field { name = "drive"; desc = "SFC_WP_IO2 pin drive capability:; 000: IO2_ level 1; 001: IO2_ level 2; 010: IO2_ level 3; 011: IO2_ level 4"; sw = rw; hw = r; reset = 0x3; } drive[6:4];
    } padctrl_reg19 @ 0x84C;
    reg {
        name = "padctrl_reg20";
        desc = "SFC_CLK pin drive capability register (SFC_CLK, ball V13). Offset 0x850, default 0x1E0. PROVEN: pin-out workbook sheet 4.";
        field { name = "pull_down_en"; desc = "Pull-down resistor enable: 0 disabled, 1 enabled"; sw = rw; hw = r; reset = 0x1; } pull_down_en[8:8];
        field { name = "slew"; desc = "Level conversion speed: 0 fast edge, 1 slow edge"; sw = rw; hw = r; reset = 0x1; } slew[7:7];
        field { name = "drive"; desc = "SFC_CLK pin drive capability:; 000: IO4_ level 8; 001: IO4_ level 7; 010: IO4_ level 6; 011: IO4_ level 5; 100: IO4_ level 4; 101: IO4_ level 3; 110: IO4_ level 2; 111: IO4_ level 1"; sw = rw; hw = r; reset = 0x6; } drive[6:4];
    } padctrl_reg20 @ 0x850;
    reg {
        name = "padctrl_reg21";
        desc = "SFC_MISO_IO1 pin drive capability register (SFC_MISO_IO1, ball U11). Offset 0x854, default 0xB0. PROVEN: pin-out workbook sheet 4.";
        field { name = "pull_down_en"; desc = "Pull-down resistor enable: 0 disabled, 1 enabled"; sw = rw; hw = r; reset = 0x0; } pull_down_en[8:8];
        field { name = "slew"; desc = "Level conversion speed: 0 fast edge, 1 slow edge"; sw = rw; hw = r; reset = 0x1; } slew[7:7];
        field { name = "drive"; desc = "SFC_MISO_IO1 pin drive capability:; 000: IO2_ level 1; 001: IO2_ level 2; 010: IO2_ level 3; 011: IO2_ level 4"; sw = rw; hw = r; reset = 0x3; } drive[6:4];
    } padctrl_reg21 @ 0x854;
    reg {
        name = "padctrl_reg22";
        desc = "SFC_HOLD_IO3 pin drive capability register (SFC_HOLD_IO3, ball W12). Offset 0x858, default 0xB0. PROVEN: pin-out workbook sheet 4.";
        field { name = "pull_down_en"; desc = "Pull-down resistor enable: 0 disabled, 1 enabled"; sw = rw; hw = r; reset = 0x0; } pull_down_en[8:8];
        field { name = "slew"; desc = "Level conversion speed: 0 fast edge, 1 slow edge"; sw = rw; hw = r; reset = 0x1; } slew[7:7];
        field { name = "drive"; desc = "SFC_HOLD_IO3 pin drive capability:; 000: IO2_ level 1; 001: IO2_ level 2; 010: IO2_ level 3; 011: IO2_ level 4"; sw = rw; hw = r; reset = 0x3; } drive[6:4];
    } padctrl_reg22 @ 0x858;
    reg {
        name = "padctrl_reg23";
        desc = "SFC_CS0N pin drive capability register (SFC_CS0N, ball Y12). Offset 0x85C, default 0xB0. PROVEN: pin-out workbook sheet 4.";
        field { name = "pull_down_en"; desc = "Pull-down resistor enable: 0 disabled, 1 enabled"; sw = rw; hw = r; reset = 0x0; } pull_down_en[8:8];
        field { name = "slew"; desc = "Level conversion speed: 0 fast edge, 1 slow edge"; sw = rw; hw = r; reset = 0x1; } slew[7:7];
        field { name = "drive"; desc = "SFC_CS0N pin drive capability:; 000: IO2_ level 1; 001: IO2_ level 2; 010: IO2_ level 3; 011: IO2_ level 4"; sw = rw; hw = r; reset = 0x3; } drive[6:4];
    } padctrl_reg23 @ 0x85C;
    reg {
        name = "padctrl_reg24";
        desc = "SFC_CS1N pin drive capability register (SFC_CS1N, ball U12). Offset 0x860, default 0xB0. PROVEN: pin-out workbook sheet 4.";
        field { name = "pull_down_en"; desc = "Pull-down resistor enable: 0 disabled, 1 enabled"; sw = rw; hw = r; reset = 0x0; } pull_down_en[8:8];
        field { name = "slew"; desc = "Level conversion speed: 0 fast edge, 1 slow edge"; sw = rw; hw = r; reset = 0x1; } slew[7:7];
        field { name = "drive"; desc = "SFC_CS1N pin drive capability:; 000: IO2_ level 1; 001: IO2_ level 2; 010: IO2_ level 3; 011: IO2_ level 4"; sw = rw; hw = r; reset = 0x3; } drive[6:4];
    } padctrl_reg24 @ 0x860;
    reg {
        name = "padctrl_reg25";
        desc = "JTAG_EN pin drive capability register (JTAG_EN, ball V5). Offset 0x864, default 0x1B0. PROVEN: pin-out workbook sheet 4.";
        field { name = "pull_down_en"; desc = "Pull-down resistor enable: 0 disabled, 1 enabled"; sw = rw; hw = r; reset = 0x1; } pull_down_en[8:8];
        field { name = "slew"; desc = "Level conversion speed: 0 fast edge, 1 slow edge"; sw = rw; hw = r; reset = 0x1; } slew[7:7];
        field { name = "drive"; desc = "JTAG_EN pin drive capability:; 000: IO2_ level 1; 001: IO2_ level 2; 010: IO2_ level 3; 011: IO2_ level 4"; sw = rw; hw = r; reset = 0x3; } drive[6:4];
    } padctrl_reg25 @ 0x864;
    reg {
        name = "padctrl_reg26";
        desc = "JTAG_TRSTN pin drive capability register (JTAG_TRSTN, ball V6). Offset 0x868, default 0x1B0. PROVEN: pin-out workbook sheet 4.";
        field { name = "pull_down_en"; desc = "Pull-down resistor enable: 0 disabled, 1 enabled"; sw = rw; hw = r; reset = 0x1; } pull_down_en[8:8];
        field { name = "slew"; desc = "Level conversion speed: 0 fast edge, 1 slow edge"; sw = rw; hw = r; reset = 0x1; } slew[7:7];
        field { name = "drive"; desc = "JTAG_TRSTN pin drive capability:; 000: IO2_ level 1; 001: IO2_ level 2; 010: IO2_ level 3; 011: IO2_ level 4"; sw = rw; hw = r; reset = 0x3; } drive[6:4];
    } padctrl_reg26 @ 0x868;
    reg {
        name = "padctrl_reg27";
        desc = "JTAG_TCK pin drive capability register (JTAG_TCK, ball V7). Offset 0x86C, default 0x1B0. PROVEN: pin-out workbook sheet 4.";
        field { name = "pull_down_en"; desc = "Pull-down resistor enable: 0 disabled, 1 enabled"; sw = rw; hw = r; reset = 0x1; } pull_down_en[8:8];
        field { name = "slew"; desc = "Level conversion speed: 0 fast edge, 1 slow edge"; sw = rw; hw = r; reset = 0x1; } slew[7:7];
        field { name = "drive"; desc = "JTAG_TCK pin drive capability:; 000: IO2_ level 1; 001: IO2_ level 2; 010: IO2_ level 3; 011: IO2_ level 4"; sw = rw; hw = r; reset = 0x3; } drive[6:4];
    } padctrl_reg27 @ 0x86C;
    reg {
        name = "padctrl_reg28";
        desc = "JTAG_TMS pin drive capability register (JTAG_TMS, ball Y6). Offset 0x870, default 0x2B0. PROVEN: pin-out workbook sheet 4.";
        field { name = "pull_down_en"; desc = "Pull-down resistor enable: 0 disabled, 1 enabled"; sw = rw; hw = r; reset = 0x0; } pull_down_en[8:8];
        field { name = "slew"; desc = "Level conversion speed: 0 fast edge, 1 slow edge"; sw = rw; hw = r; reset = 0x1; } slew[7:7];
        field { name = "drive"; desc = "JTAG_TMS pin drive capability:; 000: IO2_ level 1; 001: IO2_ level 2; 010: IO2_ level 3; 011: IO2_ level 4"; sw = rw; hw = r; reset = 0x3; } drive[6:4];
    } padctrl_reg28 @ 0x870;
    reg {
        name = "padctrl_reg29";
        desc = "JTAG_TDO pin drive capability register (JTAG_TDO, ball W7). Offset 0x874, default 0xB0. PROVEN: pin-out workbook sheet 4.";
        field { name = "pull_down_en"; desc = "Pull-down resistor enable: 0 disabled, 1 enabled"; sw = rw; hw = r; reset = 0x0; } pull_down_en[8:8];
        field { name = "slew"; desc = "Level conversion speed: 0 fast edge, 1 slow edge"; sw = rw; hw = r; reset = 0x1; } slew[7:7];
        field { name = "drive"; desc = "JTAG_TDO pin drive capability:; 000: IO2_ level 1; 001: IO2_ level 2; 010: IO2_ level 3; 011: IO2_ level 4"; sw = rw; hw = r; reset = 0x3; } drive[6:4];
    } padctrl_reg29 @ 0x874;
    reg {
        name = "padctrl_reg30";
        desc = "JTAG_TDI pin drive capability register (JTAG_TDI, ball W6). Offset 0x878, default 0x2B0. PROVEN: pin-out workbook sheet 4.";
        field { name = "pull_down_en"; desc = "Pull-down resistor enable: 0 disabled, 1 enabled"; sw = rw; hw = r; reset = 0x0; } pull_down_en[8:8];
        field { name = "slew"; desc = "Level conversion speed: 0 fast edge, 1 slow edge"; sw = rw; hw = r; reset = 0x1; } slew[7:7];
        field { name = "drive"; desc = "JTAG_TDI pin drive capability:; 000: IO2_ level 1; 001: IO2_ level 2; 010: IO2_ level 3; 011: IO2_ level 4"; sw = rw; hw = r; reset = 0x3; } drive[6:4];
    } padctrl_reg30 @ 0x878;
    reg {
        name = "padctrl_reg31";
        desc = "RSTN pin drive capability register (RSTN, ball V12). Offset 0x87C, default 0x2B0. PROVEN: pin-out workbook sheet 4.";
        field { name = "pull_down_en"; desc = "Pull-down resistor enable: 0 disabled, 1 enabled"; sw = rw; hw = r; reset = 0x0; } pull_down_en[8:8];
        field { name = "slew"; desc = "Level conversion speed: 0 fast edge, 1 slow edge"; sw = rw; hw = r; reset = 0x1; } slew[7:7];
        field { name = "drive"; desc = "RSTN pin drive capability:; 000: IO2_ level 1; 001: IO2_ level 2; 010: IO2_ level 3; 011: IO2_ level 4"; sw = rw; hw = r; reset = 0x3; } drive[6:4];
    } padctrl_reg31 @ 0x87C;
    reg {
        name = "padctrl_reg32";
        desc = "WDG_RSTN pin drive capability register (WDG_RSTN, ball V11). Offset 0x880, default 0xB0. PROVEN: pin-out workbook sheet 4.";
        field { name = "pull_down_en"; desc = "Pull-down resistor enable: 0 disabled, 1 enabled"; sw = rw; hw = r; reset = 0x0; } pull_down_en[8:8];
        field { name = "slew"; desc = "Level conversion speed: 0 fast edge, 1 slow edge"; sw = rw; hw = r; reset = 0x1; } slew[7:7];
        field { name = "drive"; desc = "WDG_RSTN pin drive capability:; 000: IO2_ level 1; 001: IO2_ level 2; 010: IO2_ level 3; 011: IO2_ level 4"; sw = rw; hw = r; reset = 0x3; } drive[6:4];
    } padctrl_reg32 @ 0x880;
    reg {
        name = "padctrl_reg33";
        desc = "TEST_MODE pin drive capability register (TEST_MODE, ball V4). Offset 0x884, default 0x1B0. PROVEN: pin-out workbook sheet 4.";
        field { name = "pull_down_en"; desc = "Pull-down resistor enable: 0 disabled, 1 enabled"; sw = rw; hw = r; reset = 0x1; } pull_down_en[8:8];
        field { name = "slew"; desc = "Level conversion speed: 0 fast edge, 1 slow edge"; sw = rw; hw = r; reset = 0x1; } slew[7:7];
        field { name = "drive"; desc = "TEST_MODE pin drive capability:; 000: IO2_ level 1; 001: IO2_ level 2; 010: IO2_ level 3; 011: IO2_ level 4"; sw = rw; hw = r; reset = 0x3; } drive[6:4];
    } padctrl_reg33 @ 0x884;
    reg {
        name = "padctrl_reg34";
        desc = "POR_ENABLE pin drive capability register (POR_ENABLE, ball W4). Offset 0x888, default 0x1B0. PROVEN: pin-out workbook sheet 4.";
        field { name = "pull_down_en"; desc = "Pull-down resistor enable: 0 disabled, 1 enabled"; sw = rw; hw = r; reset = 0x1; } pull_down_en[8:8];
        field { name = "slew"; desc = "Level conversion speed: 0 fast edge, 1 slow edge"; sw = rw; hw = r; reset = 0x1; } slew[7:7];
        field { name = "drive"; desc = "POR_ENABLE pin drive capability:; 000: IO2_ level 1; 001: IO2_ level 2; 010: IO2_ level 3; 011: IO2_ level 4"; sw = rw; hw = r; reset = 0x3; } drive[6:4];
    } padctrl_reg34 @ 0x888;
    reg {
        name = "padctrl_reg35";
        desc = "USB2_PWREN0 pin drive capability register (USB2_PWREN0, ball C7). Offset 0x88C, default 0xB0. PROVEN: pin-out workbook sheet 4.";
        field { name = "pull_down_en"; desc = "Pull-down resistor enable: 0 disabled, 1 enabled"; sw = rw; hw = r; reset = 0x0; } pull_down_en[8:8];
        field { name = "slew"; desc = "Level conversion speed: 0 fast edge, 1 slow edge"; sw = rw; hw = r; reset = 0x1; } slew[7:7];
        field { name = "drive"; desc = "USB2_PWREN0 pin drive capability:; 000: IO2_ level 1; 001: IO2_ level 2; 010: IO2_ level 3; 011: IO2_ level 4"; sw = rw; hw = r; reset = 0x3; } drive[6:4];
    } padctrl_reg35 @ 0x88C;
    reg {
        name = "padctrl_reg36";
        desc = "USB2_PWREN1 pin drive capability register (USB2_PWREN1, ball B7). Offset 0x890, default 0xB0. PROVEN: pin-out workbook sheet 4.";
        field { name = "pull_down_en"; desc = "Pull-down resistor enable: 0 disabled, 1 enabled"; sw = rw; hw = r; reset = 0x0; } pull_down_en[8:8];
        field { name = "slew"; desc = "Level conversion speed: 0 fast edge, 1 slow edge"; sw = rw; hw = r; reset = 0x1; } slew[7:7];
        field { name = "drive"; desc = "USB2_PWREN1 pin drive capability:; 000: IO2_ level 1; 001: IO2_ level 2; 010: IO2_ level 3; 011: IO2_ level 4"; sw = rw; hw = r; reset = 0x3; } drive[6:4];
    } padctrl_reg36 @ 0x890;
    reg {
        name = "padctrl_reg37";
        desc = "HDMI_HOTPLUG pin drive capability register (HDMI_HOTPLUG, ball C15). Offset 0x894, default 0xB0. PROVEN: pin-out workbook sheet 4.";
        field { name = "pull_down_en"; desc = "Pull-down resistor enable: 0 disabled, 1 enabled"; sw = rw; hw = r; reset = 0x0; } pull_down_en[8:8];
        field { name = "slew"; desc = "Level conversion speed: 0 fast edge, 1 slow edge"; sw = rw; hw = r; reset = 0x1; } slew[7:7];
        field { name = "drive"; desc = "HDMI_HOTPLUG pin drive capability:; 000: IO2_ level 1; 001: IO2_ level 2; 010: IO2_ level 3; 011: IO2_ level 4"; sw = rw; hw = r; reset = 0x3; } drive[6:4];
    } padctrl_reg37 @ 0x894;
    reg {
        name = "padctrl_reg38";
        desc = "HDMI_SDA pin drive capability register (HDMI_SDA, ball C16). Offset 0x898, default 0xB0. PROVEN: pin-out workbook sheet 4.";
        field { name = "pull_down_en"; desc = "Pull-down resistor enable: 0 disabled, 1 enabled"; sw = rw; hw = r; reset = 0x0; } pull_down_en[8:8];
        field { name = "slew"; desc = "Level conversion speed: 0 fast edge, 1 slow edge"; sw = rw; hw = r; reset = 0x1; } slew[7:7];
        field { name = "drive"; desc = "HDMI_SDA pin drive capability:; 000: IO2_ level 1; 001: IO2_ level 2; 010: IO2_ level 3; 011: IO2_ level 4"; sw = rw; hw = r; reset = 0x3; } drive[6:4];
    } padctrl_reg38 @ 0x898;
    reg {
        name = "padctrl_reg39";
        desc = "HDMI_SCL pin drive capability register (HDMI_SCL, ball B16). Offset 0x89C, default 0xB0. PROVEN: pin-out workbook sheet 4.";
        field { name = "pull_down_en"; desc = "Pull-down resistor enable: 0 disabled, 1 enabled"; sw = rw; hw = r; reset = 0x0; } pull_down_en[8:8];
        field { name = "slew"; desc = "Level conversion speed: 0 fast edge, 1 slow edge"; sw = rw; hw = r; reset = 0x1; } slew[7:7];
        field { name = "drive"; desc = "HDMI_SCL pin drive capability:; 000: IO2_ level 1; 001: IO2_ level 2; 010: IO2_ level 3; 011: IO2_ level 4"; sw = rw; hw = r; reset = 0x3; } drive[6:4];
    } padctrl_reg39 @ 0x89C;
    reg {
        name = "padctrl_reg40";
        desc = "SATA_LED_N pin drive capability register (SATA_LED_N, ball U14). Offset 0x8A0, default 0xB0. PROVEN: pin-out workbook sheet 4.";
        field { name = "pull_down_en"; desc = "Pull-down resistor enable: 0 disabled, 1 enabled"; sw = rw; hw = r; reset = 0x0; } pull_down_en[8:8];
        field { name = "slew"; desc = "Level conversion speed: 0 fast edge, 1 slow edge"; sw = rw; hw = r; reset = 0x1; } slew[7:7];
        field { name = "drive"; desc = "SATA_LED_N pin drive capability:; 000: IO2_ level 1; 001: IO2_ level 2; 010: IO2_ level 3; 011: IO2_ level 4"; sw = rw; hw = r; reset = 0x3; } drive[6:4];
    } padctrl_reg40 @ 0x8A0;
    reg {
        name = "padctrl_reg41";
        desc = "GPIO3_7 pin drive capability register (GPIO3_7, ball U13). Offset 0x8A4, default 0x1B0. PROVEN: pin-out workbook sheet 4.";
        field { name = "pull_down_en"; desc = "Pull-down resistor enable: 0 disabled, 1 enabled"; sw = rw; hw = r; reset = 0x1; } pull_down_en[8:8];
        field { name = "slew"; desc = "Level conversion speed: 0 fast edge, 1 slow edge"; sw = rw; hw = r; reset = 0x1; } slew[7:7];
        field { name = "drive"; desc = "GPIO3_7 pin drive capability:; 000: IO2_ level 1; 001: IO2_ level 2; 010: IO2_ level 3; 011: IO2_ level 4"; sw = rw; hw = r; reset = 0x3; } drive[6:4];
    } padctrl_reg41 @ 0x8A4;
    reg {
        name = "padctrl_reg42";
        desc = "GPIO0_0 pin drive capability register (GPIO0_0, ball N19). Offset 0x8A8, default 0xB0. PROVEN: pin-out workbook sheet 4.";
        field { name = "pull_down_en"; desc = "Pull-down resistor enable: 0 disabled, 1 enabled"; sw = rw; hw = r; reset = 0x0; } pull_down_en[8:8];
        field { name = "slew"; desc = "Level conversion speed: 0 fast edge, 1 slow edge"; sw = rw; hw = r; reset = 0x1; } slew[7:7];
        field { name = "drive"; desc = "GPIO0_0 pin drive capability:; 000: IO2_ level 1; 001: IO2_ level 2; 010: IO2_ level 3; 011: IO2_ level 4"; sw = rw; hw = r; reset = 0x3; } drive[6:4];
    } padctrl_reg42 @ 0x8A8;
    reg {
        name = "padctrl_reg43";
        desc = "GPIO0_1 pin drive capability register (GPIO0_1, ball R19). Offset 0x8AC, default 0xB0. PROVEN: pin-out workbook sheet 4.";
        field { name = "pull_down_en"; desc = "Pull-down resistor enable: 0 disabled, 1 enabled"; sw = rw; hw = r; reset = 0x0; } pull_down_en[8:8];
        field { name = "slew"; desc = "Level conversion speed: 0 fast edge, 1 slow edge"; sw = rw; hw = r; reset = 0x1; } slew[7:7];
        field { name = "drive"; desc = "GPIO0_1 pin drive capability:; 000: IO2_ level 1; 001: IO2_ level 2; 010: IO2_ level 3; 011: IO2_ level 4"; sw = rw; hw = r; reset = 0x3; } drive[6:4];
    } padctrl_reg43 @ 0x8AC;
    reg {
        name = "padctrl_reg44";
        desc = "GPIO0_2 pin drive capability register (GPIO0_2, ball P18). Offset 0x8B0, default 0xB0. PROVEN: pin-out workbook sheet 4.";
        field { name = "pull_down_en"; desc = "Pull-down resistor enable: 0 disabled, 1 enabled"; sw = rw; hw = r; reset = 0x0; } pull_down_en[8:8];
        field { name = "slew"; desc = "Level conversion speed: 0 fast edge, 1 slow edge"; sw = rw; hw = r; reset = 0x1; } slew[7:7];
        field { name = "drive"; desc = "GPIO0_2 pin drive capability:; 000: IO2_ level 1; 001: IO2_ level 2; 010: IO2_ level 3; 011: IO2_ level 4"; sw = rw; hw = r; reset = 0x3; } drive[6:4];
    } padctrl_reg44 @ 0x8B0;
    reg {
        name = "padctrl_reg45";
        desc = "GPIO0_3 pin drive capability register (GPIO0_3, ball P19). Offset 0x8B4, default 0xB0. PROVEN: pin-out workbook sheet 4.";
        field { name = "pull_down_en"; desc = "Pull-down resistor enable: 0 disabled, 1 enabled"; sw = rw; hw = r; reset = 0x0; } pull_down_en[8:8];
        field { name = "slew"; desc = "Level conversion speed: 0 fast edge, 1 slow edge"; sw = rw; hw = r; reset = 0x1; } slew[7:7];
        field { name = "drive"; desc = "GPIO0_3 pin drive capability:; 000: IO2_ level 1; 001: IO2_ level 2; 010: IO2_ level 3; 011: IO2_ level 4"; sw = rw; hw = r; reset = 0x3; } drive[6:4];
    } padctrl_reg45 @ 0x8B4;
    reg {
        name = "padctrl_reg46";
        desc = "GPIO0_4 pin drive capability register (GPIO0_4, ball P20). Offset 0x8B8, default 0xB0. PROVEN: pin-out workbook sheet 4.";
        field { name = "pull_down_en"; desc = "Pull-down resistor enable: 0 disabled, 1 enabled"; sw = rw; hw = r; reset = 0x0; } pull_down_en[8:8];
        field { name = "slew"; desc = "Level conversion speed: 0 fast edge, 1 slow edge"; sw = rw; hw = r; reset = 0x1; } slew[7:7];
        field { name = "drive"; desc = "GPIO0_4 pin drive capability:; 000: IO2_ level 1; 001: IO2_ level 2; 010: IO2_ level 3; 011: IO2_ level 4"; sw = rw; hw = r; reset = 0x3; } drive[6:4];
    } padctrl_reg46 @ 0x8B8;
    reg {
        name = "padctrl_reg47";
        desc = "GPIO0_5 pin drive capability register (GPIO0_5, ball R18). Offset 0x8BC, default 0xF0. PROVEN: pin-out workbook sheet 4.";
        field { name = "pull_down_en"; desc = "Pull-down resistor enable: 0 disabled, 1 enabled"; sw = rw; hw = r; reset = 0x0; } pull_down_en[8:8];
        field { name = "slew"; desc = "Level conversion speed: 0 fast edge, 1 slow edge"; sw = rw; hw = r; reset = 0x1; } slew[7:7];
        field { name = "drive"; desc = "GPIO0_5 pin drive capability:; 000: IO6_ level 8; 001: IO6_ level 7; 010: IO6_ level 6; 011: IO6_ level 5; 100: IO6_ level 4; 101: IO6_ level 3; 110: IO6_ level 2; 111: IO6_ level 1"; sw = rw; hw = r; reset = 0x7; } drive[6:4];
    } padctrl_reg47 @ 0x8BC;
    reg {
        name = "padctrl_reg48";
        desc = "GPIO0_6 pin drive capability register (GPIO0_6, ball V20). Offset 0x8C0, default 0xB0. PROVEN: pin-out workbook sheet 4.";
        field { name = "pull_down_en"; desc = "Pull-down resistor enable: 0 disabled, 1 enabled"; sw = rw; hw = r; reset = 0x0; } pull_down_en[8:8];
        field { name = "slew"; desc = "Level conversion speed: 0 fast edge, 1 slow edge"; sw = rw; hw = r; reset = 0x1; } slew[7:7];
        field { name = "drive"; desc = "GPIO0_6 pin drive capability:; 000: IO2_ level 1; 001: IO2_ level 2; 010: IO2_ level 3; 011: IO2_ level 4"; sw = rw; hw = r; reset = 0x3; } drive[6:4];
    } padctrl_reg48 @ 0x8C0;
    reg {
        name = "padctrl_reg49";
        desc = "GPIO0_7 pin drive capability register (GPIO0_7, ball U18). Offset 0x8C4, default 0xB0. PROVEN: pin-out workbook sheet 4.";
        field { name = "pull_down_en"; desc = "Pull-down resistor enable: 0 disabled, 1 enabled"; sw = rw; hw = r; reset = 0x0; } pull_down_en[8:8];
        field { name = "slew"; desc = "Level conversion speed: 0 fast edge, 1 slow edge"; sw = rw; hw = r; reset = 0x1; } slew[7:7];
        field { name = "drive"; desc = "GPIO0_7 pin drive capability:; 000: IO2_ level 1; 001: IO2_ level 2; 010: IO2_ level 3; 011: IO2_ level 4"; sw = rw; hw = r; reset = 0x3; } drive[6:4];
    } padctrl_reg49 @ 0x8C4;
    reg {
        name = "padctrl_reg50";
        desc = "GPIO1_0 pin drive capability register (GPIO1_0, ball U19). Offset 0x8C8, default 0xB0. PROVEN: pin-out workbook sheet 4.";
        field { name = "pull_down_en"; desc = "Pull-down resistor enable: 0 disabled, 1 enabled"; sw = rw; hw = r; reset = 0x0; } pull_down_en[8:8];
        field { name = "slew"; desc = "Level conversion speed: 0 fast edge, 1 slow edge"; sw = rw; hw = r; reset = 0x1; } slew[7:7];
        field { name = "drive"; desc = "GPIO1_0 pin drive capability:; 000: IO2_ level 1; 001: IO2_ level 2; 010: IO2_ level 3; 011: IO2_ level 4"; sw = rw; hw = r; reset = 0x3; } drive[6:4];
    } padctrl_reg50 @ 0x8C8;
    reg {
        name = "padctrl_reg51";
        desc = "GPIO1_1 pin drive capability register (GPIO1_1, ball T18). Offset 0x8CC, default 0xB0. PROVEN: pin-out workbook sheet 4.";
        field { name = "pull_down_en"; desc = "Pull-down resistor enable: 0 disabled, 1 enabled"; sw = rw; hw = r; reset = 0x0; } pull_down_en[8:8];
        field { name = "slew"; desc = "Level conversion speed: 0 fast edge, 1 slow edge"; sw = rw; hw = r; reset = 0x1; } slew[7:7];
        field { name = "drive"; desc = "GPIO1_1 pin drive capability:; 000: IO2_ level 1; 001: IO2_ level 2; 010: IO2_ level 3; 011: IO2_ level 4"; sw = rw; hw = r; reset = 0x3; } drive[6:4];
    } padctrl_reg51 @ 0x8CC;
    reg {
        name = "padctrl_reg52";
        desc = "GPIO1_2 pin drive capability register (GPIO1_2, ball T19). Offset 0x8D0, default 0xB0. PROVEN: pin-out workbook sheet 4.";
        field { name = "pull_down_en"; desc = "Pull-down resistor enable: 0 disabled, 1 enabled"; sw = rw; hw = r; reset = 0x0; } pull_down_en[8:8];
        field { name = "slew"; desc = "Level conversion speed: 0 fast edge, 1 slow edge"; sw = rw; hw = r; reset = 0x1; } slew[7:7];
        field { name = "drive"; desc = "GPIO1_2 pin drive capability:; 000: IO2_ level 1; 001: IO2_ level 2; 010: IO2_ level 3; 011: IO2_ level 4"; sw = rw; hw = r; reset = 0x3; } drive[6:4];
    } padctrl_reg52 @ 0x8D0;
    reg {
        name = "padctrl_reg53";
        desc = "GPIO1_3 pin drive capability register (GPIO1_3, ball T20). Offset 0x8D4, default 0xF0. PROVEN: pin-out workbook sheet 4.";
        field { name = "pull_down_en"; desc = "Pull-down resistor enable: 0 disabled, 1 enabled"; sw = rw; hw = r; reset = 0x0; } pull_down_en[8:8];
        field { name = "slew"; desc = "Level conversion speed: 0 fast edge, 1 slow edge"; sw = rw; hw = r; reset = 0x1; } slew[7:7];
        field { name = "drive"; desc = "GPIO1_3 pin drive capability:; 000: IO6_ level 8; 001: IO6_ level 7; 010: IO6_ level 6; 011: IO6_ level 5; 100: IO6_ level 4; 101: IO6_ level 3; 110: IO6_ level 2; 111: IO6_ level 1"; sw = rw; hw = r; reset = 0x7; } drive[6:4];
    } padctrl_reg53 @ 0x8D4;
    reg {
        name = "padctrl_reg54";
        desc = "GPIO1_4 pin drive capability register (GPIO1_4, ball Y19). Offset 0x8D8, default 0x1B0. PROVEN: pin-out workbook sheet 4.";
        field { name = "pull_down_en"; desc = "Pull-down resistor enable: 0 disabled, 1 enabled"; sw = rw; hw = r; reset = 0x1; } pull_down_en[8:8];
        field { name = "slew"; desc = "Level conversion speed: 0 fast edge, 1 slow edge"; sw = rw; hw = r; reset = 0x1; } slew[7:7];
        field { name = "drive"; desc = "GPIO1_4 pin drive capability:; 000: IO2_ level 1; 001: IO2_ level 2; 010: IO2_ level 3; 011: IO2_ level 4"; sw = rw; hw = r; reset = 0x3; } drive[6:4];
    } padctrl_reg54 @ 0x8D8;
    reg {
        name = "padctrl_reg55";
        desc = "GPIO1_5 pin drive capability register (GPIO1_5, ball V18). Offset 0x8DC, default 0x1B0. PROVEN: pin-out workbook sheet 4.";
        field { name = "pull_down_en"; desc = "Pull-down resistor enable: 0 disabled, 1 enabled"; sw = rw; hw = r; reset = 0x1; } pull_down_en[8:8];
        field { name = "slew"; desc = "Level conversion speed: 0 fast edge, 1 slow edge"; sw = rw; hw = r; reset = 0x1; } slew[7:7];
        field { name = "drive"; desc = "GPIO1_5 pin drive capability:; 000: IO2_ level 1; 001: IO2_ level 2; 010: IO2_ level 3; 011: IO2_ level 4"; sw = rw; hw = r; reset = 0x3; } drive[6:4];
    } padctrl_reg55 @ 0x8DC;
    reg {
        name = "padctrl_reg56";
        desc = "GPIO1_6 pin drive capability register (GPIO1_6, ball V17). Offset 0x8E0, default 0x1B0. PROVEN: pin-out workbook sheet 4.";
        field { name = "pull_down_en"; desc = "Pull-down resistor enable: 0 disabled, 1 enabled"; sw = rw; hw = r; reset = 0x1; } pull_down_en[8:8];
        field { name = "slew"; desc = "Level conversion speed: 0 fast edge, 1 slow edge"; sw = rw; hw = r; reset = 0x1; } slew[7:7];
        field { name = "drive"; desc = "GPIO1_6 pin drive capability:; 000: IO2_ level 1; 001: IO2_ level 2; 010: IO2_ level 3; 011: IO2_ level 4"; sw = rw; hw = r; reset = 0x3; } drive[6:4];
    } padctrl_reg56 @ 0x8E0;
    reg {
        name = "padctrl_reg57";
        desc = "GPIO1_7 pin drive capability register (GPIO1_7, ball W17). Offset 0x8E4, default 0xB0. PROVEN: pin-out workbook sheet 4.";
        field { name = "pull_down_en"; desc = "Pull-down resistor enable: 0 disabled, 1 enabled"; sw = rw; hw = r; reset = 0x0; } pull_down_en[8:8];
        field { name = "slew"; desc = "Level conversion speed: 0 fast edge, 1 slow edge"; sw = rw; hw = r; reset = 0x1; } slew[7:7];
        field { name = "drive"; desc = "GPIO1_7 pin drive capability:; 000: IO2_ level 1; 001: IO2_ level 2; 010: IO2_ level 3; 011: IO2_ level 4"; sw = rw; hw = r; reset = 0x3; } drive[6:4];
    } padctrl_reg57 @ 0x8E4;
    reg {
        name = "padctrl_reg58";
        desc = "GPIO2_0 pin drive capability register (GPIO2_0, ball W18). Offset 0x8E8, default 0xF0. PROVEN: pin-out workbook sheet 4.";
        field { name = "pull_down_en"; desc = "Pull-down resistor enable: 0 disabled, 1 enabled"; sw = rw; hw = r; reset = 0x0; } pull_down_en[8:8];
        field { name = "slew"; desc = "Level conversion speed: 0 fast edge, 1 slow edge"; sw = rw; hw = r; reset = 0x1; } slew[7:7];
        field { name = "drive"; desc = "GPIO2_0 pin drive capability:; 000: IO6_ level 8; 001: IO6_ level 7; 010: IO6_ level 6; 011: IO6_ level 5; 100: IO6_ level 4; 101: IO6_ level 3; 110: IO6_ level 2; 111: IO6_ level 1"; sw = rw; hw = r; reset = 0x7; } drive[6:4];
    } padctrl_reg58 @ 0x8E8;
    reg {
        name = "padctrl_reg59";
        desc = "GPIO2_1 pin drive capability register (GPIO2_1, ball V19). Offset 0x8EC, default 0xB0. PROVEN: pin-out workbook sheet 4.";
        field { name = "pull_down_en"; desc = "Pull-down resistor enable: 0 disabled, 1 enabled"; sw = rw; hw = r; reset = 0x0; } pull_down_en[8:8];
        field { name = "slew"; desc = "Level conversion speed: 0 fast edge, 1 slow edge"; sw = rw; hw = r; reset = 0x1; } slew[7:7];
        field { name = "drive"; desc = "GPIO2_1 pin drive capability:; 000: IO2_ level 1; 001: IO2_ level 2; 010: IO2_ level 3; 011: IO2_ level 4"; sw = rw; hw = r; reset = 0x3; } drive[6:4];
    } padctrl_reg59 @ 0x8EC;
    reg {
        name = "padctrl_reg60";
        desc = "MDCK pin drive capability register (MDCK, ball W20). Offset 0x8F0, default 0x1B0. PROVEN: pin-out workbook sheet 4.";
        field { name = "pull_down_en"; desc = "Pull-down resistor enable: 0 disabled, 1 enabled"; sw = rw; hw = r; reset = 0x1; } pull_down_en[8:8];
        field { name = "slew"; desc = "Level conversion speed: 0 fast edge, 1 slow edge"; sw = rw; hw = r; reset = 0x1; } slew[7:7];
        field { name = "drive"; desc = "MDCK pin drive capability:; 000: IO2_ level 1; 001: IO2_ level 2; 010: IO2_ level 3; 011: IO2_ level 4"; sw = rw; hw = r; reset = 0x3; } drive[6:4];
    } padctrl_reg60 @ 0x8F0;
    reg {
        name = "padctrl_reg61";
        desc = "MDIO pin drive capability register (MDIO, ball W19). Offset 0x8F4, default 0xB0. PROVEN: pin-out workbook sheet 4.";
        field { name = "pull_down_en"; desc = "Pull-down resistor enable: 0 disabled, 1 enabled"; sw = rw; hw = r; reset = 0x0; } pull_down_en[8:8];
        field { name = "slew"; desc = "Level conversion speed: 0 fast edge, 1 slow edge"; sw = rw; hw = r; reset = 0x1; } slew[7:7];
        field { name = "drive"; desc = "MDIO pin drive capability:; 000: IO2_ level 1; 001: IO2_ level 2; 010: IO2_ level 3; 011: IO2_ level 4"; sw = rw; hw = r; reset = 0x3; } drive[6:4];
    } padctrl_reg61 @ 0x8F4;
};

`endif
