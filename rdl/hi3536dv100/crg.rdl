`ifndef HI3536D_CRG_RDL
`define HI3536D_CRG_RDL
regfile eHI3536D_CRG {
    name = "Clock and reset generator (CRG), Hi3536D V100";
    desc = "Clock and reset generator (CRG) of the Hi3536D V100 at base 0x12040000. 42 registers extracted programmatically from the Hi3536D V100 data sheet (Issue 00B04, 2017-12-13, Table 3-7, chapter 3.2), register descriptions and field tables; reset values are the data sheet total reset values split onto the fields. Source: dl/research-hi3536 ReleaseDoc (unofficial copy of the HiSilicon SDK documentation; facts only). Field names, bit ranges, access types and reset values are exact; the free-text descriptions are attributed to fields from the PDF text layout (title sentence above the bit row, enumerations below) and can be shifted by one field where a sentence wraps: check the data sheet page when a description matters. Hardware not yet verified (no Hi3536D board on the bench).";
    reg {
        name = "PERI_CRG0";
        desc = "PERI_CRG0 (offset 0x0, total reset 0x12000000; PROVEN: Hi3536D V100 data sheet).";
        field {
            name = "reserved_31_31";
            desc = "Reserved";
            sw = rw; hw = r;
            reset = 0x0;
        } reserved_31_31[31:31];
        field {
            name = "apll_postdiv2";
            desc = "Level-2 output divider of the APLL";
            sw = rw; hw = r;
            reset = 0x1;
        } apll_postdiv2[30:28];
        field {
            name = "reserved_27_27";
            desc = "Reserved";
            sw = rw; hw = r;
            reset = 0x0;
        } reserved_27_27[27:27];
        field {
            name = "apll_postdiv1";
            desc = "Level-1 output divider of the APLL";
            sw = rw; hw = r;
            reset = 0x2;
        } apll_postdiv1[26:24];
        field {
            name = "apll_frac";
            desc = "Decimal part of the APLL frequency multiplication coefficient";
            sw = rw; hw = r;
            reset = 0x0;
        } apll_frac[23:0];
    } PERI_CRG0 @ 0x0;
    reg {
        name = "PERI_CRG1";
        desc = "PERI_CRG_PLL1 is APLL configuration register 1. (offset 0x4, total reset 0x010030AF; PROVEN: Hi3536D V100 data sheet).";
        field {
            name = "reserved_31_27";
            desc = "Reserved";
            sw = rw; hw = r;
            reset = 0x0;
        } reserved_31_27[31:27];
        field {
            name = "apll_bypass";
            desc = "APLL clock frequency-division bypass control 0: not bypassed 1: bypassed";
            sw = rw; hw = r;
            reset = 0x0;
        } apll_bypass[26:26];
        field {
            name = "apll_dacpd";
            desc = "APLL test signal control 0: normal operating mode 1: power-down mode";
            sw = rw; hw = r;
            reset = 0x0;
        } apll_dacpd[25:25];
        field {
            name = "apll_dsmpd";
            desc = "APLL decimal frequency-division control 0: decimal frequency-division mode 1: integer frequency-division mode";
            sw = rw; hw = r;
            reset = 0x1;
        } apll_dsmpd[24:24];
        field {
            name = "apll_pd";
            desc = "APLL power-down control 0: normal operating mode 1: power-down mode";
            sw = rw; hw = r;
            reset = 0x0;
        } apll_pd[23:23];
        field {
            name = "apll_foutvcopd";
            desc = "Power-down control for the APLL VCO output 0: normal output clock 1: no output clock";
            sw = rw; hw = r;
            reset = 0x0;
        } apll_foutvcopd[22:22];
        field {
            name = "apll_postdivpd";
            desc = "Power-down control for the APLL POSTDIV output 0: normal output clock 1: no output clock";
            sw = rw; hw = r;
            reset = 0x0;
        } apll_postdivpd[21:21];
        field {
            name = "apll_fout4phasepd";
            desc = "Power-down control for the APLL FOUT output 0: normal output clock 1: no output clock";
            sw = rw; hw = r;
            reset = 0x0;
        } apll_fout4phasepd[20:20];
        field {
            name = "reserved_19_18";
            desc = "Reserved";
            sw = rw; hw = r;
            reset = 0x0;
        } reserved_19_18[19:18];
        field {
            name = "apll_refdiv";
            desc = "Divider of the APLL reference clock";
            sw = rw; hw = r;
            reset = 0x3;
        } apll_refdiv[17:12];
        field {
            name = "apll_fbdiv";
            desc = "Integral part of the APLL frequency multiplication coefficient";
            sw = rw; hw = r;
            reset = 0xaf;
        } apll_fbdiv[11:0];
    } PERI_CRG1 @ 0x4;
    reg {
        name = "PERI_CRG_PLL2";
        desc = "PERI_CRG_PLL2 is VPLL0 configuration register 0. (offset 0x8, total reset 0x12000000; PROVEN: Hi3536D V100 data sheet).";
        field {
            name = "reserved_31_31";
            desc = "Reserved";
            sw = rw; hw = r;
            reset = 0x0;
        } reserved_31_31[31:31];
        field {
            name = "vpll0_postdiv2";
            desc = "Level-2 output divider of VPLL0";
            sw = rw; hw = r;
            reset = 0x1;
        } vpll0_postdiv2[30:28];
        field {
            name = "reserved_27_27";
            desc = "Reserved";
            sw = rw; hw = r;
            reset = 0x0;
        } reserved_27_27[27:27];
        field {
            name = "vpll0_postdiv1";
            desc = "Level-1 output divider of VPLL0";
            sw = rw; hw = r;
            reset = 0x2;
        } vpll0_postdiv1[26:24];
        field {
            name = "vpll0_frac";
            desc = "Decimal part of the VPLL0 frequency multiplication coefficient";
            sw = rw; hw = r;
            reset = 0x0;
        } vpll0_frac[23:0];
    } PERI_CRG_PLL2 @ 0x8;
    reg {
        name = "PERI_CRG_PLL3";
        desc = "PERI_CRG_PLL3 is VPLL0 configuration register 1. (offset 0xC, total reset 0x01002063; PROVEN: Hi3536D V100 data sheet).";
        field {
            name = "reserved_31_27";
            desc = "Reserved";
            sw = rw; hw = r;
            reset = 0x0;
        } reserved_31_27[31:27];
        field {
            name = "vpll0_bypass";
            desc = "VPLL0 clock frequency-division bypass control 0: not bypassed 1: bypassed";
            sw = rw; hw = r;
            reset = 0x0;
        } vpll0_bypass[26:26];
        field {
            name = "vpll0_dacpd";
            desc = "VPLL0 test signal control 0: normal operating mode 1: power-down mode";
            sw = rw; hw = r;
            reset = 0x0;
        } vpll0_dacpd[25:25];
        field {
            name = "vpll0_dsmpd";
            desc = "VPLL0 decimal frequency-division control 0: decimal frequency-division mode 1: integer frequency-division mode";
            sw = rw; hw = r;
            reset = 0x1;
        } vpll0_dsmpd[24:24];
        field {
            name = "vpll0_pd";
            desc = "VPLL0 power-down control 0: normal operating mode 1: power-down mode";
            sw = rw; hw = r;
            reset = 0x0;
        } vpll0_pd[23:23];
        field {
            name = "vpll0_foutvcopd";
            desc = "Power-down control for the VPLL0 VCO output 0: normal output clock 1: no output clock";
            sw = rw; hw = r;
            reset = 0x0;
        } vpll0_foutvcopd[22:22];
        field {
            name = "vpll0_postdivpd";
            desc = "Power-down control for the VPLL0 POSTDIV output 0: normal output clock 1: no output clock";
            sw = rw; hw = r;
            reset = 0x0;
        } vpll0_postdivpd[21:21];
        field {
            name = "vpll0_fout4phasepd";
            desc = "Power-down control for the VPLL0 FOUT output 0: normal output clock 1: no output clock";
            sw = rw; hw = r;
            reset = 0x0;
        } vpll0_fout4phasepd[20:20];
        field {
            name = "reserved_19_18";
            desc = "Reserved";
            sw = rw; hw = r;
            reset = 0x0;
        } reserved_19_18[19:18];
        field {
            name = "vpll0_refdiv";
            desc = "Divider of the VPLL0 reference clock";
            sw = rw; hw = r;
            reset = 0x2;
        } vpll0_refdiv[17:12];
        field {
            name = "vpll0_fbdiv";
            desc = "Integral part of the VPLL0 frequency multiplication coefficient";
            sw = rw; hw = r;
            reset = 0x63;
        } vpll0_fbdiv[11:0];
    } PERI_CRG_PLL3 @ 0xC;
    reg {
        name = "PERI_CRG_PLL4";
        desc = "PERI_CRG_PLL4 is VPLL1 configuration register 0. (offset 0x10, total reset 0x1289374B; PROVEN: Hi3536D V100 data sheet).";
        field {
            name = "reserved_31_31";
            desc = "Reserved";
            sw = rw; hw = r;
            reset = 0x0;
        } reserved_31_31[31:31];
        field {
            name = "vpll1_postdiv2";
            desc = "Level-2 output divider of VPLL1";
            sw = rw; hw = r;
            reset = 0x1;
        } vpll1_postdiv2[30:28];
        field {
            name = "reserved_27_27";
            desc = "Reserved";
            sw = rw; hw = r;
            reset = 0x0;
        } reserved_27_27[27:27];
        field {
            name = "vpll1_postdiv1";
            desc = "Level-1 output divider of VPLL1";
            sw = rw; hw = r;
            reset = 0x2;
        } vpll1_postdiv1[26:24];
        field {
            name = "vpll1_frac";
            desc = "Decimal part of the VPLL1 frequency multiplication coefficient";
            sw = rw; hw = r;
            reset = 0x89374b;
        } vpll1_frac[23:0];
    } PERI_CRG_PLL4 @ 0x10;
    reg {
        name = "PERI_CRG_PLL5";
        desc = "PERI_CRG_PLL5 (offset 0x14, total reset 0x00001041; PROVEN: Hi3536D V100 data sheet).";
        field {
            name = "reserved_31_27";
            desc = "Reserved";
            sw = rw; hw = r;
            reset = 0x0;
        } reserved_31_27[31:27];
        field {
            name = "vpll1_bypass";
            desc = "VPLL1 clock frequency-division bypass control 0: not bypassed 1: bypassed";
            sw = rw; hw = r;
            reset = 0x0;
        } vpll1_bypass[26:26];
        field {
            name = "vpll1_dacpd";
            desc = "VPLL1test signal control 0: normal operating mode 1: power-down mode";
            sw = rw; hw = r;
            reset = 0x0;
        } vpll1_dacpd[25:25];
        field {
            name = "vpll1_dsmpd";
            desc = "VPLL1 decimal frequency-division control 0: decimal frequency-division mode 1: integer frequency-division mode";
            sw = rw; hw = r;
            reset = 0x0;
        } vpll1_dsmpd[24:24];
        field {
            name = "vpll1_pd";
            desc = "VPLL1 power-down control 0: normal operating mode 1: power-down mode";
            sw = rw; hw = r;
            reset = 0x0;
        } vpll1_pd[23:23];
        field {
            name = "vpll1_foutvcopd";
            desc = "Power-down control for the VPLL1 VCO output 0: normal output clock 1: no output clock";
            sw = rw; hw = r;
            reset = 0x0;
        } vpll1_foutvcopd[22:22];
        field {
            name = "vpll1_postdivpd";
            desc = "Power-down control for the VPLL1 POSTDIV output 0: normal output clock 1: no output clock";
            sw = rw; hw = r;
            reset = 0x0;
        } vpll1_postdivpd[21:21];
        field {
            name = "vpll1_fout4phasepd";
            desc = "Power-down control for the VPLL1 FOUT output 0: normal output clock 1: no output clock";
            sw = rw; hw = r;
            reset = 0x0;
        } vpll1_fout4phasepd[20:20];
        field {
            name = "reserved_19_18";
            desc = "Reserved";
            sw = r; hw = w;
            reset = 0x0;
        } reserved_19_18[19:18];
        field {
            name = "vpll1_refdiv";
            desc = "Divider of the VPLL1 reference clock";
            sw = rw; hw = r;
            reset = 0x1;
        } vpll1_refdiv[17:12];
        field {
            name = "vpll1_fbdiv";
            desc = "Integral part of the VPLL1 frequency multiplication coefficient";
            sw = rw; hw = r;
            reset = 0x41;
        } vpll1_fbdiv[11:0];
    } PERI_CRG_PLL5 @ 0x14;
    reg {
        name = "PERI_CRG_PLL6";
        desc = "PERI_CRG_PLL6 is VPLL2 configuration register 0. (offset 0x18, total reset 0x15000000; PROVEN: Hi3536D V100 data sheet).";
        field {
            name = "reserved_31_31";
            desc = "Reserved";
            sw = rw; hw = r;
            reset = 0x0;
        } reserved_31_31[31:31];
        field {
            name = "vpll2_postdiv2";
            desc = "Level-2 output divider of VPLL2";
            sw = rw; hw = r;
            reset = 0x1;
        } vpll2_postdiv2[30:28];
        field {
            name = "reserved_27_27";
            desc = "Reserved";
            sw = rw; hw = r;
            reset = 0x0;
        } reserved_27_27[27:27];
        field {
            name = "vpll2_postdiv1";
            desc = "Level-1 output divider of VPLL2";
            sw = rw; hw = r;
            reset = 0x5;
        } vpll2_postdiv1[26:24];
        field {
            name = "vpll2_frac";
            desc = "Decimal part of the VPLL2 frequency multiplication coefficient";
            sw = rw; hw = r;
            reset = 0x0;
        } vpll2_frac[23:0];
    } PERI_CRG_PLL6 @ 0x18;
    reg {
        name = "PERI_CRG_PLL7";
        desc = "PERI_CRG_PLL7 is VPLL2 configuration register 1. (offset 0x1C, total reset 0x01002087; PROVEN: Hi3536D V100 data sheet).";
        field {
            name = "reserved_31_27";
            desc = "Reserved";
            sw = rw; hw = r;
            reset = 0x0;
        } reserved_31_27[31:27];
        field {
            name = "vpll2_bypass";
            desc = "VPLL2 clock frequency-division bypass control 0: not bypassed 1: bypassed";
            sw = rw; hw = r;
            reset = 0x0;
        } vpll2_bypass[26:26];
        field {
            name = "vpll2_dacpd";
            desc = "VPLL2test signal control 0: normal operating mode 1: power-down mode";
            sw = rw; hw = r;
            reset = 0x0;
        } vpll2_dacpd[25:25];
        field {
            name = "vpll2_dsmpd";
            desc = "VPLL2 decimal frequency-division control 0: decimal frequency-division mode 1: integer frequency-division mode";
            sw = rw; hw = r;
            reset = 0x1;
        } vpll2_dsmpd[24:24];
        field {
            name = "vpll2_pd";
            desc = "VPLL2 power-down control 0: normal operating mode 1: power-down mode";
            sw = rw; hw = r;
            reset = 0x0;
        } vpll2_pd[23:23];
        field {
            name = "vpll2_foutvcopd";
            desc = "Power-down control for the VPLL2 VCO output 0: normal output clock 1: no output clock";
            sw = rw; hw = r;
            reset = 0x0;
        } vpll2_foutvcopd[22:22];
        field {
            name = "vpll2_postdivpd";
            desc = "Power-down control for the VPLL2 POSTDIV output 0: normal output clock 1: no output clock";
            sw = rw; hw = r;
            reset = 0x0;
        } vpll2_postdivpd[21:21];
        field {
            name = "vpll2_fout4phasepd";
            desc = "Power-down control for the VPLL2 FOUT output 0: normal output clock 1: no output clock";
            sw = rw; hw = r;
            reset = 0x0;
        } vpll2_fout4phasepd[20:20];
        field {
            name = "reserved_19_18";
            desc = "Reserved";
            sw = rw; hw = r;
            reset = 0x0;
        } reserved_19_18[19:18];
        field {
            name = "vpll2_refdiv";
            desc = "Divider of the VPLL2 reference clock";
            sw = rw; hw = r;
            reset = 0x2;
        } vpll2_refdiv[17:12];
        field {
            name = "vpll2_fbdiv";
            desc = "Integral part of the VPLL2 frequency multiplication coefficient";
            sw = rw; hw = r;
            reset = 0x87;
        } vpll2_fbdiv[11:0];
    } PERI_CRG_PLL7 @ 0x1C;
    reg {
        name = "PERI_CRG_PLL8";
        desc = "PERI_CRG_PLL8 (offset 0x20, total reset 0x13000000; PROVEN: Hi3536D V100 data sheet).";
        field {
            name = "reserved_31_31";
            desc = "Reserved";
            sw = rw; hw = r;
            reset = 0x0;
        } reserved_31_31[31:31];
        field {
            name = "epll_postdiv2";
            desc = "Level-2 output divider of EPLL";
            sw = rw; hw = r;
            reset = 0x1;
        } epll_postdiv2[30:28];
        field {
            name = "reserved_27_27";
            desc = "Reserved";
            sw = rw; hw = r;
            reset = 0x0;
        } reserved_27_27[27:27];
        field {
            name = "epll_postdiv1";
            desc = "Level-1 output divider of EPLL";
            sw = rw; hw = r;
            reset = 0x3;
        } epll_postdiv1[26:24];
        field {
            name = "epll_frac";
            desc = "Decimal part of the EPLL frequency multiplication coefficient";
            sw = rw; hw = r;
            reset = 0x0;
        } epll_frac[23:0];
    } PERI_CRG_PLL8 @ 0x20;
    reg {
        name = "PERI_CRG_PLL9";
        desc = "PERI_CRG_PLL9 is EPLL configuration register 1. (offset 0x24, total reset 0x0100207D; PROVEN: Hi3536D V100 data sheet).";
        field {
            name = "reserved_31_27";
            desc = "Reserved";
            sw = rw; hw = r;
            reset = 0x0;
        } reserved_31_27[31:27];
        field {
            name = "epll_bypass";
            desc = "EPLL clock frequency-division bypass control 0: not bypassed 1: bypassed";
            sw = rw; hw = r;
            reset = 0x0;
        } epll_bypass[26:26];
        field {
            name = "epll_dacpd";
            desc = "EPLL test signal control 0: normal operating mode 1: power-down mode";
            sw = rw; hw = r;
            reset = 0x0;
        } epll_dacpd[25:25];
        field {
            name = "epll_dsmpd";
            desc = "EPLL decimal frequency-division control 0: decimal frequency-division mode 1: integer frequency-division mode";
            sw = rw; hw = r;
            reset = 0x1;
        } epll_dsmpd[24:24];
        field {
            name = "epll_pd";
            desc = "EPLL power-down control 0: normal operating mode 1: power-down mode";
            sw = rw; hw = r;
            reset = 0x0;
        } epll_pd[23:23];
        field {
            name = "epll_foutvcopd";
            desc = "Power-down control for the EPLL VCO output 0: normal output clock 1: no output clock";
            sw = rw; hw = r;
            reset = 0x0;
        } epll_foutvcopd[22:22];
        field {
            name = "epll_postdivpd";
            desc = "Power-down control for the EPLL POSTDIV output 0: normal output clock 1: no output clock";
            sw = rw; hw = r;
            reset = 0x0;
        } epll_postdivpd[21:21];
        field {
            name = "epll_fout4phasepd";
            desc = "Power-down control for the EPLL FOUT output 0: normal output clock 1: no output clock";
            sw = rw; hw = r;
            reset = 0x0;
        } epll_fout4phasepd[20:20];
        field {
            name = "reserved_19_18";
            desc = "Reserved";
            sw = rw; hw = r;
            reset = 0x0;
        } reserved_19_18[19:18];
        field {
            name = "epll_refdiv";
            desc = "Divider of the EPLL reference clock";
            sw = rw; hw = r;
            reset = 0x2;
        } epll_refdiv[17:12];
        field {
            name = "epll_fbdiv";
            desc = "Integral part of the EPLL frequency multiplication coefficient";
            sw = rw; hw = r;
            reset = 0x7d;
        } epll_fbdiv[11:0];
    } PERI_CRG_PLL9 @ 0x24;
    reg {
        name = "PERI_CRG_PLL10";
        desc = "PERI_CRG_PLL10 is DPLL configuration register 0. (offset 0x28, total reset 0x14000000; PROVEN: Hi3536D V100 data sheet).";
        field {
            name = "reserved_31_31";
            desc = "Reserved";
            sw = rw; hw = r;
            reset = 0x0;
        } reserved_31_31[31:31];
        field {
            name = "dpll_postdiv2";
            desc = "Level-2 output divider of the DPLL";
            sw = rw; hw = r;
            reset = 0x1;
        } dpll_postdiv2[30:28];
        field {
            name = "reserved_27_27";
            desc = "Reserved";
            sw = rw; hw = r;
            reset = 0x0;
        } reserved_27_27[27:27];
        field {
            name = "dpll_postdiv1";
            desc = "Level-1 output divider of the DPLL";
            sw = rw; hw = r;
            reset = 0x4;
        } dpll_postdiv1[26:24];
        field {
            name = "dpll_frac";
            desc = "Decimal part of the DPLL frequency multiplication coefficient";
            sw = rw; hw = r;
            reset = 0x0;
        } dpll_frac[23:0];
    } PERI_CRG_PLL10 @ 0x28;
    reg {
        name = "PERI_CRG_PLL11";
        desc = "PERI_CRG_PLL11 is DPLL configuration register 1. (offset 0x2C, total reset 0x010030C8; PROVEN: Hi3536D V100 data sheet).";
        field {
            name = "reserved_31_27";
            desc = "Reserved";
            sw = rw; hw = r;
            reset = 0x0;
        } reserved_31_27[31:27];
        field {
            name = "dpll_bypass";
            desc = "DPLL clock frequency-division bypass control 0: not bypassed 1: bypassed";
            sw = rw; hw = r;
            reset = 0x0;
        } dpll_bypass[26:26];
        field {
            name = "dpll_dacpd";
            desc = "DPLL test signal control 0: normal operating mode 1: power-down mode";
            sw = rw; hw = r;
            reset = 0x0;
        } dpll_dacpd[25:25];
        field {
            name = "dpll_dsmpd";
            desc = "DPLL decimal frequency-division control 0: decimal frequency-division mode 1: integer frequency-division mode";
            sw = rw; hw = r;
            reset = 0x1;
        } dpll_dsmpd[24:24];
        field {
            name = "dpll_pd";
            desc = "DPLL power-down control 0: normal operating mode 1: power-down mode";
            sw = rw; hw = r;
            reset = 0x0;
        } dpll_pd[23:23];
        field {
            name = "dpll_foutvcopd";
            desc = "Power-down control for the DPLL VCO output 0: normal output clock 1: no output clock";
            sw = rw; hw = r;
            reset = 0x0;
        } dpll_foutvcopd[22:22];
        field {
            name = "dpll_postdivpd";
            desc = "Power-down control for the DPLL POSTDIV output 0: normal output clock 1: no output clock";
            sw = rw; hw = r;
            reset = 0x0;
        } dpll_postdivpd[21:21];
        field {
            name = "dpll_fout4phasepd";
            desc = "Power-down control for the DPLL FOUT output 0: normal output clock 1: no output clock";
            sw = rw; hw = r;
            reset = 0x0;
        } dpll_fout4phasepd[20:20];
        field {
            name = "reserved_19_18";
            desc = "Reserved";
            sw = r; hw = w;
            reset = 0x0;
        } reserved_19_18[19:18];
        field {
            name = "dpll_refdiv";
            desc = "Divider of the DPLL reference clock";
            sw = rw; hw = r;
            reset = 0x3;
        } dpll_refdiv[17:12];
        field {
            name = "dpll_fbdiv";
            desc = "Integral part of the DPLL frequency multiplication coefficient";
            sw = rw; hw = r;
            reset = 0xc8;
        } dpll_fbdiv[11:0];
    } PERI_CRG_PLL11 @ 0x2C;
    reg {
        name = "PERI_CRG20";
        desc = "PERI_CRG20 is an SoC clock selection register. (offset 0x50, total reset 0x00000000; PROVEN: Hi3536D V100 data sheet).";
        field {
            name = "reserved_31_8";
            desc = "Reserved 00: crystal oscillator clock";
            sw = rw; hw = r;
            reset = 0x0;
        } reserved_31_8[31:8];
        field {
            name = "a7_sc_sel";
            desc = "A7 clock select 01: APLL FOUTPOSTDIV clock 10: reserved 11: reserved 00: crystal oscillator clock";
            sw = rw; hw = r;
            reset = 0x0;
        } a7_sc_sel[7:6];
        field {
            name = "ddr_sc_sel";
            desc = "DDR clock select 01: DPLL FOUTPOSTDIV clock 10: reserved 11: reserved 00: crystal oscillator clock";
            sw = rw; hw = r;
            reset = 0x0;
        } ddr_sc_sel[5:4];
        field {
            name = "sysbus_sc_sel";
            desc = "SYSAXI clock select 01: reserved 10: 202.5 MHz clock 11: reserved";
            sw = rw; hw = r;
            reset = 0x0;
        } sysbus_sc_sel[3:2];
        field {
            name = "mdaapb_sc_sel";
            desc = "MDAAPB clock select 0: crystal oscillator clock 1: 100 MHz clock";
            sw = rw; hw = r;
            reset = 0x0;
        } mdaapb_sc_sel[1:1];
        field {
            name = "sysapb_sc_sel";
            desc = "SYSAPB clock select 0: crystal oscillator clock 1: 50 MHz clock";
            sw = rw; hw = r;
            reset = 0x0;
        } sysapb_sc_sel[0:0];
    } PERI_CRG20 @ 0x50;
    reg {
        name = "PERI_CRG21";
        desc = "PERI_CRG21 is an SOC_SW_READBACK register. (offset 0x54, total reset 0x00000000; PROVEN: Hi3536D V100 data sheet).";
        field {
            name = "reserved_31_8";
            desc = "Reserved 00: The clock is switched to a crystal oscillator clock.";
            sw = r; hw = w;
            reset = 0x0;
        } reserved_31_8[31:8];
        field {
            name = "a7_sc_seled";
            desc = "A7 clock switching completion indicator 01: The clock is switched to the APLL FOUTPOSTDIV clock. 10: reserved 11: reserved 00: The clock is switched to a crystal oscillator clock.";
            sw = r; hw = w;
            reset = 0x0;
        } a7_sc_seled[7:6];
        field {
            name = "ddr_sc_seled";
            desc = "DDR clock switching completion indicator 01: The clock is switched to the DPLL FOUTPOSTDIV clock. Other values: reserved 00: The clock is switched to a crystal oscillator clock.";
            sw = r; hw = w;
            reset = 0x0;
        } ddr_sc_seled[5:4];
        field {
            name = "sysbus_sc_seled";
            desc = "SYSAXI clock switching completion indicator 10: The clock is switched to a 202.5 MHz clock. Other values: reserved";
            sw = r; hw = w;
            reset = 0x0;
        } sysbus_sc_seled[3:2];
        field {
            name = "mdaapb_sc_seled";
            desc = "MDAAPB clock switching completion indicator 0: The clock is switched to a crystal oscillator clock. 1: The clock is switched to a 100 MHz clock.";
            sw = r; hw = w;
            reset = 0x0;
        } mdaapb_sc_seled[1:1];
        field {
            name = "sysapb_sc_seled";
            desc = "SYSAPB clock switching completion indicator 0: The clock is switched to a crystal oscillator clock. 1: The clock is switched to a 50 MHz clock.";
            sw = r; hw = w;
            reset = 0x0;
        } sysapb_sc_seled[0:0];
    } PERI_CRG21 @ 0x54;
    reg {
        name = "PERI_CRG33";
        desc = "PERI_CRG33 is a DDR clock configuration register. (offset 0x84, total reset 0x00000007; PROVEN: Hi3536D V100 data sheet).";
        field {
            name = "reserved_31_5";
            desc = "Reserved ddr_hipack_srst_re";
            sw = rw; hw = r;
            reset = 0x0;
        } reserved_31_5[31:5];
        field {
            name = "f_0_";
            desc = "DDR HiPACK soft reset request deassert reset q 1: reset";
            sw = rw; hw = r;
            reset = 0x0;
        } f_0_[4:4];
        field {
            name = "ddr_apb_srst_req";
            desc = "DDR APB soft reset request 0: deassert reset 1: reset";
            sw = rw; hw = r;
            reset = 0x0;
        } ddr_apb_srst_req[3:3];
        field {
            name = "ddr_cfg_cken";
            desc = "DDR CFG gating 0: Disable the clock. 1: Enable the clock.";
            sw = rw; hw = r;
            reset = 0x1;
        } ddr_cfg_cken[2:2];
        field {
            name = "ddr_hipack_cken";
            desc = "DDR HiPack gating 0: Disable the clock. 1: Enable the clock.";
            sw = rw; hw = r;
            reset = 0x1;
        } ddr_hipack_cken[1:1];
        field {
            name = "ddr_apb_cken";
            desc = "DDR APB gating 0: Disable the clock. 1: Enable the clock.";
            sw = rw; hw = r;
            reset = 0x1;
        } ddr_apb_cken[0:0];
    } PERI_CRG33 @ 0x84;
    reg {
        name = "PERI_CRG34";
        desc = "PERI_CRG34 is a VDP clock and reset control register. (offset 0x88, total reset 0x00003200; PROVEN: Hi3536D V100 data sheet).";
        field {
            name = "reserved_31_17";
            desc = "Reserved (1–32) (N + 1) vo_hd0_hdmi_clk_ 0x0: divided by 1 [16:12]        RW div              0x1: divided by 2 0x2: divided by 3 ... 0x1F: divided by 32";
            sw = rw; hw = r;
            reset = 0x0;
        } reserved_31_17[31:17];
        field {
            name = "reserved_11_11";
            desc = "Frequency division for the HDMI clock of the VDP HD0 channel Reserved 00: The input clock is bypassed.";
            sw = rw; hw = r;
            reset = 0x0;
        } reserved_11_11[11:11];
        field {
            name = "hd_dacdly_sel";
            desc = "DLY control for the output clock of the VGA HSVS 01: The input clock is delayed by one gear. 10: The input clock is delayed by two gears. 11: The input clock is delayed by three gears.";
            sw = rw; hw = r;
            reset = 0x1;
        } hd_dacdly_sel[10:9];
        field {
            name = "vo_hd0_clk_div";
            desc = "Frequency division for the clock of the VO HD0 0: divided by 1 1: divided by 2";
            sw = rw; hw = r;
            reset = 0x0;
        } vo_hd0_clk_div[8:8];
        field {
            name = "hd_dac_pctrl1";
            desc = "Phase control for the VGA HSVS clock 0: positive-phase clock 1: negative-phase clock";
            sw = rw; hw = r;
            reset = 0x0;
        } hd_dac_pctrl1[7:7];
        field {
            name = "vdp_cksel";
            desc = "Source selection of the VDP operating clock 0: 202.5 MHz 1: 100 MHz";
            sw = rw; hw = r;
            reset = 0x0;
        } vdp_cksel[6:6];
        field {
            name = "vou_cken";
            desc = "Gating configuration of the VDP operating clock 0: Disable the clock. 1: Enable the clock.";
            sw = rw; hw = r;
            reset = 0x0;
        } vou_cken[5:5];
        field {
            name = "vou_hd0_cken";
            desc = "Gating configuration of the VDP HD0 operating clock 0: Disable the clock. 1: Enable the clock.";
            sw = rw; hw = r;
            reset = 0x0;
        } vou_hd0_cken[4:4];
        field {
            name = "vou_hcken";
            desc = "Gating configuration of the VDP bus clock 0: Disable the clock. 1: Enable the clock.";
            sw = rw; hw = r;
            reset = 0x0;
        } vou_hcken[3:3];
        field {
            name = "hd_dac_cken";
            desc = "Gating configuration of the HD DAC clock 0: Disable the clock. 1: Enable the clock.";
            sw = rw; hw = r;
            reset = 0x0;
        } hd_dac_cken[2:2];
        field {
            name = "hd_dac_pctrl";
            desc = "Phase control for the HD DAC clock 0: positive-phase clock 1: negative-phase clock";
            sw = rw; hw = r;
            reset = 0x0;
        } hd_dac_pctrl[1:1];
        field {
            name = "vo_srst_req";
            desc = "VDP reset request 0: deassert reset 1: reset";
            sw = rw; hw = r;
            reset = 0x0;
        } vo_srst_req[0:0];
    } PERI_CRG34 @ 0x88;
    reg {
        name = "PERI_CRG35";
        desc = "PERI_CRG35 (offset 0x8C, total reset 0x0001043F; PROVEN: Hi3536D V100 data sheet).";
        field {
            name = "reserved_31_20";
            desc = "Reserved 0: Select the CLK_SSC_COM clock (VPLL0 FOUTPOSTDIV";
            sw = rw; hw = r;
            reset = 0x0;
        } reserved_31_20[31:20];
        field {
            name = "ssc_bypass_clk_sel";
            desc = "Selection signal of the HDMI_SSC bypass clock clock). 1: Select the clock sent from the VDP (CLK_VPLL0_DIV).";
            sw = rw; hw = r;
            reset = 0x0;
        } ssc_bypass_clk_sel[19:19];
        field {
            name = "reserved_18_17";
            desc = "Reserved";
            sw = rw; hw = r;
            reset = 0x0;
        } reserved_18_17[18:17];
        field {
            name = "hdmitx_pxl_cken";
            desc = "PXL clock gating 0: Disable the PXL clock gating. 1: Enable the PXL clock gating.";
            sw = rw; hw = r;
            reset = 0x1;
        } hdmitx_pxl_cken[16:16];
        field {
            name = "reserved_15_14";
            desc = "Reserved (N + 1) 0x0: divided by 1";
            sw = rw; hw = r;
            reset = 0x0;
        } reserved_15_14[15:14];
        field {
            name = "ssc_clk_div";
            desc = "HDMI_SSC clock division coefficient (1–16) 0x1: divided by 2 0x2: divided by 3 … 0xF: divided by 16 hdmitx_ssc_srst_re";
            sw = rw; hw = r;
            reset = 0x1;
        } ssc_clk_div[13:10];
        field {
            name = "f_0_";
            desc = "Soft reset request for the HDMI_SSC frequency divider deassert reset q 1: reset";
            sw = rw; hw = r;
            reset = 0x0;
        } f_0_[9:9];
        field {
            name = "reserved_8_8";
            desc = "Reserved hdmitx_ctrl_srst_re";
            sw = r; hw = w;
            reset = 0x0;
        } reserved_8_8[8:8];
        field {
            name = "f_0__7";
            desc = "HDMI TX soft reset request deassert reset q 1: reset hdmitx_ctrl_bus_sr";
            sw = rw; hw = r;
            reset = 0x0;
        } f_0__7[7:7];
        field {
            name = "f_0__6";
            desc = "Soft reset request for HDMI TX bus deassert reset st_req 1: reset";
            sw = rw; hw = r;
            reset = 0x0;
        } f_0__6[6:6];
        field {
            name = "reserved_5_3";
            desc = "Reserved hdmitx_ctrl_osc_24";
            sw = r; hw = na;
            reset = 0x7;
        } reserved_5_3[5:3];
        field {
            name = "f_0__2";
            desc = "HDMI TX OS 24 MHz clock gating Disable the clock. 1: Enable the clock.";
            sw = rw; hw = r;
            reset = 0x1;
        } f_0__2[2:2];
        field {
            name = "ssc_bypass_cken";
            desc = "m_cken HDMI TX SSC bypass clock gating 0: Disable the clock. 1: Enable the clock.";
            sw = rw; hw = r;
            reset = 0x1;
        } ssc_bypass_cken[1:1];
        field {
            name = "ssc_in_cken";
            desc = "HDMI TX SSC clock gating 0: Disable the clock. 1: Enable the clock.";
            sw = rw; hw = r;
            reset = 0x1;
        } ssc_in_cken[0:0];
    } PERI_CRG35 @ 0x8C;
    reg {
        name = "PERI_CRG36";
        desc = "PERI_CRG36 is an HDMI TX_PHY clock and soft reset control register. (offset 0x90, total reset 0x00000001; PROVEN: Hi3536D V100 data sheet).";
        field {
            name = "reserved_31_9";
            desc = "Reserved (N + 1) 0x0: divided by 1";
            sw = rw; hw = r;
            reset = 0x0;
        } reserved_31_9[31:9];
        field {
            name = "tmds_clk_div";
            desc = "TMDS clock frequency division coefficient (1–8) 0x1: divided by 2 0x2: divided by 3 … 0x7: divided by 8 divider";
            sw = rw; hw = r;
            reset = 0x0;
        } tmds_clk_div[8:6];
        field {
            name = "phy_tmds_srst_req";
            desc = "Soft reset request for the HDMI TX PHY TMDS frequency 0: deassert reset 1: reset hdmitx_phy_srst_re";
            sw = rw; hw = r;
            reset = 0x0;
        } phy_tmds_srst_req[5:5];
        field {
            name = "f_0_";
            desc = "HDMI TX PHY soft reset request deassert reset q 1: reset";
            sw = rw; hw = r;
            reset = 0x0;
        } f_0_[4:4];
        field {
            name = "reserved_3_1";
            desc = "Reserved";
            sw = rw; hw = r;
            reset = 0x0;
        } reserved_3_1[3:1];
        field {
            name = "phy_tmds_cken";
            desc = "HDMI TX PHY TMDS clock gating 0: Disable the clock. 1: Enable the clock.";
            sw = rw; hw = r;
            reset = 0x1;
        } phy_tmds_cken[0:0];
    } PERI_CRG36 @ 0x90;
    reg {
        name = "PERI_CRG37";
        desc = "PERI_CRG37 is a TDE clock and soft reset control register. (offset 0x94, total reset 0x00000002; PROVEN: Hi3536D V100 data sheet).";
        field {
            name = "reserved_31_2";
            desc = "Reserved";
            sw = rw; hw = r;
            reset = 0x0;
        } reserved_31_2[31:2];
        field {
            name = "tde_cken";
            desc = "TDE clock gating 0: Disable the clock. 1: Enable the clock.";
            sw = rw; hw = r;
            reset = 0x1;
        } tde_cken[1:1];
        field {
            name = "tde_srst_req";
            desc = "TDE soft reset request 0: deassert reset 1: reset";
            sw = rw; hw = r;
            reset = 0x0;
        } tde_srst_req[0:0];
    } PERI_CRG37 @ 0x94;
    reg {
        name = "PERI_CRG38";
        desc = "PERI_CRG38 is a VGS clock and soft reset control register. (offset 0x98, total reset 0x00000002; PROVEN: Hi3536D V100 data sheet).";
        field {
            name = "reserved_31_2";
            desc = "Reserved";
            sw = rw; hw = r;
            reset = 0x0;
        } reserved_31_2[31:2];
        field {
            name = "vgs_cken";
            desc = "VGS clock gating 0: Disable the clock. 1: Enable the clock.";
            sw = rw; hw = r;
            reset = 0x1;
        } vgs_cken[1:1];
        field {
            name = "vgs_srst_req";
            desc = "VGS soft reset request 0: deassert reset 1: reset";
            sw = rw; hw = r;
            reset = 0x0;
        } vgs_srst_req[0:0];
    } PERI_CRG38 @ 0x98;
    reg {
        name = "PERI_CRG39";
        desc = "PERI_CRG39 (offset 0x9C, total reset 0x00000002; PROVEN: Hi3536D V100 data sheet).";
        field {
            name = "reserved_31_2";
            desc = "Reserved";
            sw = rw; hw = r;
            reset = 0x0;
        } reserved_31_2[31:2];
        field {
            name = "jpge_cken";
            desc = "JPGE clock gating 0: Disable the clock. 1: Enable the clock.";
            sw = rw; hw = r;
            reset = 0x1;
        } jpge_cken[1:1];
        field {
            name = "jpge_srst_req";
            desc = "JPGE soft reset request 0: deassert reset 1: reset";
            sw = rw; hw = r;
            reset = 0x0;
        } jpge_srst_req[0:0];
    } PERI_CRG39 @ 0x9C;
    reg {
        name = "PERI_CRG40";
        desc = "PERI_CRG40 is a JPGD clock and soft reset control register. (offset 0xA0, total reset 0x00000002; PROVEN: Hi3536D V100 data sheet).";
        field {
            name = "reserved_31_2";
            desc = "Reserved";
            sw = rw; hw = r;
            reset = 0x0;
        } reserved_31_2[31:2];
        field {
            name = "jpgd_cken";
            desc = "JPGD clock gating 0: Disable the clock. 1: Enable the clock.";
            sw = rw; hw = r;
            reset = 0x1;
        } jpgd_cken[1:1];
        field {
            name = "jpgd_srst_req";
            desc = "JPGD soft reset request 0: deassert reset 1: reset";
            sw = rw; hw = r;
            reset = 0x0;
        } jpgd_srst_req[0:0];
    } PERI_CRG40 @ 0xA0;
    reg {
        name = "PERI_CRG41";
        desc = "PERI_CRG41 is a VDH clock and reset control register. (offset 0xA4, total reset 0x00000073; PROVEN: Hi3536D V100 data sheet).";
        field {
            name = "reserved_31_7";
            desc = "Reserved";
            sw = rw; hw = r;
            reset = 0x0;
        } reserved_31_7[31:7];
        field {
            name = "vdh_all_srst_req";
            desc = "VDH soft reset request 0: deassert reset 1: reset";
            sw = rw; hw = r;
            reset = 0x1;
        } vdh_all_srst_req[6:6];
        field {
            name = "vdh_scd_srst_req";
            desc = "VDH SCD soft reset request 0: deassert reset 1: reset";
            sw = rw; hw = r;
            reset = 0x1;
        } vdh_scd_srst_req[5:5];
        field {
            name = "vdh_mfd_srst_req";
            desc = "VDH MFD soft reset request 0: deassert reset 1: reset";
            sw = rw; hw = r;
            reset = 0x1;
        } vdh_mfd_srst_req[4:4];
        field {
            name = "reserved_3_1";
            desc = "Reserved";
            sw = r; hw = na;
            reset = 0x1;
        } reserved_3_1[3:1];
        field {
            name = "vdh_cken";
            desc = "VDH clock gating 0: Disable the clock. 1: Enable the clock.";
            sw = rw; hw = r;
            reset = 0x1;
        } vdh_cken[0:0];
    } PERI_CRG41 @ 0xA4;
    reg {
        name = "PERI_CRG42";
        desc = "PERI_CRG42 is a cipher clock and soft reset control register. (offset 0xA8, total reset 0x00000002; PROVEN: Hi3536D V100 data sheet).";
        field {
            name = "reserved_31_2";
            desc = "Reserved";
            sw = rw; hw = r;
            reset = 0x0;
        } reserved_31_2[31:2];
        field {
            name = "cipher_cken";
            desc = "CIPHER clock gating 0: Disable the clock. 1: Enable the clock.";
            sw = rw; hw = r;
            reset = 0x1;
        } cipher_cken[1:1];
        field {
            name = "cipher_srst_req";
            desc = "CIPHER soft reset request 0: deassert reset 1: reset";
            sw = rw; hw = r;
            reset = 0x0;
        } cipher_srst_req[0:0];
    } PERI_CRG42 @ 0xA8;
    reg {
        name = "PERI_CRG43";
        desc = "PERI_CRG43 (offset 0xAC, total reset 0x00000802; PROVEN: Hi3536D V100 data sheet).";
        field {
            name = "reserved_31_12";
            desc = "Reserved";
            sw = rw; hw = r;
            reset = 0x0;
        } reserved_31_12[31:12];
        field {
            name = "codec_cken";
            desc = "CODEC clock gating 0: Disable the clock. 1: Enable the clock.";
            sw = rw; hw = r;
            reset = 0x1;
        } codec_cken[11:11];
        field {
            name = "codec_srst_req";
            desc = "CODEC soft reset request 0: deassert reset 1: reset";
            sw = rw; hw = r;
            reset = 0x0;
        } codec_srst_req[10:10];
        field {
            name = "reserved_9_4";
            desc = "Reserved";
            sw = rw; hw = r;
            reset = 0x0;
        } reserved_9_4[9:4];
        field {
            name = "aiao_core_cksel";
            desc = "Source selection of the AIAO working clock 0: 100 MHz 1: 50 MHz";
            sw = rw; hw = r;
            reset = 0x0;
        } aiao_core_cksel[3:3];
        field {
            name = "aiao_cksel";
            desc = "Source selection of the AIAO MCLK PLL 0: VPLL1 FOUTPOSTDIV 1: 500 MHz";
            sw = rw; hw = r;
            reset = 0x0;
        } aiao_cksel[2:2];
        field {
            name = "aiao_cken";
            desc = "AIAO clock gating 0: Disable the clock. 1: Enable the clock.";
            sw = rw; hw = r;
            reset = 0x1;
        } aiao_cken[1:1];
        field {
            name = "aiao_srst_req";
            desc = "AIAO soft reset request 0: deassert reset 1: reset";
            sw = rw; hw = r;
            reset = 0x0;
        } aiao_srst_req[0:0];
    } PERI_CRG43 @ 0xAC;
    reg {
        name = "PERI_CRG44";
        desc = "PERI_CRG44 (offset 0xB0, total reset 0x0000000B; PROVEN: Hi3536D V100 data sheet).";
        field {
            name = "reserved_31_4";
            desc = "Reserved 00: reserved";
            sw = rw; hw = r;
            reset = 0x0;
        } reserved_31_4[31:4];
        field {
            name = "sataphy0_refclk_sel";
            desc = "Selection of the SATA PHY0 lane reference clock 01: 25 MHz 10: 100 MHz 11: reserved sataphy0_lane_srst";
            sw = rw; hw = r;
            reset = 0x2;
        } sataphy0_refclk_sel[3:2];
        field {
            name = "f_0_";
            desc = "SATAPHY0 LANE soft reset request deassert reset _req 1: reset";
            sw = rw; hw = r;
            reset = 0x1;
        } f_0_[1:1];
        field {
            name = "sataphy0_ref_cken";
            desc = "SATA PHY0 lane reference clock gating 0: Disable the clock. 1: Enable the clock.";
            sw = rw; hw = r;
            reset = 0x1;
        } sataphy0_ref_cken[0:0];
    } PERI_CRG44 @ 0xB0;
    reg {
        name = "PERI_CRG45";
        desc = "PERI_CRG45 (offset 0xB4, total reset 0x0000000F; PROVEN: Hi3536D V100 data sheet).";
        field {
            name = "reserved_31_12";
            desc = "Reserved";
            sw = rw; hw = r;
            reset = 0x0;
        } reserved_31_12[31:12];
        field {
            name = "sata0_srst_req";
            desc = "SATA CTRL SATA0 soft reset 0: deassert reset 1: reset";
            sw = rw; hw = r;
            reset = 0x0;
        } sata0_srst_req[11:11];
        field {
            name = "sata_rx0_srst_req";
            desc = "SATA CTRL RX0 soft reset 0: deassert reset 1: reset sata_cko_alive_srst";
            sw = rw; hw = r;
            reset = 0x0;
        } sata_rx0_srst_req[10:10];
        field {
            name = "f_0_";
            desc = "SATA CTRL CKO_ALIVE soft reset deassert reset _req 1: reset";
            sw = rw; hw = r;
            reset = 0x0;
        } f_0_[9:9];
        field {
            name = "sata_bus_srst_req";
            desc = "SATA CTRL bus soft reset 0: deassert reset 1: reset";
            sw = rw; hw = r;
            reset = 0x0;
        } sata_bus_srst_req[8:8];
        field {
            name = "reserved_7_6";
            desc = "Reserved";
            sw = rw; hw = r;
            reset = 0x0;
        } reserved_7_6[7:6];
        field {
            name = "sata_tx0_pctrl";
            desc = "SATA TX0 clock phase control 0 (default): positive-phase clock 1: negative-phase clock";
            sw = rw; hw = r;
            reset = 0x0;
        } sata_tx0_pctrl[5:5];
        field {
            name = "sata_rx0_pctrl";
            desc = "SATA RX0 clock phase control 0 (default): positive-phase clock 1: negative-phase clock";
            sw = rw; hw = r;
            reset = 0x0;
        } sata_rx0_pctrl[4:4];
        field {
            name = "sata_tx0_cken";
            desc = "SATA CTRL TX0 clock gating 0: Disable the clock. 1: Enable the clock.";
            sw = rw; hw = r;
            reset = 0x1;
        } sata_tx0_cken[3:3];
        field {
            name = "f_0__2";
            desc = "SATA CTRL CKO_ALIVE clock gating sata_cko_alive_cke Disable the clock. 1: Enable the clock";
            sw = rw; hw = r;
            reset = 0x1;
        } f_0__2[2:2];
        field {
            name = "sata_rx0_cken";
            desc = "n SATA CTRL RX0 clock gating 0: Disable the clock. 1: Enable the clock.";
            sw = rw; hw = r;
            reset = 0x1;
        } sata_rx0_cken[1:1];
        field {
            name = "sata_bus_cken";
            desc = "SATA CTRL clock gating 0: Disable the clock. 1: Enable the clock.";
            sw = rw; hw = r;
            reset = 0x1;
        } sata_bus_cken[0:0];
    } PERI_CRG45 @ 0xB4;
    reg {
        name = "PERI_CRG46";
        desc = "PERI_CRG46 is a USB 2.0 CTRL clock and soft reset control register. (offset 0xB8, total reset 0x00017077; PROVEN: Hi3536D V100 data sheet).";
        field {
            name = "reserved_31_21";
            desc = "Reserved";
            sw = rw; hw = r;
            reset = 0x0;
        } reserved_31_21[31:21];
        field {
            name = "usb2_phy_clk_sel";
            desc = "USB2.0 PHY clock 48/free clock/UTMI clock source select 0: PHY output 1: provided by the CRG";
            sw = rw; hw = r;
            reset = 0x0;
        } usb2_phy_clk_sel[20:20];
        field {
            name = "reserved_19_17";
            desc = "Reserved usb2_hst_phy_srst_";
            sw = rw; hw = r;
            reset = 0x0;
        } reserved_19_17[19:17];
        field {
            name = "f_0_";
            desc = "USB 2.0 CTRL HST_PHY soft reset deassert reset req 1: reset";
            sw = rw; hw = r;
            reset = 0x1;
        } f_0_[16:16];
        field {
            name = "reserved_15_15";
            desc = "Reserved usb2_utmi1_srst_re";
            sw = rw; hw = r;
            reset = 0x0;
        } reserved_15_15[15:15];
        field {
            name = "f_0__14";
            desc = "USB 2.0 CTRL UTMI1 soft reset deassert reset q 1: reset usb2_utmi0_srst_re";
            sw = rw; hw = r;
            reset = 0x1;
        } f_0__14[14:14];
        field {
            name = "f_0__13";
            desc = "USB 2.0 CTRL UTMI0 soft reset deassert reset q 1: reset";
            sw = rw; hw = r;
            reset = 0x1;
        } f_0__13[13:13];
        field {
            name = "usb2_bus_srst_req";
            desc = "USB 2.0 CTRL bus soft reset 0: deassert reset 1: reset";
            sw = rw; hw = r;
            reset = 0x1;
        } usb2_bus_srst_req[12:12];
        field {
            name = "reserved_11_7";
            desc = "Reserved";
            sw = rw; hw = r;
            reset = 0x0;
        } reserved_11_7[11:7];
        field {
            name = "usb2_utmi1_cken";
            desc = "USB 2.0 CTRL UTMI1 clock gating 0: Disable the clock. 1: Enable the clock.";
            sw = rw; hw = r;
            reset = 0x1;
        } usb2_utmi1_cken[6:6];
        field {
            name = "usb2_utmi0_cken";
            desc = "USB 2.0 CTRL UTMI0 clock gating 0: Disable the clock. 1: Enable the clock.";
            sw = rw; hw = r;
            reset = 0x1;
        } usb2_utmi0_cken[5:5];
        field {
            name = "usb2_hst_phy_cken";
            desc = "USB 2.0 CTRL HST_PHY clock gating 0: Disable the clock. 1: Enable the clock.";
            sw = rw; hw = r;
            reset = 0x1;
        } usb2_hst_phy_cken[4:4];
        field {
            name = "reserved_3_3";
            desc = "Reserved usb2_ohci12m_cke";
            sw = rw; hw = r;
            reset = 0x0;
        } reserved_3_3[3:3];
        field {
            name = "f_0__2";
            desc = "USB 2.0 CTRL OHCI12M clock gating Disable the clock. 1: Enable the clock.";
            sw = rw; hw = r;
            reset = 0x1;
        } f_0__2[2:2];
        field {
            name = "f_0__1";
            desc = "n USB 2.0 CTRL OHCI48M clock gating usb2_ohci48m_cke Disable the clock. 1: Enable the clock.";
            sw = rw; hw = r;
            reset = 0x1;
        } f_0__1[1:1];
        field {
            name = "usb2_bus_cken";
            desc = "n USB 2.0 CTRL bus clock gating 0: Disable the clock. 1: Enable the clock.";
            sw = rw; hw = r;
            reset = 0x1;
        } usb2_bus_cken[0:0];
    } PERI_CRG46 @ 0xB8;
    reg {
        name = "PERI_CRG47";
        desc = "PERI_CRG47 (offset 0xBC, total reset 0x0000001F; PROVEN: Hi3536D V100 data sheet).";
        field {
            name = "reserved_31_5";
            desc = "Reserved usb2_phy_test_srst";
            sw = rw; hw = r;
            reset = 0x0;
        } reserved_31_5[31:5];
        field {
            name = "f_0_";
            desc = "Soft reset request of the USB 2.0 PHY test deassert reset _req 1: reset usb2_phy_port1_tr";
            sw = rw; hw = r;
            reset = 0x1;
        } f_0_[4:4];
        field {
            name = "f_0__3";
            desc = "USB 2.0 PHY TPOR1 soft reset deassert reset eq 1: reset usb2_phy_port0_tr";
            sw = rw; hw = r;
            reset = 0x1;
        } f_0__3[3:3];
        field {
            name = "f_0__2";
            desc = "USB 2.0 PHY TPOR0 soft reset deassert reset eq 1: reset";
            sw = rw; hw = r;
            reset = 0x1;
        } f_0__2[2:2];
        field {
            name = "usb2_phy_req";
            desc = "USB 2.0 PHY soft reset 0: deassert reset 1: reset";
            sw = rw; hw = r;
            reset = 0x1;
        } usb2_phy_req[1:1];
        field {
            name = "usb2_phy_cken";
            desc = "USB 2.0 PHY reference clock gating 0: Disable the clock. 1: Enable the clock.";
            sw = rw; hw = r;
            reset = 0x1;
        } usb2_phy_cken[0:0];
    } PERI_CRG47 @ 0xBC;
    reg {
        name = "PERI_CRG48";
        desc = "PERI_CRG48 (offset 0xC0, total reset 0x00000002; PROVEN: Hi3536D V100 data sheet).";
        field {
            name = "reserved_31_4";
            desc = "Reserved 00: 24 MHz clock";
            sw = rw; hw = r;
            reset = 0x0;
        } reserved_31_4[31:4];
        field {
            name = "fmc_cksel";
            desc = "FMC clock source select 01: 83.3 MHz clock 10: 150 MHz clock 11: reserved";
            sw = rw; hw = r;
            reset = 0x0;
        } fmc_cksel[3:2];
        field {
            name = "fmc_cken";
            desc = "FMC clock gating 0: Disable the clock. 1: Enable the clock.";
            sw = rw; hw = r;
            reset = 0x1;
        } fmc_cken[1:1];
        field {
            name = "fmc_srst_req";
            desc = "FMC soft reset 0: deassert reset 1: reset";
            sw = rw; hw = r;
            reset = 0x0;
        } fmc_srst_req[0:0];
    } PERI_CRG48 @ 0xC0;
    reg {
        name = "PERI_CRG49";
        desc = "PERI_CRG49 (offset 0xC4, total reset 0x0000060A; PROVEN: Hi3536D V100 data sheet).";
        field {
            name = "reserved_31_11";
            desc = "Reserved";
            sw = rw; hw = r;
            reset = 0x0;
        } reserved_31_11[31:11];
        field {
            name = "int_fephy_cken";
            desc = "FE PHY PUB clock gating 0: Disable the clock. 1: Enable the clock.";
            sw = rw; hw = r;
            reset = 0x1;
        } int_fephy_cken[10:10];
        field {
            name = "int_fephy_srst_req";
            desc = "Soft reset request of the FE PHY 0: deassert reset 1: reset";
            sw = rw; hw = r;
            reset = 0x1;
        } int_fephy_srst_req[9:9];
        field {
            name = "rmii_mode";
            desc = "Mode selection of the ETH interface clock 0: MII mode 1: RMII mode";
            sw = rw; hw = r;
            reset = 0x0;
        } rmii_mode[8:8];
        field {
            name = "ethcore_cksel";
            desc = "ETH clock source selection 0: 54 MHz clock 1: 100 MHz clock";
            sw = rw; hw = r;
            reset = 0x0;
        } ethcore_cksel[7:7];
        field {
            name = "reserved_6_6";
            desc = "Reserved 00: 25 MHz clock";
            sw = rw; hw = r;
            reset = 0x0;
        } reserved_6_6[6:6];
        field {
            name = "ext_ethphy_cksel";
            desc = "Source selection of the ETH PHY output clock 01: 24 MHz clock 1X: 27 MHz clock";
            sw = rw; hw = r;
            reset = 0x0;
        } ext_ethphy_cksel[5:4];
        field {
            name = "ext_fephy_srst_req";
            desc = "Soft reset request of the FE PHY 0: deassert reset 1: reset";
            sw = rw; hw = r;
            reset = 0x1;
        } ext_fephy_srst_req[3:3];
        field {
            name = "eth_rmiick_sel";
            desc = "Source selection of the ETH RMII clock 0: internal CRG clock 1: PAD input clock";
            sw = rw; hw = r;
            reset = 0x0;
        } eth_rmiick_sel[2:2];
        field {
            name = "eth_cken";
            desc = "ETH clock gating 0: Disable the clock. 1: Enable the clock.";
            sw = rw; hw = r;
            reset = 0x1;
        } eth_cken[1:1];
        field {
            name = "hrst_eth_s";
            desc = "ETH soft reset 0: deassert reset 1: reset";
            sw = rw; hw = r;
            reset = 0x0;
        } hrst_eth_s[0:0];
    } PERI_CRG49 @ 0xC4;
    reg {
        name = "PERI_CRG50";
        desc = "PERI_CRG50 is a DMA/DDRTEST clock and soft reset control register. (offset 0xC8, total reset 0x0000002A; PROVEN: Hi3536D V100 data sheet).";
        field {
            name = "reserved_31_6";
            desc = "Reserved";
            sw = rw; hw = r;
            reset = 0x0;
        } reserved_31_6[31:6];
        field {
            name = "dmac_cken";
            desc = "DMA clock gating 0: Disable the clock. 1: Enable the clock.";
            sw = rw; hw = r;
            reset = 0x1;
        } dmac_cken[5:5];
        field {
            name = "dmac_srst_req";
            desc = "DMA soft reset request 0: deassert reset 1: reset";
            sw = rw; hw = r;
            reset = 0x0;
        } dmac_srst_req[4:4];
        field {
            name = "ddrtest_cken";
            desc = "DDRTEST clock gating 0: Disable the clock. 1: Enable the clock.";
            sw = rw; hw = r;
            reset = 0x1;
        } ddrtest_cken[3:3];
        field {
            name = "ddrtest_srst_req";
            desc = "DDRTEST soft reset request 0: deassert reset 1: reset";
            sw = rw; hw = r;
            reset = 0x0;
        } ddrtest_srst_req[2:2];
        field {
            name = "reserved_1_0";
            desc = "Reserved";
            sw = r; hw = na;
            reset = 0x2;
        } reserved_1_0[1:0];
    } PERI_CRG50 @ 0xC8;
    reg {
        name = "PERI_CRG51";
        desc = "PERI_CRG51 is an APB peripheral clock reset control register (offset 0xCC, total reset 0x0007B001; PROVEN: Hi3536D V100 data sheet).";
        field {
            name = "reserved_31_20";
            desc = "Reserved 00: APB clock";
            sw = rw; hw = r;
            reset = 0x0;
        } reserved_31_20[31:20];
        field {
            name = "uart_cksel";
            desc = "UART clock selection 01: oscillator clock 10: 2 MHz clock Other values: reserved";
            sw = rw; hw = r;
            reset = 0x1;
        } uart_cksel[19:18];
        field {
            name = "uart2_cken";
            desc = "UART2 clock gating 0: Disable the clock. 1: Enable the clock.";
            sw = rw; hw = r;
            reset = 0x1;
        } uart2_cken[17:17];
        field {
            name = "uart1_cken";
            desc = "UART1 clock gating 0: Disable the clock. 1: Enable the clock.";
            sw = rw; hw = r;
            reset = 0x1;
        } uart1_cken[16:16];
        field {
            name = "uart0_cken";
            desc = "UART0 clock gating 0: Disable the clock. 1: Enable the clock.";
            sw = rw; hw = r;
            reset = 0x1;
        } uart0_cken[15:15];
        field {
            name = "reserved_14_14";
            desc = "Reserved";
            sw = rw; hw = r;
            reset = 0x0;
        } reserved_14_14[14:14];
        field {
            name = "reserved_13_13";
            desc = "Reserved";
            sw = r; hw = na;
            reset = 0x1;
        } reserved_13_13[13:13];
        field {
            name = "ir_cken";
            desc = "IR clock gating 0: Disable the clock. 1: Enable the clock.";
            sw = rw; hw = r;
            reset = 0x1;
        } ir_cken[12:12];
        field {
            name = "reserved_11_11";
            desc = "Reserved";
            sw = rw; hw = r;
            reset = 0x0;
        } reserved_11_11[11:11];
        field {
            name = "reserved_10_10";
            desc = "Reserved";
            sw = rw; hw = r;
            reset = 0x0;
        } reserved_10_10[10:10];
        field {
            name = "uart2_srst_req";
            desc = "UART2 soft reset 0: deassert reset 1: reset";
            sw = rw; hw = r;
            reset = 0x0;
        } uart2_srst_req[9:9];
        field {
            name = "uart1_srst_req";
            desc = "UART1 soft reset 0: deassert reset 1: reset";
            sw = rw; hw = r;
            reset = 0x0;
        } uart1_srst_req[8:8];
        field {
            name = "uart0_srst_req";
            desc = "UART0 soft reset 0: deassert reset 1: reset";
            sw = rw; hw = r;
            reset = 0x0;
        } uart0_srst_req[7:7];
        field {
            name = "reserved_6_6";
            desc = "Reserved";
            sw = r; hw = w;
            reset = 0x0;
        } reserved_6_6[6:6];
        field {
            name = "reserved_5_5";
            desc = "Reserved";
            sw = rw; hw = r;
            reset = 0x0;
        } reserved_5_5[5:5];
        field {
            name = "ir_srst_req";
            desc = "IR soft reset 0: deassert reset 1: reset";
            sw = rw; hw = r;
            reset = 0x0;
        } ir_srst_req[4:4];
        field {
            name = "rtc_srst_req";
            desc = "RTC soft reset 0: deassert reset 1: reset";
            sw = rw; hw = r;
            reset = 0x0;
        } rtc_srst_req[3:3];
        field {
            name = "reserved_2_2";
            desc = "Reserved";
            sw = rw; hw = r;
            reset = 0x0;
        } reserved_2_2[2:2];
        field {
            name = "i2c_srst_req";
            desc = "I2C soft reset 0: deassert reset 1: reset";
            sw = rw; hw = r;
            reset = 0x0;
        } i2c_srst_req[1:1];
        field {
            name = "test_clk_en";
            desc = "Test clock enable 0: All test clocks are disabled. 1: All test clocks are enabled.";
            sw = rw; hw = r;
            reset = 0x1;
        } test_clk_en[0:0];
    } PERI_CRG51 @ 0xCC;
    reg {
        name = "PERI_CRG52";
        desc = "PERI_CRG52 (offset 0xD0, total reset 0x00000000; PROVEN: Hi3536D V100 data sheet).";
        field {
            name = "reserved_31_6";
            desc = "Reserved";
            sw = r; hw = w;
            reset = 0x0;
        } reserved_31_6[31:6];
        field {
            name = "dpll_lock";
            desc = "DPLL lock status 0: unlocked 1: locked";
            sw = r; hw = w;
            reset = 0x0;
        } dpll_lock[5:5];
        field {
            name = "epll_lock";
            desc = "EPLL lock status 0: unlocked 1: locked";
            sw = r; hw = w;
            reset = 0x0;
        } epll_lock[4:4];
        field {
            name = "vpll2_lock";
            desc = "VPLL2 lock status 0: unlocked 1: locked";
            sw = r; hw = w;
            reset = 0x0;
        } vpll2_lock[3:3];
        field {
            name = "vpll1_lock";
            desc = "VPLL1 lock status 0: unlocked 1: locked";
            sw = r; hw = w;
            reset = 0x0;
        } vpll1_lock[2:2];
        field {
            name = "vpll0_lock";
            desc = "VPLL0 LOCK status 0: unlocked 1: locked";
            sw = r; hw = w;
            reset = 0x0;
        } vpll0_lock[1:1];
        field {
            name = "apll_lock";
            desc = "APLL lock status 0: unlocked 1: locked";
            sw = r; hw = w;
            reset = 0x0;
        } apll_lock[0:0];
    } PERI_CRG52 @ 0xD0;
    reg {
        name = "PERI_CRG53";
        desc = "PERI_CRG53 (offset 0xD4, total reset 0x00000004; PROVEN: Hi3536D V100 data sheet).";
        field {
            name = "reserved_31_13";
            desc = "Reserved ssmod divval[12:9]: SSMOD divval control    0x0: no frequency division    0x1: no frequency division    0x2: divided by 2    0x3: divided by 3    …    0xF: divided by 15 ssmod spread[8:4]: SSMOD spread control    0x00: 0%    0x01: 0.1%    0x02: 0.2%    0x03: 0.3%    0x04: 0.4%    0x05: 0.5%    0x06: 0.6%";
            sw = rw; hw = r;
            reset = 0x0;
        } reserved_31_13[31:13];
        field {
            name = "vpll0_ssmod_cfg";
            desc = "    0x07: 0.7%    ...    0x1F: 3.1% ssmod downspread[3]: SSMOD downspread control    0: reserved    1: down spread spectrum ssmod_disable[2]: SSMOD disable control    0: enabled    1: disabled ssmod_rst_req[1]: SSMOD reset control    0: not reset    1: reset ssmod_cken[0]: SSMOD clock gating, disabled by default    0: disabled    1: enabled";
            sw = rw; hw = r;
            reset = 0x4;
        } vpll0_ssmod_cfg[11:0];
    } PERI_CRG53 @ 0xD4;
    reg {
        name = "PERI_CRG54";
        desc = "PERI_CRG54 is a VPLL1 spread spectrum configuration register. (offset 0xD8, total reset 0x00000004; PROVEN: Hi3536D V100 data sheet).";
        field {
            name = "reserved_31_13";
            desc = "Reserved ssmod divval[12:9]: SSMOD divval control    0x0: no frequency division    0x1: no frequency division    0x2: divided by 2    0x3: divided by 3    …    0xF: divided by 15 ssmod spread[8:4]: SSMOD spread control    0x00: 0%    0x01: 0.1%    0x02: 0.2%    0x03: 0.3%    0x04: 0.4%    0x05: 0.5%    0x06: 0.6%";
            sw = rw; hw = r;
            reset = 0x0;
        } reserved_31_13[31:13];
        field {
            name = "vpll1_ssmod_cfg";
            desc = "    0x07: 0.7%    ...    0x1F: 3.1% ssmod downspread[3]: SSMOD downspread control    0: reserved    1: down spread spectrum ssmod_disable[2]: SSMOD disable control    0: enabled    1: disabled ssmod_rst_req[1]: SSMOD reset control    0: not reset    1: reset ssmod_cken[0]: SSMOD clock gating, disabled by default    0: disabled    1: enabled";
            sw = rw; hw = r;
            reset = 0x4;
        } vpll1_ssmod_cfg[12:0];
    } PERI_CRG54 @ 0xD8;
    reg {
        name = "PERI_CRG55";
        desc = "PERI_CRG55 is a VPLL2 spread spectrum configuration register. (offset 0xDC, total reset 0x00000004; PROVEN: Hi3536D V100 data sheet).";
        field {
            name = "reserved_31_13";
            desc = "Reserved ssmod divval[12:9]: SSMOD divval control    0x0: no frequency division    0x1: no frequency division    0x2: divided by 2    0x3: divided by 3    …    0xF: divided by 15 ssmod spread[8:4]: SSMOD spread control    0x00: 0%    0x01: 0.1%    0x02: 0.2%    0x03: 0.3%    0x04: 0.4%    0x05: 0.5%    0x06: 0.6%";
            sw = rw; hw = r;
            reset = 0x0;
        } reserved_31_13[31:13];
        field {
            name = "vpll2_ssmod_cfg";
            desc = "    0x07: 0.7%    ...    0x1F: 3.1% ssmod downspread[3]: SSMOD downspread control    0: reserved    1: down spread spectrum ssmod_disable[2]: SSMOD disable control    0: enabled    1: disabled ssmod_rst_req[1]: SSMOD reset control    0: not reset    1: reset ssmod_cken[0]: SSMOD clock gating, disabled by default    0: disabled    1: enabled";
            sw = rw; hw = r;
            reset = 0x4;
        } vpll2_ssmod_cfg[12:0];
    } PERI_CRG55 @ 0xDC;
    reg {
        name = "PERI_CRG56";
        desc = "PERI_CRG56 (offset 0xE0, total reset 0x00000004; PROVEN: Hi3536D V100 data sheet).";
        field {
            name = "reserved_31_13";
            desc = "Reserved ssmod divval[12:9]: SSMOD divval control    0x0: no frequency division    0x1: no frequency division    0x2: divided by 2    0x3: divided by 3    …    0xF: divided by 15 ssmod spread[8:4]: SSMOD spread control    0x00: 0%    0x01: 0.1%    0x02: 0.2%    0x03: 0.3%    0x04: 0.4%    0x05: 0.5%    0x06: 0.6%";
            sw = rw; hw = r;
            reset = 0x0;
        } reserved_31_13[31:13];
        field {
            name = "apll_ssmod_cfg";
            desc = "    0x07: 0.7%    ...    0x1F: 3.1% ssmod downspread[3]: SSMOD downspread control    0: reserved    1: down spread spectrum ssmod_disable[2]: SSMOD disable control    0: enabled    1: disabled ssmod_rst_req[1]: SSMOD reset control    0: not reset    1: reset ssmod_cken[0]: SSMOD clock gating, disabled by default    0: disabled    1: enabled";
            sw = rw; hw = r;
            reset = 0x4;
        } apll_ssmod_cfg[12:0];
    } PERI_CRG56 @ 0xE0;
    reg {
        name = "PERI_CRG57";
        desc = "PERI_CRG57 is an EPLL spread spectrum configuration register. (offset 0xE4, total reset 0x00000004; PROVEN: Hi3536D V100 data sheet).";
        field {
            name = "reserved_31_13";
            desc = "Reserved ssmod divval[12:9]: SSMOD divval control    0x0: no frequency division    0x1: no frequency division    0x2: divided by 2    0x3: divided by 3    …    0xF: divided by 15 ssmod spread[8:4]: SSMOD spread control    0x00: 0%    0x01: 0.1%    0x02: 0.2%    0x03: 0.3%    0x04: 0.4%    0x05: 0.5%    0x06: 0.6%";
            sw = rw; hw = r;
            reset = 0x0;
        } reserved_31_13[31:13];
        field {
            name = "epll_ssmod_cfg";
            desc = "    0x07: 0.7%    ...    0x1F: 3.1% ssmod downspread[3]: SSMOD downspread control    0: reserved    1: down spread spectrum ssmod_disable[2]: SSMOD disable control    0: enabled    1: disabled ssmod_rst_req[1]: SSMOD reset control    0: not reset    1: reset ssmod_cken[0]: SSMOD clock gating, disabled by default    0: disabled    1: enabled";
            sw = rw; hw = r;
            reset = 0x4;
        } epll_ssmod_cfg[12:0];
    } PERI_CRG57 @ 0xE4;
    reg {
        name = "PERI_CRG58";
        desc = "PERI_CRG58 is a DPLL spread spectrum configuration register. (offset 0xE8, total reset 0x00000004; PROVEN: Hi3536D V100 data sheet).";
        field {
            name = "reserved_31_13";
            desc = "Reserved ssmod divval[12:9]: SSMOD divval control    0x0: no frequency division    0x1: no frequency division    0x2: divided by 2    0x3: divided by 3    …    0xF: divided by 15 ssmod spread[8:4]: SSMOD spread control    0x00: 0%    0x01: 0.1%    0x02: 0.2%    0x03: 0.3%    0x04: 0.4%    0x05: 0.5%    0x06: 0.6%";
            sw = rw; hw = r;
            reset = 0x0;
        } reserved_31_13[31:13];
        field {
            name = "dpll_ssmod_cfg";
            desc = "    0x07: 0.7%    ...    0x1F: 3.1% ssmod downspread[3]: SSMOD downspread control    0: reserved    1: down spread spectrum ssmod_disable[2]: SSMOD disable control    0: enabled    1: disabled ssmod_rst_req[1]: SSMOD reset control    0: not reset    1: reset ssmod_cken[0]: SSMOD clock gating, disabled by default    0: disabled    1: enabled";
            sw = rw; hw = r;
            reset = 0x4;
        } dpll_ssmod_cfg[12:0];
    } PERI_CRG58 @ 0xE8;
    reg {
        name = "PERI_CRG_PLL60";
        desc = "PERI_CRG_PLL60 (offset 0xF0, total reset 0x00000000; PROVEN: Hi3536D V100 data sheet).";
        field {
            name = "reserved_31_1";
            desc = "Reserved mem_adjust_bypas";
            sw = rw; hw = r;
            reset = 0x0;
        } reserved_31_1[31:1];
        field {
            name = "f_0_";
            desc = "A7 high-speed memory speed adjustment mode non-bypass mode s 1: bypass mode";
            sw = rw; hw = r;
            reset = 0x0;
        } f_0_[0:0];
    } PERI_CRG_PLL60 @ 0xF0;
    reg {
        name = "PERI_CRG_PLL61";
        desc = "PERI_CRG_PLL61 is a VDH reset status register. (offset 0xF4, total reset 0x00000000; PROVEN: Hi3536D V100 data sheet).";
        field {
            name = "reserved_31_3";
            desc = "Reserved";
            sw = r; hw = w;
            reset = 0x0;
        } reserved_31_3[31:3];
        field {
            name = "vdh_all_rst_ok";
            desc = "Signal indicating the completion of the VDH soft rest 0: Soft reset is uncompleted. 1: Soft reset is completed.";
            sw = r; hw = w;
            reset = 0x0;
        } vdh_all_rst_ok[2:2];
        field {
            name = "vdh_mfd_rst_ok";
            desc = "Signal indicating the completion of the VDH MFD soft rest 0: Soft reset is uncompleted. 1: Soft reset is completed.";
            sw = r; hw = w;
            reset = 0x0;
        } vdh_mfd_rst_ok[1:1];
        field {
            name = "vdh_scd_rst_ok";
            desc = "Signal indicating the completion of the VDH SCD soft rest. 0: Soft reset is uncompleted. 1: Soft reset is completed. 3.3 Processor Subsystem The Hi3536D V100 uses the single-core ARM Cortex-A7 MPCore processor with the heterogeneous architecture.      850 MHz dominant working frequency      32 KB I-cache and 32 KB D-cache for the L1 cache      Integrated 128 KB 8-way set-associative L2 cache. T";
            sw = r; hw = w;
            reset = 0x0;
        } vdh_scd_rst_ok[0:0];
    } PERI_CRG_PLL61 @ 0xF4;
};

`endif
