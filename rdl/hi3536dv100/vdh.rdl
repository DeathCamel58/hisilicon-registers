`ifndef HI3536D_VDH_RDL
`define HI3536D_VDH_RDL

regfile eHI3536D_VDH {
    name = "VDH video decoder, V400R001 generation (H.264 / H.265), Hi3536D V100";
    desc = "VDH register window at 0x13200000 (GIC SPI 21 = interrupt bit 53 in the data sheet table 3-8). The data sheet has NO register table for the VDH (feature text only: H.265 Main@L4.1 and H.264 High@L4.2 up to 3072 x 3072, 4 x 1080p@20). Evidence: static disassembly of hi3536dv100_vfmw.ko (the HAL functions VDMHAL_V400R001_*, H264HAL_V400R001_*, HEVCHAL_V400R001_*) plus the GPL source of the later generation V400R004 for names and bit layouts. Every register and field carries PROVEN (offset and value seen in the Hi3536D vendor module), INFERRED (taken from V400R004 or from register semantics) or GUESS. Nothing was verified on hardware. The H.264 and HEVC paths use the same register set; HEVC differs only in the message words (see eHI3536D_VDH_PICMSG / SLICEMSG) and in BASIC_CFG0/1 values. Clock and reset: PERI_CRG41 (0x120400A4) bit 0 clock, bits 4/5/6 reset requests (MFD/SCD/ALL), status in PERI_CRG_PLL61 (0x120400F4) bits 1/2; VDM_OpenHardware writes 1 to CRG41 (one whole-register write, no PLL61 wait afterwards) and, when the chip-revision byte at 0x12060024 equals 2, ORs 0xC. ResetVdm/ResetGlb (0x16ddc/0x16ed8) set CRG41 bit 4 / 6, poll PLL61 bit 1 / 2 up to 1000 x 30 us, only log on timeout, clear the bit and restore INT_MASK. The vendor software watchdog is 5000 ms (VDMDRV_CheckDevice 0x113a4). No VDH clock select exists in vfmw/vdec or the data sheet: the rate is open. Documented in docs/research/hi3536dv100-blocks.md.";

    reg {
        name = "Decode start";
        desc = "Pulse 0, 1, 0 starts decoding one picture (slice chain). PROVEN: VDMHAL_V400R001_StartHwDecode writes 0,1,0 after INT_MASK. Provenance: PROVEN. Source: hi3536dv100_vfmw.ko (VDMHAL_V400R001 / HEVCHAL_V400R001 disassembly, SDK 2.0.2.0).";
        field {
            name = "dec_start";
            desc = "1 starts the decode [PROVEN]";
            sw = rw;
            hw = r;
        } dec_start[0:0];
    } VDH_START @ 0x0;

    reg {
        name = "Repair start";
        desc = "Hardware error-repair copy start (pulse). Not used by the paths read. Provenance: INFERRED. Source: Huawei Kirin GPL VDH V400R004 header vdm_hal_local.h (a later generation of the same VDH).";
        field {
            name = "repair_start";
            desc = "start repair [INFERRED]";
            sw = rw;
            hw = r;
        } repair_start[0:0];
    } VDH_REPAIR @ 0x4;

    reg {
        name = "Basic configuration 0";
        desc = "HEVC path value: mbamt_to_dec = CTB count - 1, bit 24 set, bit 30 = scaling_list_enabled_flag, bit 28 is set by R001 for BOTH codecs, unconditionally (PROVEN: HEVC byte 3 = 0x11 | scaling_list_enabled_flag << 6, H.264 byte 3 = 0x51: bits 24, 28, 30 always set; the R004 name luma_sum_en is INFERRED from BackupInfo always reading the luma sum and histogram registers), bit 23 = 0. Not a codec difference. Provenance: PROVEN for offset, mbamt, bits 24/28/30 (2026-11-22 dynamic: mbamt 509 gives 0x110001FD, with a scaling list 0x510001FD). Source: hi3536dv100_vfmw.ko (VDMHAL_V400R001 / HEVCHAL_V400R001 disassembly, SDK 2.0.2.0); field names Huawei Kirin GPL VDH V400R004 header vdm_hal_local.h (a later generation of the same VDH).";
        field {
            name = "mbamt_to_dec";
            desc = "Macroblock/CTB count to decode minus 1 [PROVEN]";
            sw = rw;
            hw = r;
        } mbamt_to_dec[19:0];
        field {
            name = "memory_clock_gating_en";
            desc = "Memory clock gating enable (name from R004; R001 leaves 0) [INFERRED]";
            sw = rw;
            hw = r;
        } memory_clock_gating_en[20:20];
        field {
            name = "module_clock_gating_en";
            desc = "Module clock gating enable (R004; R001 leaves 0) [INFERRED]";
            sw = rw;
            hw = r;
        } module_clock_gating_en[21:21];
        field {
            name = "marker_bit_detect_en";
            desc = "MPEG-4 marker bit detect (0) [INFERRED]";
            sw = rw;
            hw = r;
        } marker_bit_detect_en[22:22];
        field {
            name = "ac_last_detect_en";
            desc = "AC last detect (0 in R001) [PROVEN]";
            sw = rw;
            hw = r;
        } ac_last_detect_en[23:23];
        field {
            name = "coef_idx_detect_en";
            desc = "Coefficient index detect (1 in R001) [PROVEN]";
            sw = rw;
            hw = r;
        } coef_idx_detect_en[24:24];
        field {
            name = "vop_type_detect_en";
            desc = "VOP type detect (0) [INFERRED]";
            sw = rw;
            hw = r;
        } vop_type_detect_en[25:25];
        field {
            name = "work_mode";
            desc = "Work mode (R004 HEVC struct; R001 writes 0) [INFERRED]";
            sw = rw;
            hw = r;
        } work_mode[27:26];
        field {
            name = "luma_sum_en";
            desc = "R001 writes 1 for both codecs, unconditionally; name from R004 (luma sum statistics enable) [PROVEN value, INFERRED meaning]";
            sw = rw;
            hw = r;
        } luma_sum_en[28:28];
        field {
            name = "luma_histogram_en";
            desc = "Luma histogram enable (0) [INFERRED]";
            sw = rw;
            hw = r;
        } luma_histogram_en[29:29];
        field {
            name = "load_qmatrix_flag";
            desc = "Load scaling list (HEVC: scaling_list_enabled_flag; H.264: hard 1, the scaling matrix is always loaded) [PROVEN]";
            sw = rw;
            hw = r;
        } load_qmatrix_flag[30:30];
        field {
            name = "vdh_safe_flag";
            desc = "Secure mode flag (0 in the normal build) [INFERRED]";
            sw = rw;
            hw = r;
        } vdh_safe_flag[31:31];
    } BASIC_CFG0 @ 0x8;

    reg {
        name = "Basic configuration 1";
        desc = "HEVC value built by HEVCHAL_V400R001_CfgVdmReg: [3:0] video_standard 0xD, bit 15 mv_output_en 1, bit 14 fst_slc_grp = NewPicFlag, bit 13 uv_order_en 0 (hard), [27:16] max_slcgrp_num 3, bit 28 0, bit 29 = output format select (below), bit 30 frm_cmp_en = Compress_en, bit 31 0; example 0x2003C00D (1080p, linear, no compression) or 0x0003C00D (TILE64). H.264 (H264HAL_V400R001_StartDec): video_standard 0, [12:4] ddr_stride = stride >> 6, bit 14 NewPicFlag, [27:16] max_slcgrp_num 4, bit 29 = the same format select, bits 13/15/28/30/31 0. OUTPUT FORMAT (M1, 2026-11-22): bit 29 is NOT the constant 1 of the R004 source. It is a per-channel software choice: vdec.ko VdecGenChanCfg (0x6f88) sets channel-config word +0x64 = (enVideoFormat == VIDEO_FORMAT_LINEAR), VCTRL_ConfigChan (0xad5c) copies it to chan+0x5d8 and both StartDec paths insert that byte at bit 29. Dynamic: LINEAR gives 1, TILE64 gives 0. So bit 29 = 1: raster (linear, semi-planar) output; bit 29 = 0: TILE64 (64 x 16 tiles, the HiMPP default). R004 hard-sets it to 1 (its platform outputs linear). Compression (bit 30) is only allowed with TILE64 (vdec rejects LINEAR + compress: only LINEAR/NONE, TILE64/NONE, TILE64/SEG128 are valid). Provenance: PROVEN for video_standard, max_slcgrp_num; others INFERRED. Source: hi3536dv100_vfmw.ko (VDMHAL_V400R001 / HEVCHAL_V400R001 disassembly, SDK 2.0.2.0); names Huawei Kirin GPL VDH V400R004 header vdm_hal_local.h (a later generation of the same VDH). BOARD 2026-11-23: reset value 0x20008000 (bits 29 and 15 set); with bit 13 = 1 the output is NV12.";
        field {
            name = "video_standard";
            desc = "0 = H.264, 0xD = HEVC (the module dispatches on standard code 0 / 16 = H.264 / HEVC) [PROVEN]";
            sw = rw;
            hw = r;
        } video_standard[3:0];
        field {
            name = "reserved_12_4";
            desc = "reserved for HEVC (0); H.264: ddr_stride = YSTRIDE_1D >> 6 in [12:4] [PROVEN for H.264 R001, dynamic StartDec run]";
            sw = r;
            hw = r;
        } reserved_12_4[12:4];
        field {
            name = "uv_order_en";
            desc = "Chroma order swap: R004 sets it from the channel option u8UVOrder (0: uv, 1: vu), because the HEVC CRC check is NV12; R001 HEVC writes 0 (hard) [PROVEN value, INFERRED meaning; 0 = UV order = NV12 per the vfmw comment, to be confirmed by a colored test frame] BOARD 2026-11-23 (Hi3536D, hevc and h264, FFmpeg reference): 1 = NV12 (U first, the layout a V4L2 NV12 client expects), 0 = NV21 (V first). The vendor value 0 is the NV21 order; our driver and kit must set the bit. [PROVEN]";
            sw = rw;
            hw = r;
        } uv_order_en[13:13];
        field {
            name = "fst_slc_grp";
            desc = "first slice group of a picture [INFERRED]";
            sw = rw;
            hw = r;
        } fst_slc_grp[14:14];
        field {
            name = "mv_output_en";
            desc = "write motion vectors to DDR (HEVC: 1 [PROVEN]; H.264: 0) [INFERRED meaning]";
            sw = rw;
            hw = r;
        } mv_output_en[15:15];
        field {
            name = "max_slcgrp_num";
            desc = "max slice groups per batch (HEVC 3, H.264 4) [PROVEN]";
            sw = rw;
            hw = r;
        } max_slcgrp_num[27:16];
        field {
            name = "line_num_output_en";
            desc = "line number output (0) [INFERRED]";
            sw = rw;
            hw = r;
        } line_num_output_en[28:28];
        field {
            name = "vdh_2d_en";
            desc = "Output format select, 2026-11-22: 1 = linear raster output (VIDEO_FORMAT_LINEAR), 0 = TILE64 (default of the vendor stack). Per-channel option, see the register text. Name from R004 (hard 1 there). [PROVEN source and polarity of the vendor value, INFERRED hardware meaning] BOARD 2026-11-23: the register reads 0x20008000 after the power-on reset, so bit 29 is 1 by default; 1 = linear raster NV12 with stride = YSTRIDE_1D/16 (byte exact on 128x128 .. 1920x1080 and 2304x128, both codecs); 0 = a tiled layout: 64 byte rows, 1024 byte tiles (16 rows), the first tile in row order, the second tile starts at +1024 with the rows in a different order (not decoded further; not the simple row-major 64 x 16 tiling). [PROVEN polarity]";
            sw = rw;
            hw = r;
        } vdh_2d_en[29:29];
        field {
            name = "frm_cmp_en";
            desc = "frame compression (Compress_en): only with TILE64 + COMPRESS_MODE_SEG128 in the vendor stack; needs the compression header (HEAD_INF_OFFSET, UVOFFSET_1D includes the header) [INFERRED]";
            sw = rw;
            hw = r;
        } frm_cmp_en[30:30];
        field {
            name = "ppfd_en";
            desc = "PPFD enable (0) [INFERRED]";
            sw = rw;
            hw = r;
        } ppfd_en[31:31];
    } BASIC_CFG1 @ 0xC;

    reg {
        name = "Down message (AV) address";
        desc = "Physical address of the picture+slice message chain, bits [3:0] zero. PROVEN: stored as MsgSlotAddr & 0xFFFFFFF0. Provenance: PROVEN. Source: hi3536dv100_vfmw.ko (VDMHAL_V400R001 / HEVCHAL_V400R001 disassembly, SDK 2.0.2.0).";
        field {
            name = "av_msg_addr";
            desc = "message pool address >> 0, 16-byte aligned [PROVEN]";
            sw = rw;
            hw = r;
        } av_msg_addr[31:0];
    } AVM_ADDR @ 0x10;

    reg {
        name = "Up message (VA) address";
        desc = "Physical address of the up (report) message, 16-byte aligned. PROVEN. Provenance: PROVEN. Source: hi3536dv100_vfmw.ko (VDMHAL_V400R001 / HEVCHAL_V400R001 disassembly, SDK 2.0.2.0).";
        field {
            name = "va_msg_addr";
            desc = "up message address [PROVEN]";
            sw = rw;
            hw = r;
        } va_msg_addr[31:0];
    } VAM_ADDR @ 0x14;

    reg {
        name = "Stream base address";
        desc = "Physical start of the stream buffer, & ~0xF. PROVEN; slice offsets in the message are relative to it. Provenance: PROVEN. Source: hi3536dv100_vfmw.ko (VDMHAL_V400R001 / HEVCHAL_V400R001 disassembly, SDK 2.0.2.0). BOARD 2026-11-23: reset value 0xFFFFFF00 (restored by the all reset); 0x12345670 latches. HEVC valid bits (slice message D2) must include the rbsp stop bit (+1), H.264 CABAC includes it and CAVLC does not (exact: +-1 flags an error or corrupts); the hardware does NOT remove emulation prevention bytes: a 00 00 03 inside the slice data decodes wrong, the same stream without the 03 byte exact (HEVC and H.264).";
        field {
            name = "stream_base_addr";
            desc = "stream base [PROVEN]";
            sw = rw;
            hw = r;
        } stream_base_addr[31:0];
    } STREAM_BASE_ADDR @ 0x18;

    reg {
        name = "VDH state";
        desc = "Decoded slice count, over/error status and version id. R004 layout; offset 0x1C INFERRED. [18:17] == 01 is the only success value the vendor accepts (anything else = failed picture; MPEG-2 tests bit 17 only): PROVEN, VDMHAL_V400R001_MakeDecReport (0x17a80), dynamic with injected values. [16:0] = decoded slice count, forced to 0 when above 300 (R004: 200). version_id [26:19] is NEVER read or extracted by hi3536dv100_vfmw.ko (PROVEN absence); in the R004 low-delay code bit 19 acts as a class bit next to bit 17, which does not fit a plain 8-bit version id: the field is unverified, the Hi3536D value needs a board read. Provenance: PROVEN for [18:0], INFERRED for the rest. Source: Huawei Kirin GPL VDH V400R004 header vdm_hal_local.h (a later generation of the same VDH). BOARD 2026-11-23: after power-on 0x0001c5e0 (meaningless slice count, id field 0), NOT cleared by a block reset (keeps the last picture: 0x00020001 after a clean one, 0x00060001 after a flagged one); a clean picture reads slice count 1, [18:17] = 01.";
        field {
            name = "decoded_slice_num";
            desc = "decoded slice count (MakeDecReport: ubfx 0,17; > 300 is an error) [PROVEN] BOARD 2026-11-23 (run 2): equals the number of slices of the picture: 1, 3 and 4 seen (0x00020003, 0x00020004 for a clean picture, 0x00060004 flagged), P and B pictures included; one up message record per slice.";
            sw = r;
            hw = r;
        } decoded_slice_num[16:0];
        field {
            name = "intrs_vdh_dec_over";
            desc = "decode over; with bit 18 clear = success [PROVEN] BOARD 2026-11-23: 1 after every picture, clean or damaged.";
            sw = r;
            hw = r;
        } intrs_vdh_dec_over[17:17];
        field {
            name = "intrs_vdh_dec_err";
            desc = "decode error; the vendor treats [18:17] != 01 as a failed picture [PROVEN] BOARD 2026-11-23: 0 for a clean picture. 1 for a damaged slice (up message last block stops short) and also for a HEVC picture whose slice valid-bits count (D2) does not include the stop bit (output still byte exact), and for many H.264 CABAC pictures that decode byte exact with a correct D2 (SED_STA 0x1014 reads 0x14210000 instead of 0x14000000, 0x1004 bit 18 clear instead of set; CAVLC and HEVC are clean); cause of the H.264 CABAC case not found. [PROVEN observation, meaning OPEN] BOARD run 2 (2026-11-23, 91 + 85 pictures read through the driver): the flag appears only on H.264 CABAC pictures (55 of 91, I, P and B, 1 to 4 slices); never on CAVLC or HEVC pictures (85 pictures, P and B included, up to 4 slices). 19 of 20 deliberately damaged pictures (flipped, overwritten, junk, truncated slice data; H.264 CABAC and CAVLC, HEVC) read 1 here and their last up message record stops short of the last block (W2 0x7, 0x11, 0x17, 0x2f, 0x18 ... instead of 0x3f, W0 bit 31 set); the 20th, a flipped bit in a CAVLC picture that stays valid syntax, reads clean (0x00020001) and decodes with wrong chroma: the status cannot tell valid-syntax damage.";
            sw = r;
            hw = r;
        } intrs_vdh_dec_err[18:18];
        field {
            name = "version_id";
            desc = "R004 name hardware version; never read by the R001 module; unverified (board read) [INFERRED, unused] BOARD 2026-11-23: reads 0 on a Hi3536D V100 (idle value after power-on 0x0001c5e0, after a picture 0x00020001).";
            sw = r;
            hw = r;
        } version_id[26:19];
        field {
            name = "reserved_31_27";
            desc = "reserved [INFERRED]";
            sw = r;
            hw = r;
        } reserved_31_27[31:27];
    } VDH_STATE @ 0x1C;

    reg {
        name = "Interrupt status";
        desc = "PROVEN: ClearIntState writes 0xFFFFFFFF (write-1-to-clear: R004 clears single bits with 0xFFFFFFF4 / 0xFFFFFFF1 in its low-delay path). The ISR (VDMDRV_VdmIntServProc 0x116f0) examines ONLY bit 0: a picture is finished when INT_STATE[0] is set; failure is then read from VDH_STATE[18:17]. Bit 1 (R004 name dec_err) is never read by the R001 module. Bit 2 is the R004 low-delay line-number interrupt, unused by R001. Provenance: PROVEN (offset, clear, bit 0 use); bit 1 meaning INFERRED. Source: hi3536dv100_vfmw.ko (VDMHAL_V400R001 / HEVCHAL_V400R001 disassembly, SDK 2.0.2.0); names Huawei Kirin GPL VDH V400R004 header vdm_hal_local.h (a later generation of the same VDH). BOARD 2026-11-23: 0 after reset, 1 after every finished picture (clean, damaged and flagged), INT_MASK 0xFFFFFFFE; the up message of a damaged picture shows the stop (W2 = last block reached).";
        field {
            name = "intrs_vdm_dec_over";
            desc = "decode finished (the only bit the vendor ISR tests; whether it also fires on a failed picture is INFERRED, board test) [PROVEN use]";
            sw = rw;
            hw = r;
        } intrs_vdm_dec_over[0:0];
        field {
            name = "intrs_vdm_dec_err";
            desc = "decode error (R004 name); never examined by the R001 module [INFERRED]";
            sw = rw;
            hw = r;
        } intrs_vdm_dec_err[1:1];
        field {
            name = "reserved_31_2";
            desc = "reserved [INFERRED]";
            sw = r;
            hw = r;
        } reserved_31_2[31:2];
    } INT_STATE @ 0x20;

    reg {
        name = "Interrupt mask";
        desc = "PROVEN: EnableInt/StartHwDecode write 0xFFFFFFFE (bit 0 unmasked, 1 = masked); the low-delay build 0xFFFFFFFA (bits 0 and 2 enabled), the busy-wait build 0xFFFFFFFF (all masked, status polled; polarity from the three R004 values). ResetVdm/ResetGlb save and restore it around the reset. Provenance: PROVEN. Source: hi3536dv100_vfmw.ko (VDMHAL_V400R001 / HEVCHAL_V400R001 disassembly, SDK 2.0.2.0).";
        field {
            name = "mask_dec_over";
            desc = "0 = interrupt enabled [PROVEN] BOARD 2026-11-23: the register has 3 implemented bits, reset value 7 (all masked), write 0xFFFFFFFE reads 6; bit 0 = 0 fires on every finished picture. [PROVEN]";
            sw = rw;
            hw = r;
        } mask_dec_over[0:0];
        field {
            name = "mask_dec_err";
            desc = "0 = interrupt enabled (0xFFFFFFFE leaves it masked) [PROVEN]";
            sw = rw;
            hw = r;
        } mask_dec_err[1:1];
        field {
            name = "reserved_31_2";
            desc = "reserved [INFERRED]";
            sw = r;
            hw = r;
        } reserved_31_2[31:2];
    } INT_MASK @ 0x24;

    reg {
        name = "VCTRL state";
        desc = "PROVEN: IsVdmRun reads this register and treats value 1 as idle. Provenance: PROVEN. Source: hi3536dv100_vfmw.ko (VDMHAL_V400R001 / HEVCHAL_V400R001 disassembly, SDK 2.0.2.0).";
        field {
            name = "vctrl_state";
            desc = "1 = idle, else running [PROVEN]";
            sw = r;
            hw = r;
        } vctrl_state[31:0];
    } VCTRL_STATE @ 0x28;

    reg {
        name = "AXI master id / outstanding";
        desc = "R004 location; in R001 the EMAR_ID value is written in the SCD top window (0x1320C004), not here. Provenance: INFERRED. Source: Huawei Kirin GPL VDH V400R004 header vdm_hal_local.h (a later generation of the same VDH).";
        field {
            name = "emar_id";
            desc = "AXI master configuration [INFERRED]";
            sw = rw;
            hw = r;
        } emar_id[31:0];
    } EMAR_ID @ 0x30;

    reg {
        name = "Sed To";
        desc = "Module timeout counter. PROVEN: HEVC CfgVdmReg writes 0x00300C03 to every timeout register 0x3C-0x54. Provenance: PROVEN. Source: hi3536dv100_vfmw.ko (VDMHAL_V400R001 / HEVCHAL_V400R001 disassembly, SDK 2.0.2.0).";
        field {
            name = "sed_to";
            desc = "timeout value, written 0x00300C03 [PROVEN]";
            sw = rw;
            hw = r;
        } sed_to[31:0];
    } SED_TO @ 0x3C;

    reg {
        name = "Itrans To";
        desc = "Module timeout counter. PROVEN: HEVC CfgVdmReg writes 0x00300C03 to every timeout register 0x3C-0x54. Provenance: PROVEN. Source: hi3536dv100_vfmw.ko (VDMHAL_V400R001 / HEVCHAL_V400R001 disassembly, SDK 2.0.2.0).";
        field {
            name = "itrans_to";
            desc = "timeout value, written 0x00300C03 [PROVEN]";
            sw = rw;
            hw = r;
        } itrans_to[31:0];
    } ITRANS_TO @ 0x40;

    reg {
        name = "Pmv To";
        desc = "Module timeout counter. PROVEN: HEVC CfgVdmReg writes 0x00300C03 to every timeout register 0x3C-0x54. Provenance: PROVEN. Source: hi3536dv100_vfmw.ko (VDMHAL_V400R001 / HEVCHAL_V400R001 disassembly, SDK 2.0.2.0).";
        field {
            name = "pmv_to";
            desc = "timeout value, written 0x00300C03 [PROVEN]";
            sw = rw;
            hw = r;
        } pmv_to[31:0];
    } PMV_TO @ 0x44;

    reg {
        name = "Prc To";
        desc = "Module timeout counter. PROVEN: HEVC CfgVdmReg writes 0x00300C03 to every timeout register 0x3C-0x54. Provenance: PROVEN. Source: hi3536dv100_vfmw.ko (VDMHAL_V400R001 / HEVCHAL_V400R001 disassembly, SDK 2.0.2.0).";
        field {
            name = "prc_to";
            desc = "timeout value, written 0x00300C03 [PROVEN]";
            sw = rw;
            hw = r;
        } prc_to[31:0];
    } PRC_TO @ 0x48;

    reg {
        name = "Rcn To";
        desc = "Module timeout counter. PROVEN: HEVC CfgVdmReg writes 0x00300C03 to every timeout register 0x3C-0x54. Provenance: PROVEN. Source: hi3536dv100_vfmw.ko (VDMHAL_V400R001 / HEVCHAL_V400R001 disassembly, SDK 2.0.2.0).";
        field {
            name = "rcn_to";
            desc = "timeout value, written 0x00300C03 [PROVEN]";
            sw = rw;
            hw = r;
        } rcn_to[31:0];
    } RCN_TO @ 0x4C;

    reg {
        name = "Dblk To";
        desc = "Module timeout counter. PROVEN: HEVC CfgVdmReg writes 0x00300C03 to every timeout register 0x3C-0x54. Provenance: PROVEN. Source: hi3536dv100_vfmw.ko (VDMHAL_V400R001 / HEVCHAL_V400R001 disassembly, SDK 2.0.2.0).";
        field {
            name = "dblk_to";
            desc = "timeout value, written 0x00300C03 [PROVEN]";
            sw = rw;
            hw = r;
        } dblk_to[31:0];
    } DBLK_TO @ 0x50;

    reg {
        name = "Ppfd To";
        desc = "Module timeout counter. PROVEN: HEVC CfgVdmReg writes 0x00300C03 to every timeout register 0x3C-0x54. Provenance: PROVEN. Source: hi3536dv100_vfmw.ko (VDMHAL_V400R001 / HEVCHAL_V400R001 disassembly, SDK 2.0.2.0).";
        field {
            name = "ppfd_to";
            desc = "timeout value, written 0x00300C03 [PROVEN]";
            sw = rw;
            hw = r;
        } ppfd_to[31:0];
    } PPFD_TO @ 0x54;

    reg {
        name = "Luma frame address (1D)";
        desc = "PROVEN: ImgPhyAddr & 0xFFFFFF00 (256-byte aligned). Provenance: PROVEN. Source: hi3536dv100_vfmw.ko (VDMHAL_V400R001 / HEVCHAL_V400R001 disassembly, SDK 2.0.2.0).";
        field {
            name = "ystaddr_1d";
            desc = "luma base address of the output picture [PROVEN]";
            sw = rw;
            hw = r;
        } ystaddr_1d[31:0];
    } YSTADDR_1D @ 0x60;

    reg {
        name = "Luma stride";
        desc = "PROVEN: imgstride = fs_image.image_stride = ArrangeMem VahbStride = 16 x the line stride in bytes (R004 comment: ystride x 16; vdec VDEC_PackFrameInfo reports u32Stride = image_stride >> 4). The line stride is ALIGN64(width) (VDMHAL_V400R001_ArrangeMem, 80 dynamic points). The same register value is programmed for TILE64 and linear output (INFERRED: the hardware takes the distance of 16 lines in both layouts). Provenance: PROVEN. Source: hi3536dv100_vfmw.ko (VDMHAL_V400R001 / HEVCHAL_V400R001 disassembly, SDK 2.0.2.0).";
        field {
            name = "ystride_1d";
            desc = "16 x line stride in bytes (= bytes between 16-line groups) [PROVEN value rule, INFERRED hardware reading]";
            sw = rw;
            hw = r;
        } ystride_1d[31:0];
    } YSTRIDE_1D @ 0x64;

    reg {
        name = "Chroma offset";
        desc = "PROVEN: UVOffset = chrom_phy_addr - luma_phy_addr in bytes = line stride x aligned height (+ compression header when frm_cmp_en): the height is ALIGN16(H) rounded up to 64 for HEVC (to 16 for H.264), ArrangeMem +0x110. Same rule for TILE64 and linear. Provenance: PROVEN. Source: hi3536dv100_vfmw.ko (VDMHAL_V400R001 / HEVCHAL_V400R001 disassembly, SDK 2.0.2.0).";
        field {
            name = "uvoffset_1d";
            desc = "chroma plane offset in bytes from the luma base [PROVEN]";
            sw = rw;
            hw = r;
        } uvoffset_1d[31:0];
    } UVOFFSET_1D @ 0x68;

    reg {
        name = "Header info offset (compression)";
        desc = "PROVEN: written 0 without compression; with frm_cmp_en = 1 HEVCHAL_V400R001_CfgVdmReg writes ((H + 63) >> 6) << 5 times (((W + 2047) >> 7) & ~0xF) (1080p: 0x2200; H = ctx+0xb8, W = ctx+0xbc). Provenance: PROVEN. Source: hi3536dv100_vfmw.ko (VDMHAL_V400R001 / HEVCHAL_V400R001 disassembly, SDK 2.0.2.0).";
        field {
            name = "head_inf_offset";
            desc = "compression header offset [PROVEN]";
            sw = rw;
            hw = r;
        } head_inf_offset[31:0];
    } HEAD_INF_OFFSET @ 0x6C;

    reg {
        name = "Line number output address";
        desc = "R004 alias PRCMEM1_1D_CNT; written only with the low-delay build option. Provenance: INFERRED. Source: Huawei Kirin GPL VDH V400R004 header vdm_hal_local.h (a later generation of the same VDH).";
        field {
            name = "line_num_staddr";
            desc = "line number buffer [INFERRED]";
            sw = rw;
            hw = r;
        } line_num_staddr[31:0];
    } LINE_NUM_STADDR @ 0x70;

    reg {
        name = "PPFD buffer address";
        desc = "PROVEN offset, value 0 (PPFD unused). Provenance: PROVEN. Source: hi3536dv100_vfmw.ko (VDMHAL_V400R001 / HEVCHAL_V400R001 disassembly, SDK 2.0.2.0).";
        field {
            name = "ppfd_buf_addr";
            desc = "PPFD buffer [PROVEN]";
            sw = rw;
            hw = r;
        } ppfd_buf_addr[31:0];
    } PPFD_BUF_ADDR @ 0x80;

    reg {
        name = "PPFD buffer length";
        desc = "PROVEN offset, value 0. Provenance: PROVEN. Source: hi3536dv100_vfmw.ko (VDMHAL_V400R001 / HEVCHAL_V400R001 disassembly, SDK 2.0.2.0).";
        field {
            name = "ppfd_buf_len";
            desc = "length [PROVEN]";
            sw = rw;
            hw = r;
        } ppfd_buf_len[15:0];
        field {
            name = "reserved_31_16";
            desc = "reserved [INFERRED]";
            sw = r;
            hw = r;
        } reserved_31_16[31:16];
    } PPFD_BUF_LEN @ 0x84;

    reg {
        name = "Reference picture type";
        desc = "2 bits per reference picture (16 entries); R004 layout. Offset PROVEN: H264HAL_V400R001_StartDec writes 0x94 (arm-re path-sensitive scan, 2026-11-12); not written on the HEVC path. Provenance: PROVEN offset; fields INFERRED. Source: hi3536dv100_vfmw.ko (VDMHAL_V400R001 / HEVCHAL_V400R001 disassembly, SDK 2.0.2.0); Huawei Kirin GPL VDH V400R004 header vdm_hal_local.h (a later generation of the same VDH).";
        field {
            name = "ref_pic_type_0";
            desc = "reference type [INFERRED]";
            sw = rw;
            hw = r;
        } ref_pic_type_0[1:0];
        field {
            name = "ref_pic_type_1";
            desc = "reference type [INFERRED]";
            sw = rw;
            hw = r;
        } ref_pic_type_1[3:2];
        field {
            name = "ref_pic_type_2";
            desc = "reference type [INFERRED]";
            sw = rw;
            hw = r;
        } ref_pic_type_2[5:4];
        field {
            name = "ref_pic_type_3";
            desc = "reference type [INFERRED]";
            sw = rw;
            hw = r;
        } ref_pic_type_3[7:6];
        field {
            name = "ref_pic_type_4";
            desc = "reference type [INFERRED]";
            sw = rw;
            hw = r;
        } ref_pic_type_4[9:8];
        field {
            name = "ref_pic_type_5";
            desc = "reference type [INFERRED]";
            sw = rw;
            hw = r;
        } ref_pic_type_5[11:10];
        field {
            name = "ref_pic_type_6";
            desc = "reference type [INFERRED]";
            sw = rw;
            hw = r;
        } ref_pic_type_6[13:12];
        field {
            name = "ref_pic_type_7";
            desc = "reference type [INFERRED]";
            sw = rw;
            hw = r;
        } ref_pic_type_7[15:14];
        field {
            name = "ref_pic_type_8";
            desc = "reference type [INFERRED]";
            sw = rw;
            hw = r;
        } ref_pic_type_8[17:16];
        field {
            name = "ref_pic_type_9";
            desc = "reference type [INFERRED]";
            sw = rw;
            hw = r;
        } ref_pic_type_9[19:18];
        field {
            name = "ref_pic_type_10";
            desc = "reference type [INFERRED]";
            sw = rw;
            hw = r;
        } ref_pic_type_10[21:20];
        field {
            name = "ref_pic_type_11";
            desc = "reference type [INFERRED]";
            sw = rw;
            hw = r;
        } ref_pic_type_11[23:22];
        field {
            name = "ref_pic_type_12";
            desc = "reference type [INFERRED]";
            sw = rw;
            hw = r;
        } ref_pic_type_12[25:24];
        field {
            name = "ref_pic_type_13";
            desc = "reference type [INFERRED]";
            sw = rw;
            hw = r;
        } ref_pic_type_13[27:26];
        field {
            name = "ref_pic_type_14";
            desc = "reference type [INFERRED]";
            sw = rw;
            hw = r;
        } ref_pic_type_14[29:28];
        field {
            name = "ref_pic_type_15";
            desc = "reference type [INFERRED]";
            sw = rw;
            hw = r;
        } ref_pic_type_15[31:30];
    } REF_PIC_TYPE @ 0x94;

    reg {
        name = "Frame-flush / adaptive enable";
        desc = "PROVEN offset and value: HEVC CfgVdmReg writes 0 (R004 writes 2); H264HAL_V400R001_StartDec writes 2 for a progressive frame picture and 0 for field pictures or MBAFF (dynamic run). Provenance: PROVEN. Source: hi3536dv100_vfmw.ko (VDMHAL_V400R001 / HEVCHAL_V400R001 disassembly, SDK 2.0.2.0).";
        field {
            name = "ff_apt_en";
            desc = "enable: H.264 progressive frame writes 2 (bit 1 of the value, not this bit 0), HEVC 0 [PROVEN values, INFERRED meaning]";
            sw = rw;
            hw = r;
        } ff_apt_en[0:0];
        field {
            name = "reserved_31_1";
            desc = "reserved [INFERRED]";
            sw = r;
            hw = r;
        } reserved_31_1[31:1];
    } FF_APT_EN @ 0x98;

    reg {
        name = "Decode cycles per picture";
        desc = "Performance counter (R004). Provenance: INFERRED. Source: Huawei Kirin GPL VDH V400R004 header vdm_hal_local.h (a later generation of the same VDH).";
        field {
            name = "dec_cycleperpic";
            desc = "cycles [INFERRED]";
            sw = r;
            hw = r;
        } dec_cycleperpic[31:0];
    } DEC_CYCLEPERPIC @ 0xB0;

    reg {
        name = "Read bandwidth per picture";
        desc = "Counter (R004). Provenance: INFERRED. Source: Huawei Kirin GPL VDH V400R004 header vdm_hal_local.h (a later generation of the same VDH).";
        field {
            name = "rd_bdwidth_perpic";
            desc = "bytes [INFERRED]";
            sw = r;
            hw = r;
        } rd_bdwidth_perpic[31:0];
    } RD_BDWIDTH_PERPIC @ 0xB4;

    reg {
        name = "Write bandwidth per picture";
        desc = "Counter (R004). Provenance: INFERRED. Source: Huawei Kirin GPL VDH V400R004 header vdm_hal_local.h (a later generation of the same VDH).";
        field {
            name = "wr_bdwidth_perpic";
            desc = "bytes [INFERRED]";
            sw = r;
            hw = r;
        } wr_bdwidth_perpic[31:0];
    } WR_BDWIDTH_PERPIC @ 0xB8;

    reg {
        name = "Read requests per picture";
        desc = "Counter (R004). Provenance: INFERRED. Source: Huawei Kirin GPL VDH V400R004 header vdm_hal_local.h (a later generation of the same VDH).";
        field {
            name = "rd_req_perpic";
            desc = "requests [INFERRED]";
            sw = r;
            hw = r;
        } rd_req_perpic[31:0];
    } RD_REQ_PERPIC @ 0xBC;

    reg {
        name = "Write requests per picture";
        desc = "Counter (R004). Provenance: INFERRED. Source: Huawei Kirin GPL VDH V400R004 header vdm_hal_local.h (a later generation of the same VDH).";
        field {
            name = "wr_req_perpic";
            desc = "requests [INFERRED]";
            sw = r;
            hw = r;
        } wr_req_perpic[31:0];
    } WR_REQ_PERPIC @ 0xC0;

    reg {
        name = "Luma sum low (statistics)";
        desc = "Read-only picture statistic read by VDMHAL_V400R001_BackupInfo (arm-re scan, 2026-11-12). The R004 header has LUMA_SUM_LOW/HIGH at 0x8180/0x8184: the Hi3536D V400R001 module reads them at 0xB848/0xB84C (offset PROVEN, name INFERRED from R004). Provenance: PROVEN offset; name INFERRED. Source: hi3536dv100_vfmw.ko (VDMHAL_V400R001 / HEVCHAL_V400R001 disassembly, SDK 2.0.2.0).";
        field {
            name = "luma_sum_low";
            desc = "low 32 bits of the luma sum [INFERRED]";
            sw = r;
            hw = r;
        } luma_sum_low[31:0];
    } LUMA_SUM_LOW @ 0xB848;

    reg {
        name = "Luma sum high (statistics)";
        desc = "See LUMA_SUM_LOW. Provenance: PROVEN offset; name INFERRED. Source: hi3536dv100_vfmw.ko (VDMHAL_V400R001 / HEVCHAL_V400R001 disassembly, SDK 2.0.2.0).";
        field {
            name = "luma_sum_high";
            desc = "high bits of the luma sum [INFERRED]";
            sw = r;
            hw = r;
        } luma_sum_high[31:0];
    } LUMA_SUM_HIGH @ 0xB84C;

};

regfile eHI3536D_VDH_TOP {
    name = "VDH top / SCD glue registers (0x1320C000 window), Hi3536D V100";
    desc = "Four glue registers at the start of the SCD window (the SCD proper is eHISI_SCD_AV300 at 0x1320C800: the SCD of this chip is a function of the VDH IP, it shares the 64 KB window, the clock gate and the reset register PERI_CRG41 with it and has its own interrupt, SPI 23). PROVEN offsets: hi3536dv100_vfmw.ko writes 0xC000 (VDMHAL_V400R001_PrepareDec: 1 when the standard code is 6 else 0), 0xC004 (WriteScdEMARID: 0x0481A1F7 once at init; per picture bit 16 is read-modify-written: set when the picture width is <= 2048, cleared above, HEVC CfgVdmReg 0x411d8 PROVEN, H.264 StartDec by the macroblock width <= 128), 0xC008 (PrepareDec: 1, VDH 0, after AVS_FLAG and before the codec StartDec), 0xC00C (StartHwDecode for VDH 0: 2 for HEVC, 3 for other standards, after INT_MASK and before the START pulse; corrected 2026-11-22, the earlier text said VDH1 only). Order before START (vendor): AVS_FLAG, SELRST, picture registers, INT_STATE/INT_MASK, messages, INT_MASK, CK_GT, START 0/1/0. Names AVS_FLAG / EMAR_ID / VDH_SELRST / VDH_CK_GT follow the V400R004 documentation in docs/rdl-campaign/vdh-scd.md (INFERRED). BOARD 2026-11-23 (reads after a whole block reset, all addresses in the 0x1320C800 SCD page): SCD_INT_MASK (+0x81C) reads 1 (masked) after reset and keeps a written 1, SCD_OVER (+0x840) 2, +0x820 0x00000C00, +0x844 0x0000FFFF, +0x800/804/808/810/814/818/848 and SCD_NUM (+0x84C) 0; no scan was run, so the polarity of the mask (1 = masked, the reset state, as for the VDH INT_MASK whose reset value is 7) is supported but not proven.";
    reg {
        name = "AVS flag";
        desc = "1 when the stream standard code is 6 (AVS), else 0. PROVEN offset and value. Provenance: PROVEN. Source: hi3536dv100_vfmw.ko (VDMHAL_V400R001 / HEVCHAL_V400R001 disassembly, SDK 2.0.2.0).";
        field {
            name = "avs_flag";
            desc = "AVS mode [PROVEN]";
            sw = rw;
            hw = r;
        } avs_flag[0:0];
    } AVS_FLAG @ 0x0;

    reg {
        name = "AXI master ID / limits";
        desc = "PROVEN: VDMHAL_V400R001_WriteScdEMARID writes 0x0481A1F7; Per picture the bit 16 is set when the picture width is <= 2048 and cleared above (R001 module; R004 uses 4096), for HEVC (CfgVdmReg, dynamic widths 1920/2048 keep 0x0481A1F7, 2049/3072 write 0x0480A1F7) and H.264. Bit 17 is never touched by R001. R004 header comment: 0x0000FF00 no RAM on chip, 0x0001FF00 all RAM on chip, 0x0002FF00 all on-chip RAM except the DBLK RAM. R004 default value 0x161F7 differs from the R001 0x0481A1F7. Provenance: PROVEN value and bit 16 rule, INFERRED bit 16 meaning. Source: hi3536dv100_vfmw.ko (VDMHAL_V400R001 / HEVCHAL_V400R001 disassembly, SDK 2.0.2.0); Huawei Kirin GPL VDH V400R004 header vdm_hal_local.h (a later generation of the same VDH). BOARD 2026-11-23: reset 0x000161F7; only bits [16:0] are implemented, bits [15:14] read 01 whatever is written (0x8 written reads 0x4), bit 16 stores. Bit 16 = 0 is byte exact at 128 and at 2304 pixels width, bit 16 = 1 is exact at 128 and corrupts 384 luma bytes at 2304 (on-chip line RAM too small above 2048). SELRST reads 0 after reset, AVS_FLAG 0.";
        field {
            name = "emar_id";
            desc = "AXI master configuration word (fields unknown); written 0x0481A1F7 at init, bit 16 per picture below [PROVEN value] [INFERRED field meanings]";
            sw = rw;
            hw = r;
        } emar_id[31:0];
    } EMAR_ID @ 0x4;

    reg {
        name = "VDH reset select";
        desc = "PROVEN: PrepareDec writes 1 for VDH 0. Provenance: PROVEN. Source: hi3536dv100_vfmw.ko (VDMHAL_V400R001 / HEVCHAL_V400R001 disassembly, SDK 2.0.2.0).";
        field {
            name = "vdh_selrst";
            desc = "VDH self reset enable (R004 source comment 'set VDH self reset'); written 1 and never cleared by the module, ResetVdm/ResetGlb do not touch it [PROVEN value and order, INFERRED meaning]";
            sw = rw;
            hw = r;
        } vdh_selrst[0:0];
    } VDH_SELRST @ 0x8;

    reg {
        name = "VDH clock gate";
        desc = "Written for VDH 0 by VDMHAL_V400R001_StartHwDecode (0x17ea8) before every start, after INT_MASK and before the START pulse: 2 for HEVC (standard 16), 3 for H.264 and the others (dynamic run). R004 comment: VDH clock gating, its default leaves it unwritten. Bit meanings unknown (GUESS: bit 1 common clock gating, bit 0 H.264-only path). Provenance: PROVEN value, order and path, INFERRED meaning. Source: hi3536dv100_vfmw.ko (VDMHAL_V400R001 / HEVCHAL_V400R001 disassembly, SDK 2.0.2.0). BOARD 2026-11-23: HEVC CK_GT 0, 2 and 3 all decode byte exact on 128x128 and 2304x128 (no visible effect).";
        field {
            name = "vdh_ck_gt";
            desc = "clock gating control: HEVC 2, H.264 3 [PROVEN values, bit meanings GUESS]";
            sw = rw;
            hw = r;
        } vdh_ck_gt[1:0];
    } VDH_CK_GT @ 0xC;

};

regfile eHI3536D_VDH_BPD {
    name = "VDH bitplane decoder (VC-1/WMV9), window at VDH+0xD000, Hi3536D V100";
    desc = "Window at 0x1320D000 mapped by VDMHAL_V400R001_OpenHAL (PROVEN: MEM_Phy2Vir(0x1320D000) stored as the second register base of g_HwMem). In the GPL V400R004 source this is the bitplane decoder (BPD_REG_OFFSET 0xD000, bitplane.h): it decodes the VC-1 bitplane syntax elements. The Hi3536D vfmw module maps the window but no BPD register access was found in the H.264/HEVC paths read (VC-1 is not a feature of this chip per the data sheet: only H.265/H.264/MJPEG). Register names and offsets are from the V400R004 header (INFERRED); not used on this chip as far as the module shows.";
    reg {
        name = "BPD_START";
        desc = "Bitplane decoder register named in the V400R004 header; layout of the fields unknown. Provenance: INFERRED. Source: Huawei Kirin GPL VDH V400R004 header vdm_hal_local.h (a later generation of the same VDH).";
        field {
            name = "bpd_start";
            desc = "value (fields unknown) [INFERRED]";
            sw = rw;
            hw = r;
        } bpd_start[31:0];
    } BPD_START @ 0x0;

    reg {
        name = "BPD_CFG0";
        desc = "Bitplane decoder register named in the V400R004 header; layout of the fields unknown. Provenance: INFERRED. Source: Huawei Kirin GPL VDH V400R004 header vdm_hal_local.h (a later generation of the same VDH).";
        field {
            name = "bpd_cfg0";
            desc = "value (fields unknown) [INFERRED]";
            sw = rw;
            hw = r;
        } bpd_cfg0[31:0];
    } BPD_CFG0 @ 0x4;

    reg {
        name = "BPD_CFG1";
        desc = "Bitplane decoder register named in the V400R004 header; layout of the fields unknown. Provenance: INFERRED. Source: Huawei Kirin GPL VDH V400R004 header vdm_hal_local.h (a later generation of the same VDH).";
        field {
            name = "bpd_cfg1";
            desc = "value (fields unknown) [INFERRED]";
            sw = rw;
            hw = r;
        } bpd_cfg1[31:0];
    } BPD_CFG1 @ 0x8;

    reg {
        name = "BPD_CFG2";
        desc = "Bitplane decoder register named in the V400R004 header; layout of the fields unknown. Provenance: INFERRED. Source: Huawei Kirin GPL VDH V400R004 header vdm_hal_local.h (a later generation of the same VDH).";
        field {
            name = "bpd_cfg2";
            desc = "value (fields unknown) [INFERRED]";
            sw = rw;
            hw = r;
        } bpd_cfg2[31:0];
    } BPD_CFG2 @ 0xC;

    reg {
        name = "BPD_CFG3";
        desc = "Bitplane decoder register named in the V400R004 header; layout of the fields unknown. Provenance: INFERRED. Source: Huawei Kirin GPL VDH V400R004 header vdm_hal_local.h (a later generation of the same VDH).";
        field {
            name = "bpd_cfg3";
            desc = "value (fields unknown) [INFERRED]";
            sw = rw;
            hw = r;
        } bpd_cfg3[31:0];
    } BPD_CFG3 @ 0x10;

    reg {
        name = "BPD_CFG4";
        desc = "Bitplane decoder register named in the V400R004 header; layout of the fields unknown. Provenance: INFERRED. Source: Huawei Kirin GPL VDH V400R004 header vdm_hal_local.h (a later generation of the same VDH).";
        field {
            name = "bpd_cfg4";
            desc = "value (fields unknown) [INFERRED]";
            sw = rw;
            hw = r;
        } bpd_cfg4[31:0];
    } BPD_CFG4 @ 0x14;

    reg {
        name = "BPD_CFG5";
        desc = "Bitplane decoder register named in the V400R004 header; layout of the fields unknown. Provenance: INFERRED. Source: Huawei Kirin GPL VDH V400R004 header vdm_hal_local.h (a later generation of the same VDH).";
        field {
            name = "bpd_cfg5";
            desc = "value (fields unknown) [INFERRED]";
            sw = rw;
            hw = r;
        } bpd_cfg5[31:0];
    } BPD_CFG5 @ 0x18;

    reg {
        name = "BPD_CFG6";
        desc = "Bitplane decoder register named in the V400R004 header; layout of the fields unknown. Provenance: INFERRED. Source: Huawei Kirin GPL VDH V400R004 header vdm_hal_local.h (a later generation of the same VDH).";
        field {
            name = "bpd_cfg6";
            desc = "value (fields unknown) [INFERRED]";
            sw = rw;
            hw = r;
        } bpd_cfg6[31:0];
    } BPD_CFG6 @ 0x1C;

    reg {
        name = "BPD_CFG7";
        desc = "Bitplane decoder register named in the V400R004 header; layout of the fields unknown. Provenance: INFERRED. Source: Huawei Kirin GPL VDH V400R004 header vdm_hal_local.h (a later generation of the same VDH).";
        field {
            name = "bpd_cfg7";
            desc = "value (fields unknown) [INFERRED]";
            sw = rw;
            hw = r;
        } bpd_cfg7[31:0];
    } BPD_CFG7 @ 0x20;

    reg {
        name = "BPD_CFG8";
        desc = "Bitplane decoder register named in the V400R004 header; layout of the fields unknown. Provenance: INFERRED. Source: Huawei Kirin GPL VDH V400R004 header vdm_hal_local.h (a later generation of the same VDH).";
        field {
            name = "bpd_cfg8";
            desc = "value (fields unknown) [INFERRED]";
            sw = rw;
            hw = r;
        } bpd_cfg8[31:0];
    } BPD_CFG8 @ 0x24;

    reg {
        name = "BPD_CFG9";
        desc = "Bitplane decoder register named in the V400R004 header; layout of the fields unknown. Provenance: INFERRED. Source: Huawei Kirin GPL VDH V400R004 header vdm_hal_local.h (a later generation of the same VDH).";
        field {
            name = "bpd_cfg9";
            desc = "value (fields unknown) [INFERRED]";
            sw = rw;
            hw = r;
        } bpd_cfg9[31:0];
    } BPD_CFG9 @ 0x28;

    reg {
        name = "BPD_CFG10";
        desc = "Bitplane decoder register named in the V400R004 header; layout of the fields unknown. Provenance: INFERRED. Source: Huawei Kirin GPL VDH V400R004 header vdm_hal_local.h (a later generation of the same VDH).";
        field {
            name = "bpd_cfg10";
            desc = "value (fields unknown) [INFERRED]";
            sw = rw;
            hw = r;
        } bpd_cfg10[31:0];
    } BPD_CFG10 @ 0x2C;

    reg {
        name = "BPD_CFG11";
        desc = "Bitplane decoder register named in the V400R004 header; layout of the fields unknown. Provenance: INFERRED. Source: Huawei Kirin GPL VDH V400R004 header vdm_hal_local.h (a later generation of the same VDH).";
        field {
            name = "bpd_cfg11";
            desc = "value (fields unknown) [INFERRED]";
            sw = rw;
            hw = r;
        } bpd_cfg11[31:0];
    } BPD_CFG11 @ 0x30;

    reg {
        name = "BPD_INT_MASK";
        desc = "Bitplane decoder register named in the V400R004 header; layout of the fields unknown. Provenance: INFERRED. Source: Huawei Kirin GPL VDH V400R004 header vdm_hal_local.h (a later generation of the same VDH).";
        field {
            name = "bpd_int_mask";
            desc = "value (fields unknown) [INFERRED]";
            sw = rw;
            hw = r;
        } bpd_int_mask[31:0];
    } BPD_INT_MASK @ 0x34;

    reg {
        name = "BPD_STATE";
        desc = "Bitplane decoder register named in the V400R004 header; layout of the fields unknown. Provenance: INFERRED. Source: Huawei Kirin GPL VDH V400R004 header vdm_hal_local.h (a later generation of the same VDH).";
        field {
            name = "bpd_state";
            desc = "value (fields unknown) [INFERRED]";
            sw = rw;
            hw = r;
        } bpd_state[31:0];
    } BPD_STATE @ 0x40;

    reg {
        name = "BPD_INT_STATE";
        desc = "Bitplane decoder register named in the V400R004 header; layout of the fields unknown. Provenance: INFERRED. Source: Huawei Kirin GPL VDH V400R004 header vdm_hal_local.h (a later generation of the same VDH).";
        field {
            name = "bpd_int_state";
            desc = "value (fields unknown) [INFERRED]";
            sw = rw;
            hw = r;
        } bpd_int_state[31:0];
    } BPD_INT_STATE @ 0x44;

    reg {
        name = "BPD_VCTRL_STATE";
        desc = "Bitplane decoder register named in the V400R004 header; layout of the fields unknown. Provenance: INFERRED. Source: Huawei Kirin GPL VDH V400R004 header vdm_hal_local.h (a later generation of the same VDH).";
        field {
            name = "bpd_vctrl_state";
            desc = "value (fields unknown) [INFERRED]";
            sw = rw;
            hw = r;
        } bpd_vctrl_state[31:0];
    } BPD_VCTRL_STATE @ 0x48;

    reg {
        name = "BPD_OUT0";
        desc = "Bitplane decoder register named in the V400R004 header; layout of the fields unknown. Provenance: INFERRED. Source: Huawei Kirin GPL VDH V400R004 header vdm_hal_local.h (a later generation of the same VDH).";
        field {
            name = "bpd_out0";
            desc = "value (fields unknown) [INFERRED]";
            sw = rw;
            hw = r;
        } bpd_out0[31:0];
    } BPD_OUT0 @ 0x50;

    reg {
        name = "BPD_OUT1";
        desc = "Bitplane decoder register named in the V400R004 header; layout of the fields unknown. Provenance: INFERRED. Source: Huawei Kirin GPL VDH V400R004 header vdm_hal_local.h (a later generation of the same VDH).";
        field {
            name = "bpd_out1";
            desc = "value (fields unknown) [INFERRED]";
            sw = rw;
            hw = r;
        } bpd_out1[31:0];
    } BPD_OUT1 @ 0x54;

};

regfile eHI3536D_VDH_PICMSG {
    name = "VDH HEVC picture message (DDR, NOT registers), Hi3536D V100";
    desc = "NOT A REGISTER FILE: layout of the 64-word picture message ('burst 0', D0-D63) the HEVC driver writes into the message pool (slot DN_MSG_SLOT_INDEX) before the slice messages; the VDH reads it through AVM_ADDR. Offsets are word index x 4. Names and bit positions from the GPL Kirin V400R004 source; the R001 module of this chip was checked by its stored word offsets (1-7, 25, 43, 54-61, 63, plus the loops for D8-D24 and D26-D41) and by the shift constants of D0 (25, 23, 22, 21, 19, 18), D2 (29, 28, 27, 24, 21, 18, 15, 12, 9, 6, 3), D3 (22, 16, 12, 8, 4), D54 (16), D60 (24-19, 16, 13-10, 5): all agree. Words not listed are not written. Words 64-319 (bursts 1-4) hold the scaling lists (4 x 64 words, HEVC_WriteQmatrix, order 4x4/8x8/16x16/32x32 as the driver's Qmatrix array); the tile table is a separate buffer pointed to by D55 (TileId 2 x 128 words of 4 packed bytes, TilePosX 20 words, TilePosY 22 words, 16-bit pairs).";
    reg {
        name = "D0 sequence flags and size";
        desc = "D0 sequence flags and size Provenance: PROVEN (shift constants). Source: HEVCHAL_V400R004_SetPicMsg / SetSliceMsg (GPL Kirin source); shift constants and stored word offsets of HEVCHAL_V400R001_SetPicMsg / SetSliceMsg (hi3536dv100_vfmw.ko) agree.";
        field {
            name = "pic_width_in_ctbs_minus1";
            desc = "PicWidthInCtbsYMinus1 [INFERRED]";
            sw = rw;
            hw = r;
        } pic_width_in_ctbs_minus1[8:0];
        field {
            name = "pic_height_in_ctbs_minus1";
            desc = "PicHightInCtbsYMinus1 [INFERRED]";
            sw = rw;
            hw = r;
        } pic_height_in_ctbs_minus1[17:9];
        field {
            name = "pcm_enabled_flag";
            desc = " [INFERRED]";
            sw = rw;
            hw = r;
        } pcm_enabled_flag[18:18];
        field {
            name = "chroma_format_idc";
            desc = " [INFERRED]";
            sw = rw;
            hw = r;
        } chroma_format_idc[20:19];
        field {
            name = "amp_enabled_flag";
            desc = " [INFERRED]";
            sw = rw;
            hw = r;
        } amp_enabled_flag[21:21];
        field {
            name = "sample_adaptive_offset_enabled_flag";
            desc = " [INFERRED]";
            sw = rw;
            hw = r;
        } sample_adaptive_offset_enabled_flag[22:22];
        field {
            name = "pcm_loop_filter_disabled_flag";
            desc = " [INFERRED]";
            sw = rw;
            hw = r;
        } pcm_loop_filter_disabled_flag[23:23];
        field {
            name = "scaling_list_enabled_flag";
            desc = " [INFERRED]";
            sw = rw;
            hw = r;
        } scaling_list_enabled_flag[24:24];
        field {
            name = "strong_intra_smoothing_enabled_flag";
            desc = " [INFERRED]";
            sw = rw;
            hw = r;
        } strong_intra_smoothing_enabled_flag[25:25];
    } D0 @ 0x0;

    reg {
        name = "D1 POC";
        desc = "D1 POC Provenance: PROVEN (word offset). Source: HEVCHAL_V400R004_SetPicMsg / SetSliceMsg (GPL Kirin source); shift constants and stored word offsets of HEVCHAL_V400R001_SetPicMsg / SetSliceMsg (hi3536dv100_vfmw.ko) agree.";
        field {
            name = "this_poc";
            desc = "ThisPoc [INFERRED]";
            sw = rw;
            hw = r;
        } this_poc[31:0];
    } D1 @ 0x4;

    reg {
        name = "D2 coding tree parameters";
        desc = "D2 coding tree parameters Provenance: PROVEN (shift constants). Source: HEVCHAL_V400R004_SetPicMsg / SetSliceMsg (GPL Kirin source); shift constants and stored word offsets of HEVCHAL_V400R001_SetPicMsg / SetSliceMsg (hi3536dv100_vfmw.ko) agree.";
        field {
            name = "ctb_log2_size_y";
            desc = " [INFERRED]";
            sw = rw;
            hw = r;
        } ctb_log2_size_y[2:0];
        field {
            name = "log2_min_cb_size_y";
            desc = " [INFERRED]";
            sw = rw;
            hw = r;
        } log2_min_cb_size_y[5:3];
        field {
            name = "max_cu_depth";
            desc = " [INFERRED]";
            sw = rw;
            hw = r;
        } max_cu_depth[8:6];
        field {
            name = "log2_max_trafo_size";
            desc = " [INFERRED]";
            sw = rw;
            hw = r;
        } log2_max_trafo_size[11:9];
        field {
            name = "log2_min_trafo_size";
            desc = " [INFERRED]";
            sw = rw;
            hw = r;
        } log2_min_trafo_size[14:12];
        field {
            name = "log2_max_ipcm_cb_size_y";
            desc = " [INFERRED]";
            sw = rw;
            hw = r;
        } log2_max_ipcm_cb_size_y[17:15];
        field {
            name = "log2_min_ipcm_cb_size_y";
            desc = " [INFERRED]";
            sw = rw;
            hw = r;
        } log2_min_ipcm_cb_size_y[20:18];
        field {
            name = "max_transform_hierarchy_depth_intra";
            desc = " [INFERRED]";
            sw = rw;
            hw = r;
        } max_transform_hierarchy_depth_intra[23:21];
        field {
            name = "max_transform_hierarchy_depth_inter";
            desc = " [INFERRED]";
            sw = rw;
            hw = r;
        } max_transform_hierarchy_depth_inter[26:24];
        field {
            name = "weighted_pred_flag";
            desc = " [INFERRED]";
            sw = rw;
            hw = r;
        } weighted_pred_flag[27:27];
        field {
            name = "weighted_bipred_flag";
            desc = " [INFERRED]";
            sw = rw;
            hw = r;
        } weighted_bipred_flag[28:28];
        field {
            name = "log2_parallel_merge_level_minus2";
            desc = " [INFERRED]";
            sw = rw;
            hw = r;
        } log2_parallel_merge_level_minus2[31:29];
    } D2 @ 0x8;

    reg {
        name = "D3 bit depths";
        desc = "D3 bit depths Provenance: PROVEN (shift constants). Source: HEVCHAL_V400R004_SetPicMsg / SetSliceMsg (GPL Kirin source); shift constants and stored word offsets of HEVCHAL_V400R001_SetPicMsg / SetSliceMsg (hi3536dv100_vfmw.ko) agree.";
        field {
            name = "bit_depth_y";
            desc = " [INFERRED]";
            sw = rw;
            hw = r;
        } bit_depth_y[3:0];
        field {
            name = "bit_depth_c";
            desc = " [INFERRED]";
            sw = rw;
            hw = r;
        } bit_depth_c[7:4];
        field {
            name = "pcm_bit_depth_y";
            desc = " [INFERRED]";
            sw = rw;
            hw = r;
        } pcm_bit_depth_y[11:8];
        field {
            name = "pcm_bit_depth_c";
            desc = " [INFERRED]";
            sw = rw;
            hw = r;
        } pcm_bit_depth_c[15:12];
        field {
            name = "qp_bd_offset_y";
            desc = " [INFERRED]";
            sw = rw;
            hw = r;
        } qp_bd_offset_y[21:16];
        field {
            name = "qp_bd_offset_c";
            desc = " [INFERRED]";
            sw = rw;
            hw = r;
        } qp_bd_offset_c[27:22];
    } D3 @ 0xC;

    reg {
        name = "D4 SED top line buffer";
        desc = "D4 SED top line buffer R001 layout (HAL memory block, W = maximum picture width the context is configured for, A = ALIGN128(W)): size A, allocated only for W > 2048 (for W <= 2048 the vendor leaves a zero-size region and the address aliases the next one; EMAR_ID bit 16 is set for those pictures). PROVEN. Not the 256 B per column of R004: those constants are about 12x too large for this chip. Provenance: PROVEN (word offset). Source: HEVCHAL_V400R004_SetPicMsg / SetSliceMsg (GPL Kirin source); shift constants and stored word offsets of HEVCHAL_V400R001_SetPicMsg / SetSliceMsg (hi3536dv100_vfmw.ko) agree.";
        field {
            name = "sed_top_addr";
            desc = "physical address [INFERRED]";
            sw = rw;
            hw = r;
        } sed_top_addr[31:0];
    } D4 @ 0x10;

    reg {
        name = "D5 PMV top line buffer";
        desc = "D5 PMV top line buffer Size 3A (A = ALIGN128(W)), W > 2048 only (see D4). PROVEN. Provenance: PROVEN (word offset). Source: HEVCHAL_V400R004_SetPicMsg / SetSliceMsg (GPL Kirin source); shift constants and stored word offsets of HEVCHAL_V400R001_SetPicMsg / SetSliceMsg (hi3536dv100_vfmw.ko) agree.";
        field {
            name = "pmv_top_addr";
            desc = "physical address [INFERRED]";
            sw = rw;
            hw = r;
        } pmv_top_addr[31:0];
    } D5 @ 0x14;

    reg {
        name = "D6 PMV buffer of the current picture";
        desc = "D6 PMV buffer of the current picture Per-frame buffer: vdec.ko VDEC_DRV_UpdateFrameSize reserves ALIGN256(((W + 63) >> 4) * ((H + 63) >> 4) * 16) bytes per HEVC frame (139776 for 1080p; ArrangeMem reports a half-slot of ALIGN128(WMB*HMB*16)/2 = 130560, so allocate the vdec number), 16-byte aligned address. PROVEN formula. Provenance: PROVEN (word offset). Source: HEVCHAL_V400R004_SetPicMsg / SetSliceMsg (GPL Kirin source); shift constants and stored word offsets of HEVCHAL_V400R001_SetPicMsg / SetSliceMsg (hi3536dv100_vfmw.ko) agree.";
        field {
            name = "pmv_cur_addr";
            desc = "physical address [INFERRED]";
            sw = rw;
            hw = r;
        } pmv_cur_addr[31:0];
    } D6 @ 0x18;

    reg {
        name = "D7 RCN top line buffer";
        desc = "D7 RCN top line buffer Size 2.5A (A = ALIGN128(W)), W > 2048 only (see D4). PROVEN. Provenance: PROVEN (word offset). Source: HEVCHAL_V400R004_SetPicMsg / SetSliceMsg (GPL Kirin source); shift constants and stored word offsets of HEVCHAL_V400R001_SetPicMsg / SetSliceMsg (hi3536dv100_vfmw.ko) agree.";
        field {
            name = "rcn_top_addr";
            desc = "physical address [INFERRED]";
            sw = rw;
            hw = r;
        } rcn_top_addr[31:0];
    } D7 @ 0x1C;

    reg {
        name = "D8-D24 reference picture addresses";
        desc = "D8-D24 reference picture addresses Provenance: INFERRED. Source: HEVCHAL_V400R004_SetPicMsg / SetSliceMsg (GPL Kirin source); shift constants and stored word offsets of HEVCHAL_V400R001_SetPicMsg / SetSliceMsg (hi3536dv100_vfmw.ko) agree.";
        field {
            name = "ref_pic_addr";
            desc = "D8..D23: picture address per APC index (16 words) [INFERRED]";
            sw = rw;
            hw = r;
        } ref_pic_addr[31:0];
    } D8 @ 0x20;

    reg {
        name = "D25 MN (CABAC init) table address";
        desc = "D25 MN (CABAC init) table address Region of 1024 bytes in the HAL block (464 entries x 2 bytes used, built by HEVCWriteCabacTab from the spec init values), 1024 aligned. PROVEN. Provenance: PROVEN (word offset). Source: HEVCHAL_V400R004_SetPicMsg / SetSliceMsg (GPL Kirin source); shift constants and stored word offsets of HEVCHAL_V400R001_SetPicMsg / SetSliceMsg (hi3536dv100_vfmw.ko) agree.";
        field {
            name = "mn_addr";
            desc = "CABAC m/n table, written once [INFERRED]";
            sw = rw;
            hw = r;
        } mn_addr[31:0];
    } D25 @ 0x64;

    reg {
        name = "D26-D41 POC table";
        desc = "D26-D41 POC table Provenance: INFERRED. Source: HEVCHAL_V400R004_SetPicMsg / SetSliceMsg (GPL Kirin source); shift constants and stored word offsets of HEVCHAL_V400R001_SetPicMsg / SetSliceMsg (hi3536dv100_vfmw.ko) agree.";
        field {
            name = "apc_poc";
            desc = "D26..D41: POC of each APC entry (16 words) [INFERRED]";
            sw = rw;
            hw = r;
        } apc_poc[31:0];
    } D26 @ 0x68;

    reg {
        name = "D43 PMV left buffer";
        desc = "D43 PMV left buffer Size 3B (B = ALIGN128(H maximum)); always allocated. PROVEN. Provenance: PROVEN (word offset). Source: HEVCHAL_V400R004_SetPicMsg / SetSliceMsg (GPL Kirin source); shift constants and stored word offsets of HEVCHAL_V400R001_SetPicMsg / SetSliceMsg (hi3536dv100_vfmw.ko) agree.";
        field {
            name = "pmv_left_addr";
            desc = "physical address [INFERRED]";
            sw = rw;
            hw = r;
        } pmv_left_addr[31:0];
    } D43 @ 0xAC;

    reg {
        name = "D54 picture size in luma samples";
        desc = "D54 picture size in luma samples Provenance: PROVEN (shift constant 16). Source: HEVCHAL_V400R004_SetPicMsg / SetSliceMsg (GPL Kirin source); shift constants and stored word offsets of HEVCHAL_V400R001_SetPicMsg / SetSliceMsg (hi3536dv100_vfmw.ko) agree.";
        field {
            name = "pic_width_luma";
            desc = " [INFERRED]";
            sw = rw;
            hw = r;
        } pic_width_luma[15:0];
        field {
            name = "pic_height_luma";
            desc = " [INFERRED]";
            sw = rw;
            hw = r;
        } pic_height_luma[31:16];
    } D54 @ 0xD8;

    reg {
        name = "D55 tile info buffer address";
        desc = "D55 tile info buffer address 2048-byte region, 298 words used (eHI3536D_VDH_TILETAB), written for every picture. PROVEN. Provenance: PROVEN (word offset). Source: HEVCHAL_V400R004_SetPicMsg / SetSliceMsg (GPL Kirin source); shift constants and stored word offsets of HEVCHAL_V400R001_SetPicMsg / SetSliceMsg (hi3536dv100_vfmw.ko) agree. BOARD 2026-11-24 (runs 3 and 4): the table limit of 16 columns x 11 rows IS CONFIRMED: uniform 16 x 11 tiles of 3 x 2 CTBs (3072 x 2048, CTB 64) decode byte exact, as do 8x6 up to 12 x 11 and 16 x 6 and 16 x 1 and 1 x 11 (PCM and kvazaar streams); the earlier 16 x 11 failures had tiles of ONE CTB (1024 x 704). What the hardware gets wrong is the SIZE of a tile: a tile column of one CTB (2 columns of 1 CTB at the picture end or in the middle, at CTB 32 and 64; at CTB 16 also at the start), tile columns narrower than 64 pixels at CTB 16 and 32 and tile rows lower than 64 pixels at CTB 16 and 32 (some CTBs next to the tile edges differ, some pictures end with the decode error flag; 52 of the 74 tested streams with such tiles; of the 94 tested streams with columns of at least 2 CTBs and 64 pixels and rows of at least 64 pixels 90 are exact and the other 4 are PCM streams with loop filters, see the picture message notes; a row of one CTB of 64 pixels is exact). Not the uniform_spacing flag (forcing it 0 changed nothing) and not the stream content (4 PCM seeds, same result). The picture message keeps TileId bytes per 16 pixel unit and CTB column positions as the vendor code writes them (UNVERIFIED M9: why small tiles fail)";
        field {
            name = "tile_info_addr";
            desc = "tile segment table address [INFERRED]";
            sw = rw;
            hw = r;
        } tile_info_addr[31:0];
    } D55 @ 0xDC;

    reg {
        name = "D56 line buffer";
        desc = "D56 line buffer This word is the SAO LEFT buffer: size 21B (B = ALIGN128(H maximum)); always allocated. PROVEN. Provenance: PROVEN (word offset). Source: HEVCHAL_V400R004_SetPicMsg / SetSliceMsg (GPL Kirin source); shift constants and stored word offsets of HEVCHAL_V400R001_SetPicMsg / SetSliceMsg (hi3536dv100_vfmw.ko) agree.";
        field {
            name = "sao_left_addr";
            desc = "physical address [INFERRED]";
            sw = rw;
            hw = r;
        } sao_left_addr[31:0];
    } D56 @ 0xE0;

    reg {
        name = "D57 line buffer";
        desc = "D57 line buffer This word is the DBLK LEFT buffer: size 11B. PROVEN. Provenance: PROVEN (word offset). Source: HEVCHAL_V400R004_SetPicMsg / SetSliceMsg (GPL Kirin source); shift constants and stored word offsets of HEVCHAL_V400R001_SetPicMsg / SetSliceMsg (hi3536dv100_vfmw.ko) agree.";
        field {
            name = "dblk_left_addr";
            desc = "physical address [INFERRED]";
            sw = rw;
            hw = r;
        } dblk_left_addr[31:0];
    } D57 @ 0xE4;

    reg {
        name = "D58 line buffer";
        desc = "D58 line buffer This word is the SAO TOP buffer: size 3.5A, W > 2048 only. PROVEN. Provenance: PROVEN (word offset). Source: HEVCHAL_V400R004_SetPicMsg / SetSliceMsg (GPL Kirin source); shift constants and stored word offsets of HEVCHAL_V400R001_SetPicMsg / SetSliceMsg (hi3536dv100_vfmw.ko) agree.";
        field {
            name = "sao_top_addr";
            desc = "physical address [INFERRED]";
            sw = rw;
            hw = r;
        } sao_top_addr[31:0];
    } D58 @ 0xE8;

    reg {
        name = "D59 line buffer";
        desc = "D59 line buffer This word is the DBLK TOP buffer: size 11A + 256, W > 2048 only. PROVEN. Provenance: PROVEN (word offset). Source: HEVCHAL_V400R004_SetPicMsg / SetSliceMsg (GPL Kirin source); shift constants and stored word offsets of HEVCHAL_V400R001_SetPicMsg / SetSliceMsg (hi3536dv100_vfmw.ko) agree.";
        field {
            name = "dblk_top_addr";
            desc = "physical address [INFERRED]";
            sw = rw;
            hw = r;
        } dblk_top_addr[31:0];
    } D59 @ 0xEC;

    reg {
        name = "D60 PPS flags";
        desc = "D60 PPS flags Provenance: PROVEN (shift constants). Source: HEVCHAL_V400R004_SetPicMsg / SetSliceMsg (GPL Kirin source); shift constants and stored word offsets of HEVCHAL_V400R001_SetPicMsg / SetSliceMsg (hi3536dv100_vfmw.ko) agree.";
        field {
            name = "pps_cr_qp_offset";
            desc = " [INFERRED]";
            sw = rw;
            hw = r;
        } pps_cr_qp_offset[4:0];
        field {
            name = "pps_cb_qp_offset";
            desc = " [INFERRED]";
            sw = rw;
            hw = r;
        } pps_cb_qp_offset[9:5];
        field {
            name = "constrained_intra_pred_flag";
            desc = " [INFERRED]";
            sw = rw;
            hw = r;
        } constrained_intra_pred_flag[10:10];
        field {
            name = "transquant_bypass_enabled_flag";
            desc = " [INFERRED]";
            sw = rw;
            hw = r;
        } transquant_bypass_enabled_flag[11:11];
        field {
            name = "cu_qp_delta_enabled_flag";
            desc = " [INFERRED]";
            sw = rw;
            hw = r;
        } cu_qp_delta_enabled_flag[12:12];
        field {
            name = "diff_cu_qp_delta_depth";
            desc = " [INFERRED]";
            sw = rw;
            hw = r;
        } diff_cu_qp_delta_depth[15:13];
        field {
            name = "log2_min_cu_qp_delta_size";
            desc = " [INFERRED]";
            sw = rw;
            hw = r;
        } log2_min_cu_qp_delta_size[18:16];
        field {
            name = "tiles_enabled_flag";
            desc = " [INFERRED]";
            sw = rw;
            hw = r;
        } tiles_enabled_flag[19:19];
        field {
            name = "uniform_spacing_flag";
            desc = " [INFERRED]";
            sw = rw;
            hw = r;
        } uniform_spacing_flag[20:20];
        field {
            name = "entropy_coding_sync_enabled_flag";
            desc = " [INFERRED]";
            sw = rw;
            hw = r;
        } entropy_coding_sync_enabled_flag[21:21];
        field {
            name = "sign_data_hiding_enabled_flag";
            desc = " [INFERRED]";
            sw = rw;
            hw = r;
        } sign_data_hiding_enabled_flag[22:22];
        field {
            name = "transform_skip_enabled_flag";
            desc = " [INFERRED]";
            sw = rw;
            hw = r;
        } transform_skip_enabled_flag[23:23];
        field {
            name = "loop_filter_across_tiles_enabled_flag";
            desc = " [INFERRED]";
            sw = rw;
            hw = r;
        } loop_filter_across_tiles_enabled_flag[24:24];
    } D60 @ 0xF0;

    reg {
        name = "D61 tile counts";
        desc = "D61 tile counts Provenance: INFERRED. Source: HEVCHAL_V400R004_SetPicMsg / SetSliceMsg (GPL Kirin source); shift constants and stored word offsets of HEVCHAL_V400R001_SetPicMsg / SetSliceMsg (hi3536dv100_vfmw.ko) agree.";
        field {
            name = "num_tile_columns_minus1";
            desc = " [INFERRED]";
            sw = rw;
            hw = r;
        } num_tile_columns_minus1[15:0];
        field {
            name = "num_tile_rows_minus1";
            desc = " [INFERRED]";
            sw = rw;
            hw = r;
        } num_tile_rows_minus1[31:16];
    } D61 @ 0xF4;

    reg {
        name = "D63 first slice message address";
        desc = "D63 first slice message address Provenance: PROVEN (word offset). Source: HEVCHAL_V400R004_SetPicMsg / SetSliceMsg (GPL Kirin source); shift constants and stored word offsets of HEVCHAL_V400R001_SetPicMsg / SetSliceMsg (hi3536dv100_vfmw.ko) agree.";
        field {
            name = "first_slice_msg_addr";
            desc = "physical address of the first slice message slot [INFERRED]";
            sw = rw;
            hw = r;
        } first_slice_msg_addr[31:0];
    } D63 @ 0xFC;

};

regfile eHI3536D_VDH_SLICEMSG {
    name = "VDH HEVC slice message (DDR, NOT registers), Hi3536D V100";
    desc = "NOT A REGISTER FILE: layout of one 64-word slice message slot (burst 0), chained through D63 (next slot address). Followed by burst 1/2 (words 64-191) with the explicit weighted-prediction tables when (weighted_pred_flag and P slice) or (weighted_bipred_flag and B slice): burst 1 D0-D15 luma list0, D16-D31 luma list1; burst 2 D0-D15 chroma Cb list0, D16-D31 Cb list1, D32-D47 Cr list0, D48-D63 Cr list1; luma/Cb word = offset[7:0] << 12 | weight[8:0] << 3 | log2_denom[2:0]; Cr word = offset[7:0] << 9 | weight[8:0]. Positions: GPL Kirin V400R004 source, checked in the Hi3536D module by the stored word offsets (1-14, 23, 24, 43, 44, 63) and the D6/D7/D12 shift constants (27, 18; 28, 24, 20, 16, 15, 14, 8, 2; 16, 3, 1). R001 additionally writes D24 = 0.";
    reg {
        name = "D0/D3 stream segment 0 byte offset";
        desc = "D0/D3 stream segment 0 byte offset Stream conventions (M7): the hardware does NOT remove the 00 00 03 emulation prevention bytes, the stream it reads must not have them (PROVEN on the board 2026-11-23: a slice with a 00 00 03 inside decodes wrong and exact once the 03 byte is removed, HEVC and H.264; board run 2: escape bytes in the slice header and behind the data exact too, so the software copies the NAL unit without them and counts the offset and the lengths in the copy); the byte offset is of the 16-byte chunk holding the first slice-data bit, relative to STREAM_BASE_ADDR & ~0xF; STREAM_BASE_ADDR is & ~0xF of the lowest segment address of the picture (vendor, PROVEN dynamic: bytespos 0x81000123, base 0x81000007 gives D0 = 0x120). HEVC: slice data starts after slice_segment_header and byte_alignment(). Provenance: PROVEN (word offsets). Source: HEVCHAL_V400R004_SetPicMsg / SetSliceMsg (GPL Kirin source); shift constants and stored word offsets of HEVCHAL_V400R001_SetPicMsg / SetSliceMsg (hi3536dv100_vfmw.ko) agree.";
        field {
            name = "byte_offset";
            desc = " (stream_start & ~0xF) - (stream_base & ~0xF) of segment i; segment 1 is D3-D5 [INFERRED]";
            sw = rw;
            hw = r;
        } byte_offset[31:0];
    } D0 @ 0x0;

    reg {
        name = "D1 bit offset segment 0";
        desc = "D1 bit offset segment 0 Bit position of the first slice-data bit in the 16-byte chunk: (bitsoffset + 8 * bytespos) & 0x7F (PROVEN dynamic: bitsoffset 5 gives D1 = 0x1d with the example above). Provenance: INFERRED. Source: HEVCHAL_V400R004_SetPicMsg / SetSliceMsg (GPL Kirin source); shift constants and stored word offsets of HEVCHAL_V400R001_SetPicMsg / SetSliceMsg (hi3536dv100_vfmw.ko) agree.";
        field {
            name = "bit_offset";
            desc = "(bitsoffset + 8 x (bytespos & 0xF)) & 0x7F [INFERRED]";
            sw = rw;
            hw = r;
        } bit_offset[6:0];
        field {
            name = "reserved_31_7";
            desc = " [INFERRED]";
            sw = r;
            hw = r;
        } reserved_31_7[31:7];
    } D1 @ 0x4;

    reg {
        name = "D2 valid bit length segment 0";
        desc = "D2 valid bit length segment 0 Bits from the first slice-data bit to the end of the data in the stream the hardware reads (the NAL unit without its emulation prevention bytes), counted INCLUDING the rbsp_stop_one_bit for HEVC and H.264 CABAC; H.264 CAVLC does not count it; trailing zero bytes (cabac_zero_words, after the stripping) are not counted. PROVEN on the board 2026-11-23: HEVC with the stop bit gives VDH_STATE 0x00020001 and an exact picture, a count without it (or off by 1, 8 or 32) sets the error flag (the output stays exact for 0 and -1); H.264 CABAC and CAVLC exact with the counts above, +-1 flags an error and -1 also corrupts the picture. Board run 2: several slices (HEVC segments, H.264 slices) in one picture each have their own D0..D2, all exact. The vendor code (HEVC_FindTrailZeros 0x3b8ac, HEVC_CalcStreamBits 0x33b14, CalcStreamBits 0x1f83c) was read as excluding the HEVC stop bit: that reading was wrong. Segment 1 (D3-D5) exists for ring-buffer wrap only. Entry point offsets are NOT passed (no message word depends on them, M9; a wavefront stream decoded exact without them). The stream buffer needs a readable tail past the last byte: no margin in the vendor code, the hardware reads 16-byte units (GUESS: keep >= 128 bytes; a 0xFF fill instead of zeros changed nothing, a smaller margin was not tried). Provenance: PROVEN (stop bit rule, conventions), GUESS (tail margin). Source: HEVCHAL_V400R004_SetPicMsg / SetSliceMsg (GPL Kirin source); shift constants and stored word offsets of HEVCHAL_V400R001_SetPicMsg / SetSliceMsg (hi3536dv100_vfmw.ko) agree.";
        field {
            name = "valid_bitlen";
            desc = "bits of slice data in this segment [INFERRED]";
            sw = rw;
            hw = r;
        } valid_bitlen[31:0];
    } D2 @ 0x8;

    reg {
        name = "D6 slice control";
        desc = "D6 slice control Provenance: PROVEN (shift constants). Source: HEVCHAL_V400R004_SetPicMsg / SetSliceMsg (GPL Kirin source); shift constants and stored word offsets of HEVCHAL_V400R001_SetPicMsg / SetSliceMsg (hi3536dv100_vfmw.ko) agree.";
        field {
            name = "independent_slice_segment_addr";
            desc = " [INFERRED]";
            sw = rw;
            hw = r;
        } independent_slice_segment_addr[17:0];
        field {
            name = "cabac_init_flag";
            desc = " [INFERRED]";
            sw = rw;
            hw = r;
        } cabac_init_flag[18:18];
        field {
            name = "slice_qp_y";
            desc = "SliceQpY & 0x3F [INFERRED]";
            sw = rw;
            hw = r;
        } slice_qp_y[24:19];
        field {
            name = "dependent_slice_segment_flag";
            desc = " [INFERRED]";
            sw = rw;
            hw = r;
        } dependent_slice_segment_flag[26:26];
        field {
            name = "is_low_delay";
            desc = " [INFERRED]";
            sw = rw;
            hw = r;
        } is_low_delay[27:27];
    } D6 @ 0x18;

    reg {
        name = "D7 slice reference setup";
        desc = "D7 slice reference setup Provenance: PROVEN (shift constants). Source: HEVCHAL_V400R004_SetPicMsg / SetSliceMsg (GPL Kirin source); shift constants and stored word offsets of HEVCHAL_V400R001_SetPicMsg / SetSliceMsg (hi3536dv100_vfmw.ko) agree.";
        field {
            name = "slice_type_for_pmv";
            desc = "s_SliceTypeForPMV[SliceType] [INFERRED]";
            sw = rw;
            hw = r;
        } slice_type_for_pmv[1:0];
        field {
            name = "list0_size";
            desc = "listXsize[0] [INFERRED]";
            sw = rw;
            hw = r;
        } list0_size[7:2];
        field {
            name = "list1_size";
            desc = "listXsize[1] [INFERRED]";
            sw = rw;
            hw = r;
        } list1_size[13:8];
        field {
            name = "mvd_l1_zero_flag";
            desc = " [INFERRED]";
            sw = rw;
            hw = r;
        } mvd_l1_zero_flag[14:14];
        field {
            name = "slice_temporal_mvp_enabled_flag";
            desc = " [INFERRED]";
            sw = rw;
            hw = r;
        } slice_temporal_mvp_enabled_flag[15:15];
        field {
            name = "num_ref_idx_l0_active_minus1";
            desc = " [INFERRED]";
            sw = rw;
            hw = r;
        } num_ref_idx_l0_active_minus1[19:16];
        field {
            name = "num_ref_idx_l1_active_minus1";
            desc = " [INFERRED]";
            sw = rw;
            hw = r;
        } num_ref_idx_l1_active_minus1[23:20];
        field {
            name = "max_num_merge_cand";
            desc = " [INFERRED]";
            sw = rw;
            hw = r;
        } max_num_merge_cand[26:24];
        field {
            name = "collocated_from_l0_flag";
            desc = " [INFERRED]";
            sw = rw;
            hw = r;
        } collocated_from_l0_flag[27:27];
        field {
            name = "col_pic_apc";
            desc = " [INFERRED]";
            sw = rw;
            hw = r;
        } col_pic_apc[31:28];
    } D7 @ 0x1C;

    reg {
        name = "D8 slice segment address (CTB raster)";
        desc = "D8 slice segment address (CTB raster) Provenance: PROVEN (word offset). Source: HEVCHAL_V400R004_SetPicMsg / SetSliceMsg (GPL Kirin source); shift constants and stored word offsets of HEVCHAL_V400R001_SetPicMsg / SetSliceMsg (hi3536dv100_vfmw.ko) agree.";
        field {
            name = "slice_segment_address";
            desc = "first CTB of the slice segment [INFERRED]";
            sw = rw;
            hw = r;
        } slice_segment_address[31:0];
    } D8 @ 0x20;

    reg {
        name = "D9 slice start x/y";
        desc = "D9 slice start x/y Provenance: INFERRED. Source: HEVCHAL_V400R004_SetPicMsg / SetSliceMsg (GPL Kirin source); shift constants and stored word offsets of HEVCHAL_V400R001_SetPicMsg / SetSliceMsg (hi3536dv100_vfmw.ko) agree.";
        field {
            name = "x";
            desc = "address % width in CTBs [INFERRED]";
            sw = rw;
            hw = r;
        } x[15:0];
        field {
            name = "y";
            desc = "address / width [INFERRED]";
            sw = rw;
            hw = r;
        } y[31:16];
    } D9 @ 0x24;

    reg {
        name = "D10 slice segment tile address";
        desc = "D10 slice segment tile address Provenance: INFERRED. Source: HEVCHAL_V400R004_SetPicMsg / SetSliceMsg (GPL Kirin source); shift constants and stored word offsets of HEVCHAL_V400R001_SetPicMsg / SetSliceMsg (hi3536dv100_vfmw.ko) agree.";
        field {
            name = "slice_segment_tile_address";
            desc = "tile-scan address [INFERRED]";
            sw = rw;
            hw = r;
        } slice_segment_tile_address[31:0];
    } D10 @ 0x28;

    reg {
        name = "D11 chroma QP offsets";
        desc = "D11 chroma QP offsets Provenance: INFERRED. Source: HEVCHAL_V400R004_SetPicMsg / SetSliceMsg (GPL Kirin source); shift constants and stored word offsets of HEVCHAL_V400R001_SetPicMsg / SetSliceMsg (hi3536dv100_vfmw.ko) agree.";
        field {
            name = "slice_cr_qp_offset";
            desc = " [INFERRED]";
            sw = rw;
            hw = r;
        } slice_cr_qp_offset[4:0];
        field {
            name = "slice_cb_qp_offset";
            desc = " [INFERRED]";
            sw = rw;
            hw = r;
        } slice_cb_qp_offset[12:8];
    } D11 @ 0x2C;

    reg {
        name = "D12 loop filter";
        desc = "D12 loop filter Provenance: PROVEN (shift constants). Source: HEVCHAL_V400R004_SetPicMsg / SetSliceMsg (GPL Kirin source); shift constants and stored word offsets of HEVCHAL_V400R001_SetPicMsg / SetSliceMsg (hi3536dv100_vfmw.ko) agree.";
        field {
            name = "slice_loop_filter_across_slices_enabled_flag";
            desc = " [INFERRED]";
            sw = rw;
            hw = r;
        } slice_loop_filter_across_slices_enabled_flag[0:0];
        field {
            name = "slice_deblocking_filter_disabled_flag";
            desc = " [INFERRED]";
            sw = rw;
            hw = r;
        } slice_deblocking_filter_disabled_flag[1:1];
        field {
            name = "slice_sao_chroma_flag";
            desc = " [INFERRED]";
            sw = rw;
            hw = r;
        } slice_sao_chroma_flag[2:2];
        field {
            name = "slice_sao_luma_flag";
            desc = " [INFERRED]";
            sw = rw;
            hw = r;
        } slice_sao_luma_flag[3:3];
        field {
            name = "slice_beta_offset_div2";
            desc = " [INFERRED]";
            sw = rw;
            hw = r;
        } slice_beta_offset_div2[11:8];
        field {
            name = "slice_tc_offset_div2";
            desc = " [INFERRED]";
            sw = rw;
            hw = r;
        } slice_tc_offset_div2[19:16];
    } D12 @ 0x30;

    reg {
        name = "D13 list0 long-term bits";
        desc = "D13 list0 long-term bits Provenance: INFERRED. Source: HEVCHAL_V400R004_SetPicMsg / SetSliceMsg (GPL Kirin source); shift constants and stored word offsets of HEVCHAL_V400R001_SetPicMsg / SetSliceMsg (hi3536dv100_vfmw.ko) agree.";
        field {
            name = "is_long_term_l0";
            desc = "bit i = entry i of list 0 is long-term [INFERRED]";
            sw = rw;
            hw = r;
        } is_long_term_l0[31:0];
    } D13 @ 0x34;

    reg {
        name = "D14 list1 long-term bits";
        desc = "D14 list1 long-term bits Provenance: INFERRED. Source: HEVCHAL_V400R004_SetPicMsg / SetSliceMsg (GPL Kirin source); shift constants and stored word offsets of HEVCHAL_V400R001_SetPicMsg / SetSliceMsg (hi3536dv100_vfmw.ko) agree.";
        field {
            name = "is_long_term_l1";
            desc = "bit i = entry i of list 1 is long-term [INFERRED]";
            sw = rw;
            hw = r;
        } is_long_term_l1[31:0];
    } D14 @ 0x38;

    reg {
        name = "D15-D16 list0 APC indices";
        desc = "D15-D16 list0 APC indices Provenance: INFERRED. Source: HEVCHAL_V400R004_SetPicMsg / SetSliceMsg (GPL Kirin source); shift constants and stored word offsets of HEVCHAL_V400R001_SetPicMsg / SetSliceMsg (hi3536dv100_vfmw.ko) agree.";
        field {
            name = "apc";
            desc = "4 bits per entry, 8 entries per word (D15, D16) [INFERRED]";
            sw = rw;
            hw = r;
        } apc[31:0];
    } D15 @ 0x3C;

    reg {
        name = "D17-D18 list1 APC indices";
        desc = "D17-D18 list1 APC indices Provenance: INFERRED. Source: HEVCHAL_V400R004_SetPicMsg / SetSliceMsg (GPL Kirin source); shift constants and stored word offsets of HEVCHAL_V400R001_SetPicMsg / SetSliceMsg (hi3536dv100_vfmw.ko) agree.";
        field {
            name = "apc";
            desc = "4 bits per entry, 8 entries per word (D17, D18) [INFERRED]";
            sw = rw;
            hw = r;
        } apc[31:0];
    } D17 @ 0x44;

    reg {
        name = "D23 collocated MV address (Apc2MvAddr)";
        desc = "D23 collocated MV address (Apc2MvAddr) Provenance: PROVEN (word offset). Source: HEVCHAL_V400R004_SetPicMsg / SetSliceMsg (GPL Kirin source); shift constants and stored word offsets of HEVCHAL_V400R001_SetPicMsg / SetSliceMsg (hi3536dv100_vfmw.ko) agree.";
        field {
            name = "apc2mvaddr";
            desc = " [INFERRED]";
            sw = rw;
            hw = r;
        } apc2mvaddr[31:0];
    } D23 @ 0x5C;

    reg {
        name = "D24 (R001 writes 0)";
        desc = "D24 (R001 writes 0) Provenance: PROVEN. Source: HEVCHAL_V400R001_SetSliceMsg (str to word 24).";
        field {
            name = "zero";
            desc = "written 0 by the Hi3536D module, not present in R004 [PROVEN]";
            sw = rw;
            hw = r;
        } zero[31:0];
    } D24 @ 0x60;

    reg {
        name = "D43 end CTB (raster)";
        desc = "D43 end CTB (raster) Provenance: PROVEN (word offset). Source: HEVCHAL_V400R004_SetPicMsg / SetSliceMsg (GPL Kirin source); shift constants and stored word offsets of HEVCHAL_V400R001_SetPicMsg / SetSliceMsg (hi3536dv100_vfmw.ko) agree.";
        field {
            name = "end_ctb_in_slice_raster";
            desc = " [INFERRED]";
            sw = rw;
            hw = r;
        } end_ctb_in_slice_raster[31:0];
    } D43 @ 0xAC;

    reg {
        name = "D44 end CTB (tile scan)";
        desc = "D44 end CTB (tile scan) Provenance: PROVEN (word offset). Source: HEVCHAL_V400R004_SetPicMsg / SetSliceMsg (GPL Kirin source); shift constants and stored word offsets of HEVCHAL_V400R001_SetPicMsg / SetSliceMsg (hi3536dv100_vfmw.ko) agree.";
        field {
            name = "end_ctb_in_slice_tile";
            desc = " [INFERRED]";
            sw = rw;
            hw = r;
        } end_ctb_in_slice_tile[31:0];
    } D44 @ 0xB0;

    reg {
        name = "D63 next slice message address";
        desc = "D63 next slice message address Provenance: PROVEN (word offset). Source: HEVCHAL_V400R004_SetPicMsg / SetSliceMsg (GPL Kirin source); shift constants and stored word offsets of HEVCHAL_V400R001_SetPicMsg / SetSliceMsg (hi3536dv100_vfmw.ko) agree.";
        field {
            name = "next_slice_msg_addr";
            desc = " [INFERRED]";
            sw = rw;
            hw = r;
        } next_slice_msg_addr[31:0];
    } D63 @ 0xFC;

};

regfile eHI3536D_VDH_UPMSG {
    name = "VDH up message (report) slice record (DDR, NOT registers), Hi3536D V100";
    desc = "NOT A REGISTER FILE: the VDH writes one 4-word record per decoded slice into the up message buffer (VAM_ADDR); the driver reads min(decoded_slice_num, 300) records (VDH_STATE[16:0]; R001: at most 300 slices = 4800 bytes = 1200 words, MakeDecReport 0x17a80 forces the count to 0 above 300 and ReadMsgSlot 0x1743c refuses more; R004: 200) and uses word 1 and 2 as the decoded macroblock/CTB range of each slice for error concealment: the R001 module uses only the low 16 bits of each (PROVEN, dynamic), word 3 is never read, word 0 only through the SED_STA copy (register 0x1000: [25:24] == 2 requests a whole-picture H.264 repair). Picture status is in VDH_STATE: bits [18:17] == 01 means decode over without error. Evidence: GPL V400R004 MakeDecReport; same record size 4 words for all standards on this generation (comment in the source: hi3531 uniform). Word 0 and 3 are only partly known. Record stride 16 bytes PROVEN (MakeDecReport add lsl #4).";
    reg {
        name = "W0 slice status";
        desc = "W0 slice status Provenance: INFERRED. Source: VDMHAL_V400R004_IMP_MakeDecReport / BackInfo (GPL Kirin source); R001 module: same VDH_STATE/SED_STA/SED_END0 reads in VDMHAL_V400R001_BackupInfo (offsets 0x1000, 0x1014, 0xB0-0xC0 seen).";
        field {
            name = "sed_status";
            desc = "low-delay mode: 00 no error, 10 stream end error, 01 data error, 11 reserved (R004 comment; the last slice record only) [INFERRED] BOARD 2026-11-23: W0 of a clean picture 0x14020000 (H.264) / 0x00020000 (HEVC) / 0x80430000 for a damaged HEVC picture; the flagged-but-exact H.264 CABAC pictures read 0x14230000 (bits 21 and 16 set). BOARD run 2: the same 0x14230000 / 0x14020000 pair for multi-slice and P/B pictures (record of the last slice); damaged pictures read 0x94230000, 0x94430000, 0x98230000, 0x9c230000 (bit 31 set, class 01 data error or 10 stream end error, bits 28:26 occasionally set), HEVC 0x80430000.";
            sw = rw;
            hw = r;
        } sed_status[22:21];
        field {
            name = "sed_status_normal";
            desc = "normal mode: value 2 means the whole picture needs repair (H.264) [INFERRED]";
            sw = rw;
            hw = r;
        } sed_status_normal[25:24];
    } W0 @ 0x0;

    reg {
        name = "W1 slice start";
        desc = "W1 slice start Provenance: INFERRED. Source: VDMHAL_V400R004_IMP_MakeDecReport / BackInfo (GPL Kirin source); R001 module: same VDH_STATE/SED_STA/SED_END0 reads in VDMHAL_V400R001_BackupInfo (offsets 0x1000, 0x1014, 0xB0-0xC0 seen).";
        field {
            name = "start_mb";
            desc = "first macroblock/CTB of the slice [INFERRED]";
            sw = rw;
            hw = r;
        } start_mb[19:0];
    } W1 @ 0x4;

    reg {
        name = "W2 slice end";
        desc = "W2 slice end Provenance: INFERRED. Source: VDMHAL_V400R004_IMP_MakeDecReport / BackInfo (GPL Kirin source); R001 module: same VDH_STATE/SED_STA/SED_END0 reads in VDMHAL_V400R001_BackupInfo (offsets 0x1000, 0x1014, 0xB0-0xC0 seen).";
        field {
            name = "end_mb";
            desc = "last macroblock/CTB decoded (low-delay: bits [19:0] of the last record, word 2) [INFERRED] BOARD 2026-11-23 (run 2): the record of the last slice of a complete picture holds the index of the last macroblock (63 for 128 x 128, 0x397 = 919 for 640 x 360 H.264) for I, P and B pictures and for 1 to 4 slices; a damaged picture stops short (0x7, 0x11, 0x17, 0x2f, 0x18 ...). The H.264 driver rule (accept the CABAC error flag when this value is the last block) separated 19 of 20 damaged pictures from 55 flagged good ones.";
            sw = rw;
            hw = r;
        } end_mb[19:0];
    } W2 @ 0x8;

    reg {
        name = "W3 reserved/unknown";
        desc = "W3 reserved/unknown Provenance: GUESS. Source: VDMHAL_V400R004_IMP_MakeDecReport / BackInfo (GPL Kirin source); R001 module: same VDH_STATE/SED_STA/SED_END0 reads in VDMHAL_V400R001_BackupInfo (offsets 0x1000, 0x1014, 0xB0-0xC0 seen).";
        field {
            name = "unknown";
            desc = "not used by the driver [GUESS]";
            sw = rw;
            hw = r;
        } unknown[31:0];
    } W3 @ 0xC;

};

regfile eHI3536D_VDH_H264_PICMSG {
    name = "VDH H.264 picture message (DDR, NOT registers), Hi3536D V100";
    desc = "NOT A REGISTER FILE: layout of the H.264 picture message (D0-D63) plus scaling matrix burst 1 (words 64-119) the VFMW software builds for H264HAL_V400R001_SetPicMsg; the VDH reads it through AVM_ADDR. Offsets are word index x 4. All words PROVEN (differential run); names INFERRED (R004). Differences to R004: D1 is not rounded up by 0xF, D0 bit 31 has two extra vendor-struct conditions (flag at +0x388 and a non-null current PMV buffer). The scaling matrix word packing (bytes 1 and 2 swapped in 4x4 words, 8x8 words interleaved) is read from the instruction pattern of WritePicMsg 0x1cf84 and the R004 source and is INFERRED (not run).";

    reg {
        name = "D0 sequence flags and size";
        desc = "D0. Provenance: PROVEN. Source: hi3536dv100_vfmw.ko H264HAL_V400R001_SetPicMsg (0x2ac04) / SetSliceMsg (0x2ae80), word-checked statically and by a differential run of the vendor code in qemu-arm user mode on 2026-11-22 (what the code programs, not what silicon answers); names and shift constants agree with R004 vdm_hal_h264.c (GPL Kirin source), docs/research/vdh-hi3536d-static-analysis-2026-11-22.md.";
        field {
            name = "pic_width_in_mb_minus1";
            desc = "pic_width_in_mb - 1";
            sw = rw;
            hw = r;
        } pic_width_in_mb_minus1[8:0];
        field {
            name = "structure";
            desc = "structure code from g_StructTrans[pic_structure * 2 + mbaff] = {0, 3, 1, 1, 2, 2, 3, 3}";
            sw = rw;
            hw = r;
        } structure[15:14];
        field {
            name = "pic_height_in_mb_minus1";
            desc = "pic_height_in_mb - 1";
            sw = rw;
            hw = r;
        } pic_height_in_mb_minus1[24:16];
        field {
            name = "chroma_format_is_420";
            desc = "chroma_format_idc == 1";
            sw = rw;
            hw = r;
        } chroma_format_is_420[25:25];
        field {
            name = "constrained_intra_pred_flag";
            desc = "constrained_intra_pred_flag";
            sw = rw;
            hw = r;
        } constrained_intra_pred_flag[26:26];
        field {
            name = "entropy_coding_mode_flag";
            desc = "entropy_coding_mode_flag (1 = CABAC)";
            sw = rw;
            hw = r;
        } entropy_coding_mode_flag[27:27];
        field {
            name = "transform_8x8_mode_flag";
            desc = "transform_8x8_mode_flag";
            sw = rw;
            hw = r;
        } transform_8x8_mode_flag[28:28];
        field {
            name = "ref_pic_write_pmv";
            desc = "(nal_ref_idc != 0) and a vendor flag and a non-null current PMV buffer: write the PMV of this picture (INFERRED meaning)";
            sw = rw;
            hw = r;
        } ref_pic_write_pmv[31:31];
    } D0 @ 0x0;

    reg {
        name = "D1 current picture frame address";
        desc = "D1: frame address & ~0xF (R004 rounds up first, R001 does not). Provenance: PROVEN. Source: hi3536dv100_vfmw.ko H264HAL_V400R001_SetPicMsg (0x2ac04) / SetSliceMsg (0x2ae80), word-checked statically and by a differential run of the vendor code in qemu-arm user mode on 2026-11-22 (what the code programs, not what silicon answers); names and shift constants agree with R004 vdm_hal_h264.c (GPL Kirin source), docs/research/vdh-hi3536d-static-analysis-2026-11-22.md.";
        field {
            name = "cur_pic_addr";
            desc = "current picture frame address";
            sw = rw;
            hw = r;
        } cur_pic_addr[31:0];
    } D1 @ 0x4;

    reg {
        name = "D2 POC";
        desc = "D2. Provenance: PROVEN. Source: hi3536dv100_vfmw.ko H264HAL_V400R001_SetPicMsg (0x2ac04) / SetSliceMsg (0x2ae80), word-checked statically and by a differential run of the vendor code in qemu-arm user mode on 2026-11-22 (what the code programs, not what silicon answers); names and shift constants agree with R004 vdm_hal_h264.c (GPL Kirin source), docs/research/vdh-hi3536d-static-analysis-2026-11-22.md.";
        field {
            name = "cur_poc";
            desc = "POC of the current picture";
            sw = rw;
            hw = r;
        } cur_poc[31:0];
    } D2 @ 0x8;

    reg {
        name = "D3 top POC";
        desc = "D3: top POC if MBAFF else 0. Provenance: PROVEN. Source: hi3536dv100_vfmw.ko H264HAL_V400R001_SetPicMsg (0x2ac04) / SetSliceMsg (0x2ae80), word-checked statically and by a differential run of the vendor code in qemu-arm user mode on 2026-11-22 (what the code programs, not what silicon answers); names and shift constants agree with R004 vdm_hal_h264.c (GPL Kirin source), docs/research/vdh-hi3536d-static-analysis-2026-11-22.md.";
        field {
            name = "top_poc";
            desc = "top field POC (MBAFF)";
            sw = rw;
            hw = r;
        } top_poc[31:0];
    } D3 @ 0xC;

    reg {
        name = "D4 bottom POC";
        desc = "D4: bottom POC if MBAFF else 0. Provenance: PROVEN. Source: hi3536dv100_vfmw.ko H264HAL_V400R001_SetPicMsg (0x2ac04) / SetSliceMsg (0x2ae80), word-checked statically and by a differential run of the vendor code in qemu-arm user mode on 2026-11-22 (what the code programs, not what silicon answers); names and shift constants agree with R004 vdm_hal_h264.c (GPL Kirin source), docs/research/vdh-hi3536d-static-analysis-2026-11-22.md.";
        field {
            name = "bottom_poc";
            desc = "bottom field POC (MBAFF)";
            sw = rw;
            hw = r;
        } bottom_poc[31:0];
    } D4 @ 0x10;

    reg {
        name = "D5 SED top line buffer";
        desc = "D5: & ~0xF. Sizes: see eHI3536D_VDH_PICMSG D4 and docs (H.264-only memory mode uses 3A, one 8A block for the transform/dblk tops). Provenance: PROVEN. Source: hi3536dv100_vfmw.ko H264HAL_V400R001_SetPicMsg (0x2ac04) / SetSliceMsg (0x2ae80), word-checked statically and by a differential run of the vendor code in qemu-arm user mode on 2026-11-22 (what the code programs, not what silicon answers); names and shift constants agree with R004 vdm_hal_h264.c (GPL Kirin source), docs/research/vdh-hi3536d-static-analysis-2026-11-22.md.";
        field {
            name = "sed_top_addr";
            desc = "SED top line buffer";
            sw = rw;
            hw = r;
        } sed_top_addr[31:0];
    } D5 @ 0x14;

    reg {
        name = "D6 PMV top line buffer";
        desc = "D6. Provenance: PROVEN. Source: hi3536dv100_vfmw.ko H264HAL_V400R001_SetPicMsg (0x2ac04) / SetSliceMsg (0x2ae80), word-checked statically and by a differential run of the vendor code in qemu-arm user mode on 2026-11-22 (what the code programs, not what silicon answers); names and shift constants agree with R004 vdm_hal_h264.c (GPL Kirin source), docs/research/vdh-hi3536d-static-analysis-2026-11-22.md.";
        field {
            name = "pmv_top_addr";
            desc = "PMV top line buffer";
            sw = rw;
            hw = r;
        } pmv_top_addr[31:0];
    } D6 @ 0x18;

    reg {
        name = "D7 PMV buffer of the current picture";
        desc = "D7: & ~0xF, plus half_pmvblk_offset for pic_structure == 2. Provenance: PROVEN. Source: hi3536dv100_vfmw.ko H264HAL_V400R001_SetPicMsg (0x2ac04) / SetSliceMsg (0x2ae80), word-checked statically and by a differential run of the vendor code in qemu-arm user mode on 2026-11-22 (what the code programs, not what silicon answers); names and shift constants agree with R004 vdm_hal_h264.c (GPL Kirin source), docs/research/vdh-hi3536d-static-analysis-2026-11-22.md.";
        field {
            name = "pmv_cur_addr";
            desc = "current picture PMV (co-located motion vector) buffer";
            sw = rw;
            hw = r;
        } pmv_cur_addr[31:0];
    } D7 @ 0x1C;

    reg {
        name = "D8 RCN/ITRANS top line buffer";
        desc = "D8. Provenance: PROVEN. Source: hi3536dv100_vfmw.ko H264HAL_V400R001_SetPicMsg (0x2ac04) / SetSliceMsg (0x2ae80), word-checked statically and by a differential run of the vendor code in qemu-arm user mode on 2026-11-22 (what the code programs, not what silicon answers); names and shift constants agree with R004 vdm_hal_h264.c (GPL Kirin source), docs/research/vdh-hi3536d-static-analysis-2026-11-22.md.";
        field {
            name = "rcn_top_addr";
            desc = "RCN/ITRANS top line buffer";
            sw = rw;
            hw = r;
        } rcn_top_addr[31:0];
    } D8 @ 0x20;

    reg {
        name = "D9 first slice message address";
        desc = "D9: & ~0xF. Provenance: PROVEN. Source: hi3536dv100_vfmw.ko H264HAL_V400R001_SetPicMsg (0x2ac04) / SetSliceMsg (0x2ae80), word-checked statically and by a differential run of the vendor code in qemu-arm user mode on 2026-11-22 (what the code programs, not what silicon answers); names and shift constants agree with R004 vdm_hal_h264.c (GPL Kirin source), docs/research/vdh-hi3536d-static-analysis-2026-11-22.md.";
        field {
            name = "first_slice_msg_addr";
            desc = "address of the first slice message";
            sw = rw;
            hw = r;
        } first_slice_msg_addr[31:0];
    } D9 @ 0x24;

    reg {
        name = "D10 reference picture address";
        desc = "D10-D25: the 16 reference picture addresses & ~0xF (the same buffers as the output frames; entries beyond the reference count repeat entry 0). Provenance: PROVEN. Source: hi3536dv100_vfmw.ko H264HAL_V400R001_SetPicMsg (0x2ac04) / SetSliceMsg (0x2ae80), word-checked statically and by a differential run of the vendor code in qemu-arm user mode on 2026-11-22 (what the code programs, not what silicon answers); names and shift constants agree with R004 vdm_hal_h264.c (GPL Kirin source), docs/research/vdh-hi3536d-static-analysis-2026-11-22.md. BOARD 2026-11-24 (run 3, design doc docs/drivers/vdh-design.md 17.3 H0): the index of an entry of the DPB tables (D10 addresses, D27 POCs, the D20-D35 list indices, D36 map) is the identity under which the hardware keeps a reference picture in the motion vector data of the pictures it decodes: H.264 temporal direct (colocated data) decodes wrong when the entry order of the tables changes from the picture that was decoded to the later B picture that uses it as the colocated picture (7 streams, all B pictures wrong, no error flag) and byte exact when every reference keeps one index while it is in the DPB (stable slots; the same streams, 21 streams of the group exact). P pictures, B pictures with spatial direct, long term and modified lists do not depend on it.";
        field {
            name = "ref_pic_addr";
            desc = "reference frame address";
            sw = rw;
            hw = r;
        } ref_pic_addr[31:0];
    } D10[16] @ 0x28 += 0x4;

    reg {
        name = "D26 CABAC table address";
        desc = "D26: the 5120-byte (m,n) table (H.264 g_CabacMN image, see docs: regenerated byte for byte from the standard tables 9-12..9-33). Provenance: PROVEN. Source: hi3536dv100_vfmw.ko H264HAL_V400R001_SetPicMsg (0x2ac04) / SetSliceMsg (0x2ae80), word-checked statically and by a differential run of the vendor code in qemu-arm user mode on 2026-11-22 (what the code programs, not what silicon answers); names and shift constants agree with R004 vdm_hal_h264.c (GPL Kirin source), docs/research/vdh-hi3536d-static-analysis-2026-11-22.md.";
        field {
            name = "mn_addr";
            desc = "CABAC (m,n) table address";
            sw = rw;
            hw = r;
        } mn_addr[31:0];
    } D26 @ 0x68;

    reg {
        name = "D27 reference POC";
        desc = "D27-D58: 16 x (POC top/list0, POC bottom) for the reference entries, zero padded. Provenance: PROVEN. Source: hi3536dv100_vfmw.ko H264HAL_V400R001_SetPicMsg (0x2ac04) / SetSliceMsg (0x2ae80), word-checked statically and by a differential run of the vendor code in qemu-arm user mode on 2026-11-22 (what the code programs, not what silicon answers); names and shift constants agree with R004 vdm_hal_h264.c (GPL Kirin source), docs/research/vdh-hi3536d-static-analysis-2026-11-22.md. BOARD 2026-11-24: see D10 (the entry index must be stable per picture for temporal direct).";
        field {
            name = "ref_poc";
            desc = "reference POC word";
            sw = rw;
            hw = r;
        } ref_poc[31:0];
    } D27[32] @ 0x6C += 0x4;

    reg {
        name = "D59 DBLK top line buffer";
        desc = "D59: & ~0xF. Provenance: PROVEN. Source: hi3536dv100_vfmw.ko H264HAL_V400R001_SetPicMsg (0x2ac04) / SetSliceMsg (0x2ae80), word-checked statically and by a differential run of the vendor code in qemu-arm user mode on 2026-11-22 (what the code programs, not what silicon answers); names and shift constants agree with R004 vdm_hal_h264.c (GPL Kirin source), docs/research/vdh-hi3536d-static-analysis-2026-11-22.md.";
        field {
            name = "dblk_top_addr";
            desc = "DBLK top line buffer";
            sw = rw;
            hw = r;
        } dblk_top_addr[31:0];
    } D59 @ 0xEC;

    reg {
        name = "D64 scaling matrix";
        desc = "D64-D119 (burst 1): 56 words = 6 x 4x4 lists (24 words) + 2 x 8x8 lists, Intra Y and Inter Y (32 words); 4:2:0 / 4:2:2 only. Provenance: PROVEN position, INFERRED packing. Source: hi3536dv100_vfmw.ko H264HAL_V400R001_SetPicMsg (0x2ac04) / SetSliceMsg (0x2ae80), word-checked statically and by a differential run of the vendor code in qemu-arm user mode on 2026-11-22 (what the code programs, not what silicon answers); names and shift constants agree with R004 vdm_hal_h264.c (GPL Kirin source), docs/research/vdh-hi3536d-static-analysis-2026-11-22.md.";
        field {
            name = "scaling_word";
            desc = "scaling matrix word (packing INFERRED)";
            sw = rw;
            hw = r;
        } scaling_word[31:0];
    } D64[56] @ 0x100 += 0x4;

};

regfile eHI3536D_VDH_H264_SLICEMSG {
    name = "VDH H.264 slice message (DDR, NOT registers), Hi3536D V100";
    desc = "NOT A REGISTER FILE: one 64-word slice message per H.264 slice plus the weighted prediction bursts (words 64-255), chained by D63 (0 ends the chain), built by H264HAL_V400R001_SetSliceMsg. Equal to the R004 text word for word; unlike the Hi3520D generation D44 (last macroblock) is written in both branches. All positions PROVEN (static plus differential run); B/field-related words INFERRED.";

    reg {
        name = "D0 segment 0 byte offset";
        desc = "D0: (bytespos & ~0xF) - (STREAM_BASE_ADDR & ~0xF). D1[6:0] bit offset, D2 valid bit length (conventions: see eHI3536D_VDH_SLICEMSG). Provenance: PROVEN. Source: hi3536dv100_vfmw.ko H264HAL_V400R001_SetPicMsg (0x2ac04) / SetSliceMsg (0x2ae80), word-checked statically and by a differential run of the vendor code in qemu-arm user mode on 2026-11-22 (what the code programs, not what silicon answers); names and shift constants agree with R004 vdm_hal_h264.c (GPL Kirin source), docs/research/vdh-hi3536d-static-analysis-2026-11-22.md.";
        field {
            name = "byte_offset";
            desc = "segment 0 byte offset";
            sw = rw;
            hw = r;
        } byte_offset[31:0];
    } D0 @ 0x0;

    reg {
        name = "D1 segment 0 bit offset";
        desc = "D1. Provenance: PROVEN. Source: hi3536dv100_vfmw.ko H264HAL_V400R001_SetPicMsg (0x2ac04) / SetSliceMsg (0x2ae80), word-checked statically and by a differential run of the vendor code in qemu-arm user mode on 2026-11-22 (what the code programs, not what silicon answers); names and shift constants agree with R004 vdm_hal_h264.c (GPL Kirin source), docs/research/vdh-hi3536d-static-analysis-2026-11-22.md.";
        field {
            name = "bit_offset";
            desc = "(bitsoffset + 8 * bytespos) & 0x7F";
            sw = rw;
            hw = r;
        } bit_offset[6:0];
    } D1 @ 0x4;

    reg {
        name = "D2 segment 0 valid bit length";
        desc = "D2. Provenance: PROVEN. Source: hi3536dv100_vfmw.ko H264HAL_V400R001_SetPicMsg (0x2ac04) / SetSliceMsg (0x2ae80), word-checked statically and by a differential run of the vendor code in qemu-arm user mode on 2026-11-22 (what the code programs, not what silicon answers); names and shift constants agree with R004 vdm_hal_h264.c (GPL Kirin source), docs/research/vdh-hi3536d-static-analysis-2026-11-22.md.";
        field {
            name = "valid_bitlen";
            desc = "valid bits (H.264 CABAC: stop bit counted as valid)";
            sw = rw;
            hw = r;
        } valid_bitlen[31:0];
    } D2 @ 0x8;

    reg {
        name = "D3 segment 1 byte offset";
        desc = "D3-D5: the same three words for the second segment (ring-buffer wrap); all zero when valid_bitlen1 == 0. Provenance: PROVEN. Source: hi3536dv100_vfmw.ko H264HAL_V400R001_SetPicMsg (0x2ac04) / SetSliceMsg (0x2ae80), word-checked statically and by a differential run of the vendor code in qemu-arm user mode on 2026-11-22 (what the code programs, not what silicon answers); names and shift constants agree with R004 vdm_hal_h264.c (GPL Kirin source), docs/research/vdh-hi3536d-static-analysis-2026-11-22.md.";
        field {
            name = "seg1_word";
            desc = "segment 1 word";
            sw = rw;
            hw = r;
        } seg1_word[31:0];
    } D3[3] @ 0xC += 0x4;

    reg {
        name = "D6 slice control";
        desc = "D6. Provenance: PROVEN. Source: hi3536dv100_vfmw.ko H264HAL_V400R001_SetPicMsg (0x2ac04) / SetSliceMsg (0x2ae80), word-checked statically and by a differential run of the vendor code in qemu-arm user mode on 2026-11-22 (what the code programs, not what silicon answers); names and shift constants agree with R004 vdm_hal_h264.c (GPL Kirin source), docs/research/vdh-hi3536d-static-analysis-2026-11-22.md.";
        field {
            name = "first_mb_in_slice";
            desc = "first_mb_in_slice";
            sw = rw;
            hw = r;
        } first_mb_in_slice[19:0];
        field {
            name = "cabac_init_idc";
            desc = "cabac_init_idc & 3 (must be 0 for I slices: selects the (m,n) set, INFERRED)";
            sw = rw;
            hw = r;
        } cabac_init_idc[25:24];
        field {
            name = "slice_qp";
            desc = "slice QP (signed byte shifted, no mask)";
            sw = rw;
            hw = r;
        } slice_qp[31:26];
    } D6 @ 0x18;

    reg {
        name = "D7 slice reference setup";
        desc = "D7. Provenance: PROVEN. Source: hi3536dv100_vfmw.ko H264HAL_V400R001_SetPicMsg (0x2ac04) / SetSliceMsg (0x2ae80), word-checked statically and by a differential run of the vendor code in qemu-arm user mode on 2026-11-22 (what the code programs, not what silicon answers); names and shift constants agree with R004 vdm_hal_h264.c (GPL Kirin source), docs/research/vdh-hi3536d-static-analysis-2026-11-22.md.";
        field {
            name = "slice_type";
            desc = "P = 1, B = 2, I = 0 (g_SliceTypeForPMV)";
            sw = rw;
            hw = r;
        } slice_type[1:0];
        field {
            name = "listsize0";
            desc = "list0 size";
            sw = rw;
            hw = r;
        } listsize0[7:2];
        field {
            name = "listsize1";
            desc = "list1 size";
            sw = rw;
            hw = r;
        } listsize1[13:8];
        field {
            name = "direct_8x8_inference";
            desc = "direct_8x8_inference_flag";
            sw = rw;
            hw = r;
        } direct_8x8_inference[14:14];
        field {
            name = "direct_spatial_mv_pred";
            desc = "direct_spatial_mv_pred_flag";
            sw = rw;
            hw = r;
        } direct_spatial_mv_pred[15:15];
        field {
            name = "num_ref_idx_l0_active_minus1";
            desc = "num_ref_idx_l0_active_minus1";
            sw = rw;
            hw = r;
        } num_ref_idx_l0_active_minus1[20:16];
        field {
            name = "num_ref_idx_l1_active_minus1";
            desc = "num_ref_idx_l1_active_minus1";
            sw = rw;
            hw = r;
        } num_ref_idx_l1_active_minus1[25:21];
    } D7 @ 0x1C;

    reg {
        name = "D8 list1[0] PMV address";
        desc = "D8-D9 (B slices only): PMV address of list1[0] & ~0xF; D9 the same + half_pmvblk_offset for field pairs else 0 (INFERRED). Provenance: PROVEN position, INFERRED meaning. Source: hi3536dv100_vfmw.ko H264HAL_V400R001_SetPicMsg (0x2ac04) / SetSliceMsg (0x2ae80), word-checked statically and by a differential run of the vendor code in qemu-arm user mode on 2026-11-22 (what the code programs, not what silicon answers); names and shift constants agree with R004 vdm_hal_h264.c (GPL Kirin source), docs/research/vdh-hi3536d-static-analysis-2026-11-22.md. BOARD 2026-11-24: byte exact for B slices with spatial direct and for temporal direct once the DPB indices are stable (see D10 of the picture message).";
        field {
            name = "col_pmv_addr";
            desc = "PMV address of list1[0]";
            sw = rw;
            hw = r;
        } col_pmv_addr[31:0];
    } D8[2] @ 0x20 += 0x4;

    reg {
        name = "D10 weighting and chroma QP";
        desc = "D10. Provenance: PROVEN. Source: hi3536dv100_vfmw.ko H264HAL_V400R001_SetPicMsg (0x2ac04) / SetSliceMsg (0x2ae80), word-checked statically and by a differential run of the vendor code in qemu-arm user mode on 2026-11-22 (what the code programs, not what silicon answers); names and shift constants agree with R004 vdm_hal_h264.c (GPL Kirin source), docs/research/vdh-hi3536d-static-analysis-2026-11-22.md.";
        field {
            name = "second_chroma_qp_index_offset";
            desc = "second_chroma_qp_index_offset & 0x1F";
            sw = rw;
            hw = r;
        } second_chroma_qp_index_offset[4:0];
        field {
            name = "chroma_qp_index_offset";
            desc = "chroma_qp_index_offset & 0x1F";
            sw = rw;
            hw = r;
        } chroma_qp_index_offset[9:5];
        field {
            name = "weight_mode";
            desc = "Prediction weighting of the slice: weighted_pred_flag for P slices, weighted_bipred_idc for B slices (0 none, 1 explicit, 2 implicit), 0 for I slices; the vendor code writes the value shifted by 16 (R004 `weight_flag << 16`), so the implicit mode sets bit 17. Earlier text called bit 16 a one-bit 'explicit weighted prediction' flag [PROVEN position and value rule, INFERRED hardware reading]";
            sw = rw;
            hw = r;
        } weight_mode[17:16];
    } D10 @ 0x28;

    reg {
        name = "D11 deblocking";
        desc = "D11. Provenance: PROVEN. Source: hi3536dv100_vfmw.ko H264HAL_V400R001_SetPicMsg (0x2ac04) / SetSliceMsg (0x2ae80), word-checked statically and by a differential run of the vendor code in qemu-arm user mode on 2026-11-22 (what the code programs, not what silicon answers); names and shift constants agree with R004 vdm_hal_h264.c (GPL Kirin source), docs/research/vdh-hi3536d-static-analysis-2026-11-22.md.";
        field {
            name = "disable_deblocking_filter_idc";
            desc = "disable_deblocking_filter_idc";
            sw = rw;
            hw = r;
        } disable_deblocking_filter_idc[7:0];
        field {
            name = "slice_beta_offset_div2";
            desc = "slice_beta_offset_div2 & 0xF";
            sw = rw;
            hw = r;
        } slice_beta_offset_div2[11:8];
        field {
            name = "slice_alpha_c0_offset_div2";
            desc = "slice_alpha_c0_offset_div2 & 0xF";
            sw = rw;
            hw = r;
        } slice_alpha_c0_offset_div2[19:16];
    } D11 @ 0x2C;

    reg {
        name = "D12 list0 reference flags";
        desc = "D12-D15: 8 entries per word, nibble i % 8: bit 3 long-term, bit 2 field marker (field slices only), [1:0] structure code (frame: g_ListStructFrame[structure][mbaff] = {0, 1, 3, 3, 3, 3, 2, 2}). Provenance: PROVEN. Source: hi3536dv100_vfmw.ko H264HAL_V400R001_SetPicMsg (0x2ac04) / SetSliceMsg (0x2ae80), word-checked statically and by a differential run of the vendor code in qemu-arm user mode on 2026-11-22 (what the code programs, not what silicon answers); names and shift constants agree with R004 vdm_hal_h264.c (GPL Kirin source), docs/research/vdh-hi3536d-static-analysis-2026-11-22.md.";
        field {
            name = "list0_flags";
            desc = "list0 reference flag nibbles";
            sw = rw;
            hw = r;
        } list0_flags[31:0];
    } D12[4] @ 0x30 += 0x4;

    reg {
        name = "D16 list1 reference flags";
        desc = "D16-D19: the same for list1 (B slices only). Provenance: PROVEN. Source: hi3536dv100_vfmw.ko H264HAL_V400R001_SetPicMsg (0x2ac04) / SetSliceMsg (0x2ae80), word-checked statically and by a differential run of the vendor code in qemu-arm user mode on 2026-11-22 (what the code programs, not what silicon answers); names and shift constants agree with R004 vdm_hal_h264.c (GPL Kirin source), docs/research/vdh-hi3536d-static-analysis-2026-11-22.md.";
        field {
            name = "list1_flags";
            desc = "list1 reference flag nibbles";
            sw = rw;
            hw = r;
        } list1_flags[31:0];
    } D16[4] @ 0x40 += 0x4;

    reg {
        name = "D20 list0 picture indices";
        desc = "D20-D27: 4 entries per word, 5 bits each at 5 * (i % 4): (apc_idx << 1) & 0x1F, | 1 for a bottom field. Provenance: PROVEN. Source: hi3536dv100_vfmw.ko H264HAL_V400R001_SetPicMsg (0x2ac04) / SetSliceMsg (0x2ae80), word-checked statically and by a differential run of the vendor code in qemu-arm user mode on 2026-11-22 (what the code programs, not what silicon answers); names and shift constants agree with R004 vdm_hal_h264.c (GPL Kirin source), docs/research/vdh-hi3536d-static-analysis-2026-11-22.md.";
        field {
            name = "list0_idx";
            desc = "list0 picture index word";
            sw = rw;
            hw = r;
        } list0_idx[31:0];
    } D20[8] @ 0x50 += 0x4;

    reg {
        name = "D28 list1 picture indices";
        desc = "D28-D35: the same for list1. Provenance: PROVEN. Source: hi3536dv100_vfmw.ko H264HAL_V400R001_SetPicMsg (0x2ac04) / SetSliceMsg (0x2ae80), word-checked statically and by a differential run of the vendor code in qemu-arm user mode on 2026-11-22 (what the code programs, not what silicon answers); names and shift constants agree with R004 vdm_hal_h264.c (GPL Kirin source), docs/research/vdh-hi3536d-static-analysis-2026-11-22.md.";
        field {
            name = "list1_idx";
            desc = "list1 picture index word";
            sw = rw;
            hw = r;
        } list1_idx[31:0];
    } D28[8] @ 0x70 += 0x4;

    reg {
        name = "D36 APC to reference index map";
        desc = "D36-D43: 32 entries, 4 per word, 5 bits each at 5 * (i % 4). Provenance: PROVEN. Source: hi3536dv100_vfmw.ko H264HAL_V400R001_SetPicMsg (0x2ac04) / SetSliceMsg (0x2ae80), word-checked statically and by a differential run of the vendor code in qemu-arm user mode on 2026-11-22 (what the code programs, not what silicon answers); names and shift constants agree with R004 vdm_hal_h264.c (GPL Kirin source), docs/research/vdh-hi3536d-static-analysis-2026-11-22.md.";
        field {
            name = "apc_map";
            desc = "apc map word";
            sw = rw;
            hw = r;
        } apc_map[31:0];
    } D36[8] @ 0x90 += 0x4;

    reg {
        name = "D44 last macroblock";
        desc = "D44: last macroblock of the slice: the last_mb argument if a next slice exists, else (mbtodec - 1) / (1 + mbaff). Provenance: PROVEN. Source: hi3536dv100_vfmw.ko H264HAL_V400R001_SetPicMsg (0x2ac04) / SetSliceMsg (0x2ae80), word-checked statically and by a differential run of the vendor code in qemu-arm user mode on 2026-11-22 (what the code programs, not what silicon answers); names and shift constants agree with R004 vdm_hal_h264.c (GPL Kirin source), docs/research/vdh-hi3536d-static-analysis-2026-11-22.md.";
        field {
            name = "end_mb";
            desc = "last macroblock of the slice";
            sw = rw;
            hw = r;
        } end_mb[31:0];
    } D44 @ 0xB0;

    reg {
        name = "D63 next slice message address";
        desc = "D63: & ~0xF, 0 ends the chain. Provenance: PROVEN. Source: hi3536dv100_vfmw.ko H264HAL_V400R001_SetPicMsg (0x2ac04) / SetSliceMsg (0x2ae80), word-checked statically and by a differential run of the vendor code in qemu-arm user mode on 2026-11-22 (what the code programs, not what silicon answers); names and shift constants agree with R004 vdm_hal_h264.c (GPL Kirin source), docs/research/vdh-hi3536d-static-analysis-2026-11-22.md.";
        field {
            name = "next_slice_msg_addr";
            desc = "next slice message address";
            sw = rw;
            hw = r;
        } next_slice_msg_addr[31:0];
    } D63 @ 0xFC;

    reg {
        name = "W64 luma weight list0";
        desc = "Words 64-95: luma weight/offset list0 (i < 32): [19:12] offset (signed 8), [11:3] weight (9 bits), [2:0] log2 denominator. Weighted bursts exist only if (weighted_pred_flag and P) or (weighted_bipred_idc == 1 and B). Provenance: PROVEN. Source: hi3536dv100_vfmw.ko H264HAL_V400R001_SetPicMsg (0x2ac04) / SetSliceMsg (0x2ae80), word-checked statically and by a differential run of the vendor code in qemu-arm user mode on 2026-11-22 (what the code programs, not what silicon answers); names and shift constants agree with R004 vdm_hal_h264.c (GPL Kirin source), docs/research/vdh-hi3536d-static-analysis-2026-11-22.md.";
        field {
            name = "luma_l0";
            desc = "luma weight word";
            sw = rw;
            hw = r;
        } luma_l0[31:0];
    } W64[32] @ 0x100 += 0x4;

    reg {
        name = "W96 luma weight list1";
        desc = "Words 96-127: luma list1, same format. Provenance: PROVEN. Source: hi3536dv100_vfmw.ko H264HAL_V400R001_SetPicMsg (0x2ac04) / SetSliceMsg (0x2ae80), word-checked statically and by a differential run of the vendor code in qemu-arm user mode on 2026-11-22 (what the code programs, not what silicon answers); names and shift constants agree with R004 vdm_hal_h264.c (GPL Kirin source), docs/research/vdh-hi3536d-static-analysis-2026-11-22.md.";
        field {
            name = "luma_l1";
            desc = "luma weight word";
            sw = rw;
            hw = r;
        } luma_l1[31:0];
    } W96[32] @ 0x180 += 0x4;

    reg {
        name = "W128 Cb weight list0";
        desc = "Words 128-159: Cb list0, same format with the chroma denominator. Provenance: PROVEN. Source: hi3536dv100_vfmw.ko H264HAL_V400R001_SetPicMsg (0x2ac04) / SetSliceMsg (0x2ae80), word-checked statically and by a differential run of the vendor code in qemu-arm user mode on 2026-11-22 (what the code programs, not what silicon answers); names and shift constants agree with R004 vdm_hal_h264.c (GPL Kirin source), docs/research/vdh-hi3536d-static-analysis-2026-11-22.md.";
        field {
            name = "cb_l0";
            desc = "Cb weight word";
            sw = rw;
            hw = r;
        } cb_l0[31:0];
    } W128[32] @ 0x200 += 0x4;

    reg {
        name = "W160 Cb weight list1";
        desc = "Words 160-191: Cb list1. Provenance: PROVEN. Source: hi3536dv100_vfmw.ko H264HAL_V400R001_SetPicMsg (0x2ac04) / SetSliceMsg (0x2ae80), word-checked statically and by a differential run of the vendor code in qemu-arm user mode on 2026-11-22 (what the code programs, not what silicon answers); names and shift constants agree with R004 vdm_hal_h264.c (GPL Kirin source), docs/research/vdh-hi3536d-static-analysis-2026-11-22.md.";
        field {
            name = "cb_l1";
            desc = "Cb weight word";
            sw = rw;
            hw = r;
        } cb_l1[31:0];
    } W160[32] @ 0x280 += 0x4;

    reg {
        name = "W192 Cr weight list0";
        desc = "Words 192-223: Cr list0: [16:9] offset (signed 8), [8:0] weight (no denominator). Provenance: PROVEN. Source: hi3536dv100_vfmw.ko H264HAL_V400R001_SetPicMsg (0x2ac04) / SetSliceMsg (0x2ae80), word-checked statically and by a differential run of the vendor code in qemu-arm user mode on 2026-11-22 (what the code programs, not what silicon answers); names and shift constants agree with R004 vdm_hal_h264.c (GPL Kirin source), docs/research/vdh-hi3536d-static-analysis-2026-11-22.md.";
        field {
            name = "cr_l0";
            desc = "Cr weight word";
            sw = rw;
            hw = r;
        } cr_l0[31:0];
    } W192[32] @ 0x300 += 0x4;

    reg {
        name = "W224 Cr weight list1";
        desc = "Words 224-255: Cr list1. Provenance: PROVEN. Source: hi3536dv100_vfmw.ko H264HAL_V400R001_SetPicMsg (0x2ac04) / SetSliceMsg (0x2ae80), word-checked statically and by a differential run of the vendor code in qemu-arm user mode on 2026-11-22 (what the code programs, not what silicon answers); names and shift constants agree with R004 vdm_hal_h264.c (GPL Kirin source), docs/research/vdh-hi3536d-static-analysis-2026-11-22.md.";
        field {
            name = "cr_l1";
            desc = "Cr weight word";
            sw = rw;
            hw = r;
        } cr_l1[31:0];
    } W224[32] @ 0x380 += 0x4;

};

regfile eHI3536D_VDH_TILETAB {
    name = "VDH HEVC tile table (DDR, NOT registers), Hi3536D V100";
    desc = "NOT A REGISTER FILE: 298 words (1192 bytes) at the address in picture message D55, written for every picture by HEVC_WriteTileInfo, 16-byte aligned. Limits of this chip: at most 16 tile columns, 11 tile rows, 256 tile-id entries per direction (matches the vendor Logic limit messages). The tile-id entries are indexed in 16-pixel units, not CTBs (HEVC_CalcTileInfo of the Hi3536D module shifts the CTB position by log2(CTB size) - 4, disassembly 0x2d348 `sub r9, r9, #4`, 2026-11-23): 256 entries cover 4096 pixels. Entry point offsets are neither passed nor used (M9). Layout PROVEN (dynamic run); that the hardware uses TileId is INFERRED; the content for a picture without tiles is INFERRED from R004 HEVC_CalcTileInfo (not run).";

    reg {
        name = "TILEID_COL";
        desc = "Words 0-127: one byte per 16-pixel column unit j (byte j % 4 of word j / 4) = index of the tile column containing it (the CTB column position is multiplied by CTB size / 16: for a 64 pixel CTB every CTB column fills four bytes); only j <= 255 written (words 64-127 stay zero). Provenance: PROVEN. Source: hi3536dv100_vfmw.ko HEVC_WriteTileInfo (0x4059c), dynamic run of the vendor code in qemu-arm user mode on 2026-11-22 (what it programs, not what silicon answers), docs/research/vdh-hi3536d-static-analysis-2026-11-22.md.";
        field {
            name = "tileid_col_word";
            desc = "four tile column indices";
            sw = rw;
            hw = r;
        } tileid_col_word[31:0];
    } TILEID_COL[128] @ 0x0 += 0x4;

    reg {
        name = "TILEID_ROW";
        desc = "Words 128-255: one byte per 16-pixel row unit = tile row index (same unit and limit; words 192-255 stay zero). Provenance: PROVEN. Source: hi3536dv100_vfmw.ko HEVC_WriteTileInfo (0x4059c), dynamic run of the vendor code in qemu-arm user mode on 2026-11-22 (what it programs, not what silicon answers), docs/research/vdh-hi3536d-static-analysis-2026-11-22.md.";
        field {
            name = "tileid_row_word";
            desc = "four tile row indices";
            sw = rw;
            hw = r;
        } tileid_row_word[31:0];
    } TILEID_ROW[128] @ 0x200 += 0x4;

    reg {
        name = "TILEPOSX";
        desc = "Words 256-271: (last_ctb_column << 16) | first_ctb_column of tile column i (i < 16); words 272-275 zero. Provenance: PROVEN. Source: hi3536dv100_vfmw.ko HEVC_WriteTileInfo (0x4059c), dynamic run of the vendor code in qemu-arm user mode on 2026-11-22 (what it programs, not what silicon answers), docs/research/vdh-hi3536d-static-analysis-2026-11-22.md.";
        field {
            name = "first_ctb_col";
            desc = "first CTB column of the tile column";
            sw = rw;
            hw = r;
        } first_ctb_col[15:0];
        field {
            name = "last_ctb_col";
            desc = "last CTB column";
            sw = rw;
            hw = r;
        } last_ctb_col[31:16];
    } TILEPOSX[16] @ 0x400 += 0x4;

    reg {
        name = "TILEPOSY";
        desc = "Words 276-286: (last_ctb_row << 16) | first_ctb_row of tile row i (i < 11); words 287-297 zero. Provenance: PROVEN. Source: hi3536dv100_vfmw.ko HEVC_WriteTileInfo (0x4059c), dynamic run of the vendor code in qemu-arm user mode on 2026-11-22 (what it programs, not what silicon answers), docs/research/vdh-hi3536d-static-analysis-2026-11-22.md.";
        field {
            name = "first_ctb_row";
            desc = "first CTB row of the tile row";
            sw = rw;
            hw = r;
        } first_ctb_row[15:0];
        field {
            name = "last_ctb_row";
            desc = "last CTB row";
            sw = rw;
            hw = r;
        } last_ctb_row[31:16];
    } TILEPOSY[11] @ 0x450 += 0x4;

};

addrmap aHI3536D_VDH_MSG {
    name = "VDH DDR message layouts (placeholder window, NOT hardware)";
    desc = "Placeholder address 0x13210000 just past the VDH window (reserved in the data sheet): this only shows the DDR message layouts (HEVC and H.264 picture/slice, up message, HEVC tile table) in the register browser. The words live in the message pool in DDR, never at this address.";
    eHI3536D_VDH_PICMSG   PICMSG   @ 0x0;
    eHI3536D_VDH_SLICEMSG SLICEMSG @ 0x1000;
    eHI3536D_VDH_UPMSG    UPMSG    @ 0x2000;
    eHI3536D_VDH_H264_PICMSG   H264_PICMSG   @ 0x3000;
    eHI3536D_VDH_H264_SLICEMSG H264_SLICEMSG @ 0x4000;
    eHI3536D_VDH_TILETAB       TILETAB       @ 0x5000;
};

`endif
