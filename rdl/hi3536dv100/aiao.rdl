`ifndef HI3536D_AIAO_RDL
`define HI3536D_AIAO_RDL
regfile eHI3536D_AIAO {
    name = "Audio interface (AIAO), Hi3536D V100";
    desc = "Audio interface (AIAO), Hi3536D V100 of the Hi3536D V100 at base 0x1304_0000. 40 registers extracted programmatically from the Hi3536D V100 data sheet (Issue 00B04, 2017-12-13) (Table 10-2 Summary of AIAO registers (base address: 0x1304_0000)): register headings, offsets, total reset values, field bit ranges, access types, names, reset values and descriptions, with PDF page numbers in each register description. Field names, bit ranges, access types and offsets are exact; the free-text descriptions are taken from the cell text of the field table and were checked by sampling only. Hardware not verified.";
    reg {
        name = "AIAO_INT_ENA";
        desc = "AIAO_INT_ENA is an AIAO interrupt enable register. (offset 0x0; total reset 0x00000000; PROVEN: Hi3536D V100 data sheet (Issue 00B04, 2017-12-13), section 10.1.6, PDF page 599).";
        field {
            name = "reserved";
            desc = "Reserved";
            sw = r; hw = w;
            reset = 0x0;
        } reserved_31_18[31:18];
        field {
            name = "tx_ch1_int_ena";
            desc = "TX channel 1 interrupt enable
- 0: disabled
- 1: enabled";
            sw = rw; hw = r;
            reset = 0x0;
        } tx_ch1_int_ena[17:17];
        field {
            name = "tx_ch0_int_ena";
            desc = "TX channel 0 interrupt enable
- 0: disabled
- 1: enabled";
            sw = rw; hw = r;
            reset = 0x0;
        } tx_ch0_int_ena[16:16];
        field {
            name = "reserved";
            desc = "Reserved";
            sw = r; hw = w;
            reset = 0x0;
        } reserved_15_1[15:1];
        field {
            name = "rx_ch0_int_ena";
            desc = "RX channel 0 interrupt enable
- 0: disabled
- 1: enabled";
            sw = rw; hw = r;
            reset = 0x0;
        } rx_ch0_int_ena[0:0];
    } AIAO_INT_ENA @ 0x0;
    reg {
        name = "AIAO_INT_STATUS";
        desc = "AIAO_INT_STATUS is an AIAO interrupt status register. (offset 0x4; total reset 0x00000000; PROVEN: Hi3536D V100 data sheet (Issue 00B04, 2017-12-13), section 10.1.6, PDF page 599).";
        field {
            name = "reserved";
            desc = "Reserved";
            sw = r; hw = w;
            reset = 0x0;
        } reserved_31_18[31:18];
        field {
            name = "tx_ch1_int_status";
            desc = "Interrupt status of TX channel 1
- 0: No interrupt is generated.
- 1: An interrupt is generated.";
            sw = r; hw = w;
            reset = 0x0;
        } tx_ch1_int_status[17:17];
        field {
            name = "tx_ch0_int_status";
            desc = "Interrupt status of TX channel 0
- 0: No interrupt is generated.
- 1: An interrupt is generated.";
            sw = r; hw = w;
            reset = 0x0;
        } tx_ch0_int_status[16:16];
        field {
            name = "reserved";
            desc = "Reserved";
            sw = r; hw = w;
            reset = 0x0;
        } reserved_15_1[15:1];
        field {
            name = "rx_ch0_int_status";
            desc = "Interrupt status of RX channel 0
- 0: No interrupt is generated.
- 1: An interrupt is generated.";
            sw = r; hw = w;
            reset = 0x0;
        } rx_ch0_int_status[0:0];
    } AIAO_INT_STATUS @ 0x4;
    reg {
        name = "AIAO_INT_RAW";
        desc = "AIAO_INT_RAW is an AIAO raw interrupt register. (offset 0x8; total reset 0x00000000; PROVEN: Hi3536D V100 data sheet (Issue 00B04, 2017-12-13), section 10.1.6, PDF page 600).";
        field {
            name = "reserved";
            desc = "Reserved";
            sw = r; hw = w;
            reset = 0x0;
        } reserved_31_29[31:29];
        field {
            name = "reserved";
            desc = "Reserved";
            sw = r; hw = w;
            reset = 0x0;
        } reserved_26_18[26:18];
        field {
            name = "tx_ch1_int_raw";
            desc = "Raw interrupt of TX channel 1
- 0: No raw interrupt is generated.
- 1: A raw interrupt is generated.";
            sw = r; hw = w;
            reset = 0x0;
        } tx_ch1_int_raw[17:17];
        field {
            name = "tx_ch0_int_raw";
            desc = "Raw interrupt of TX channel 0
- 0: No raw interrupt is generated.
- 1: A raw interrupt is generated.";
            sw = r; hw = w;
            reset = 0x0;
        } tx_ch0_int_raw[16:16];
        field {
            name = "reserved";
            desc = "Reserved";
            sw = r; hw = w;
            reset = 0x0;
        } reserved_15_1[15:1];
        field {
            name = "rx_ch0_int_raw";
            desc = "Raw interrupt of RX channel 0
- 0: No raw interrupt is generated.
- 1: A raw interrupt is generated.";
            sw = r; hw = w;
            reset = 0x0;
        } rx_ch0_int_raw[0:0];
    } AIAO_INT_RAW @ 0x8;
    reg {
        name = "AIAO_SWITCH_RX_BCLK";
        desc = "AIAO_SWITCH_RX_BCLK is an AIAO I2S RX BCLK switch configuration register. (offset 0x28; total reset 0x76543210; PROVEN: Hi3536D V100 data sheet (Issue 00B04, 2017-12-13), section 10.1.6, PDF page 601).";
        field {
            name = "reserved";
            desc = "Reserved";
            sw = r; hw = w;
            reset = 0x7654321;
        } reserved_31_4[31:4];
        field {
            name = "inner_bclk_ws_sel_rx_00";
            desc = "Internal BCLK select for the RX channel 0
- 0x0: BCLK0
- 0x8: BCLK8
- 0x9: BCLK9

Other values: reserved";
            sw = rw; hw = r;
            reset = 0x0;
        } inner_bclk_ws_sel_rx_00[3:0];
    } AIAO_SWITCH_RX_BCLK @ 0x28;
    reg {
        name = "AIAO_SWITCH_TX_BCLK";
        desc = "AIAO_SWITCH_TX_BCLK is an AIAO I2S TX BCLK switch configuration register. (offset 0x2C; total reset 0x76543210; PROVEN: Hi3536D V100 data sheet (Issue 00B04, 2017-12-13), section 10.1.6, PDF page 601).";
        field {
            name = "reserved";
            desc = "Reserved";
            sw = r; hw = w;
            reset = 0x765432;
        } reserved_31_8[31:8];
        field {
            name = "inner_bclk_ws_sel_tx_01";
            desc = "Internal BCLK select for TX channel 1
- 0x0: BCLK0
- 0x8: BCLK8
- 0x9: BCLK9

Other values: reserved";
            sw = rw; hw = r;
            reset = 0x1;
        } inner_bclk_ws_sel_tx_01[7:4];
        field {
            name = "field_3_0";
            desc = "BCLK select for TX channel 0 BCLK0 BCLK8 BCLK9 values: reserved";
            sw = rw; hw = r;
            reset = 0x0;
        } field_3_0[3:0];
    } AIAO_SWITCH_TX_BCLK @ 0x2C;
    reg {
        name = "VHB_OUTSTANDING";
        desc = "VHB_OUTSTANDING is a VHB outstanding configuration register. (offset 0x34; total reset 0x00000000; PROVEN: Hi3536D V100 data sheet (Issue 00B04, 2017-12-13), section 10.1.6, PDF page 602).";
        field {
            name = "reserved";
            desc = "Reserved";
            sw = r; hw = w;
            reset = 0x0;
        } reserved_31_3[31:3];
        field {
            name = "vhb_outst_num";
            desc = "Number of VHB outstandings The recommended value is 3.";
            sw = rw; hw = r;
            reset = 0x0;
        } vhb_outst_num[2:0];
    } VHB_OUTSTANDING @ 0x34;
    reg {
        name = "AIAO_RST_REQ";
        desc = "AIAO_RST_REQ is a soft reset request register. (offset 0x4C; total reset 0x00000000; PROVEN: Hi3536D V100 data sheet (Issue 00B04, 2017-12-13), section 10.1.6, PDF page 603).";
        field {
            name = "reserved";
            desc = "Reserved";
            sw = rw; hw = r;
            reset = 0x0;
        } reserved_31_10[31:10];
        field {
            name = "srst_tcx1_apb";
            desc = "Writing 1 to this bit resets write channel 1. Hardware automatically sets this bit to 0 after the reset is complete.";
            sw = rw; hw = r;
            reset = 0x0;
        } srst_tcx1_apb[9:9];
        field {
            name = "srst_tcx0_apb";
            desc = "Writing 1 to this bit resets write channel 0. Hardware automatically sets this bit to 0 after the reset is complete.";
            sw = rw; hw = r;
            reset = 0x0;
        } srst_tcx0_apb[8:8];
        field {
            name = "reserved";
            desc = "Reserved";
            sw = rw; hw = r;
            reset = 0x0;
        } reserved_7_1[7:1];
        field {
            name = "srst_rcx0_apb";
            desc = "Writing 1 to this bit resets read channel 0. Hardware automatically sets this bit to 0 after the reset is complete.";
            sw = rw; hw = r;
            reset = 0x0;
        } srst_rcx0_apb[0:0];
    } AIAO_RST_REQ @ 0x4C;
    reg {
        name = "AIAO_RST_DONE";
        desc = "AIAO_RST_DONE is a soft reset result feedback register. (offset 0x50; total reset 0x00000000; PROVEN: Hi3536D V100 data sheet (Issue 00B04, 2017-12-13), section 10.1.6, PDF page 603).";
        field {
            name = "reserved";
            desc = "Reserved";
            sw = r; hw = w;
            reset = 0x0;
        } reserved_31_27[31:27];
        field {
            name = "srst_varb_done_apb";
            desc = "VHB to AXI bus bridge reset completion flag. This bit is cleared when software writes 0 to it.

Access type WC in the data sheet: written 1 clears the bit.";
            sw = rw; hw = w; onwrite = woclr;
            reset = 0x0;
        } srst_varb_done_apb[26:26];
        field {
            name = "srst_pcfg_done_apb";
            desc = "Configuration register (not configured in the channel) reset completion flag. This bit is cleared when software writes 0 to it.

Access type WC in the data sheet: written 1 clears the bit.";
            sw = rw; hw = w; onwrite = woclr;
            reset = 0x0;
        } srst_pcfg_done_apb[25:25];
        field {
            name = "srst_tdsp_done_apb";
            desc = "Volume adjustment module reset completion flag. This bit is cleared when software writes 0 to it.

Access type WC in the data sheet: written 1 clears the bit.";
            sw = rw; hw = w; onwrite = woclr;
            reset = 0x0;
        } srst_tdsp_done_apb[24:24];
        field {
            name = "reserved";
            desc = "Reserved";
            sw = r; hw = w;
            reset = 0x0;
        } reserved_23_10[23:10];
        field {
            name = "srst_tcx1_done_apb";
            desc = "Write channel 1 reset completion flag. This bit is cleared when software writes 0 to it.

Access type WC in the data sheet: written 1 clears the bit.";
            sw = rw; hw = w; onwrite = woclr;
            reset = 0x0;
        } srst_tcx1_done_apb[9:9];
        field {
            name = "srst_tcx0_done_apb";
            desc = "Write channel 0 reset completion flag. This bit is cleared when software writes 0 to it.

Access type WC in the data sheet: written 1 clears the bit.";
            sw = rw; hw = w; onwrite = woclr;
            reset = 0x0;
        } srst_tcx0_done_apb[8:8];
        field {
            name = "reserved";
            desc = "Reserved";
            sw = r; hw = w;
            reset = 0x0;
        } reserved_7_1[7:1];
        field {
            name = "srst_rcx0_done_apb";
            desc = "Read channel 0 reset completion flag. This bit is cleared when software writes 0 to it.

Access type WC in the data sheet: written 1 clears the bit.";
            sw = rw; hw = w; onwrite = woclr;
            reset = 0x0;
        } srst_rcx0_done_apb[0:0];
    } AIAO_RST_DONE @ 0x50;
    reg I2S_CRG_CFG0_00_t {
        name = "I2S_CRG_CFG0_00";
        desc = "I2S_CRG_CFG0_00 is I2S00 CRG configuration register 0. (offset 0x100, 3 instances at stride 0x8; total reset 0x00AAAAAA; PROVEN: Hi3536D V100 data sheet (Issue 00B04, 2017-12-13), section 10.1.6, PDF page 604).";
        field {
            name = "reserved";
            desc = "Reserved";
            sw = r; hw = w;
            reset = 0x0;
        } reserved_31_27[31:27];
        field {
            name = "aiao_mclk_div";
            desc = "Clock divider of the MCLK. The configured value is calculated as follows: (Frequency of the target MCLK clock/Frequency of the MCLK PLL source clock) x 2^27. For details about the frequency of the MCLK PLL source clock, see section 3.2 \"Clock\" in chapter 3 \"System.\"";
            sw = rw; hw = r;
            reset = 0xaaaaaa;
        } aiao_mclk_div[26:0];
    };
    I2S_CRG_CFG0_00_t I2S_CRG_CFG0_00_0 @ 0x100;
    I2S_CRG_CFG0_00_t I2S_CRG_CFG0_00_1 @ 0x108;
    I2S_CRG_CFG0_00_t I2S_CRG_CFG0_00_2 @ 0x110;
    reg {
        name = "I2S_CRG_CFG1_00";
        desc = "I2S_CRG_CFG1_00 is I2S00 CRG configuration register 1. (offset 0x104; total reset 0x00000131; PROVEN: Hi3536D V100 data sheet (Issue 00B04, 2017-12-13), section 10.1.6, PDF page 605).";
        field {
            name = "reserved";
            desc = "Reserved";
            sw = r; hw = w;
            reset = 0x0;
        } reserved_31_14[31:14];
        field {
            name = "aiao_bclkout_pctrl";
            desc = "BCLKOUT polarity
- 0: positive
- 1: negative";
            sw = rw; hw = r;
            reset = 0x0;
        } aiao_bclkout_pctrl[13:13];
        field {
            name = "aiao_bclkin_pctrl";
            desc = "BCLKIN polarity
- 0: positive
- 1: negative";
            sw = rw; hw = r;
            reset = 0x0;
        } aiao_bclkin_pctrl[12:12];
        field {
            name = "aiao_bclk_sel";
            desc = "BCLK/FCLK select
- 0: Clocks are internally generated.
- 1: Clocks are input from the external audio DAC.";
            sw = rw; hw = r;
            reset = 0x0;
        } aiao_bclk_sel[11:11];
        field {
            name = "aiao_bclk_oen";
            desc = "BCLK/FCLK I/O OEN control
- 0: The BCLK/FCLK I/O is output.
- 1: The BCLK/FCLK I/O is input.

Note: This field needs to work with aiao_bclk_sel to select the master/slave mode of the I2S interface.";
            sw = rw; hw = r;
            reset = 0x0;
        } aiao_bclk_oen[10:10];
        field {
            name = "aiao_srst_req";
            desc = "Soft reset request
- 0: deassert reset
- 1: reset";
            sw = rw; hw = r;
            reset = 0x0;
        } aiao_srst_req[9:9];
        field {
            name = "aiao_cken";
            desc = "Clock status
- 0: disabled
- 1: enabled";
            sw = rw; hw = r;
            reset = 0x1;
        } aiao_cken[8:8];
        field {
            name = "reserved";
            desc = "Reserved";
            sw = r; hw = w;
            reset = 0x0;
        } reserved_7_7[7:7];
        field {
            name = "aiao_fsclk_div";
            desc = "Frequency division relationship between the bit clock BCLK and the sampling clock FS
- 000: The FS is obtained by dividing the BCLK by 16.
- 001: The FS is obtained by dividing the BCLK by 32.
- 010: The FS is obtained by dividing the BCLK by 48.
- 011: The FS is obtained by dividing the BCLK by 64.
- 100: The FS is obtained by dividing the BCLK by 128.
- 101: The FS is obtained by dividing the BCLK by 256.
- 110: The FS is obtained by dividing the BCLK by 320.
- 111: The FS is obtained by dividing the BCLK by 384.";
            sw = rw; hw = r;
            reset = 0x3;
        } aiao_fsclk_div[6:4];
        field {
            name = "aiao_bclk_div";
            desc = "Frequency division relationship between the main clock MCLK and the bit clock BCLK
- 0x0: The BCLK is obtained by dividing the MCLK by 1.
- 0x1: The BCLK is obtained by dividing the MCLK by 3.
- 0x2: The BCLK is obtained by dividing the MCLK by 2.
- 0x3: The BCLK is obtained by dividing the MCLK by 4.
- 0x4: The BCLK is obtained by dividing the MCLK by 6.
- 0x5: The BCLK is obtained by dividing the MCLK by 8.
- 0x6: The BCLK is obtained by dividing the MCLK by 12.
- 0x7: The BCLK is obtained by dividing the MCLK by 16.
- 0x8: The BCLK is obtained by dividing the MCLK by 24.
- 0x9: The BCLK is obtained by dividing the MCLK by 32.
- 0xA: The BCLK is obtained by dividing the MCLK by 48.
- 0xB: The BCLK is obtained by dividing the MCLK by 64.

Other values: The BCLK is obtained by dividing the MCLK by 8.";
            sw = rw; hw = r;
            reset = 0x1;
        } aiao_bclk_div[3:0];
    } I2S_CRG_CFG1_00 @ 0x104;
    reg I2S_CRG_CFG0_08_t {
        name = "I2S_CRG_CFG0_08";
        desc = "I2S_CRG_CFG0_08 is I2S08 CRG configuration register 0. (offset 0x140, 3 instances at stride 0x8; total reset 0x00AAAAAA; PROVEN: Hi3536D V100 data sheet (Issue 00B04, 2017-12-13), section 10.1.6, PDF page 606).";
        field {
            name = "reserved";
            desc = "Reserved";
            sw = r; hw = w;
            reset = 0x0;
        } reserved_31_27[31:27];
        field {
            name = "aiao_mclk_div";
            desc = "Clock divider of the MCLK. The configured value is calculated as follows: (Frequency of the target MCLK clock/Frequency of the MCLK PLL source clock) x 2^27. For details about the frequency of the MCLK PLL source clock, see section 3.2 \"Clock\" in chapter 3 \"System.\"";
            sw = rw; hw = r;
            reset = 0xaaaaaa;
        } aiao_mclk_div[26:0];
    };
    I2S_CRG_CFG0_08_t I2S_CRG_CFG0_08_0 @ 0x140;
    I2S_CRG_CFG0_08_t I2S_CRG_CFG0_08_1 @ 0x148;
    I2S_CRG_CFG0_08_t I2S_CRG_CFG0_08_2 @ 0x150;
    reg I2S_CRG_CFG1_08_t {
        name = "I2S_CRG_CFG1_08";
        desc = "I2S_CRG_CFG1_08 is I2S08 CRG configuration register 1. (offset 0x144, 3 instances at stride 0x8; total reset 0x00000131; PROVEN: Hi3536D V100 data sheet (Issue 00B04, 2017-12-13), section 10.1.6, PDF page 607).";
        field {
            name = "reserved";
            desc = "Reserved";
            sw = r; hw = w;
            reset = 0x0;
        } reserved_31_14[31:14];
        field {
            name = "aiao_bclkout_pctrl";
            desc = "BCLKOUT polarity
- 0: positive
- 1: negative";
            sw = rw; hw = r;
            reset = 0x0;
        } aiao_bclkout_pctrl[13:13];
        field {
            name = "aiao_bclkin_pctrl";
            desc = "BCLKIN polarity
- 0: positive
- 1: negative";
            sw = rw; hw = r;
            reset = 0x0;
        } aiao_bclkin_pctrl[12:12];
        field {
            name = "aiao_bclk_sel";
            desc = "BCLK/FCLK select
- 0: Clocks are internally generated.
- 1: Clocks are input from the external audio DAC.";
            sw = rw; hw = r;
            reset = 0x0;
        } aiao_bclk_sel[11:11];
        field {
            name = "aiao_bclk_oen";
            desc = "BCLK/FCLK I/O OEN control
- 0: The BCLK/FCLK I/O is output.
- 1: The BCLK/FCLK I/O is input.

Note: This field needs to work with aiao_bclk_sel to select the master/slave mode of the I2S interface.";
            sw = rw; hw = r;
            reset = 0x0;
        } aiao_bclk_oen[10:10];
        field {
            name = "aiao_srst_req";
            desc = "Soft reset request
- 0: deassert reset
- 1: reset";
            sw = rw; hw = r;
            reset = 0x0;
        } aiao_srst_req[9:9];
        field {
            name = "aiao_cken";
            desc = "Clock status
- 0: disabled
- 1: enabled";
            sw = rw; hw = r;
            reset = 0x1;
        } aiao_cken[8:8];
        field {
            name = "reserved";
            desc = "Reserved";
            sw = r; hw = w;
            reset = 0x0;
        } reserved_7_7[7:7];
        field {
            name = "aiao_fsclk_div";
            desc = "Frequency division relationship between the bit clock BCLK and the sampling clock FS
- 000: The FS is obtained by dividing the BCLK by 16.
- 001: The FS is obtained by dividing the BCLK by 32.
- 010: The FS is obtained by dividing the BCLK by 48.
- 011: The FS is obtained by dividing the BCLK by 64.
- 100: The FS is obtained by dividing the BCLK by 128.
- 101: The FS is obtained by dividing the BCLK by 256.
- 110: The FS is obtained by dividing the BCLK by 320.
- 111: The FS is obtained by dividing the BCLK by 384.";
            sw = rw; hw = r;
            reset = 0x3;
        } aiao_fsclk_div[6:4];
        field {
            name = "aiao_bclk_div";
            desc = "Frequency division relationship between the main clock MCLK and the bit clock BCLK
- 0x0: The BCLK is obtained by dividing the MCLK by 1.
- 0x1: The BCLK is obtained by dividing the MCLK by 3.
- 0x2: The BCLK is obtained by dividing the MCLK by 2.
- 0x3: The BCLK is obtained by dividing the MCLK by 4.
- 0x4: The BCLK is obtained by dividing the MCLK by 6.
- 0x5: The BCLK is obtained by dividing the MCLK by 8.
- 0x6: The BCLK is obtained by dividing the MCLK by 12.
- 0x7: The BCLK is obtained by dividing the MCLK by 16.
- 0x8: The BCLK is obtained by dividing the MCLK by 24.
- 0x9: The BCLK is obtained by dividing the MCLK by 32.
- 0xA: The BCLK is obtained by dividing the MCLK by 48.
- 0xB: The BCLK is obtained by dividing the MCLK by 64.

Other values: The BCLK is obtained by dividing the MCLK by 8.";
            sw = rw; hw = r;
            reset = 0x1;
        } aiao_bclk_div[3:0];
    };
    I2S_CRG_CFG1_08_t I2S_CRG_CFG1_08_0 @ 0x144;
    I2S_CRG_CFG1_08_t I2S_CRG_CFG1_08_1 @ 0x14C;
    I2S_CRG_CFG1_08_t I2S_CRG_CFG1_08_2 @ 0x154;
    reg RX_IF_ATTRI_t {
        name = "RX_IF_ATTRI";
        desc = "RX_IF_ATTRI is an interface attribute configuration register for the RX channel. (offset 0x1000, 3 instances at stride 0x100; total reset 0xE4000004; PROVEN: Hi3536D V100 data sheet (Issue 00B04, 2017-12-13), section 10.1.6, PDF page 609).";
        field {
            name = "reserved";
            desc = "Reserved";
            sw = r; hw = w;
            reset = 0x39;
        } reserved_31_26[31:26];
        field {
            name = "rx_sd0_sel";
            desc = "SD0 select. This field must be fixed at 0.";
            sw = rw; hw = r;
            reset = 0x0;
        } rx_sd0_sel[25:24];
        field {
            name = "rx_sd_source_sel";
            desc = "Input interface source select for the RX channel
- 0x0: I2S TX0
- 0x1: I2S TX1
- 0x8: I2S RX0

Other values: reserved Note: If TX0, TX1 or TX2 is selected as the input interface source, the TX0, TX1 or TX2 data can be looped back.";
            sw = rw; hw = r;
            reset = 0x0;
        } rx_sd_source_sel[23:20];
        field {
            name = "reserved";
            desc = "Reserved";
            sw = r; hw = w;
            reset = 0x0;
        } reserved_19_19[19:19];
        field {
            name = "rx_trackmode";
            desc = "Audio-left and audio-right channel mode in I2S mode
- 000: The sound is not processed.
- 001: The sounds in two channels are audio-left channel sounds.
- 010: The sounds in two channels are audio-right channel sounds.
- 011: The sounds in two channels are exchanged.
- 100: The sounds of two channels are added and then output.
- 101: The audio-left channel is muted, and the sound of the audio- right channel is from the original audio-right channel.
- 110: The audio-right channel is muted, and the sound of the audio- left channel is from the original audio-left channel.
- 111: The audio-left and audio-right channels are muted.

Note: trackmode is still valid in 1-channel RX mode. In this case, the value 101 indicates that the sound is not processed, and the value 110 indicates that the audio channels are muted.";
            sw = rw; hw = r;
            reset = 0x0;
        } rx_trackmode[18:16];
        field {
            name = "rx_sd_offset";
            desc = "Number of BCLK clocks delayed for data relative to the frame sync signal in PCM mode
- 0x00: 0 bit clocks
- 0x01: 1 bit clock
- 0x02: 2 bit clocks …
- 0xFE: 254 bit clocks
- 0xFF: 255 bit clocks";
            sw = rw; hw = r;
            reset = 0x0;
        } rx_sd_offset[15:8];
        field {
            name = "rx_multislot_en";
            desc = "Time-division multiplexing validity indicator
- 0: invalid (normal mode)
- 1: valid";
            sw = rw; hw = r;
            reset = 0x0;
        } rx_multislot_en[7:7];
        field {
            name = "rx_ch_num";
            desc = "Number of RX channels rx_multislot_en = 0
- 000: 1-channel RX (SD0 data line)
- 001: 2-channel RX (SD0 data line)

Other values: reserved rx_multislot_en = 1 Number of RX channels in time-division multiplexing mode.
- 000: 2-channel RX (SD0 data line)
- 001: 4-channel RX (SD0 data line)
- 010: 8-channel RX (SD0 data line)
- 011: 16-channel RX (SD0 data line)

Other values: reserved Note: The data line must be SD0 for multi-channel RX.";
            sw = rw; hw = r;
            reset = 0x0;
        } rx_ch_num[6:4];
        field {
            name = "rx_i2s_precision";
            desc = "Data sampling precision rx_multislot_en = 0 I2S normal mode:
- 00: reserved
- 01: 16 bits
- 10: 24 bits
- 11: reserved

PCM normal mode:
- 00: 8 bits
- 01: 16 bits

Other values: reserved rx_multislot_en = 1 I2S/PCM mode:
- 00: 8 bits
- 01: 16 bits

Other values: reserved";
            sw = rw; hw = r;
            reset = 0x1;
        } rx_i2s_precision[3:2];
        field {
            name = "rx_mode";
            desc = "Interface mode of the RX channel
- 00: I2S mode
- 01: PCM mode

Other values: reserved";
            sw = rw; hw = r;
            reset = 0x0;
        } rx_mode[1:0];
    };
    RX_IF_ATTRI_t RX_IF_ATTRI_0 @ 0x1000;
    RX_IF_ATTRI_t RX_IF_ATTRI_1 @ 0x1100;
    RX_IF_ATTRI_t RX_IF_ATTRI_2 @ 0x1200;
    reg RX_DSP_CTRL_t {
        name = "RX_DSP_CTRL";
        desc = "RX_DSP_CTRL is an RX channel control register. (offset 0x1004, 3 instances at stride 0x100; total reset 0x00000000; PROVEN: Hi3536D V100 data sheet (Issue 00B04, 2017-12-13), section 10.1.6, PDF page 611).";
        field {
            name = "reserved";
            desc = "Reserved";
            sw = r; hw = w;
            reset = 0x0;
        } reserved_31_30[31:30];
        field {
            name = "disable_done";
            desc = "RX channel stop/complete indicator
- 0: The RX channel stops but the operation is not complete.
- 1: The RX channel stops and the operation is complete.";
            sw = rw; hw = r;
            reset = 0x0;
        } disable_done[29:29];
        field {
            name = "rx_enable";
            desc = "RX channel start/stop indicator
- 0: stop
- 1: start";
            sw = rw; hw = r;
            reset = 0x0;
        } rx_enable[28:28];
        field {
            name = "bypass_en";
            desc = "Operation bypass enable (the control function still takes effect)
- 0: disabled
- 1: enabled (trackmode is bypassed)";
            sw = rw; hw = r;
            reset = 0x0;
        } bypass_en[27:27];
        field {
            name = "reserved";
            desc = "Reserved";
            sw = r; hw = w;
            reset = 0x0;
        } reserved_26_0[26:0];
    };
    RX_DSP_CTRL_t RX_DSP_CTRL_0 @ 0x1004;
    RX_DSP_CTRL_t RX_DSP_CTRL_1 @ 0x1104;
    RX_DSP_CTRL_t RX_DSP_CTRL_2 @ 0x1204;
    reg RX_BUFF_SADDR_t {
        name = "RX_BUFF_SADDR";
        desc = "RX_BUFF_SADDR is a DDR buffer start address register for the RX channel. (offset 0x1080, 3 instances at stride 0x100; total reset 0x00000000; PROVEN: Hi3536D V100 data sheet (Issue 00B04, 2017-12-13), section 10.1.6, PDF page 612).";
        field {
            name = "rx_buff_saddr";
            desc = "Start address for the DDR buffer of RX channel 0. Its unit is byte. Note: The start address must be 128x2-bit-aligned.";
            sw = rw; hw = r;
            reset = 0x0;
        } rx_buff_saddr[31:0];
    };
    RX_BUFF_SADDR_t RX_BUFF_SADDR_0 @ 0x1080;
    RX_BUFF_SADDR_t RX_BUFF_SADDR_1 @ 0x1180;
    RX_BUFF_SADDR_t RX_BUFF_SADDR_2 @ 0x1280;
    reg RX_BUFF_SIZE_t {
        name = "RX_BUFF_SIZE";
        desc = "RX_BUFF_SIZE is a DDR buffer size register for the RX channel. (offset 0x1084, 3 instances at stride 0x100; total reset 0x00000000; PROVEN: Hi3536D V100 data sheet (Issue 00B04, 2017-12-13), section 10.1.6, PDF page 612).";
        field {
            name = "reserved";
            desc = "Reserved";
            sw = r; hw = w;
            reset = 0x0;
        } reserved_31_24[31:24];
        field {
            name = "rx_buff_size";
            desc = "DDR buffer size of the RX channel. Its unit is byte. Note: The buffer size must be an integral multiple of 32 bytes.";
            sw = rw; hw = r;
            reset = 0x0;
        } rx_buff_size[23:0];
    };
    RX_BUFF_SIZE_t RX_BUFF_SIZE_0 @ 0x1084;
    RX_BUFF_SIZE_t RX_BUFF_SIZE_1 @ 0x1184;
    RX_BUFF_SIZE_t RX_BUFF_SIZE_2 @ 0x1284;
    reg RX_BUFF_WPTR_t {
        name = "RX_BUFF_WPTR";
        desc = "RX_BUFF_WPTR is a DDR buffer write address register for the RX channel. (offset 0x1088, 3 instances at stride 0x100; total reset 0x00000000; PROVEN: Hi3536D V100 data sheet (Issue 00B04, 2017-12-13), section 10.1.6, PDF page 612).";
        field {
            name = "reserved";
            desc = "Reserved";
            sw = r; hw = w;
            reset = 0x0;
        } reserved_31_24[31:24];
        field {
            name = "rx_buff_wptr";
            desc = "Write address for the DDR buffer of the RX channel. Its unit is byte. Note: The write address in the RX direction is maintained by the logic and is the offset address relative to the start address for the DDR buffer. The write address must be 128x2-bit-aligned.";
            sw = rw; hw = r;
            reset = 0x0;
        } rx_buff_wptr[23:0];
    };
    RX_BUFF_WPTR_t RX_BUFF_WPTR_0 @ 0x1088;
    RX_BUFF_WPTR_t RX_BUFF_WPTR_1 @ 0x1188;
    RX_BUFF_WPTR_t RX_BUFF_WPTR_2 @ 0x1288;
    reg RX_BUFF_RPTR_t {
        name = "RX_BUFF_RPTR";
        desc = "RX_BUFF_RPTR is a DDR buffer read address register for the RX channel. (offset 0x108C, 3 instances at stride 0x100; total reset 0x00000000; PROVEN: Hi3536D V100 data sheet (Issue 00B04, 2017-12-13), section 10.1.6, PDF page 613).";
        field {
            name = "reserved";
            desc = "Reserved";
            sw = r; hw = w;
            reset = 0x0;
        } reserved_31_24[31:24];
        field {
            name = "rx_buff_rptr";
            desc = "Read address for the DDR buffer of the RX channel. Its unit is byte. Note: The read address in the RX direction is maintained by the logic and is the offset address relative to the start address for the DDR buffer. The software operation is performed by byte, and the hardware operation is performed by 32 bytes.";
            sw = rw; hw = r;
            reset = 0x0;
        } rx_buff_rptr[23:0];
    };
    RX_BUFF_RPTR_t RX_BUFF_RPTR_0 @ 0x108C;
    RX_BUFF_RPTR_t RX_BUFF_RPTR_1 @ 0x118C;
    RX_BUFF_RPTR_t RX_BUFF_RPTR_2 @ 0x128C;
    reg RX_BUFF_ALFULL_TH_t {
        name = "RX_BUFF_ALFULL_TH";
        desc = "RX_BUFF_ALFULL_TH is a DDR buffer almost full threshold register for the RX channel. (offset 0x1090, 3 instances at stride 0x100; total reset 0x00000000; PROVEN: Hi3536D V100 data sheet (Issue 00B04, 2017-12-13), section 10.1.6, PDF page 614).";
        field {
            name = "reserved";
            desc = "Reserved";
            sw = r; hw = w;
            reset = 0x0;
        } reserved_31_24[31:24];
        field {
            name = "rx_buff_alfull_th";
            desc = "Almost full threshold for the DDR buffer of the RX channel. Its unit is byte. If the available space of the DDR buffer is below the almost full threshold, the almost full raw interrupt is generated. Note: If the rx_alfull_int interrupt is used, the field value must be an integral multiple of 16 bytes and greater than or equal to 0x40.";
            sw = rw; hw = r;
            reset = 0x0;
        } rx_buff_alfull_th[23:0];
    };
    RX_BUFF_ALFULL_TH_t RX_BUFF_ALFULL_TH_0 @ 0x1090;
    RX_BUFF_ALFULL_TH_t RX_BUFF_ALFULL_TH_1 @ 0x1190;
    RX_BUFF_ALFULL_TH_t RX_BUFF_ALFULL_TH_2 @ 0x1290;
    reg RX_TRANS_SIZE_t {
        name = "RX_TRANS_SIZE";
        desc = "RX_TRANS_SIZE is data transfer length register for the RX interrupt. (offset 0x1094, 3 instances at stride 0x100; total reset 0x00000000; PROVEN: Hi3536D V100 data sheet (Issue 00B04, 2017-12-13), section 10.1.6, PDF page 614).";
        field {
            name = "reserved";
            desc = "Reserved";
            sw = r; hw = w;
            reset = 0x0;
        } reserved_31_24[31:24];
        field {
            name = "rx_trans_size";
            desc = "After the RX channel receives the audio data with the length of rx_trans_size (in byte), a transfer completion interrupt is generated.";
            sw = rw; hw = r;
            reset = 0x0;
        } rx_trans_size[23:0];
    };
    RX_TRANS_SIZE_t RX_TRANS_SIZE_0 @ 0x1094;
    RX_TRANS_SIZE_t RX_TRANS_SIZE_1 @ 0x1194;
    RX_TRANS_SIZE_t RX_TRANS_SIZE_2 @ 0x1294;
    reg RX_WPTR_TMP_t {
        name = "RX_WPTR_TMP";
        desc = "RX_WPTR_TMP is a write address storage register for the RX channel upon reporting of the transfer completion interrupt. (offset 0x1098, 3 instances at stride 0x100; total reset 0x00000000; PROVEN: Hi3536D V100 data sheet (Issue 00B04, 2017-12-13), section 10.1.6, PDF page 615).";
        field {
            name = "reserved";
            desc = "Reserved";
            sw = r; hw = w;
            reset = 0x0;
        } reserved_31_24[31:24];
        field {
            name = "rx_wptr_tmp";
            desc = "This field is used to save the write address for the RX channel when the transfer completion interrupt is reported.";
            sw = r; hw = w;
            reset = 0x0;
        } rx_wptr_tmp[23:0];
    };
    RX_WPTR_TMP_t RX_WPTR_TMP_0 @ 0x1098;
    RX_WPTR_TMP_t RX_WPTR_TMP_1 @ 0x1198;
    RX_WPTR_TMP_t RX_WPTR_TMP_2 @ 0x1298;
    reg RX_INT_ENA_t {
        name = "RX_INT_ENA";
        desc = "RX_INT_ENA is an interrupt enable register for the RX channel. (offset 0x10A0, 3 instances at stride 0x100; total reset 0x00000000; PROVEN: Hi3536D V100 data sheet (Issue 00B04, 2017-12-13), section 10.1.6, PDF page 615).";
        field {
            name = "reserved";
            desc = "Reserved";
            sw = r; hw = w;
            reset = 0x0;
        } reserved_31_8[31:8];
        field {
            name = "rx_fifo_lost_int_ena";
            desc = "Frame loss interrupt enable for the RX channel
- 0: disabled
- 1: enabled";
            sw = r; hw = w;
            reset = 0x0;
        } rx_fifo_lost_int_ena[7:7];
        field {
            name = "reserved";
            desc = "Reserved";
            sw = r; hw = w;
            reset = 0x0;
        } reserved_6_6[6:6];
        field {
            name = "rx_stop_int_ena";
            desc = "Stop interrupt enable for the RX channel
- 0: disabled
- 1: enabled";
            sw = rw; hw = r;
            reset = 0x0;
        } rx_stop_int_ena[5:5];
        field {
            name = "rx_ififo_full_int_ena";
            desc = "Interface FIFO overflow interrupt enable for the RX channel
- 0: disabled
- 1: enabled";
            sw = rw; hw = r;
            reset = 0x0;
        } rx_ififo_full_int_ena[4:4];
        field {
            name = "rx_bfifo_full_int_ena";
            desc = "Bus FIFO overflow interrupt enable for the RX channel
- 0: disabled
- 1: enabled";
            sw = rw; hw = r;
            reset = 0x0;
        } rx_bfifo_full_int_ena[3:3];
        field {
            name = "rx_alfull_int_ena";
            desc = "DDR buffer almost full interrupt enable for the RX channel
- 0: disabled
- 1: enabled";
            sw = rw; hw = r;
            reset = 0x0;
        } rx_alfull_int_ena[2:2];
        field {
            name = "rx_full_int_ena";
            desc = "DDR buffer full interrupt for the RX channel
- 0: disabled
- 1: enabled";
            sw = rw; hw = r;
            reset = 0x0;
        } rx_full_int_ena[1:1];
        field {
            name = "rx_trans_int_ena";
            desc = "Transfer completion interrupt enable for the RX channel
- 0: disabled
- 1: enabled";
            sw = rw; hw = r;
            reset = 0x0;
        } rx_trans_int_ena[0:0];
    };
    RX_INT_ENA_t RX_INT_ENA_0 @ 0x10A0;
    RX_INT_ENA_t RX_INT_ENA_1 @ 0x11A0;
    RX_INT_ENA_t RX_INT_ENA_2 @ 0x12A0;
    reg RX_INT_RAW_t {
        name = "RX_INT_RAW";
        desc = "RX_INT_RAW is a raw interrupt register for the RX channel. (offset 0x10A4, 3 instances at stride 0x100; total reset 0x00000000; PROVEN: Hi3536D V100 data sheet (Issue 00B04, 2017-12-13), section 10.1.6, PDF page 616).";
        field {
            name = "reserved";
            desc = "Reserved";
            sw = r; hw = w;
            reset = 0x0;
        } reserved_31_8[31:8];
        field {
            name = "rx_if_full_lost_int_raw";
            desc = "Data full lost raw interrupt of the RX channel
- 0: No raw interrupt is generated.
- 1: A raw interrupt is generated.";
            sw = r; hw = w;
            reset = 0x0;
        } rx_if_full_lost_int_raw[7:7];
        field {
            name = "reserved";
            desc = "Reserved";
            sw = r; hw = w;
            reset = 0x0;
        } reserved_6_6[6:6];
        field {
            name = "rx_stop_int_raw";
            desc = "Stop raw interrupt of the RX channel
- 0: No raw interrupt is generated.
- 1: A raw interrupt is generated.";
            sw = r; hw = w;
            reset = 0x0;
        } rx_stop_int_raw[5:5];
        field {
            name = "rx_ififo_full_int_raw";
            desc = "Interface FIFO overflow raw interrupt of the RX channel
- 0: No raw interrupt is generated.
- 1: A raw interrupt is generated.";
            sw = r; hw = w;
            reset = 0x0;
        } rx_ififo_full_int_raw[4:4];
        field {
            name = "rx_bfifo_full_int_raw";
            desc = "Bus FIFO overflow raw interrupt of the RX channel
- 0: No raw interrupt is generated.
- 1: A raw interrupt is generated.";
            sw = r; hw = w;
            reset = 0x0;
        } rx_bfifo_full_int_raw[3:3];
        field {
            name = "rx_alfull_int_raw";
            desc = "DDR buffer almost full raw interrupt of the RX channel
- 0: No raw interrupt is generated.
- 1: A raw interrupt is generated.";
            sw = r; hw = w;
            reset = 0x0;
        } rx_alfull_int_raw[2:2];
        field {
            name = "rx_full_int_raw";
            desc = "DDR buffer full raw interrupt of the RX channel
- 0: No raw interrupt is generated.
- 1: A raw interrupt is generated.";
            sw = r; hw = w;
            reset = 0x0;
        } rx_full_int_raw[1:1];
        field {
            name = "rx_trans_int_raw";
            desc = "Transfer completion raw interrupt of the RX interrupt
- 0: No raw interrupt is generated.
- 1: A raw interrupt is generated.";
            sw = r; hw = w;
            reset = 0x0;
        } rx_trans_int_raw[0:0];
    };
    RX_INT_RAW_t RX_INT_RAW_0 @ 0x10A4;
    RX_INT_RAW_t RX_INT_RAW_1 @ 0x11A4;
    RX_INT_RAW_t RX_INT_RAW_2 @ 0x12A4;
    reg RX_INT_STATUS_t {
        name = "RX_INT_STATUS";
        desc = "RX_INT_STATUS is an interrupt status register for the RX channel. (offset 0x10A8, 3 instances at stride 0x100; total reset 0x00000000; PROVEN: Hi3536D V100 data sheet (Issue 00B04, 2017-12-13), section 10.1.6, PDF page 617).";
        field {
            name = "reserved";
            desc = "Reserved";
            sw = r; hw = w;
            reset = 0x0;
        } reserved_31_8[31:8];
        field {
            name = "rx_if_full_lost_int_status";
            desc = "Status of the data full loss interrupt of the RX channel
- 0: No interrupt is generated.
- 1: An interrupt is generated.";
            sw = r; hw = w;
            reset = 0x0;
        } rx_if_full_lost_int_status[7:7];
        field {
            name = "reserved";
            desc = "Reserved";
            sw = r; hw = w;
            reset = 0x0;
        } reserved_6_6[6:6];
        field {
            name = "rx_stop_int_status";
            desc = "Status of the stop interrupt of the RX interrupt
- 0: No interrupt is generated.
- 1: An interrupt is generated.";
            sw = r; hw = w;
            reset = 0x0;
        } rx_stop_int_status[5:5];
        field {
            name = "rx_ififo_full_int_status";
            desc = "Status of the interface FIFO overflow interrupt of the RX channel
- 0: No interrupt is generated.
- 1: An interrupt is generated.";
            sw = r; hw = w;
            reset = 0x0;
        } rx_ififo_full_int_status[4:4];
        field {
            name = "rx_bfifo_full_int_status";
            desc = "Status of the bus FIFO overflow interrupt of the RX channel
- 0: No interrupt is generated.
- 1: An interrupt is generated.";
            sw = r; hw = w;
            reset = 0x0;
        } rx_bfifo_full_int_status[3:3];
        field {
            name = "rx_alfull_int_status";
            desc = "Status of the DDR buffer almost full interrupt of the RX channel
- 0: No interrupt is generated.
- 1: An interrupt is generated.";
            sw = r; hw = w;
            reset = 0x0;
        } rx_alfull_int_status[2:2];
        field {
            name = "rx_full_int_status";
            desc = "Status of the DDR buffer full interrupt of the RX interrupt
- 0: No interrupt is generated.
- 1: An interrupt is generated.";
            sw = r; hw = w;
            reset = 0x0;
        } rx_full_int_status[1:1];
        field {
            name = "rx_trans_int_status";
            desc = "Status of the transfer completion interrupt of the RX channel
- 0: No interrupt is generated.
- 1: An interrupt is generated.";
            sw = r; hw = w;
            reset = 0x0;
        } rx_trans_int_status[0:0];
    };
    RX_INT_STATUS_t RX_INT_STATUS_0 @ 0x10A8;
    RX_INT_STATUS_t RX_INT_STATUS_1 @ 0x11A8;
    RX_INT_STATUS_t RX_INT_STATUS_2 @ 0x12A8;
    reg RX_INT_CLR_t {
        name = "RX_INT_CLR";
        desc = "RX_INT_CLR is an interrupt clear register for the RX channel. (offset 0x10AC, 3 instances at stride 0x100; total reset 0x00000000; PROVEN: Hi3536D V100 data sheet (Issue 00B04, 2017-12-13), section 10.1.6, PDF page 618).";
        field {
            name = "reserved";
            desc = "Reserved";
            sw = r; hw = w;
            reset = 0x0;
        } reserved_31_8[31:8];
        field {
            name = "rx_if_full_lost_int_clear";
            desc = "Data full loss interrupt clear for the RX channel
- 0: not cleared
- 1: cleared

Access type WC in the data sheet: written 1 clears the bit.";
            sw = rw; hw = w; onwrite = woclr;
            reset = 0x0;
        } rx_if_full_lost_int_clear[7:7];
        field {
            name = "reserved";
            desc = "Reserved";
            sw = r; hw = w;
            reset = 0x0;
        } reserved_6_6[6:6];
        field {
            name = "rx_stop_int_clear";
            desc = "Stop interrupt clear for the RX channel
- 0: not cleared
- 1: cleared

Access type WC in the data sheet: written 1 clears the bit.";
            sw = rw; hw = w; onwrite = woclr;
            reset = 0x0;
        } rx_stop_int_clear[5:5];
        field {
            name = "rx_ififo_full_int_clear";
            desc = "Interface FIFO overflow interrupt clear for the RX channel
- 0: not cleared
- 1: cleared

Access type WC in the data sheet: written 1 clears the bit.";
            sw = rw; hw = w; onwrite = woclr;
            reset = 0x0;
        } rx_ififo_full_int_clear[4:4];
        field {
            name = "rx_bfifo_full_int_clear";
            desc = "Bus FIFO overflow interrupt clear for the RX channel
- 0: not cleared
- 1: cleared

Access type WC in the data sheet: written 1 clears the bit.";
            sw = rw; hw = w; onwrite = woclr;
            reset = 0x0;
        } rx_bfifo_full_int_clear[3:3];
        field {
            name = "rx_alfull_int_clear";
            desc = "DDR buffer almost full interrupt clear for the RX channel
- 0: not cleared
- 1: cleared

Access type WC in the data sheet: written 1 clears the bit.";
            sw = rw; hw = w; onwrite = woclr;
            reset = 0x0;
        } rx_alfull_int_clear[2:2];
        field {
            name = "rx_full_int_clear";
            desc = "DDR buffer full interrupt clear for the RX channel
- 0: not cleared
- 1: cleared

Access type WC in the data sheet: written 1 clears the bit.";
            sw = rw; hw = w; onwrite = woclr;
            reset = 0x0;
        } rx_full_int_clear[1:1];
        field {
            name = "rx_trans_int_clear";
            desc = "Transfer completion interrupt clear for the RX interrupt
- 0: not cleared
- 1: cleared";
            sw = w; hw = r;
            reset = 0x0;
        } rx_trans_int_clear[0:0];
    };
    RX_INT_CLR_t RX_INT_CLR_0 @ 0x10AC;
    RX_INT_CLR_t RX_INT_CLR_1 @ 0x11AC;
    RX_INT_CLR_t RX_INT_CLR_2 @ 0x12AC;
    reg TX_IF_ATTRI_t {
        name = "TX_IF_ATTRI";
        desc = "TX_IF_ATTRI is an interface attribute configuration register for the TX channel. (offset 0x2000, 3 instances at stride 0x100; total reset 0xE4000004; PROVEN: Hi3536D V100 data sheet (Issue 00B04, 2017-12-13), section 10.1.6, PDF page 620).";
        field {
            name = "reserved";
            desc = "Reserved";
            sw = r; hw = w;
            reset = 0x39;
        } reserved_31_26[31:26];
        field {
            name = "tx_sd0_sel";
            desc = "SD0 select. This field must be fixed at 0. Note: Select the channel and data line in sequence.";
            sw = rw; hw = r;
            reset = 0x0;
        } tx_sd0_sel[25:24];
        field {
            name = "tx_sd_source_sel";
            desc = "Source select for SD0, SD1, SD2, and SD3
- 0x0: I2S TX0
- 0x1: I2S TX1
- 0x8: I2S RX0

Other values: reserved";
            sw = rw; hw = r;
            reset = 0x0;
        } tx_sd_source_sel[23:20];
        field {
            name = "reserved";
            desc = "Reserved";
            sw = r; hw = w;
            reset = 0x0;
        } reserved_19_19[19:19];
        field {
            name = "tx_trackmode";
            desc = "Audio-left and audio-right channel mode in I2S mode
- 000: The sound is not processed.
- 001: The sounds in two channels are audio-left channel sounds.
- 010: The sounds in two channels are audio-right channel sounds.
- 011: The sounds in two channels are exchanged.
- 100: The sounds of two channels are added and then output.
- 101: The audio-left channel is muted, and the sound of the audio- right channel is from the original audio-right channel.
- 110: The audio-right channel is muted, and the sound of the audio- left channel is from the original audio-left channel.
- 111: The audio-left and audio-right channels are muted.

Note: trackmode is still valid in 1-channel TX mode.";
            sw = rw; hw = r;
            reset = 0x0;
        } tx_trackmode[18:16];
        field {
            name = "tx_sd_offset";
            desc = "Number of BCLK clocks delayed for data relative to the frame sync signal in PCM mode
- 0x00: 0 bit clocks
- 0x01: 1 bit clocks
- 0x02: 2 bit clocks …
- 0xFE: 254 bit clocks
- 0xFF: 255 bit clocks";
            sw = rw; hw = r;
            reset = 0x0;
        } tx_sd_offset[15:8];
        field {
            name = "reserved";
            desc = "Reserved";
            sw = r; hw = w;
            reset = 0x0;
        } reserved_7_6[7:6];
        field {
            name = "tx_ch_num";
            desc = "Number of TX channels
- 00: 1-channel TX
- 01: 2-channel TX

Other values: reserved Note: The time-division multiplexing mode is not supported during transmission.";
            sw = rw; hw = r;
            reset = 0x0;
        } tx_ch_num[5:4];
        field {
            name = "tx_i2s_precision";
            desc = "Data sampling precision I2S normal mode:
- 00: reserved
- 01: 16 bits
- 10: 24 bits
- 11: reserved

PCM normal mode:
- 00: 8 bits
- 01: 16 bits

Other values: reserved";
            sw = rw; hw = r;
            reset = 0x1;
        } tx_i2s_precision[3:2];
        field {
            name = "tx_mode";
            desc = "Interface mode of the TX channel
- 00: I2S mode
- 01: PCM mode

Other values: reserved";
            sw = rw; hw = r;
            reset = 0x0;
        } tx_mode[1:0];
    };
    TX_IF_ATTRI_t TX_IF_ATTRI_0 @ 0x2000;
    TX_IF_ATTRI_t TX_IF_ATTRI_1 @ 0x2100;
    TX_IF_ATTRI_t TX_IF_ATTRI_2 @ 0x2200;
    reg TX_DSP_CTRL_t {
        name = "TX_DSP_CTRL";
        desc = "TX_DSP_CTRL is a TX channel control register. (offset 0x2004, 3 instances at stride 0x100; total reset 0x20000000; PROVEN: Hi3536D V100 data sheet (Issue 00B04, 2017-12-13), section 10.1.6, PDF page 622).";
        field {
            name = "reserved";
            desc = "Reserved";
            sw = r; hw = w;
            reset = 0x0;
        } reserved_31_30[31:30];
        field {
            name = "tx_disable_done";
            desc = "TX channel stop/complete identifier
- 0: not complete
- 1: complete";
            sw = r; hw = w;
            reset = 0x1;
        } tx_disable_done[29:29];
        field {
            name = "tx_enable";
            desc = "TX channel start/stop indicator
- 0: stop
- 1: start";
            sw = rw; hw = r;
            reset = 0x0;
        } tx_enable[28:28];
        field {
            name = "bypass_en";
            desc = "Operation bypass enable (the control function still takes effect)
- 0: disabled
- 1: enabled (the functions such as volume control, trackmode, and fade-in/fade-out are bypassed)";
            sw = rw; hw = r;
            reset = 0x0;
        } bypass_en[27:27];
        field {
            name = "reserved";
            desc = "Reserved";
            sw = r; hw = w;
            reset = 0x0;
        } reserved_26_24[26:24];
        field {
            name = "fade_out_rate";
            desc = "Fade-out rate register
- 0x0: The fade-out rate changes every one sampling point.
- 0x1: The fade-out rate changes every two sampling points.
- 0x2: The fade-out rate changes every four sampling points.
- 0x3: The fade-out rate changes every eight sampling points.
- 0x4: The fade-out rate changes every 16 sampling points.
- 0x5: The fade-out rate changes every 32 sampling points.
- 0x6: The fade-out rate changes every 64 sampling points.
- 0x7: The fade-out rate changes every 128 sampling points.

Other values: reserved";
            sw = rw; hw = r;
            reset = 0x0;
        } fade_out_rate[23:20];
        field {
            name = "fade_in_rate";
            desc = "Fade-in rate register.
- 0x0: The fade-in rate changes every one sampling point.
- 0x1: The fade-in rate changes every two sampling points.
- 0x2: The fade-in rate changes every four sampling points.
- 0x3: The fade-in rate changes every eight sampling points.
- 0x4: The fade-in rate changes every 16 sampling points.
- 0x5: The fade-in rate changes every 32 sampling points.
- 0x6: The fade-in rate changes every 64 sampling points.
- 0x7: The fade-in rate changes every 128 sampling points.

Other values: reserved";
            sw = rw; hw = r;
            reset = 0x0;
        } fade_in_rate[19:16];
        field {
            name = "reserved";
            desc = "Reserved";
            sw = r; hw = w;
            reset = 0x0;
        } reserved_15_15[15:15];
        field {
            name = "volume";
            desc = "Volume 0x00-0x28: mute
- 0x29: -80 dB …
- 0x7E: +5 dB
- 0x7F: +6 dB";
            sw = rw; hw = r;
            reset = 0x0;
        } volume[14:8];
        field {
            name = "reserved";
            desc = "Reserved.";
            sw = rw; hw = r;
            reset = 0x0;
        } reserved_7_2[7:2];
        field {
            name = "mute_fade_en";
            desc = "Mute fade-in/fade-out control
- 0: disabled
- 1: enabled";
            sw = rw; hw = r;
            reset = 0x0;
        } mute_fade_en[1:1];
        field {
            name = "mute_en";
            desc = "Mute control
- 0: unmuted
- 1: muted";
            sw = rw; hw = r;
            reset = 0x0;
        } mute_en[0:0];
    };
    TX_DSP_CTRL_t TX_DSP_CTRL_0 @ 0x2004;
    TX_DSP_CTRL_t TX_DSP_CTRL_1 @ 0x2104;
    TX_DSP_CTRL_t TX_DSP_CTRL_2 @ 0x2204;
    reg TX_WS_CNT_t {
        name = "TX_WS_CNT";
        desc = "TX_WS_CNT is a WS cyclic count status register for the TX channel. (offset 0x2020, 3 instances at stride 0x100; total reset 0x00000000; PROVEN: Hi3536D V100 data sheet (Issue 00B04, 2017-12-13), section 10.1.6, PDF page 623).";
        field {
            name = "reserved";
            desc = "Reserved";
            sw = r; hw = w;
            reset = 0x0;
        } reserved_31_24[31:24];
        field {
            name = "ws_count";
            desc = "FSCLK cyclic count register The unit is FSCLK.";
            sw = r; hw = w;
            reset = 0x0;
        } ws_count[23:0];
    };
    TX_WS_CNT_t TX_WS_CNT_0 @ 0x2020;
    TX_WS_CNT_t TX_WS_CNT_1 @ 0x2120;
    TX_WS_CNT_t TX_WS_CNT_2 @ 0x2220;
    reg TX_BCLK_CNT_t {
        name = "TX_BCLK_CNT";
        desc = "TX_BCLK_CNT is a BCLK cyclic count status register for the TX channel. (offset 0x2024, 2 instances at stride 0x100; total reset 0x00000000; PROVEN: Hi3536D V100 data sheet (Issue 00B04, 2017-12-13), section 10.1.6, PDF page 624).";
        field {
            name = "reserved";
            desc = "Reserved";
            sw = r; hw = w;
            reset = 0x0;
        } reserved_31_24[31:24];
        field {
            name = "bclk_count";
            desc = "BCLK cyclic count register The unit is BCLK.";
            sw = r; hw = w;
            reset = 0x0;
        } bclk_count[23:0];
    };
    TX_BCLK_CNT_t TX_BCLK_CNT_0 @ 0x2024;
    TX_BCLK_CNT_t TX_BCLK_CNT_1 @ 0x2124;
    reg TX_BUFF_SADDR_t {
        name = "TX_BUFF_SADDR";
        desc = "TX_BUFF_SADDR is a DDR buffer start address register for the TX channel. (offset 0x2080, 2 instances at stride 0x100; total reset 0x00000000; PROVEN: Hi3536D V100 data sheet (Issue 00B04, 2017-12-13), section 10.1.6, PDF page 624).";
        field {
            name = "tx_buff_saddr";
            desc = "Start address for the DDR buffer of the TX channel. Its unit is byte. Note: The start address must be 128x2-bit-aligned.";
            sw = rw; hw = r;
            reset = 0x0;
        } tx_buff_saddr[31:0];
    };
    TX_BUFF_SADDR_t TX_BUFF_SADDR_0 @ 0x2080;
    TX_BUFF_SADDR_t TX_BUFF_SADDR_1 @ 0x2180;
    reg TX_BUFF_SIZE_t {
        name = "TX_BUFF_SIZE";
        desc = "TX_BUFF_SIZE is a DDR buffer size register for the TX channel. (offset 0x2084, 3 instances at stride 0x100; total reset 0x00000000; PROVEN: Hi3536D V100 data sheet (Issue 00B04, 2017-12-13), section 10.1.6, PDF page 625).";
        field {
            name = "reserved";
            desc = "Reserved";
            sw = r; hw = w;
            reset = 0x0;
        } reserved_31_24[31:24];
        field {
            name = "tx_buff_size";
            desc = "DDR buffer size of the TX channel. Its unit is byte. Note: The buffer size must be an integral multiple of 32 bytes.";
            sw = rw; hw = r;
            reset = 0x0;
        } tx_buff_size[23:0];
    };
    TX_BUFF_SIZE_t TX_BUFF_SIZE_0 @ 0x2084;
    TX_BUFF_SIZE_t TX_BUFF_SIZE_1 @ 0x2184;
    TX_BUFF_SIZE_t TX_BUFF_SIZE_2 @ 0x2284;
    reg TX_BUFF_WPTR_t {
        name = "TX_BUFF_WPTR";
        desc = "TX_BUFF_WPTR is a DDR buffer write address register for the TX channel. (offset 0x2088, 2 instances at stride 0x100; total reset 0x00000000; PROVEN: Hi3536D V100 data sheet (Issue 00B04, 2017-12-13), section 10.1.6, PDF page 625).";
        field {
            name = "reserved";
            desc = "Reserved";
            sw = r; hw = w;
            reset = 0x0;
        } reserved_31_24[31:24];
        field {
            name = "tx_buff_wptr";
            desc = "Write address for the DDR buffer of the TX channel Note: The write address in the TX direction is maintained by the logic and is the offset address relative to the start address for the DDR buffer. The available space of the TX buffer must be greater than or equal to 32 bytes. The software operation is performed by byte, and the hardware operation is performed by 32 bytes.";
            sw = rw; hw = r;
            reset = 0x0;
        } tx_buff_wptr[23:0];
    };
    TX_BUFF_WPTR_t TX_BUFF_WPTR_0 @ 0x2088;
    TX_BUFF_WPTR_t TX_BUFF_WPTR_1 @ 0x2188;
    reg TX_BUFF_RPTR_t {
        name = "TX_BUFF_RPTR";
        desc = "TX_BUFF_RPTR is a DDR buffer read address register for the TX channel. (offset 0x208C, 2 instances at stride 0x100; total reset 0x00000000; PROVEN: Hi3536D V100 data sheet (Issue 00B04, 2017-12-13), section 10.1.6, PDF page 626).";
        field {
            name = "reserved";
            desc = "Reserved";
            sw = r; hw = w;
            reset = 0x0;
        } reserved_31_24[31:24];
        field {
            name = "tx_buff_rptr";
            desc = "Read address for the DDR buffer of the TX channel Note: The read address in the TX direction is maintained by the logic and is the offset address relative to the start address for the DDR buffer. The address must be 128x2-bit-aligned.";
            sw = rw; hw = r;
            reset = 0x0;
        } tx_buff_rptr[23:0];
    };
    TX_BUFF_RPTR_t TX_BUFF_RPTR_0 @ 0x208C;
    TX_BUFF_RPTR_t TX_BUFF_RPTR_1 @ 0x218C;
    reg TX_BUFF_ALEMPTY_TH_t {
        name = "TX_BUFF_ALEMPTY_TH";
        desc = "TX_BUFF_ALEMPTY_TH is a DDR buffer almost empty threshold register for the TX channel. (offset 0x2090, 3 instances at stride 0x100; total reset 0x00000000; PROVEN: Hi3536D V100 data sheet (Issue 00B04, 2017-12-13), section 10.1.6, PDF page 626).";
        field {
            name = "reserved";
            desc = "Reserved";
            sw = r; hw = w;
            reset = 0x0;
        } reserved_31_24[31:24];
        field {
            name = "tx_buff_alempty_th";
            desc = "Almost empty threshold for the DDR buffer of the TX channel. Its unit is byte. If the available space of the DDR buffer is below the almost empty threshold, the almost empty raw interrupt is generated. Note: If the tx_alempty_int interrupt is used, the field value must be an integral multiple of 16 bytes and greater than or equal to 0x20.";
            sw = rw; hw = r;
            reset = 0x0;
        } tx_buff_alempty_th[23:0];
    };
    TX_BUFF_ALEMPTY_TH_t TX_BUFF_ALEMPTY_TH_0 @ 0x2090;
    TX_BUFF_ALEMPTY_TH_t TX_BUFF_ALEMPTY_TH_1 @ 0x2190;
    TX_BUFF_ALEMPTY_TH_t TX_BUFF_ALEMPTY_TH_2 @ 0x2290;
    reg TX_TRANS_SIZE_t {
        name = "TX_TRANS_SIZE";
        desc = "TX_TRANS_SIZE is a data transfer length register for the TX channel. (offset 0x2094, 2 instances at stride 0x100; total reset 0x00000000; PROVEN: Hi3536D V100 data sheet (Issue 00B04, 2017-12-13), section 10.1.6, PDF page 627).";
        field {
            name = "reserved";
            desc = "Reserved";
            sw = r; hw = w;
            reset = 0x0;
        } reserved_31_24[31:24];
        field {
            name = "tx_trans_size";
            desc = "After the TX channel transmits the audio data with the length of tx_trans_size (in byte), a transfer completion interrupt is generated.";
            sw = rw; hw = r;
            reset = 0x0;
        } tx_trans_size[23:0];
    };
    TX_TRANS_SIZE_t TX_TRANS_SIZE_0 @ 0x2094;
    TX_TRANS_SIZE_t TX_TRANS_SIZE_1 @ 0x2194;
    reg TX_RPTR_TMP_t {
        name = "TX_RPTR_TMP";
        desc = "TX_RPTR_TMP is a read address storage register for the TX channel upon reporting of the transfer completion interrupt. (offset 0x2098, 3 instances at stride 0x100; total reset 0x00000000; PROVEN: Hi3536D V100 data sheet (Issue 00B04, 2017-12-13), section 10.1.6, PDF page 627).";
        field {
            name = "reserved";
            desc = "Reserved";
            sw = r; hw = w;
            reset = 0x0;
        } reserved_31_24[31:24];
        field {
            name = "tx_rptr_tmp";
            desc = "This field is used to save the read address for the TX channel when the transfer completion interrupt is reported.";
            sw = r; hw = w;
            reset = 0x0;
        } tx_rptr_tmp[23:0];
    };
    TX_RPTR_TMP_t TX_RPTR_TMP_0 @ 0x2098;
    TX_RPTR_TMP_t TX_RPTR_TMP_1 @ 0x2198;
    TX_RPTR_TMP_t TX_RPTR_TMP_2 @ 0x2298;
    reg TX_INT_ENA_t {
        name = "TX_INT_ENA";
        desc = "TX_INT_ENA is an interrupt enable register for the TX channel. (offset 0x20A0, 3 instances at stride 0x100; total reset 0x00000000; PROVEN: Hi3536D V100 data sheet (Issue 00B04, 2017-12-13), section 10.1.6, PDF page 628).";
        field {
            name = "reserved";
            desc = "Reserved";
            sw = r; hw = w;
            reset = 0x0;
        } reserved_31_8[31:8];
        field {
            name = "tx_dat_break_int_ena";
            desc = "Interface data break interrupt enable for the TX channel
- 0: No raw interrupt is generated.
- 1: A raw interrupt is generated.";
            sw = rw; hw = r;
            reset = 0x0;
        } tx_dat_break_int_ena[7:7];
        field {
            name = "tx_mfade_int_ena";
            desc = "Mute fade-in/fade-output completion interrupt enable for the TX channel
- 0: disabled
- 1: enabled";
            sw = rw; hw = r;
            reset = 0x0;
        } tx_mfade_int_ena[6:6];
        field {
            name = "tx_stop_int_ena";
            desc = "Stop interrupt enable for the TX channel
- 0: disabled
- 1: enabled";
            sw = rw; hw = r;
            reset = 0x0;
        } tx_stop_int_ena[5:5];
        field {
            name = "tx_ififo_empty_int_ena";
            desc = "Interface FIFO underflow interrupt enable for the TX channel
- 0: disabled
- 1: enabled";
            sw = rw; hw = r;
            reset = 0x0;
        } tx_ififo_empty_int_ena[4:4];
        field {
            name = "tx_bfifo_empty_int_ena";
            desc = "Bus FIFO underflow interrupt enable for the TX channel
- 0: disabled
- 1: enabled";
            sw = rw; hw = r;
            reset = 0x0;
        } tx_bfifo_empty_int_ena[3:3];
        field {
            name = "tx_alempty_int_ena";
            desc = "DDR buffer almost empty interrupt enable for the TX channel
- 0: disabled
- 1: enabled";
            sw = rw; hw = r;
            reset = 0x0;
        } tx_alempty_int_ena[2:2];
        field {
            name = "tx_empty_int_ena";
            desc = "DDR buffer empty interrupt for the TX channel
- 0: disabled
- 1: enabled";
            sw = rw; hw = r;
            reset = 0x0;
        } tx_empty_int_ena[1:1];
        field {
            name = "tx_trans_int_ena";
            desc = "Transfer completion interrupt enable for the TX channel
- 0: disabled
- 1: enabled";
            sw = rw; hw = r;
            reset = 0x0;
        } tx_trans_int_ena[0:0];
    };
    TX_INT_ENA_t TX_INT_ENA_0 @ 0x20A0;
    TX_INT_ENA_t TX_INT_ENA_1 @ 0x21A0;
    TX_INT_ENA_t TX_INT_ENA_2 @ 0x22A0;
    reg TX_INT_RAW_t {
        name = "TX_INT_RAW";
        desc = "TX_INT_RAW is a raw interrupt register for the TX channel. (offset 0x20A4, 3 instances at stride 0x100; total reset 0x00000000; PROVEN: Hi3536D V100 data sheet (Issue 00B04, 2017-12-13), section 10.1.6, PDF page 629).";
        field {
            name = "reserved";
            desc = "Reserved";
            sw = r; hw = w;
            reset = 0x0;
        } reserved_31_8[31:8];
        field {
            name = "tx_dat_break_int_raw";
            desc = "Interface data break raw interrupt of the TX channel
- 0: No raw interrupt is generated.
- 1: A raw interrupt is generated.";
            sw = r; hw = w;
            reset = 0x0;
        } tx_dat_break_int_raw[7:7];
        field {
            name = "tx_mfade_int_raw";
            desc = "Mute fade-in/fade-output completion raw interrupt of the TX channel
- 0: No raw interrupt is generated.
- 1: A raw interrupt is generated.";
            sw = r; hw = w;
            reset = 0x0;
        } tx_mfade_int_raw[6:6];
        field {
            name = "tx_stop_int_raw";
            desc = "Stop raw interrupt of the TX channel
- 0: No raw interrupt is generated.
- 1: A raw interrupt is generated.";
            sw = r; hw = w;
            reset = 0x0;
        } tx_stop_int_raw[5:5];
        field {
            name = "tx_ififo_empty_int_raw";
            desc = "Interface FIFO underflow raw interrupt of the TX channel
- 0: No raw interrupt is generated.
- 1: A raw interrupt is generated.";
            sw = r; hw = w;
            reset = 0x0;
        } tx_ififo_empty_int_raw[4:4];
        field {
            name = "tx_bfifo_empty_int_raw";
            desc = "Bus FIFO underflow raw interrupt of the TX channel
- 0: No raw interrupt is generated.
- 1: A raw interrupt is generated.";
            sw = r; hw = w;
            reset = 0x0;
        } tx_bfifo_empty_int_raw[3:3];
        field {
            name = "tx_alempty_int_raw";
            desc = "DDR buffer almost empty raw interrupt of the TX channel
- 0: No raw interrupt is generated.
- 1: A raw interrupt is generated.";
            sw = r; hw = w;
            reset = 0x0;
        } tx_alempty_int_raw[2:2];
        field {
            name = "tx_empty_int_raw";
            desc = "DDR buffer empty raw interrupt of the TX channel
- 0: No raw interrupt is generated.
- 1: A raw interrupt is generated.";
            sw = r; hw = w;
            reset = 0x0;
        } tx_empty_int_raw[1:1];
        field {
            name = "tx_trans_int_raw";
            desc = "Transfer completion raw interrupt of the TX channel
- 0: No raw interrupt is generated.
- 1: A raw interrupt is generated.";
            sw = r; hw = w;
            reset = 0x0;
        } tx_trans_int_raw[0:0];
    };
    TX_INT_RAW_t TX_INT_RAW_0 @ 0x20A4;
    TX_INT_RAW_t TX_INT_RAW_1 @ 0x21A4;
    TX_INT_RAW_t TX_INT_RAW_2 @ 0x22A4;
    reg TX_INT_STATUS_t {
        name = "TX_INT_STATUS";
        desc = "TX_INT_STATUS is an interrupt status register for the TX channel. (offset 0x20A8, 3 instances at stride 0x100; total reset 0x00000000; PROVEN: Hi3536D V100 data sheet (Issue 00B04, 2017-12-13), section 10.1.6, PDF page 630).";
        field {
            name = "reserved";
            desc = "Reserved";
            sw = r; hw = w;
            reset = 0x0;
        } reserved_31_8[31:8];
        field {
            name = "tx_dat_break_int_status";
            desc = "Status of the interface data break interrupt of the TX channel
- 0: No interrupt is generated.
- 1: An interrupt is generated.";
            sw = r; hw = w;
            reset = 0x0;
        } tx_dat_break_int_status[7:7];
        field {
            name = "tx_mfade_int_status";
            desc = "Status of the mute fade-in/fade-output completion interrupt of the TX channel
- 0: No interrupt is generated.
- 1: An interrupt is generated.";
            sw = r; hw = w;
            reset = 0x0;
        } tx_mfade_int_status[6:6];
        field {
            name = "tx_stop_int_status";
            desc = "Status of the stop interrupt of the TX interrupt
- 0: No interrupt is generated.
- 1: An interrupt is generated.";
            sw = r; hw = w;
            reset = 0x0;
        } tx_stop_int_status[5:5];
        field {
            name = "tx_ififo_empty_int_status";
            desc = "Status of the interface FIFO underflow interrupt of the TX channel
- 0: No interrupt is generated.
- 1: An interrupt is generated.";
            sw = r; hw = w;
            reset = 0x0;
        } tx_ififo_empty_int_status[4:4];
        field {
            name = "tx_bfifo_empty_int_status";
            desc = "Status of the bus FIFO underflow interrupt of the TX channel
- 0: No interrupt is generated.
- 1: An interrupt is generated.";
            sw = r; hw = w;
            reset = 0x0;
        } tx_bfifo_empty_int_status[3:3];
        field {
            name = "tx_alempty_int_status";
            desc = "DDR buffer almost empty interrupt of the TX channel
- 0: No interrupt is generated.
- 1: An interrupt is generated.";
            sw = r; hw = w;
            reset = 0x0;
        } tx_alempty_int_status[2:2];
        field {
            name = "tx_empty_int_status";
            desc = "Status of the DDR buffer empty interrupt of the TX channel
- 0: No interrupt is generated.
- 1: An interrupt is generated.";
            sw = r; hw = w;
            reset = 0x0;
        } tx_empty_int_status[1:1];
        field {
            name = "tx_trans_int_status";
            desc = "Status of the transfer completion interrupt of the TX channel
- 0: No interrupt is generated.
- 1: An interrupt is generated.";
            sw = r; hw = w;
            reset = 0x0;
        } tx_trans_int_status[0:0];
    };
    TX_INT_STATUS_t TX_INT_STATUS_0 @ 0x20A8;
    TX_INT_STATUS_t TX_INT_STATUS_1 @ 0x21A8;
    TX_INT_STATUS_t TX_INT_STATUS_2 @ 0x22A8;
    reg TX_INT_CLR_t {
        name = "TX_INT_CLR";
        desc = "TX_INT_CLR is an interrupt clear register for the TX channel. (offset 0x20AC, 3 instances at stride 0x100; total reset 0x00000000; PROVEN: Hi3536D V100 data sheet (Issue 00B04, 2017-12-13), section 10.1.6, PDF page 631).";
        field {
            name = "reserved";
            desc = "Reserved";
            sw = r; hw = w;
            reset = 0x0;
        } reserved_31_8[31:8];
        field {
            name = "tx_dat_break_int_clear";
            desc = "Interface data break interrupt clear for the TX channel
- 0: No raw interrupt is generated.
- 1: A raw interrupt is generated.

Access type WC in the data sheet: written 1 clears the bit.";
            sw = rw; hw = w; onwrite = woclr;
            reset = 0x0;
        } tx_dat_break_int_clear[7:7];
        field {
            name = "tx_mfade_int_clear";
            desc = "Mute fade-in/fade-output completion interrupt clear for the TX channel
- 0: not cleared
- 1: cleared

Access type WC in the data sheet: written 1 clears the bit.";
            sw = rw; hw = w; onwrite = woclr;
            reset = 0x0;
        } tx_mfade_int_clear[6:6];
        field {
            name = "tx_stop_int_clear";
            desc = "Stop interrupt clear for the TX channel
- 0: not cleared
- 1: cleared

Access type WC in the data sheet: written 1 clears the bit.";
            sw = rw; hw = w; onwrite = woclr;
            reset = 0x0;
        } tx_stop_int_clear[5:5];
        field {
            name = "tx_ififo_empty_int_clear";
            desc = "Interface FIFO underflow interrupt clear for the TX channel
- 0: not cleared
- 1: cleared

Access type WC in the data sheet: written 1 clears the bit.";
            sw = rw; hw = w; onwrite = woclr;
            reset = 0x0;
        } tx_ififo_empty_int_clear[4:4];
        field {
            name = "tx_bfifo_empty_int_clear";
            desc = "Bus FIFO underflow interrupt clear for the TX channel
- 0: not cleared
- 1: cleared

Access type WC in the data sheet: written 1 clears the bit.";
            sw = rw; hw = w; onwrite = woclr;
            reset = 0x0;
        } tx_bfifo_empty_int_clear[3:3];
        field {
            name = "tx_alempty_int_clear";
            desc = "DDR buffer almost empty interrupt clear for the TX channel
- 0: not cleared
- 1: cleared

Access type WC in the data sheet: written 1 clears the bit.";
            sw = rw; hw = w; onwrite = woclr;
            reset = 0x0;
        } tx_alempty_int_clear[2:2];
        field {
            name = "tx_empty_int_clear";
            desc = "DDR buffer empty interrupt clear for the RX channel
- 0: not cleared
- 1: cleared

Access type WC in the data sheet: written 1 clears the bit.";
            sw = rw; hw = w; onwrite = woclr;
            reset = 0x0;
        } tx_empty_int_clear[1:1];
        field {
            name = "tx_trans_int_clear";
            desc = "Transfer completion interrupt clear for the TX channel
- 0: not cleared
- 1: cleared

Access type WC in the data sheet: written 1 clears the bit.";
            sw = rw; hw = w; onwrite = woclr;
            reset = 0x0;
        } tx_trans_int_clear[0:0];
    };
    TX_INT_CLR_t TX_INT_CLR_0 @ 0x20AC;
    TX_INT_CLR_t TX_INT_CLR_1 @ 0x21AC;
    TX_INT_CLR_t TX_INT_CLR_2 @ 0x22AC;
};
`endif
