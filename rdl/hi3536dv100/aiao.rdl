`ifndef HI3536D_AIAO_RDL
`define HI3536D_AIAO_RDL
regfile eHI3536D_AIAO {
    name = "Audio interface (AIAO), Hi3536D V100";
    desc = "Audio interface (AIAO) of the Hi3536D V100 at base 0x13040000. 9 registers extracted programmatically from the Hi3536D V100 data sheet (Issue 00B04, 2017-12-13, Table 10-2), register descriptions and field tables; reset values are the data sheet total reset values split onto the fields. Source: dl/research-hi3536 ReleaseDoc (unofficial copy of the HiSilicon SDK documentation; facts only). Field names, bit ranges, access types and reset values are exact; the free-text descriptions are attributed to fields from the PDF text layout (title sentence above the bit row, enumerations below) and can be shifted by one field where a sentence wraps: check the data sheet page when a description matters. Hardware not yet verified (no Hi3536D board on the bench).";
    reg {
        name = "AIAO_INT_ENA";
        desc = "AIAO_INT_ENA (offset 0x0, total reset 0x00000000; PROVEN: Hi3536D V100 data sheet).";
        field {
            name = "reserved_31_18";
            desc = "Reserved";
            sw = r; hw = w;
            reset = 0x0;
        } reserved_31_18[31:18];
        field {
            name = "tx_ch1_int_ena";
            desc = "TX channel 1 interrupt enable 0: disabled 1: enabled";
            sw = rw; hw = r;
            reset = 0x0;
        } tx_ch1_int_ena[17:17];
        field {
            name = "tx_ch0_int_ena";
            desc = "TX channel 0 interrupt enable 0: disabled 1: enabled";
            sw = rw; hw = r;
            reset = 0x0;
        } tx_ch0_int_ena[16:16];
        field {
            name = "reserved_15_1";
            desc = "Reserved";
            sw = r; hw = w;
            reset = 0x0;
        } reserved_15_1[15:1];
        field {
            name = "rx_ch0_int_ena";
            desc = "RX channel 0 interrupt enable 0: disabled 1: enabled";
            sw = rw; hw = r;
            reset = 0x0;
        } rx_ch0_int_ena[0:0];
    } AIAO_INT_ENA @ 0x0;
    reg {
        name = "AIAO_INT_STATUS";
        desc = "AIAO_INT_STATUS is an AIAO interrupt status register. (offset 0x4, total reset 0x00000000; PROVEN: Hi3536D V100 data sheet).";
        field {
            name = "reserved_31_18";
            desc = "Reserved";
            sw = r; hw = w;
            reset = 0x0;
        } reserved_31_18[31:18];
        field {
            name = "tx_ch1_int_status";
            desc = "Interrupt status of TX channel 1 0: No interrupt is generated. 1: An interrupt is generated.";
            sw = r; hw = w;
            reset = 0x0;
        } tx_ch1_int_status[17:17];
        field {
            name = "tx_ch0_int_status";
            desc = "Interrupt status of TX channel 0 0: No interrupt is generated. 1: An interrupt is generated.";
            sw = r; hw = w;
            reset = 0x0;
        } tx_ch0_int_status[16:16];
        field {
            name = "reserved_15_1";
            desc = "Reserved";
            sw = r; hw = w;
            reset = 0x0;
        } reserved_15_1[15:1];
        field {
            name = "rx_ch0_int_status";
            desc = "Interrupt status of RX channel 0 0: No interrupt is generated. 1: An interrupt is generated.";
            sw = r; hw = w;
            reset = 0x0;
        } rx_ch0_int_status[0:0];
    } AIAO_INT_STATUS @ 0x4;
    reg {
        name = "AIAO_INT_RAW";
        desc = "AIAO_INT_RAW is an AIAO raw interrupt register. (offset 0x8, total reset 0x00000000; PROVEN: Hi3536D V100 data sheet).";
        field {
            name = "reserved_31_29";
            desc = "Reserved";
            sw = r; hw = w;
            reset = 0x0;
        } reserved_31_29[31:29];
        field {
            name = "reserved_26_18";
            desc = "Reserved";
            sw = r; hw = w;
            reset = 0x0;
        } reserved_26_18[26:18];
        field {
            name = "tx_ch1_int_raw";
            desc = "Raw interrupt of TX channel 1 0: No raw interrupt is generated. 1: A raw interrupt is generated.";
            sw = r; hw = w;
            reset = 0x0;
        } tx_ch1_int_raw[17:17];
        field {
            name = "tx_ch0_int_raw";
            desc = "Raw interrupt of TX channel 0 0: No raw interrupt is generated. 1: A raw interrupt is generated.";
            sw = r; hw = w;
            reset = 0x0;
        } tx_ch0_int_raw[16:16];
        field {
            name = "reserved_15_1";
            desc = "Reserved";
            sw = r; hw = w;
            reset = 0x0;
        } reserved_15_1[15:1];
        field {
            name = "rx_ch0_int_raw";
            desc = "Raw interrupt of RX channel 0 0: No raw interrupt is generated. 1: A raw interrupt is generated.";
            sw = r; hw = w;
            reset = 0x0;
        } rx_ch0_int_raw[0:0];
    } AIAO_INT_RAW @ 0x8;
    reg {
        name = "AIAO_SWITCH_RX_BCLK";
        desc = "AIAO_SWITCH_RX_BCLK is an AIAO I2S RX BCLK switch configuration register. (offset 0x28, total reset 0x76543210; PROVEN: Hi3536D V100 data sheet).";
        field {
            name = "reserved_31_4";
            desc = "Reserved 0x0: BCLK0 inner_bclk_ws_sel_";
            sw = r; hw = na;
            reset = 0x7654321;
        } reserved_31_4[31:4];
        field {
            name = "f_0x8_";
            desc = "Internal BCLK select for the RX channel 0 BCLK8 rx_00 0x9: BCLK9 Other values: reserved";
            sw = rw; hw = r;
            reset = 0x0;
        } f_0x8_[3:0];
    } AIAO_SWITCH_RX_BCLK @ 0x28;
    reg {
        name = "AIAO_SWITCH_TX_BCLK";
        desc = "AIAO_SWITCH_TX_BCLK is an AIAO I2S TX BCLK switch configuration register. (offset 0x2C, total reset 0x76543210; PROVEN: Hi3536D V100 data sheet).";
        field {
            name = "reserved_31_8";
            desc = "Reserved 0x0: BCLK0 inner_bclk_ws_sel_";
            sw = r; hw = na;
            reset = 0x765432;
        } reserved_31_8[31:8];
        field {
            name = "f_0x8_";
            desc = "Internal BCLK select for TX channel 1 BCLK8 tx_01 0x9: BCLK9 Other values: reserved 0x0: BCLK0 inner_bclk_ws_sel_";
            sw = rw; hw = r;
            reset = 0x1;
        } f_0x8_[7:4];
        field {
            name = "f_0x8__0";
            desc = "Internal BCLK select for TX channel 0 BCLK8 tx_00 0x9: BCLK9 Other values: reserved";
            sw = rw; hw = r;
            reset = 0x0;
        } f_0x8__0[3:0];
    } AIAO_SWITCH_TX_BCLK @ 0x2C;
    reg {
        name = "VHB_OUTSTANDING";
        desc = "VHB_OUTSTANDING is a VHB outstanding configuration register. (offset 0x34, total reset 0x00000000; PROVEN: Hi3536D V100 data sheet).";
        field {
            name = "reserved_31_3";
            desc = "Reserved";
            sw = r; hw = w;
            reset = 0x0;
        } reserved_31_3[31:3];
        field {
            name = "vhb_outst_num";
            desc = "Number of VHB outstandings The recommended value is 3.";
            sw = rw; hw = r;
            reset = 0x0;
        } vhb_outst_num[2:0];
    } VHB_OUTSTANDING @ 0x34;
    reg {
        name = "AIAO_RST_REQ";
        desc = "AIAO_RST_REQ (offset 0x4C, total reset 0x00000000; PROVEN: Hi3536D V100 data sheet).";
        field {
            name = "reserved_31_10";
            desc = "Reserved";
            sw = rw; hw = r;
            reset = 0x0;
        } reserved_31_10[31:10];
        field {
            name = "srst_tcx1_apb";
            desc = "Writing 1 to this bit resets write channel 1. Hardware automatically sets this bit to 0 after the reset is complete.";
            sw = rw; hw = r;
            reset = 0x0;
        } srst_tcx1_apb[9:9];
        field {
            name = "srst_tcx0_apb";
            desc = "Writing 1 to this bit resets write channel 0. Hardware automatically sets this bit to 0 after the reset is complete.";
            sw = rw; hw = r;
            reset = 0x0;
        } srst_tcx0_apb[8:8];
        field {
            name = "reserved_7_1";
            desc = "Reserved";
            sw = rw; hw = r;
            reset = 0x0;
        } reserved_7_1[7:1];
        field {
            name = "srst_rcx0_apb";
            desc = "Writing 1 to this bit resets read channel 0. Hardware automatically sets this bit to 0 after the reset is complete.";
            sw = rw; hw = r;
            reset = 0x0;
        } srst_rcx0_apb[0:0];
    } AIAO_RST_REQ @ 0x4C;
    reg {
        name = "AIAO_RST_DONE";
        desc = "AIAO_RST_DONE is a soft reset result feedback register. (offset 0x50, total reset 0x00000000; PROVEN: Hi3536D V100 data sheet).";
        field {
            name = "reserved_31_27";
            desc = "Reserved";
            sw = r; hw = w;
            reset = 0x0;
        } reserved_31_27[31:27];
        field {
            name = "srst_varb_done_apb";
            desc = "VHB to AXI bus bridge reset completion flag. This bit is cleared when software writes 0 to it.";
            sw = rw; hw = w; woclr;
            reset = 0x0;
        } srst_varb_done_apb[26:26];
        field {
            name = "srst_pcfg_done_apb";
            desc = "Configuration register (not configured in the channel) reset completion flag. This bit is cleared when software writes 0 to it.";
            sw = rw; hw = w; woclr;
            reset = 0x0;
        } srst_pcfg_done_apb[25:25];
        field {
            name = "srst_tdsp_done_apb";
            desc = "Volume adjustment module reset completion flag. This bit is cleared when software writes 0 to it.";
            sw = rw; hw = w; woclr;
            reset = 0x0;
        } srst_tdsp_done_apb[24:24];
        field {
            name = "reserved_23_10";
            desc = "Reserved";
            sw = r; hw = w;
            reset = 0x0;
        } reserved_23_10[23:10];
        field {
            name = "srst_tcx1_done_apb";
            desc = "Write channel 1 reset completion flag. This bit is cleared when software writes 0 to it.";
            sw = rw; hw = w; woclr;
            reset = 0x0;
        } srst_tcx1_done_apb[9:9];
        field {
            name = "srst_tcx0_done_apb";
            desc = "Write channel 0 reset completion flag. This bit is cleared when software writes 0 to it.";
            sw = rw; hw = w; woclr;
            reset = 0x0;
        } srst_tcx0_done_apb[8:8];
        field {
            name = "reserved_7_1";
            desc = "Reserved";
            sw = r; hw = w;
            reset = 0x0;
        } reserved_7_1[7:1];
        field {
            name = "srst_rcx0_done_apb";
            desc = "Read channel 0 reset completion flag. This bit is cleared when software writes 0 to it.";
            sw = rw; hw = w; woclr;
            reset = 0x0;
        } srst_rcx0_done_apb[0:0];
    } AIAO_RST_DONE @ 0x50;
    reg {
        name = "I2S_CRG_CFG1_00";
        desc = "I2S_CRG_CFG1_00 (offset 0x104, total reset 0x00000131; PROVEN: Hi3536D V100 data sheet).";
        field {
            name = "reserved_31_14";
            desc = "Reserved";
            sw = r; hw = w;
            reset = 0x0;
        } reserved_31_14[31:14];
        field {
            name = "aiao_bclkout_pctrl";
            desc = "BCLKOUT polarity 0: positive 1: negative";
            sw = rw; hw = r;
            reset = 0x0;
        } aiao_bclkout_pctrl[13:13];
        field {
            name = "aiao_bclkin_pctrl";
            desc = "BCLKIN polarity 0: positive 1: negative";
            sw = rw; hw = r;
            reset = 0x0;
        } aiao_bclkin_pctrl[12:12];
        field {
            name = "aiao_bclk_sel";
            desc = "BCLK/FCLK select 0: Clocks are internally generated. 1: Clocks are input from the external audio DAC. 0: The BCLK/FCLK I/O is output.";
            sw = rw; hw = r;
            reset = 0x0;
        } aiao_bclk_sel[11:11];
        field {
            name = "aiao_bclk_oen";
            desc = "BCLK/FCLK I/O OEN control 1: The BCLK/FCLK I/O is input.";
            sw = rw; hw = r;
            reset = 0x0;
        } aiao_bclk_oen[10:10];
        field {
            name = "aiao_srst_req";
            desc = "Note: This field needs to work with aiao_bclk_sel to select the master/slave mode of the I2S interface. Soft reset request 0: deassert reset 1: reset";
            sw = rw; hw = r;
            reset = 0x0;
        } aiao_srst_req[9:9];
        field {
            name = "aiao_cken";
            desc = "Clock status 0: disabled 1: enabled";
            sw = rw; hw = r;
            reset = 0x1;
        } aiao_cken[8:8];
        field {
            name = "reserved_7_7";
            desc = "Reserved the sampling clock FS 000: The FS is obtained by dividing the BCLK by 16. 001: The FS is obtained by dividing the BCLK by 32. 010: The FS is obtained by dividing the BCLK by 48.";
            sw = r; hw = w;
            reset = 0x0;
        } reserved_7_7[7:7];
        field {
            name = "aiao_fsclk_div";
            desc = "Frequency division relationship between the bit clock BCLK and 011: The FS is obtained by dividing the BCLK by 64. 100: The FS is obtained by dividing the BCLK by 128. 101: The FS is obtained by dividing the BCLK by 256. 110: The FS is obtained by dividing the BCLK by 320. 111: The FS is obtained by dividing the BCLK by 384. 0x0: The BCLK is obtained by dividing the MCLK by 1. 0x1: The BCLK is obt";
            sw = rw; hw = r;
            reset = 0x3;
        } aiao_fsclk_div[6:4];
        field {
            name = "aiao_bclk_div";
            desc = "Frequency division relationship between the main clock MCLK and the bit clock BCLK 0x5: The BCLK is obtained by dividing the MCLK by 8. 0x6: The BCLK is obtained by dividing the MCLK by 12. 0x7: The BCLK is obtained by dividing the MCLK by 16. 0x8: The BCLK is obtained by dividing the MCLK by 24. 0x9: The BCLK is obtained by dividing the MCLK by 32. 0xA: The BCLK is obtained by dividing the MCLK b";
            sw = rw; hw = r;
            reset = 0x1;
        } aiao_bclk_div[3:0];
    } I2S_CRG_CFG1_00 @ 0x104;
};

`endif
