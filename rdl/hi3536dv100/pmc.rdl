`ifndef HI3536D_PMC_RDL
`define HI3536D_PMC_RDL
regfile eHI3536D_PMC {
    name = "Power management control (PMC / PWM + HPM) registers, Hi3536D V100";
    desc = "Power management control (PMC / PWM + HPM) registers of the Hi3536D V100 at base 0x120E0000. 21 registers extracted programmatically from the Hi3536D V100 data sheet (Issue 00B04, 2017-12-13, Table 3-21), register descriptions and field tables; reset values are the data sheet total reset values split onto the fields. Source: dl/research-hi3536 ReleaseDoc (unofficial copy of the HiSilicon SDK documentation; facts only). Field names, bit ranges, access types and reset values are exact; the free-text descriptions are attributed to fields from the PDF text layout (title sentence above the bit row, enumerations below) and can be shifted by one field where a sentence wraps: check the data sheet page when a description matters. Hardware not yet verified (no Hi3536D board on the bench).";
    reg {
        name = "PERI_PMC0";
        desc = "PERI_PMC0 is a core AVS PWM configuration register. (offset 0x0, total reset 0x00120078; PROVEN: Hi3536D V100 data sheet).";
        field {
            name = "core_pwm_duty";
            desc = "Number of PWM high-level beats for the core AVS output. If the value is greater than or equal to the number of PWM cycles, the output level is always high.";
            sw = rw; hw = r;
            reset = 0x12;
        } core_pwm_duty[31:16];
        field {
            name = "core_pwm_period";
            desc = "Number of PWM cycles for the core AVS output..";
            sw = rw; hw = r;
            reset = 0x78;
        } core_pwm_period[15:0];
    } PERI_PMC0 @ 0x0;
    reg {
        name = "PERI_PMC1";
        desc = "PERI_PMC1 (offset 0x4, total reset 0x00120078; PROVEN: Hi3536D V100 data sheet).";
        field {
            name = "cpu_pwm_duty";
            desc = "Number of PWM high-level beats for the CPU AVS output. If the value is greater than or equal to the number of PWM cycles, the output level is always high.";
            sw = rw; hw = r;
            reset = 0x12;
        } cpu_pwm_duty[31:16];
        field {
            name = "cpu_pwm_period";
            desc = "Number of PWM cycles for the CPU AVS output.";
            sw = rw; hw = r;
            reset = 0x78;
        } cpu_pwm_period[15:0];
    } PERI_PMC1 @ 0x4;
    reg {
        name = "PERI_PMC2";
        desc = "PERI_PMC2 is a FREE PWM configuration register. (offset 0x8, total reset 0x00120078; PROVEN: Hi3536D V100 data sheet).";
        field {
            name = "free_pwm_duty";
            desc = "Number of PWM high-level beats for the FREE PWM output. If the value is greater than or equal to the number of PWM cycles, the output level is always high.";
            sw = rw; hw = r;
            reset = 0x12;
        } free_pwm_duty[31:16];
        field {
            name = "free_pwm_period";
            desc = "Number of PWM cycles for the FREE PWM output.";
            sw = rw; hw = r;
            reset = 0x78;
        } free_pwm_period[15:0];
    } PERI_PMC2 @ 0x8;
    reg {
        name = "PERI_PMC4";
        desc = "PERI_PMC4 (offset 0x10, total reset 0x00002400; PROVEN: Hi3536D V100 data sheet).";
        field {
            name = "reserved_31_6";
            desc = "Reserved";
            sw = r; hw = na;
            reset = 0x90;
        } reserved_31_6[31:6];
        field {
            name = "free_pwm_inv";
            desc = "PWM phase control for the FREE PWM output 0: normal output 1: inverted output";
            sw = rw; hw = r;
            reset = 0x0;
        } free_pwm_inv[5:5];
        field {
            name = "free_pwm_enable";
            desc = "PWM enable control for the FREE PWM output 0: disabled 1: enabled";
            sw = rw; hw = r;
            reset = 0x0;
        } free_pwm_enable[4:4];
        field {
            name = "cpu_pwm_inv";
            desc = "PWM phase control for the CPU AVS output 0: normal output 1: inverted output";
            sw = rw; hw = r;
            reset = 0x0;
        } cpu_pwm_inv[3:3];
        field {
            name = "cpu_pwm_enable";
            desc = "PWM enable for the CPU AVS output 0: disabled 1: enabled";
            sw = rw; hw = r;
            reset = 0x0;
        } cpu_pwm_enable[2:2];
        field {
            name = "core_pwm_inv";
            desc = "PWM phase control for the core AVS output 0: normal output 1: inverted output";
            sw = rw; hw = r;
            reset = 0x0;
        } core_pwm_inv[1:1];
        field {
            name = "core_pwm_enable";
            desc = "PWM enable for the core AVS output 0: disabled 1: enabled";
            sw = rw; hw = r;
            reset = 0x0;
        } core_pwm_enable[0:0];
    } PERI_PMC4 @ 0x10;
    reg {
        name = "PERI_PMC10";
        desc = "PERI_PMC10 (offset 0x28, total reset 0x0000000A; PROVEN: Hi3536D V100 data sheet).";
        field {
            name = "reserved_31_28";
            desc = "Reserved";
            sw = r; hw = w;
            reset = 0x0;
        } reserved_31_28[31:28];
        field {
            name = "core_hpm_srst_req";
            desc = "Core HPM reset request 0: deassert reset 1: reset core_hpm_monitor";
            sw = rw; hw = r;
            reset = 0x0;
        } core_hpm_srst_req[27:27];
        field {
            name = "f_0_";
            desc = "Core HPM cyclic monitoring enable one-time monitoring _en 1: cyclic monitoring";
            sw = rw; hw = r;
            reset = 0x0;
        } f_0_[26:26];
        field {
            name = "reserved_25_25";
            desc = "Reserved";
            sw = rw; hw = r;
            reset = 0x0;
        } reserved_25_25[25:25];
        field {
            name = "core_hpm_en";
            desc = "Core HPM measurement enable 0: The value retains 0 before a process is started. 1: A frequency modulation process is started.";
            sw = rw; hw = r;
            reset = 0x0;
        } core_hpm_en[24:24];
        field {
            name = "reserved_23_22";
            desc = "Reserved";
            sw = w; hw = r;
            reset = 0x0;
        } reserved_23_22[23:22];
        field {
            name = "core_hpm_offset";
            desc = "Core HPM offset";
            sw = rw; hw = r;
            reset = 0x0;
        } core_hpm_offset[21:12];
        field {
            name = "reserved_11_10";
            desc = "Reserved";
            sw = r; hw = w;
            reset = 0x0;
        } reserved_11_10[11:10];
        field {
            name = "core_hpm_shift";
            desc = "Core HPM shift";
            sw = rw; hw = r;
            reset = 0x0;
        } core_hpm_shift[9:8];
        field {
            name = "reserved_7_6";
            desc = "Reserved";
            sw = r; hw = w;
            reset = 0x0;
        } reserved_7_6[7:6];
        field {
            name = "core_hpm_div";
            desc = "Divider of the core HPM reference clock n: (n + 1) frequency division (n must be greater than 0.)";
            sw = rw; hw = r;
            reset = 0xa;
        } core_hpm_div[5:0];
    } PERI_PMC10 @ 0x28;
    reg {
        name = "PERI_PMC11";
        desc = "PERI_PMC11 (offset 0x2C, total reset 0x00000000; PROVEN: Hi3536D V100 data sheet).";
        field {
            name = "reserved_31_26";
            desc = "Reserved core_hpm_up_warn";
            sw = r; hw = w;
            reset = 0x0;
        } reserved_31_26[31:26];
        field {
            name = "Core";
            desc = "HPM overflow alarm, active high ing core_hpm_low_war";
            sw = r; hw = w;
            reset = 0x0;
        } Core[25:25];
        field {
            name = "Core_24";
            desc = "HPM underflow alarm, active high ning";
            sw = r; hw = w;
            reset = 0x0;
        } Core_24[24:24];
        field {
            name = "reserved_23_22";
            desc = "Reserved core_hpm_pc_recor";
            sw = r; hw = w;
            reset = 0x0;
        } reserved_23_22[23:22];
        field {
            name = "Core_12";
            desc = "HPM original code pattern 1 d1";
            sw = r; hw = w;
            reset = 0x0;
        } Core_12[21:12];
        field {
            name = "reserved_11_11";
            desc = "Reserved";
            sw = r; hw = w;
            reset = 0x0;
        } reserved_11_11[11:11];
        field {
            name = "core_hpm_pc_valid";
            desc = "Core HPM output validity indicator 0: invalid 1: valid core_hpm_pc_recor";
            sw = r; hw = w;
            reset = 0x0;
        } core_hpm_pc_valid[10:10];
        field {
            name = "Core_0";
            desc = "HPM original code pattern 0 d0";
            sw = r; hw = w;
            reset = 0x0;
        } Core_0[9:0];
    } PERI_PMC11 @ 0x2C;
    reg {
        name = "PERI_PMC12";
        desc = "PERI_PMC12 (offset 0x30, total reset 0x00000000; PROVEN: Hi3536D V100 data sheet).";
        field {
            name = "reserved_31_29";
            desc = "Reserved";
            sw = r; hw = w;
            reset = 0x0;
        } reserved_31_29[31:29];
        field {
            name = "core_hpm_rcc";
            desc = "Core HPM output with the RCC code";
            sw = r; hw = w;
            reset = 0x0;
        } core_hpm_rcc[28:24];
        field {
            name = "reserved_23_22";
            desc = "Reserved core_hpm_pc_recor";
            sw = r; hw = w;
            reset = 0x0;
        } reserved_23_22[23:22];
        field {
            name = "Core";
            desc = "HPM original code pattern 3 d3";
            sw = r; hw = w;
            reset = 0x0;
        } Core[21:12];
        field {
            name = "reserved_11_10";
            desc = "Reserved core_hpm_pc_recor";
            sw = r; hw = w;
            reset = 0x0;
        } reserved_11_10[11:10];
        field {
            name = "Core_0";
            desc = "HPM original code pattern 2 d2";
            sw = r; hw = w;
            reset = 0x0;
        } Core_0[9:0];
    } PERI_PMC12 @ 0x30;
    reg {
        name = "PERI_PMC13";
        desc = "PERI_PMC13 is core HPM control register 3. (offset 0x34, total reset 0x01000000; PROVEN: Hi3536D V100 data sheet).";
        field {
            name = "reserved_23_22";
            desc = "Core HPM cyclic monitoring period If the configured value is N, the monitoring period (T) is as core_hpm_monitor follows: [31:24]             RW _period          T = N x 2048/1000 ms The maximum monitoring interval is 522 ms, and the minimum interval is 2 ms. Reserved";
            sw = r; hw = w;
            reset = 0x0;
        } reserved_23_22[23:22];
        field {
            name = "core_hpm_lowlimit";
            desc = "Core HPM lower limit";
            sw = rw; hw = r;
            reset = 0x0;
        } core_hpm_lowlimit[21:12];
        field {
            name = "reserved_11_10";
            desc = "Reserved";
            sw = r; hw = w;
            reset = 0x0;
        } reserved_11_10[11:10];
        field {
            name = "core_hpm_uplimit";
            desc = "Core HPM upper limit";
            sw = rw; hw = r;
            reset = 0x0;
        } core_hpm_uplimit[9:0];
    } PERI_PMC13 @ 0x34;
    reg {
        name = "PERI_PMC14";
        desc = "PERI_PMC14 is CPU HPM control register 0. (offset 0x38, total reset 0x0000000A; PROVEN: Hi3536D V100 data sheet).";
        field {
            name = "reserved_31_28";
            desc = "Reserved";
            sw = r; hw = w;
            reset = 0x0;
        } reserved_31_28[31:28];
        field {
            name = "cpu_hpm_srst_req";
            desc = "CPU HPM reset request, active high 0: deassert reset 1: reset cpu_hpm_monitor_";
            sw = rw; hw = r;
            reset = 0x0;
        } cpu_hpm_srst_req[27:27];
        field {
            name = "f_0_";
            desc = "CPU HPM cyclic monitoring enable one-time monitoring en 1: cyclic monitoring";
            sw = rw; hw = r;
            reset = 0x0;
        } f_0_[26:26];
        field {
            name = "reserved_25_25";
            desc = "Reserved";
            sw = rw; hw = r;
            reset = 0x0;
        } reserved_25_25[25:25];
        field {
            name = "cpu_hpm_en";
            desc = "CPU HPM measurement enable 0: The value retains 0 before a process is started. 1: A frequency measurement process is started.";
            sw = rw; hw = r;
            reset = 0x0;
        } cpu_hpm_en[24:24];
        field {
            name = "reserved_23_22";
            desc = "Reserved";
            sw = r; hw = w;
            reset = 0x0;
        } reserved_23_22[23:22];
        field {
            name = "cpu_hpm_offset";
            desc = "CPU HPM offset";
            sw = rw; hw = r;
            reset = 0x0;
        } cpu_hpm_offset[21:12];
        field {
            name = "reserved_11_10";
            desc = "Reserved";
            sw = r; hw = w;
            reset = 0x0;
        } reserved_11_10[11:10];
        field {
            name = "cpu_hpm_shift";
            desc = "CPU HPM shift";
            sw = rw; hw = r;
            reset = 0x0;
        } cpu_hpm_shift[9:8];
        field {
            name = "reserved_7_6";
            desc = "Reserved";
            sw = rw; hw = r;
            reset = 0x0;
        } reserved_7_6[7:6];
        field {
            name = "cpu_hpm_div";
            desc = "Divider of the CPU HPM reference clock n: (n + 1) frequency division (n must be greater than 0.)";
            sw = rw; hw = r;
            reset = 0xa;
        } cpu_hpm_div[5:0];
    } PERI_PMC14 @ 0x38;
    reg {
        name = "PERI_PMC15";
        desc = "PERI_PMC15 is CPU HPM status register 1. (offset 0x3C, total reset 0x00000000; PROVEN: Hi3536D V100 data sheet).";
        field {
            name = "reserved_31_26";
            desc = "Reserved cpu_hpm_up_warni";
            sw = r; hw = w;
            reset = 0x0;
        } reserved_31_26[31:26];
        field {
            name = "CPU";
            desc = "HPM overflow alarm, active high ng cpu_hpm_low_war";
            sw = r; hw = w;
            reset = 0x0;
        } CPU[25:25];
        field {
            name = "CPU_24";
            desc = "HPM underflow alarm, active high ning";
            sw = r; hw = w;
            reset = 0x0;
        } CPU_24[24:24];
        field {
            name = "reserved_23_22";
            desc = "Reserved cpu_hpm_pc_recor";
            sw = r; hw = w;
            reset = 0x0;
        } reserved_23_22[23:22];
        field {
            name = "CPU_12";
            desc = "HPM original code pattern 1 d1";
            sw = r; hw = w;
            reset = 0x0;
        } CPU_12[21:12];
        field {
            name = "reserved_11_11";
            desc = "Reserved";
            sw = r; hw = w;
            reset = 0x0;
        } reserved_11_11[11:11];
        field {
            name = "cpu_hpm_pc_valid";
            desc = "CPU HPM output validity indicator 0: invalid 1: valid cpu_hpm_pc_recor";
            sw = r; hw = w;
            reset = 0x0;
        } cpu_hpm_pc_valid[10:10];
        field {
            name = "CPU_0";
            desc = "HPM original code pattern 0 d0";
            sw = r; hw = w;
            reset = 0x0;
        } CPU_0[9:0];
    } PERI_PMC15 @ 0x3C;
    reg {
        name = "PERI_PMC16";
        desc = "PERI_PMC16 (offset 0x40, total reset 0x00000000; PROVEN: Hi3536D V100 data sheet).";
        field {
            name = "reserved_31_29";
            desc = "Reserved";
            sw = r; hw = w;
            reset = 0x0;
        } reserved_31_29[31:29];
        field {
            name = "cpu_hpm_rcc";
            desc = "CPU HPM output with the RCC code";
            sw = r; hw = w;
            reset = 0x0;
        } cpu_hpm_rcc[28:24];
        field {
            name = "reserved_23_22";
            desc = "Reserved cpu_hpm_pc_recor";
            sw = r; hw = w;
            reset = 0x0;
        } reserved_23_22[23:22];
        field {
            name = "CPU";
            desc = "HPM original code pattern 3 d3";
            sw = r; hw = w;
            reset = 0x0;
        } CPU[21:12];
        field {
            name = "reserved_11_10";
            desc = "Reserved cpu_hpm_pc_recor";
            sw = r; hw = w;
            reset = 0x0;
        } reserved_11_10[11:10];
        field {
            name = "CPU_0";
            desc = "HPM original code pattern 2 d2";
            sw = r; hw = w;
            reset = 0x0;
        } CPU_0[9:0];
    } PERI_PMC16 @ 0x40;
    reg {
        name = "PERI_PMC17";
        desc = "PERI_PMC17 is CPU HPM control register 3. (offset 0x44, total reset 0x01000000; PROVEN: Hi3536D V100 data sheet).";
        field {
            name = "reserved_23_22";
            desc = "CPU HPM cyclic monitoring period If the configured value is N, the monitoring period (T) is as cpu_hpm_monitor_ follows: [31:24]               RW period           T = N x 2048/1000 ms The maximum monitoring interval is 522 ms, and the minimum interval is 2 ms. Reserved";
            sw = r; hw = w;
            reset = 0x0;
        } reserved_23_22[23:22];
        field {
            name = "cpu_hpm_lowlimit";
            desc = "CPU HPM lower limit";
            sw = rw; hw = r;
            reset = 0x0;
        } cpu_hpm_lowlimit[21:12];
        field {
            name = "reserved_11_10";
            desc = "Reserved";
            sw = r; hw = w;
            reset = 0x0;
        } reserved_11_10[11:10];
        field {
            name = "cpu_hpm_uplimit";
            desc = "CPU HPM upper limit";
            sw = rw; hw = r;
            reset = 0x0;
        } cpu_hpm_uplimit[9:0];
    } PERI_PMC17 @ 0x44;
    reg {
        name = "PERI_PMC30";
        desc = "PERI_PMC30 is HPM monitoring fine-tuning control register 1. (offset 0x78, total reset 0x00000000; PROVEN: Hi3536D V100 data sheet).";
        field {
            name = "Parameter";
            desc = "cpu_hpm_monitor_ for fine-tuning the CPU HPM cyclic monitoring cycle period_fine";
            sw = rw; hw = r;
            reset = 0x0;
        } Parameter[31:24];
        field {
            name = "reserved_23_8";
            desc = "Reserved";
            sw = rw; hw = r;
            reset = 0x0;
        } reserved_23_8[23:8];
        field {
            name = "reserved_7_0";
            desc = "Reserved";
            sw = r; hw = w;
            reset = 0x0;
        } reserved_7_0[7:0];
    } PERI_PMC30 @ 0x78;
    reg {
        name = "PERI_PMC31";
        desc = "PERI_PMC31 is HPM monitoring fine-tuning control register 2. (offset 0x7C, total reset 0x00000000; PROVEN: Hi3536D V100 data sheet).";
        field {
            name = "reserved_31_8";
            desc = "Reserved core_hpm_monitor";
            sw = r; hw = w;
            reset = 0x0;
        } reserved_31_8[31:8];
        field {
            name = "Parameter";
            desc = "for fine-tuning the core HPM cyclic monitoring cycle _period";
            sw = rw; hw = r;
            reset = 0x0;
        } Parameter[7:0];
    } PERI_PMC31 @ 0x7C;
    reg {
        name = "PERI_PMC68";
        desc = "PERI_PMC68 (offset 0x110, total reset 0x00000000; PROVEN: Hi3536D V100 data sheet).";
        field {
            name = "reserved_31_31";
            desc = "Reserved";
            sw = r; hw = w;
            reset = 0x0;
        } reserved_31_31[31:31];
        field {
            name = "tsensor_en";
            desc = "Temperature sensor enable 0: disabled 1: enabled";
            sw = rw; hw = r;
            reset = 0x0;
        } tsensor_en[30:30];
        field {
            name = "tsensor_monitor_en";
            desc = "Cyclic temperature monitoring enable 0: disabled 1: enabled";
            sw = rw; hw = r;
            reset = 0x0;
        } tsensor_monitor_en[29:29];
        field {
            name = "reserved_28_24";
            desc = "Reserved tsensor_monitor_pe Cyclic temperature monitoring cycle. The timing reference is 2 [23:16]                                        RW riod               ms.";
            sw = r; hw = w;
            reset = 0x0;
        } reserved_28_24[28:24];
        field {
            name = "reserved_15_0";
            desc = "Reserved";
            sw = r; hw = w;
            reset = 0x0;
        } reserved_15_0[15:0];
    } PERI_PMC68 @ 0x110;
    reg {
        name = "PERI_PMC69";
        desc = "PERI_PMC69 is a Tsensor overflow/underflow configuration register. (offset 0x114, total reset 0x00000000; PROVEN: Hi3536D V100 data sheet).";
        field {
            name = "reserved_31_26";
            desc = "Reserved tsensor_temp_upli";
            sw = rw; hw = r;
            reset = 0x0;
        } reserved_31_26[31:26];
        field {
            name = "Temperature";
            desc = "overflow value mit";
            sw = rw; hw = r;
            reset = 0x0;
        } Temperature[25:16];
        field {
            name = "reserved_15_10";
            desc = "Reserved tsensor_temp_lowli";
            sw = rw; hw = r;
            reset = 0x0;
        } reserved_15_10[15:10];
        field {
            name = "Temperature_0";
            desc = "underflow value mit";
            sw = rw; hw = r;
            reset = 0x0;
        } Temperature_0[9:0];
    } PERI_PMC69 @ 0x114;
    reg {
        name = "PERI_PMC70";
        desc = "PERI_PMC70 is a Tsensor measurement value 0/1 register. (offset 0x118, total reset 0x00000000; PROVEN: Hi3536D V100 data sheet).";
        field {
            name = "reserved_31_26";
            desc = "Reserved tsensor_temp_code";
            sw = r; hw = w;
            reset = 0x0;
        } reserved_31_26[31:26];
        field {
            name = "Temperature";
            desc = "record value 1 1";
            sw = r; hw = w;
            reset = 0x0;
        } Temperature[25:16];
        field {
            name = "reserved_15_10";
            desc = "Reserved tsensor_temp_code";
            sw = r; hw = w;
            reset = 0x0;
        } reserved_15_10[15:10];
        field {
            name = "Temperature_0";
            desc = "record value 0 0";
            sw = r; hw = w;
            reset = 0x0;
        } Temperature_0[9:0];
    } PERI_PMC70 @ 0x118;
    reg {
        name = "PERI_PMC71";
        desc = "PERI_PMC71 is a Tsensor measurement value 2/3 register. (offset 0x11C, total reset 0x00000000; PROVEN: Hi3536D V100 data sheet).";
        field {
            name = "reserved_31_26";
            desc = "Reserved tsensor_temp_code";
            sw = r; hw = w;
            reset = 0x0;
        } reserved_31_26[31:26];
        field {
            name = "Temperature";
            desc = "record value 3 3";
            sw = r; hw = w;
            reset = 0x0;
        } Temperature[25:16];
        field {
            name = "reserved_15_10";
            desc = "Reserved tsensor_temp_code";
            sw = r; hw = w;
            reset = 0x0;
        } reserved_15_10[15:10];
        field {
            name = "Temperature_0";
            desc = "record value 2 2";
            sw = r; hw = w;
            reset = 0x0;
        } Temperature_0[9:0];
    } PERI_PMC71 @ 0x11C;
    reg {
        name = "PERI_PMC72";
        desc = "PERI_PMC72 is a Tsensor measurement value 4/5 register. (offset 0x120, total reset 0x00000000; PROVEN: Hi3536D V100 data sheet).";
        field {
            name = "reserved_31_26";
            desc = "Reserved tsensor_temp_code";
            sw = r; hw = w;
            reset = 0x0;
        } reserved_31_26[31:26];
        field {
            name = "Temperature";
            desc = "record value 5 5";
            sw = r; hw = w;
            reset = 0x0;
        } Temperature[25:16];
        field {
            name = "reserved_15_10";
            desc = "Reserved tsensor_temp_code";
            sw = r; hw = w;
            reset = 0x0;
        } reserved_15_10[15:10];
        field {
            name = "Temperature_0";
            desc = "record value 4 4";
            sw = r; hw = w;
            reset = 0x0;
        } Temperature_0[9:0];
    } PERI_PMC72 @ 0x120;
    reg {
        name = "PERI_PMC73";
        desc = "PERI_PMC73 is a Tsensor measurement value 6/7 register. (offset 0x124, total reset 0x00000000; PROVEN: Hi3536D V100 data sheet).";
        field {
            name = "reserved_31_26";
            desc = "Reserved tsensor_temp_code";
            sw = r; hw = w;
            reset = 0x0;
        } reserved_31_26[31:26];
        field {
            name = "Temperature";
            desc = "record value 7 7";
            sw = r; hw = w;
            reset = 0x0;
        } Temperature[25:16];
        field {
            name = "reserved_15_10";
            desc = "Reserved tsensor_temp_code";
            sw = r; hw = w;
            reset = 0x0;
        } reserved_15_10[15:10];
        field {
            name = "Temperature_0";
            desc = "record value 6 6";
            sw = r; hw = w;
            reset = 0x0;
        } Temperature_0[9:0];
    } PERI_PMC73 @ 0x124;
    reg {
        name = "PERI_PMC74";
        desc = "PERI_PMC74 (offset 0x128, total reset 0x00000000; PROVEN: Hi3536D V100 data sheet).";
        field {
            name = "reserved_31_2";
            desc = "Reserved tsensor_low_warni";
            sw = r; hw = w;
            reset = 0x0;
        } reserved_31_2[31:2];
        field {
            name = "Temperature";
            desc = "underflow alarm flag, active high ng tsensor_up_warnin";
            sw = r; hw = w;
            reset = 0x0;
        } Temperature[1:1];
        field {
            name = "Temperature_0";
            desc = "overflow alarm flag, active high g 3.12 Power Management and Low-Power Mode Control 3.12.1 Overview     Clock gating and clock frequency adjustment consumption of the chip. In addition, the frequency of the system working clock can be adjusted. That is, when the function requirement is met, you can adjust the clock frequency to reduce the power consumption of the chip. In low-power mode, the powe";
            sw = r; hw = w;
            reset = 0x0;
        } Temperature_0[0:0];
    } PERI_PMC74 @ 0x128;
};

`endif
