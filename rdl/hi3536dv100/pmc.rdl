`ifndef HI3536D_PMC_RDL
`define HI3536D_PMC_RDL
regfile eHI3536D_PMC {
    name = "Power management control (PMC / PWM + HPM) registers, Hi3536D V100";
    desc = "Power management control (PMC / PWM + HPM) registers, Hi3536D V100 of the Hi3536D V100 at base 0x120E_0000. 21 registers extracted programmatically from the Hi3536D V100 data sheet (Issue 00B04, 2017-12-13) (Table 3-21 Summary of PMC registers (base address: 0x120E_0000)): register headings, offsets, total reset values, field bit ranges, access types, names, reset values and descriptions, with PDF page numbers in each register description. Field names, bit ranges, access types and offsets are exact; the free-text descriptions are taken from the cell text of the field table and were checked by sampling only. Hardware not verified.";
    reg {
        name = "PERI_PMC0";
        desc = "PERI_PMC0 is a core AVS PWM configuration register. (offset 0x0; total reset 0x00120078; PROVEN: Hi3536D V100 data sheet (Issue 00B04, 2017-12-13), section 3.11.4, PDF page 237).";
        field {
            name = "core_pwm_duty";
            desc = "Number of PWM high-level beats for the core AVS output. If the value is greater than or equal to the number of PWM cycles, the output level is always high.";
            sw = rw; hw = r;
            reset = 0x12;
        } core_pwm_duty[31:16];
        field {
            name = "core_pwm_period";
            desc = "Number of PWM cycles for the core AVS output..";
            sw = rw; hw = r;
            reset = 0x78;
        } core_pwm_period[15:0];
    } PERI_PMC0 @ 0x0;
    reg {
        name = "PERI_PMC1";
        desc = "PERI_PMC1 is a CPU AVS PWM configuration register. (offset 0x4; total reset 0x00120078; PROVEN: Hi3536D V100 data sheet (Issue 00B04, 2017-12-13), section 3.11.4, PDF page 238).";
        field {
            name = "cpu_pwm_duty";
            desc = "Number of PWM high-level beats for the CPU AVS output. If the value is greater than or equal to the number of PWM cycles, the output level is always high.";
            sw = rw; hw = r;
            reset = 0x12;
        } cpu_pwm_duty[31:16];
        field {
            name = "cpu_pwm_period";
            desc = "Number of PWM cycles for the CPU AVS output.";
            sw = rw; hw = r;
            reset = 0x78;
        } cpu_pwm_period[15:0];
    } PERI_PMC1 @ 0x4;
    reg {
        name = "PERI_PMC2";
        desc = "PERI_PMC2 is a FREE PWM configuration register. (offset 0x8; total reset 0x00120078; PROVEN: Hi3536D V100 data sheet (Issue 00B04, 2017-12-13), section 3.11.4, PDF page 238).";
        field {
            name = "free_pwm_duty";
            desc = "Number of PWM high-level beats for the FREE PWM output. If the value is greater than or equal to the number of PWM cycles, the output level is always high.";
            sw = rw; hw = r;
            reset = 0x12;
        } free_pwm_duty[31:16];
        field {
            name = "free_pwm_period";
            desc = "Number of PWM cycles for the FREE PWM output.";
            sw = rw; hw = r;
            reset = 0x78;
        } free_pwm_period[15:0];
    } PERI_PMC2 @ 0x8;
    reg {
        name = "PERI_PMC4";
        desc = "PERI_PMC4 is an AVS PWM output source select configuration register. (offset 0x10; total reset 0x00002400; PROVEN: Hi3536D V100 data sheet (Issue 00B04, 2017-12-13), section 3.11.4, PDF page 239).";
        field {
            name = "reserved";
            desc = "Reserved";
            sw = r; hw = w;
            reset = 0x90;
        } reserved_31_6[31:6];
        field {
            name = "free_pwm_inv";
            desc = "PWM phase control for the FREE PWM output
- 0: normal output
- 1: inverted output";
            sw = rw; hw = r;
            reset = 0x0;
        } free_pwm_inv[5:5];
        field {
            name = "free_pwm_enable";
            desc = "PWM enable control for the FREE PWM output
- 0: disabled
- 1: enabled";
            sw = rw; hw = r;
            reset = 0x0;
        } free_pwm_enable[4:4];
        field {
            name = "cpu_pwm_inv";
            desc = "PWM phase control for the CPU AVS output
- 0: normal output
- 1: inverted output";
            sw = rw; hw = r;
            reset = 0x0;
        } cpu_pwm_inv[3:3];
        field {
            name = "cpu_pwm_enable";
            desc = "PWM enable for the CPU AVS output
- 0: disabled
- 1: enabled";
            sw = rw; hw = r;
            reset = 0x0;
        } cpu_pwm_enable[2:2];
        field {
            name = "core_pwm_inv";
            desc = "PWM phase control for the core AVS output
- 0: normal output
- 1: inverted output";
            sw = rw; hw = r;
            reset = 0x0;
        } core_pwm_inv[1:1];
        field {
            name = "core_pwm_enable";
            desc = "PWM enable for the core AVS output
- 0: disabled
- 1: enabled";
            sw = rw; hw = r;
            reset = 0x0;
        } core_pwm_enable[0:0];
    } PERI_PMC4 @ 0x10;
    reg {
        name = "PERI_PMC10";
        desc = "PERI_PMC10 is core HPM control register 0. (offset 0x28; total reset 0x0000000A; PROVEN: Hi3536D V100 data sheet (Issue 00B04, 2017-12-13), section 3.11.4, PDF page 240).";
        field {
            name = "reserved";
            desc = "Reserved";
            sw = r; hw = w;
            reset = 0x0;
        } reserved_31_28[31:28];
        field {
            name = "core_hpm_srst_req";
            desc = "Core HPM reset request
- 0: deassert reset
- 1: reset";
            sw = rw; hw = r;
            reset = 0x0;
        } core_hpm_srst_req[27:27];
        field {
            name = "core_hpm_monitor_en";
            desc = "Core HPM cyclic monitoring enable
- 0: one-time monitoring
- 1: cyclic monitoring";
            sw = rw; hw = r;
            reset = 0x0;
        } core_hpm_monitor_en[26:26];
        field {
            name = "reserved";
            desc = "Reserved";
            sw = rw; hw = r;
            reset = 0x0;
        } reserved_25_25[25:25];
        field {
            name = "core_hpm_en";
            desc = "Core HPM measurement enable
- 0: The value retains 0 before a process is started.
- 1: A frequency modulation process is started.";
            sw = rw; hw = r;
            reset = 0x0;
        } core_hpm_en[24:24];
        field {
            name = "reserved";
            desc = "Reserved";
            sw = w; hw = r;
            reset = 0x0;
        } reserved_23_22[23:22];
        field {
            name = "core_hpm_offset";
            desc = "Core HPM offset";
            sw = rw; hw = r;
            reset = 0x0;
        } core_hpm_offset[21:12];
        field {
            name = "reserved";
            desc = "Reserved";
            sw = r; hw = w;
            reset = 0x0;
        } reserved_11_10[11:10];
        field {
            name = "core_hpm_shift";
            desc = "Core HPM shift";
            sw = rw; hw = r;
            reset = 0x0;
        } core_hpm_shift[9:8];
        field {
            name = "reserved";
            desc = "Reserved";
            sw = r; hw = w;
            reset = 0x0;
        } reserved_7_6[7:6];
        field {
            name = "core_hpm_div";
            desc = "Divider of the core HPM reference clock n: (n + 1) frequency division (n must be greater than 0.)";
            sw = rw; hw = r;
            reset = 0xa;
        } core_hpm_div[5:0];
    } PERI_PMC10 @ 0x28;
    reg {
        name = "PERI_PMC11";
        desc = "PERI_PMC11 is core HPM status register 1. (offset 0x2C; total reset 0x00000000; PROVEN: Hi3536D V100 data sheet (Issue 00B04, 2017-12-13), section 3.11.4, PDF page 241).";
        field {
            name = "reserved";
            desc = "Reserved";
            sw = r; hw = w;
            reset = 0x0;
        } reserved_31_26[31:26];
        field {
            name = "core_hpm_up_warning";
            desc = "Core HPM overflow alarm, active high";
            sw = r; hw = w;
            reset = 0x0;
        } core_hpm_up_warning[25:25];
        field {
            name = "core_hpm_low_warning";
            desc = "Core HPM underflow alarm, active high";
            sw = r; hw = w;
            reset = 0x0;
        } core_hpm_low_warning[24:24];
        field {
            name = "reserved";
            desc = "Reserved";
            sw = r; hw = w;
            reset = 0x0;
        } reserved_23_22[23:22];
        field {
            name = "core_hpm_pc_record1";
            desc = "Core HPM original code pattern 1";
            sw = r; hw = w;
            reset = 0x0;
        } core_hpm_pc_record1[21:12];
        field {
            name = "reserved";
            desc = "Reserved";
            sw = r; hw = w;
            reset = 0x0;
        } reserved_11_11[11:11];
        field {
            name = "core_hpm_pc_valid";
            desc = "Core HPM output validity indicator
- 0: invalid
- 1: valid";
            sw = r; hw = w;
            reset = 0x0;
        } core_hpm_pc_valid[10:10];
        field {
            name = "core_hpm_pc_record0";
            desc = "Core HPM original code pattern 0";
            sw = r; hw = w;
            reset = 0x0;
        } core_hpm_pc_record0[9:0];
    } PERI_PMC11 @ 0x2C;
    reg {
        name = "PERI_PMC12";
        desc = "PERI_PMC12 is core HPM status register 2. (offset 0x30; total reset 0x00000000; PROVEN: Hi3536D V100 data sheet (Issue 00B04, 2017-12-13), section 3.11.4, PDF page 242).";
        field {
            name = "reserved";
            desc = "Reserved";
            sw = r; hw = w;
            reset = 0x0;
        } reserved_31_29[31:29];
        field {
            name = "core_hpm_rcc";
            desc = "Core HPM output with the RCC code";
            sw = r; hw = w;
            reset = 0x0;
        } core_hpm_rcc[28:24];
        field {
            name = "reserved";
            desc = "Reserved";
            sw = r; hw = w;
            reset = 0x0;
        } reserved_23_22[23:22];
        field {
            name = "core_hpm_pc_record3";
            desc = "Core HPM original code pattern 3";
            sw = r; hw = w;
            reset = 0x0;
        } core_hpm_pc_record3[21:12];
        field {
            name = "reserved";
            desc = "Reserved";
            sw = r; hw = w;
            reset = 0x0;
        } reserved_11_10[11:10];
        field {
            name = "core_hpm_pc_record2";
            desc = "Core HPM original code pattern 2";
            sw = r; hw = w;
            reset = 0x0;
        } core_hpm_pc_record2[9:0];
    } PERI_PMC12 @ 0x30;
    reg {
        name = "PERI_PMC13";
        desc = "PERI_PMC13 is core HPM control register 3. (offset 0x34; total reset 0x01000000; PROVEN: Hi3536D V100 data sheet (Issue 00B04, 2017-12-13), section 3.11.4, PDF page 242).";
        field {
            name = "core_hpm_monitor_period";
            desc = "Core HPM cyclic monitoring period If the configured value is N, the monitoring period (T) is as follows: T = N x 2048/1000 ms The maximum monitoring interval is 522 ms, and the minimum interval is 2 ms.";
            sw = rw; hw = r;
            reset = 0x1;
        } core_hpm_monitor_period[31:24];
        field {
            name = "reserved";
            desc = "Reserved";
            sw = r; hw = w;
            reset = 0x0;
        } reserved_23_22[23:22];
        field {
            name = "core_hpm_lowlimit";
            desc = "Core HPM lower limit";
            sw = rw; hw = r;
            reset = 0x0;
        } core_hpm_lowlimit[21:12];
        field {
            name = "reserved";
            desc = "Reserved";
            sw = r; hw = w;
            reset = 0x0;
        } reserved_11_10[11:10];
        field {
            name = "core_hpm_uplimit";
            desc = "Core HPM upper limit";
            sw = rw; hw = r;
            reset = 0x0;
        } core_hpm_uplimit[9:0];
    } PERI_PMC13 @ 0x34;
    reg {
        name = "PERI_PMC14";
        desc = "PERI_PMC14 is CPU HPM control register 0. (offset 0x38; total reset 0x0000000A; PROVEN: Hi3536D V100 data sheet (Issue 00B04, 2017-12-13), section 3.11.4, PDF page 243).";
        field {
            name = "reserved";
            desc = "Reserved";
            sw = r; hw = w;
            reset = 0x0;
        } reserved_31_28[31:28];
        field {
            name = "cpu_hpm_srst_req";
            desc = "CPU HPM reset request, active high
- 0: deassert reset
- 1: reset";
            sw = rw; hw = r;
            reset = 0x0;
        } cpu_hpm_srst_req[27:27];
        field {
            name = "cpu_hpm_monitor_en";
            desc = "CPU HPM cyclic monitoring enable
- 0: one-time monitoring
- 1: cyclic monitoring";
            sw = rw; hw = r;
            reset = 0x0;
        } cpu_hpm_monitor_en[26:26];
        field {
            name = "reserved";
            desc = "Reserved";
            sw = rw; hw = r;
            reset = 0x0;
        } reserved_25_25[25:25];
        field {
            name = "cpu_hpm_en";
            desc = "CPU HPM measurement enable
- 0: The value retains 0 before a process is started.
- 1: A frequency measurement process is started.";
            sw = rw; hw = r;
            reset = 0x0;
        } cpu_hpm_en[24:24];
        field {
            name = "reserved";
            desc = "Reserved";
            sw = r; hw = w;
            reset = 0x0;
        } reserved_23_22[23:22];
        field {
            name = "cpu_hpm_offset";
            desc = "CPU HPM offset";
            sw = rw; hw = r;
            reset = 0x0;
        } cpu_hpm_offset[21:12];
        field {
            name = "reserved";
            desc = "Reserved";
            sw = r; hw = w;
            reset = 0x0;
        } reserved_11_10[11:10];
        field {
            name = "cpu_hpm_shift";
            desc = "CPU HPM shift";
            sw = rw; hw = r;
            reset = 0x0;
        } cpu_hpm_shift[9:8];
        field {
            name = "reserved";
            desc = "Reserved";
            sw = rw; hw = r;
            reset = 0x0;
        } reserved_7_6[7:6];
        field {
            name = "cpu_hpm_div";
            desc = "Divider of the CPU HPM reference clock n: (n + 1) frequency division (n must be greater than 0.)";
            sw = rw; hw = r;
            reset = 0xa;
        } cpu_hpm_div[5:0];
    } PERI_PMC14 @ 0x38;
    reg {
        name = "PERI_PMC15";
        desc = "PERI_PMC15 is CPU HPM status register 1. (offset 0x3C; total reset 0x00000000; PROVEN: Hi3536D V100 data sheet (Issue 00B04, 2017-12-13), section 3.11.4, PDF page 244).";
        field {
            name = "reserved";
            desc = "Reserved";
            sw = r; hw = w;
            reset = 0x0;
        } reserved_31_26[31:26];
        field {
            name = "cpu_hpm_up_warning";
            desc = "CPU HPM overflow alarm, active high";
            sw = r; hw = w;
            reset = 0x0;
        } cpu_hpm_up_warning[25:25];
        field {
            name = "cpu_hpm_low_warning";
            desc = "CPU HPM underflow alarm, active high";
            sw = r; hw = w;
            reset = 0x0;
        } cpu_hpm_low_warning[24:24];
        field {
            name = "reserved";
            desc = "Reserved";
            sw = r; hw = w;
            reset = 0x0;
        } reserved_23_22[23:22];
        field {
            name = "cpu_hpm_pc_record1";
            desc = "CPU HPM original code pattern 1";
            sw = r; hw = w;
            reset = 0x0;
        } cpu_hpm_pc_record1[21:12];
        field {
            name = "reserved";
            desc = "Reserved";
            sw = r; hw = w;
            reset = 0x0;
        } reserved_11_11[11:11];
        field {
            name = "cpu_hpm_pc_valid";
            desc = "CPU HPM output validity indicator
- 0: invalid
- 1: valid";
            sw = r; hw = w;
            reset = 0x0;
        } cpu_hpm_pc_valid[10:10];
        field {
            name = "cpu_hpm_pc_record0";
            desc = "CPU HPM original code pattern 0";
            sw = r; hw = w;
            reset = 0x0;
        } cpu_hpm_pc_record0[9:0];
    } PERI_PMC15 @ 0x3C;
    reg {
        name = "PERI_PMC16";
        desc = "PERI_PMC16 is CPU HPM status register 2. (offset 0x40; total reset 0x00000000; PROVEN: Hi3536D V100 data sheet (Issue 00B04, 2017-12-13), section 3.11.4, PDF page 245).";
        field {
            name = "reserved";
            desc = "Reserved";
            sw = r; hw = w;
            reset = 0x0;
        } reserved_31_29[31:29];
        field {
            name = "cpu_hpm_rcc";
            desc = "CPU HPM output with the RCC code";
            sw = r; hw = w;
            reset = 0x0;
        } cpu_hpm_rcc[28:24];
        field {
            name = "reserved";
            desc = "Reserved";
            sw = r; hw = w;
            reset = 0x0;
        } reserved_23_22[23:22];
        field {
            name = "cpu_hpm_pc_record3";
            desc = "CPU HPM original code pattern 3";
            sw = r; hw = w;
            reset = 0x0;
        } cpu_hpm_pc_record3[21:12];
        field {
            name = "reserved";
            desc = "Reserved";
            sw = r; hw = w;
            reset = 0x0;
        } reserved_11_10[11:10];
        field {
            name = "cpu_hpm_pc_record2";
            desc = "CPU HPM original code pattern 2";
            sw = r; hw = w;
            reset = 0x0;
        } cpu_hpm_pc_record2[9:0];
    } PERI_PMC16 @ 0x40;
    reg {
        name = "PERI_PMC17";
        desc = "PERI_PMC17 is CPU HPM control register 3. (offset 0x44; total reset 0x01000000; PROVEN: Hi3536D V100 data sheet (Issue 00B04, 2017-12-13), section 3.11.4, PDF page 245).";
        field {
            name = "cpu_hpm_monitor_period";
            desc = "CPU HPM cyclic monitoring period If the configured value is N, the monitoring period (T) is as follows: T = N x 2048/1000 ms The maximum monitoring interval is 522 ms, and the minimum interval is 2 ms.";
            sw = rw; hw = r;
            reset = 0x1;
        } cpu_hpm_monitor_period[31:24];
        field {
            name = "reserved";
            desc = "Reserved";
            sw = r; hw = w;
            reset = 0x0;
        } reserved_23_22[23:22];
        field {
            name = "cpu_hpm_lowlimit";
            desc = "CPU HPM lower limit";
            sw = rw; hw = r;
            reset = 0x0;
        } cpu_hpm_lowlimit[21:12];
        field {
            name = "reserved";
            desc = "Reserved";
            sw = r; hw = w;
            reset = 0x0;
        } reserved_11_10[11:10];
        field {
            name = "cpu_hpm_uplimit";
            desc = "CPU HPM upper limit";
            sw = rw; hw = r;
            reset = 0x0;
        } cpu_hpm_uplimit[9:0];
    } PERI_PMC17 @ 0x44;
    reg {
        name = "PERI_PMC30";
        desc = "PERI_PMC30 is HPM monitoring fine-tuning control register 1. (offset 0x78; total reset 0x00000000; PROVEN: Hi3536D V100 data sheet (Issue 00B04, 2017-12-13), section 3.11.4, PDF page 246).";
        field {
            name = "cpu_hpm_monitor_period_fine";
            desc = "Parameter for fine-tuning the CPU HPM cyclic monitoring cycle";
            sw = rw; hw = r;
            reset = 0x0;
        } cpu_hpm_monitor_period_fine[31:24];
        field {
            name = "reserved";
            desc = "Reserved";
            sw = rw; hw = r;
            reset = 0x0;
        } reserved_23_8[23:8];
        field {
            name = "reserved";
            desc = "Reserved";
            sw = r; hw = w;
            reset = 0x0;
        } reserved_7_0[7:0];
    } PERI_PMC30 @ 0x78;
    reg {
        name = "PERI_PMC31";
        desc = "PERI_PMC31 is HPM monitoring fine-tuning control register 2. (offset 0x7C; total reset 0x00000000; PROVEN: Hi3536D V100 data sheet (Issue 00B04, 2017-12-13), section 3.11.4, PDF page 246).";
        field {
            name = "reserved";
            desc = "Reserved";
            sw = r; hw = w;
            reset = 0x0;
        } reserved_31_8[31:8];
        field {
            name = "core_hpm_monitor_period";
            desc = "Parameter for fine-tuning the core HPM cyclic monitoring cycle";
            sw = rw; hw = r;
            reset = 0x0;
        } core_hpm_monitor_period[7:0];
    } PERI_PMC31 @ 0x7C;
    reg {
        name = "PERI_PMC68";
        desc = "PERI_PMC68 is a Tsensor control register. (offset 0x110; total reset 0x00000000; PROVEN: Hi3536D V100 data sheet (Issue 00B04, 2017-12-13), section 3.11.4, PDF page 247).";
        field {
            name = "reserved";
            desc = "Reserved";
            sw = r; hw = w;
            reset = 0x0;
        } reserved_31_31[31:31];
        field {
            name = "tsensor_en";
            desc = "Temperature sensor enable
- 0: disabled
- 1: enabled";
            sw = rw; hw = r;
            reset = 0x0;
        } tsensor_en[30:30];
        field {
            name = "tsensor_monitor_en";
            desc = "Cyclic temperature monitoring enable
- 0: disabled
- 1: enabled";
            sw = rw; hw = r;
            reset = 0x0;
        } tsensor_monitor_en[29:29];
        field {
            name = "reserved";
            desc = "Reserved";
            sw = r; hw = w;
            reset = 0x0;
        } reserved_28_24[28:24];
        field {
            name = "tsensor_monitor_period";
            desc = "Cyclic temperature monitoring cycle. The timing reference is 2 ms.";
            sw = rw; hw = r;
            reset = 0x0;
        } tsensor_monitor_period[23:16];
        field {
            name = "reserved";
            desc = "Reserved";
            sw = r; hw = w;
            reset = 0x0;
        } reserved_15_0[15:0];
    } PERI_PMC68 @ 0x110;
    reg {
        name = "PERI_PMC69";
        desc = "PERI_PMC69 is a Tsensor overflow/underflow configuration register. (offset 0x114; total reset 0x00000000; PROVEN: Hi3536D V100 data sheet (Issue 00B04, 2017-12-13), section 3.11.4, PDF page 247).";
        field {
            name = "reserved";
            desc = "Reserved";
            sw = rw; hw = r;
            reset = 0x0;
        } reserved_31_26[31:26];
        field {
            name = "tsensor_temp_uplimit";
            desc = "Temperature overflow value";
            sw = rw; hw = r;
            reset = 0x0;
        } tsensor_temp_uplimit[25:16];
        field {
            name = "reserved";
            desc = "Reserved";
            sw = rw; hw = r;
            reset = 0x0;
        } reserved_15_10[15:10];
        field {
            name = "tsensor_temp_lowlimit";
            desc = "Temperature underflow value";
            sw = rw; hw = r;
            reset = 0x0;
        } tsensor_temp_lowlimit[9:0];
    } PERI_PMC69 @ 0x114;
    reg {
        name = "PERI_PMC70";
        desc = "PERI_PMC70 is a Tsensor measurement value 0/1 register. (offset 0x118; total reset 0x00000000; PROVEN: Hi3536D V100 data sheet (Issue 00B04, 2017-12-13), section 3.11.4, PDF page 248).";
        field {
            name = "reserved";
            desc = "Reserved";
            sw = r; hw = w;
            reset = 0x0;
        } reserved_31_26[31:26];
        field {
            name = "tsensor_temp_code1";
            desc = "Temperature record value 1";
            sw = r; hw = w;
            reset = 0x0;
        } tsensor_temp_code1[25:16];
        field {
            name = "reserved";
            desc = "Reserved";
            sw = r; hw = w;
            reset = 0x0;
        } reserved_15_10[15:10];
        field {
            name = "tsensor_temp_code0";
            desc = "Temperature record value 0";
            sw = r; hw = w;
            reset = 0x0;
        } tsensor_temp_code0[9:0];
    } PERI_PMC70 @ 0x118;
    reg {
        name = "PERI_PMC71";
        desc = "PERI_PMC71 is a Tsensor measurement value 2/3 register. (offset 0x11C; total reset 0x00000000; PROVEN: Hi3536D V100 data sheet (Issue 00B04, 2017-12-13), section 3.11.4, PDF page 248).";
        field {
            name = "reserved";
            desc = "Reserved";
            sw = r; hw = w;
            reset = 0x0;
        } reserved_31_26[31:26];
        field {
            name = "tsensor_temp_code3";
            desc = "Temperature record value 3";
            sw = r; hw = w;
            reset = 0x0;
        } tsensor_temp_code3[25:16];
        field {
            name = "reserved";
            desc = "Reserved";
            sw = r; hw = w;
            reset = 0x0;
        } reserved_15_10[15:10];
        field {
            name = "tsensor_temp_code2";
            desc = "Temperature record value 2";
            sw = r; hw = w;
            reset = 0x0;
        } tsensor_temp_code2[9:0];
    } PERI_PMC71 @ 0x11C;
    reg {
        name = "PERI_PMC72";
        desc = "PERI_PMC72 is a Tsensor measurement value 4/5 register. (offset 0x120; total reset 0x00000000; PROVEN: Hi3536D V100 data sheet (Issue 00B04, 2017-12-13), section 3.11.4, PDF page 249).";
        field {
            name = "reserved";
            desc = "Reserved";
            sw = r; hw = w;
            reset = 0x0;
        } reserved_31_26[31:26];
        field {
            name = "tsensor_temp_code5";
            desc = "Temperature record value 5";
            sw = r; hw = w;
            reset = 0x0;
        } tsensor_temp_code5[25:16];
        field {
            name = "reserved";
            desc = "Reserved";
            sw = r; hw = w;
            reset = 0x0;
        } reserved_15_10[15:10];
        field {
            name = "tsensor_temp_code4";
            desc = "Temperature record value 4";
            sw = r; hw = w;
            reset = 0x0;
        } tsensor_temp_code4[9:0];
    } PERI_PMC72 @ 0x120;
    reg {
        name = "PERI_PMC73";
        desc = "PERI_PMC73 is a Tsensor measurement value 6/7 register. (offset 0x124; total reset 0x00000000; PROVEN: Hi3536D V100 data sheet (Issue 00B04, 2017-12-13), section 3.11.4, PDF page 249).";
        field {
            name = "reserved";
            desc = "Reserved";
            sw = r; hw = w;
            reset = 0x0;
        } reserved_31_26[31:26];
        field {
            name = "tsensor_temp_code7";
            desc = "Temperature record value 7";
            sw = r; hw = w;
            reset = 0x0;
        } tsensor_temp_code7[25:16];
        field {
            name = "reserved";
            desc = "Reserved";
            sw = r; hw = w;
            reset = 0x0;
        } reserved_15_10[15:10];
        field {
            name = "tsensor_temp_code6";
            desc = "Temperature record value 6";
            sw = r; hw = w;
            reset = 0x0;
        } tsensor_temp_code6[9:0];
    } PERI_PMC73 @ 0x124;
    reg {
        name = "PERI_PMC74";
        desc = "PERI_PMC74 is a Tsensor overflow/underflow alarm flag register. (offset 0x128; total reset 0x00000000; PROVEN: Hi3536D V100 data sheet (Issue 00B04, 2017-12-13), section 3.11.4, PDF page 250).";
        field {
            name = "reserved";
            desc = "Reserved";
            sw = r; hw = w;
            reset = 0x0;
        } reserved_31_2[31:2];
        field {
            name = "tsensor_low_warning";
            desc = "Temperature underflow alarm flag, active high";
            sw = r; hw = w;
            reset = 0x0;
        } tsensor_low_warning[1:1];
        field {
            name = "tsensor_up_warning";
            desc = "Temperature overflow alarm flag, active high";
            sw = r; hw = w;
            reset = 0x0;
        } tsensor_up_warning[0:0];
    } PERI_PMC74 @ 0x128;
};
`endif
