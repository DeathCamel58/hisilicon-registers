`ifndef HI3536D_MISC_CTRL_RDL
`define HI3536D_MISC_CTRL_RDL
regfile eHI3536D_MISC_CTRL {
    name = "Peripheral control (MISC) incl. USB 2.0 PHY and FE PHY trim, Hi3536D V100";
    desc = "Peripheral control (MISC) incl. USB 2.0 PHY and FE PHY trim, Hi3536D V100 of the Hi3536D V100 at base 0x1212_0000. 16 registers extracted programmatically from the Hi3536D V100 data sheet (Issue 00B04, 2017-12-13) (Table 3-10 Summary of peripheral control registers (base address: 0x1212_0000)): register headings, offsets, total reset values, field bit ranges, access types, names, reset values and descriptions, with PDF page numbers in each register description. Field names, bit ranges, access types and offsets are exact; the free-text descriptions are taken from the cell text of the field table and were checked by sampling only. Hardware not verified.";
    reg {
        name = "MISC_CTRL2";
        desc = "MISC_CTRL2 is peripheral function selection register 0. (offset 0x8; total reset 0x000033C0; PROVEN: Hi3536D V100 data sheet (Issue 00B04, 2017-12-13), section 3.5.5.2, PDF page 129).";
        field {
            name = "reserved";
            desc = "Reserved";
            sw = rw; hw = r;
            reset = 0x3;
        } reserved_31_12[31:12];
        field {
            name = "rom_pgen";
            desc = "System ROM power supply enable
- 0: enabled
- 1: disabled";
            sw = rw; hw = r;
            reset = 0x0;
        } rom_pgen[11:11];
        field {
            name = "jtag_sel";
            desc = "JTAG interface selection
- 0: CPU
- 1: DDRC";
            sw = rw; hw = r;
            reset = 0x0;
        } jtag_sel[10:10];
        field {
            name = "reserved";
            desc = "Reserved";
            sw = rw; hw = r;
            reset = 0x3;
        } reserved_9_8[9:8];
        field {
            name = "vgs_bootram_mode";
            desc = "VGS RAM working mode
- 1: BOOTRAM function
- 0: VGS function

Vendor code (PROVEN, static: hi3536dv100_sys.ko SYS_HAL_VgsClkEn, called when the VGS clock is enabled): the bit is CLEARED together with the clock enable, so the VGS only works with the bit at 0 (INFERRED: the VGS RAM is the boot RAM while it is 1; the effect has not been observed on hardware). BOARD run 3 2026-11-24: with the bit LEFT SET during a job (register level, and through the driver with the bit set again after every power-up) the job is accepted and the interrupt comes at once (INT_STATUS 0x01, NODE_ID 0, 0.0 ms) but the output is ALL ZEROES (copy, 5:4 scaling and 90 degree rotation of the kit; every 1080p job of the driver run: 4.8 dB against the model): the block only works with the bit 0 [PROVEN]. The reset value is 1. BOARD 2026-11-23 (NBD80XXS): MISC_CTRL2 reads 0x000030C0 at a Linux boot (bit 7 = 1, the reset value, not changed by the stock U-Boot or the kernel), reads 0x00003040 after the clear and all VGS jobs ran with the bit at 0; whether a job fails with the bit at 1 was NOT tried (the kit always clears it).";
            sw = rw; hw = r;
            reset = 0x1;
        } vgs_bootram_mode[7:7];
        field {
            name = "reserved";
            desc = "Reserved";
            sw = r; hw = w;
            reset = 0x40;
        } reserved_6_0[6:0];
    } MISC_CTRL2 @ 0x8;
    reg {
        name = "MISC_CTRL20";
        desc = "MISC_CTRL20 is USB 2.0 control register 0. (offset 0x50; total reset 0x000C33E0; PROVEN: Hi3536D V100 data sheet (Issue 00B04, 2017-12-13), section 3.5.5.2, PDF page 130).";
        field {
            name = "reserved";
            desc = "Reserved";
            sw = r; hw = w;
            reset = 0x0;
        } reserved_31_28[31:28];
        field {
            name = "usb_r_tuning";
            desc = "Tuning value of USB PHY internal resister";
            sw = r; hw = w;
            reset = 0x0;
        } usb_r_tuning[27:23];
        field {
            name = "reserved";
            desc = "Reserved";
            sw = r; hw = w;
            reset = 0x0;
        } reserved_22_21[22:21];
        field {
            name = "usb2_host_pwr_merge";
            desc = "Enable bit controlling whether two USB ports use the same power enable signal.
- 0: disabled
- 1: enabled";
            sw = rw; hw = r;
            reset = 0x0;
        } usb2_host_pwr_merge[20:20];
        field {
            name = "reserved";
            desc = "Reserved";
            sw = rw; hw = r;
            reset = 0x1;
        } reserved_19_19[19:19];
        field {
            name = "usb2_host_pwren_pol";
            desc = "Power enable polarity control for the USB port
- 0: active low
- 1: active high";
            sw = rw; hw = r;
            reset = 0x1;
        } usb2_host_pwren_pol[18:18];
        field {
            name = "reserved";
            desc = "Reserved";
            sw = r; hw = w;
            reset = 0x0;
        } reserved_17_14[17:14];
        field {
            name = "usb2_host_p1_pwr_en";
            desc = "Power shutdown control for the USB port 1
- 0: The power is shut down.
- 1: The output power of the USB controller is turned on.";
            sw = rw; hw = r;
            reset = 0x1;
        } usb2_host_p1_pwr_en[13:13];
        field {
            name = "usb2_host_p0_pwr_en";
            desc = "Power shutdown control for the USB 2.0 port 0
- 0: The power is shut down.
- 1: The output power of the USB 2.0 controller is turned on.";
            sw = rw; hw = r;
            reset = 0x1;
        } usb2_host_p0_pwr_en[12:12];
        field {
            name = "reserved";
            desc = "Reserved";
            sw = r; hw = w;
            reset = 0x0;
        } reserved_11_10[11:10];
        field {
            name = "usb2_host_ena_incr16";
            desc = "USB 2.0 controller burst16 enable
- 0: disabled
- 1: enabled";
            sw = rw; hw = r;
            reset = 0x1;
        } usb2_host_ena_incr16[9:9];
        field {
            name = "usb2_host_ena_incr8";
            desc = "USB 2.0 controller burst8 enable
- 0: disabled
- 1: enabled";
            sw = rw; hw = r;
            reset = 0x1;
        } usb2_host_ena_incr8[8:8];
        field {
            name = "usb2_host_ena_incr4";
            desc = "USB 2.0 controller burst4 enable
- 0: disabled
- 1: enabled";
            sw = rw; hw = r;
            reset = 0x1;
        } usb2_host_ena_incr4[7:7];
        field {
            name = "usb2_host_ena_incrx_align";
            desc = "USB 2.0 controller burst alignment enable
- 0: disabled
- 1: enabled";
            sw = rw; hw = r;
            reset = 0x1;
        } usb2_host_ena_incrx_align[6:6];
        field {
            name = "reserved";
            desc = "Reserved";
            sw = r; hw = w;
            reset = 0x4;
        } reserved_5_3[5:3];
        field {
            name = "usb2_host_app_start_clk";
            desc = "USB 2.0 OHCI clock control signal
- 0: The OHCI works normal.
- 1: The OHCI clock is enabled in suspend mode.";
            sw = rw; hw = r;
            reset = 0x0;
        } usb2_host_app_start_clk[2:2];
        field {
            name = "usb2_host_ohci_susp_lgcy";
            desc = "Strap input signal when the USB 2.0 OHCI is suspended.";
            sw = rw; hw = r;
            reset = 0x0;
        } usb2_host_ohci_susp_lgcy[1:1];
        field {
            name = "usb2_host_word_if";
            desc = "Data bit width select signal of the USB 2.0 host UTMI
- 0: 8 bits
- 1: 16 bits";
            sw = rw; hw = r;
            reset = 0x0;
        } usb2_host_word_if[0:0];
    } MISC_CTRL20 @ 0x50;
    reg {
        name = "MISC_CTRL21";
        desc = "MISC_CTRL21 is USB 2.0 control register 1. (offset 0x54; total reset 0x00000000; PROVEN: Hi3536D V100 data sheet (Issue 00B04, 2017-12-13), section 3.5.5.2, PDF page 131).";
        field {
            name = "usb2_phy_test_rddReadata";
            desc = "data of the USB 2.0 PHY test register";
            sw = r; hw = w;
            reset = 0x0;
        } usb2_phy_test_rddReadata[31:24];
        field {
            name = "usb2_phy_test_rstn";
            desc = "Reset control for the USB 2.0 PHY test register
- 0: reset
- 1: not reset
(The vendor kernel never sets this bit; the vendor U-Boot writes 0x800000 and then 0xA0060C, so it is set when the kernel starts. Added 2026-11-22 from the data sheet text: the extraction had kept only [31:24].)";
            sw = rw; hw = r;
            reset = 0x0;
        } usb2_phy_test_rstn[23:23];
        field {
            name = "phy_test_reg_access";
            desc = "USB 2.0 PHY register access mode
- 0: register access mode (indirect: write enable, address and data fields below)
- 1: bus access mode (the PHY registers appear at offset 0x8000 of the MISC_CTRL block; the vendor kernel sets this bit before it writes the tuning registers)";
            sw = rw; hw = r;
            reset = 0x0;
        } phy_test_reg_access[22:22];
        field {
            name = "usb2_phy_test_wren";
            desc = "Read/write control for the USB 2.0 PHY test register (register access mode)
- 0: read enable
- 1: write enable";
            sw = rw; hw = r;
            reset = 0x0;
        } usb2_phy_test_wren[21:21];
        field {
            name = "reserved";
            desc = "Reserved";
            sw = r; hw = w;
            reset = 0x0;
        } reserved_20_19[20:19];
        field {
            name = "usb2_phy_test_addr";
            desc = "Address of the USB 2.0 PHY test register (register access mode; the vendor U-Boot writes address 0x006 with data 0x0C)";
            sw = rw; hw = r;
            reset = 0x0;
        } usb2_phy_test_addr[18:8];
        field {
            name = "usb2_phy_test_wrdata";
            desc = "Write data of the USB 2.0 PHY test register (register access mode)";
            sw = rw; hw = r;
            reset = 0x0;
        } usb2_phy_test_wrdata[7:0];
    } MISC_CTRL21 @ 0x54;
    reg {
        name = "MISC_CTRL24";
        desc = "MISC_CTRL24 is internal FE PHY control register 0 (offset 0x60; total reset 0x00000300; PROVEN: Hi3536D V100 data sheet (Issue 00B04, 2017-12-13), section 3.5.5.2, PDF page 132).";
        field {
            name = "reserved";
            desc = "Reserved";
            sw = r; hw = w;
            reset = 0x0;
        } reserved_31_22[31:22];
        field {
            name = "fun_fephy_mdio_io_test";
            desc = "Test mode control of the FE PHY MDIO and MDCKIO In this mode, the FE PHY is communicated by the MDIO and MDCK pins of the chip. Note: The patch mode and the I/O test mode do not take effect at the same time.";
            sw = rw; hw = r;
            reset = 0x0;
        } fun_fephy_mdio_io_test[21:21];
        field {
            name = "fun_fephy_patch_mdio_enb";
            desc = "mdio_enb output of the FE PHY in patch mode";
            sw = r; hw = w;
            reset = 0x0;
        } fun_fephy_patch_mdio_enb[20:20];
        field {
            name = "fun_fephy_patch_mdio_o";
            desc = "mdio_o output of the FE PHY in patch mode";
            sw = r; hw = w;
            reset = 0x0;
        } fun_fephy_patch_mdio_o[19:19];
        field {
            name = "fun_fephy_patch_mdio_i";
            desc = "mdio_i input of the FE PHY in patch mode";
            sw = rw; hw = r;
            reset = 0x0;
        } fun_fephy_patch_mdio_i[18:18];
        field {
            name = "fun_fephy_patch_mdck";
            desc = "mdck input of the FE PHY in patch mode";
            sw = rw; hw = r;
            reset = 0x0;
        } fun_fephy_patch_mdck[17:17];
        field {
            name = "fun_fephy_patch_en";
            desc = "FE PHY patch mode control
- 0: disabled
- 1: enabled

Note: The patch mode and the I/O test mode do not take effect at the same time.";
            sw = rw; hw = r;
            reset = 0x0;
        } fun_fephy_patch_en[16:16];
        field {
            name = "reserved";
            desc = "Reserved";
            sw = rw; hw = r;
            reset = 0x300;
        } reserved_15_0[15:0];
    } MISC_CTRL24 @ 0x60;
    reg {
        name = "MISC_CTRL25";
        desc = "MISC_CTRL25 is internal FE PHY control register 1. (offset 0x64; total reset 0x00000180; PROVEN: Hi3536D V100 data sheet (Issue 00B04, 2017-12-13), section 3.5.5.2, PDF page 133).";
        field {
            name = "keep_reserved0";
            desc = "Reserved";
            sw = rw; hw = r;
            reset = 0x0;
        } keep_reserved0[31:29];
        field {
            name = "reserved";
            desc = "Reserved";
            sw = r; hw = w;
            reset = 0x0;
        } reserved_28_12[28:12];
        field {
            name = "fephy_led_pol";
            desc = "FE PHY output LED on polarity control
- 0: active high
- 1: active low";
            sw = rw; hw = r;
            reset = 0x0;
        } fephy_led_pol[11:11];
        field {
            name = "fun_fephy_test_en";
            desc = "FEPHY testing mode control
- 0: disabled
- 1: enabled";
            sw = rw; hw = r;
            reset = 0x0;
        } fun_fephy_test_en[10:10];
        field {
            name = "fun_fephy_iddq_mode";
            desc = "FE PHY low-power mode control
- 0: disabled
- 1: enabled";
            sw = rw; hw = r;
            reset = 0x0;
        } fun_fephy_iddq_mode[9:9];
        field {
            name = "fun_fephy_rstn_ldo";
            desc = "FE PHY LDO reset control
- 0: reset
- 1: not reset";
            sw = rw; hw = r;
            reset = 0x1;
        } fun_fephy_rstn_ldo[8:8];
        field {
            name = "fun_fephy_en_ldo";
            desc = "FE PHY LDO output control
- 0: disabled
- 1: enabled";
            sw = rw; hw = r;
            reset = 0x1;
        } fun_fephy_en_ldo[7:7];
        field {
            name = "fun_fephy_enz_ldo";
            desc = "FE PHY LDO output high-resistance control
- 0: normal mode
- 1: high resistance";
            sw = rw; hw = r;
            reset = 0x0;
        } fun_fephy_enz_ldo[6:6];
        field {
            name = "fephy_io_sel";
            desc = "Selection of the FE PHY connected to the ETH
- 0: internal FE PHY
- 1: external FE PHY";
            sw = rw; hw = r;
            reset = 0x0;
        } fephy_io_sel[5:5];
        field {
            name = "fephy_addr";
            desc = "Internal FE PHY MDIO address configuration register";
            sw = rw; hw = r;
            reset = 0x0;
        } fephy_addr[4:0];
    } MISC_CTRL25 @ 0x64;
    reg {
        name = "MISC_CTRL30";
        desc = "MISC_CTRL30 is DDR write QoS control register 0. (offset 0x78; total reset 0x00000000; PROVEN: Hi3536D V100 data sheet (Issue 00B04, 2017-12-13), section 3.5.5.2, PDF page 134).";
        field {
            name = "jpgd_wqos";
            desc = "JPGD at DDRC write QoS set register";
            sw = rw; hw = r;
            reset = 0x0;
        } jpgd_wqos[31:28];
        field {
            name = "jpge_wqos";
            desc = "JPGE at DDRC write QoS set register";
            sw = rw; hw = r;
            reset = 0x0;
        } jpge_wqos[27:24];
        field {
            name = "tde_wqos";
            desc = "TDE at DDRC write QoS set register";
            sw = rw; hw = r;
            reset = 0x0;
        } tde_wqos[23:20];
        field {
            name = "vgs_wqos";
            desc = "VGS at DDRC write QoS set register";
            sw = rw; hw = r;
            reset = 0x0;
        } vgs_wqos[19:16];
        field {
            name = "vdh_wqos";
            desc = "VDH at DDRC write QoS set register";
            sw = rw; hw = r;
            reset = 0x0;
        } vdh_wqos[15:12];
        field {
            name = "cpu_wqos";
            desc = "CPU at DDRC write QoS set register";
            sw = rw; hw = r;
            reset = 0x0;
        } cpu_wqos[11:8];
        field {
            name = "vdp_wqos";
            desc = "VDP at DDRC write QoS set register";
            sw = rw; hw = r;
            reset = 0x0;
        } vdp_wqos[7:4];
        field {
            name = "aiao_wqos";
            desc = "AIAO at DDRC write QoS set register";
            sw = rw; hw = r;
            reset = 0x0;
        } aiao_wqos[3:0];
    } MISC_CTRL30 @ 0x78;
    reg {
        name = "MISC_CTRL31";
        desc = "MISC_CTRL31 is DDR write QoS control register 1. (offset 0x7C; total reset 0x00000000; PROVEN: Hi3536D V100 data sheet (Issue 00B04, 2017-12-13), section 3.5.5.2, PDF page 135).";
        field {
            name = "fmc_wqos";
            desc = "FMC at DDRC write QoS set register";
            sw = rw; hw = r;
            reset = 0x0;
        } fmc_wqos[31:28];
        field {
            name = "dma_m1_wqos";
            desc = "DMA_M1 at DDRC write QoS set register";
            sw = rw; hw = r;
            reset = 0x0;
        } dma_m1_wqos[27:24];
        field {
            name = "dma_m0_wqos";
            desc = "DMA_M2 at DDRC write QoS set register";
            sw = rw; hw = r;
            reset = 0x0;
        } dma_m0_wqos[23:20];
        field {
            name = "ddrt_wqos";
            desc = "DDRT at DDRC write QoS set register";
            sw = rw; hw = r;
            reset = 0x0;
        } ddrt_wqos[19:16];
        field {
            name = "sata_wqos";
            desc = "SATA at DDRC write QoS set register";
            sw = rw; hw = r;
            reset = 0x0;
        } sata_wqos[15:12];
        field {
            name = "reserved";
            desc = "Reserved";
            sw = rw; hw = r;
            reset = 0x0;
        } reserved_11_8[11:8];
        field {
            name = "eth_wqos";
            desc = "ETH at DDRC write QoS set register";
            sw = rw; hw = r;
            reset = 0x0;
        } eth_wqos[7:4];
        field {
            name = "reserved";
            desc = "Reserved";
            sw = r; hw = w;
            reset = 0x0;
        } reserved_3_0[3:0];
    } MISC_CTRL31 @ 0x7C;
    reg {
        name = "MISC_CTRL32";
        desc = "MISC_CTRL32 is DDR write QoS control register 2. (offset 0x80; total reset 0x00000000; PROVEN: Hi3536D V100 data sheet (Issue 00B04, 2017-12-13), section 3.5.5.2, PDF page 135).";
        field {
            name = "reserved";
            desc = "Reserved";
            sw = rw; hw = r;
            reset = 0x0;
        } reserved_31_8[31:8];
        field {
            name = "cipher_wqos";
            desc = "CIPHER at DDRC writes QoS setting";
            sw = rw; hw = r;
            reset = 0x0;
        } cipher_wqos[7:4];
        field {
            name = "usb_wqos";
            desc = "USB at DDRC writes QoS setting";
            sw = rw; hw = r;
            reset = 0x0;
        } usb_wqos[3:0];
    } MISC_CTRL32 @ 0x80;
    reg {
        name = "MISC_CTRL33";
        desc = "MISC_CTRL33 is DDR read QoS control register 0. (offset 0x84; total reset 0x00000000; PROVEN: Hi3536D V100 data sheet (Issue 00B04, 2017-12-13), section 3.5.5.2, PDF page 136).";
        field {
            name = "jpgd_rqos";
            desc = "JPGD at DDRC read QoS set register";
            sw = rw; hw = r;
            reset = 0x0;
        } jpgd_rqos[31:28];
        field {
            name = "jpge_rqos";
            desc = "JPGE at DDRC read QoS set register";
            sw = rw; hw = r;
            reset = 0x0;
        } jpge_rqos[27:24];
        field {
            name = "tde_rqos";
            desc = "TDE at DDRC read QoS set register";
            sw = rw; hw = r;
            reset = 0x0;
        } tde_rqos[23:20];
        field {
            name = "vgs_rqos";
            desc = "VGS at DDRC read QoS set register";
            sw = rw; hw = r;
            reset = 0x0;
        } vgs_rqos[19:16];
        field {
            name = "vdh_rqos";
            desc = "VDH at DDRC read QoS set register";
            sw = rw; hw = r;
            reset = 0x0;
        } vdh_rqos[15:12];
        field {
            name = "cpu_rqos";
            desc = "CPU at DDRC read QoS set register";
            sw = rw; hw = r;
            reset = 0x0;
        } cpu_rqos[11:8];
        field {
            name = "vdp_rqos";
            desc = "VDP at DDRC read QoS set register";
            sw = rw; hw = r;
            reset = 0x0;
        } vdp_rqos[7:4];
        field {
            name = "aiao_rqos";
            desc = "AIAO at DDRC read QoS set register";
            sw = rw; hw = r;
            reset = 0x0;
        } aiao_rqos[3:0];
    } MISC_CTRL33 @ 0x84;
    reg {
        name = "MISC_CTRL34";
        desc = "MISC_CTRL34 is DDR read QoS control register 1. (offset 0x88; total reset 0x00000000; PROVEN: Hi3536D V100 data sheet (Issue 00B04, 2017-12-13), section 3.5.5.2, PDF page 136).";
        field {
            name = "fmc_rqos";
            desc = "FMC at DDRC read QoS set register";
            sw = rw; hw = r;
            reset = 0x0;
        } fmc_rqos[31:28];
        field {
            name = "dma_m1_rqos";
            desc = "DMA_M1 at DDRC read QoS set register";
            sw = rw; hw = r;
            reset = 0x0;
        } dma_m1_rqos[27:24];
        field {
            name = "dma_m0_rqos";
            desc = "DMA_at DDRC read QoS set register";
            sw = rw; hw = r;
            reset = 0x0;
        } dma_m0_rqos[23:20];
        field {
            name = "ddrt_rqos";
            desc = "DDRT at DDRC read QoS set register";
            sw = rw; hw = r;
            reset = 0x0;
        } ddrt_rqos[19:16];
        field {
            name = "sata_rqos";
            desc = "SATA at DDRC read QoS set register";
            sw = rw; hw = r;
            reset = 0x0;
        } sata_rqos[15:12];
        field {
            name = "reserved";
            desc = "Reserved";
            sw = rw; hw = r;
            reset = 0x0;
        } reserved_11_8[11:8];
        field {
            name = "eth_rqos";
            desc = "ETH at DDRC read QoS set register";
            sw = rw; hw = r;
            reset = 0x0;
        } eth_rqos[7:4];
        field {
            name = "reserved";
            desc = "Reserved";
            sw = r; hw = w;
            reset = 0x0;
        } reserved_3_0[3:0];
    } MISC_CTRL34 @ 0x88;
    reg {
        name = "MISC_CTRL35";
        desc = "MISC_CTRL35 is DDR read QoS control register 2. (offset 0x8C; total reset 0x00000000; PROVEN: Hi3536D V100 data sheet (Issue 00B04, 2017-12-13), section 3.5.5.2, PDF page 137).";
        field {
            name = "reserved";
            desc = "Reserved";
            sw = rw; hw = r;
            reset = 0x0;
        } reserved_31_8[31:8];
        field {
            name = "cipher_rqos";
            desc = "CIPHER at DDRC read QoS set register";
            sw = rw; hw = r;
            reset = 0x0;
        } cipher_rqos[7:4];
        field {
            name = "usb_rqos";
            desc = "USB at DDRC read QoS set register";
            sw = rw; hw = r;
            reset = 0x0;
        } usb_rqos[3:0];
    } MISC_CTRL35 @ 0x8C;
    reg {
        name = "FEPHY_TRIM";
        desc = "FEPHY_TRIM is an internal FE PHY adjustment parameter register. (offset 0x1000; total reset 0x00000000; PROVEN: Hi3536D V100 data sheet (Issue 00B04, 2017-12-13), section 3.5.5.2, PDF page 137).";
        field {
            name = "reserved";
            desc = "Reserved";
            sw = r; hw = w;
            reset = 0x0;
        } reserved_31_14[31:14];
        field {
            name = "fephy_r_tuning";
            desc = "Adjustment parameter 2 of the internal FE PHY";
            sw = r; hw = w;
            reset = 0x0;
        } fephy_r_tuning[13:8];
        field {
            name = "fephy_ldo_set";
            desc = "Adjustment parameter 1 of internal FEPHY";
            sw = r; hw = w;
            reset = 0x0;
        } fephy_ldo_set[7:5];
        field {
            name = "fephy_ld_set";
            desc = "Adjustment parameter 0 of internal FEPHY";
            sw = r; hw = w;
            reset = 0x0;
        } fephy_ld_set[4:0];
    } FEPHY_TRIM @ 0x1000;
    reg {
        name = "USB2_PHY0_PRE_EMPHASIS_EN";
        desc = "USB2_PHY0_PRE_EMPHASIS_EN is a USB 2.0 PHY0 pre-emphasis switch register. (offset 0x8000; total reset 0x00000019; PROVEN: Hi3536D V100 data sheet (Issue 00B04, 2017-12-13), section 11.6.5, PDF page 767).";
        field {
            name = "reserved";
            desc = "Reserved";
            sw = rw; hw = r;
            reset = 0x3;
        } reserved_31_3[31:3];
        field {
            name = "usb2_phy0_unchirp_emphasis_en";
            desc = "- 0: Disable the non-chirp pre-emphasis function.
- 1: Enable the non-chirp pre-emphasis function.";
            sw = rw; hw = r;
            reset = 0x0;
        } usb2_phy0_unchirp_emphasis_en[2:2];
        field {
            name = "usb2_phy0_chirp_pre_emphasis_en";
            desc = "- 0: Disable the chirp pre-emphasis function.
- 1: Enable the chirp pre-emphasis function.";
            sw = rw; hw = r;
            reset = 0x0;
        } usb2_phy0_chirp_pre_emphasis_en[1:1];
        field {
            name = "usb2_phy0_eop_pre_emphasis_en";
            desc = "- 0: Disable the end of packet (EOP) pre-emphasis function.
- 1: Enable the EOP pre-emphasis function.";
            sw = rw; hw = r;
            reset = 0x1;
        } usb2_phy0_eop_pre_emphasis_en[0:0];
    } USB2_PHY0_PRE_EMPHASIS_EN @ 0x8000;
    reg {
        name = "USB2_PHY0_RCOMP";
        desc = "USB2_PHY0_RCOMP is configuration register 0 for the USB 2.0 PHY0 amplitude. This register controls the reference voltage of the amplitude calibration (Rcomp). The larger the reference voltage value is, the greater the signal amplitude becomes. (offset 0x8008; total reset 0x0000000C; PROVEN: Hi3536D V100 data sheet (Issue 00B04, 2017-12-13), section 11.6.5, PDF page 768).";
        field {
            name = "reserved";
            desc = "Reserved";
            sw = rw; hw = r;
            reset = 0x0;
        } reserved_31_7[31:7];
        field {
            name = "usb2_phy0_rcomp";
            desc = "Adjustment of the eye pattern amplitude in HS mode
- 000: 400 mV
- 001: 362.5 mV
- 010: 350 mV
- 011: 387.5 mV
- 100: 412.5 mV
- 101: 425 mV
- 110: 475 mV
- 111: 450 mV";
            sw = rw; hw = r;
            reset = 0x0;
        } usb2_phy0_rcomp[6:4];
        field {
            name = "reserved";
            desc = "Reserved";
            sw = rw; hw = r;
            reset = 0xc;
        } reserved_3_0[3:0];
    } USB2_PHY0_RCOMP @ 0x8008;
    reg {
        name = "USB2_PHY1_PRE_EMPHASIS_EN";
        desc = "USB2_PHY1_PRE_EMPHASIS_EN is a USB 2.0 PHY1 pre-emphasis switch register. (offset 0x8400; total reset 0x00000019; PROVEN: Hi3536D V100 data sheet (Issue 00B04, 2017-12-13), section 11.6.5, PDF page 769).";
        field {
            name = "reserved";
            desc = "Reserved";
            sw = rw; hw = r;
            reset = 0x3;
        } reserved_31_3[31:3];
        field {
            name = "usb2_phy1_unchirp_emphasis_en";
            desc = "- 0: Disable the non-chirp pre-emphasis function.
- 1: Enable the non-chirp pre-emphasis function.";
            sw = rw; hw = r;
            reset = 0x0;
        } usb2_phy1_unchirp_emphasis_en[2:2];
        field {
            name = "usb2_phy1_chirp_pre_emphasis_en";
            desc = "- 0: Disable the chirp pre-emphasis function.
- 1: Enable the chirp pre-emphasis function.";
            sw = rw; hw = r;
            reset = 0x0;
        } usb2_phy1_chirp_pre_emphasis_en[1:1];
        field {
            name = "usb2_phy1_eop_pre_emphasis_en";
            desc = "- 0: Disable the EOP pre-emphasis function.
- 1: Enable the EOP pre-emphasis function.";
            sw = rw; hw = r;
            reset = 0x1;
        } usb2_phy1_eop_pre_emphasis_en[0:0];
    } USB2_PHY1_PRE_EMPHASIS_EN @ 0x8400;
    reg {
        name = "USB2_PHY1_RCOMP";
        desc = "USB2_PHY1_RCOMP is configuration register 0 for the USB 2.0 PHY1 amplitude This register controls the reference voltage of the amplitude calibration (Rcomp). The larger the reference voltage value is, the greater the signal amplitude becomes. (offset 0x8408; total reset 0x0000000C; PROVEN: Hi3536D V100 data sheet (Issue 00B04, 2017-12-13), section 11.6.5, PDF page 770).";
        field {
            name = "reserved";
            desc = "Reserved";
            sw = rw; hw = r;
            reset = 0x0;
        } reserved_31_7[31:7];
        field {
            name = "usb2_phy1_rcomp";
            desc = "Adjustment of the eye pattern amplitude in HS mode
- 000: 400 mV
- 001: 362.5 mV
- 010: 350 mV
- 011: 387.5 mV
- 100: 412.5 mV
- 101: 425 mV
- 110: 475 mV
- 111: 450 mV";
            sw = rw; hw = r;
            reset = 0x0;
        } usb2_phy1_rcomp[6:4];
        field {
            name = "reserved";
            desc = "Reserved";
            sw = rw; hw = r;
            reset = 0xc;
        } reserved_3_0[3:0];
    } USB2_PHY1_RCOMP @ 0x8408;
    reg {
        name = "AIO_VDP_AXI_TIMEOUT";
        desc = "AIO_VDP_AXI_TIMEOUT: DT comment aio_vdp_axi_timeout, value 0x80020000 (offset 0x90). Provenance: PROVEN offset and written value (vendor Linux 4.9 demo device tree node sysctrl-ddr,pins, device-trees-hisilicon openipc-branches hi3536dv100-demb); bit layout NOT in the data sheet; name is the vendor DT comment / a GUESS.";
        field { sw = rw; hw = r; } value[31:0];
    } AIO_VDP_AXI_TIMEOUT @ 0x90;
    reg {
        name = "AIO_VDP_AXI_PRI";
        desc = "AIO_VDP_AXI_PRI: DT comment aio_vdp_axi_pri, value 0x10 (offset 0x94). Provenance: PROVEN offset and written value (vendor Linux 4.9 demo device tree node sysctrl-ddr,pins, device-trees-hisilicon openipc-branches hi3536dv100-demb); bit layout NOT in the data sheet; name is the vendor DT comment / a GUESS.";
        field { sw = rw; hw = r; } value[31:0];
    } AIO_VDP_AXI_PRI @ 0x94;
};
`endif
