`ifndef HI3536D_MISC_CTRL_RDL
`define HI3536D_MISC_CTRL_RDL
regfile eHI3536D_MISC_CTRL {
    name = "Peripheral control (MISC) incl. USB 2.0 PHY and FE PHY trim, Hi3536D V100";
    desc = "Peripheral control (MISC) incl. USB 2.0 PHY and FE PHY trim of the Hi3536D V100 at base 0x12120000. 16 registers extracted programmatically from the Hi3536D V100 data sheet (Issue 00B04, 2017-12-13, Table 3-10 and Table 11-18), register descriptions and field tables; reset values are the data sheet total reset values split onto the fields. Source: dl/research-hi3536 ReleaseDoc (unofficial copy of the HiSilicon SDK documentation; facts only). Field names, bit ranges, access types and reset values are exact; the free-text descriptions are attributed to fields from the PDF text layout (title sentence above the bit row, enumerations below) and can be shifted by one field where a sentence wraps: check the data sheet page when a description matters. Hardware not yet verified (no Hi3536D board on the bench).";
    reg {
        name = "MISC_CTRL2";
        desc = "MISC_CTRL2 is peripheral function selection register 0. (offset 0x8, total reset 0x000033C0; PROVEN: Hi3536D V100 data sheet).";
        field {
            name = "reserved_31_12";
            desc = "Reserved";
            sw = r; hw = na;
            reset = 0x3;
        } reserved_31_12[31:12];
        field {
            name = "rom_pgen";
            desc = "System ROM power supply enable 0: enabled 1: disabled";
            sw = rw; hw = r;
            reset = 0x0;
        } rom_pgen[11:11];
        field {
            name = "jtag_sel";
            desc = "JTAG interface selection 0: CPU 1: DDRC";
            sw = rw; hw = r;
            reset = 0x0;
        } jtag_sel[10:10];
        field {
            name = "reserved_9_8";
            desc = "Reserved";
            sw = r; hw = na;
            reset = 0x3;
        } reserved_9_8[9:8];
        field {
            name = "vgs_bootram_mode";
            desc = "VGS RAM working mode 1: BOOTRAM function 0: VGS function";
            sw = rw; hw = r;
            reset = 0x1;
        } vgs_bootram_mode[7:7];
        field {
            name = "reserved_6_0";
            desc = "Reserved";
            sw = r; hw = na;
            reset = 0x40;
        } reserved_6_0[6:0];
    } MISC_CTRL2 @ 0x8;
    reg {
        name = "MISC_CTRL20";
        desc = "MISC_CTRL20 (offset 0x50, total reset 0x000C33E0; PROVEN: Hi3536D V100 data sheet).";
        field {
            name = "reserved_31_28";
            desc = "Reserved";
            sw = rw; hw = r;
            reset = 0x0;
        } reserved_31_28[31:28];
        field {
            name = "usb_r_tuning";
            desc = "Tuning value of USB PHY internal resister";
            sw = r; hw = w;
            reset = 0x0;
        } usb_r_tuning[27:23];
        field {
            name = "reserved_22_21";
            desc = "Reserved usb2_host_pwr_me enable signal. 1: enabled";
            sw = r; hw = w;
            reset = 0x0;
        } reserved_22_21[22:21];
        field {
            name = "reserved_19_19";
            desc = "Enable bit controlling whether two USB ports use the same power [20]                  RW rge                                                0: disabled Reserved usb2_host_pwren_";
            sw = r; hw = na;
            reset = 0x1;
        } reserved_19_19[19:19];
        field {
            name = "f_0_";
            desc = "Power enable polarity control for the USB port active low pol 1: active high";
            sw = rw; hw = r;
            reset = 0x1;
        } f_0_[18:18];
        field {
            name = "reserved_17_14";
            desc = "Reserved usb2_host_p1_pwr";
            sw = r; hw = w;
            reset = 0x0;
        } reserved_17_14[17:14];
        field {
            name = "f_0__13";
            desc = "Power shutdown control for the USB port 1 The power is shut down. 1: The output power of the USB controller is turned on.";
            sw = rw; hw = r;
            reset = 0x1;
        } f_0__13[13:13];
        field {
            name = "f_0__12";
            desc = "_en Power shutdown control for the USB 2.0 port 0 usb2_host_p0_pwr The power is shut down. 1: The output power of the USB 2.0 controller is turned on.";
            sw = rw; hw = r;
            reset = 0x1;
        } f_0__12[12:12];
        field {
            name = "reserved_11_10";
            desc = "_en Reserved usb2_host_ena_incr";
            sw = rw; hw = r;
            reset = 0x0;
        } reserved_11_10[11:10];
        field {
            name = "f_0__9";
            desc = "USB 2.0 controller burst16 enable disabled 16 1: enabled usb2_host_ena_incr";
            sw = rw; hw = r;
            reset = 0x1;
        } f_0__9[9:9];
        field {
            name = "f_0__8";
            desc = "USB 2.0 controller burst8 enable disabled 8 1: enabled usb2_host_ena_incr";
            sw = rw; hw = r;
            reset = 0x1;
        } f_0__8[8:8];
        field {
            name = "f_0__7";
            desc = "USB 2.0 controller burst4 enable disabled 4 1: enabled usb2_host_ena_incr";
            sw = rw; hw = r;
            reset = 0x1;
        } f_0__7[7:7];
        field {
            name = "f_0__6";
            desc = "USB 2.0 controller burst alignment enable disabled x_align 1: enabled";
            sw = rw; hw = r;
            reset = 0x1;
        } f_0__6[6:6];
        field {
            name = "reserved_5_3";
            desc = "Reserved usb2_host_app_star";
            sw = r; hw = na;
            reset = 0x4;
        } reserved_5_3[5:3];
        field {
            name = "f_0__2";
            desc = "USB 2.0 OHCI clock control signal The OHCI works normal. 1: The OHCI clock is enabled in suspend mode.";
            sw = rw; hw = r;
            reset = 0x0;
        } f_0__2[2:2];
        field {
            name = "Strap";
            desc = "t_clk usb2_host_ohci_su input signal when the USB 2.0 OHCI is suspended.";
            sw = rw; hw = r;
            reset = 0x0;
        } Strap[1:1];
        field {
            name = "usb2_host_word_if";
            desc = "sp_lgcy Data bit width select signal of the USB 2.0 host UTMI 0: 8 bits 1: 16 bits";
            sw = rw; hw = r;
            reset = 0x0;
        } usb2_host_word_if[0:0];
    } MISC_CTRL20 @ 0x50;
    reg {
        name = "MISC_CTRL21";
        desc = "MISC_CTRL21 is USB 2.0 control register 1. (offset 0x54, total reset 0x00000000; PROVEN: Hi3536D V100 data sheet).";
        field {
            name = "Read";
            desc = "usb2_phy_test_rdd data of the USB 2.0 PHY test register ata";
            sw = r; hw = w;
            reset = 0x0;
        } Read[31:24];
        field {
            name = "usb2_phy_test_rstn";
            desc = "0: reset 1: not reset phy_test_reg_acces";
            sw = rw; hw = r;
            reset = 0x0;
        } usb2_phy_test_rstn[23:23];
        field {
            name = "f_0_";
            desc = "USB 2.0 PHY register access mode register access mode s 1: bus access mode usb2_phy_test_wre";
            sw = rw; hw = r;
            reset = 0x0;
        } f_0_[22:22];
        field {
            name = "f_0__21";
            desc = "Read/Write control for the USB 2.0 PHY test register read enable n 1: write enable";
            sw = rw; hw = r;
            reset = 0x0;
        } f_0__21[21:21];
        field {
            name = "reserved_20_19";
            desc = "Reserved usb2_phy_test_add";
            sw = r; hw = w;
            reset = 0x0;
        } reserved_20_19[20:19];
        field {
            name = "Address";
            desc = "of the USB 2.0 PHY test register r usb2_phy_test_wrd";
            sw = rw; hw = r;
            reset = 0x0;
        } Address[18:8];
        field {
            name = "Write";
            desc = "data of the USB 2.0 PHY test register ata";
            sw = rw; hw = r;
            reset = 0x0;
        } Write[7:0];
    } MISC_CTRL21 @ 0x54;
    reg {
        name = "MISC_CTRL24";
        desc = "MISC_CTRL24 is internal FE PHY control register 0 (offset 0x60, total reset 0x00000300; PROVEN: Hi3536D V100 data sheet).";
        field {
            name = "reserved_31_22";
            desc = "Reserved fun_fephy_mdio_io MDCK pins of the chip.";
            sw = r; hw = w;
            reset = 0x0;
        } reserved_31_22[31:22];
        field {
            name = "mdio_enb";
            desc = "Test mode control of the FE PHY MDIO and MDCKIO In this mode, the FE PHY is communicated by the MDIO and [21]                        RW _test             Note: The patch mode and the I/O test mode do not take effect at the same time. fun_fephy_patch_ output of the FE PHY in patch mode mdio_enb fun_fephy_patch_";
            sw = r; hw = w;
            reset = 0x0;
        } mdio_enb[20:20];
        field {
            name = "mdio_o";
            desc = "output of the FE PHY in patch mode mdio_o fun_fephy_patch_";
            sw = r; hw = w;
            reset = 0x0;
        } mdio_o[19:19];
        field {
            name = "mdio_i";
            desc = "input of the FE PHY in patch mode mdio_i fun_fephy_patch_";
            sw = rw; hw = r;
            reset = 0x0;
        } mdio_i[18:18];
        field {
            name = "mdck";
            desc = "input of the FE PHY in patch mode mdck 0: disabled fun_fephy_patch_e 1: enabled [16]                        RW n                 Note: same time.";
            sw = rw; hw = r;
            reset = 0x0;
        } mdck[17:17];
        field {
            name = "reserved_15_0";
            desc = "FE PHY patch mode control The patch mode and the I/O test mode do not take effect at the Reserved";
            sw = r; hw = na;
            reset = 0x300;
        } reserved_15_0[15:0];
    } MISC_CTRL24 @ 0x60;
    reg {
        name = "MISC_CTRL25";
        desc = "MISC_CTRL25 is internal FE PHY control register 1. (offset 0x64, total reset 0x00000180; PROVEN: Hi3536D V100 data sheet).";
        field {
            name = "keep_reserved0";
            desc = "Reserved";
            sw = rw; hw = r;
            reset = 0x0;
        } keep_reserved0[31:29];
        field {
            name = "reserved_28_12";
            desc = "Reserved";
            sw = r; hw = w;
            reset = 0x0;
        } reserved_28_12[28:12];
        field {
            name = "fephy_led_pol";
            desc = "FE PHY output LED on polarity control 0: active high 1: active low";
            sw = rw; hw = r;
            reset = 0x0;
        } fephy_led_pol[11:11];
        field {
            name = "fun_fephy_test_en";
            desc = "FEPHY testing mode control 0: disabled 1: enabled fun_fephy_iddq_m";
            sw = rw; hw = r;
            reset = 0x0;
        } fun_fephy_test_en[10:10];
        field {
            name = "f_0_";
            desc = "FE PHY low-power mode control disabled ode 1: enabled";
            sw = rw; hw = r;
            reset = 0x0;
        } f_0_[9:9];
        field {
            name = "fun_fephy_rstn_ldo";
            desc = "FE PHY LDO reset control 0: reset 1: not reset";
            sw = rw; hw = r;
            reset = 0x1;
        } fun_fephy_rstn_ldo[8:8];
        field {
            name = "fun_fephy_en_ldo";
            desc = "FE PHY LDO output control 0: disabled 1: enabled";
            sw = rw; hw = r;
            reset = 0x1;
        } fun_fephy_en_ldo[7:7];
        field {
            name = "fun_fephy_enz_ldo";
            desc = "FE PHY LDO output high-resistance control 0: normal mode 1: high resistance";
            sw = rw; hw = r;
            reset = 0x0;
        } fun_fephy_enz_ldo[6:6];
        field {
            name = "fephy_io_sel";
            desc = "Selection of the FE PHY connected to the ETH 0: internal FE PHY 1: external FE PHY";
            sw = rw; hw = r;
            reset = 0x0;
        } fephy_io_sel[5:5];
        field {
            name = "fephy_addr";
            desc = "Internal FE PHY MDIO address configuration register";
            sw = rw; hw = r;
            reset = 0x0;
        } fephy_addr[4:0];
    } MISC_CTRL25 @ 0x64;
    reg {
        name = "MISC_CTRL30";
        desc = "MISC_CTRL30 is DDR write QoS control register 0. (offset 0x78, total reset 0x00000000; PROVEN: Hi3536D V100 data sheet).";
        field {
            name = "jpgd_wqos";
            desc = "JPGD at DDRC write QoS set register";
            sw = rw; hw = r;
            reset = 0x0;
        } jpgd_wqos[31:28];
        field {
            name = "jpge_wqos";
            desc = "JPGE at DDRC write QoS set register";
            sw = rw; hw = r;
            reset = 0x0;
        } jpge_wqos[27:24];
        field {
            name = "tde_wqos";
            desc = "TDE at DDRC write QoS set register";
            sw = rw; hw = r;
            reset = 0x0;
        } tde_wqos[23:20];
        field {
            name = "vgs_wqos";
            desc = "VGS at DDRC write QoS set register";
            sw = rw; hw = r;
            reset = 0x0;
        } vgs_wqos[19:16];
        field {
            name = "vdh_wqos";
            desc = "VDH at DDRC write QoS set register";
            sw = rw; hw = r;
            reset = 0x0;
        } vdh_wqos[15:12];
        field {
            name = "cpu_wqos";
            desc = "CPU at DDRC write QoS set register";
            sw = rw; hw = r;
            reset = 0x0;
        } cpu_wqos[11:8];
        field {
            name = "vdp_wqos";
            desc = "VDP at DDRC write QoS set register";
            sw = rw; hw = r;
            reset = 0x0;
        } vdp_wqos[7:4];
        field {
            name = "aiao_wqos";
            desc = "AIAO at DDRC write QoS set register";
            sw = rw; hw = r;
            reset = 0x0;
        } aiao_wqos[3:0];
    } MISC_CTRL30 @ 0x78;
    reg {
        name = "MISC_CTRL31";
        desc = "MISC_CTRL31 is DDR write QoS control register 1. (offset 0x7C, total reset 0x00000000; PROVEN: Hi3536D V100 data sheet).";
        field {
            name = "fmc_wqos";
            desc = "FMC at DDRC write QoS set register";
            sw = rw; hw = r;
            reset = 0x0;
        } fmc_wqos[31:28];
        field {
            name = "dma_m1_wqos";
            desc = "DMA_M1 at DDRC write QoS set register";
            sw = rw; hw = r;
            reset = 0x0;
        } dma_m1_wqos[27:24];
        field {
            name = "dma_m0_wqos";
            desc = "DMA_M2 at DDRC write QoS set register";
            sw = rw; hw = r;
            reset = 0x0;
        } dma_m0_wqos[23:20];
        field {
            name = "ddrt_wqos";
            desc = "DDRT at DDRC write QoS set register";
            sw = rw; hw = r;
            reset = 0x0;
        } ddrt_wqos[19:16];
        field {
            name = "sata_wqos";
            desc = "SATA at DDRC write QoS set register";
            sw = rw; hw = r;
            reset = 0x0;
        } sata_wqos[15:12];
        field {
            name = "reserved_11_8";
            desc = "Reserved";
            sw = rw; hw = r;
            reset = 0x0;
        } reserved_11_8[11:8];
        field {
            name = "eth_wqos";
            desc = "ETH at DDRC write QoS set register";
            sw = rw; hw = r;
            reset = 0x0;
        } eth_wqos[7:4];
        field {
            name = "reserved_3_0";
            desc = "Reserved";
            sw = r; hw = w;
            reset = 0x0;
        } reserved_3_0[3:0];
    } MISC_CTRL31 @ 0x7C;
    reg {
        name = "MISC_CTRL32";
        desc = "MISC_CTRL32 is DDR write QoS control register 2. (offset 0x80, total reset 0x00000000; PROVEN: Hi3536D V100 data sheet).";
        field {
            name = "reserved_31_8";
            desc = "Reserved";
            sw = rw; hw = r;
            reset = 0x0;
        } reserved_31_8[31:8];
        field {
            name = "cipher_wqos";
            desc = "CIPHER at DDRC writes QoS setting";
            sw = rw; hw = r;
            reset = 0x0;
        } cipher_wqos[7:4];
        field {
            name = "usb_wqos";
            desc = "USB at DDRC writes QoS setting";
            sw = rw; hw = r;
            reset = 0x0;
        } usb_wqos[3:0];
    } MISC_CTRL32 @ 0x80;
    reg {
        name = "MISC_CTRL33";
        desc = "MISC_CTRL33 is DDR read QoS control register 0. (offset 0x84, total reset 0x00000000; PROVEN: Hi3536D V100 data sheet).";
        field {
            name = "jpgd_rqos";
            desc = "JPGD at DDRC read QoS set register";
            sw = rw; hw = r;
            reset = 0x0;
        } jpgd_rqos[31:28];
        field {
            name = "jpge_rqos";
            desc = "JPGE at DDRC read QoS set register";
            sw = rw; hw = r;
            reset = 0x0;
        } jpge_rqos[27:24];
        field {
            name = "tde_rqos";
            desc = "TDE at DDRC read QoS set register";
            sw = rw; hw = r;
            reset = 0x0;
        } tde_rqos[23:20];
        field {
            name = "vgs_rqos";
            desc = "VGS at DDRC read QoS set register";
            sw = rw; hw = r;
            reset = 0x0;
        } vgs_rqos[19:16];
        field {
            name = "vdh_rqos";
            desc = "VDH at DDRC read QoS set register";
            sw = rw; hw = r;
            reset = 0x0;
        } vdh_rqos[15:12];
        field {
            name = "cpu_rqos";
            desc = "CPU at DDRC read QoS set register";
            sw = rw; hw = r;
            reset = 0x0;
        } cpu_rqos[11:8];
        field {
            name = "vdp_rqos";
            desc = "VDP at DDRC read QoS set register";
            sw = rw; hw = r;
            reset = 0x0;
        } vdp_rqos[7:4];
        field {
            name = "aiao_rqos";
            desc = "AIAO at DDRC read QoS set register";
            sw = rw; hw = r;
            reset = 0x0;
        } aiao_rqos[3:0];
    } MISC_CTRL33 @ 0x84;
    reg {
        name = "MISC_CTRL34";
        desc = "MISC_CTRL34 is DDR read QoS control register 1. (offset 0x88, total reset 0x00000000; PROVEN: Hi3536D V100 data sheet).";
        field {
            name = "fmc_rqos";
            desc = "FMC at DDRC read QoS set register";
            sw = rw; hw = r;
            reset = 0x0;
        } fmc_rqos[31:28];
        field {
            name = "dma_m1_rqos";
            desc = "DMA_M1 at DDRC read QoS set register";
            sw = rw; hw = r;
            reset = 0x0;
        } dma_m1_rqos[27:24];
        field {
            name = "dma_m0_rqos";
            desc = "DMA_at DDRC read QoS set register";
            sw = rw; hw = r;
            reset = 0x0;
        } dma_m0_rqos[23:20];
        field {
            name = "ddrt_rqos";
            desc = "DDRT at DDRC read QoS set register";
            sw = rw; hw = r;
            reset = 0x0;
        } ddrt_rqos[19:16];
        field {
            name = "sata_rqos";
            desc = "SATA at DDRC read QoS set register";
            sw = rw; hw = r;
            reset = 0x0;
        } sata_rqos[15:12];
        field {
            name = "reserved_11_8";
            desc = "Reserved";
            sw = rw; hw = r;
            reset = 0x0;
        } reserved_11_8[11:8];
        field {
            name = "eth_rqos";
            desc = "ETH at DDRC read QoS set register";
            sw = rw; hw = r;
            reset = 0x0;
        } eth_rqos[7:4];
        field {
            name = "reserved_3_0";
            desc = "Reserved";
            sw = r; hw = w;
            reset = 0x0;
        } reserved_3_0[3:0];
    } MISC_CTRL34 @ 0x88;
    reg {
        name = "MISC_CTRL35";
        desc = "MISC_CTRL35 is DDR read QoS control register 2. (offset 0x8C, total reset 0x00000000; PROVEN: Hi3536D V100 data sheet).";
        field {
            name = "reserved_31_8";
            desc = "Reserved";
            sw = rw; hw = r;
            reset = 0x0;
        } reserved_31_8[31:8];
        field {
            name = "cipher_rqos";
            desc = "CIPHER at DDRC read QoS set register";
            sw = rw; hw = r;
            reset = 0x0;
        } cipher_rqos[7:4];
        field {
            name = "usb_rqos";
            desc = "USB at DDRC read QoS set register";
            sw = rw; hw = r;
            reset = 0x0;
        } usb_rqos[3:0];
    } MISC_CTRL35 @ 0x8C;
    reg {
        name = "FEPHY_TRIM";
        desc = "FEPHY_TRIM is an internal FE PHY adjustment parameter register. (offset 0x1000, total reset 0x00000000; PROVEN: Hi3536D V100 data sheet).";
        field {
            name = "reserved_31_14";
            desc = "Reserved";
            sw = r; hw = w;
            reset = 0x0;
        } reserved_31_14[31:14];
        field {
            name = "fephy_r_tuning";
            desc = "Adjustment parameter 2 of the internal FE PHY";
            sw = r; hw = w;
            reset = 0x0;
        } fephy_r_tuning[13:8];
        field {
            name = "fephy_ldo_set";
            desc = "Adjustment parameter 1 of internal FEPHY";
            sw = r; hw = w;
            reset = 0x0;
        } fephy_ldo_set[7:5];
        field {
            name = "fephy_ld_set";
            desc = "Adjustment parameter 0 of internal FEPHY 3.6 DMA Controller 3.6.1 Overview between peripherals and memories without using the CPU. The direction memory access controller (DMAC) directly transfers data between a memory and a peripheral, between peripherals, or between memories. This avoids the CPU intervention and reduces the interrupt handling overhead of the CPU. The DMA operation is a high-speed";
            sw = r; hw = w;
            reset = 0x0;
        } fephy_ld_set[4:0];
    } FEPHY_TRIM @ 0x1000;
    reg {
        name = "USB2_PHY0_PRE_EMPHASIS_EN";
        desc = "USB2_PHY0_PRE_EMPHASIS_EN is a USB 2.0 PHY0 pre-emphasis switch register. (offset 0x8000, total reset 0x00000019; PROVEN: Hi3536D V100 data sheet).";
        field {
            name = "reserved_31_3";
            desc = "Reserved usb2_phy0_unchirp 0: Disable the non-chirp pre-emphasis function. [2]           RW _emphasis_en      1: Enable the non-chirp pre-emphasis function. usb2_phy0_chirp_p 0: Disable the chirp pre-emphasis function. [1]           RW re_emphasis_en    1: Enable the chirp pre-emphasis function. usb2_phy0_eop_pr 0: Disable the end of packet (EOP) pre-emphasis function. [0]           RW e_emphasis_";
            sw = r; hw = na;
            reset = 0x3;
        } reserved_31_3[31:3];
    } USB2_PHY0_PRE_EMPHASIS_EN @ 0x8000;
    reg {
        name = "USB2_PHY0_RCOMP";
        desc = "USB2_PHY0_RCOMP is configuration register 0 for the USB 2.0 PHY0 amplitude. (offset 0x8008, total reset 0x0000000C; PROVEN: Hi3536D V100 data sheet).";
        field {
            name = "reserved_31_7";
            desc = "Reserved 000: 400 mV 001: 362.5 mV 010: 350 mV";
            sw = rw; hw = r;
            reset = 0x0;
        } reserved_31_7[31:7];
        field {
            name = "usb2_phy0_rcomp";
            desc = "Adjustment of the eye pattern amplitude in HS mode 011: 387.5 mV 100: 412.5 mV 101: 425 mV 110: 475 mV 111: 450 mV";
            sw = rw; hw = r;
            reset = 0x0;
        } usb2_phy0_rcomp[6:4];
        field {
            name = "reserved_3_0";
            desc = "Reserved";
            sw = r; hw = na;
            reset = 0xc;
        } reserved_3_0[3:0];
    } USB2_PHY0_RCOMP @ 0x8008;
    reg {
        name = "USB2_PHY1_PRE_EMPHASIS_EN";
        desc = "USB2_PHY1_PRE_EMPHASIS_EN (offset 0x8400, total reset 0x00000019; PROVEN: Hi3536D V100 data sheet).";
        field {
            name = "reserved_31_3";
            desc = "Reserved usb2_phy1_unchirp 0: Disable the non-chirp pre-emphasis function. [2]           RW _emphasis_en      1: Enable the non-chirp pre-emphasis function. usb2_phy1_chirp_p 0: Disable the chirp pre-emphasis function. [1]           RW re_emphasis_en    1: Enable the chirp pre-emphasis function. usb2_phy1_eop_pr 0: Disable the EOP pre-emphasis function. [0]           RW e_emphasis_en    1: Enable ";
            sw = r; hw = na;
            reset = 0x3;
        } reserved_31_3[31:3];
    } USB2_PHY1_PRE_EMPHASIS_EN @ 0x8400;
    reg {
        name = "USB2_PHY1_RCOMP";
        desc = "USB2_PHY1_RCOMP (offset 0x8408, total reset 0x0000000C; PROVEN: Hi3536D V100 data sheet).";
        field {
            name = "reserved_31_7";
            desc = "Reserved 000: 400 mV 001: 362.5 mV 010: 350 mV";
            sw = rw; hw = r;
            reset = 0x0;
        } reserved_31_7[31:7];
        field {
            name = "usb2_phy1_rcomp";
            desc = "Adjustment of the eye pattern amplitude in HS mode 011: 387.5 mV 100: 412.5 mV 101: 425 mV 110: 475 mV 111: 450 mV";
            sw = rw; hw = r;
            reset = 0x0;
        } usb2_phy1_rcomp[6:4];
        field {
            name = "reserved_3_0";
            desc = "Reserved";
            sw = r; hw = na;
            reset = 0xc;
        } reserved_3_0[3:0];
    } USB2_PHY1_RCOMP @ 0x8408;
};

`endif
