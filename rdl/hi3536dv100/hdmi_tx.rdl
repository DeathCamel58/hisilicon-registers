`ifndef HI3536D_HDMI_TX_RDL
`define HI3536D_HDMI_TX_RDL

regfile eHI3536D_HDMI_aon {
    name = "HDMI TX aon, Hi3536D V100 / HDMI v2 (hisiv100)";
    desc = "TX always-on block (HW info/version, reset control). Offsets are relative to the sub-block base 0x13004000 (HDMI TX window 0x13000000 + 0x4000). Provenance: PROVEN (vendor code): register names, offsets, field names/bit ranges and reset (INIT) values come from the machine-generated register headers of the vendor HDMI v2 driver (nManager-generated hdmi_reg_aon.h, product/hiosd/hdmi/hdmi_v2/drv/hal in the vendor U-Boot tree for the Hi3536D/Hi3536C/Hi3531D/Hi3521D family, source: sources/openipc-u-boot-hi3536dv100); the Hi3536D V100 maps the window at 0x13000000 per its hdmi_product_define.h and the closed hi3536dv100_hdmi.ko symbol names (HDMI_TX_S_*_REGS_TYPE_Init) agree. INFERRED: access types. Of the 503 register definitions in the vendor headers only 38 carry an ATTR (all RW); the others have none, so fields are modelled read/write except reserved/rsv fields and registers whose names mark them read-only by convention where the vendor hal/drv C sources call the accessors (203 registers) a register only ever read is modelled sw=r and the call-site counts are in each register description; for the other registers the name convention (SW_VER*, HW_INFO/HW_VERSION/HW_FEATURE, _STATUS, _STAT, _STATE, _OUT<n>: sw=r) is used. The 8051 MCU window (mcu sub-block) is modelled the same way and its function is inferred from the HDCP2X_* names only and hardware behavior; nothing run on hardware. NOT in the data sheet (no HDMI TX chapter)." ;
    reg {
        name = "TX_HW_INFO";
        desc = "TX_HW_INFO (offset 0x0 in this sub-block, absolute 0x13004000). Reset INIT 0x07DF0912. PROVEN: vendor register header. No call site in the vendor hal/drv C sources: access by register-name convention only (INFERRED). ";
        field { name = "tx_hw_year"; desc = ""; sw = r; hw = w; reset = 0x7DF; } tx_hw_year[31:16];
        field { name = "tx_hw_month"; desc = ""; sw = r; hw = w; reset = 0x9; } tx_hw_month[15:8];
        field { name = "tx_hw_day"; desc = ""; sw = r; hw = w; reset = 0x12; } tx_hw_day[7:0];
    } TX_HW_INFO @ 0x0;
    reg {
        name = "TX_HW_VERSION";
        desc = "TX_HW_VERSION (offset 0x4 in this sub-block, absolute 0x13004004). Reset INIT 0x00101010. PROVEN: vendor register header. No call site in the vendor hal/drv C sources: access by register-name convention only (INFERRED). ";
        field { name = "rsv_0"; desc = ""; sw = r; hw = na; reset = 0x0; } rsv_0[31:24];
        field { name = "tx_rtl_version"; desc = ""; sw = r; hw = w; reset = 0x10; } tx_rtl_version[23:16];
        field { name = "tx_drv_version"; desc = ""; sw = r; hw = w; reset = 0x10; } tx_drv_version[15:8];
        field { name = "tx_reg_version"; desc = ""; sw = r; hw = w; reset = 0x10; } tx_reg_version[7:0];
    } TX_HW_VERSION @ 0x4;
    reg {
        name = "TX_HW_FEATURE";
        desc = "TX_HW_FEATURE (offset 0x8 in this sub-block, absolute 0x13004008). Reset INIT 0x00000000. PROVEN: vendor register header. No call site in the vendor hal/drv C sources: access by register-name convention only (INFERRED). ";
        field { name = "rsv_1"; desc = ""; sw = r; hw = na; reset = 0x0; } rsv_1[31:0];
    } TX_HW_FEATURE @ 0x8;
    reg {
        name = "TX_AON_RST_CTRL";
        desc = "TX_AON_RST_CTRL (offset 0x1C in this sub-block, absolute 0x1300401C). Reset INIT 0x00000000. PROVEN: vendor register header. No call site in the vendor hal/drv C sources: access by register-name convention only (INFERRED). ";
        field { name = "rsv_2"; desc = ""; sw = r; hw = na; reset = 0x0; } rsv_2[31:1];
        field { name = "tx_aon_soft_arst_req"; desc = ""; sw = rw; hw = r; reset = 0x0; } tx_aon_soft_arst_req[0:0];
    } TX_AON_RST_CTRL @ 0x1C;
    reg {
        name = "HOTPLUG_ST_CFG";
        desc = "HOTPLUG_ST_CFG (offset 0x20 in this sub-block, absolute 0x13004020). Reset INIT 0x00007CF1. PROVEN: vendor register header. Driver usage (vendor hal/drv C, uncommented call sites): 1 Get, 0 Set (hdmi_hal_ctrl.c): read-only by usage (INFERRED RO). ";
        field { name = "rsv_3"; desc = ""; sw = r; hw = na; reset = 0x0; } rsv_3[31:16];
        field { name = "osc_div_cnt"; desc = ""; sw = r; hw = w; reset = 0x7CF; } osc_div_cnt[15:4];
        field { name = "hpd_soft_value"; desc = ""; sw = r; hw = w; reset = 0x0; } hpd_soft_value[3:3];
        field { name = "hpd_polarity_ctl"; desc = ""; sw = r; hw = w; reset = 0x0; } hpd_polarity_ctl[2:2];
        field { name = "hpd_override_en"; desc = ""; sw = r; hw = w; reset = 0x0; } hpd_override_en[1:1];
        field { name = "hpd_fillter_en"; desc = ""; sw = r; hw = w; reset = 0x1; } hpd_fillter_en[0:0];
    } HOTPLUG_ST_CFG @ 0x20;
    reg {
        name = "HOTPLUG_FILLTER_CFG";
        desc = "HOTPLUG_FILLTER_CFG (offset 0x24 in this sub-block, absolute 0x13004024). Reset INIT 0x00090063. PROVEN: vendor register header. No call site in the vendor hal/drv C sources: access by register-name convention only (INFERRED). ";
        field { name = "hpd_low_reshold"; desc = ""; sw = rw; hw = r; reset = 0x9; } hpd_low_reshold[31:16];
        field { name = "hpd_high_reshold"; desc = ""; sw = rw; hw = r; reset = 0x63; } hpd_high_reshold[15:0];
    } HOTPLUG_FILLTER_CFG @ 0x24;
    reg {
        name = "TX_AON_STATE";
        desc = "TX_AON_STATE (offset 0x28 in this sub-block, absolute 0x13004028). Reset INIT 0x00000000. PROVEN: vendor register header. Driver usage (vendor hal/drv C, uncommented call sites): 2 Get, 0 Set (hdmi_hal_ctrl.c): read-only by usage (INFERRED RO). ";
        field { name = "rsv_4"; desc = ""; sw = r; hw = na; reset = 0x0; } rsv_4[31:2];
        field { name = "phy_rx_sense"; desc = ""; sw = r; hw = w; reset = 0x0; } phy_rx_sense[1:1];
        field { name = "hotplug_state"; desc = ""; sw = r; hw = w; reset = 0x0; } hotplug_state[0:0];
    } TX_AON_STATE @ 0x28;
    reg {
        name = "TX_AON_INTR_MASK";
        desc = "TX_AON_INTR_MASK (offset 0x30 in this sub-block, absolute 0x13004030). Reset INIT 0x00000000. PROVEN: vendor register header. Driver usage (vendor hal/drv C, uncommented call sites): 0 Get, 11 Set (hdmi_hal_cec.c, hdmi_hal_ctrl.c): only written by the driver (kept RW: a write-only register cannot be told from an unread one). ";
        field { name = "rsv_7"; desc = ""; sw = r; hw = na; reset = 0x0; } rsv_7[31:14];
        field { name = "aon_intr_mask13"; desc = ""; sw = rw; hw = r; reset = 0x0; } aon_intr_mask13[13:13];
        field { name = "aon_intr_mask12"; desc = ""; sw = rw; hw = r; reset = 0x0; } aon_intr_mask12[12:12];
        field { name = "aon_intr_mask11"; desc = ""; sw = rw; hw = r; reset = 0x0; } aon_intr_mask11[11:11];
        field { name = "aon_intr_mask10"; desc = ""; sw = rw; hw = r; reset = 0x0; } aon_intr_mask10[10:10];
        field { name = "aon_intr_mask9"; desc = ""; sw = rw; hw = r; reset = 0x0; } aon_intr_mask9[9:9];
        field { name = "aon_intr_mask8"; desc = ""; sw = rw; hw = r; reset = 0x0; } aon_intr_mask8[8:8];
        field { name = "aon_intr_mask7"; desc = ""; sw = rw; hw = r; reset = 0x0; } aon_intr_mask7[7:7];
        field { name = "aon_intr_mask6"; desc = ""; sw = rw; hw = r; reset = 0x0; } aon_intr_mask6[6:6];
        field { name = "aon_intr_mask5"; desc = ""; sw = rw; hw = r; reset = 0x0; } aon_intr_mask5[5:5];
        field { name = "aon_intr_mask4"; desc = ""; sw = rw; hw = r; reset = 0x0; } aon_intr_mask4[4:4];
        field { name = "rsv_6"; desc = ""; sw = r; hw = na; reset = 0x0; } rsv_6[3:3];
        field { name = "rsv_5"; desc = ""; sw = r; hw = na; reset = 0x0; } rsv_5[2:2];
        field { name = "aon_intr_mask1"; desc = ""; sw = rw; hw = r; reset = 0x0; } aon_intr_mask1[1:1];
        field { name = "aon_intr_mask0"; desc = ""; sw = rw; hw = r; reset = 0x0; } aon_intr_mask0[0:0];
    } TX_AON_INTR_MASK @ 0x30;
    reg {
        name = "TX_AON_INTR_STATE";
        desc = "TX_AON_INTR_STATE (offset 0x34 in this sub-block, absolute 0x13004034). Reset INIT 0x00000000. PROVEN: vendor register header. Driver usage (vendor hal/drv C, uncommented call sites): 12 Get, 21 Set (hdmi_hal_cec.c, hdmi_hal_ctrl.c): read and written (RW). ";
        field { name = "rsv_10"; desc = ""; sw = r; hw = na; reset = 0x0; } rsv_10[31:14];
        field { name = "aon_intr_stat13"; desc = ""; sw = rw; hw = r; reset = 0x0; } aon_intr_stat13[13:13];
        field { name = "aon_intr_stat12"; desc = ""; sw = rw; hw = r; reset = 0x0; } aon_intr_stat12[12:12];
        field { name = "aon_intr_stat11"; desc = ""; sw = rw; hw = r; reset = 0x0; } aon_intr_stat11[11:11];
        field { name = "aon_intr_stat10"; desc = ""; sw = rw; hw = r; reset = 0x0; } aon_intr_stat10[10:10];
        field { name = "aon_intr_stat9"; desc = ""; sw = rw; hw = r; reset = 0x0; } aon_intr_stat9[9:9];
        field { name = "aon_intr_stat8"; desc = ""; sw = rw; hw = r; reset = 0x0; } aon_intr_stat8[8:8];
        field { name = "aon_intr_stat7"; desc = ""; sw = rw; hw = r; reset = 0x0; } aon_intr_stat7[7:7];
        field { name = "aon_intr_stat6"; desc = ""; sw = rw; hw = r; reset = 0x0; } aon_intr_stat6[6:6];
        field { name = "aon_intr_stat5"; desc = ""; sw = rw; hw = r; reset = 0x0; } aon_intr_stat5[5:5];
        field { name = "aon_intr_stat4"; desc = ""; sw = rw; hw = r; reset = 0x0; } aon_intr_stat4[4:4];
        field { name = "rsv_9"; desc = ""; sw = r; hw = na; reset = 0x0; } rsv_9[3:3];
        field { name = "rsv_8"; desc = ""; sw = r; hw = na; reset = 0x0; } rsv_8[2:2];
        field { name = "aon_intr_stat1"; desc = ""; sw = rw; hw = r; reset = 0x0; } aon_intr_stat1[1:1];
        field { name = "aon_intr_stat0"; desc = ""; sw = rw; hw = r; reset = 0x0; } aon_intr_stat0[0:0];
    } TX_AON_INTR_STATE @ 0x34;
    reg {
        name = "DDC_MST_CTRL";
        desc = "DDC_MST_CTRL (offset 0x40 in this sub-block, absolute 0x13004040). Reset INIT 0x000004A0. PROVEN: vendor register header. Driver usage (vendor hal/drv C, uncommented call sites): 0 Get, 1 Set (hdmi_hal_ddc.c): only written by the driver (kept RW: a write-only register cannot be told from an unread one). ";
        field { name = "rsv_12"; desc = ""; sw = r; hw = na; reset = 0x0; } rsv_12[31:13];
        field { name = "ddc_speed_cnt"; desc = ""; sw = rw; hw = r; reset = 0x4A; } ddc_speed_cnt[12:4];
        field { name = "rsv_11"; desc = ""; sw = r; hw = na; reset = 0x0; } rsv_11[3:2];
        field { name = "dcc_man_en"; desc = ""; sw = rw; hw = r; reset = 0x0; } dcc_man_en[1:1];
        field { name = "ddc_aon_access"; desc = ""; sw = rw; hw = r; reset = 0x0; } ddc_aon_access[0:0];
    } DDC_MST_CTRL @ 0x40;
    reg {
        name = "DDC_FIFO_RDATA";
        desc = "DDC_FIFO_RDATA (offset 0x44 in this sub-block, absolute 0x13004044). Reset INIT 0x00000000. PROVEN: vendor register header. No call site in the vendor hal/drv C sources: access by register-name convention only (INFERRED). ";
        field { name = "rsv_13"; desc = ""; sw = r; hw = na; reset = 0x0; } rsv_13[31:8];
        field { name = "ddc_fifo_data_out"; desc = ""; sw = rw; hw = r; reset = 0x0; } ddc_fifo_data_out[7:0];
    } DDC_FIFO_RDATA @ 0x44;
    reg {
        name = "DDC_FIFO_WDATA";
        desc = "DDC_FIFO_WDATA (offset 0x48 in this sub-block, absolute 0x13004048). Reset INIT 0x00000000. PROVEN: vendor register header. No call site in the vendor hal/drv C sources: access by register-name convention only (INFERRED). ";
        field { name = "rsv_14"; desc = ""; sw = r; hw = na; reset = 0x0; } rsv_14[31:8];
        field { name = "ddc_fifo_data_in"; desc = ""; sw = rw; hw = r; reset = 0x0; } ddc_fifo_data_in[7:0];
    } DDC_FIFO_WDATA @ 0x48;
    reg {
        name = "DDC_DATA_CNT";
        desc = "DDC_DATA_CNT (offset 0x4C in this sub-block, absolute 0x1300404C). Reset INIT 0x00000000. PROVEN: vendor register header. No call site in the vendor hal/drv C sources: access by register-name convention only (INFERRED). ";
        field { name = "rsv_16"; desc = ""; sw = r; hw = na; reset = 0x0; } rsv_16[31:18];
        field { name = "ddc_data_out_cnt"; desc = ""; sw = rw; hw = r; reset = 0x0; } ddc_data_out_cnt[17:8];
        field { name = "rsv_15"; desc = ""; sw = r; hw = na; reset = 0x0; } rsv_15[7:5];
        field { name = "ddc_fifo_data_cnt"; desc = ""; sw = rw; hw = r; reset = 0x0; } ddc_fifo_data_cnt[4:0];
    } DDC_DATA_CNT @ 0x4C;
    reg {
        name = "DDC_SLAVE_CFG";
        desc = "DDC_SLAVE_CFG (offset 0x50 in this sub-block, absolute 0x13004050). Reset INIT 0x00000000. PROVEN: vendor register header. No call site in the vendor hal/drv C sources: access by register-name convention only (INFERRED). ";
        field { name = "rsv_17"; desc = ""; sw = r; hw = na; reset = 0x0; } rsv_17[31:24];
        field { name = "ddc_slave_seg"; desc = ""; sw = rw; hw = r; reset = 0x0; } ddc_slave_seg[23:16];
        field { name = "ddc_slave_offset"; desc = ""; sw = rw; hw = r; reset = 0x0; } ddc_slave_offset[15:8];
        field { name = "ddc_slave_addr"; desc = ""; sw = rw; hw = r; reset = 0x0; } ddc_slave_addr[7:0];
    } DDC_SLAVE_CFG @ 0x50;
    reg {
        name = "DDC_MST_STATE";
        desc = "DDC_MST_STATE (offset 0x54 in this sub-block, absolute 0x13004054). Reset INIT 0x00000020. PROVEN: vendor register header. No call site in the vendor hal/drv C sources: access by register-name convention only (INFERRED). ";
        field { name = "rsv_18"; desc = ""; sw = r; hw = na; reset = 0x0; } rsv_18[31:8];
        field { name = "ddc_fifo_full"; desc = ""; sw = r; hw = w; reset = 0x0; } ddc_fifo_full[7:7];
        field { name = "ddc_fifo_half_full"; desc = ""; sw = r; hw = w; reset = 0x0; } ddc_fifo_half_full[6:6];
        field { name = "ddc_fifo_empty"; desc = ""; sw = r; hw = w; reset = 0x1; } ddc_fifo_empty[5:5];
        field { name = "ddc_fifo_rd_in_use"; desc = ""; sw = r; hw = w; reset = 0x0; } ddc_fifo_rd_in_use[4:4];
        field { name = "ddc_fifo_wr_in_use"; desc = ""; sw = r; hw = w; reset = 0x0; } ddc_fifo_wr_in_use[3:3];
        field { name = "ddc_i2c_in_prog"; desc = ""; sw = r; hw = w; reset = 0x0; } ddc_i2c_in_prog[2:2];
        field { name = "ddc_i2c_bus_low"; desc = ""; sw = r; hw = w; reset = 0x0; } ddc_i2c_bus_low[1:1];
        field { name = "ddc_i2c_no_ack"; desc = ""; sw = r; hw = w; reset = 0x0; } ddc_i2c_no_ack[0:0];
    } DDC_MST_STATE @ 0x54;
    reg {
        name = "DDC_MST_CMD";
        desc = "DDC_MST_CMD (offset 0x58 in this sub-block, absolute 0x13004058). Reset INIT 0x00000000. PROVEN: vendor register header. No call site in the vendor hal/drv C sources: access by register-name convention only (INFERRED). ";
        field { name = "rsv_19"; desc = ""; sw = r; hw = na; reset = 0x0; } rsv_19[31:4];
        field { name = "ddc_mst_cmd"; desc = ""; sw = rw; hw = r; reset = 0x0; } ddc_mst_cmd[3:0];
    } DDC_MST_CMD @ 0x58;
    reg {
        name = "DDC_MAN_CTRL";
        desc = "DDC_MAN_CTRL (offset 0x5C in this sub-block, absolute 0x1300405C). Reset INIT 0x0000000C. PROVEN: vendor register header. Driver usage (vendor hal/drv C, uncommented call sites): 1 Get, 5 Set (hdmi_hal_ddc.c): read and written (RW). ";
        field { name = "rsv_20"; desc = ""; sw = r; hw = na; reset = 0x0; } rsv_20[31:4];
        field { name = "ddc_sda_oen"; desc = ""; sw = rw; hw = r; reset = 0x1; } ddc_sda_oen[3:3];
        field { name = "ddc_scl_oen"; desc = ""; sw = rw; hw = r; reset = 0x1; } ddc_scl_oen[2:2];
        field { name = "ddc_sda_st"; desc = ""; sw = rw; hw = r; reset = 0x0; } ddc_sda_st[1:1];
        field { name = "ddc_scl_st"; desc = ""; sw = rw; hw = r; reset = 0x0; } ddc_scl_st[0:0];
    } DDC_MAN_CTRL @ 0x5C;
    reg {
        name = "DDC_STATE_CLR";
        desc = "DDC_STATE_CLR (offset 0x60 in this sub-block, absolute 0x13004060). Reset INIT 0x00000000. PROVEN: vendor register header. No call site in the vendor hal/drv C sources: access by register-name convention only (INFERRED). ";
        field { name = "rsv_21"; desc = ""; sw = r; hw = na; reset = 0x0; } rsv_21[31:2];
        field { name = "ddc_clr_no_ack"; desc = ""; sw = rw; hw = r; reset = 0x0; } ddc_clr_no_ack[1:1];
        field { name = "ddc_clr_bus_low"; desc = ""; sw = rw; hw = r; reset = 0x0; } ddc_clr_bus_low[0:0];
    } DDC_STATE_CLR @ 0x60;
};

regfile eHI3536D_HDMI_audio_path {
    name = "HDMI TX audio_path, Hi3536D V100 / HDMI v2 (hisiv100)";
    desc = "TX audio path. Offsets are relative to the sub-block base 0x13001000 (HDMI TX window 0x13000000 + 0x1000). Provenance: PROVEN (vendor code): register names, offsets, field names/bit ranges and reset (INIT) values come from the machine-generated register headers of the vendor HDMI v2 driver (nManager-generated hdmi_reg_audio_path.h, product/hiosd/hdmi/hdmi_v2/drv/hal in the vendor U-Boot tree for the Hi3536D/Hi3536C/Hi3531D/Hi3521D family, source: sources/openipc-u-boot-hi3536dv100); the Hi3536D V100 maps the window at 0x13000000 per its hdmi_product_define.h and the closed hi3536dv100_hdmi.ko symbol names (HDMI_TX_S_*_REGS_TYPE_Init) agree. INFERRED: access types. Of the 503 register definitions in the vendor headers only 38 carry an ATTR (all RW); the others have none, so fields are modelled read/write except reserved/rsv fields and registers whose names mark them read-only by convention where the vendor hal/drv C sources call the accessors (203 registers) a register only ever read is modelled sw=r and the call-site counts are in each register description; for the other registers the name convention (SW_VER*, HW_INFO/HW_VERSION/HW_FEATURE, _STATUS, _STAT, _STATE, _OUT<n>: sw=r) is used. The 8051 MCU window (mcu sub-block) is modelled the same way and its function is inferred from the HDCP2X_* names only and hardware behavior; nothing run on hardware. NOT in the data sheet (no HDMI TX chapter)." ;
    reg {
        name = "TX_AUDIO_CTRL";
        desc = "TX_AUDIO_CTRL (offset 0x0 in this sub-block, absolute 0x13001000). Reset INIT 0x000E4001. PROVEN: vendor register header. Driver usage (vendor hal/drv C, uncommented call sites): 5 Get, 5 Set (hdmi_hal_ctrl.c): read and written (RW). ";
        field { name = "rsv_2"; desc = ""; sw = r; hw = na; reset = 0x0; } rsv_2[31:20];
        field { name = "aud_fifo3_map"; desc = ""; sw = rw; hw = r; reset = 0x3; } aud_fifo3_map[19:18];
        field { name = "aud_fifo2_map"; desc = ""; sw = rw; hw = r; reset = 0x2; } aud_fifo2_map[17:16];
        field { name = "aud_fifo1_map"; desc = ""; sw = rw; hw = r; reset = 0x1; } aud_fifo1_map[15:14];
        field { name = "aud_fifo0_map"; desc = ""; sw = rw; hw = r; reset = 0x0; } aud_fifo0_map[13:12];
        field { name = "rsv_1"; desc = ""; sw = r; hw = na; reset = 0x0; } rsv_1[11:11];
        field { name = "aud_src_ctrl"; desc = ""; sw = rw; hw = r; reset = 0x0; } aud_src_ctrl[10:10];
        field { name = "aud_src_en"; desc = ""; sw = rw; hw = r; reset = 0x0; } aud_src_en[9:9];
        field { name = "aud_spdif_en"; desc = ""; sw = rw; hw = r; reset = 0x0; } aud_spdif_en[8:8];
        field { name = "aud_i2s_en"; desc = ""; sw = rw; hw = r; reset = 0x0; } aud_i2s_en[7:4];
        field { name = "rsv_0"; desc = ""; sw = r; hw = na; reset = 0x0; } rsv_0[3:3];
        field { name = "aud_layout"; desc = ""; sw = rw; hw = r; reset = 0x0; } aud_layout[2:2];
        field { name = "aud_mute_en"; desc = ""; sw = rw; hw = r; reset = 0x0; } aud_mute_en[1:1];
        field { name = "aud_in_en"; desc = ""; sw = rw; hw = r; reset = 0x1; } aud_in_en[0:0];
    } TX_AUDIO_CTRL @ 0x0;
    reg {
        name = "AUD_I2S_CTRL";
        desc = "AUD_I2S_CTRL (offset 0x4 in this sub-block, absolute 0x13001004). Reset INIT 0x00000B00. PROVEN: vendor register header. Driver usage (vendor hal/drv C, uncommented call sites): 1 Get, 8 Set (hdmi_hal_ctrl.c): read and written (RW). ";
        field { name = "rsv_4"; desc = ""; sw = r; hw = na; reset = 0x0; } rsv_4[31:16];
        field { name = "i2s_ch_swap"; desc = ""; sw = rw; hw = r; reset = 0x0; } i2s_ch_swap[15:12];
        field { name = "i2s_length"; desc = ""; sw = rw; hw = r; reset = 0xB; } i2s_length[11:8];
        field { name = "rsv_3"; desc = ""; sw = r; hw = na; reset = 0x0; } rsv_3[7:6];
        field { name = "i2s_vbit"; desc = ""; sw = rw; hw = r; reset = 0x0; } i2s_vbit[5:5];
        field { name = "i2s_data_dir"; desc = ""; sw = rw; hw = r; reset = 0x0; } i2s_data_dir[4:4];
        field { name = "i2s_justify"; desc = ""; sw = rw; hw = r; reset = 0x0; } i2s_justify[3:3];
        field { name = "i2s_ws_polarity"; desc = ""; sw = rw; hw = r; reset = 0x0; } i2s_ws_polarity[2:2];
        field { name = "i2s_1st_shift"; desc = ""; sw = rw; hw = r; reset = 0x0; } i2s_1st_shift[1:1];
        field { name = "i2s_hbra_on"; desc = ""; sw = rw; hw = r; reset = 0x0; } i2s_hbra_on[0:0];
    } AUD_I2S_CTRL @ 0x4;
    reg {
        name = "AUD_SPDIF_CTRL";
        desc = "AUD_SPDIF_CTRL (offset 0x8 in this sub-block, absolute 0x13001008). Reset INIT 0x00904084. PROVEN: vendor register header. No call site in the vendor hal/drv C sources: access by register-name convention only (INFERRED). ";
        field { name = "rsv_5"; desc = ""; sw = r; hw = na; reset = 0x0; } rsv_5[31:28];
        field { name = "spdif_2ui_max"; desc = ""; sw = rw; hw = r; reset = 0x9; } spdif_2ui_max[27:20];
        field { name = "spdif_1ui_max"; desc = ""; sw = rw; hw = r; reset = 0x4; } spdif_1ui_max[19:12];
        field { name = "spdif_size_sw"; desc = ""; sw = rw; hw = r; reset = 0x0; } spdif_size_sw[11:10];
        field { name = "spdif_err_thresh"; desc = ""; sw = rw; hw = r; reset = 0x8; } spdif_err_thresh[9:4];
        field { name = "spdif_fs_ovr_en"; desc = ""; sw = rw; hw = r; reset = 0x0; } spdif_fs_ovr_en[3:3];
        field { name = "i2s_cbit_order"; desc = ""; sw = rw; hw = r; reset = 0x1; } i2s_cbit_order[2:2];
        field { name = "spdif_2ui_lock"; desc = ""; sw = rw; hw = r; reset = 0x0; } spdif_2ui_lock[1:1];
        field { name = "spdif_1ui_lock"; desc = ""; sw = rw; hw = r; reset = 0x0; } spdif_1ui_lock[0:0];
    } AUD_SPDIF_CTRL @ 0x8;
    reg {
        name = "AUD_CHST_CFG0";
        desc = "AUD_CHST_CFG0 (offset 0xC in this sub-block, absolute 0x1300100C). Reset INIT 0x00000000. PROVEN: vendor register header. Driver usage (vendor hal/drv C, uncommented call sites): 1 Get, 4 Set (hdmi_hal_ctrl.c): read and written (RW). ";
        field { name = "chst_byte3_clock_accuracy"; desc = ""; sw = rw; hw = r; reset = 0x0; } chst_byte3_clock_accuracy[31:28];
        field { name = "chst_byte3_fs"; desc = ""; sw = rw; hw = r; reset = 0x0; } chst_byte3_fs[27:24];
        field { name = "chst_byte2"; desc = ""; sw = rw; hw = r; reset = 0x0; } chst_byte2[23:16];
        field { name = "chst_byte1"; desc = ""; sw = rw; hw = r; reset = 0x0; } chst_byte1[15:8];
        field { name = "chst_byte0_other"; desc = ""; sw = rw; hw = r; reset = 0x0; } chst_byte0_other[7:2];
        field { name = "chst_byte0_b"; desc = ""; sw = rw; hw = r; reset = 0x0; } chst_byte0_b[1:1];
        field { name = "chst_byte0_a"; desc = ""; sw = rw; hw = r; reset = 0x0; } chst_byte0_a[0:0];
    } AUD_CHST_CFG0 @ 0xC;
    reg {
        name = "AUD_CHST_CFG1";
        desc = "AUD_CHST_CFG1 (offset 0x10 in this sub-block, absolute 0x13001010). Reset INIT 0x0000000B. PROVEN: vendor register header. Driver usage (vendor hal/drv C, uncommented call sites): 2 Get, 2 Set (hdmi_hal_ctrl.c): read and written (RW). ";
        field { name = "rsv_6"; desc = ""; sw = r; hw = na; reset = 0x0; } rsv_6[31:24];
        field { name = "chst_byte5_6"; desc = ""; sw = rw; hw = r; reset = 0x0; } chst_byte5_6[23:8];
        field { name = "chst_byte4_org_fs"; desc = ""; sw = rw; hw = r; reset = 0x0; } chst_byte4_org_fs[7:4];
        field { name = "chst_byte4_length"; desc = ""; sw = rw; hw = r; reset = 0xB; } chst_byte4_length[3:0];
    } AUD_CHST_CFG1 @ 0x10;
    reg {
        name = "TX_AUDIO_STATE";
        desc = "TX_AUDIO_STATE (offset 0x14 in this sub-block, absolute 0x13001014). Reset INIT 0x00000000. PROVEN: vendor register header. Driver usage (vendor hal/drv C, uncommented call sites): 2 Get, 0 Set (hdmi_hal_ctrl.c): read-only by usage (INFERRED RO). ";
        field { name = "spdif_max_2ui_st"; desc = ""; sw = r; hw = w; reset = 0x0; } spdif_max_2ui_st[31:24];
        field { name = "spdif_max_1ui_st"; desc = ""; sw = r; hw = w; reset = 0x0; } spdif_max_1ui_st[23:16];
        field { name = "rsv_8"; desc = ""; sw = r; hw = na; reset = 0x0; } rsv_8[15:14];
        field { name = "aud_spdif_fs"; desc = ""; sw = r; hw = w; reset = 0x0; } aud_spdif_fs[13:8];
        field { name = "aud_length"; desc = ""; sw = r; hw = w; reset = 0x0; } aud_length[7:4];
        field { name = "rsv_7"; desc = ""; sw = r; hw = na; reset = 0x0; } rsv_7[3:2];
        field { name = "aud_spdif_new_fs"; desc = ""; sw = r; hw = w; reset = 0x0; } aud_spdif_new_fs[1:1];
        field { name = "aud_inavailable"; desc = ""; sw = r; hw = w; reset = 0x0; } aud_inavailable[0:0];
    } TX_AUDIO_STATE @ 0x14;
    reg {
        name = "AUD_FIFO_CTRL";
        desc = "AUD_FIFO_CTRL (offset 0x18 in this sub-block, absolute 0x13001018). Reset INIT 0x00000001. PROVEN: vendor register header. Driver usage (vendor hal/drv C, uncommented call sites): 0 Get, 2 Set (hdmi_hal_ctrl.c): only written by the driver (kept RW: a write-only register cannot be told from an unread one). ";
        field { name = "rsv_11"; desc = ""; sw = r; hw = na; reset = 0x0; } rsv_11[31:22];
        field { name = "aud_fifo_ptr_diff"; desc = ""; sw = rw; hw = r; reset = 0x0; } aud_fifo_ptr_diff[21:16];
        field { name = "rsv_10"; desc = ""; sw = r; hw = na; reset = 0x0; } rsv_10[15:12];
        field { name = "aud_fifo_hbr_mask"; desc = ""; sw = rw; hw = r; reset = 0x0; } aud_fifo_hbr_mask[11:8];
        field { name = "rsv_9"; desc = ""; sw = r; hw = na; reset = 0x0; } rsv_9[7:5];
        field { name = "aud_fifo_test"; desc = ""; sw = rw; hw = r; reset = 0x1; } aud_fifo_test[4:0];
    } AUD_FIFO_CTRL @ 0x18;
    reg {
        name = "AUD_ACR_CTRL";
        desc = "AUD_ACR_CTRL (offset 0x40 in this sub-block, absolute 0x13001040). Reset INIT 0x00000005. PROVEN: vendor register header. Driver usage (vendor hal/drv C, uncommented call sites): 1 Get, 1 Set (hdmi_hal_ctrl.c): read and written (RW). ";
        field { name = "rsv_12"; desc = ""; sw = r; hw = na; reset = 0x0; } rsv_12[31:6];
        field { name = "acr_cts_ave_en"; desc = ""; sw = rw; hw = r; reset = 0x0; } acr_cts_ave_en[5:5];
        field { name = "acr_use_sw_cts"; desc = ""; sw = rw; hw = r; reset = 0x0; } acr_use_sw_cts[4:4];
        field { name = "acr_cts_flt_en"; desc = ""; sw = rw; hw = r; reset = 0x0; } acr_cts_flt_en[3:3];
        field { name = "acr_cts_gen_sel"; desc = ""; sw = rw; hw = r; reset = 0x1; } acr_cts_gen_sel[2:2];
        field { name = "acr_cts_hw_sw_sel"; desc = ""; sw = rw; hw = r; reset = 0x0; } acr_cts_hw_sw_sel[1:1];
        field { name = "acr_cts_req_en"; desc = ""; sw = rw; hw = r; reset = 0x1; } acr_cts_req_en[0:0];
    } AUD_ACR_CTRL @ 0x40;
    reg {
        name = "AUD_ACR_CFG";
        desc = "AUD_ACR_CFG (offset 0x44 in this sub-block, absolute 0x13001044). Reset INIT 0x00001040. PROVEN: vendor register header. No call site in the vendor hal/drv C sources: access by register-name convention only (INFERRED). ";
        field { name = "rsv_13"; desc = ""; sw = r; hw = na; reset = 0x0; } rsv_13[31:24];
        field { name = "acr_cts_chg_thre"; desc = ""; sw = rw; hw = r; reset = 0x0; } acr_cts_chg_thre[23:16];
        field { name = "acr_cts_thre"; desc = ""; sw = rw; hw = r; reset = 0x10; } acr_cts_thre[15:8];
        field { name = "acr_ave_max"; desc = ""; sw = rw; hw = r; reset = 0x8; } acr_ave_max[7:3];
        field { name = "acr_fm_val_sw"; desc = ""; sw = rw; hw = r; reset = 0x0; } acr_fm_val_sw[2:0];
    } AUD_ACR_CFG @ 0x44;
    reg {
        name = "ACR_N_VAL_SW";
        desc = "ACR_N_VAL_SW (offset 0x48 in this sub-block, absolute 0x13001048). Reset INIT 0x00000000. PROVEN: vendor register header. Driver usage (vendor hal/drv C, uncommented call sites): 1 Get, 1 Set (hdmi_hal_ctrl.c): read and written (RW). ";
        field { name = "rsv_14"; desc = ""; sw = r; hw = na; reset = 0x0; } rsv_14[31:20];
        field { name = "acr_n_val_sw"; desc = ""; sw = rw; hw = r; reset = 0x0; } acr_n_val_sw[19:0];
    } ACR_N_VAL_SW @ 0x48;
    reg {
        name = "ACR_CTS_VAL_SW";
        desc = "ACR_CTS_VAL_SW (offset 0x4C in this sub-block, absolute 0x1300104C). Reset INIT 0x00000000. PROVEN: vendor register header. Driver usage (vendor hal/drv C, uncommented call sites): 1 Get, 0 Set (hdmi_hal_ctrl.c): read-only by usage (INFERRED RO). ";
        field { name = "rsv_15"; desc = ""; sw = r; hw = na; reset = 0x0; } rsv_15[31:20];
        field { name = "acr_cts_val_sw"; desc = ""; sw = r; hw = w; reset = 0x0; } acr_cts_val_sw[19:0];
    } ACR_CTS_VAL_SW @ 0x4C;
    reg {
        name = "ACR_CTS_VAL_HW";
        desc = "ACR_CTS_VAL_HW (offset 0x50 in this sub-block, absolute 0x13001050). Reset INIT 0x00000000. PROVEN: vendor register header. Driver usage (vendor hal/drv C, uncommented call sites): 1 Get, 0 Set (hdmi_hal_ctrl.c): read-only by usage (INFERRED RO). ";
        field { name = "rsv_16"; desc = ""; sw = r; hw = na; reset = 0x0; } rsv_16[31:20];
        field { name = "acr_cts_val_hw"; desc = ""; sw = r; hw = w; reset = 0x0; } acr_cts_val_hw[19:0];
    } ACR_CTS_VAL_HW @ 0x50;
};

regfile eHI3536D_HDMI_cec {
    name = "HDMI TX cec, Hi3536D V100 / HDMI v2 (hisiv100)";
    desc = "TX CEC controller. Offsets are relative to the sub-block base 0x13004800 (HDMI TX window 0x13000000 + 0x4800). Provenance: PROVEN (vendor code): register names, offsets, field names/bit ranges and reset (INIT) values come from the machine-generated register headers of the vendor HDMI v2 driver (nManager-generated hdmi_reg_cec.h, product/hiosd/hdmi/hdmi_v2/drv/hal in the vendor U-Boot tree for the Hi3536D/Hi3536C/Hi3531D/Hi3521D family, source: sources/openipc-u-boot-hi3536dv100); the Hi3536D V100 maps the window at 0x13000000 per its hdmi_product_define.h and the closed hi3536dv100_hdmi.ko symbol names (HDMI_TX_S_*_REGS_TYPE_Init) agree. INFERRED: access types. Of the 503 register definitions in the vendor headers only 38 carry an ATTR (all RW); the others have none, so fields are modelled read/write except reserved/rsv fields and registers whose names mark them read-only by convention where the vendor hal/drv C sources call the accessors (203 registers) a register only ever read is modelled sw=r and the call-site counts are in each register description; for the other registers the name convention (SW_VER*, HW_INFO/HW_VERSION/HW_FEATURE, _STATUS, _STAT, _STATE, _OUT<n>: sw=r) is used. The 8051 MCU window (mcu sub-block) is modelled the same way and its function is inferred from the HDCP2X_* names only and hardware behavior; nothing run on hardware. NOT in the data sheet (no HDMI TX chapter)." ;
    reg {
        name = "CEC_DEV_INFO";
        desc = "CEC_DEV_INFO (offset 0x0 in this sub-block, absolute 0x13004800). Reset INIT 0xA08014CC. PROVEN: vendor register header. No call site in the vendor hal/drv C sources: access by register-name convention only (INFERRED). ";
        field { name = "cec_hw_ver"; desc = ""; sw = rw; hw = r; reset = 0xA0; } cec_hw_ver[31:24];
        field { name = "cec_sub_sys"; desc = ""; sw = rw; hw = r; reset = 0x1; } cec_sub_sys[23:23];
        field { name = "rsv_0"; desc = ""; sw = r; hw = na; reset = 0x0; } rsv_0[22:20];
        field { name = "cec_spec_suffix"; desc = ""; sw = rw; hw = r; reset = 0x0; } cec_spec_suffix[19:16];
        field { name = "cec_spec_ver"; desc = ""; sw = rw; hw = r; reset = 0x14; } cec_spec_ver[15:8];
        field { name = "cec_device_id"; desc = ""; sw = rw; hw = r; reset = 0xCC; } cec_device_id[7:0];
    } CEC_DEV_INFO @ 0x0;
    reg {
        name = "CEC_START_PRIOD";
        desc = "CEC_START_PRIOD (offset 0x4 in this sub-block, absolute 0x13004804). Reset INIT 0x00000000. PROVEN: vendor register header. No call site in the vendor hal/drv C sources: access by register-name convention only (INFERRED). ";
        field { name = "rsv_1"; desc = ""; sw = r; hw = na; reset = 0x0; } rsv_1[31:16];
        field { name = "cec_start_low_priod"; desc = ""; sw = rw; hw = r; reset = 0x0; } cec_start_low_priod[15:8];
        field { name = "cec_start_bit_priod"; desc = ""; sw = rw; hw = r; reset = 0x0; } cec_start_bit_priod[7:0];
    } CEC_START_PRIOD @ 0x4;
    reg {
        name = "CEC_TX_CTRL";
        desc = "CEC_TX_CTRL (offset 0x8 in this sub-block, absolute 0x13004808). Reset INIT 0x10060000. PROVEN: vendor register header. Driver usage (vendor hal/drv C, uncommented call sites): 0 Get, 8 Set (hdmi_hal_cec.c): only written by the driver (kept RW: a write-only register cannot be told from an unread one). ";
        field { name = "auto_clear_intrp_rx_fifo_nempty"; desc = ""; sw = rw; hw = r; reset = 0x0; } auto_clear_intrp_rx_fifo_nempty[31:31];
        field { name = "cec_reg_rx_clr_all"; desc = ""; sw = rw; hw = r; reset = 0x0; } cec_reg_rx_clr_all[30:30];
        field { name = "cec_reg_rx_clr_cur_set"; desc = ""; sw = rw; hw = r; reset = 0x0; } cec_reg_rx_clr_cur_set[29:29];
        field { name = "cec_reg_tx_retry_limit"; desc = ""; sw = rw; hw = r; reset = 0x4; } cec_reg_tx_retry_limit[28:26];
        field { name = "cec_reg_tx_cmd_cnt"; desc = ""; sw = rw; hw = r; reset = 0x0; } cec_reg_tx_cmd_cnt[25:22];
        field { name = "cec_reg_tx_bfr_ac"; desc = ""; sw = rw; hw = r; reset = 0x0; } cec_reg_tx_bfr_ac[21:21];
        field { name = "cec_reg_tx_auto_calc"; desc = ""; sw = rw; hw = r; reset = 0x0; } cec_reg_tx_auto_calc[20:20];
        field { name = "manual_cmd_set"; desc = ""; sw = rw; hw = r; reset = 0x0; } manual_cmd_set[19:19];
        field { name = "cec_reg_i2c_cec_passthru"; desc = ""; sw = rw; hw = r; reset = 0x1; } cec_reg_i2c_cec_passthru[18:18];
        field { name = "cec_reg_force_non_calib"; desc = ""; sw = rw; hw = r; reset = 0x1; } cec_reg_force_non_calib[17:17];
        field { name = "cec_reg_calib_cec_en"; desc = ""; sw = rw; hw = r; reset = 0x0; } cec_reg_calib_cec_en[16:16];
        field { name = "cec_reg_calib_cec"; desc = ""; sw = rw; hw = r; reset = 0x0; } cec_reg_calib_cec[15:15];
        field { name = "cec_reg_flush_tx_ff"; desc = ""; sw = rw; hw = r; reset = 0x0; } cec_reg_flush_tx_ff[14:14];
        field { name = "cec_ctl_retry_cnt"; desc = ""; sw = rw; hw = r; reset = 0x0; } cec_ctl_retry_cnt[13:11];
        field { name = "cec_inv_ack_brcst"; desc = ""; sw = rw; hw = r; reset = 0x0; } cec_inv_ack_brcst[10:10];
        field { name = "cec_reg_nack_hdr"; desc = ""; sw = rw; hw = r; reset = 0x0; } cec_reg_nack_hdr[9:9];
        field { name = "cec_reg_snoop"; desc = ""; sw = rw; hw = r; reset = 0x0; } cec_reg_snoop[8:8];
        field { name = "cec_snoop_initiator"; desc = ""; sw = rw; hw = r; reset = 0x0; } cec_snoop_initiator[7:4];
        field { name = "cec_bus_owner"; desc = ""; sw = rw; hw = r; reset = 0x0; } cec_bus_owner[3:0];
    } CEC_TX_CTRL @ 0x8;
    reg {
        name = "CEC_RX_STATE";
        desc = "CEC_RX_STATE (offset 0xC in this sub-block, absolute 0x1300480C). Reset INIT 0x00000000. PROVEN: vendor register header. Driver usage (vendor hal/drv C, uncommented call sites): 6 Get, 0 Set (hdmi_hal_cec.c): read-only by usage (INFERRED RO). ";
        field { name = "rsv_3"; desc = ""; sw = r; hw = na; reset = 0x0; } rsv_3[31:16];
        field { name = "cec_rx_init_cmd_header"; desc = ""; sw = r; hw = w; reset = 0x0; } cec_rx_init_cmd_header[15:12];
        field { name = "cec_rx_dest_cmd_header"; desc = ""; sw = r; hw = w; reset = 0x0; } cec_rx_dest_cmd_header[11:8];
        field { name = "cec_rx_error"; desc = ""; sw = r; hw = w; reset = 0x0; } cec_rx_error[7:7];
        field { name = "rsv_2"; desc = ""; sw = r; hw = na; reset = 0x0; } rsv_2[6:6];
        field { name = "cec_reg_rx_ff_wr_sel"; desc = ""; sw = r; hw = w; reset = 0x0; } cec_reg_rx_ff_wr_sel[5:4];
        field { name = "cec_reg_rx_cmd_byte_cnt"; desc = ""; sw = r; hw = w; reset = 0x0; } cec_reg_rx_cmd_byte_cnt[3:0];
    } CEC_RX_STATE @ 0xC;
    reg {
        name = "CEC_AUTO_DISC";
        desc = "CEC_AUTO_DISC (offset 0x10 in this sub-block, absolute 0x13004810). Reset INIT 0x00000000. PROVEN: vendor register header. Driver usage (vendor hal/drv C, uncommented call sites): 1 Get, 2 Set (hdmi_hal_cec.c): read and written (RW). ";
        field { name = "rsv_4"; desc = ""; sw = r; hw = na; reset = 0x0; } rsv_4[31:3];
        field { name = "cec_auto_ping_done"; desc = ""; sw = rw; hw = r; reset = 0x0; } cec_auto_ping_done[2:2];
        field { name = "cec_auto_ping_clear"; desc = ""; sw = rw; hw = r; reset = 0x0; } cec_auto_ping_clear[1:1];
        field { name = "cec_auto_ping_start"; desc = ""; sw = rw; hw = r; reset = 0x0; } cec_auto_ping_start[0:0];
    } CEC_AUTO_DISC @ 0x10;
    reg {
        name = "CEC_CDC_CTRL";
        desc = "CEC_CDC_CTRL (offset 0x14 in this sub-block, absolute 0x13004814). Reset INIT 0x0000F823. PROVEN: vendor register header. No call site in the vendor hal/drv C sources: access by register-name convention only (INFERRED). ";
        field { name = "rsv_6"; desc = ""; sw = r; hw = na; reset = 0x0; } rsv_6[31:16];
        field { name = "cec_cdc_opcode"; desc = ""; sw = rw; hw = r; reset = 0xF8; } cec_cdc_opcode[15:8];
        field { name = "rsv_5"; desc = ""; sw = r; hw = na; reset = 0x0; } rsv_5[7:6];
        field { name = "cec_cdc_arb_en"; desc = ""; sw = rw; hw = r; reset = 0x1; } cec_cdc_arb_en[5:5];
        field { name = "cec_cdc_arb_cnt"; desc = ""; sw = rw; hw = r; reset = 0x3; } cec_cdc_arb_cnt[4:0];
    } CEC_CDC_CTRL @ 0x14;
    reg {
        name = "CEC_AUTODISC_MAP";
        desc = "CEC_AUTODISC_MAP (offset 0x18 in this sub-block, absolute 0x13004818). Reset INIT 0x00000000. PROVEN: vendor register header. Driver usage (vendor hal/drv C, uncommented call sites): 1 Get, 0 Set (hdmi_hal_cec.c): read-only by usage (INFERRED RO). ";
        field { name = "rsv_7"; desc = ""; sw = r; hw = na; reset = 0x0; } rsv_7[31:16];
        field { name = "cec_auto_ping_map"; desc = ""; sw = r; hw = w; reset = 0x0; } cec_auto_ping_map[15:0];
    } CEC_AUTODISC_MAP @ 0x18;
    reg {
        name = "CEC_TX_INIT";
        desc = "CEC_TX_INIT (offset 0x1C in this sub-block, absolute 0x1300481C). Reset INIT 0x00000000. PROVEN: vendor register header. Driver usage (vendor hal/drv C, uncommented call sites): 0 Get, 1 Set (hdmi_hal_cec.c): only written by the driver (kept RW: a write-only register cannot be told from an unread one). ";
        field { name = "rsv_8"; desc = ""; sw = r; hw = na; reset = 0x0; } rsv_8[31:4];
        field { name = "cec_tx_init_id"; desc = ""; sw = rw; hw = r; reset = 0x0; } cec_tx_init_id[3:0];
    } CEC_TX_INIT @ 0x1C;
    reg {
        name = "CEC_TX_DEST";
        desc = "CEC_TX_DEST (offset 0x20 in this sub-block, absolute 0x13004820). Reset INIT 0x00000000. PROVEN: vendor register header. Driver usage (vendor hal/drv C, uncommented call sites): 0 Get, 3 Set (hdmi_hal_cec.c): only written by the driver (kept RW: a write-only register cannot be told from an unread one). ";
        field { name = "rsv_9"; desc = ""; sw = r; hw = na; reset = 0x0; } rsv_9[31:5];
        field { name = "cec_reg_sd_poll_intern"; desc = ""; sw = rw; hw = r; reset = 0x0; } cec_reg_sd_poll_intern[4:4];
        field { name = "cec_tx_dest_id"; desc = ""; sw = rw; hw = r; reset = 0x0; } cec_tx_dest_id[3:0];
    } CEC_TX_DEST @ 0x20;
    reg {
        name = "CEC_CAPTUTR_ID";
        desc = "CEC_CAPTUTR_ID (offset 0x24 in this sub-block, absolute 0x13004824). Reset INIT 0x00000000. PROVEN: vendor register header. Driver usage (vendor hal/drv C, uncommented call sites): 0 Get, 1 Set (hdmi_hal_cec.c): only written by the driver (kept RW: a write-only register cannot be told from an unread one). ";
        field { name = "rsv_10"; desc = ""; sw = r; hw = na; reset = 0x0; } rsv_10[31:16];
        field { name = "cec_capture_id"; desc = ""; sw = rw; hw = r; reset = 0x0; } cec_capture_id[15:0];
    } CEC_CAPTUTR_ID @ 0x24;
    reg {
        name = "TX_CEC_CMD0";
        desc = "TX_CEC_CMD0 (offset 0x28 in this sub-block, absolute 0x13004828). Reset INIT 0x00000000. PROVEN: vendor register header. Driver usage (vendor hal/drv C, uncommented call sites): 0 Get, 4 Set (hdmi_hal_cec.c): only written by the driver (kept RW: a write-only register cannot be told from an unread one). ";
        field { name = "tx_cec_operand2"; desc = ""; sw = rw; hw = r; reset = 0x0; } tx_cec_operand2[31:24];
        field { name = "tx_cec_operand1"; desc = ""; sw = rw; hw = r; reset = 0x0; } tx_cec_operand1[23:16];
        field { name = "tx_cec_operand0"; desc = ""; sw = rw; hw = r; reset = 0x0; } tx_cec_operand0[15:8];
        field { name = "tx_cec_command"; desc = ""; sw = rw; hw = r; reset = 0x0; } tx_cec_command[7:0];
    } TX_CEC_CMD0 @ 0x28;
    reg {
        name = "TX_CEC_CMD1";
        desc = "TX_CEC_CMD1 (offset 0x2C in this sub-block, absolute 0x1300482C). Reset INIT 0x00000000. PROVEN: vendor register header. Driver usage (vendor hal/drv C, uncommented call sites): 0 Get, 4 Set (hdmi_hal_cec.c): only written by the driver (kept RW: a write-only register cannot be told from an unread one). ";
        field { name = "tx_cec_operand6"; desc = ""; sw = rw; hw = r; reset = 0x0; } tx_cec_operand6[31:24];
        field { name = "tx_cec_operand5"; desc = ""; sw = rw; hw = r; reset = 0x0; } tx_cec_operand5[23:16];
        field { name = "tx_cec_operand4"; desc = ""; sw = rw; hw = r; reset = 0x0; } tx_cec_operand4[15:8];
        field { name = "tx_cec_operand3"; desc = ""; sw = rw; hw = r; reset = 0x0; } tx_cec_operand3[7:0];
    } TX_CEC_CMD1 @ 0x2C;
    reg {
        name = "TX_CEC_CMD2";
        desc = "TX_CEC_CMD2 (offset 0x30 in this sub-block, absolute 0x13004830). Reset INIT 0x00000000. PROVEN: vendor register header. Driver usage (vendor hal/drv C, uncommented call sites): 0 Get, 4 Set (hdmi_hal_cec.c): only written by the driver (kept RW: a write-only register cannot be told from an unread one). ";
        field { name = "tx_cec_operand10"; desc = ""; sw = rw; hw = r; reset = 0x0; } tx_cec_operand10[31:24];
        field { name = "tx_cec_operand9"; desc = ""; sw = rw; hw = r; reset = 0x0; } tx_cec_operand9[23:16];
        field { name = "tx_cec_operand8"; desc = ""; sw = rw; hw = r; reset = 0x0; } tx_cec_operand8[15:8];
        field { name = "tx_cec_operand7"; desc = ""; sw = rw; hw = r; reset = 0x0; } tx_cec_operand7[7:0];
    } TX_CEC_CMD2 @ 0x30;
    reg {
        name = "TX_CEC_CMD3";
        desc = "TX_CEC_CMD3 (offset 0x34 in this sub-block, absolute 0x13004834). Reset INIT 0x00000000. PROVEN: vendor register header. Driver usage (vendor hal/drv C, uncommented call sites): 0 Get, 4 Set (hdmi_hal_cec.c): only written by the driver (kept RW: a write-only register cannot be told from an unread one). ";
        field { name = "tx_cec_operand14"; desc = ""; sw = rw; hw = r; reset = 0x0; } tx_cec_operand14[31:24];
        field { name = "tx_cec_operand13"; desc = ""; sw = rw; hw = r; reset = 0x0; } tx_cec_operand13[23:16];
        field { name = "tx_cec_operand12"; desc = ""; sw = rw; hw = r; reset = 0x0; } tx_cec_operand12[15:8];
        field { name = "tx_cec_operand11"; desc = ""; sw = rw; hw = r; reset = 0x0; } tx_cec_operand11[7:0];
    } TX_CEC_CMD3 @ 0x34;
    reg {
        name = "RX_CEC_CMD0";
        desc = "RX_CEC_CMD0 (offset 0x38 in this sub-block, absolute 0x13004838). Reset INIT 0x00000000. PROVEN: vendor register header. Driver usage (vendor hal/drv C, uncommented call sites): 4 Get, 0 Set (hdmi_hal_cec.c): read-only by usage (INFERRED RO). ";
        field { name = "rx_cec_operand2"; desc = ""; sw = r; hw = w; reset = 0x0; } rx_cec_operand2[31:24];
        field { name = "rx_cec_operand1"; desc = ""; sw = r; hw = w; reset = 0x0; } rx_cec_operand1[23:16];
        field { name = "rx_cec_operand0"; desc = ""; sw = r; hw = w; reset = 0x0; } rx_cec_operand0[15:8];
        field { name = "rx_cec_command"; desc = ""; sw = r; hw = w; reset = 0x0; } rx_cec_command[7:0];
    } RX_CEC_CMD0 @ 0x38;
    reg {
        name = "RX_CEC_CMD1";
        desc = "RX_CEC_CMD1 (offset 0x3C in this sub-block, absolute 0x1300483C). Reset INIT 0x00000000. PROVEN: vendor register header. Driver usage (vendor hal/drv C, uncommented call sites): 4 Get, 0 Set (hdmi_hal_cec.c): read-only by usage (INFERRED RO). ";
        field { name = "rx_cec_operand6"; desc = ""; sw = r; hw = w; reset = 0x0; } rx_cec_operand6[31:24];
        field { name = "rx_cec_operand5"; desc = ""; sw = r; hw = w; reset = 0x0; } rx_cec_operand5[23:16];
        field { name = "rx_cec_operand4"; desc = ""; sw = r; hw = w; reset = 0x0; } rx_cec_operand4[15:8];
        field { name = "rx_cec_operand3"; desc = ""; sw = r; hw = w; reset = 0x0; } rx_cec_operand3[7:0];
    } RX_CEC_CMD1 @ 0x3C;
    reg {
        name = "RX_CEC_CMD2";
        desc = "RX_CEC_CMD2 (offset 0x40 in this sub-block, absolute 0x13004840). Reset INIT 0x00000000. PROVEN: vendor register header. Driver usage (vendor hal/drv C, uncommented call sites): 4 Get, 0 Set (hdmi_hal_cec.c): read-only by usage (INFERRED RO). ";
        field { name = "rx_cec_operand10"; desc = ""; sw = r; hw = w; reset = 0x0; } rx_cec_operand10[31:24];
        field { name = "rx_cec_operand9"; desc = ""; sw = r; hw = w; reset = 0x0; } rx_cec_operand9[23:16];
        field { name = "rx_cec_operand8"; desc = ""; sw = r; hw = w; reset = 0x0; } rx_cec_operand8[15:8];
        field { name = "rx_cec_operand7"; desc = ""; sw = r; hw = w; reset = 0x0; } rx_cec_operand7[7:0];
    } RX_CEC_CMD2 @ 0x40;
    reg {
        name = "RX_CEC_CMD3";
        desc = "RX_CEC_CMD3 (offset 0x44 in this sub-block, absolute 0x13004844). Reset INIT 0x00000000. PROVEN: vendor register header. Driver usage (vendor hal/drv C, uncommented call sites): 4 Get, 0 Set (hdmi_hal_cec.c): read-only by usage (INFERRED RO). ";
        field { name = "rx_cec_operand14"; desc = ""; sw = r; hw = w; reset = 0x0; } rx_cec_operand14[31:24];
        field { name = "rx_cec_operand13"; desc = ""; sw = r; hw = w; reset = 0x0; } rx_cec_operand13[23:16];
        field { name = "rx_cec_operand12"; desc = ""; sw = r; hw = w; reset = 0x0; } rx_cec_operand12[15:8];
        field { name = "rx_cec_operand11"; desc = ""; sw = r; hw = w; reset = 0x0; } rx_cec_operand11[7:0];
    } RX_CEC_CMD3 @ 0x44;
    reg {
        name = "CEC_OP_ABORT_0";
        desc = "CEC_OP_ABORT_0 (offset 0x48 in this sub-block, absolute 0x13004848). Reset INIT 0x00000000. PROVEN: vendor register header. No call site in the vendor hal/drv C sources: access by register-name convention only (INFERRED). ";
        field { name = "cec_op_abort_0"; desc = ""; sw = rw; hw = r; reset = 0x0; } cec_op_abort_0[31:0];
    } CEC_OP_ABORT_0 @ 0x48;
    reg {
        name = "CEC_OP_ABORT_1";
        desc = "CEC_OP_ABORT_1 (offset 0x4C in this sub-block, absolute 0x1300484C). Reset INIT 0x00000000. PROVEN: vendor register header. No call site in the vendor hal/drv C sources: access by register-name convention only (INFERRED). ";
        field { name = "cec_op_abort_1"; desc = ""; sw = rw; hw = r; reset = 0x0; } cec_op_abort_1[31:0];
    } CEC_OP_ABORT_1 @ 0x4C;
    reg {
        name = "CEC_OP_ABORT_2";
        desc = "CEC_OP_ABORT_2 (offset 0x50 in this sub-block, absolute 0x13004850). Reset INIT 0x00000000. PROVEN: vendor register header. No call site in the vendor hal/drv C sources: access by register-name convention only (INFERRED). ";
        field { name = "cec_op_abort_2"; desc = ""; sw = rw; hw = r; reset = 0x0; } cec_op_abort_2[31:0];
    } CEC_OP_ABORT_2 @ 0x50;
    reg {
        name = "CEC_OP_ABORT_3";
        desc = "CEC_OP_ABORT_3 (offset 0x54 in this sub-block, absolute 0x13004854). Reset INIT 0x00000000. PROVEN: vendor register header. No call site in the vendor hal/drv C sources: access by register-name convention only (INFERRED). ";
        field { name = "cec_op_abort_3"; desc = ""; sw = rw; hw = r; reset = 0x0; } cec_op_abort_3[31:0];
    } CEC_OP_ABORT_3 @ 0x54;
    reg {
        name = "CEC_OP_ABORT_4";
        desc = "CEC_OP_ABORT_4 (offset 0x58 in this sub-block, absolute 0x13004858). Reset INIT 0x00000000. PROVEN: vendor register header. No call site in the vendor hal/drv C sources: access by register-name convention only (INFERRED). ";
        field { name = "cec_op_abort_4"; desc = ""; sw = rw; hw = r; reset = 0x0; } cec_op_abort_4[31:0];
    } CEC_OP_ABORT_4 @ 0x58;
    reg {
        name = "CEC_OP_ABORT_5";
        desc = "CEC_OP_ABORT_5 (offset 0x5C in this sub-block, absolute 0x1300485C). Reset INIT 0x00000000. PROVEN: vendor register header. No call site in the vendor hal/drv C sources: access by register-name convention only (INFERRED). ";
        field { name = "cec_op_abort_5"; desc = ""; sw = rw; hw = r; reset = 0x0; } cec_op_abort_5[31:0];
    } CEC_OP_ABORT_5 @ 0x5C;
    reg {
        name = "CEC_OP_ABORT_6";
        desc = "CEC_OP_ABORT_6 (offset 0x60 in this sub-block, absolute 0x13004860). Reset INIT 0x00000000. PROVEN: vendor register header. No call site in the vendor hal/drv C sources: access by register-name convention only (INFERRED). ";
        field { name = "cec_op_abort_6"; desc = ""; sw = rw; hw = r; reset = 0x0; } cec_op_abort_6[31:0];
    } CEC_OP_ABORT_6 @ 0x60;
    reg {
        name = "CEC_OP_ABORT_7";
        desc = "CEC_OP_ABORT_7 (offset 0x64 in this sub-block, absolute 0x13004864). Reset INIT 0x00000000. PROVEN: vendor register header. No call site in the vendor hal/drv C sources: access by register-name convention only (INFERRED). ";
        field { name = "cec_op_abort_7"; desc = ""; sw = rw; hw = r; reset = 0x0; } cec_op_abort_7[31:0];
    } CEC_OP_ABORT_7 @ 0x64;
};

regfile eHI3536D_HDMI_ctrl {
    name = "HDMI TX ctrl, Hi3536D V100 / HDMI v2 (hisiv100)";
    desc = "TX control (reset/power, SCDC FSM, interrupts). Offsets are relative to the sub-block base 0x13000000 (HDMI TX window 0x13000000 + 0x0). Provenance: PROVEN (vendor code): register names, offsets, field names/bit ranges and reset (INIT) values come from the machine-generated register headers of the vendor HDMI v2 driver (nManager-generated hdmi_reg_ctrl.h, product/hiosd/hdmi/hdmi_v2/drv/hal in the vendor U-Boot tree for the Hi3536D/Hi3536C/Hi3531D/Hi3521D family, source: sources/openipc-u-boot-hi3536dv100); the Hi3536D V100 maps the window at 0x13000000 per its hdmi_product_define.h and the closed hi3536dv100_hdmi.ko symbol names (HDMI_TX_S_*_REGS_TYPE_Init) agree. INFERRED: access types. Of the 503 register definitions in the vendor headers only 38 carry an ATTR (all RW); the others have none, so fields are modelled read/write except reserved/rsv fields and registers whose names mark them read-only by convention where the vendor hal/drv C sources call the accessors (203 registers) a register only ever read is modelled sw=r and the call-site counts are in each register description; for the other registers the name convention (SW_VER*, HW_INFO/HW_VERSION/HW_FEATURE, _STATUS, _STAT, _STATE, _OUT<n>: sw=r) is used. The 8051 MCU window (mcu sub-block) is modelled the same way and its function is inferred from the HDCP2X_* names only and hardware behavior; nothing run on hardware. NOT in the data sheet (no HDMI TX chapter)." ;
    reg {
        name = "TX_PWD_RST_CTRL";
        desc = "TX_PWD_RST_CTRL (offset 0x10 in this sub-block, absolute 0x13000010). Reset INIT 0x00000400. PROVEN: vendor register header. Driver usage (vendor hal/drv C, uncommented call sites): 0 Get, 8 Set (hdmi_hal_ctrl.c, hdmi_hal_hdcp22.c): only written by the driver (kept RW: a write-only register cannot be told from an unread one). ";
        field { name = "rsv_0"; desc = ""; sw = r; hw = na; reset = 0x0; } rsv_0[31:11];
        field { name = "tx_mcu_srst_req"; desc = ""; sw = rw; hw = r; reset = 0x1; } tx_mcu_srst_req[10:10];
        field { name = "tx_hdcp2x_srst_req"; desc = ""; sw = rw; hw = r; reset = 0x0; } tx_hdcp2x_srst_req[9:9];
        field { name = "tx_afifo_srst_req"; desc = ""; sw = rw; hw = r; reset = 0x0; } tx_afifo_srst_req[8:8];
        field { name = "tx_acr_srst_req"; desc = ""; sw = rw; hw = r; reset = 0x0; } tx_acr_srst_req[7:7];
        field { name = "tx_aud_srst_req"; desc = ""; sw = rw; hw = r; reset = 0x0; } tx_aud_srst_req[6:6];
        field { name = "tx_phy_srst_req"; desc = ""; sw = rw; hw = r; reset = 0x0; } tx_phy_srst_req[5:5];
        field { name = "tx_hdcp1x_srst_req"; desc = ""; sw = rw; hw = r; reset = 0x0; } tx_hdcp1x_srst_req[4:4];
        field { name = "tx_hdmi_srst_req"; desc = ""; sw = rw; hw = r; reset = 0x0; } tx_hdmi_srst_req[3:3];
        field { name = "tx_vid_srst_req"; desc = ""; sw = rw; hw = r; reset = 0x0; } tx_vid_srst_req[2:2];
        field { name = "tx_sys_srst_req"; desc = ""; sw = rw; hw = r; reset = 0x0; } tx_sys_srst_req[1:1];
        field { name = "tx_pwd_srst_req"; desc = ""; sw = rw; hw = r; reset = 0x0; } tx_pwd_srst_req[0:0];
    } TX_PWD_RST_CTRL @ 0x10;
    reg {
        name = "SCDC_FSM_CTRL";
        desc = "SCDC_FSM_CTRL (offset 0x14 in this sub-block, absolute 0x13000014). Reset INIT 0x00000020. PROVEN: vendor register header. No call site in the vendor hal/drv C sources: access by register-name convention only (INFERRED). ";
        field { name = "rsv_1"; desc = ""; sw = r; hw = na; reset = 0x0; } rsv_1[31:8];
        field { name = "scdc_stall_req"; desc = ""; sw = rw; hw = r; reset = 0x0; } scdc_stall_req[7:7];
        field { name = "scdc_hdcp_det_en"; desc = ""; sw = rw; hw = r; reset = 0x0; } scdc_hdcp_det_en[6:6];
        field { name = "scdc_poll_sel"; desc = ""; sw = rw; hw = r; reset = 0x1; } scdc_poll_sel[5:5];
        field { name = "scdc_auto_reply_stop"; desc = ""; sw = rw; hw = r; reset = 0x0; } scdc_auto_reply_stop[4:4];
        field { name = "scdc_auto_poll"; desc = ""; sw = rw; hw = r; reset = 0x0; } scdc_auto_poll[3:3];
        field { name = "scdc_auto_reply"; desc = ""; sw = rw; hw = r; reset = 0x0; } scdc_auto_reply[2:2];
        field { name = "scdc_access_en"; desc = ""; sw = rw; hw = r; reset = 0x0; } scdc_access_en[1:1];
        field { name = "scdc_ddcm_abort"; desc = ""; sw = rw; hw = r; reset = 0x0; } scdc_ddcm_abort[0:0];
    } SCDC_FSM_CTRL @ 0x14;
    reg {
        name = "SCDC_POLL_TIMER";
        desc = "SCDC_POLL_TIMER (offset 0x18 in this sub-block, absolute 0x13000018). Reset INIT 0x00249F00. PROVEN: vendor register header. No call site in the vendor hal/drv C sources: access by register-name convention only (INFERRED). ";
        field { name = "rsv_2"; desc = ""; sw = r; hw = na; reset = 0x0; } rsv_2[31:22];
        field { name = "scdc_poll_timer"; desc = ""; sw = rw; hw = r; reset = 0x249F00; } scdc_poll_timer[21:0];
    } SCDC_POLL_TIMER @ 0x18;
    reg {
        name = "SCDC_FSM_STATE";
        desc = "SCDC_FSM_STATE (offset 0x1C in this sub-block, absolute 0x1300001C). Reset INIT 0x00000000. PROVEN: vendor register header. No call site in the vendor hal/drv C sources: access by register-name convention only (INFERRED). ";
        field { name = "rsv_3"; desc = ""; sw = r; hw = na; reset = 0x0; } rsv_3[31:11];
        field { name = "scdc_rreq_in_prog"; desc = ""; sw = r; hw = w; reset = 0x0; } scdc_rreq_in_prog[10:10];
        field { name = "scdc_in_prog"; desc = ""; sw = r; hw = w; reset = 0x0; } scdc_in_prog[9:9];
        field { name = "scdc_active"; desc = ""; sw = r; hw = w; reset = 0x0; } scdc_active[8:8];
        field { name = "scdc_rreq_state"; desc = ""; sw = r; hw = w; reset = 0x0; } scdc_rreq_state[7:4];
        field { name = "scdc_fsm_state"; desc = ""; sw = r; hw = w; reset = 0x0; } scdc_fsm_state[3:0];
    } SCDC_FSM_STATE @ 0x1C;
    reg {
        name = "SCDC_FLAG_BTYE";
        desc = "SCDC_FLAG_BTYE (offset 0x20 in this sub-block, absolute 0x13000020). Reset INIT 0x00000000. PROVEN: vendor register header. No call site in the vendor hal/drv C sources: access by register-name convention only (INFERRED). ";
        field { name = "rsv_4"; desc = ""; sw = r; hw = na; reset = 0x0; } rsv_4[31:16];
        field { name = "scdc_flag_byte1"; desc = ""; sw = rw; hw = r; reset = 0x0; } scdc_flag_byte1[15:8];
        field { name = "scdc_flag_byte0"; desc = ""; sw = rw; hw = r; reset = 0x0; } scdc_flag_byte0[7:0];
    } SCDC_FLAG_BTYE @ 0x20;
    reg {
        name = "PWD_FIFO_RDATA";
        desc = "PWD_FIFO_RDATA (offset 0x38 in this sub-block, absolute 0x13000038). Reset INIT 0x00000000. PROVEN: vendor register header. Driver usage (vendor hal/drv C, uncommented call sites): 1 Get, 0 Set (hdmi_hal_ddc.c): read-only by usage (INFERRED RO). ";
        field { name = "rsv_5"; desc = ""; sw = r; hw = na; reset = 0x0; } rsv_5[31:8];
        field { name = "pwd_fifo_data_out"; desc = ""; sw = r; hw = w; reset = 0x0; } pwd_fifo_data_out[7:0];
    } PWD_FIFO_RDATA @ 0x38;
    reg {
        name = "PWD_FIFO_WDATA";
        desc = "PWD_FIFO_WDATA (offset 0x3C in this sub-block, absolute 0x1300003C). Reset INIT 0x00000000. PROVEN: vendor register header. Driver usage (vendor hal/drv C, uncommented call sites): 0 Get, 1 Set (hdmi_hal_ddc.c): only written by the driver (kept RW: a write-only register cannot be told from an unread one). ";
        field { name = "rsv_6"; desc = ""; sw = r; hw = na; reset = 0x0; } rsv_6[31:8];
        field { name = "pwd_fifo_data_in"; desc = ""; sw = rw; hw = r; reset = 0x0; } pwd_fifo_data_in[7:0];
    } PWD_FIFO_WDATA @ 0x3C;
    reg {
        name = "PWD_DATA_CNT";
        desc = "PWD_DATA_CNT (offset 0x40 in this sub-block, absolute 0x13000040). Reset INIT 0x00000000. PROVEN: vendor register header. Driver usage (vendor hal/drv C, uncommented call sites): 2 Get, 1 Set (hdmi_hal_ddc.c): read and written (RW). ";
        field { name = "rsv_8"; desc = ""; sw = r; hw = na; reset = 0x0; } rsv_8[31:18];
        field { name = "pwd_data_out_cnt"; desc = ""; sw = rw; hw = r; reset = 0x0; } pwd_data_out_cnt[17:8];
        field { name = "rsv_7"; desc = ""; sw = r; hw = na; reset = 0x0; } rsv_7[7:5];
        field { name = "pwd_fifo_data_cnt"; desc = ""; sw = rw; hw = r; reset = 0x0; } pwd_fifo_data_cnt[4:0];
    } PWD_DATA_CNT @ 0x40;
    reg {
        name = "PWD_SLAVE_CFG";
        desc = "PWD_SLAVE_CFG (offset 0x44 in this sub-block, absolute 0x13000044). Reset INIT 0x000000A0. PROVEN: vendor register header. Driver usage (vendor hal/drv C, uncommented call sites): 0 Get, 3 Set (hdmi_hal_ddc.c): only written by the driver (kept RW: a write-only register cannot be told from an unread one). ";
        field { name = "rsv_9"; desc = ""; sw = r; hw = na; reset = 0x0; } rsv_9[31:24];
        field { name = "pwd_slave_seg"; desc = ""; sw = rw; hw = r; reset = 0x0; } pwd_slave_seg[23:16];
        field { name = "pwd_slave_offset"; desc = ""; sw = rw; hw = r; reset = 0x0; } pwd_slave_offset[15:8];
        field { name = "pwd_slave_addr"; desc = ""; sw = rw; hw = r; reset = 0xA0; } pwd_slave_addr[7:0];
    } PWD_SLAVE_CFG @ 0x44;
    reg {
        name = "PWD_MST_STATE";
        desc = "PWD_MST_STATE (offset 0x48 in this sub-block, absolute 0x13000048). Reset INIT 0x00000020. PROVEN: vendor register header. Driver usage (vendor hal/drv C, uncommented call sites): 2 Get, 0 Set (hdmi_hal_ddc.c): read-only by usage (INFERRED RO). ";
        field { name = "rsv_10"; desc = ""; sw = r; hw = na; reset = 0x0; } rsv_10[31:8];
        field { name = "pwd_fifo_full"; desc = ""; sw = r; hw = w; reset = 0x0; } pwd_fifo_full[7:7];
        field { name = "pwd_fifo_half_full"; desc = ""; sw = r; hw = w; reset = 0x0; } pwd_fifo_half_full[6:6];
        field { name = "pwd_fifo_empty"; desc = ""; sw = r; hw = w; reset = 0x1; } pwd_fifo_empty[5:5];
        field { name = "pwd_fifo_rd_in_use"; desc = ""; sw = r; hw = w; reset = 0x0; } pwd_fifo_rd_in_use[4:4];
        field { name = "pwd_fifo_wr_in_use"; desc = ""; sw = r; hw = w; reset = 0x0; } pwd_fifo_wr_in_use[3:3];
        field { name = "pwd_i2c_in_prog"; desc = ""; sw = r; hw = w; reset = 0x0; } pwd_i2c_in_prog[2:2];
        field { name = "pwd_i2c_bus_low"; desc = ""; sw = r; hw = w; reset = 0x0; } pwd_i2c_bus_low[1:1];
        field { name = "pwd_i2c_no_ack"; desc = ""; sw = r; hw = w; reset = 0x0; } pwd_i2c_no_ack[0:0];
    } PWD_MST_STATE @ 0x48;
    reg {
        name = "PWD_MST_CMD";
        desc = "PWD_MST_CMD (offset 0x4C in this sub-block, absolute 0x1300004C). Reset INIT 0x00000000. PROVEN: vendor register header. Driver usage (vendor hal/drv C, uncommented call sites): 0 Get, 2 Set (hdmi_hal_ddc.c): only written by the driver (kept RW: a write-only register cannot be told from an unread one). ";
        field { name = "rsv_11"; desc = ""; sw = r; hw = na; reset = 0x0; } rsv_11[31:4];
        field { name = "pwd_mst_cmd"; desc = ""; sw = rw; hw = r; reset = 0x0; } pwd_mst_cmd[3:0];
    } PWD_MST_CMD @ 0x4C;
    reg {
        name = "PWD_MST_CLR";
        desc = "PWD_MST_CLR (offset 0x50 in this sub-block, absolute 0x13000050). Reset INIT 0x00000000. PROVEN: vendor register header. No call site in the vendor hal/drv C sources: access by register-name convention only (INFERRED). ";
        field { name = "rsv_12"; desc = ""; sw = r; hw = na; reset = 0x0; } rsv_12[31:2];
        field { name = "pwd_clr_no_ack"; desc = ""; sw = rw; hw = r; reset = 0x0; } pwd_clr_no_ack[1:1];
        field { name = "pwd_clr_bus_low"; desc = ""; sw = rw; hw = r; reset = 0x0; } pwd_clr_bus_low[0:0];
    } PWD_MST_CLR @ 0x50;
    reg {
        name = "DDC_MST_ARB_CTRL";
        desc = "DDC_MST_ARB_CTRL (offset 0x64 in this sub-block, absolute 0x13000064). Reset INIT 0x00000002. PROVEN: vendor register header. No call site in the vendor hal/drv C sources: access by register-name convention only (INFERRED). ";
        field { name = "rsv_13"; desc = ""; sw = r; hw = na; reset = 0x0; } rsv_13[31:2];
        field { name = "reg_auto_abort_en"; desc = ""; sw = rw; hw = r; reset = 0x1; } reg_auto_abort_en[1:1];
        field { name = "cpu_ddc_force_req"; desc = ""; sw = rw; hw = r; reset = 0x0; } cpu_ddc_force_req[0:0];
    } DDC_MST_ARB_CTRL @ 0x64;
    reg {
        name = "DDC_MST_ARB_REQ";
        desc = "DDC_MST_ARB_REQ (offset 0x68 in this sub-block, absolute 0x13000068). Reset INIT 0x00000000. PROVEN: vendor register header. No call site in the vendor hal/drv C sources: access by register-name convention only (INFERRED). ";
        field { name = "rsv_14"; desc = ""; sw = r; hw = na; reset = 0x0; } rsv_14[31:1];
        field { name = "cpu_ddc_req"; desc = ""; sw = rw; hw = r; reset = 0x0; } cpu_ddc_req[0:0];
    } DDC_MST_ARB_REQ @ 0x68;
    reg {
        name = "DDC_MST_ARB_ACK";
        desc = "DDC_MST_ARB_ACK (offset 0x6C in this sub-block, absolute 0x1300006C). Reset INIT 0x00000000. PROVEN: vendor register header. No call site in the vendor hal/drv C sources: access by register-name convention only (INFERRED). ";
        field { name = "rsv_15"; desc = ""; sw = r; hw = na; reset = 0x0; } rsv_15[31:1];
        field { name = "cpu_ddc_req_ack"; desc = ""; sw = rw; hw = r; reset = 0x0; } cpu_ddc_req_ack[0:0];
    } DDC_MST_ARB_ACK @ 0x6C;
    reg {
        name = "DDC_MST_ARB_STATE";
        desc = "DDC_MST_ARB_STATE (offset 0x70 in this sub-block, absolute 0x13000070). Reset INIT 0x00000000. PROVEN: vendor register header. No call site in the vendor hal/drv C sources: access by register-name convention only (INFERRED). ";
        field { name = "rsv_16"; desc = ""; sw = r; hw = na; reset = 0x0; } rsv_16[31:9];
        field { name = "ddc_arb_state"; desc = ""; sw = r; hw = w; reset = 0x0; } ddc_arb_state[8:0];
    } DDC_MST_ARB_STATE @ 0x70;
    reg {
        name = "TX_PWD_INTR_STATE";
        desc = "TX_PWD_INTR_STATE (offset 0x100 in this sub-block, absolute 0x13000100). Reset INIT 0x00000000. PROVEN: vendor register header. No call site in the vendor hal/drv C sources: access by register-name convention only (INFERRED). ";
        field { name = "rsv_17"; desc = ""; sw = r; hw = na; reset = 0x0; } rsv_17[31:1];
        field { name = "tx_pwd_intr_state"; desc = ""; sw = r; hw = w; reset = 0x0; } tx_pwd_intr_state[0:0];
    } TX_PWD_INTR_STATE @ 0x100;
    reg {
        name = "PWD_SUB_INTR_STATE";
        desc = "PWD_SUB_INTR_STATE (offset 0x104 in this sub-block, absolute 0x13000104). Reset INIT 0x00000000. PROVEN: vendor register header. No call site in the vendor hal/drv C sources: access by register-name convention only (INFERRED). ";
        field { name = "rsv_18"; desc = ""; sw = r; hw = na; reset = 0x0; } rsv_18[31:6];
        field { name = "hdcp2x_intr_state"; desc = ""; sw = r; hw = w; reset = 0x0; } hdcp2x_intr_state[5:5];
        field { name = "txhdcp_intr_state"; desc = ""; sw = r; hw = w; reset = 0x0; } txhdcp_intr_state[4:4];
        field { name = "txhdmi_intr_state"; desc = ""; sw = r; hw = w; reset = 0x0; } txhdmi_intr_state[3:3];
        field { name = "audpath_intr_state"; desc = ""; sw = r; hw = w; reset = 0x0; } audpath_intr_state[2:2];
        field { name = "vidpath_intr_state"; desc = ""; sw = r; hw = w; reset = 0x0; } vidpath_intr_state[1:1];
        field { name = "tx_sys_intr_state"; desc = ""; sw = r; hw = w; reset = 0x0; } tx_sys_intr_state[0:0];
    } PWD_SUB_INTR_STATE @ 0x104;
    reg {
        name = "PWD_SUB_INTR_MASK";
        desc = "PWD_SUB_INTR_MASK (offset 0x108 in this sub-block, absolute 0x13000108). Reset INIT 0x00000000. PROVEN: vendor register header. No call site in the vendor hal/drv C sources: access by register-name convention only (INFERRED). ";
        field { name = "rsv_19"; desc = ""; sw = r; hw = na; reset = 0x0; } rsv_19[31:6];
        field { name = "hdcp2x_intr_mask"; desc = ""; sw = rw; hw = r; reset = 0x0; } hdcp2x_intr_mask[5:5];
        field { name = "txhdcp_intr_mask"; desc = ""; sw = rw; hw = r; reset = 0x0; } txhdcp_intr_mask[4:4];
        field { name = "txhdmi_intr_mask"; desc = ""; sw = rw; hw = r; reset = 0x0; } txhdmi_intr_mask[3:3];
        field { name = "audpath_intr_mask"; desc = ""; sw = rw; hw = r; reset = 0x0; } audpath_intr_mask[2:2];
        field { name = "vidpath_intr_mask"; desc = ""; sw = rw; hw = r; reset = 0x0; } vidpath_intr_mask[1:1];
        field { name = "tx_sys_intr_mask"; desc = ""; sw = rw; hw = r; reset = 0x0; } tx_sys_intr_mask[0:0];
    } PWD_SUB_INTR_MASK @ 0x108;
    reg {
        name = "TXSYS_INTR_STATE";
        desc = "TXSYS_INTR_STATE (offset 0x10C in this sub-block, absolute 0x1300010C). Reset INIT 0x00000000. PROVEN: vendor register header. No call site in the vendor hal/drv C sources: access by register-name convention only (INFERRED). ";
        field { name = "rsv_20"; desc = ""; sw = r; hw = na; reset = 0x0; } rsv_20[31:6];
        field { name = "tx_sys_intr_state5"; desc = ""; sw = r; hw = w; reset = 0x0; } tx_sys_intr_state5[5:5];
        field { name = "tx_sys_intr_state4"; desc = ""; sw = r; hw = w; reset = 0x0; } tx_sys_intr_state4[4:4];
        field { name = "tx_sys_intr_state3"; desc = ""; sw = r; hw = w; reset = 0x0; } tx_sys_intr_state3[3:3];
        field { name = "tx_sys_intr_state2"; desc = ""; sw = r; hw = w; reset = 0x0; } tx_sys_intr_state2[2:2];
        field { name = "tx_sys_intr_state1"; desc = ""; sw = r; hw = w; reset = 0x0; } tx_sys_intr_state1[1:1];
        field { name = "tx_sys_intr_state0"; desc = ""; sw = r; hw = w; reset = 0x0; } tx_sys_intr_state0[0:0];
    } TXSYS_INTR_STATE @ 0x10C;
    reg {
        name = "TXSYS_INTR_MASK";
        desc = "TXSYS_INTR_MASK (offset 0x110 in this sub-block, absolute 0x13000110). Reset INIT 0x00000000. PROVEN: vendor register header. No call site in the vendor hal/drv C sources: access by register-name convention only (INFERRED). ";
        field { name = "rsv_21"; desc = ""; sw = r; hw = na; reset = 0x0; } rsv_21[31:6];
        field { name = "tx_sys_intr_mask5"; desc = ""; sw = rw; hw = r; reset = 0x0; } tx_sys_intr_mask5[5:5];
        field { name = "tx_sys_intr_mask4"; desc = ""; sw = rw; hw = r; reset = 0x0; } tx_sys_intr_mask4[4:4];
        field { name = "tx_sys_intr_mask3"; desc = ""; sw = rw; hw = r; reset = 0x0; } tx_sys_intr_mask3[3:3];
        field { name = "tx_sys_intr_mask2"; desc = ""; sw = rw; hw = r; reset = 0x0; } tx_sys_intr_mask2[2:2];
        field { name = "tx_sys_intr_mask1"; desc = ""; sw = rw; hw = r; reset = 0x0; } tx_sys_intr_mask1[1:1];
        field { name = "tx_sys_intr_mask0"; desc = ""; sw = rw; hw = r; reset = 0x0; } tx_sys_intr_mask0[0:0];
    } TXSYS_INTR_MASK @ 0x110;
    reg {
        name = "VIDPATH_INTR_STATE";
        desc = "VIDPATH_INTR_STATE (offset 0x114 in this sub-block, absolute 0x13000114). Reset INIT 0x00000000. PROVEN: vendor register header. No call site in the vendor hal/drv C sources: access by register-name convention only (INFERRED). ";
        field { name = "rsv_22"; desc = ""; sw = r; hw = na; reset = 0x0; } rsv_22[31:7];
        field { name = "vidpath_intr_state6"; desc = ""; sw = r; hw = w; reset = 0x0; } vidpath_intr_state6[6:6];
        field { name = "vidpath_intr_state5"; desc = ""; sw = r; hw = w; reset = 0x0; } vidpath_intr_state5[5:5];
        field { name = "vidpath_intr_state4"; desc = ""; sw = r; hw = w; reset = 0x0; } vidpath_intr_state4[4:4];
        field { name = "vidpath_intr_state3"; desc = ""; sw = r; hw = w; reset = 0x0; } vidpath_intr_state3[3:3];
        field { name = "vidpath_intr_state2"; desc = ""; sw = r; hw = w; reset = 0x0; } vidpath_intr_state2[2:2];
        field { name = "vidpath_intr_state1"; desc = ""; sw = r; hw = w; reset = 0x0; } vidpath_intr_state1[1:1];
        field { name = "vidpath_intr_state0"; desc = ""; sw = r; hw = w; reset = 0x0; } vidpath_intr_state0[0:0];
    } VIDPATH_INTR_STATE @ 0x114;
    reg {
        name = "VIDPATH_INTR_MASK";
        desc = "VIDPATH_INTR_MASK (offset 0x118 in this sub-block, absolute 0x13000118). Reset INIT 0x00000000. PROVEN: vendor register header. No call site in the vendor hal/drv C sources: access by register-name convention only (INFERRED). ";
        field { name = "rsv_23"; desc = ""; sw = r; hw = na; reset = 0x0; } rsv_23[31:7];
        field { name = "vidpath_intr_mask6"; desc = ""; sw = rw; hw = r; reset = 0x0; } vidpath_intr_mask6[6:6];
        field { name = "vidpath_intr_mask5"; desc = ""; sw = rw; hw = r; reset = 0x0; } vidpath_intr_mask5[5:5];
        field { name = "vidpath_intr_mask4"; desc = ""; sw = rw; hw = r; reset = 0x0; } vidpath_intr_mask4[4:4];
        field { name = "vidpath_intr_mask3"; desc = ""; sw = rw; hw = r; reset = 0x0; } vidpath_intr_mask3[3:3];
        field { name = "vidpath_intr_mask2"; desc = ""; sw = rw; hw = r; reset = 0x0; } vidpath_intr_mask2[2:2];
        field { name = "vidpath_intr_mask1"; desc = ""; sw = rw; hw = r; reset = 0x0; } vidpath_intr_mask1[1:1];
        field { name = "vidpath_intr_mask0"; desc = ""; sw = rw; hw = r; reset = 0x0; } vidpath_intr_mask0[0:0];
    } VIDPATH_INTR_MASK @ 0x118;
    reg {
        name = "AUDPATH_INTR_STATE";
        desc = "AUDPATH_INTR_STATE (offset 0x11C in this sub-block, absolute 0x1300011C). Reset INIT 0x00000000. PROVEN: vendor register header. No call site in the vendor hal/drv C sources: access by register-name convention only (INFERRED). ";
        field { name = "rsv_24"; desc = ""; sw = r; hw = na; reset = 0x0; } rsv_24[31:9];
        field { name = "audpath_intr_state8"; desc = ""; sw = r; hw = w; reset = 0x0; } audpath_intr_state8[8:8];
        field { name = "audpath_intr_state7"; desc = ""; sw = r; hw = w; reset = 0x0; } audpath_intr_state7[7:7];
        field { name = "audpath_intr_state6"; desc = ""; sw = r; hw = w; reset = 0x0; } audpath_intr_state6[6:6];
        field { name = "audpath_intr_state5"; desc = ""; sw = r; hw = w; reset = 0x0; } audpath_intr_state5[5:5];
        field { name = "audpath_intr_state4"; desc = ""; sw = r; hw = w; reset = 0x0; } audpath_intr_state4[4:4];
        field { name = "audpath_intr_state3"; desc = ""; sw = r; hw = w; reset = 0x0; } audpath_intr_state3[3:3];
        field { name = "audpath_intr_state2"; desc = ""; sw = r; hw = w; reset = 0x0; } audpath_intr_state2[2:2];
        field { name = "audpath_intr_state1"; desc = ""; sw = r; hw = w; reset = 0x0; } audpath_intr_state1[1:1];
        field { name = "audpath_intr_state0"; desc = ""; sw = r; hw = w; reset = 0x0; } audpath_intr_state0[0:0];
    } AUDPATH_INTR_STATE @ 0x11C;
    reg {
        name = "AUDPATH_INTR_MASK";
        desc = "AUDPATH_INTR_MASK (offset 0x120 in this sub-block, absolute 0x13000120). Reset INIT 0x00000000. PROVEN: vendor register header. No call site in the vendor hal/drv C sources: access by register-name convention only (INFERRED). ";
        field { name = "rsv_25"; desc = ""; sw = r; hw = na; reset = 0x0; } rsv_25[31:9];
        field { name = "audpath_intr_mask8"; desc = ""; sw = rw; hw = r; reset = 0x0; } audpath_intr_mask8[8:8];
        field { name = "audpath_intr_mask7"; desc = ""; sw = rw; hw = r; reset = 0x0; } audpath_intr_mask7[7:7];
        field { name = "audpath_intr_mask6"; desc = ""; sw = rw; hw = r; reset = 0x0; } audpath_intr_mask6[6:6];
        field { name = "audpath_intr_mask5"; desc = ""; sw = rw; hw = r; reset = 0x0; } audpath_intr_mask5[5:5];
        field { name = "audpath_intr_mask4"; desc = ""; sw = rw; hw = r; reset = 0x0; } audpath_intr_mask4[4:4];
        field { name = "audpath_intr_mask3"; desc = ""; sw = rw; hw = r; reset = 0x0; } audpath_intr_mask3[3:3];
        field { name = "audpath_intr_mask2"; desc = ""; sw = rw; hw = r; reset = 0x0; } audpath_intr_mask2[2:2];
        field { name = "audpath_intr_mask1"; desc = ""; sw = rw; hw = r; reset = 0x0; } audpath_intr_mask1[1:1];
        field { name = "audpath_intr_mask0"; desc = ""; sw = rw; hw = r; reset = 0x0; } audpath_intr_mask0[0:0];
    } AUDPATH_INTR_MASK @ 0x120;
    reg {
        name = "TXHDMI_INTR_STATE";
        desc = "TXHDMI_INTR_STATE (offset 0x124 in this sub-block, absolute 0x13000124). Reset INIT 0x00000000. PROVEN: vendor register header. No call site in the vendor hal/drv C sources: access by register-name convention only (INFERRED). ";
        field { name = "rsv_26"; desc = ""; sw = r; hw = na; reset = 0x0; } rsv_26[31:1];
        field { name = "txhdmi_intr_state0"; desc = ""; sw = r; hw = w; reset = 0x0; } txhdmi_intr_state0[0:0];
    } TXHDMI_INTR_STATE @ 0x124;
    reg {
        name = "TXHDMI_INTR_MASK";
        desc = "TXHDMI_INTR_MASK (offset 0x128 in this sub-block, absolute 0x13000128). Reset INIT 0x00000000. PROVEN: vendor register header. No call site in the vendor hal/drv C sources: access by register-name convention only (INFERRED). ";
        field { name = "rsv_27"; desc = ""; sw = r; hw = na; reset = 0x0; } rsv_27[31:1];
        field { name = "txhdmi_intr_mask0"; desc = ""; sw = rw; hw = r; reset = 0x0; } txhdmi_intr_mask0[0:0];
    } TXHDMI_INTR_MASK @ 0x128;
    reg {
        name = "HDCP_INTR_STATE";
        desc = "HDCP_INTR_STATE (offset 0x12C in this sub-block, absolute 0x1300012C). Reset INIT 0x00000000. PROVEN: vendor register header. No call site in the vendor hal/drv C sources: access by register-name convention only (INFERRED). ";
        field { name = "rsv_28"; desc = ""; sw = r; hw = na; reset = 0x0; } rsv_28[31:2];
        field { name = "hdcp_intr_state1"; desc = ""; sw = r; hw = w; reset = 0x0; } hdcp_intr_state1[1:1];
        field { name = "hdcp_intr_state0"; desc = ""; sw = r; hw = w; reset = 0x0; } hdcp_intr_state0[0:0];
    } HDCP_INTR_STATE @ 0x12C;
    reg {
        name = "HDCP_INTR_MASK";
        desc = "HDCP_INTR_MASK (offset 0x130 in this sub-block, absolute 0x13000130). Reset INIT 0x00000000. PROVEN: vendor register header. No call site in the vendor hal/drv C sources: access by register-name convention only (INFERRED). ";
        field { name = "rsv_29"; desc = ""; sw = r; hw = na; reset = 0x0; } rsv_29[31:2];
        field { name = "hdcp_intr_mask1"; desc = ""; sw = rw; hw = r; reset = 0x0; } hdcp_intr_mask1[1:1];
        field { name = "hdcp_intr_mask0"; desc = ""; sw = rw; hw = r; reset = 0x0; } hdcp_intr_mask0[0:0];
    } HDCP_INTR_MASK @ 0x130;
};

regfile eHI3536D_HDMI_hdcp {
    name = "HDMI TX hdcp, Hi3536D V100 / HDMI v2 (hisiv100)";
    desc = "TX HDCP 1.x. Offsets are relative to the sub-block base 0x13002000 (HDMI TX window 0x13000000 + 0x2000). Provenance: PROVEN (vendor code): register names, offsets, field names/bit ranges and reset (INIT) values come from the machine-generated register headers of the vendor HDMI v2 driver (nManager-generated hdmi_reg_hdcp.h, product/hiosd/hdmi/hdmi_v2/drv/hal in the vendor U-Boot tree for the Hi3536D/Hi3536C/Hi3531D/Hi3521D family, source: sources/openipc-u-boot-hi3536dv100); the Hi3536D V100 maps the window at 0x13000000 per its hdmi_product_define.h and the closed hi3536dv100_hdmi.ko symbol names (HDMI_TX_S_*_REGS_TYPE_Init) agree. INFERRED: access types. Of the 503 register definitions in the vendor headers only 38 carry an ATTR (all RW); the others have none, so fields are modelled read/write except reserved/rsv fields and registers whose names mark them read-only by convention where the vendor hal/drv C sources call the accessors (203 registers) a register only ever read is modelled sw=r and the call-site counts are in each register description; for the other registers the name convention (SW_VER*, HW_INFO/HW_VERSION/HW_FEATURE, _STATUS, _STAT, _STATE, _OUT<n>: sw=r) is used. The 8051 MCU window (mcu sub-block) is modelled the same way and its function is inferred from the HDCP2X_* names only and hardware behavior; nothing run on hardware. NOT in the data sheet (no HDMI TX chapter)." ;
    reg {
        name = "HDCP1X_MEM_CTRL";
        desc = "HDCP1X_MEM_CTRL (offset 0x0 in this sub-block, absolute 0x13002000). Reset INIT 0x00000000. PROVEN: vendor register header. Driver usage (vendor hal/drv C, uncommented call sites): 5 Get, 10 Set (hdmi_hal_hdcp14.c): read and written (RW). ";
        field { name = "rsv_0"; desc = ""; sw = r; hw = na; reset = 0x0; } rsv_0[31:11];
        field { name = "hdcp1x_bist2_err"; desc = ""; sw = rw; hw = r; reset = 0x0; } hdcp1x_bist2_err[10:10];
        field { name = "hdcp1x_bist1_err"; desc = ""; sw = rw; hw = r; reset = 0x0; } hdcp1x_bist1_err[9:9];
        field { name = "hdcp1x_bist0_err"; desc = ""; sw = rw; hw = r; reset = 0x0; } hdcp1x_bist0_err[8:8];
        field { name = "hdcp1x_cmd_done"; desc = ""; sw = rw; hw = r; reset = 0x0; } hdcp1x_cmd_done[7:7];
        field { name = "hdcp1x_key_cmd_valid"; desc = ""; sw = rw; hw = r; reset = 0x0; } hdcp1x_key_cmd_valid[6:6];
        field { name = "hdcp1x_key_cmd"; desc = ""; sw = rw; hw = r; reset = 0x0; } hdcp1x_key_cmd[5:1];
        field { name = "hdcp1x_key_load"; desc = ""; sw = rw; hw = r; reset = 0x0; } hdcp1x_key_load[0:0];
    } HDCP1X_MEM_CTRL @ 0x0;
    reg {
        name = "HDCP1X_KEY_AKSV0";
        desc = "HDCP1X_KEY_AKSV0 (offset 0x4 in this sub-block, absolute 0x13002004). Reset INIT 0x00000000. PROVEN: vendor register header. Driver usage (vendor hal/drv C, uncommented call sites): 4 Get, 0 Set (hdmi_hal_hdcp14.c): read-only by usage (INFERRED RO). ";
        field { name = "hdcp1x_key_aksv_byte3"; desc = ""; sw = r; hw = w; reset = 0x0; } hdcp1x_key_aksv_byte3[31:24];
        field { name = "hdcp1x_key_aksv_byte2"; desc = ""; sw = r; hw = w; reset = 0x0; } hdcp1x_key_aksv_byte2[23:16];
        field { name = "hdcp1x_key_aksv_byte1"; desc = ""; sw = r; hw = w; reset = 0x0; } hdcp1x_key_aksv_byte1[15:8];
        field { name = "hdcp1x_key_aksv_byte0"; desc = ""; sw = r; hw = w; reset = 0x0; } hdcp1x_key_aksv_byte0[7:0];
    } HDCP1X_KEY_AKSV0 @ 0x4;
    reg {
        name = "HDCP1X_KEY_AKSV1";
        desc = "HDCP1X_KEY_AKSV1 (offset 0x8 in this sub-block, absolute 0x13002008). Reset INIT 0x00000000. PROVEN: vendor register header. Driver usage (vendor hal/drv C, uncommented call sites): 1 Get, 0 Set (hdmi_hal_hdcp14.c): read-only by usage (INFERRED RO). ";
        field { name = "rsv_1"; desc = ""; sw = r; hw = na; reset = 0x0; } rsv_1[31:8];
        field { name = "hdcp1x_key_aksv_byte4"; desc = ""; sw = r; hw = w; reset = 0x0; } hdcp1x_key_aksv_byte4[7:0];
    } HDCP1X_KEY_AKSV1 @ 0x8;
    reg {
        name = "HDCP_MUTE_CTRL";
        desc = "HDCP_MUTE_CTRL (offset 0xC in this sub-block, absolute 0x1300200C). Reset INIT 0x00000000. PROVEN: vendor register header. Driver usage (vendor hal/drv C, uncommented call sites): 2 Get, 2 Set (hdmi_hal_hdcp14.c): read and written (RW). ";
        field { name = "rsv_2"; desc = ""; sw = r; hw = na; reset = 0x0; } rsv_2[31:6];
        field { name = "hdcp2x_amute_ctrl"; desc = ""; sw = rw; hw = r; reset = 0x0; } hdcp2x_amute_ctrl[5:4];
        field { name = "hdcp2x_vmute_ctrl"; desc = ""; sw = rw; hw = r; reset = 0x0; } hdcp2x_vmute_ctrl[3:3];
        field { name = "hdcp1x_amute_ctrl"; desc = ""; sw = rw; hw = r; reset = 0x0; } hdcp1x_amute_ctrl[2:1];
        field { name = "hdcp1x_vmute_ctrl"; desc = ""; sw = rw; hw = r; reset = 0x0; } hdcp1x_vmute_ctrl[0:0];
    } HDCP_MUTE_CTRL @ 0xC;
    reg {
        name = "HDCP_FUN_SEL";
        desc = "HDCP_FUN_SEL (offset 0x14 in this sub-block, absolute 0x13002014). Reset INIT 0x00000001. PROVEN: vendor register header. Driver usage (vendor hal/drv C, uncommented call sites): 1 Get, 3 Set (hdmi_hal_hdcp14.c, hdmi_hal_hdcp22.c): read and written (RW). ";
        field { name = "rsv_3"; desc = ""; sw = r; hw = na; reset = 0x0; } rsv_3[31:1];
        field { name = "hdcp_fun_sel"; desc = ""; sw = rw; hw = r; reset = 0x1; } hdcp_fun_sel[0:0];
    } HDCP_FUN_SEL @ 0x14;
    reg {
        name = "HDCP1X_SEC_CFG";
        desc = "HDCP1X_SEC_CFG (offset 0x1C in this sub-block, absolute 0x1300201C). Reset INIT 0x00000000. PROVEN: vendor register header. Driver usage (vendor hal/drv C, uncommented call sites): 0 Get, 2 Set (hdmi_hal_hdcp14.c): only written by the driver (kept RW: a write-only register cannot be told from an unread one). ";
        field { name = "rsv_4"; desc = ""; sw = r; hw = na; reset = 0x0; } rsv_4[31:2];
        field { name = "hdcp1x_sec_rpt_on"; desc = ""; sw = rw; hw = r; reset = 0x0; } hdcp1x_sec_rpt_on[1:1];
        field { name = "hdcp1x_sec_enc_en"; desc = ""; sw = rw; hw = r; reset = 0x0; } hdcp1x_sec_enc_en[0:0];
    } HDCP1X_SEC_CFG @ 0x1C;
    reg {
        name = "HDCP1X_ENG_CTRL";
        desc = "HDCP1X_ENG_CTRL (offset 0x20 in this sub-block, absolute 0x13002020). Reset INIT 0x00000FE1. PROVEN: vendor register header. Driver usage (vendor hal/drv C, uncommented call sites): 2 Get, 2 Set (hdmi_hal_hdcp14.c): read and written (RW). ";
        field { name = "rsv_5"; desc = ""; sw = r; hw = na; reset = 0x0; } rsv_5[31:12];
        field { name = "hdcp1x_ri_comp"; desc = ""; sw = rw; hw = r; reset = 0x7F; } hdcp1x_ri_comp[11:5];
        field { name = "hdcp1x_ri_hold"; desc = ""; sw = rw; hw = r; reset = 0x0; } hdcp1x_ri_hold[4:4];
        field { name = "hdcp1x_ri_trush"; desc = ""; sw = rw; hw = r; reset = 0x0; } hdcp1x_ri_trush[3:3];
        field { name = "hdcp1x_rpt_on"; desc = ""; sw = rw; hw = r; reset = 0x0; } hdcp1x_rpt_on[2:2];
        field { name = "hdcp1x_an_stop"; desc = ""; sw = rw; hw = r; reset = 0x0; } hdcp1x_an_stop[1:1];
        field { name = "hdcp1x_enc_en"; desc = ""; sw = rw; hw = r; reset = 0x1; } hdcp1x_enc_en[0:0];
    } HDCP1X_ENG_CTRL @ 0x20;
    reg {
        name = "HDCP1X_ENG_STATUS";
        desc = "HDCP1X_ENG_STATUS (offset 0x24 in this sub-block, absolute 0x13002024). Reset INIT 0x00000000. PROVEN: vendor register header. Driver usage (vendor hal/drv C, uncommented call sites): 3 Get, 0 Set (hdmi_hal_hdcp14.c): read-only by usage (INFERRED RO). ";
        field { name = "rsv_6"; desc = ""; sw = r; hw = na; reset = 0x0; } rsv_6[31:9];
        field { name = "hdcp1x_ri_rdy"; desc = ""; sw = r; hw = w; reset = 0x0; } hdcp1x_ri_rdy[8:8];
        field { name = "hdcp1x_bksv_err"; desc = ""; sw = r; hw = w; reset = 0x0; } hdcp1x_bksv_err[7:7];
        field { name = "hdcp1x_i_cnt"; desc = ""; sw = r; hw = w; reset = 0x0; } hdcp1x_i_cnt[6:0];
    } HDCP1X_ENG_STATUS @ 0x24;
    reg {
        name = "HDCP1X_ENG_BKSV0";
        desc = "HDCP1X_ENG_BKSV0 (offset 0x28 in this sub-block, absolute 0x13002028). Reset INIT 0x00000000. PROVEN: vendor register header. Driver usage (vendor hal/drv C, uncommented call sites): 0 Get, 4 Set (hdmi_hal_hdcp14.c): only written by the driver (kept RW: a write-only register cannot be told from an unread one). ";
        field { name = "hdcp1x_key_bksv_byte3"; desc = ""; sw = rw; hw = r; reset = 0x0; } hdcp1x_key_bksv_byte3[31:24];
        field { name = "hdcp1x_key_bksv_byte2"; desc = ""; sw = rw; hw = r; reset = 0x0; } hdcp1x_key_bksv_byte2[23:16];
        field { name = "hdcp1x_key_bksv_byte1"; desc = ""; sw = rw; hw = r; reset = 0x0; } hdcp1x_key_bksv_byte1[15:8];
        field { name = "hdcp1x_key_bksv_byte0"; desc = ""; sw = rw; hw = r; reset = 0x0; } hdcp1x_key_bksv_byte0[7:0];
    } HDCP1X_ENG_BKSV0 @ 0x28;
    reg {
        name = "HDCP1X_ENG_BKSV1";
        desc = "HDCP1X_ENG_BKSV1 (offset 0x2C in this sub-block, absolute 0x1300202C). Reset INIT 0x00000000. PROVEN: vendor register header. Driver usage (vendor hal/drv C, uncommented call sites): 0 Get, 1 Set (hdmi_hal_hdcp14.c): only written by the driver (kept RW: a write-only register cannot be told from an unread one). ";
        field { name = "rsv_7"; desc = ""; sw = r; hw = na; reset = 0x0; } rsv_7[31:8];
        field { name = "hdcp1x_key_bksv_byte4"; desc = ""; sw = rw; hw = r; reset = 0x0; } hdcp1x_key_bksv_byte4[7:0];
    } HDCP1X_ENG_BKSV1 @ 0x2C;
    reg {
        name = "HDCP1X_ENG_GEN_AN0";
        desc = "HDCP1X_ENG_GEN_AN0 (offset 0x30 in this sub-block, absolute 0x13002030). Reset INIT 0x00000000. PROVEN: vendor register header. Driver usage (vendor hal/drv C, uncommented call sites): 1 Get, 0 Set (hdmi_hal_hdcp14.c): read-only by usage (INFERRED RO). ";
        field { name = "hdcp1x_eng_gen_an0"; desc = ""; sw = r; hw = w; reset = 0x0; } hdcp1x_eng_gen_an0[31:0];
    } HDCP1X_ENG_GEN_AN0 @ 0x30;
    reg {
        name = "HDCP1X_ENG_GEN_AN1";
        desc = "HDCP1X_ENG_GEN_AN1 (offset 0x34 in this sub-block, absolute 0x13002034). Reset INIT 0x00000000. PROVEN: vendor register header. Driver usage (vendor hal/drv C, uncommented call sites): 1 Get, 0 Set (hdmi_hal_hdcp14.c): read-only by usage (INFERRED RO). ";
        field { name = "hdcp1x_eng_gen_an1"; desc = ""; sw = r; hw = w; reset = 0x0; } hdcp1x_eng_gen_an1[31:0];
    } HDCP1X_ENG_GEN_AN1 @ 0x34;
    reg {
        name = "HDCP1X_ENG_FUN_AN0";
        desc = "HDCP1X_ENG_FUN_AN0 (offset 0x38 in this sub-block, absolute 0x13002038). Reset INIT 0x00000000. PROVEN: vendor register header. No call site in the vendor hal/drv C sources: access by register-name convention only (INFERRED). ";
        field { name = "hdcp1x_eng_fun_an0"; desc = ""; sw = rw; hw = r; reset = 0x0; } hdcp1x_eng_fun_an0[31:0];
    } HDCP1X_ENG_FUN_AN0 @ 0x38;
    reg {
        name = "HDCP1X_ENG_FUN_AN1";
        desc = "HDCP1X_ENG_FUN_AN1 (offset 0x3C in this sub-block, absolute 0x1300203C). Reset INIT 0x00000000. PROVEN: vendor register header. No call site in the vendor hal/drv C sources: access by register-name convention only (INFERRED). ";
        field { name = "hdcp1x_eng_fun_an1"; desc = ""; sw = rw; hw = r; reset = 0x0; } hdcp1x_eng_fun_an1[31:0];
    } HDCP1X_ENG_FUN_AN1 @ 0x3C;
    reg {
        name = "HDCP1X_ENG_RI";
        desc = "HDCP1X_ENG_RI (offset 0x40 in this sub-block, absolute 0x13002040). Reset INIT 0x00000000. PROVEN: vendor register header. Driver usage (vendor hal/drv C, uncommented call sites): 2 Get, 0 Set (hdmi_hal_hdcp14.c): read-only by usage (INFERRED RO). ";
        field { name = "rsv_8"; desc = ""; sw = r; hw = na; reset = 0x0; } rsv_8[31:16];
        field { name = "hdcp1x_eng_ri1"; desc = ""; sw = r; hw = w; reset = 0x0; } hdcp1x_eng_ri1[15:8];
        field { name = "hdcp1x_eng_ri0"; desc = ""; sw = r; hw = w; reset = 0x0; } hdcp1x_eng_ri0[7:0];
    } HDCP1X_ENG_RI @ 0x40;
    reg {
        name = "HDCP1X_RPT_BSTATUS";
        desc = "HDCP1X_RPT_BSTATUS (offset 0x58 in this sub-block, absolute 0x13002058). Reset INIT 0x00000000. PROVEN: vendor register header. Driver usage (vendor hal/drv C, uncommented call sites): 0 Get, 1 Set (hdmi_hal_hdcp14.c): only written by the driver (kept RW: a write-only register cannot be told from an unread one). ";
        field { name = "rsv_9"; desc = ""; sw = r; hw = na; reset = 0x0; } rsv_9[31:16];
        field { name = "hdcp1x_bstatus"; desc = ""; sw = rw; hw = r; reset = 0x0; } hdcp1x_bstatus[15:0];
    } HDCP1X_RPT_BSTATUS @ 0x58;
    reg {
        name = "HDCP1X_RPT_KLIST";
        desc = "HDCP1X_RPT_KLIST (offset 0x5C in this sub-block, absolute 0x1300205C). Reset INIT 0x00000000. PROVEN: vendor register header. Driver usage (vendor hal/drv C, uncommented call sites): 0 Get, 1 Set (hdmi_hal_hdcp14.c): only written by the driver (kept RW: a write-only register cannot be told from an unread one). ";
        field { name = "rsv_10"; desc = ""; sw = r; hw = na; reset = 0x0; } rsv_10[31:8];
        field { name = "hdcp1x_rpt_klist"; desc = ""; sw = rw; hw = r; reset = 0x0; } hdcp1x_rpt_klist[7:0];
    } HDCP1X_RPT_KLIST @ 0x5C;
    reg {
        name = "HDCP1X_SHA_CTRL";
        desc = "HDCP1X_SHA_CTRL (offset 0x60 in this sub-block, absolute 0x13002060). Reset INIT 0x00000000. PROVEN: vendor register header. Driver usage (vendor hal/drv C, uncommented call sites): 2 Get, 2 Set (hdmi_hal_hdcp14.c): read and written (RW). ";
        field { name = "rsv_11"; desc = ""; sw = r; hw = na; reset = 0x0; } rsv_11[31:3];
        field { name = "hdcp1x_sha_ready"; desc = ""; sw = rw; hw = r; reset = 0x0; } hdcp1x_sha_ready[2:2];
        field { name = "hdcp1x_sha_no_ds"; desc = ""; sw = rw; hw = r; reset = 0x0; } hdcp1x_sha_no_ds[1:1];
        field { name = "hdcp1x_sha_start"; desc = ""; sw = rw; hw = r; reset = 0x0; } hdcp1x_sha_start[0:0];
    } HDCP1X_SHA_CTRL @ 0x60;
    reg {
        name = "HDCP1X_SHA_V0";
        desc = "HDCP1X_SHA_V0 (offset 0x64 in this sub-block, absolute 0x13002064). Reset INIT 0x00000000. PROVEN: vendor register header. Driver usage (vendor hal/drv C, uncommented call sites): 1 Get, 0 Set (hdmi_hal_hdcp14.c): read-only by usage (INFERRED RO). ";
        field { name = "hdcp1x_rpt_vh0"; desc = ""; sw = r; hw = w; reset = 0x0; } hdcp1x_rpt_vh0[31:0];
    } HDCP1X_SHA_V0 @ 0x64;
    reg {
        name = "HDCP1X_SHA_V1";
        desc = "HDCP1X_SHA_V1 (offset 0x68 in this sub-block, absolute 0x13002068). Reset INIT 0x00000000. PROVEN: vendor register header. Driver usage (vendor hal/drv C, uncommented call sites): 1 Get, 0 Set (hdmi_hal_hdcp14.c): read-only by usage (INFERRED RO). ";
        field { name = "hdcp1x_rpt_vh1"; desc = ""; sw = r; hw = w; reset = 0x0; } hdcp1x_rpt_vh1[31:0];
    } HDCP1X_SHA_V1 @ 0x68;
    reg {
        name = "HDCP1X_SHA_V2";
        desc = "HDCP1X_SHA_V2 (offset 0x6C in this sub-block, absolute 0x1300206C). Reset INIT 0x00000000. PROVEN: vendor register header. Driver usage (vendor hal/drv C, uncommented call sites): 1 Get, 0 Set (hdmi_hal_hdcp14.c): read-only by usage (INFERRED RO). ";
        field { name = "hdcp1x_rpt_vh2"; desc = ""; sw = r; hw = w; reset = 0x0; } hdcp1x_rpt_vh2[31:0];
    } HDCP1X_SHA_V2 @ 0x6C;
    reg {
        name = "HDCP1X_SHA_V3";
        desc = "HDCP1X_SHA_V3 (offset 0x70 in this sub-block, absolute 0x13002070). Reset INIT 0x00000000. PROVEN: vendor register header. Driver usage (vendor hal/drv C, uncommented call sites): 1 Get, 0 Set (hdmi_hal_hdcp14.c): read-only by usage (INFERRED RO). ";
        field { name = "hdcp1x_rpt_vh3"; desc = ""; sw = r; hw = w; reset = 0x0; } hdcp1x_rpt_vh3[31:0];
    } HDCP1X_SHA_V3 @ 0x70;
    reg {
        name = "HDCP1X_SHA_V4";
        desc = "HDCP1X_SHA_V4 (offset 0x74 in this sub-block, absolute 0x13002074). Reset INIT 0x00000000. PROVEN: vendor register header. Driver usage (vendor hal/drv C, uncommented call sites): 1 Get, 0 Set (hdmi_hal_hdcp14.c): read-only by usage (INFERRED RO). ";
        field { name = "hdcp1x_rpt_vh4"; desc = ""; sw = r; hw = w; reset = 0x0; } hdcp1x_rpt_vh4[31:0];
    } HDCP1X_SHA_V4 @ 0x74;
    reg {
        name = "HDCP1X_CHK_CTRL";
        desc = "HDCP1X_CHK_CTRL (offset 0x80 in this sub-block, absolute 0x13002080). Reset INIT 0x00000012. PROVEN: vendor register header. Driver usage (vendor hal/drv C, uncommented call sites): 0 Get, 1 Set (hdmi_hal_hdcp14.c): only written by the driver (kept RW: a write-only register cannot be told from an unread one). ";
        field { name = "rsv_12"; desc = ""; sw = r; hw = na; reset = 0x0; } rsv_12[31:5];
        field { name = "hdcp1x_check_errcnt_en"; desc = ""; sw = rw; hw = r; reset = 0x1; } hdcp1x_check_errcnt_en[4:4];
        field { name = "hdcp1x_check_start_sel"; desc = ""; sw = rw; hw = r; reset = 0x0; } hdcp1x_check_start_sel[3:2];
        field { name = "hdcp1x_ddc_req_priority"; desc = ""; sw = rw; hw = r; reset = 0x1; } hdcp1x_ddc_req_priority[1:1];
        field { name = "hdcp1x_auto_check_en"; desc = ""; sw = rw; hw = r; reset = 0x0; } hdcp1x_auto_check_en[0:0];
    } HDCP1X_CHK_CTRL @ 0x80;
    reg {
        name = "HDCP1X_CHK_START";
        desc = "HDCP1X_CHK_START (offset 0x84 in this sub-block, absolute 0x13002084). Reset INIT 0x107E007F. PROVEN: vendor register header. No call site in the vendor hal/drv C sources: access by register-name convention only (INFERRED). ";
        field { name = "hdcp1x_linecnt_thre"; desc = ""; sw = rw; hw = r; reset = 0x10; } hdcp1x_linecnt_thre[31:24];
        field { name = "hdcp1x_ddc_req_fcnt"; desc = ""; sw = rw; hw = r; reset = 0x7E; } hdcp1x_ddc_req_fcnt[23:16];
        field { name = "hdcp1x_ri_chk2_fcnt"; desc = ""; sw = rw; hw = r; reset = 0x0; } hdcp1x_ri_chk2_fcnt[15:8];
        field { name = "hdcp1x_ri_chk1_fcnt"; desc = ""; sw = rw; hw = r; reset = 0x7F; } hdcp1x_ri_chk1_fcnt[7:0];
    } HDCP1X_CHK_START @ 0x84;
    reg {
        name = "HDCP1X_CHK_ERR";
        desc = "HDCP1X_CHK_ERR (offset 0x88 in this sub-block, absolute 0x13002088). Reset INIT 0x00000000. PROVEN: vendor register header. Driver usage (vendor hal/drv C, uncommented call sites): 4 Get, 0 Set (hdmi_hal_hdcp14.c): read-only by usage (INFERRED RO). ";
        field { name = "hdcp1x_nodone_err_cnt"; desc = ""; sw = r; hw = w; reset = 0x0; } hdcp1x_nodone_err_cnt[31:24];
        field { name = "hdcp1x_notchg_err_cnt"; desc = ""; sw = r; hw = w; reset = 0x0; } hdcp1x_notchg_err_cnt[23:16];
        field { name = "hdcp1x_000frm_err_cnt"; desc = ""; sw = r; hw = w; reset = 0x0; } hdcp1x_000frm_err_cnt[15:8];
        field { name = "hdcp1x_127frm_err_cnt"; desc = ""; sw = r; hw = w; reset = 0x0; } hdcp1x_127frm_err_cnt[7:0];
    } HDCP1X_CHK_ERR @ 0x88;
    reg {
        name = "HDCP1X_CHK_STATE";
        desc = "HDCP1X_CHK_STATE (offset 0x8C in this sub-block, absolute 0x1300208C). Reset INIT 0x00000000. PROVEN: vendor register header. Driver usage (vendor hal/drv C, uncommented call sites): 1 Get, 0 Set (hdmi_hal_hdcp14.c): read-only by usage (INFERRED RO). ";
        field { name = "rsv_13"; desc = ""; sw = r; hw = na; reset = 0x0; } rsv_13[31:4];
        field { name = "hdcp1x_fsm_state"; desc = ""; sw = r; hw = w; reset = 0x0; } hdcp1x_fsm_state[3:0];
    } HDCP1X_CHK_STATE @ 0x8C;
    reg {
        name = "HDCP2X_ENC_CTRL";
        desc = "HDCP2X_ENC_CTRL (offset 0xA0 in this sub-block, absolute 0x130020A0). Reset INIT 0x00000001. PROVEN: vendor register header. No call site in the vendor hal/drv C sources: access by register-name convention only (INFERRED). ";
        field { name = "rsv_14"; desc = ""; sw = r; hw = na; reset = 0x0; } rsv_14[31:1];
        field { name = "hdcp2x_enc_en"; desc = ""; sw = rw; hw = r; reset = 0x1; } hdcp2x_enc_en[0:0];
    } HDCP2X_ENC_CTRL @ 0xA0;
    reg {
        name = "HDCP2X_DBG_CTRL";
        desc = "HDCP2X_DBG_CTRL (offset 0xA4 in this sub-block, absolute 0x130020A4). Reset INIT 0x00000000. PROVEN: vendor register header. No call site in the vendor hal/drv C sources: access by register-name convention only (INFERRED). ";
        field { name = "rsv_15"; desc = ""; sw = r; hw = na; reset = 0x0; } rsv_15[31:1];
        field { name = "hdcp2x_uart_sel"; desc = ""; sw = rw; hw = r; reset = 0x0; } hdcp2x_uart_sel[0:0];
    } HDCP2X_DBG_CTRL @ 0xA4;
    reg {
        name = "HDCP2X_ENC_STATE";
        desc = "HDCP2X_ENC_STATE (offset 0xB4 in this sub-block, absolute 0x130020B4). Reset INIT 0x00000000. PROVEN: vendor register header. No call site in the vendor hal/drv C sources: access by register-name convention only (INFERRED). ";
        field { name = "rsv_16"; desc = ""; sw = r; hw = na; reset = 0x0; } rsv_16[31:1];
        field { name = "hdcp2x_enc_state"; desc = ""; sw = r; hw = w; reset = 0x0; } hdcp2x_enc_state[0:0];
    } HDCP2X_ENC_STATE @ 0xB4;
    reg {
        name = "HDCP1X_RPT_V0";
        desc = "HDCP1X_RPT_V0 (offset 0xE0 in this sub-block, absolute 0x130020E0). Reset INIT 0x00000000. PROVEN: vendor register header. Driver usage (vendor hal/drv C, uncommented call sites): 0 Get, 1 Set (hdmi_hal_hdcp14.c): only written by the driver (kept RW: a write-only register cannot be told from an unread one). ";
        field { name = "hdcp1x_rpt_calc_vh0"; desc = ""; sw = rw; hw = r; reset = 0x0; } hdcp1x_rpt_calc_vh0[31:0];
    } HDCP1X_RPT_V0 @ 0xE0;
    reg {
        name = "HDCP1X_RPT_V1";
        desc = "HDCP1X_RPT_V1 (offset 0xE4 in this sub-block, absolute 0x130020E4). Reset INIT 0x00000000. PROVEN: vendor register header. Driver usage (vendor hal/drv C, uncommented call sites): 0 Get, 1 Set (hdmi_hal_hdcp14.c): only written by the driver (kept RW: a write-only register cannot be told from an unread one). ";
        field { name = "hdcp1x_rpt_calc_vh1"; desc = ""; sw = rw; hw = r; reset = 0x0; } hdcp1x_rpt_calc_vh1[31:0];
    } HDCP1X_RPT_V1 @ 0xE4;
    reg {
        name = "HDCP1X_RPT_V2";
        desc = "HDCP1X_RPT_V2 (offset 0xE8 in this sub-block, absolute 0x130020E8). Reset INIT 0x00000000. PROVEN: vendor register header. Driver usage (vendor hal/drv C, uncommented call sites): 0 Get, 1 Set (hdmi_hal_hdcp14.c): only written by the driver (kept RW: a write-only register cannot be told from an unread one). ";
        field { name = "hdcp1x_rpt_calc_vh2"; desc = ""; sw = rw; hw = r; reset = 0x0; } hdcp1x_rpt_calc_vh2[31:0];
    } HDCP1X_RPT_V2 @ 0xE8;
    reg {
        name = "HDCP1X_RPT_V3";
        desc = "HDCP1X_RPT_V3 (offset 0xEC in this sub-block, absolute 0x130020EC). Reset INIT 0x00000000. PROVEN: vendor register header. Driver usage (vendor hal/drv C, uncommented call sites): 0 Get, 1 Set (hdmi_hal_hdcp14.c): only written by the driver (kept RW: a write-only register cannot be told from an unread one). ";
        field { name = "hdcp1x_rpt_calc_vh3"; desc = ""; sw = rw; hw = r; reset = 0x0; } hdcp1x_rpt_calc_vh3[31:0];
    } HDCP1X_RPT_V3 @ 0xEC;
    reg {
        name = "HDCP1X_RPT_V4";
        desc = "HDCP1X_RPT_V4 (offset 0xF0 in this sub-block, absolute 0x130020F0). Reset INIT 0x00000000. PROVEN: vendor register header. Driver usage (vendor hal/drv C, uncommented call sites): 0 Get, 1 Set (hdmi_hal_hdcp14.c): only written by the driver (kept RW: a write-only register cannot be told from an unread one). ";
        field { name = "hdcp1x_rpt_calc_vh4"; desc = ""; sw = rw; hw = r; reset = 0x0; } hdcp1x_rpt_calc_vh4[31:0];
    } HDCP1X_RPT_V4 @ 0xF0;
    reg {
        name = "HDCP1X_SHA_CHECK";
        desc = "HDCP1X_SHA_CHECK (offset 0xF4 in this sub-block, absolute 0x130020F4). Reset INIT 0x00000000. PROVEN: vendor register header. Driver usage (vendor hal/drv C, uncommented call sites): 0 Get, 1 Set (hdmi_hal_hdcp14.c): only written by the driver (kept RW: a write-only register cannot be told from an unread one). ";
        field { name = "rsv_17"; desc = ""; sw = r; hw = na; reset = 0x0; } rsv_17[31:1];
        field { name = "hdcp1x_sha_check"; desc = ""; sw = rw; hw = r; reset = 0x0; } hdcp1x_sha_check[0:0];
    } HDCP1X_SHA_CHECK @ 0xF4;
    reg {
        name = "HDCP1X_SHA_RESULT";
        desc = "HDCP1X_SHA_RESULT (offset 0xF8 in this sub-block, absolute 0x130020F8). Reset INIT 0x00000000. PROVEN: vendor register header. Driver usage (vendor hal/drv C, uncommented call sites): 2 Get, 0 Set (hdmi_hal_hdcp14.c): read-only by usage (INFERRED RO). ";
        field { name = "rsv_18"; desc = ""; sw = r; hw = na; reset = 0x0; } rsv_18[31:2];
        field { name = "hdcp1x_sha_invalid"; desc = ""; sw = r; hw = w; reset = 0x0; } hdcp1x_sha_invalid[1:1];
        field { name = "hdcp1x_sha_ok"; desc = ""; sw = r; hw = w; reset = 0x0; } hdcp1x_sha_ok[0:0];
    } HDCP1X_SHA_RESULT @ 0xF8;
};

regfile eHI3536D_HDMI_tx {
    name = "HDMI TX tx, Hi3536D V100 / HDMI v2 (hisiv100)";
    desc = "TX HDMI core (info frames, TMDS, packets). Offsets are relative to the sub-block base 0x13001800 (HDMI TX window 0x13000000 + 0x1800). Provenance: PROVEN (vendor code): register names, offsets, field names/bit ranges and reset (INIT) values come from the machine-generated register headers of the vendor HDMI v2 driver (nManager-generated hdmi_reg_tx.h, product/hiosd/hdmi/hdmi_v2/drv/hal in the vendor U-Boot tree for the Hi3536D/Hi3536C/Hi3531D/Hi3521D family, source: sources/openipc-u-boot-hi3536dv100); the Hi3536D V100 maps the window at 0x13000000 per its hdmi_product_define.h and the closed hi3536dv100_hdmi.ko symbol names (HDMI_TX_S_*_REGS_TYPE_Init) agree. INFERRED: access types. Of the 503 register definitions in the vendor headers only 38 carry an ATTR (all RW); the others have none, so fields are modelled read/write except reserved/rsv fields and registers whose names mark them read-only by convention where the vendor hal/drv C sources call the accessors (203 registers) a register only ever read is modelled sw=r and the call-site counts are in each register description; for the other registers the name convention (SW_VER*, HW_INFO/HW_VERSION/HW_FEATURE, _STATUS, _STAT, _STATE, _OUT<n>: sw=r) is used. The 8051 MCU window (mcu sub-block) is modelled the same way and its function is inferred from the HDCP2X_* names only and hardware behavior; nothing run on hardware. NOT in the data sheet (no HDMI TX chapter)." ;
    reg {
        name = "TX_PACK_FIFO_CTRL";
        desc = "TX_PACK_FIFO_CTRL (offset 0x0 in this sub-block, absolute 0x13001800). Reset INIT 0x00000004. PROVEN: vendor register header. Driver usage (vendor hal/drv C, uncommented call sites): 1 Get, 1 Set (hdmi_hal_ctrl.c): read and written (RW). ";
        field { name = "rsv_1"; desc = ""; sw = r; hw = na; reset = 0x0; } rsv_1[31:16];
        field { name = "reg_fifo_delay_cnt"; desc = ""; sw = rw; hw = r; reset = 0x0; } reg_fifo_delay_cnt[15:8];
        field { name = "rsv_0"; desc = ""; sw = r; hw = na; reset = 0x0; } rsv_0[7:6];
        field { name = "reg_ext_tmds_para"; desc = ""; sw = rw; hw = r; reset = 0x0; } reg_ext_tmds_para[5:5];
        field { name = "reg_clock_det_en"; desc = ""; sw = rw; hw = r; reset = 0x0; } reg_clock_det_en[4:4];
        field { name = "reg_fifo_manu_rst"; desc = ""; sw = rw; hw = r; reset = 0x0; } reg_fifo_manu_rst[3:3];
        field { name = "reg_fifo_auto_rst_en"; desc = ""; sw = rw; hw = r; reset = 0x1; } reg_fifo_auto_rst_en[2:2];
        field { name = "tmds_pack_mode"; desc = ""; sw = rw; hw = r; reset = 0x0; } tmds_pack_mode[1:0];
    } TX_PACK_FIFO_CTRL @ 0x0;
    reg {
        name = "TX_PACK_FIFO_ST";
        desc = "TX_PACK_FIFO_ST (offset 0x4 in this sub-block, absolute 0x13001804). Reset INIT 0x00000000. PROVEN: vendor register header. No call site in the vendor hal/drv C sources: access by register-name convention only (INFERRED). ";
        field { name = "rsv_2"; desc = ""; sw = r; hw = na; reset = 0x0; } rsv_2[31:1];
        field { name = "pclk2tclk_stable"; desc = ""; sw = rw; hw = r; reset = 0x0; } pclk2tclk_stable[0:0];
    } TX_PACK_FIFO_ST @ 0x4;
    reg {
        name = "PCLK_REFER_CNT";
        desc = "PCLK_REFER_CNT (offset 0x8 in this sub-block, absolute 0x13001808). Reset INIT 0x000003FF. PROVEN: vendor register header. No call site in the vendor hal/drv C sources: access by register-name convention only (INFERRED). ";
        field { name = "rsv_3"; desc = ""; sw = r; hw = na; reset = 0x0; } rsv_3[31:18];
        field { name = "reg_pclk_refer_cnt"; desc = ""; sw = rw; hw = r; reset = 0x3FF; } reg_pclk_refer_cnt[17:0];
    } PCLK_REFER_CNT @ 0x8;
    reg {
        name = "TCLK_LOWER_THRESHOLD";
        desc = "TCLK_LOWER_THRESHOLD (offset 0xC in this sub-block, absolute 0x1300180C). Reset INIT 0x000003F8. PROVEN: vendor register header. No call site in the vendor hal/drv C sources: access by register-name convention only (INFERRED). ";
        field { name = "rsv_4"; desc = ""; sw = r; hw = na; reset = 0x0; } rsv_4[31:18];
        field { name = "reg_tcnt_lower_threshold"; desc = ""; sw = rw; hw = r; reset = 0x3F8; } reg_tcnt_lower_threshold[17:0];
    } TCLK_LOWER_THRESHOLD @ 0xC;
    reg {
        name = "TCLK_UPPER_THRESHOLD";
        desc = "TCLK_UPPER_THRESHOLD (offset 0x10 in this sub-block, absolute 0x13001810). Reset INIT 0x00000408. PROVEN: vendor register header. No call site in the vendor hal/drv C sources: access by register-name convention only (INFERRED). ";
        field { name = "rsv_5"; desc = ""; sw = r; hw = na; reset = 0x0; } rsv_5[31:18];
        field { name = "reg_tcnt_upper_threshold"; desc = ""; sw = rw; hw = r; reset = 0x408; } reg_tcnt_upper_threshold[17:0];
    } TCLK_UPPER_THRESHOLD @ 0x10;
    reg {
        name = "AVI_PKT_HEADER";
        desc = "AVI_PKT_HEADER (offset 0x18 in this sub-block, absolute 0x13001818). Reset INIT 0x00000000. PROVEN: vendor register header. Driver usage (vendor hal/drv C, uncommented call sites): 1 Get, 1 Set (hdmi_hal_ctrl.c): read and written (RW). ";
        field { name = "rsv_6"; desc = ""; sw = r; hw = na; reset = 0x0; } rsv_6[31:24];
        field { name = "avi_pkt_hb2"; desc = ""; sw = rw; hw = r; reset = 0x0; } avi_pkt_hb2[23:16];
        field { name = "avi_pkt_hb1"; desc = ""; sw = rw; hw = r; reset = 0x0; } avi_pkt_hb1[15:8];
        field { name = "avi_pkt_hb0"; desc = ""; sw = rw; hw = r; reset = 0x0; } avi_pkt_hb0[7:0];
    } AVI_PKT_HEADER @ 0x18;
    reg {
        name = "AVI_SUB_PKT0_L";
        desc = "AVI_SUB_PKT0_L (offset 0x1C in this sub-block, absolute 0x1300181C). Reset INIT 0x00000000. PROVEN: vendor register header. Driver usage (vendor hal/drv C, uncommented call sites): 1 Get, 1 Set (hdmi_hal_ctrl.c): read and written (RW). ";
        field { name = "avi_sub_pkt0_pb3"; desc = ""; sw = rw; hw = r; reset = 0x0; } avi_sub_pkt0_pb3[31:24];
        field { name = "avi_sub_pkt0_pb2"; desc = ""; sw = rw; hw = r; reset = 0x0; } avi_sub_pkt0_pb2[23:16];
        field { name = "avi_sub_pkt0_pb1"; desc = ""; sw = rw; hw = r; reset = 0x0; } avi_sub_pkt0_pb1[15:8];
        field { name = "avi_sub_pkt0_pb0"; desc = ""; sw = rw; hw = r; reset = 0x0; } avi_sub_pkt0_pb0[7:0];
    } AVI_SUB_PKT0_L @ 0x1C;
    reg {
        name = "AVI_SUB_PKT0_H";
        desc = "AVI_SUB_PKT0_H (offset 0x20 in this sub-block, absolute 0x13001820). Reset INIT 0x00000000. PROVEN: vendor register header. Driver usage (vendor hal/drv C, uncommented call sites): 1 Get, 1 Set (hdmi_hal_ctrl.c): read and written (RW). ";
        field { name = "rsv_7"; desc = ""; sw = r; hw = na; reset = 0x0; } rsv_7[31:24];
        field { name = "avi_sub_pkt0_pb6"; desc = ""; sw = rw; hw = r; reset = 0x0; } avi_sub_pkt0_pb6[23:16];
        field { name = "avi_sub_pkt0_pb5"; desc = ""; sw = rw; hw = r; reset = 0x0; } avi_sub_pkt0_pb5[15:8];
        field { name = "avi_sub_pkt0_pb4"; desc = ""; sw = rw; hw = r; reset = 0x0; } avi_sub_pkt0_pb4[7:0];
    } AVI_SUB_PKT0_H @ 0x20;
    reg {
        name = "AVI_SUB_PKT1_L";
        desc = "AVI_SUB_PKT1_L (offset 0x24 in this sub-block, absolute 0x13001824). Reset INIT 0x00000000. PROVEN: vendor register header. Driver usage (vendor hal/drv C, uncommented call sites): 1 Get, 1 Set (hdmi_hal_ctrl.c): read and written (RW). ";
        field { name = "avi_sub_pkt1_pb3"; desc = ""; sw = rw; hw = r; reset = 0x0; } avi_sub_pkt1_pb3[31:24];
        field { name = "avi_sub_pkt1_pb2"; desc = ""; sw = rw; hw = r; reset = 0x0; } avi_sub_pkt1_pb2[23:16];
        field { name = "avi_sub_pkt1_pb1"; desc = ""; sw = rw; hw = r; reset = 0x0; } avi_sub_pkt1_pb1[15:8];
        field { name = "avi_sub_pkt1_pb0"; desc = ""; sw = rw; hw = r; reset = 0x0; } avi_sub_pkt1_pb0[7:0];
    } AVI_SUB_PKT1_L @ 0x24;
    reg {
        name = "AVI_SUB_PKT1_H";
        desc = "AVI_SUB_PKT1_H (offset 0x28 in this sub-block, absolute 0x13001828). Reset INIT 0x00000000. PROVEN: vendor register header. Driver usage (vendor hal/drv C, uncommented call sites): 1 Get, 1 Set (hdmi_hal_ctrl.c): read and written (RW). ";
        field { name = "rsv_8"; desc = ""; sw = r; hw = na; reset = 0x0; } rsv_8[31:24];
        field { name = "avi_sub_pkt1_pb6"; desc = ""; sw = rw; hw = r; reset = 0x0; } avi_sub_pkt1_pb6[23:16];
        field { name = "avi_sub_pkt1_pb5"; desc = ""; sw = rw; hw = r; reset = 0x0; } avi_sub_pkt1_pb5[15:8];
        field { name = "avi_sub_pkt1_pb4"; desc = ""; sw = rw; hw = r; reset = 0x0; } avi_sub_pkt1_pb4[7:0];
    } AVI_SUB_PKT1_H @ 0x28;
    reg {
        name = "AVI_SUB_PKT2_L";
        desc = "AVI_SUB_PKT2_L (offset 0x2C in this sub-block, absolute 0x1300182C). Reset INIT 0x00000000. PROVEN: vendor register header. Driver usage (vendor hal/drv C, uncommented call sites): 1 Get, 1 Set (hdmi_hal_ctrl.c): read and written (RW). ";
        field { name = "avi_sub_pkt2_pb3"; desc = ""; sw = rw; hw = r; reset = 0x0; } avi_sub_pkt2_pb3[31:24];
        field { name = "avi_sub_pkt2_pb2"; desc = ""; sw = rw; hw = r; reset = 0x0; } avi_sub_pkt2_pb2[23:16];
        field { name = "avi_sub_pkt2_pb1"; desc = ""; sw = rw; hw = r; reset = 0x0; } avi_sub_pkt2_pb1[15:8];
        field { name = "avi_sub_pkt2_pb0"; desc = ""; sw = rw; hw = r; reset = 0x0; } avi_sub_pkt2_pb0[7:0];
    } AVI_SUB_PKT2_L @ 0x2C;
    reg {
        name = "AVI_SUB_PKT2_H";
        desc = "AVI_SUB_PKT2_H (offset 0x30 in this sub-block, absolute 0x13001830). Reset INIT 0x00000000. PROVEN: vendor register header. Driver usage (vendor hal/drv C, uncommented call sites): 1 Get, 1 Set (hdmi_hal_ctrl.c): read and written (RW). ";
        field { name = "rsv_9"; desc = ""; sw = r; hw = na; reset = 0x0; } rsv_9[31:24];
        field { name = "avi_sub_pkt2_pb6"; desc = ""; sw = rw; hw = r; reset = 0x0; } avi_sub_pkt2_pb6[23:16];
        field { name = "avi_sub_pkt2_pb5"; desc = ""; sw = rw; hw = r; reset = 0x0; } avi_sub_pkt2_pb5[15:8];
        field { name = "avi_sub_pkt2_pb4"; desc = ""; sw = rw; hw = r; reset = 0x0; } avi_sub_pkt2_pb4[7:0];
    } AVI_SUB_PKT2_H @ 0x30;
    reg {
        name = "AVI_SUB_PKT3_L";
        desc = "AVI_SUB_PKT3_L (offset 0x34 in this sub-block, absolute 0x13001834). Reset INIT 0x00000000. PROVEN: vendor register header. Driver usage (vendor hal/drv C, uncommented call sites): 1 Get, 1 Set (hdmi_hal_ctrl.c): read and written (RW). ";
        field { name = "avi_sub_pkt3_pb3"; desc = ""; sw = rw; hw = r; reset = 0x0; } avi_sub_pkt3_pb3[31:24];
        field { name = "avi_sub_pkt3_pb2"; desc = ""; sw = rw; hw = r; reset = 0x0; } avi_sub_pkt3_pb2[23:16];
        field { name = "avi_sub_pkt3_pb1"; desc = ""; sw = rw; hw = r; reset = 0x0; } avi_sub_pkt3_pb1[15:8];
        field { name = "avi_sub_pkt3_pb0"; desc = ""; sw = rw; hw = r; reset = 0x0; } avi_sub_pkt3_pb0[7:0];
    } AVI_SUB_PKT3_L @ 0x34;
    reg {
        name = "AVI_SUB_PKT3_H";
        desc = "AVI_SUB_PKT3_H (offset 0x38 in this sub-block, absolute 0x13001838). Reset INIT 0x00000000. PROVEN: vendor register header. Driver usage (vendor hal/drv C, uncommented call sites): 1 Get, 1 Set (hdmi_hal_ctrl.c): read and written (RW). ";
        field { name = "rsv_10"; desc = ""; sw = r; hw = na; reset = 0x0; } rsv_10[31:24];
        field { name = "avi_sub_pkt3_pb6"; desc = ""; sw = rw; hw = r; reset = 0x0; } avi_sub_pkt3_pb6[23:16];
        field { name = "avi_sub_pkt3_pb5"; desc = ""; sw = rw; hw = r; reset = 0x0; } avi_sub_pkt3_pb5[15:8];
        field { name = "avi_sub_pkt3_pb4"; desc = ""; sw = rw; hw = r; reset = 0x0; } avi_sub_pkt3_pb4[7:0];
    } AVI_SUB_PKT3_H @ 0x38;
    reg {
        name = "AIF_PKT_HEADER";
        desc = "AIF_PKT_HEADER (offset 0x3C in this sub-block, absolute 0x1300183C). Reset INIT 0x00000000. PROVEN: vendor register header. Driver usage (vendor hal/drv C, uncommented call sites): 1 Get, 0 Set (hdmi_hal_ctrl.c): read-only by usage (INFERRED RO). ";
        field { name = "rsv_11"; desc = ""; sw = r; hw = na; reset = 0x0; } rsv_11[31:24];
        field { name = "aif_pkt_hb2"; desc = ""; sw = r; hw = w; reset = 0x0; } aif_pkt_hb2[23:16];
        field { name = "aif_pkt_hb1"; desc = ""; sw = r; hw = w; reset = 0x0; } aif_pkt_hb1[15:8];
        field { name = "aif_pkt_hb0"; desc = ""; sw = r; hw = w; reset = 0x0; } aif_pkt_hb0[7:0];
    } AIF_PKT_HEADER @ 0x3C;
    reg {
        name = "AIF_SUB_PKT0_L";
        desc = "AIF_SUB_PKT0_L (offset 0x40 in this sub-block, absolute 0x13001840). Reset INIT 0x00000000. PROVEN: vendor register header. Driver usage (vendor hal/drv C, uncommented call sites): 1 Get, 0 Set (hdmi_hal_ctrl.c): read-only by usage (INFERRED RO). ";
        field { name = "aif_sub_pkt0_pb3"; desc = ""; sw = r; hw = w; reset = 0x0; } aif_sub_pkt0_pb3[31:24];
        field { name = "aif_sub_pkt0_pb2"; desc = ""; sw = r; hw = w; reset = 0x0; } aif_sub_pkt0_pb2[23:16];
        field { name = "aif_sub_pkt0_pb1"; desc = ""; sw = r; hw = w; reset = 0x0; } aif_sub_pkt0_pb1[15:8];
        field { name = "aif_sub_pkt0_pb0"; desc = ""; sw = r; hw = w; reset = 0x0; } aif_sub_pkt0_pb0[7:0];
    } AIF_SUB_PKT0_L @ 0x40;
    reg {
        name = "AIF_SUB_PKT0_H";
        desc = "AIF_SUB_PKT0_H (offset 0x44 in this sub-block, absolute 0x13001844). Reset INIT 0x00000000. PROVEN: vendor register header. Driver usage (vendor hal/drv C, uncommented call sites): 1 Get, 0 Set (hdmi_hal_ctrl.c): read-only by usage (INFERRED RO). ";
        field { name = "rsv_12"; desc = ""; sw = r; hw = na; reset = 0x0; } rsv_12[31:24];
        field { name = "aif_sub_pkt0_pb6"; desc = ""; sw = r; hw = w; reset = 0x0; } aif_sub_pkt0_pb6[23:16];
        field { name = "aif_sub_pkt0_pb5"; desc = ""; sw = r; hw = w; reset = 0x0; } aif_sub_pkt0_pb5[15:8];
        field { name = "aif_sub_pkt0_pb4"; desc = ""; sw = r; hw = w; reset = 0x0; } aif_sub_pkt0_pb4[7:0];
    } AIF_SUB_PKT0_H @ 0x44;
    reg {
        name = "AIF_SUB_PKT1_L";
        desc = "AIF_SUB_PKT1_L (offset 0x48 in this sub-block, absolute 0x13001848). Reset INIT 0x00000000. PROVEN: vendor register header. Driver usage (vendor hal/drv C, uncommented call sites): 1 Get, 0 Set (hdmi_hal_ctrl.c): read-only by usage (INFERRED RO). ";
        field { name = "aif_sub_pkt1_pb3"; desc = ""; sw = r; hw = w; reset = 0x0; } aif_sub_pkt1_pb3[31:24];
        field { name = "aif_sub_pkt1_pb2"; desc = ""; sw = r; hw = w; reset = 0x0; } aif_sub_pkt1_pb2[23:16];
        field { name = "aif_sub_pkt1_pb1"; desc = ""; sw = r; hw = w; reset = 0x0; } aif_sub_pkt1_pb1[15:8];
        field { name = "aif_sub_pkt1_pb0"; desc = ""; sw = r; hw = w; reset = 0x0; } aif_sub_pkt1_pb0[7:0];
    } AIF_SUB_PKT1_L @ 0x48;
    reg {
        name = "AIF_SUB_PKT1_H";
        desc = "AIF_SUB_PKT1_H (offset 0x4C in this sub-block, absolute 0x1300184C). Reset INIT 0x00000000. PROVEN: vendor register header. Driver usage (vendor hal/drv C, uncommented call sites): 1 Get, 0 Set (hdmi_hal_ctrl.c): read-only by usage (INFERRED RO). ";
        field { name = "rsv_13"; desc = ""; sw = r; hw = na; reset = 0x0; } rsv_13[31:24];
        field { name = "aif_sub_pkt1_pb6"; desc = ""; sw = r; hw = w; reset = 0x0; } aif_sub_pkt1_pb6[23:16];
        field { name = "aif_sub_pkt1_pb5"; desc = ""; sw = r; hw = w; reset = 0x0; } aif_sub_pkt1_pb5[15:8];
        field { name = "aif_sub_pkt1_pb4"; desc = ""; sw = r; hw = w; reset = 0x0; } aif_sub_pkt1_pb4[7:0];
    } AIF_SUB_PKT1_H @ 0x4C;
    reg {
        name = "AIF_SUB_PKT2_L";
        desc = "AIF_SUB_PKT2_L (offset 0x50 in this sub-block, absolute 0x13001850). Reset INIT 0x00000000. PROVEN: vendor register header. Driver usage (vendor hal/drv C, uncommented call sites): 1 Get, 0 Set (hdmi_hal_ctrl.c): read-only by usage (INFERRED RO). ";
        field { name = "aif_sub_pkt2_pb3"; desc = ""; sw = r; hw = w; reset = 0x0; } aif_sub_pkt2_pb3[31:24];
        field { name = "aif_sub_pkt2_pb2"; desc = ""; sw = r; hw = w; reset = 0x0; } aif_sub_pkt2_pb2[23:16];
        field { name = "aif_sub_pkt2_pb1"; desc = ""; sw = r; hw = w; reset = 0x0; } aif_sub_pkt2_pb1[15:8];
        field { name = "aif_sub_pkt2_pb0"; desc = ""; sw = r; hw = w; reset = 0x0; } aif_sub_pkt2_pb0[7:0];
    } AIF_SUB_PKT2_L @ 0x50;
    reg {
        name = "AIF_SUB_PKT2_H";
        desc = "AIF_SUB_PKT2_H (offset 0x54 in this sub-block, absolute 0x13001854). Reset INIT 0x00000000. PROVEN: vendor register header. Driver usage (vendor hal/drv C, uncommented call sites): 1 Get, 0 Set (hdmi_hal_ctrl.c): read-only by usage (INFERRED RO). ";
        field { name = "rsv_14"; desc = ""; sw = r; hw = na; reset = 0x0; } rsv_14[31:24];
        field { name = "aif_sub_pkt2_pb6"; desc = ""; sw = r; hw = w; reset = 0x0; } aif_sub_pkt2_pb6[23:16];
        field { name = "aif_sub_pkt2_pb5"; desc = ""; sw = r; hw = w; reset = 0x0; } aif_sub_pkt2_pb5[15:8];
        field { name = "aif_sub_pkt2_pb4"; desc = ""; sw = r; hw = w; reset = 0x0; } aif_sub_pkt2_pb4[7:0];
    } AIF_SUB_PKT2_H @ 0x54;
    reg {
        name = "AIF_SUB_PKT3_L";
        desc = "AIF_SUB_PKT3_L (offset 0x58 in this sub-block, absolute 0x13001858). Reset INIT 0x00000000. PROVEN: vendor register header. Driver usage (vendor hal/drv C, uncommented call sites): 1 Get, 0 Set (hdmi_hal_ctrl.c): read-only by usage (INFERRED RO). ";
        field { name = "aif_sub_pkt3_pb3"; desc = ""; sw = r; hw = w; reset = 0x0; } aif_sub_pkt3_pb3[31:24];
        field { name = "aif_sub_pkt3_pb2"; desc = ""; sw = r; hw = w; reset = 0x0; } aif_sub_pkt3_pb2[23:16];
        field { name = "aif_sub_pkt3_pb1"; desc = ""; sw = r; hw = w; reset = 0x0; } aif_sub_pkt3_pb1[15:8];
        field { name = "aif_sub_pkt3_pb0"; desc = ""; sw = r; hw = w; reset = 0x0; } aif_sub_pkt3_pb0[7:0];
    } AIF_SUB_PKT3_L @ 0x58;
    reg {
        name = "AIF_SUB_PKT3_H";
        desc = "AIF_SUB_PKT3_H (offset 0x5C in this sub-block, absolute 0x1300185C). Reset INIT 0x00000000. PROVEN: vendor register header. Driver usage (vendor hal/drv C, uncommented call sites): 1 Get, 0 Set (hdmi_hal_ctrl.c): read-only by usage (INFERRED RO). ";
        field { name = "rsv_15"; desc = ""; sw = r; hw = na; reset = 0x0; } rsv_15[31:24];
        field { name = "aif_sub_pkt3_pb6"; desc = ""; sw = r; hw = w; reset = 0x0; } aif_sub_pkt3_pb6[23:16];
        field { name = "aif_sub_pkt3_pb5"; desc = ""; sw = r; hw = w; reset = 0x0; } aif_sub_pkt3_pb5[15:8];
        field { name = "aif_sub_pkt3_pb4"; desc = ""; sw = r; hw = w; reset = 0x0; } aif_sub_pkt3_pb4[7:0];
    } AIF_SUB_PKT3_H @ 0x5C;
    reg {
        name = "SPIF_PKT_HEADER";
        desc = "SPIF_PKT_HEADER (offset 0x60 in this sub-block, absolute 0x13001860). Reset INIT 0x00000000. PROVEN: vendor register header. Driver usage (vendor hal/drv C, uncommented call sites): 1 Get, 1 Set (hdmi_hal_ctrl.c): read and written (RW). ";
        field { name = "rsv_16"; desc = ""; sw = r; hw = na; reset = 0x0; } rsv_16[31:24];
        field { name = "spd_pkt_hb2"; desc = ""; sw = rw; hw = r; reset = 0x0; } spd_pkt_hb2[23:16];
        field { name = "spd_pkt_hb1"; desc = ""; sw = rw; hw = r; reset = 0x0; } spd_pkt_hb1[15:8];
        field { name = "spd_pkt_hb0"; desc = ""; sw = rw; hw = r; reset = 0x0; } spd_pkt_hb0[7:0];
    } SPIF_PKT_HEADER @ 0x60;
    reg {
        name = "SPIF_SUB_PKT0_L";
        desc = "SPIF_SUB_PKT0_L (offset 0x64 in this sub-block, absolute 0x13001864). Reset INIT 0x00000000. PROVEN: vendor register header. Driver usage (vendor hal/drv C, uncommented call sites): 1 Get, 1 Set (hdmi_hal_ctrl.c): read and written (RW). ";
        field { name = "spd_sub_pkt0_pb3"; desc = ""; sw = rw; hw = r; reset = 0x0; } spd_sub_pkt0_pb3[31:24];
        field { name = "spd_sub_pkt0_pb2"; desc = ""; sw = rw; hw = r; reset = 0x0; } spd_sub_pkt0_pb2[23:16];
        field { name = "spd_sub_pkt0_pb1"; desc = ""; sw = rw; hw = r; reset = 0x0; } spd_sub_pkt0_pb1[15:8];
        field { name = "spd_sub_pkt0_pb0"; desc = ""; sw = rw; hw = r; reset = 0x0; } spd_sub_pkt0_pb0[7:0];
    } SPIF_SUB_PKT0_L @ 0x64;
    reg {
        name = "SPIF_SUB_PKT0_H";
        desc = "SPIF_SUB_PKT0_H (offset 0x68 in this sub-block, absolute 0x13001868). Reset INIT 0x00000000. PROVEN: vendor register header. Driver usage (vendor hal/drv C, uncommented call sites): 1 Get, 1 Set (hdmi_hal_ctrl.c): read and written (RW). ";
        field { name = "rsv_17"; desc = ""; sw = r; hw = na; reset = 0x0; } rsv_17[31:24];
        field { name = "spd_sub_pkt0_pb6"; desc = ""; sw = rw; hw = r; reset = 0x0; } spd_sub_pkt0_pb6[23:16];
        field { name = "spd_sub_pkt0_pb5"; desc = ""; sw = rw; hw = r; reset = 0x0; } spd_sub_pkt0_pb5[15:8];
        field { name = "spd_sub_pkt0_pb4"; desc = ""; sw = rw; hw = r; reset = 0x0; } spd_sub_pkt0_pb4[7:0];
    } SPIF_SUB_PKT0_H @ 0x68;
    reg {
        name = "SPIF_SUB_PKT1_L";
        desc = "SPIF_SUB_PKT1_L (offset 0x6C in this sub-block, absolute 0x1300186C). Reset INIT 0x00000000. PROVEN: vendor register header. Driver usage (vendor hal/drv C, uncommented call sites): 1 Get, 1 Set (hdmi_hal_ctrl.c): read and written (RW). ";
        field { name = "spd_sub_pkt1_pb3"; desc = ""; sw = rw; hw = r; reset = 0x0; } spd_sub_pkt1_pb3[31:24];
        field { name = "spd_sub_pkt1_pb2"; desc = ""; sw = rw; hw = r; reset = 0x0; } spd_sub_pkt1_pb2[23:16];
        field { name = "spd_sub_pkt1_pb1"; desc = ""; sw = rw; hw = r; reset = 0x0; } spd_sub_pkt1_pb1[15:8];
        field { name = "spd_sub_pkt1_pb0"; desc = ""; sw = rw; hw = r; reset = 0x0; } spd_sub_pkt1_pb0[7:0];
    } SPIF_SUB_PKT1_L @ 0x6C;
    reg {
        name = "SPIF_SUB_PKT1_H";
        desc = "SPIF_SUB_PKT1_H (offset 0x70 in this sub-block, absolute 0x13001870). Reset INIT 0x00000000. PROVEN: vendor register header. Driver usage (vendor hal/drv C, uncommented call sites): 1 Get, 1 Set (hdmi_hal_ctrl.c): read and written (RW). ";
        field { name = "rsv_18"; desc = ""; sw = r; hw = na; reset = 0x0; } rsv_18[31:24];
        field { name = "spd_sub_pkt1_pb6"; desc = ""; sw = rw; hw = r; reset = 0x0; } spd_sub_pkt1_pb6[23:16];
        field { name = "spd_sub_pkt1_pb5"; desc = ""; sw = rw; hw = r; reset = 0x0; } spd_sub_pkt1_pb5[15:8];
        field { name = "spd_sub_pkt1_pb4"; desc = ""; sw = rw; hw = r; reset = 0x0; } spd_sub_pkt1_pb4[7:0];
    } SPIF_SUB_PKT1_H @ 0x70;
    reg {
        name = "SPIF_SUB_PKT2_L";
        desc = "SPIF_SUB_PKT2_L (offset 0x74 in this sub-block, absolute 0x13001874). Reset INIT 0x00000000. PROVEN: vendor register header. Driver usage (vendor hal/drv C, uncommented call sites): 1 Get, 1 Set (hdmi_hal_ctrl.c): read and written (RW). ";
        field { name = "spd_sub_pkt2_pb3"; desc = ""; sw = rw; hw = r; reset = 0x0; } spd_sub_pkt2_pb3[31:24];
        field { name = "spd_sub_pkt2_pb2"; desc = ""; sw = rw; hw = r; reset = 0x0; } spd_sub_pkt2_pb2[23:16];
        field { name = "spd_sub_pkt2_pb1"; desc = ""; sw = rw; hw = r; reset = 0x0; } spd_sub_pkt2_pb1[15:8];
        field { name = "spd_sub_pkt2_pb0"; desc = ""; sw = rw; hw = r; reset = 0x0; } spd_sub_pkt2_pb0[7:0];
    } SPIF_SUB_PKT2_L @ 0x74;
    reg {
        name = "SPIF_SUB_PKT2_H";
        desc = "SPIF_SUB_PKT2_H (offset 0x78 in this sub-block, absolute 0x13001878). Reset INIT 0x00000000. PROVEN: vendor register header. Driver usage (vendor hal/drv C, uncommented call sites): 1 Get, 1 Set (hdmi_hal_ctrl.c): read and written (RW). ";
        field { name = "rsv_19"; desc = ""; sw = r; hw = na; reset = 0x0; } rsv_19[31:24];
        field { name = "spd_sub_pkt2_pb6"; desc = ""; sw = rw; hw = r; reset = 0x0; } spd_sub_pkt2_pb6[23:16];
        field { name = "spd_sub_pkt2_pb5"; desc = ""; sw = rw; hw = r; reset = 0x0; } spd_sub_pkt2_pb5[15:8];
        field { name = "spd_sub_pkt2_pb4"; desc = ""; sw = rw; hw = r; reset = 0x0; } spd_sub_pkt2_pb4[7:0];
    } SPIF_SUB_PKT2_H @ 0x78;
    reg {
        name = "SPIF_SUB_PKT3_L";
        desc = "SPIF_SUB_PKT3_L (offset 0x7C in this sub-block, absolute 0x1300187C). Reset INIT 0x00000000. PROVEN: vendor register header. Driver usage (vendor hal/drv C, uncommented call sites): 1 Get, 1 Set (hdmi_hal_ctrl.c): read and written (RW). ";
        field { name = "spd_sub_pkt3_pb3"; desc = ""; sw = rw; hw = r; reset = 0x0; } spd_sub_pkt3_pb3[31:24];
        field { name = "spd_sub_pkt3_pb2"; desc = ""; sw = rw; hw = r; reset = 0x0; } spd_sub_pkt3_pb2[23:16];
        field { name = "spd_sub_pkt3_pb1"; desc = ""; sw = rw; hw = r; reset = 0x0; } spd_sub_pkt3_pb1[15:8];
        field { name = "spd_sub_pkt3_pb0"; desc = ""; sw = rw; hw = r; reset = 0x0; } spd_sub_pkt3_pb0[7:0];
    } SPIF_SUB_PKT3_L @ 0x7C;
    reg {
        name = "SPIF_SUB_PKT3_H";
        desc = "SPIF_SUB_PKT3_H (offset 0x80 in this sub-block, absolute 0x13001880). Reset INIT 0x00000000. PROVEN: vendor register header. Driver usage (vendor hal/drv C, uncommented call sites): 1 Get, 1 Set (hdmi_hal_ctrl.c): read and written (RW). ";
        field { name = "rsv_20"; desc = ""; sw = r; hw = na; reset = 0x0; } rsv_20[31:24];
        field { name = "spd_sub_pkt3_pb6"; desc = ""; sw = rw; hw = r; reset = 0x0; } spd_sub_pkt3_pb6[23:16];
        field { name = "spd_sub_pkt3_pb5"; desc = ""; sw = rw; hw = r; reset = 0x0; } spd_sub_pkt3_pb5[15:8];
        field { name = "spd_sub_pkt3_pb4"; desc = ""; sw = rw; hw = r; reset = 0x0; } spd_sub_pkt3_pb4[7:0];
    } SPIF_SUB_PKT3_H @ 0x80;
    reg {
        name = "MPEG_PKT_HEADER";
        desc = "MPEG_PKT_HEADER (offset 0x84 in this sub-block, absolute 0x13001884). Reset INIT 0x00000000. PROVEN: vendor register header. Driver usage (vendor hal/drv C, uncommented call sites): 1 Get, 1 Set (hdmi_hal_ctrl.c): read and written (RW). ";
        field { name = "rsv_21"; desc = ""; sw = r; hw = na; reset = 0x0; } rsv_21[31:24];
        field { name = "mpeg_pkt_hb2"; desc = ""; sw = rw; hw = r; reset = 0x0; } mpeg_pkt_hb2[23:16];
        field { name = "mpeg_pkt_hb1"; desc = ""; sw = rw; hw = r; reset = 0x0; } mpeg_pkt_hb1[15:8];
        field { name = "mpeg_pkt_hb0"; desc = ""; sw = rw; hw = r; reset = 0x0; } mpeg_pkt_hb0[7:0];
    } MPEG_PKT_HEADER @ 0x84;
    reg {
        name = "MPEG_SUB_PKT0_L";
        desc = "MPEG_SUB_PKT0_L (offset 0x88 in this sub-block, absolute 0x13001888). Reset INIT 0x00000000. PROVEN: vendor register header. Driver usage (vendor hal/drv C, uncommented call sites): 1 Get, 1 Set (hdmi_hal_ctrl.c): read and written (RW). ";
        field { name = "mpeg_sub_pkt0_pb3"; desc = ""; sw = rw; hw = r; reset = 0x0; } mpeg_sub_pkt0_pb3[31:24];
        field { name = "mpeg_sub_pkt0_pb2"; desc = ""; sw = rw; hw = r; reset = 0x0; } mpeg_sub_pkt0_pb2[23:16];
        field { name = "mpeg_sub_pkt0_pb1"; desc = ""; sw = rw; hw = r; reset = 0x0; } mpeg_sub_pkt0_pb1[15:8];
        field { name = "mpeg_sub_pkt0_pb0"; desc = ""; sw = rw; hw = r; reset = 0x0; } mpeg_sub_pkt0_pb0[7:0];
    } MPEG_SUB_PKT0_L @ 0x88;
    reg {
        name = "MPEG_SUB_PKT0_H";
        desc = "MPEG_SUB_PKT0_H (offset 0x8C in this sub-block, absolute 0x1300188C). Reset INIT 0x00000000. PROVEN: vendor register header. Driver usage (vendor hal/drv C, uncommented call sites): 1 Get, 1 Set (hdmi_hal_ctrl.c): read and written (RW). ";
        field { name = "rsv_22"; desc = ""; sw = r; hw = na; reset = 0x0; } rsv_22[31:24];
        field { name = "mpeg_sub_pkt0_pb6"; desc = ""; sw = rw; hw = r; reset = 0x0; } mpeg_sub_pkt0_pb6[23:16];
        field { name = "mpeg_sub_pkt0_pb5"; desc = ""; sw = rw; hw = r; reset = 0x0; } mpeg_sub_pkt0_pb5[15:8];
        field { name = "mpeg_sub_pkt0_pb4"; desc = ""; sw = rw; hw = r; reset = 0x0; } mpeg_sub_pkt0_pb4[7:0];
    } MPEG_SUB_PKT0_H @ 0x8C;
    reg {
        name = "MPEG_SUB_PKT1_L";
        desc = "MPEG_SUB_PKT1_L (offset 0x90 in this sub-block, absolute 0x13001890). Reset INIT 0x00000000. PROVEN: vendor register header. Driver usage (vendor hal/drv C, uncommented call sites): 1 Get, 1 Set (hdmi_hal_ctrl.c): read and written (RW). ";
        field { name = "mpeg_sub_pkt1_pb3"; desc = ""; sw = rw; hw = r; reset = 0x0; } mpeg_sub_pkt1_pb3[31:24];
        field { name = "mpeg_sub_pkt1_pb2"; desc = ""; sw = rw; hw = r; reset = 0x0; } mpeg_sub_pkt1_pb2[23:16];
        field { name = "mpeg_sub_pkt1_pb1"; desc = ""; sw = rw; hw = r; reset = 0x0; } mpeg_sub_pkt1_pb1[15:8];
        field { name = "mpeg_sub_pkt1_pb0"; desc = ""; sw = rw; hw = r; reset = 0x0; } mpeg_sub_pkt1_pb0[7:0];
    } MPEG_SUB_PKT1_L @ 0x90;
    reg {
        name = "MPEG_SUB_PKT1_H";
        desc = "MPEG_SUB_PKT1_H (offset 0x94 in this sub-block, absolute 0x13001894). Reset INIT 0x00000000. PROVEN: vendor register header. Driver usage (vendor hal/drv C, uncommented call sites): 1 Get, 1 Set (hdmi_hal_ctrl.c): read and written (RW). ";
        field { name = "rsv_23"; desc = ""; sw = r; hw = na; reset = 0x0; } rsv_23[31:24];
        field { name = "mpeg_sub_pkt1_pb6"; desc = ""; sw = rw; hw = r; reset = 0x0; } mpeg_sub_pkt1_pb6[23:16];
        field { name = "mpeg_sub_pkt1_pb5"; desc = ""; sw = rw; hw = r; reset = 0x0; } mpeg_sub_pkt1_pb5[15:8];
        field { name = "mpeg_sub_pkt1_pb4"; desc = ""; sw = rw; hw = r; reset = 0x0; } mpeg_sub_pkt1_pb4[7:0];
    } MPEG_SUB_PKT1_H @ 0x94;
    reg {
        name = "MPEG_SUB_PKT2_L";
        desc = "MPEG_SUB_PKT2_L (offset 0x98 in this sub-block, absolute 0x13001898). Reset INIT 0x00000000. PROVEN: vendor register header. Driver usage (vendor hal/drv C, uncommented call sites): 1 Get, 1 Set (hdmi_hal_ctrl.c): read and written (RW). ";
        field { name = "mpeg_sub_pkt2_pb3"; desc = ""; sw = rw; hw = r; reset = 0x0; } mpeg_sub_pkt2_pb3[31:24];
        field { name = "mpeg_sub_pkt2_pb2"; desc = ""; sw = rw; hw = r; reset = 0x0; } mpeg_sub_pkt2_pb2[23:16];
        field { name = "mpeg_sub_pkt2_pb1"; desc = ""; sw = rw; hw = r; reset = 0x0; } mpeg_sub_pkt2_pb1[15:8];
        field { name = "mpeg_sub_pkt2_pb0"; desc = ""; sw = rw; hw = r; reset = 0x0; } mpeg_sub_pkt2_pb0[7:0];
    } MPEG_SUB_PKT2_L @ 0x98;
    reg {
        name = "MPEG_SUB_PKT2_H";
        desc = "MPEG_SUB_PKT2_H (offset 0x9C in this sub-block, absolute 0x1300189C). Reset INIT 0x00000000. PROVEN: vendor register header. Driver usage (vendor hal/drv C, uncommented call sites): 1 Get, 1 Set (hdmi_hal_ctrl.c): read and written (RW). ";
        field { name = "rsv_24"; desc = ""; sw = r; hw = na; reset = 0x0; } rsv_24[31:24];
        field { name = "mpeg_sub_pkt2_pb6"; desc = ""; sw = rw; hw = r; reset = 0x0; } mpeg_sub_pkt2_pb6[23:16];
        field { name = "mpeg_sub_pkt2_pb5"; desc = ""; sw = rw; hw = r; reset = 0x0; } mpeg_sub_pkt2_pb5[15:8];
        field { name = "mpeg_sub_pkt2_pb4"; desc = ""; sw = rw; hw = r; reset = 0x0; } mpeg_sub_pkt2_pb4[7:0];
    } MPEG_SUB_PKT2_H @ 0x9C;
    reg {
        name = "MPEG_SUB_PKT3_L";
        desc = "MPEG_SUB_PKT3_L (offset 0xA0 in this sub-block, absolute 0x130018A0). Reset INIT 0x00000000. PROVEN: vendor register header. Driver usage (vendor hal/drv C, uncommented call sites): 1 Get, 1 Set (hdmi_hal_ctrl.c): read and written (RW). ";
        field { name = "mpeg_sub_pkt3_pb3"; desc = ""; sw = rw; hw = r; reset = 0x0; } mpeg_sub_pkt3_pb3[31:24];
        field { name = "mpeg_sub_pkt3_pb2"; desc = ""; sw = rw; hw = r; reset = 0x0; } mpeg_sub_pkt3_pb2[23:16];
        field { name = "mpeg_sub_pkt3_pb1"; desc = ""; sw = rw; hw = r; reset = 0x0; } mpeg_sub_pkt3_pb1[15:8];
        field { name = "mpeg_sub_pkt3_pb0"; desc = ""; sw = rw; hw = r; reset = 0x0; } mpeg_sub_pkt3_pb0[7:0];
    } MPEG_SUB_PKT3_L @ 0xA0;
    reg {
        name = "MPEG_SUB_PKT3_H";
        desc = "MPEG_SUB_PKT3_H (offset 0xA4 in this sub-block, absolute 0x130018A4). Reset INIT 0x00000000. PROVEN: vendor register header. Driver usage (vendor hal/drv C, uncommented call sites): 1 Get, 1 Set (hdmi_hal_ctrl.c): read and written (RW). ";
        field { name = "rsv_25"; desc = ""; sw = r; hw = na; reset = 0x0; } rsv_25[31:24];
        field { name = "mpeg_sub_pkt3_pb6"; desc = ""; sw = rw; hw = r; reset = 0x0; } mpeg_sub_pkt3_pb6[23:16];
        field { name = "mpeg_sub_pkt3_pb5"; desc = ""; sw = rw; hw = r; reset = 0x0; } mpeg_sub_pkt3_pb5[15:8];
        field { name = "mpeg_sub_pkt3_pb4"; desc = ""; sw = rw; hw = r; reset = 0x0; } mpeg_sub_pkt3_pb4[7:0];
    } MPEG_SUB_PKT3_H @ 0xA4;
    reg {
        name = "GEN_PKT_HEADER";
        desc = "GEN_PKT_HEADER (offset 0xA8 in this sub-block, absolute 0x130018A8). Reset INIT 0x00000000. PROVEN: vendor register header. Driver usage (vendor hal/drv C, uncommented call sites): 1 Get, 1 Set (hdmi_hal_ctrl.c): read and written (RW). ";
        field { name = "rsv_26"; desc = ""; sw = r; hw = na; reset = 0x0; } rsv_26[31:24];
        field { name = "gen_pkt_hb2"; desc = ""; sw = rw; hw = r; reset = 0x0; } gen_pkt_hb2[23:16];
        field { name = "gen_pkt_hb1"; desc = ""; sw = rw; hw = r; reset = 0x0; } gen_pkt_hb1[15:8];
        field { name = "gen_pkt_hb0"; desc = ""; sw = rw; hw = r; reset = 0x0; } gen_pkt_hb0[7:0];
    } GEN_PKT_HEADER @ 0xA8;
    reg {
        name = "GEN_SUB_PKT0_L";
        desc = "GEN_SUB_PKT0_L (offset 0xAC in this sub-block, absolute 0x130018AC). Reset INIT 0x00000000. PROVEN: vendor register header. Driver usage (vendor hal/drv C, uncommented call sites): 1 Get, 1 Set (hdmi_hal_ctrl.c): read and written (RW). ";
        field { name = "gen_sub_pkt0_pb3"; desc = ""; sw = rw; hw = r; reset = 0x0; } gen_sub_pkt0_pb3[31:24];
        field { name = "gen_sub_pkt0_pb2"; desc = ""; sw = rw; hw = r; reset = 0x0; } gen_sub_pkt0_pb2[23:16];
        field { name = "gen_sub_pkt0_pb1"; desc = ""; sw = rw; hw = r; reset = 0x0; } gen_sub_pkt0_pb1[15:8];
        field { name = "gen_sub_pkt0_pb0"; desc = ""; sw = rw; hw = r; reset = 0x0; } gen_sub_pkt0_pb0[7:0];
    } GEN_SUB_PKT0_L @ 0xAC;
    reg {
        name = "GEN_SUB_PKT0_H";
        desc = "GEN_SUB_PKT0_H (offset 0xB0 in this sub-block, absolute 0x130018B0). Reset INIT 0x00000000. PROVEN: vendor register header. Driver usage (vendor hal/drv C, uncommented call sites): 1 Get, 1 Set (hdmi_hal_ctrl.c): read and written (RW). ";
        field { name = "rsv_27"; desc = ""; sw = r; hw = na; reset = 0x0; } rsv_27[31:24];
        field { name = "gen_sub_pkt0_pb6"; desc = ""; sw = rw; hw = r; reset = 0x0; } gen_sub_pkt0_pb6[23:16];
        field { name = "gen_sub_pkt0_pb5"; desc = ""; sw = rw; hw = r; reset = 0x0; } gen_sub_pkt0_pb5[15:8];
        field { name = "gen_sub_pkt0_pb4"; desc = ""; sw = rw; hw = r; reset = 0x0; } gen_sub_pkt0_pb4[7:0];
    } GEN_SUB_PKT0_H @ 0xB0;
    reg {
        name = "GEN_SUB_PKT1_L";
        desc = "GEN_SUB_PKT1_L (offset 0xB4 in this sub-block, absolute 0x130018B4). Reset INIT 0x00000000. PROVEN: vendor register header. Driver usage (vendor hal/drv C, uncommented call sites): 1 Get, 1 Set (hdmi_hal_ctrl.c): read and written (RW). ";
        field { name = "gen_sub_pkt1_pb3"; desc = ""; sw = rw; hw = r; reset = 0x0; } gen_sub_pkt1_pb3[31:24];
        field { name = "gen_sub_pkt1_pb2"; desc = ""; sw = rw; hw = r; reset = 0x0; } gen_sub_pkt1_pb2[23:16];
        field { name = "gen_sub_pkt1_pb1"; desc = ""; sw = rw; hw = r; reset = 0x0; } gen_sub_pkt1_pb1[15:8];
        field { name = "gen_sub_pkt1_pb0"; desc = ""; sw = rw; hw = r; reset = 0x0; } gen_sub_pkt1_pb0[7:0];
    } GEN_SUB_PKT1_L @ 0xB4;
    reg {
        name = "GEN_SUB_PKT1_H";
        desc = "GEN_SUB_PKT1_H (offset 0xB8 in this sub-block, absolute 0x130018B8). Reset INIT 0x00000000. PROVEN: vendor register header. Driver usage (vendor hal/drv C, uncommented call sites): 1 Get, 1 Set (hdmi_hal_ctrl.c): read and written (RW). ";
        field { name = "rsv_28"; desc = ""; sw = r; hw = na; reset = 0x0; } rsv_28[31:24];
        field { name = "gen_sub_pkt1_pb6"; desc = ""; sw = rw; hw = r; reset = 0x0; } gen_sub_pkt1_pb6[23:16];
        field { name = "gen_sub_pkt1_pb5"; desc = ""; sw = rw; hw = r; reset = 0x0; } gen_sub_pkt1_pb5[15:8];
        field { name = "gen_sub_pkt1_pb4"; desc = ""; sw = rw; hw = r; reset = 0x0; } gen_sub_pkt1_pb4[7:0];
    } GEN_SUB_PKT1_H @ 0xB8;
    reg {
        name = "GEN_SUB_PKT2_L";
        desc = "GEN_SUB_PKT2_L (offset 0xBC in this sub-block, absolute 0x130018BC). Reset INIT 0x00000000. PROVEN: vendor register header. Driver usage (vendor hal/drv C, uncommented call sites): 1 Get, 1 Set (hdmi_hal_ctrl.c): read and written (RW). ";
        field { name = "gen_sub_pkt2_pb3"; desc = ""; sw = rw; hw = r; reset = 0x0; } gen_sub_pkt2_pb3[31:24];
        field { name = "gen_sub_pkt2_pb2"; desc = ""; sw = rw; hw = r; reset = 0x0; } gen_sub_pkt2_pb2[23:16];
        field { name = "gen_sub_pkt2_pb1"; desc = ""; sw = rw; hw = r; reset = 0x0; } gen_sub_pkt2_pb1[15:8];
        field { name = "gen_sub_pkt2_pb0"; desc = ""; sw = rw; hw = r; reset = 0x0; } gen_sub_pkt2_pb0[7:0];
    } GEN_SUB_PKT2_L @ 0xBC;
    reg {
        name = "GEN_SUB_PKT2_H";
        desc = "GEN_SUB_PKT2_H (offset 0xC0 in this sub-block, absolute 0x130018C0). Reset INIT 0x00000000. PROVEN: vendor register header. Driver usage (vendor hal/drv C, uncommented call sites): 1 Get, 1 Set (hdmi_hal_ctrl.c): read and written (RW). ";
        field { name = "rsv_29"; desc = ""; sw = r; hw = na; reset = 0x0; } rsv_29[31:24];
        field { name = "gen_sub_pkt2_pb6"; desc = ""; sw = rw; hw = r; reset = 0x0; } gen_sub_pkt2_pb6[23:16];
        field { name = "gen_sub_pkt2_pb5"; desc = ""; sw = rw; hw = r; reset = 0x0; } gen_sub_pkt2_pb5[15:8];
        field { name = "gen_sub_pkt2_pb4"; desc = ""; sw = rw; hw = r; reset = 0x0; } gen_sub_pkt2_pb4[7:0];
    } GEN_SUB_PKT2_H @ 0xC0;
    reg {
        name = "GEN_SUB_PKT3_L";
        desc = "GEN_SUB_PKT3_L (offset 0xC4 in this sub-block, absolute 0x130018C4). Reset INIT 0x00000000. PROVEN: vendor register header. Driver usage (vendor hal/drv C, uncommented call sites): 1 Get, 1 Set (hdmi_hal_ctrl.c): read and written (RW). ";
        field { name = "gen_sub_pkt3_pb3"; desc = ""; sw = rw; hw = r; reset = 0x0; } gen_sub_pkt3_pb3[31:24];
        field { name = "gen_sub_pkt3_pb2"; desc = ""; sw = rw; hw = r; reset = 0x0; } gen_sub_pkt3_pb2[23:16];
        field { name = "gen_sub_pkt3_pb1"; desc = ""; sw = rw; hw = r; reset = 0x0; } gen_sub_pkt3_pb1[15:8];
        field { name = "gen_sub_pkt3_pb0"; desc = ""; sw = rw; hw = r; reset = 0x0; } gen_sub_pkt3_pb0[7:0];
    } GEN_SUB_PKT3_L @ 0xC4;
    reg {
        name = "GEN_SUB_PKT3_H";
        desc = "GEN_SUB_PKT3_H (offset 0xC8 in this sub-block, absolute 0x130018C8). Reset INIT 0x00000000. PROVEN: vendor register header. Driver usage (vendor hal/drv C, uncommented call sites): 1 Get, 1 Set (hdmi_hal_ctrl.c): read and written (RW). ";
        field { name = "rsv_30"; desc = ""; sw = r; hw = na; reset = 0x0; } rsv_30[31:24];
        field { name = "gen_sub_pkt3_pb6"; desc = ""; sw = rw; hw = r; reset = 0x0; } gen_sub_pkt3_pb6[23:16];
        field { name = "gen_sub_pkt3_pb5"; desc = ""; sw = rw; hw = r; reset = 0x0; } gen_sub_pkt3_pb5[15:8];
        field { name = "gen_sub_pkt3_pb4"; desc = ""; sw = rw; hw = r; reset = 0x0; } gen_sub_pkt3_pb4[7:0];
    } GEN_SUB_PKT3_H @ 0xC8;
    reg {
        name = "GEN2_PKT_HEADER";
        desc = "GEN2_PKT_HEADER (offset 0xCC in this sub-block, absolute 0x130018CC). Reset INIT 0x00000000. PROVEN: vendor register header. No call site in the vendor hal/drv C sources: access by register-name convention only (INFERRED). ";
        field { name = "rsv_31"; desc = ""; sw = r; hw = na; reset = 0x0; } rsv_31[31:24];
        field { name = "gen2_pkt_hb2"; desc = ""; sw = rw; hw = r; reset = 0x0; } gen2_pkt_hb2[23:16];
        field { name = "gen2_pkt_hb1"; desc = ""; sw = rw; hw = r; reset = 0x0; } gen2_pkt_hb1[15:8];
        field { name = "gen2_pkt_hb0"; desc = ""; sw = rw; hw = r; reset = 0x0; } gen2_pkt_hb0[7:0];
    } GEN2_PKT_HEADER @ 0xCC;
    reg {
        name = "GEN2_SUB_PKT0_L";
        desc = "GEN2_SUB_PKT0_L (offset 0xD0 in this sub-block, absolute 0x130018D0). Reset INIT 0x00000000. PROVEN: vendor register header. No call site in the vendor hal/drv C sources: access by register-name convention only (INFERRED). ";
        field { name = "gen2_sub_pkt0_pb3"; desc = ""; sw = rw; hw = r; reset = 0x0; } gen2_sub_pkt0_pb3[31:24];
        field { name = "gen2_sub_pkt0_pb2"; desc = ""; sw = rw; hw = r; reset = 0x0; } gen2_sub_pkt0_pb2[23:16];
        field { name = "gen2_sub_pkt0_pb1"; desc = ""; sw = rw; hw = r; reset = 0x0; } gen2_sub_pkt0_pb1[15:8];
        field { name = "gen2_sub_pkt0_pb0"; desc = ""; sw = rw; hw = r; reset = 0x0; } gen2_sub_pkt0_pb0[7:0];
    } GEN2_SUB_PKT0_L @ 0xD0;
    reg {
        name = "GEN2_SUB_PKT0_H";
        desc = "GEN2_SUB_PKT0_H (offset 0xD4 in this sub-block, absolute 0x130018D4). Reset INIT 0x00000000. PROVEN: vendor register header. No call site in the vendor hal/drv C sources: access by register-name convention only (INFERRED). ";
        field { name = "rsv_32"; desc = ""; sw = r; hw = na; reset = 0x0; } rsv_32[31:24];
        field { name = "gen2_sub_pkt0_pb6"; desc = ""; sw = rw; hw = r; reset = 0x0; } gen2_sub_pkt0_pb6[23:16];
        field { name = "gen2_sub_pkt0_pb5"; desc = ""; sw = rw; hw = r; reset = 0x0; } gen2_sub_pkt0_pb5[15:8];
        field { name = "gen2_sub_pkt0_pb4"; desc = ""; sw = rw; hw = r; reset = 0x0; } gen2_sub_pkt0_pb4[7:0];
    } GEN2_SUB_PKT0_H @ 0xD4;
    reg {
        name = "GEN2_SUB_PKT1_L";
        desc = "GEN2_SUB_PKT1_L (offset 0xD8 in this sub-block, absolute 0x130018D8). Reset INIT 0x00000000. PROVEN: vendor register header. No call site in the vendor hal/drv C sources: access by register-name convention only (INFERRED). ";
        field { name = "gen2_sub_pkt1_pb3"; desc = ""; sw = rw; hw = r; reset = 0x0; } gen2_sub_pkt1_pb3[31:24];
        field { name = "gen2_sub_pkt1_pb2"; desc = ""; sw = rw; hw = r; reset = 0x0; } gen2_sub_pkt1_pb2[23:16];
        field { name = "gen2_sub_pkt1_pb1"; desc = ""; sw = rw; hw = r; reset = 0x0; } gen2_sub_pkt1_pb1[15:8];
        field { name = "gen2_sub_pkt1_pb0"; desc = ""; sw = rw; hw = r; reset = 0x0; } gen2_sub_pkt1_pb0[7:0];
    } GEN2_SUB_PKT1_L @ 0xD8;
    reg {
        name = "GEN2_SUB_PKT1_H";
        desc = "GEN2_SUB_PKT1_H (offset 0xDC in this sub-block, absolute 0x130018DC). Reset INIT 0x00000000. PROVEN: vendor register header. No call site in the vendor hal/drv C sources: access by register-name convention only (INFERRED). ";
        field { name = "rsv_33"; desc = ""; sw = r; hw = na; reset = 0x0; } rsv_33[31:24];
        field { name = "gen2_sub_pkt1_pb6"; desc = ""; sw = rw; hw = r; reset = 0x0; } gen2_sub_pkt1_pb6[23:16];
        field { name = "gen2_sub_pkt1_pb5"; desc = ""; sw = rw; hw = r; reset = 0x0; } gen2_sub_pkt1_pb5[15:8];
        field { name = "gen2_sub_pkt1_pb4"; desc = ""; sw = rw; hw = r; reset = 0x0; } gen2_sub_pkt1_pb4[7:0];
    } GEN2_SUB_PKT1_H @ 0xDC;
    reg {
        name = "GEN2_SUB_PKT2_L";
        desc = "GEN2_SUB_PKT2_L (offset 0xE0 in this sub-block, absolute 0x130018E0). Reset INIT 0x00000000. PROVEN: vendor register header. No call site in the vendor hal/drv C sources: access by register-name convention only (INFERRED). ";
        field { name = "gen2_sub_pkt2_pb3"; desc = ""; sw = rw; hw = r; reset = 0x0; } gen2_sub_pkt2_pb3[31:24];
        field { name = "gen2_sub_pkt2_pb2"; desc = ""; sw = rw; hw = r; reset = 0x0; } gen2_sub_pkt2_pb2[23:16];
        field { name = "gen2_sub_pkt2_pb1"; desc = ""; sw = rw; hw = r; reset = 0x0; } gen2_sub_pkt2_pb1[15:8];
        field { name = "gen2_sub_pkt2_pb0"; desc = ""; sw = rw; hw = r; reset = 0x0; } gen2_sub_pkt2_pb0[7:0];
    } GEN2_SUB_PKT2_L @ 0xE0;
    reg {
        name = "GEN2_SUB_PKT2_H";
        desc = "GEN2_SUB_PKT2_H (offset 0xE4 in this sub-block, absolute 0x130018E4). Reset INIT 0x00000000. PROVEN: vendor register header. No call site in the vendor hal/drv C sources: access by register-name convention only (INFERRED). ";
        field { name = "rsv_34"; desc = ""; sw = r; hw = na; reset = 0x0; } rsv_34[31:24];
        field { name = "gen2_sub_pkt2_pb6"; desc = ""; sw = rw; hw = r; reset = 0x0; } gen2_sub_pkt2_pb6[23:16];
        field { name = "gen2_sub_pkt2_pb5"; desc = ""; sw = rw; hw = r; reset = 0x0; } gen2_sub_pkt2_pb5[15:8];
        field { name = "gen2_sub_pkt2_pb4"; desc = ""; sw = rw; hw = r; reset = 0x0; } gen2_sub_pkt2_pb4[7:0];
    } GEN2_SUB_PKT2_H @ 0xE4;
    reg {
        name = "GEN2_SUB_PKT3_L";
        desc = "GEN2_SUB_PKT3_L (offset 0xE8 in this sub-block, absolute 0x130018E8). Reset INIT 0x00000000. PROVEN: vendor register header. No call site in the vendor hal/drv C sources: access by register-name convention only (INFERRED). ";
        field { name = "gen2_sub_pkt3_pb3"; desc = ""; sw = rw; hw = r; reset = 0x0; } gen2_sub_pkt3_pb3[31:24];
        field { name = "gen2_sub_pkt3_pb2"; desc = ""; sw = rw; hw = r; reset = 0x0; } gen2_sub_pkt3_pb2[23:16];
        field { name = "gen2_sub_pkt3_pb1"; desc = ""; sw = rw; hw = r; reset = 0x0; } gen2_sub_pkt3_pb1[15:8];
        field { name = "gen2_sub_pkt3_pb0"; desc = ""; sw = rw; hw = r; reset = 0x0; } gen2_sub_pkt3_pb0[7:0];
    } GEN2_SUB_PKT3_L @ 0xE8;
    reg {
        name = "GEN2_SUB_PKT3_H";
        desc = "GEN2_SUB_PKT3_H (offset 0xEC in this sub-block, absolute 0x130018EC). Reset INIT 0x00000000. PROVEN: vendor register header. No call site in the vendor hal/drv C sources: access by register-name convention only (INFERRED). ";
        field { name = "rsv_35"; desc = ""; sw = r; hw = na; reset = 0x0; } rsv_35[31:24];
        field { name = "gen2_sub_pkt3_pb6"; desc = ""; sw = rw; hw = r; reset = 0x0; } gen2_sub_pkt3_pb6[23:16];
        field { name = "gen2_sub_pkt3_pb5"; desc = ""; sw = rw; hw = r; reset = 0x0; } gen2_sub_pkt3_pb5[15:8];
        field { name = "gen2_sub_pkt3_pb4"; desc = ""; sw = rw; hw = r; reset = 0x0; } gen2_sub_pkt3_pb4[7:0];
    } GEN2_SUB_PKT3_H @ 0xEC;
    reg {
        name = "GEN3_PKT_HEADER";
        desc = "GEN3_PKT_HEADER (offset 0xF0 in this sub-block, absolute 0x130018F0). Reset INIT 0x00000000. PROVEN: vendor register header. No call site in the vendor hal/drv C sources: access by register-name convention only (INFERRED). ";
        field { name = "rsv_36"; desc = ""; sw = r; hw = na; reset = 0x0; } rsv_36[31:24];
        field { name = "gen3_pkt_hb2"; desc = ""; sw = rw; hw = r; reset = 0x0; } gen3_pkt_hb2[23:16];
        field { name = "gen3_pkt_hb1"; desc = ""; sw = rw; hw = r; reset = 0x0; } gen3_pkt_hb1[15:8];
        field { name = "gen3_pkt_hb0"; desc = ""; sw = rw; hw = r; reset = 0x0; } gen3_pkt_hb0[7:0];
    } GEN3_PKT_HEADER @ 0xF0;
    reg {
        name = "GEN3_SUB_PKT0_L";
        desc = "GEN3_SUB_PKT0_L (offset 0xF4 in this sub-block, absolute 0x130018F4). Reset INIT 0x00000000. PROVEN: vendor register header. No call site in the vendor hal/drv C sources: access by register-name convention only (INFERRED). ";
        field { name = "gen3_sub_pkt0_pb3"; desc = ""; sw = rw; hw = r; reset = 0x0; } gen3_sub_pkt0_pb3[31:24];
        field { name = "gen3_sub_pkt0_pb2"; desc = ""; sw = rw; hw = r; reset = 0x0; } gen3_sub_pkt0_pb2[23:16];
        field { name = "gen3_sub_pkt0_pb1"; desc = ""; sw = rw; hw = r; reset = 0x0; } gen3_sub_pkt0_pb1[15:8];
        field { name = "gen3_sub_pkt0_pb0"; desc = ""; sw = rw; hw = r; reset = 0x0; } gen3_sub_pkt0_pb0[7:0];
    } GEN3_SUB_PKT0_L @ 0xF4;
    reg {
        name = "GEN3_SUB_PKT0_H";
        desc = "GEN3_SUB_PKT0_H (offset 0xF8 in this sub-block, absolute 0x130018F8). Reset INIT 0x00000000. PROVEN: vendor register header. No call site in the vendor hal/drv C sources: access by register-name convention only (INFERRED). ";
        field { name = "rsv_37"; desc = ""; sw = r; hw = na; reset = 0x0; } rsv_37[31:24];
        field { name = "gen3_sub_pkt0_pb6"; desc = ""; sw = rw; hw = r; reset = 0x0; } gen3_sub_pkt0_pb6[23:16];
        field { name = "gen3_sub_pkt0_pb5"; desc = ""; sw = rw; hw = r; reset = 0x0; } gen3_sub_pkt0_pb5[15:8];
        field { name = "gen3_sub_pkt0_pb4"; desc = ""; sw = rw; hw = r; reset = 0x0; } gen3_sub_pkt0_pb4[7:0];
    } GEN3_SUB_PKT0_H @ 0xF8;
    reg {
        name = "GEN3_SUB_PKT1_L";
        desc = "GEN3_SUB_PKT1_L (offset 0xFC in this sub-block, absolute 0x130018FC). Reset INIT 0x00000000. PROVEN: vendor register header. No call site in the vendor hal/drv C sources: access by register-name convention only (INFERRED). ";
        field { name = "gen3_sub_pkt1_pb3"; desc = ""; sw = rw; hw = r; reset = 0x0; } gen3_sub_pkt1_pb3[31:24];
        field { name = "gen3_sub_pkt1_pb2"; desc = ""; sw = rw; hw = r; reset = 0x0; } gen3_sub_pkt1_pb2[23:16];
        field { name = "gen3_sub_pkt1_pb1"; desc = ""; sw = rw; hw = r; reset = 0x0; } gen3_sub_pkt1_pb1[15:8];
        field { name = "gen3_sub_pkt1_pb0"; desc = ""; sw = rw; hw = r; reset = 0x0; } gen3_sub_pkt1_pb0[7:0];
    } GEN3_SUB_PKT1_L @ 0xFC;
    reg {
        name = "GEN3_SUB_PKT1_H";
        desc = "GEN3_SUB_PKT1_H (offset 0x100 in this sub-block, absolute 0x13001900). Reset INIT 0x00000000. PROVEN: vendor register header. No call site in the vendor hal/drv C sources: access by register-name convention only (INFERRED). ";
        field { name = "rsv_38"; desc = ""; sw = r; hw = na; reset = 0x0; } rsv_38[31:24];
        field { name = "gen3_sub_pkt1_pb6"; desc = ""; sw = rw; hw = r; reset = 0x0; } gen3_sub_pkt1_pb6[23:16];
        field { name = "gen3_sub_pkt1_pb5"; desc = ""; sw = rw; hw = r; reset = 0x0; } gen3_sub_pkt1_pb5[15:8];
        field { name = "gen3_sub_pkt1_pb4"; desc = ""; sw = rw; hw = r; reset = 0x0; } gen3_sub_pkt1_pb4[7:0];
    } GEN3_SUB_PKT1_H @ 0x100;
    reg {
        name = "GEN3_SUB_PKT2_L";
        desc = "GEN3_SUB_PKT2_L (offset 0x104 in this sub-block, absolute 0x13001904). Reset INIT 0x00000000. PROVEN: vendor register header. No call site in the vendor hal/drv C sources: access by register-name convention only (INFERRED). ";
        field { name = "gen3_sub_pkt2_pb3"; desc = ""; sw = rw; hw = r; reset = 0x0; } gen3_sub_pkt2_pb3[31:24];
        field { name = "gen3_sub_pkt2_pb2"; desc = ""; sw = rw; hw = r; reset = 0x0; } gen3_sub_pkt2_pb2[23:16];
        field { name = "gen3_sub_pkt2_pb1"; desc = ""; sw = rw; hw = r; reset = 0x0; } gen3_sub_pkt2_pb1[15:8];
        field { name = "gen3_sub_pkt2_pb0"; desc = ""; sw = rw; hw = r; reset = 0x0; } gen3_sub_pkt2_pb0[7:0];
    } GEN3_SUB_PKT2_L @ 0x104;
    reg {
        name = "GEN3_SUB_PKT2_H";
        desc = "GEN3_SUB_PKT2_H (offset 0x108 in this sub-block, absolute 0x13001908). Reset INIT 0x00000000. PROVEN: vendor register header. No call site in the vendor hal/drv C sources: access by register-name convention only (INFERRED). ";
        field { name = "rsv_39"; desc = ""; sw = r; hw = na; reset = 0x0; } rsv_39[31:24];
        field { name = "gen3_sub_pkt2_pb6"; desc = ""; sw = rw; hw = r; reset = 0x0; } gen3_sub_pkt2_pb6[23:16];
        field { name = "gen3_sub_pkt2_pb5"; desc = ""; sw = rw; hw = r; reset = 0x0; } gen3_sub_pkt2_pb5[15:8];
        field { name = "gen3_sub_pkt2_pb4"; desc = ""; sw = rw; hw = r; reset = 0x0; } gen3_sub_pkt2_pb4[7:0];
    } GEN3_SUB_PKT2_H @ 0x108;
    reg {
        name = "GEN3_SUB_PKT3_L";
        desc = "GEN3_SUB_PKT3_L (offset 0x10C in this sub-block, absolute 0x1300190C). Reset INIT 0x00000000. PROVEN: vendor register header. No call site in the vendor hal/drv C sources: access by register-name convention only (INFERRED). ";
        field { name = "gen3_sub_pkt3_pb3"; desc = ""; sw = rw; hw = r; reset = 0x0; } gen3_sub_pkt3_pb3[31:24];
        field { name = "gen3_sub_pkt3_pb2"; desc = ""; sw = rw; hw = r; reset = 0x0; } gen3_sub_pkt3_pb2[23:16];
        field { name = "gen3_sub_pkt3_pb1"; desc = ""; sw = rw; hw = r; reset = 0x0; } gen3_sub_pkt3_pb1[15:8];
        field { name = "gen3_sub_pkt3_pb0"; desc = ""; sw = rw; hw = r; reset = 0x0; } gen3_sub_pkt3_pb0[7:0];
    } GEN3_SUB_PKT3_L @ 0x10C;
    reg {
        name = "GEN3_SUB_PKT3_H";
        desc = "GEN3_SUB_PKT3_H (offset 0x110 in this sub-block, absolute 0x13001910). Reset INIT 0x00000000. PROVEN: vendor register header. No call site in the vendor hal/drv C sources: access by register-name convention only (INFERRED). ";
        field { name = "rsv_40"; desc = ""; sw = r; hw = na; reset = 0x0; } rsv_40[31:24];
        field { name = "gen3_sub_pkt3_pb6"; desc = ""; sw = rw; hw = r; reset = 0x0; } gen3_sub_pkt3_pb6[23:16];
        field { name = "gen3_sub_pkt3_pb5"; desc = ""; sw = rw; hw = r; reset = 0x0; } gen3_sub_pkt3_pb5[15:8];
        field { name = "gen3_sub_pkt3_pb4"; desc = ""; sw = rw; hw = r; reset = 0x0; } gen3_sub_pkt3_pb4[7:0];
    } GEN3_SUB_PKT3_H @ 0x110;
    reg {
        name = "GEN4_PKT_HEADER";
        desc = "GEN4_PKT_HEADER (offset 0x114 in this sub-block, absolute 0x13001914). Reset INIT 0x00000000. PROVEN: vendor register header. No call site in the vendor hal/drv C sources: access by register-name convention only (INFERRED). ";
        field { name = "rsv_41"; desc = ""; sw = r; hw = na; reset = 0x0; } rsv_41[31:24];
        field { name = "gen4_pkt_hb2"; desc = ""; sw = rw; hw = r; reset = 0x0; } gen4_pkt_hb2[23:16];
        field { name = "gen4_pkt_hb1"; desc = ""; sw = rw; hw = r; reset = 0x0; } gen4_pkt_hb1[15:8];
        field { name = "gen4_pkt_hb0"; desc = ""; sw = rw; hw = r; reset = 0x0; } gen4_pkt_hb0[7:0];
    } GEN4_PKT_HEADER @ 0x114;
    reg {
        name = "GEN4_SUB_PKT0_L";
        desc = "GEN4_SUB_PKT0_L (offset 0x118 in this sub-block, absolute 0x13001918). Reset INIT 0x00000000. PROVEN: vendor register header. No call site in the vendor hal/drv C sources: access by register-name convention only (INFERRED). ";
        field { name = "gen4_sub_pkt0_pb3"; desc = ""; sw = rw; hw = r; reset = 0x0; } gen4_sub_pkt0_pb3[31:24];
        field { name = "gen4_sub_pkt0_pb2"; desc = ""; sw = rw; hw = r; reset = 0x0; } gen4_sub_pkt0_pb2[23:16];
        field { name = "gen4_sub_pkt0_pb1"; desc = ""; sw = rw; hw = r; reset = 0x0; } gen4_sub_pkt0_pb1[15:8];
        field { name = "gen4_sub_pkt0_pb0"; desc = ""; sw = rw; hw = r; reset = 0x0; } gen4_sub_pkt0_pb0[7:0];
    } GEN4_SUB_PKT0_L @ 0x118;
    reg {
        name = "GEN4_SUB_PKT0_H";
        desc = "GEN4_SUB_PKT0_H (offset 0x11C in this sub-block, absolute 0x1300191C). Reset INIT 0x00000000. PROVEN: vendor register header. No call site in the vendor hal/drv C sources: access by register-name convention only (INFERRED). ";
        field { name = "rsv_42"; desc = ""; sw = r; hw = na; reset = 0x0; } rsv_42[31:24];
        field { name = "gen4_sub_pkt0_pb6"; desc = ""; sw = rw; hw = r; reset = 0x0; } gen4_sub_pkt0_pb6[23:16];
        field { name = "gen4_sub_pkt0_pb5"; desc = ""; sw = rw; hw = r; reset = 0x0; } gen4_sub_pkt0_pb5[15:8];
        field { name = "gen4_sub_pkt0_pb4"; desc = ""; sw = rw; hw = r; reset = 0x0; } gen4_sub_pkt0_pb4[7:0];
    } GEN4_SUB_PKT0_H @ 0x11C;
    reg {
        name = "GEN4_SUB_PKT1_L";
        desc = "GEN4_SUB_PKT1_L (offset 0x120 in this sub-block, absolute 0x13001920). Reset INIT 0x00000000. PROVEN: vendor register header. No call site in the vendor hal/drv C sources: access by register-name convention only (INFERRED). ";
        field { name = "gen4_sub_pkt1_pb3"; desc = ""; sw = rw; hw = r; reset = 0x0; } gen4_sub_pkt1_pb3[31:24];
        field { name = "gen4_sub_pkt1_pb2"; desc = ""; sw = rw; hw = r; reset = 0x0; } gen4_sub_pkt1_pb2[23:16];
        field { name = "gen4_sub_pkt1_pb1"; desc = ""; sw = rw; hw = r; reset = 0x0; } gen4_sub_pkt1_pb1[15:8];
        field { name = "gen4_sub_pkt1_pb0"; desc = ""; sw = rw; hw = r; reset = 0x0; } gen4_sub_pkt1_pb0[7:0];
    } GEN4_SUB_PKT1_L @ 0x120;
    reg {
        name = "GEN4_SUB_PKT1_H";
        desc = "GEN4_SUB_PKT1_H (offset 0x124 in this sub-block, absolute 0x13001924). Reset INIT 0x00000000. PROVEN: vendor register header. No call site in the vendor hal/drv C sources: access by register-name convention only (INFERRED). ";
        field { name = "rsv_43"; desc = ""; sw = r; hw = na; reset = 0x0; } rsv_43[31:24];
        field { name = "gen4_sub_pkt1_pb6"; desc = ""; sw = rw; hw = r; reset = 0x0; } gen4_sub_pkt1_pb6[23:16];
        field { name = "gen4_sub_pkt1_pb5"; desc = ""; sw = rw; hw = r; reset = 0x0; } gen4_sub_pkt1_pb5[15:8];
        field { name = "gen4_sub_pkt1_pb4"; desc = ""; sw = rw; hw = r; reset = 0x0; } gen4_sub_pkt1_pb4[7:0];
    } GEN4_SUB_PKT1_H @ 0x124;
    reg {
        name = "GEN4_SUB_PKT2_L";
        desc = "GEN4_SUB_PKT2_L (offset 0x128 in this sub-block, absolute 0x13001928). Reset INIT 0x00000000. PROVEN: vendor register header. No call site in the vendor hal/drv C sources: access by register-name convention only (INFERRED). ";
        field { name = "gen4_sub_pkt2_pb3"; desc = ""; sw = rw; hw = r; reset = 0x0; } gen4_sub_pkt2_pb3[31:24];
        field { name = "gen4_sub_pkt2_pb2"; desc = ""; sw = rw; hw = r; reset = 0x0; } gen4_sub_pkt2_pb2[23:16];
        field { name = "gen4_sub_pkt2_pb1"; desc = ""; sw = rw; hw = r; reset = 0x0; } gen4_sub_pkt2_pb1[15:8];
        field { name = "gen4_sub_pkt2_pb0"; desc = ""; sw = rw; hw = r; reset = 0x0; } gen4_sub_pkt2_pb0[7:0];
    } GEN4_SUB_PKT2_L @ 0x128;
    reg {
        name = "GEN4_SUB_PKT2_H";
        desc = "GEN4_SUB_PKT2_H (offset 0x12C in this sub-block, absolute 0x1300192C). Reset INIT 0x00000000. PROVEN: vendor register header. No call site in the vendor hal/drv C sources: access by register-name convention only (INFERRED). ";
        field { name = "rsv_44"; desc = ""; sw = r; hw = na; reset = 0x0; } rsv_44[31:24];
        field { name = "gen4_sub_pkt2_pb6"; desc = ""; sw = rw; hw = r; reset = 0x0; } gen4_sub_pkt2_pb6[23:16];
        field { name = "gen4_sub_pkt2_pb5"; desc = ""; sw = rw; hw = r; reset = 0x0; } gen4_sub_pkt2_pb5[15:8];
        field { name = "gen4_sub_pkt2_pb4"; desc = ""; sw = rw; hw = r; reset = 0x0; } gen4_sub_pkt2_pb4[7:0];
    } GEN4_SUB_PKT2_H @ 0x12C;
    reg {
        name = "GEN4_SUB_PKT3_L";
        desc = "GEN4_SUB_PKT3_L (offset 0x130 in this sub-block, absolute 0x13001930). Reset INIT 0x00000000. PROVEN: vendor register header. No call site in the vendor hal/drv C sources: access by register-name convention only (INFERRED). ";
        field { name = "gen4_sub_pkt3_pb3"; desc = ""; sw = rw; hw = r; reset = 0x0; } gen4_sub_pkt3_pb3[31:24];
        field { name = "gen4_sub_pkt3_pb2"; desc = ""; sw = rw; hw = r; reset = 0x0; } gen4_sub_pkt3_pb2[23:16];
        field { name = "gen4_sub_pkt3_pb1"; desc = ""; sw = rw; hw = r; reset = 0x0; } gen4_sub_pkt3_pb1[15:8];
        field { name = "gen4_sub_pkt3_pb0"; desc = ""; sw = rw; hw = r; reset = 0x0; } gen4_sub_pkt3_pb0[7:0];
    } GEN4_SUB_PKT3_L @ 0x130;
    reg {
        name = "GEN4_SUB_PKT3_H";
        desc = "GEN4_SUB_PKT3_H (offset 0x134 in this sub-block, absolute 0x13001934). Reset INIT 0x00000000. PROVEN: vendor register header. No call site in the vendor hal/drv C sources: access by register-name convention only (INFERRED). ";
        field { name = "rsv_45"; desc = ""; sw = r; hw = na; reset = 0x0; } rsv_45[31:24];
        field { name = "gen4_sub_pkt3_pb6"; desc = ""; sw = rw; hw = r; reset = 0x0; } gen4_sub_pkt3_pb6[23:16];
        field { name = "gen4_sub_pkt3_pb5"; desc = ""; sw = rw; hw = r; reset = 0x0; } gen4_sub_pkt3_pb5[15:8];
        field { name = "gen4_sub_pkt3_pb4"; desc = ""; sw = rw; hw = r; reset = 0x0; } gen4_sub_pkt3_pb4[7:0];
    } GEN4_SUB_PKT3_H @ 0x134;
    reg {
        name = "GEN5_PKT_HEADER";
        desc = "GEN5_PKT_HEADER (offset 0x138 in this sub-block, absolute 0x13001938). Reset INIT 0x00000000. PROVEN: vendor register header. No call site in the vendor hal/drv C sources: access by register-name convention only (INFERRED). ";
        field { name = "rsv_46"; desc = ""; sw = r; hw = na; reset = 0x0; } rsv_46[31:24];
        field { name = "gen5_pkt_hb2"; desc = ""; sw = rw; hw = r; reset = 0x0; } gen5_pkt_hb2[23:16];
        field { name = "gen5_pkt_hb1"; desc = ""; sw = rw; hw = r; reset = 0x0; } gen5_pkt_hb1[15:8];
        field { name = "gen5_pkt_hb0"; desc = ""; sw = rw; hw = r; reset = 0x0; } gen5_pkt_hb0[7:0];
    } GEN5_PKT_HEADER @ 0x138;
    reg {
        name = "GEN5_SUB_PKT0_L";
        desc = "GEN5_SUB_PKT0_L (offset 0x13C in this sub-block, absolute 0x1300193C). Reset INIT 0x00000000. PROVEN: vendor register header. No call site in the vendor hal/drv C sources: access by register-name convention only (INFERRED). ";
        field { name = "gen5_sub_pkt0_pb3"; desc = ""; sw = rw; hw = r; reset = 0x0; } gen5_sub_pkt0_pb3[31:24];
        field { name = "gen5_sub_pkt0_pb2"; desc = ""; sw = rw; hw = r; reset = 0x0; } gen5_sub_pkt0_pb2[23:16];
        field { name = "gen5_sub_pkt0_pb1"; desc = ""; sw = rw; hw = r; reset = 0x0; } gen5_sub_pkt0_pb1[15:8];
        field { name = "gen5_sub_pkt0_pb0"; desc = ""; sw = rw; hw = r; reset = 0x0; } gen5_sub_pkt0_pb0[7:0];
    } GEN5_SUB_PKT0_L @ 0x13C;
    reg {
        name = "GEN5_SUB_PKT0_H";
        desc = "GEN5_SUB_PKT0_H (offset 0x140 in this sub-block, absolute 0x13001940). Reset INIT 0x00000000. PROVEN: vendor register header. No call site in the vendor hal/drv C sources: access by register-name convention only (INFERRED). ";
        field { name = "rsv_47"; desc = ""; sw = r; hw = na; reset = 0x0; } rsv_47[31:24];
        field { name = "gen5_sub_pkt0_pb6"; desc = ""; sw = rw; hw = r; reset = 0x0; } gen5_sub_pkt0_pb6[23:16];
        field { name = "gen5_sub_pkt0_pb5"; desc = ""; sw = rw; hw = r; reset = 0x0; } gen5_sub_pkt0_pb5[15:8];
        field { name = "gen5_sub_pkt0_pb4"; desc = ""; sw = rw; hw = r; reset = 0x0; } gen5_sub_pkt0_pb4[7:0];
    } GEN5_SUB_PKT0_H @ 0x140;
    reg {
        name = "GEN5_SUB_PKT1_L";
        desc = "GEN5_SUB_PKT1_L (offset 0x144 in this sub-block, absolute 0x13001944). Reset INIT 0x00000000. PROVEN: vendor register header. No call site in the vendor hal/drv C sources: access by register-name convention only (INFERRED). ";
        field { name = "gen5_sub_pkt1_pb3"; desc = ""; sw = rw; hw = r; reset = 0x0; } gen5_sub_pkt1_pb3[31:24];
        field { name = "gen5_sub_pkt1_pb2"; desc = ""; sw = rw; hw = r; reset = 0x0; } gen5_sub_pkt1_pb2[23:16];
        field { name = "gen5_sub_pkt1_pb1"; desc = ""; sw = rw; hw = r; reset = 0x0; } gen5_sub_pkt1_pb1[15:8];
        field { name = "gen5_sub_pkt1_pb0"; desc = ""; sw = rw; hw = r; reset = 0x0; } gen5_sub_pkt1_pb0[7:0];
    } GEN5_SUB_PKT1_L @ 0x144;
    reg {
        name = "GEN5_SUB_PKT1_H";
        desc = "GEN5_SUB_PKT1_H (offset 0x148 in this sub-block, absolute 0x13001948). Reset INIT 0x00000000. PROVEN: vendor register header. No call site in the vendor hal/drv C sources: access by register-name convention only (INFERRED). ";
        field { name = "rsv_48"; desc = ""; sw = r; hw = na; reset = 0x0; } rsv_48[31:24];
        field { name = "gen5_sub_pkt1_pb6"; desc = ""; sw = rw; hw = r; reset = 0x0; } gen5_sub_pkt1_pb6[23:16];
        field { name = "gen5_sub_pkt1_pb5"; desc = ""; sw = rw; hw = r; reset = 0x0; } gen5_sub_pkt1_pb5[15:8];
        field { name = "gen5_sub_pkt1_pb4"; desc = ""; sw = rw; hw = r; reset = 0x0; } gen5_sub_pkt1_pb4[7:0];
    } GEN5_SUB_PKT1_H @ 0x148;
    reg {
        name = "GEN5_SUB_PKT2_L";
        desc = "GEN5_SUB_PKT2_L (offset 0x14C in this sub-block, absolute 0x1300194C). Reset INIT 0x00000000. PROVEN: vendor register header. No call site in the vendor hal/drv C sources: access by register-name convention only (INFERRED). ";
        field { name = "gen5_sub_pkt2_pb3"; desc = ""; sw = rw; hw = r; reset = 0x0; } gen5_sub_pkt2_pb3[31:24];
        field { name = "gen5_sub_pkt2_pb2"; desc = ""; sw = rw; hw = r; reset = 0x0; } gen5_sub_pkt2_pb2[23:16];
        field { name = "gen5_sub_pkt2_pb1"; desc = ""; sw = rw; hw = r; reset = 0x0; } gen5_sub_pkt2_pb1[15:8];
        field { name = "gen5_sub_pkt2_pb0"; desc = ""; sw = rw; hw = r; reset = 0x0; } gen5_sub_pkt2_pb0[7:0];
    } GEN5_SUB_PKT2_L @ 0x14C;
    reg {
        name = "GEN5_SUB_PKT2_H";
        desc = "GEN5_SUB_PKT2_H (offset 0x150 in this sub-block, absolute 0x13001950). Reset INIT 0x00000000. PROVEN: vendor register header. No call site in the vendor hal/drv C sources: access by register-name convention only (INFERRED). ";
        field { name = "rsv_49"; desc = ""; sw = r; hw = na; reset = 0x0; } rsv_49[31:24];
        field { name = "gen5_sub_pkt2_pb6"; desc = ""; sw = rw; hw = r; reset = 0x0; } gen5_sub_pkt2_pb6[23:16];
        field { name = "gen5_sub_pkt2_pb5"; desc = ""; sw = rw; hw = r; reset = 0x0; } gen5_sub_pkt2_pb5[15:8];
        field { name = "gen5_sub_pkt2_pb4"; desc = ""; sw = rw; hw = r; reset = 0x0; } gen5_sub_pkt2_pb4[7:0];
    } GEN5_SUB_PKT2_H @ 0x150;
    reg {
        name = "GEN5_SUB_PKT3_L";
        desc = "GEN5_SUB_PKT3_L (offset 0x154 in this sub-block, absolute 0x13001954). Reset INIT 0x00000000. PROVEN: vendor register header. No call site in the vendor hal/drv C sources: access by register-name convention only (INFERRED). ";
        field { name = "gen5_sub_pkt3_pb3"; desc = ""; sw = rw; hw = r; reset = 0x0; } gen5_sub_pkt3_pb3[31:24];
        field { name = "gen5_sub_pkt3_pb2"; desc = ""; sw = rw; hw = r; reset = 0x0; } gen5_sub_pkt3_pb2[23:16];
        field { name = "gen5_sub_pkt3_pb1"; desc = ""; sw = rw; hw = r; reset = 0x0; } gen5_sub_pkt3_pb1[15:8];
        field { name = "gen5_sub_pkt3_pb0"; desc = ""; sw = rw; hw = r; reset = 0x0; } gen5_sub_pkt3_pb0[7:0];
    } GEN5_SUB_PKT3_L @ 0x154;
    reg {
        name = "GEN5_SUB_PKT3_H";
        desc = "GEN5_SUB_PKT3_H (offset 0x158 in this sub-block, absolute 0x13001958). Reset INIT 0x00000000. PROVEN: vendor register header. No call site in the vendor hal/drv C sources: access by register-name convention only (INFERRED). ";
        field { name = "rsv_50"; desc = ""; sw = r; hw = na; reset = 0x0; } rsv_50[31:24];
        field { name = "gen5_sub_pkt3_pb6"; desc = ""; sw = rw; hw = r; reset = 0x0; } gen5_sub_pkt3_pb6[23:16];
        field { name = "gen5_sub_pkt3_pb5"; desc = ""; sw = rw; hw = r; reset = 0x0; } gen5_sub_pkt3_pb5[15:8];
        field { name = "gen5_sub_pkt3_pb4"; desc = ""; sw = rw; hw = r; reset = 0x0; } gen5_sub_pkt3_pb4[7:0];
    } GEN5_SUB_PKT3_H @ 0x158;
    reg {
        name = "GAMUT_PKT_HEADER";
        desc = "GAMUT_PKT_HEADER (offset 0x15C in this sub-block, absolute 0x1300195C). Reset INIT 0x00000000. PROVEN: vendor register header. Driver usage (vendor hal/drv C, uncommented call sites): 1 Get, 1 Set (hdmi_hal_ctrl.c): read and written (RW). ";
        field { name = "rsv_51"; desc = ""; sw = r; hw = na; reset = 0x0; } rsv_51[31:24];
        field { name = "gamut_pkt_hb2"; desc = ""; sw = rw; hw = r; reset = 0x0; } gamut_pkt_hb2[23:16];
        field { name = "gamut_pkt_hb1"; desc = ""; sw = rw; hw = r; reset = 0x0; } gamut_pkt_hb1[15:8];
        field { name = "gamut_pkt_hb0"; desc = ""; sw = rw; hw = r; reset = 0x0; } gamut_pkt_hb0[7:0];
    } GAMUT_PKT_HEADER @ 0x15C;
    reg {
        name = "GAMUT_SUB_PKT0_L";
        desc = "GAMUT_SUB_PKT0_L (offset 0x160 in this sub-block, absolute 0x13001960). Reset INIT 0x00000000. PROVEN: vendor register header. Driver usage (vendor hal/drv C, uncommented call sites): 1 Get, 1 Set (hdmi_hal_ctrl.c): read and written (RW). ";
        field { name = "gamut_sub_pkt0_pb3"; desc = ""; sw = rw; hw = r; reset = 0x0; } gamut_sub_pkt0_pb3[31:24];
        field { name = "gamut_sub_pkt0_pb2"; desc = ""; sw = rw; hw = r; reset = 0x0; } gamut_sub_pkt0_pb2[23:16];
        field { name = "gamut_sub_pkt0_pb1"; desc = ""; sw = rw; hw = r; reset = 0x0; } gamut_sub_pkt0_pb1[15:8];
        field { name = "gamut_sub_pkt0_pb0"; desc = ""; sw = rw; hw = r; reset = 0x0; } gamut_sub_pkt0_pb0[7:0];
    } GAMUT_SUB_PKT0_L @ 0x160;
    reg {
        name = "GAMUT_SUB_PKT0_H";
        desc = "GAMUT_SUB_PKT0_H (offset 0x164 in this sub-block, absolute 0x13001964). Reset INIT 0x00000000. PROVEN: vendor register header. Driver usage (vendor hal/drv C, uncommented call sites): 1 Get, 1 Set (hdmi_hal_ctrl.c): read and written (RW). ";
        field { name = "rsv_52"; desc = ""; sw = r; hw = na; reset = 0x0; } rsv_52[31:24];
        field { name = "gamut_sub_pkt0_pb6"; desc = ""; sw = rw; hw = r; reset = 0x0; } gamut_sub_pkt0_pb6[23:16];
        field { name = "gamut_sub_pkt0_pb5"; desc = ""; sw = rw; hw = r; reset = 0x0; } gamut_sub_pkt0_pb5[15:8];
        field { name = "gamut_sub_pkt0_pb4"; desc = ""; sw = rw; hw = r; reset = 0x0; } gamut_sub_pkt0_pb4[7:0];
    } GAMUT_SUB_PKT0_H @ 0x164;
    reg {
        name = "GAMUT_SUB_PKT1_L";
        desc = "GAMUT_SUB_PKT1_L (offset 0x168 in this sub-block, absolute 0x13001968). Reset INIT 0x00000000. PROVEN: vendor register header. Driver usage (vendor hal/drv C, uncommented call sites): 1 Get, 1 Set (hdmi_hal_ctrl.c): read and written (RW). ";
        field { name = "gamut_sub_pkt1_pb3"; desc = ""; sw = rw; hw = r; reset = 0x0; } gamut_sub_pkt1_pb3[31:24];
        field { name = "gamut_sub_pkt1_pb2"; desc = ""; sw = rw; hw = r; reset = 0x0; } gamut_sub_pkt1_pb2[23:16];
        field { name = "gamut_sub_pkt1_pb1"; desc = ""; sw = rw; hw = r; reset = 0x0; } gamut_sub_pkt1_pb1[15:8];
        field { name = "gamut_sub_pkt1_pb0"; desc = ""; sw = rw; hw = r; reset = 0x0; } gamut_sub_pkt1_pb0[7:0];
    } GAMUT_SUB_PKT1_L @ 0x168;
    reg {
        name = "GAMUT_SUB_PKT1_H";
        desc = "GAMUT_SUB_PKT1_H (offset 0x16C in this sub-block, absolute 0x1300196C). Reset INIT 0x00000000. PROVEN: vendor register header. Driver usage (vendor hal/drv C, uncommented call sites): 1 Get, 1 Set (hdmi_hal_ctrl.c): read and written (RW). ";
        field { name = "rsv_53"; desc = ""; sw = r; hw = na; reset = 0x0; } rsv_53[31:24];
        field { name = "gamut_sub_pkt1_pb6"; desc = ""; sw = rw; hw = r; reset = 0x0; } gamut_sub_pkt1_pb6[23:16];
        field { name = "gamut_sub_pkt1_pb5"; desc = ""; sw = rw; hw = r; reset = 0x0; } gamut_sub_pkt1_pb5[15:8];
        field { name = "gamut_sub_pkt1_pb4"; desc = ""; sw = rw; hw = r; reset = 0x0; } gamut_sub_pkt1_pb4[7:0];
    } GAMUT_SUB_PKT1_H @ 0x16C;
    reg {
        name = "GAMUT_SUB_PKT2_L";
        desc = "GAMUT_SUB_PKT2_L (offset 0x170 in this sub-block, absolute 0x13001970). Reset INIT 0x00000000. PROVEN: vendor register header. Driver usage (vendor hal/drv C, uncommented call sites): 1 Get, 1 Set (hdmi_hal_ctrl.c): read and written (RW). ";
        field { name = "gamut_sub_pkt2_pb3"; desc = ""; sw = rw; hw = r; reset = 0x0; } gamut_sub_pkt2_pb3[31:24];
        field { name = "gamut_sub_pkt2_pb2"; desc = ""; sw = rw; hw = r; reset = 0x0; } gamut_sub_pkt2_pb2[23:16];
        field { name = "gamut_sub_pkt2_pb1"; desc = ""; sw = rw; hw = r; reset = 0x0; } gamut_sub_pkt2_pb1[15:8];
        field { name = "gamut_sub_pkt2_pb0"; desc = ""; sw = rw; hw = r; reset = 0x0; } gamut_sub_pkt2_pb0[7:0];
    } GAMUT_SUB_PKT2_L @ 0x170;
    reg {
        name = "GAMUT_SUB_PKT2_H";
        desc = "GAMUT_SUB_PKT2_H (offset 0x174 in this sub-block, absolute 0x13001974). Reset INIT 0x00000000. PROVEN: vendor register header. Driver usage (vendor hal/drv C, uncommented call sites): 1 Get, 1 Set (hdmi_hal_ctrl.c): read and written (RW). ";
        field { name = "rsv_54"; desc = ""; sw = r; hw = na; reset = 0x0; } rsv_54[31:24];
        field { name = "gamut_sub_pkt2_pb6"; desc = ""; sw = rw; hw = r; reset = 0x0; } gamut_sub_pkt2_pb6[23:16];
        field { name = "gamut_sub_pkt2_pb5"; desc = ""; sw = rw; hw = r; reset = 0x0; } gamut_sub_pkt2_pb5[15:8];
        field { name = "gamut_sub_pkt2_pb4"; desc = ""; sw = rw; hw = r; reset = 0x0; } gamut_sub_pkt2_pb4[7:0];
    } GAMUT_SUB_PKT2_H @ 0x174;
    reg {
        name = "GAMUT_SUB_PKT3_L";
        desc = "GAMUT_SUB_PKT3_L (offset 0x178 in this sub-block, absolute 0x13001978). Reset INIT 0x00000000. PROVEN: vendor register header. Driver usage (vendor hal/drv C, uncommented call sites): 1 Get, 1 Set (hdmi_hal_ctrl.c): read and written (RW). ";
        field { name = "gamut_sub_pkt3_pb3"; desc = ""; sw = rw; hw = r; reset = 0x0; } gamut_sub_pkt3_pb3[31:24];
        field { name = "gamut_sub_pkt3_pb2"; desc = ""; sw = rw; hw = r; reset = 0x0; } gamut_sub_pkt3_pb2[23:16];
        field { name = "gamut_sub_pkt3_pb1"; desc = ""; sw = rw; hw = r; reset = 0x0; } gamut_sub_pkt3_pb1[15:8];
        field { name = "gamut_sub_pkt3_pb0"; desc = ""; sw = rw; hw = r; reset = 0x0; } gamut_sub_pkt3_pb0[7:0];
    } GAMUT_SUB_PKT3_L @ 0x178;
    reg {
        name = "GAMUT_SUB_PKT3_H";
        desc = "GAMUT_SUB_PKT3_H (offset 0x17C in this sub-block, absolute 0x1300197C). Reset INIT 0x00000000. PROVEN: vendor register header. Driver usage (vendor hal/drv C, uncommented call sites): 1 Get, 1 Set (hdmi_hal_ctrl.c): read and written (RW). ";
        field { name = "rsv_55"; desc = ""; sw = r; hw = na; reset = 0x0; } rsv_55[31:24];
        field { name = "gamut_sub_pkt3_pb6"; desc = ""; sw = rw; hw = r; reset = 0x0; } gamut_sub_pkt3_pb6[23:16];
        field { name = "gamut_sub_pkt3_pb5"; desc = ""; sw = rw; hw = r; reset = 0x0; } gamut_sub_pkt3_pb5[15:8];
        field { name = "gamut_sub_pkt3_pb4"; desc = ""; sw = rw; hw = r; reset = 0x0; } gamut_sub_pkt3_pb4[7:0];
    } GAMUT_SUB_PKT3_H @ 0x17C;
    reg {
        name = "VSIF_PKT_HEADER";
        desc = "VSIF_PKT_HEADER (offset 0x180 in this sub-block, absolute 0x13001980). Reset INIT 0x00000000. PROVEN: vendor register header. Driver usage (vendor hal/drv C, uncommented call sites): 1 Get, 1 Set (hdmi_hal_ctrl.c): read and written (RW). ";
        field { name = "rsv_56"; desc = ""; sw = r; hw = na; reset = 0x0; } rsv_56[31:24];
        field { name = "vsif_pkt_hb2"; desc = ""; sw = rw; hw = r; reset = 0x0; } vsif_pkt_hb2[23:16];
        field { name = "vsif_pkt_hb1"; desc = ""; sw = rw; hw = r; reset = 0x0; } vsif_pkt_hb1[15:8];
        field { name = "vsif_pkt_hb0"; desc = ""; sw = rw; hw = r; reset = 0x0; } vsif_pkt_hb0[7:0];
    } VSIF_PKT_HEADER @ 0x180;
    reg {
        name = "VSIF_SUB_PKT0_L";
        desc = "VSIF_SUB_PKT0_L (offset 0x184 in this sub-block, absolute 0x13001984). Reset INIT 0x00000000. PROVEN: vendor register header. Driver usage (vendor hal/drv C, uncommented call sites): 1 Get, 1 Set (hdmi_hal_ctrl.c): read and written (RW). ";
        field { name = "vsif_sub_pkt0_pb3"; desc = ""; sw = rw; hw = r; reset = 0x0; } vsif_sub_pkt0_pb3[31:24];
        field { name = "vsif_sub_pkt0_pb2"; desc = ""; sw = rw; hw = r; reset = 0x0; } vsif_sub_pkt0_pb2[23:16];
        field { name = "vsif_sub_pkt0_pb1"; desc = ""; sw = rw; hw = r; reset = 0x0; } vsif_sub_pkt0_pb1[15:8];
        field { name = "vsif_sub_pkt0_pb0"; desc = ""; sw = rw; hw = r; reset = 0x0; } vsif_sub_pkt0_pb0[7:0];
    } VSIF_SUB_PKT0_L @ 0x184;
    reg {
        name = "VSIF_SUB_PKT0_H";
        desc = "VSIF_SUB_PKT0_H (offset 0x188 in this sub-block, absolute 0x13001988). Reset INIT 0x00000000. PROVEN: vendor register header. Driver usage (vendor hal/drv C, uncommented call sites): 1 Get, 1 Set (hdmi_hal_ctrl.c): read and written (RW). ";
        field { name = "rsv_57"; desc = ""; sw = r; hw = na; reset = 0x0; } rsv_57[31:24];
        field { name = "vsif_sub_pkt0_pb6"; desc = ""; sw = rw; hw = r; reset = 0x0; } vsif_sub_pkt0_pb6[23:16];
        field { name = "vsif_sub_pkt0_pb5"; desc = ""; sw = rw; hw = r; reset = 0x0; } vsif_sub_pkt0_pb5[15:8];
        field { name = "vsif_sub_pkt0_pb4"; desc = ""; sw = rw; hw = r; reset = 0x0; } vsif_sub_pkt0_pb4[7:0];
    } VSIF_SUB_PKT0_H @ 0x188;
    reg {
        name = "VSIF_SUB_PKT1_L";
        desc = "VSIF_SUB_PKT1_L (offset 0x18C in this sub-block, absolute 0x1300198C). Reset INIT 0x00000000. PROVEN: vendor register header. Driver usage (vendor hal/drv C, uncommented call sites): 1 Get, 1 Set (hdmi_hal_ctrl.c): read and written (RW). ";
        field { name = "vsif_sub_pkt1_pb3"; desc = ""; sw = rw; hw = r; reset = 0x0; } vsif_sub_pkt1_pb3[31:24];
        field { name = "vsif_sub_pkt1_pb2"; desc = ""; sw = rw; hw = r; reset = 0x0; } vsif_sub_pkt1_pb2[23:16];
        field { name = "vsif_sub_pkt1_pb1"; desc = ""; sw = rw; hw = r; reset = 0x0; } vsif_sub_pkt1_pb1[15:8];
        field { name = "vsif_sub_pkt1_pb0"; desc = ""; sw = rw; hw = r; reset = 0x0; } vsif_sub_pkt1_pb0[7:0];
    } VSIF_SUB_PKT1_L @ 0x18C;
    reg {
        name = "VSIF_SUB_PKT1_H";
        desc = "VSIF_SUB_PKT1_H (offset 0x190 in this sub-block, absolute 0x13001990). Reset INIT 0x00000000. PROVEN: vendor register header. Driver usage (vendor hal/drv C, uncommented call sites): 1 Get, 1 Set (hdmi_hal_ctrl.c): read and written (RW). ";
        field { name = "rsv_58"; desc = ""; sw = r; hw = na; reset = 0x0; } rsv_58[31:24];
        field { name = "vsif_sub_pkt1_pb6"; desc = ""; sw = rw; hw = r; reset = 0x0; } vsif_sub_pkt1_pb6[23:16];
        field { name = "vsif_sub_pkt1_pb5"; desc = ""; sw = rw; hw = r; reset = 0x0; } vsif_sub_pkt1_pb5[15:8];
        field { name = "vsif_sub_pkt1_pb4"; desc = ""; sw = rw; hw = r; reset = 0x0; } vsif_sub_pkt1_pb4[7:0];
    } VSIF_SUB_PKT1_H @ 0x190;
    reg {
        name = "VSIF_SUB_PKT2_L";
        desc = "VSIF_SUB_PKT2_L (offset 0x194 in this sub-block, absolute 0x13001994). Reset INIT 0x00000000. PROVEN: vendor register header. Driver usage (vendor hal/drv C, uncommented call sites): 1 Get, 1 Set (hdmi_hal_ctrl.c): read and written (RW). ";
        field { name = "vsif_sub_pkt2_pb3"; desc = ""; sw = rw; hw = r; reset = 0x0; } vsif_sub_pkt2_pb3[31:24];
        field { name = "vsif_sub_pkt2_pb2"; desc = ""; sw = rw; hw = r; reset = 0x0; } vsif_sub_pkt2_pb2[23:16];
        field { name = "vsif_sub_pkt2_pb1"; desc = ""; sw = rw; hw = r; reset = 0x0; } vsif_sub_pkt2_pb1[15:8];
        field { name = "vsif_sub_pkt2_pb0"; desc = ""; sw = rw; hw = r; reset = 0x0; } vsif_sub_pkt2_pb0[7:0];
    } VSIF_SUB_PKT2_L @ 0x194;
    reg {
        name = "VSIF_SUB_PKT2_H";
        desc = "VSIF_SUB_PKT2_H (offset 0x198 in this sub-block, absolute 0x13001998). Reset INIT 0x00000000. PROVEN: vendor register header. Driver usage (vendor hal/drv C, uncommented call sites): 1 Get, 1 Set (hdmi_hal_ctrl.c): read and written (RW). ";
        field { name = "rsv_59"; desc = ""; sw = r; hw = na; reset = 0x0; } rsv_59[31:24];
        field { name = "vsif_sub_pkt2_pb6"; desc = ""; sw = rw; hw = r; reset = 0x0; } vsif_sub_pkt2_pb6[23:16];
        field { name = "vsif_sub_pkt2_pb5"; desc = ""; sw = rw; hw = r; reset = 0x0; } vsif_sub_pkt2_pb5[15:8];
        field { name = "vsif_sub_pkt2_pb4"; desc = ""; sw = rw; hw = r; reset = 0x0; } vsif_sub_pkt2_pb4[7:0];
    } VSIF_SUB_PKT2_H @ 0x198;
    reg {
        name = "VSIF_SUB_PKT3_L";
        desc = "VSIF_SUB_PKT3_L (offset 0x19C in this sub-block, absolute 0x1300199C). Reset INIT 0x00000000. PROVEN: vendor register header. Driver usage (vendor hal/drv C, uncommented call sites): 1 Get, 1 Set (hdmi_hal_ctrl.c): read and written (RW). ";
        field { name = "vsif_sub_pkt3_pb3"; desc = ""; sw = rw; hw = r; reset = 0x0; } vsif_sub_pkt3_pb3[31:24];
        field { name = "vsif_sub_pkt3_pb2"; desc = ""; sw = rw; hw = r; reset = 0x0; } vsif_sub_pkt3_pb2[23:16];
        field { name = "vsif_sub_pkt3_pb1"; desc = ""; sw = rw; hw = r; reset = 0x0; } vsif_sub_pkt3_pb1[15:8];
        field { name = "vsif_sub_pkt3_pb0"; desc = ""; sw = rw; hw = r; reset = 0x0; } vsif_sub_pkt3_pb0[7:0];
    } VSIF_SUB_PKT3_L @ 0x19C;
    reg {
        name = "VSIF_SUB_PKT3_H";
        desc = "VSIF_SUB_PKT3_H (offset 0x1A0 in this sub-block, absolute 0x130019A0). Reset INIT 0x00000000. PROVEN: vendor register header. Driver usage (vendor hal/drv C, uncommented call sites): 1 Get, 1 Set (hdmi_hal_ctrl.c): read and written (RW). ";
        field { name = "rsv_60"; desc = ""; sw = r; hw = na; reset = 0x0; } rsv_60[31:24];
        field { name = "vsif_sub_pkt3_pb6"; desc = ""; sw = rw; hw = r; reset = 0x0; } vsif_sub_pkt3_pb6[23:16];
        field { name = "vsif_sub_pkt3_pb5"; desc = ""; sw = rw; hw = r; reset = 0x0; } vsif_sub_pkt3_pb5[15:8];
        field { name = "vsif_sub_pkt3_pb4"; desc = ""; sw = rw; hw = r; reset = 0x0; } vsif_sub_pkt3_pb4[7:0];
    } VSIF_SUB_PKT3_H @ 0x1A0;
    reg {
        name = "CEA_AVI_CFG";
        desc = "CEA_AVI_CFG (offset 0x1A4 in this sub-block, absolute 0x130019A4). Reset INIT 0x00000000. PROVEN: vendor register header. Driver usage (vendor hal/drv C, uncommented call sites): 1 Get, 2 Set (hdmi_hal_ctrl.c): read and written (RW). ";
        field { name = "rsv_61"; desc = ""; sw = r; hw = na; reset = 0x0; } rsv_61[31:2];
        field { name = "cea_avi_rpt_en"; desc = ""; sw = rw; hw = r; reset = 0x0; } cea_avi_rpt_en[1:1];
        field { name = "cea_avi_en"; desc = ""; sw = rw; hw = r; reset = 0x0; } cea_avi_en[0:0];
    } CEA_AVI_CFG @ 0x1A4;
    reg {
        name = "CEA_SPF_CFG";
        desc = "CEA_SPF_CFG (offset 0x1A8 in this sub-block, absolute 0x130019A8). Reset INIT 0x00000000. PROVEN: vendor register header. Driver usage (vendor hal/drv C, uncommented call sites): 1 Get, 2 Set (hdmi_hal_ctrl.c): read and written (RW). ";
        field { name = "rsv_62"; desc = ""; sw = r; hw = na; reset = 0x0; } rsv_62[31:2];
        field { name = "cea_spf_rpt_en"; desc = ""; sw = rw; hw = r; reset = 0x0; } cea_spf_rpt_en[1:1];
        field { name = "cea_spf_en"; desc = ""; sw = rw; hw = r; reset = 0x0; } cea_spf_en[0:0];
    } CEA_SPF_CFG @ 0x1A8;
    reg {
        name = "CEA_AUD_CFG";
        desc = "CEA_AUD_CFG (offset 0x1AC in this sub-block, absolute 0x130019AC). Reset INIT 0x00000000. PROVEN: vendor register header. Driver usage (vendor hal/drv C, uncommented call sites): 1 Get, 2 Set (hdmi_hal_ctrl.c): read and written (RW). ";
        field { name = "rsv_63"; desc = ""; sw = r; hw = na; reset = 0x0; } rsv_63[31:2];
        field { name = "cea_aud_rpt_en"; desc = ""; sw = rw; hw = r; reset = 0x0; } cea_aud_rpt_en[1:1];
        field { name = "cea_aud_en"; desc = ""; sw = rw; hw = r; reset = 0x0; } cea_aud_en[0:0];
    } CEA_AUD_CFG @ 0x1AC;
    reg {
        name = "CEA_MPEG_CFG";
        desc = "CEA_MPEG_CFG (offset 0x1B0 in this sub-block, absolute 0x130019B0). Reset INIT 0x00000000. PROVEN: vendor register header. Driver usage (vendor hal/drv C, uncommented call sites): 1 Get, 2 Set (hdmi_hal_ctrl.c): read and written (RW). ";
        field { name = "rsv_64"; desc = ""; sw = r; hw = na; reset = 0x0; } rsv_64[31:2];
        field { name = "cea_mpeg_rpt_en"; desc = ""; sw = rw; hw = r; reset = 0x0; } cea_mpeg_rpt_en[1:1];
        field { name = "cea_mpeg_en"; desc = ""; sw = rw; hw = r; reset = 0x0; } cea_mpeg_en[0:0];
    } CEA_MPEG_CFG @ 0x1B0;
    reg {
        name = "CEA_GEN_CFG";
        desc = "CEA_GEN_CFG (offset 0x1B4 in this sub-block, absolute 0x130019B4). Reset INIT 0x00000000. PROVEN: vendor register header. Driver usage (vendor hal/drv C, uncommented call sites): 1 Get, 2 Set (hdmi_hal_ctrl.c): read and written (RW). ";
        field { name = "rsv_65"; desc = ""; sw = r; hw = na; reset = 0x0; } rsv_65[31:2];
        field { name = "cea_gen_rpt_en"; desc = ""; sw = rw; hw = r; reset = 0x0; } cea_gen_rpt_en[1:1];
        field { name = "cea_gen_en"; desc = ""; sw = rw; hw = r; reset = 0x0; } cea_gen_en[0:0];
    } CEA_GEN_CFG @ 0x1B4;
    reg {
        name = "CEA_CP_CFG";
        desc = "CEA_CP_CFG (offset 0x1B8 in this sub-block, absolute 0x130019B8). Reset INIT 0x00000000. PROVEN: vendor register header. Driver usage (vendor hal/drv C, uncommented call sites): 1 Get, 4 Set (hdmi_hal_ctrl.c): read and written (RW). ";
        field { name = "rsv_66"; desc = ""; sw = r; hw = na; reset = 0x0; } rsv_66[31:8];
        field { name = "cea_cp_rpt_cnt"; desc = ""; sw = rw; hw = r; reset = 0x0; } cea_cp_rpt_cnt[7:2];
        field { name = "cea_cp_rpt_en"; desc = ""; sw = rw; hw = r; reset = 0x0; } cea_cp_rpt_en[1:1];
        field { name = "cea_cp_en"; desc = ""; sw = rw; hw = r; reset = 0x0; } cea_cp_en[0:0];
    } CEA_CP_CFG @ 0x1B8;
    reg {
        name = "CEA_GEN2_CFG";
        desc = "CEA_GEN2_CFG (offset 0x1BC in this sub-block, absolute 0x130019BC). Reset INIT 0x00000000. PROVEN: vendor register header. No call site in the vendor hal/drv C sources: access by register-name convention only (INFERRED). ";
        field { name = "rsv_67"; desc = ""; sw = r; hw = na; reset = 0x0; } rsv_67[31:2];
        field { name = "cea_gen2_rpt_en"; desc = ""; sw = rw; hw = r; reset = 0x0; } cea_gen2_rpt_en[1:1];
        field { name = "cea_gen2_en"; desc = ""; sw = rw; hw = r; reset = 0x0; } cea_gen2_en[0:0];
    } CEA_GEN2_CFG @ 0x1BC;
    reg {
        name = "CEA_GEN3_CFG";
        desc = "CEA_GEN3_CFG (offset 0x1C0 in this sub-block, absolute 0x130019C0). Reset INIT 0x00000000. PROVEN: vendor register header. No call site in the vendor hal/drv C sources: access by register-name convention only (INFERRED). ";
        field { name = "rsv_68"; desc = ""; sw = r; hw = na; reset = 0x0; } rsv_68[31:2];
        field { name = "cea_gen3_rpt_en"; desc = ""; sw = rw; hw = r; reset = 0x0; } cea_gen3_rpt_en[1:1];
        field { name = "cea_gen3_en"; desc = ""; sw = rw; hw = r; reset = 0x0; } cea_gen3_en[0:0];
    } CEA_GEN3_CFG @ 0x1C0;
    reg {
        name = "CEA_GEN4_CFG";
        desc = "CEA_GEN4_CFG (offset 0x1C4 in this sub-block, absolute 0x130019C4). Reset INIT 0x00000000. PROVEN: vendor register header. No call site in the vendor hal/drv C sources: access by register-name convention only (INFERRED). ";
        field { name = "rsv_69"; desc = ""; sw = r; hw = na; reset = 0x0; } rsv_69[31:2];
        field { name = "cea_gen4_rpt_en"; desc = ""; sw = rw; hw = r; reset = 0x0; } cea_gen4_rpt_en[1:1];
        field { name = "cea_gen4_en"; desc = ""; sw = rw; hw = r; reset = 0x0; } cea_gen4_en[0:0];
    } CEA_GEN4_CFG @ 0x1C4;
    reg {
        name = "CEA_GEN5_CFG";
        desc = "CEA_GEN5_CFG (offset 0x1C8 in this sub-block, absolute 0x130019C8). Reset INIT 0x00000000. PROVEN: vendor register header. No call site in the vendor hal/drv C sources: access by register-name convention only (INFERRED). ";
        field { name = "rsv_70"; desc = ""; sw = r; hw = na; reset = 0x0; } rsv_70[31:2];
        field { name = "cea_gen5_rpt_en"; desc = ""; sw = rw; hw = r; reset = 0x0; } cea_gen5_rpt_en[1:1];
        field { name = "cea_gen5_en"; desc = ""; sw = rw; hw = r; reset = 0x0; } cea_gen5_en[0:0];
    } CEA_GEN5_CFG @ 0x1C8;
    reg {
        name = "CEA_GAMUT_CFG";
        desc = "CEA_GAMUT_CFG (offset 0x1CC in this sub-block, absolute 0x130019CC). Reset INIT 0x00000000. PROVEN: vendor register header. Driver usage (vendor hal/drv C, uncommented call sites): 1 Get, 2 Set (hdmi_hal_ctrl.c): read and written (RW). ";
        field { name = "rsv_71"; desc = ""; sw = r; hw = na; reset = 0x0; } rsv_71[31:2];
        field { name = "cea_gamut_rpt_en"; desc = ""; sw = rw; hw = r; reset = 0x0; } cea_gamut_rpt_en[1:1];
        field { name = "cea_gamut_en"; desc = ""; sw = rw; hw = r; reset = 0x0; } cea_gamut_en[0:0];
    } CEA_GAMUT_CFG @ 0x1CC;
    reg {
        name = "CEA_VSIF_CFG";
        desc = "CEA_VSIF_CFG (offset 0x1D0 in this sub-block, absolute 0x130019D0). Reset INIT 0x00000000. PROVEN: vendor register header. Driver usage (vendor hal/drv C, uncommented call sites): 1 Get, 2 Set (hdmi_hal_ctrl.c): read and written (RW). ";
        field { name = "rsv_72"; desc = ""; sw = r; hw = na; reset = 0x0; } rsv_72[31:2];
        field { name = "cea_vsif_rpt_en"; desc = ""; sw = rw; hw = r; reset = 0x0; } cea_vsif_rpt_en[1:1];
        field { name = "cea_vsif_en"; desc = ""; sw = rw; hw = r; reset = 0x0; } cea_vsif_en[0:0];
    } CEA_VSIF_CFG @ 0x1D0;
    reg {
        name = "CEA_PKT_STATE";
        desc = "CEA_PKT_STATE (offset 0x1E0 in this sub-block, absolute 0x130019E0). Reset INIT 0x00000000. PROVEN: vendor register header. No call site in the vendor hal/drv C sources: access by register-name convention only (INFERRED). ";
        field { name = "rsv_73"; desc = ""; sw = r; hw = na; reset = 0x0; } rsv_73[31:12];
        field { name = "cea_vsif_state"; desc = ""; sw = r; hw = w; reset = 0x0; } cea_vsif_state[11:11];
        field { name = "cea_gamut_state"; desc = ""; sw = r; hw = w; reset = 0x0; } cea_gamut_state[10:10];
        field { name = "cea_mpeg_state"; desc = ""; sw = r; hw = w; reset = 0x0; } cea_mpeg_state[9:9];
        field { name = "cea_spd_state"; desc = ""; sw = r; hw = w; reset = 0x0; } cea_spd_state[8:8];
        field { name = "cea_gen5_state"; desc = ""; sw = r; hw = w; reset = 0x0; } cea_gen5_state[7:7];
        field { name = "cea_gen4_state"; desc = ""; sw = r; hw = w; reset = 0x0; } cea_gen4_state[6:6];
        field { name = "cea_gen3_state"; desc = ""; sw = r; hw = w; reset = 0x0; } cea_gen3_state[5:5];
        field { name = "cea_gen2_state"; desc = ""; sw = r; hw = w; reset = 0x0; } cea_gen2_state[4:4];
        field { name = "cea_gen_state"; desc = ""; sw = r; hw = w; reset = 0x0; } cea_gen_state[3:3];
        field { name = "cea_cp_state"; desc = ""; sw = r; hw = w; reset = 0x0; } cea_cp_state[2:2];
        field { name = "cea_aud_state"; desc = ""; sw = r; hw = w; reset = 0x0; } cea_aud_state[1:1];
        field { name = "cea_avi_state"; desc = ""; sw = r; hw = w; reset = 0x0; } cea_avi_state[0:0];
    } CEA_PKT_STATE @ 0x1E0;
    reg {
        name = "AVMIXER_CONFIG";
        desc = "AVMIXER_CONFIG (offset 0x208 in this sub-block, absolute 0x13001A08). Reset INIT 0x00000000. PROVEN: vendor register header. Driver usage (vendor hal/drv C, uncommented call sites): 2 Get, 4 Set (hdmi_hal_ctrl.c): read and written (RW). ";
        field { name = "rsv_74"; desc = ""; sw = r; hw = na; reset = 0x0; } rsv_74[31:8];
        field { name = "pkt_bypass_mode"; desc = ""; sw = rw; hw = r; reset = 0x0; } pkt_bypass_mode[7:7];
        field { name = "pb_priotity_ctl"; desc = ""; sw = rw; hw = r; reset = 0x0; } pb_priotity_ctl[6:6];
        field { name = "pb_ovr_dc_pkt_en"; desc = ""; sw = rw; hw = r; reset = 0x0; } pb_ovr_dc_pkt_en[5:5];
        field { name = "intr_encryption"; desc = ""; sw = rw; hw = r; reset = 0x0; } intr_encryption[4:4];
        field { name = "null_pkt_en_vs_high"; desc = ""; sw = rw; hw = r; reset = 0x0; } null_pkt_en_vs_high[3:3];
        field { name = "null_pkt_en"; desc = ""; sw = rw; hw = r; reset = 0x0; } null_pkt_en[2:2];
        field { name = "dc_pkt_en"; desc = ""; sw = rw; hw = r; reset = 0x0; } dc_pkt_en[1:1];
        field { name = "hdmi_mode"; desc = ""; sw = rw; hw = r; reset = 0x0; } hdmi_mode[0:0];
    } AVMIXER_CONFIG @ 0x208;
    reg {
        name = "CP_PKT_AVMUTE";
        desc = "CP_PKT_AVMUTE (offset 0x20C in this sub-block, absolute 0x13001A0C). Reset INIT 0x00000000. PROVEN: vendor register header. Driver usage (vendor hal/drv C, uncommented call sites): 2 Get, 2 Set (hdmi_hal_ctrl.c): read and written (RW). ";
        field { name = "rsv_75"; desc = ""; sw = r; hw = na; reset = 0x0; } rsv_75[31:2];
        field { name = "cp_clr_avmute"; desc = ""; sw = rw; hw = r; reset = 0x0; } cp_clr_avmute[1:1];
        field { name = "cp_set_avmute"; desc = ""; sw = rw; hw = r; reset = 0x0; } cp_set_avmute[0:0];
    } CP_PKT_AVMUTE @ 0x20C;
    reg {
        name = "VIDEO_BLANK_CFG";
        desc = "VIDEO_BLANK_CFG (offset 0x210 in this sub-block, absolute 0x13001A10). Reset INIT 0x00000000. PROVEN: vendor register header. No call site in the vendor hal/drv C sources: access by register-name convention only (INFERRED). ";
        field { name = "rsv_76"; desc = ""; sw = r; hw = na; reset = 0x0; } rsv_76[31:24];
        field { name = "video_blank"; desc = ""; sw = rw; hw = r; reset = 0x0; } video_blank[23:0];
    } VIDEO_BLANK_CFG @ 0x210;
    reg {
        name = "TMDS_BIST_CTRL";
        desc = "TMDS_BIST_CTRL (offset 0x254 in this sub-block, absolute 0x13001A54). Reset INIT 0x00000000. PROVEN: vendor register header. No call site in the vendor hal/drv C sources: access by register-name convention only (INFERRED). ";
        field { name = "rsv_77"; desc = ""; sw = r; hw = na; reset = 0x0; } rsv_77[31:14];
        field { name = "reg_tbist_patt_sel"; desc = ""; sw = rw; hw = r; reset = 0x0; } reg_tbist_patt_sel[13:9];
        field { name = "reg_tbist_timing_sel"; desc = ""; sw = rw; hw = r; reset = 0x0; } reg_tbist_timing_sel[8:3];
        field { name = "reg_tbist_syn_pol"; desc = ""; sw = rw; hw = r; reset = 0x0; } reg_tbist_syn_pol[2:1];
        field { name = "reg_tbist_en"; desc = ""; sw = rw; hw = r; reset = 0x0; } reg_tbist_en[0:0];
    } TMDS_BIST_CTRL @ 0x254;
    reg {
        name = "HDMI_ENC_CTRL";
        desc = "HDMI_ENC_CTRL (offset 0x260 in this sub-block, absolute 0x13001A60). Reset INIT 0x00000000. PROVEN: vendor register header. Driver usage (vendor hal/drv C, uncommented call sites): 2 Get, 4 Set (hdmi_hal_ctrl.c, hdmi_hal_scdc.c): read and written (RW). ";
        field { name = "rsv_78"; desc = ""; sw = r; hw = na; reset = 0x0; } rsv_78[31:8];
        field { name = "enc_ck_div_sel"; desc = ""; sw = rw; hw = r; reset = 0x0; } enc_ck_div_sel[7:6];
        field { name = "enc_bypass"; desc = ""; sw = rw; hw = r; reset = 0x0; } enc_bypass[5:5];
        field { name = "enc_hdmi_ovr"; desc = ""; sw = rw; hw = r; reset = 0x0; } enc_hdmi_ovr[4:4];
        field { name = "enc_hdmi_val"; desc = ""; sw = rw; hw = r; reset = 0x0; } enc_hdmi_val[3:3];
        field { name = "enc_scr_md"; desc = ""; sw = rw; hw = r; reset = 0x0; } enc_scr_md[2:2];
        field { name = "enc_scr_on"; desc = ""; sw = rw; hw = r; reset = 0x0; } enc_scr_on[1:1];
        field { name = "enc_hdmi2_on"; desc = ""; sw = rw; hw = r; reset = 0x0; } enc_hdmi2_on[0:0];
    } HDMI_ENC_CTRL @ 0x260;
    reg {
        name = "ENC_CK_SHARP";
        desc = "ENC_CK_SHARP (offset 0x264 in this sub-block, absolute 0x13001A64). Reset INIT 0x000FFFE0. PROVEN: vendor register header. No call site in the vendor hal/drv C sources: access by register-name convention only (INFERRED). ";
        field { name = "rsv_79"; desc = ""; sw = r; hw = na; reset = 0x0; } rsv_79[31:30];
        field { name = "enc_ck_sharp2"; desc = ""; sw = rw; hw = r; reset = 0x0; } enc_ck_sharp2[29:20];
        field { name = "enc_ck_sharp1"; desc = ""; sw = rw; hw = r; reset = 0x3FF; } enc_ck_sharp1[19:10];
        field { name = "enc_ck_sharp0"; desc = ""; sw = rw; hw = r; reset = 0x3E0; } enc_ck_sharp0[9:0];
    } ENC_CK_SHARP @ 0x264;
};

regfile eHI3536D_HDMI_video_path {
    name = "HDMI TX video_path, Hi3536D V100 / HDMI v2 (hisiv100)";
    desc = "TX video path (timing, CSC, DITHER, packing). Offsets are relative to the sub-block base 0x13000800 (HDMI TX window 0x13000000 + 0x800). Provenance: PROVEN (vendor code): register names, offsets, field names/bit ranges and reset (INIT) values come from the machine-generated register headers of the vendor HDMI v2 driver (nManager-generated hdmi_reg_video_path.h, product/hiosd/hdmi/hdmi_v2/drv/hal in the vendor U-Boot tree for the Hi3536D/Hi3536C/Hi3531D/Hi3521D family, source: sources/openipc-u-boot-hi3536dv100); the Hi3536D V100 maps the window at 0x13000000 per its hdmi_product_define.h and the closed hi3536dv100_hdmi.ko symbol names (HDMI_TX_S_*_REGS_TYPE_Init) agree. INFERRED: access types. Of the 503 register definitions in the vendor headers only 38 carry an ATTR (all RW); the others have none, so fields are modelled read/write except reserved/rsv fields and registers whose names mark them read-only by convention where the vendor hal/drv C sources call the accessors (203 registers) a register only ever read is modelled sw=r and the call-site counts are in each register description; for the other registers the name convention (SW_VER*, HW_INFO/HW_VERSION/HW_FEATURE, _STATUS, _STAT, _STATE, _OUT<n>: sw=r) is used. The 8051 MCU window (mcu sub-block) is modelled the same way and its function is inferred from the HDCP2X_* names only and hardware behavior; nothing run on hardware. NOT in the data sheet (no HDMI TX chapter)." ;
    reg {
        name = "TIMING_GEN_CTRL";
        desc = "TIMING_GEN_CTRL (offset 0x0 in this sub-block, absolute 0x13000800). Reset INIT 0x00000000. PROVEN: vendor register header. Driver usage (vendor hal/drv C, uncommented call sites): 4 Get, 4 Set (hdmi_hal_ctrl.c): read and written (RW). ";
        field { name = "rsv_0"; desc = ""; sw = r; hw = na; reset = 0x0; } rsv_0[31:10];
        field { name = "reg_sync_polarity"; desc = ""; sw = rw; hw = r; reset = 0x0; } reg_sync_polarity[9:8];
        field { name = "reg_timing_sel"; desc = ""; sw = rw; hw = r; reset = 0x0; } reg_timing_sel[7:2];
        field { name = "reg_extmode"; desc = ""; sw = rw; hw = r; reset = 0x0; } reg_extmode[1:1];
        field { name = "reg_timing_gen_en"; desc = ""; sw = rw; hw = r; reset = 0x0; } reg_timing_gen_en[0:0];
    } TIMING_GEN_CTRL @ 0x0;
    reg {
        name = "HSYNC_TIMING_CONFIG0";
        desc = "HSYNC_TIMING_CONFIG0 (offset 0x4 in this sub-block, absolute 0x13000804). Reset INIT 0x00638359. PROVEN: vendor register header. No call site in the vendor hal/drv C sources: access by register-name convention only (INFERRED). ";
        field { name = "rsv_1"; desc = ""; sw = r; hw = na; reset = 0x0; } rsv_1[31:26];
        field { name = "hsync_high_to_low_count"; desc = ""; sw = rw; hw = r; reset = 0x31C; } hsync_high_to_low_count[25:13];
        field { name = "hsync_total_count"; desc = ""; sw = rw; hw = r; reset = 0x359; } hsync_total_count[12:0];
    } HSYNC_TIMING_CONFIG0 @ 0x4;
    reg {
        name = "HSYNC_TIMING_CONFIG1";
        desc = "HSYNC_TIMING_CONFIG1 (offset 0x8 in this sub-block, absolute 0x13000808). Reset INIT 0x000202E0. PROVEN: vendor register header. No call site in the vendor hal/drv C sources: access by register-name convention only (INFERRED). ";
        field { name = "rsv_2"; desc = ""; sw = r; hw = na; reset = 0x0; } rsv_2[31:26];
        field { name = "hsync_de_end_count"; desc = ""; sw = rw; hw = r; reset = 0x10; } hsync_de_end_count[25:13];
        field { name = "hsync_de_start_count"; desc = ""; sw = rw; hw = r; reset = 0x2E0; } hsync_de_start_count[12:0];
    } HSYNC_TIMING_CONFIG1 @ 0x8;
    reg {
        name = "HSYNC_TIMING_CONFIG2";
        desc = "HSYNC_TIMING_CONFIG2 (offset 0xC in this sub-block, absolute 0x1300080C). Reset INIT 0x00000000. PROVEN: vendor register header. No call site in the vendor hal/drv C sources: access by register-name convention only (INFERRED). ";
        field { name = "rsv_3"; desc = ""; sw = r; hw = na; reset = 0x0; } rsv_3[31:13];
        field { name = "hsync_low_to_high_count"; desc = ""; sw = rw; hw = r; reset = 0x0; } hsync_low_to_high_count[12:0];
    } HSYNC_TIMING_CONFIG2 @ 0xC;
    reg {
        name = "VSYNC_TIMING_CONFIG0";
        desc = "VSYNC_TIMING_CONFIG0 (offset 0x10 in this sub-block, absolute 0x13000810). Reset INIT 0x0000620C. PROVEN: vendor register header. No call site in the vendor hal/drv C sources: access by register-name convention only (INFERRED). ";
        field { name = "rsv_4"; desc = ""; sw = r; hw = na; reset = 0x0; } rsv_4[31:24];
        field { name = "vsync_high_to_low_count"; desc = ""; sw = rw; hw = r; reset = 0x6; } vsync_high_to_low_count[23:12];
        field { name = "vsync_total_count"; desc = ""; sw = rw; hw = r; reset = 0x20C; } vsync_total_count[11:0];
    } VSYNC_TIMING_CONFIG0 @ 0x10;
    reg {
        name = "VSYNC_TIMING_CONFIG1";
        desc = "VSYNC_TIMING_CONFIG1 (offset 0x14 in this sub-block, absolute 0x13000814). Reset INIT 0x0000F1EF. PROVEN: vendor register header. No call site in the vendor hal/drv C sources: access by register-name convention only (INFERRED). ";
        field { name = "rsv_5"; desc = ""; sw = r; hw = na; reset = 0x0; } rsv_5[31:24];
        field { name = "vsync_de_end_count"; desc = ""; sw = rw; hw = r; reset = 0xF; } vsync_de_end_count[23:12];
        field { name = "vsync_de_start_count"; desc = ""; sw = rw; hw = r; reset = 0x1EF; } vsync_de_start_count[11:0];
    } VSYNC_TIMING_CONFIG1 @ 0x14;
    reg {
        name = "VSYNC_TIMING_CONFIG2";
        desc = "VSYNC_TIMING_CONFIG2 (offset 0x18 in this sub-block, absolute 0x13000818). Reset INIT 0x00000000. PROVEN: vendor register header. No call site in the vendor hal/drv C sources: access by register-name convention only (INFERRED). ";
        field { name = "rsv_6"; desc = ""; sw = r; hw = na; reset = 0x0; } rsv_6[31:12];
        field { name = "vsync_low_to_high_count"; desc = ""; sw = rw; hw = r; reset = 0x0; } vsync_low_to_high_count[11:0];
    } VSYNC_TIMING_CONFIG2 @ 0x18;
    reg {
        name = "VIDEO_PATH_CTRL";
        desc = "VIDEO_PATH_CTRL (offset 0x30 in this sub-block, absolute 0x13000830). Reset INIT 0x00000000. PROVEN: vendor register header. Driver usage (vendor hal/drv C, uncommented call sites): 2 Get, 2 Set (hdmi_hal_ctrl.c): read and written (RW). ";
        field { name = "rsv_6"; desc = ""; sw = r; hw = na; reset = 0x0; } rsv_6[31:1];
        field { name = "reg_video_blank_en"; desc = ""; sw = rw; hw = r; reset = 0x0; } reg_video_blank_en[0:0];
    } VIDEO_PATH_CTRL @ 0x30;
    reg {
        name = "PATTERN_GEN_CTRL";
        desc = "PATTERN_GEN_CTRL (offset 0x40 in this sub-block, absolute 0x13000840). Reset INIT 0x00000000. PROVEN: vendor register header. Driver usage (vendor hal/drv C, uncommented call sites): 7 Get, 7 Set (hdmi_hal_ctrl.c): read and written (RW). ";
        field { name = "rsv_7"; desc = ""; sw = r; hw = na; reset = 0x0; } rsv_7[31:17];
        field { name = "increase_en"; desc = ""; sw = rw; hw = r; reset = 0x0; } increase_en[16:16];
        field { name = "mix_color_en"; desc = ""; sw = rw; hw = r; reset = 0x0; } mix_color_en[15:15];
        field { name = "cbar_pattern_sel"; desc = ""; sw = rw; hw = r; reset = 0x0; } cbar_pattern_sel[14:13];
        field { name = "bar_pattern_extmode"; desc = ""; sw = rw; hw = r; reset = 0x0; } bar_pattern_extmode[12:12];
        field { name = "replace_pattern_en"; desc = ""; sw = rw; hw = r; reset = 0x0; } replace_pattern_en[11:9];
        field { name = "mask_pattern_en"; desc = ""; sw = rw; hw = r; reset = 0x0; } mask_pattern_en[8:6];
        field { name = "square_pattern_en"; desc = ""; sw = rw; hw = r; reset = 0x0; } square_pattern_en[5:5];
        field { name = "colorbar_en"; desc = ""; sw = rw; hw = r; reset = 0x0; } colorbar_en[4:4];
        field { name = "solid_pattern_en"; desc = ""; sw = rw; hw = r; reset = 0x0; } solid_pattern_en[3:3];
        field { name = "video_format"; desc = ""; sw = rw; hw = r; reset = 0x0; } video_format[2:1];
        field { name = "tpg_enable"; desc = ""; sw = rw; hw = r; reset = 0x0; } tpg_enable[0:0];
    } PATTERN_GEN_CTRL @ 0x40;
    reg {
        name = "SOLID_PATTERN_CONFIG";
        desc = "SOLID_PATTERN_CONFIG (offset 0x44 in this sub-block, absolute 0x13000844). Reset INIT 0x1F8DC1F8. PROVEN: vendor register header. Driver usage (vendor hal/drv C, uncommented call sites): 0 Get, 3 Set (hdmi_hal_ctrl.c): only written by the driver (kept RW: a write-only register cannot be told from an unread one). ";
        field { name = "rsv_8"; desc = ""; sw = r; hw = na; reset = 0x0; } rsv_8[31:30];
        field { name = "solid_pattern_cr"; desc = ""; sw = rw; hw = r; reset = 0x1F8; } solid_pattern_cr[29:20];
        field { name = "solid_pattern_y"; desc = ""; sw = rw; hw = r; reset = 0x370; } solid_pattern_y[19:10];
        field { name = "solid_pattern_cb"; desc = ""; sw = rw; hw = r; reset = 0x1F8; } solid_pattern_cb[9:0];
    } SOLID_PATTERN_CONFIG @ 0x44;
    reg {
        name = "MASK_PATTERN_CONFIG";
        desc = "MASK_PATTERN_CONFIG (offset 0x48 in this sub-block, absolute 0x13000848). Reset INIT 0x3FFFFFFF. PROVEN: vendor register header. No call site in the vendor hal/drv C sources: access by register-name convention only (INFERRED). ";
        field { name = "rsv_9"; desc = ""; sw = r; hw = na; reset = 0x0; } rsv_9[31:30];
        field { name = "mask_pattern_cr"; desc = ""; sw = rw; hw = r; reset = 0x3FF; } mask_pattern_cr[29:20];
        field { name = "mask_pattern_y"; desc = ""; sw = rw; hw = r; reset = 0x3FF; } mask_pattern_y[19:10];
        field { name = "mask_pattern_cb"; desc = ""; sw = rw; hw = r; reset = 0x3FF; } mask_pattern_cb[9:0];
    } MASK_PATTERN_CONFIG @ 0x48;
    reg {
        name = "BAR_EXT_CONFIG";
        desc = "BAR_EXT_CONFIG (offset 0x4C in this sub-block, absolute 0x1300084C). Reset INIT 0x0007805A. PROVEN: vendor register header. No call site in the vendor hal/drv C sources: access by register-name convention only (INFERRED). ";
        field { name = "rsv_10"; desc = ""; sw = r; hw = na; reset = 0x0; } rsv_10[31:24];
        field { name = "square_height"; desc = ""; sw = rw; hw = r; reset = 0x78; } square_height[23:12];
        field { name = "colorbar_width"; desc = ""; sw = rw; hw = r; reset = 0x5A; } colorbar_width[11:0];
    } BAR_EXT_CONFIG @ 0x4C;
    reg {
        name = "CBAR_PATTERN_A0";
        desc = "CBAR_PATTERN_A0 (offset 0x50 in this sub-block, absolute 0x13000850). Reset INIT 0x3C3FC3FC. PROVEN: vendor register header. No call site in the vendor hal/drv C sources: access by register-name convention only (INFERRED). ";
        field { name = "rsv_11"; desc = ""; sw = r; hw = na; reset = 0x0; } rsv_11[31:30];
        field { name = "bar_pattern_a0"; desc = ""; sw = rw; hw = r; reset = 0x3C3FC3FC; } bar_pattern_a0[29:0];
    } CBAR_PATTERN_A0 @ 0x50;
    reg {
        name = "CBAR_PATTERN_A1";
        desc = "CBAR_PATTERN_A1 (offset 0x54 in this sub-block, absolute 0x13000854). Reset INIT 0x21C87000. PROVEN: vendor register header. No call site in the vendor hal/drv C sources: access by register-name convention only (INFERRED). ";
        field { name = "rsv_12"; desc = ""; sw = r; hw = na; reset = 0x0; } rsv_12[31:30];
        field { name = "bar_pattern_a1"; desc = ""; sw = rw; hw = r; reset = 0x21C87000; } bar_pattern_a1[29:0];
    } CBAR_PATTERN_A1 @ 0x54;
    reg {
        name = "CBAR_PATTERN_A2";
        desc = "CBAR_PATTERN_A2 (offset 0x58 in this sub-block, absolute 0x13000858). Reset INIT 0x0008721C. PROVEN: vendor register header. No call site in the vendor hal/drv C sources: access by register-name convention only (INFERRED). ";
        field { name = "rsv_13"; desc = ""; sw = r; hw = na; reset = 0x0; } rsv_13[31:30];
        field { name = "bar_pattern_a2"; desc = ""; sw = rw; hw = r; reset = 0x8721C; } bar_pattern_a2[29:0];
    } CBAR_PATTERN_A2 @ 0x58;
    reg {
        name = "CBAR_PATTERN_A3";
        desc = "CBAR_PATTERN_A3 (offset 0x5C in this sub-block, absolute 0x1300085C). Reset INIT 0x00087000. PROVEN: vendor register header. No call site in the vendor hal/drv C sources: access by register-name convention only (INFERRED). ";
        field { name = "rsv_14"; desc = ""; sw = r; hw = na; reset = 0x0; } rsv_14[31:30];
        field { name = "bar_pattern_a3"; desc = ""; sw = rw; hw = r; reset = 0x87000; } bar_pattern_a3[29:0];
    } CBAR_PATTERN_A3 @ 0x5C;
    reg {
        name = "CBAR_PATTERN_A4";
        desc = "CBAR_PATTERN_A4 (offset 0x60 in this sub-block, absolute 0x13000860). Reset INIT 0x21C0021C. PROVEN: vendor register header. No call site in the vendor hal/drv C sources: access by register-name convention only (INFERRED). ";
        field { name = "rsv_15"; desc = ""; sw = r; hw = na; reset = 0x0; } rsv_15[31:30];
        field { name = "bar_pattern_a4"; desc = ""; sw = rw; hw = r; reset = 0x21C0021C; } bar_pattern_a4[29:0];
    } CBAR_PATTERN_A4 @ 0x60;
    reg {
        name = "CBAR_PATTERN_A5";
        desc = "CBAR_PATTERN_A5 (offset 0x64 in this sub-block, absolute 0x13000864). Reset INIT 0x21C00000. PROVEN: vendor register header. No call site in the vendor hal/drv C sources: access by register-name convention only (INFERRED). ";
        field { name = "rsv_16"; desc = ""; sw = r; hw = na; reset = 0x0; } rsv_16[31:30];
        field { name = "bar_pattern_a5"; desc = ""; sw = rw; hw = r; reset = 0x21C00000; } bar_pattern_a5[29:0];
    } CBAR_PATTERN_A5 @ 0x64;
    reg {
        name = "CBAR_PATTERN_A6";
        desc = "CBAR_PATTERN_A6 (offset 0x68 in this sub-block, absolute 0x13000868). Reset INIT 0x0000021C. PROVEN: vendor register header. No call site in the vendor hal/drv C sources: access by register-name convention only (INFERRED). ";
        field { name = "rsv_17"; desc = ""; sw = r; hw = na; reset = 0x0; } rsv_17[31:30];
        field { name = "bar_pattern_a6"; desc = ""; sw = rw; hw = r; reset = 0x21C; } bar_pattern_a6[29:0];
    } CBAR_PATTERN_A6 @ 0x68;
    reg {
        name = "CBAR_PATTERN_A7";
        desc = "CBAR_PATTERN_A7 (offset 0x6C in this sub-block, absolute 0x1300086C). Reset INIT 0x00000000. PROVEN: vendor register header. No call site in the vendor hal/drv C sources: access by register-name convention only (INFERRED). ";
        field { name = "rsv_18"; desc = ""; sw = r; hw = na; reset = 0x0; } rsv_18[31:30];
        field { name = "bar_pattern_a7"; desc = ""; sw = rw; hw = r; reset = 0x0; } bar_pattern_a7[29:0];
    } CBAR_PATTERN_A7 @ 0x6C;
    reg {
        name = "CBAR_PATTERN_B0";
        desc = "CBAR_PATTERN_B0 (offset 0x70 in this sub-block, absolute 0x13000870). Reset INIT 0x00000000. PROVEN: vendor register header. No call site in the vendor hal/drv C sources: access by register-name convention only (INFERRED). ";
        field { name = "rsv_19"; desc = ""; sw = r; hw = na; reset = 0x0; } rsv_19[31:30];
        field { name = "bar_pattern_b0"; desc = ""; sw = rw; hw = r; reset = 0x0; } bar_pattern_b0[29:0];
    } CBAR_PATTERN_B0 @ 0x70;
    reg {
        name = "CBAR_PATTERN_B1";
        desc = "CBAR_PATTERN_B1 (offset 0x74 in this sub-block, absolute 0x13000874). Reset INIT 0x0000021C. PROVEN: vendor register header. No call site in the vendor hal/drv C sources: access by register-name convention only (INFERRED). ";
        field { name = "rsv_20"; desc = ""; sw = r; hw = na; reset = 0x0; } rsv_20[31:30];
        field { name = "bar_pattern_b1"; desc = ""; sw = rw; hw = r; reset = 0x21C; } bar_pattern_b1[29:0];
    } CBAR_PATTERN_B1 @ 0x74;
    reg {
        name = "CBAR_PATTERN_B2";
        desc = "CBAR_PATTERN_B2 (offset 0x78 in this sub-block, absolute 0x13000878). Reset INIT 0x21C00000. PROVEN: vendor register header. No call site in the vendor hal/drv C sources: access by register-name convention only (INFERRED). ";
        field { name = "rsv_21"; desc = ""; sw = r; hw = na; reset = 0x0; } rsv_21[31:30];
        field { name = "bar_pattern_b2"; desc = ""; sw = rw; hw = r; reset = 0x21C00000; } bar_pattern_b2[29:0];
    } CBAR_PATTERN_B2 @ 0x78;
    reg {
        name = "CBAR_PATTERN_B3";
        desc = "CBAR_PATTERN_B3 (offset 0x7C in this sub-block, absolute 0x1300087C). Reset INIT 0x21C0021C. PROVEN: vendor register header. No call site in the vendor hal/drv C sources: access by register-name convention only (INFERRED). ";
        field { name = "rsv_22"; desc = ""; sw = r; hw = na; reset = 0x0; } rsv_22[31:30];
        field { name = "bar_pattern_b3"; desc = ""; sw = rw; hw = r; reset = 0x21C0021C; } bar_pattern_b3[29:0];
    } CBAR_PATTERN_B3 @ 0x7C;
    reg {
        name = "CBAR_PATTERN_B4";
        desc = "CBAR_PATTERN_B4 (offset 0x80 in this sub-block, absolute 0x13000880). Reset INIT 0x00087000. PROVEN: vendor register header. No call site in the vendor hal/drv C sources: access by register-name convention only (INFERRED). ";
        field { name = "rsv_23"; desc = ""; sw = r; hw = na; reset = 0x0; } rsv_23[31:30];
        field { name = "bar_pattern_b4"; desc = ""; sw = rw; hw = r; reset = 0x87000; } bar_pattern_b4[29:0];
    } CBAR_PATTERN_B4 @ 0x80;
    reg {
        name = "CBAR_PATTERN_B5";
        desc = "CBAR_PATTERN_B5 (offset 0x84 in this sub-block, absolute 0x13000884). Reset INIT 0x0008721C. PROVEN: vendor register header. No call site in the vendor hal/drv C sources: access by register-name convention only (INFERRED). ";
        field { name = "rsv_24"; desc = ""; sw = r; hw = na; reset = 0x0; } rsv_24[31:30];
        field { name = "bar_pattern_b5"; desc = ""; sw = rw; hw = r; reset = 0x8721C; } bar_pattern_b5[29:0];
    } CBAR_PATTERN_B5 @ 0x84;
    reg {
        name = "CBAR_PATTERN_B6";
        desc = "CBAR_PATTERN_B6 (offset 0x88 in this sub-block, absolute 0x13000888). Reset INIT 0x21C87000. PROVEN: vendor register header. No call site in the vendor hal/drv C sources: access by register-name convention only (INFERRED). ";
        field { name = "rsv_25"; desc = ""; sw = r; hw = na; reset = 0x0; } rsv_25[31:30];
        field { name = "bar_pattern_b6"; desc = ""; sw = rw; hw = r; reset = 0x21C87000; } bar_pattern_b6[29:0];
    } CBAR_PATTERN_B6 @ 0x88;
    reg {
        name = "CBAR_PATTERN_B7";
        desc = "CBAR_PATTERN_B7 (offset 0x8C in this sub-block, absolute 0x1300088C). Reset INIT 0x3C3FC3FC. PROVEN: vendor register header. No call site in the vendor hal/drv C sources: access by register-name convention only (INFERRED). ";
        field { name = "rsv_26"; desc = ""; sw = r; hw = na; reset = 0x0; } rsv_26[31:30];
        field { name = "bar_pattern_b7"; desc = ""; sw = rw; hw = r; reset = 0x3C3FC3FC; } bar_pattern_b7[29:0];
    } CBAR_PATTERN_B7 @ 0x8C;
    reg {
        name = "FORMAT_DET_CONFIG";
        desc = "FORMAT_DET_CONFIG (offset 0xB8 in this sub-block, absolute 0x130008B8). Reset INIT 0x000000F0. PROVEN: vendor register header. Driver usage (vendor hal/drv C, uncommented call sites): 0 Get, 3 Set (hdmi_hal_ctrl.c): only written by the driver (kept RW: a write-only register cannot be told from an unread one). ";
        field { name = "rsv_27"; desc = ""; sw = r; hw = na; reset = 0x0; } rsv_27[31:8];
        field { name = "pixel_cnt_threhold"; desc = ""; sw = rw; hw = r; reset = 0xF; } pixel_cnt_threhold[7:4];
        field { name = "fdt_status_clear"; desc = ""; sw = rw; hw = r; reset = 0x0; } fdt_status_clear[3:3];
        field { name = "vsync_polarity_value"; desc = ""; sw = rw; hw = r; reset = 0x0; } vsync_polarity_value[2:2];
        field { name = "hsync_polarity_value"; desc = ""; sw = rw; hw = r; reset = 0x0; } hsync_polarity_value[1:1];
        field { name = "sync_polarity_force"; desc = ""; sw = rw; hw = r; reset = 0x0; } sync_polarity_force[0:0];
    } FORMAT_DET_CONFIG @ 0xB8;
    reg {
        name = "FDET_STATUS";
        desc = "FDET_STATUS (offset 0xBC in this sub-block, absolute 0x130008BC). Reset INIT 0x00000000. PROVEN: vendor register header. Driver usage (vendor hal/drv C, uncommented call sites): 3 Get, 0 Set (hdmi_hal_ctrl.c): read-only by usage (INFERRED RO). ";
        field { name = "rsv_28"; desc = ""; sw = r; hw = na; reset = 0x0; } rsv_28[31:3];
        field { name = "vsync_polarity"; desc = ""; sw = r; hw = w; reset = 0x0; } vsync_polarity[2:2];
        field { name = "hsync_polarity"; desc = ""; sw = r; hw = w; reset = 0x0; } hsync_polarity[1:1];
        field { name = "interlaced"; desc = ""; sw = r; hw = w; reset = 0x0; } interlaced[0:0];
    } FDET_STATUS @ 0xBC;
    reg {
        name = "FDET_HORI_RES";
        desc = "FDET_HORI_RES (offset 0xC0 in this sub-block, absolute 0x130008C0). Reset INIT 0x00000000. PROVEN: vendor register header. Driver usage (vendor hal/drv C, uncommented call sites): 2 Get, 0 Set (hdmi_hal_ctrl.c): read-only by usage (INFERRED RO). ";
        field { name = "rsv_29"; desc = ""; sw = r; hw = na; reset = 0x0; } rsv_29[31:26];
        field { name = "hsync_total_cnt"; desc = ""; sw = r; hw = w; reset = 0x0; } hsync_total_cnt[25:13];
        field { name = "hsync_active_cnt"; desc = ""; sw = r; hw = w; reset = 0x0; } hsync_active_cnt[12:0];
    } FDET_HORI_RES @ 0xC0;
    reg {
        name = "FDET_VERT_RES";
        desc = "FDET_VERT_RES (offset 0xC4 in this sub-block, absolute 0x130008C4). Reset INIT 0x00000000. PROVEN: vendor register header. Driver usage (vendor hal/drv C, uncommented call sites): 2 Get, 0 Set (hdmi_hal_ctrl.c): read-only by usage (INFERRED RO). ";
        field { name = "rsv_30"; desc = ""; sw = r; hw = na; reset = 0x0; } rsv_30[31:26];
        field { name = "vsync_total_cnt"; desc = ""; sw = r; hw = w; reset = 0x0; } vsync_total_cnt[25:13];
        field { name = "vsync_active_cnt"; desc = ""; sw = r; hw = w; reset = 0x0; } vsync_active_cnt[12:0];
    } FDET_VERT_RES @ 0xC4;
    reg {
        name = "DITHER_CONFIG";
        desc = "DITHER_CONFIG (offset 0xEC in this sub-block, absolute 0x130008EC). Reset INIT 0x00000001. PROVEN: vendor register header. Driver usage (vendor hal/drv C, uncommented call sites): 2 Get, 2 Set (hdmi_hal_ctrl.c): read and written (RW). ";
        field { name = "rsv_31"; desc = ""; sw = r; hw = na; reset = 0x0; } rsv_31[31:6];
        field { name = "dither_spatial_dual"; desc = ""; sw = rw; hw = r; reset = 0x0; } dither_spatial_dual[5:5];
        field { name = "dither_spatial_en"; desc = ""; sw = rw; hw = r; reset = 0x0; } dither_spatial_en[4:4];
        field { name = "dither_rnd_en"; desc = ""; sw = rw; hw = r; reset = 0x0; } dither_rnd_en[3:3];
        field { name = "dither_mode"; desc = ""; sw = rw; hw = r; reset = 0x0; } dither_mode[2:1];
        field { name = "dither_rnd_byp"; desc = ""; sw = rw; hw = r; reset = 0x1; } dither_rnd_byp[0:0];
    } DITHER_CONFIG @ 0xEC;
    reg {
        name = "CLIP_CTRL";
        desc = "CLIP_CTRL (offset 0xF8 in this sub-block, absolute 0x130008F8). Reset INIT 0x00000001. PROVEN: vendor register header. No call site in the vendor hal/drv C sources: access by register-name convention only (INFERRED). ";
        field { name = "rsv_32"; desc = ""; sw = r; hw = na; reset = 0x0; } rsv_32[31:2];
        field { name = "clip_rgb_mode"; desc = ""; sw = rw; hw = r; reset = 0x0; } clip_rgb_mode[1:1];
        field { name = "range_clip_byp"; desc = ""; sw = rw; hw = r; reset = 0x1; } range_clip_byp[0:0];
    } CLIP_CTRL @ 0xF8;
    reg {
        name = "CLIP_Y_CONFIG";
        desc = "CLIP_Y_CONFIG (offset 0xFC in this sub-block, absolute 0x130008FC). Reset INIT 0x00FFF000. PROVEN: vendor register header. No call site in the vendor hal/drv C sources: access by register-name convention only (INFERRED). ";
        field { name = "rsv_33"; desc = ""; sw = r; hw = na; reset = 0x0; } rsv_33[31:24];
        field { name = "clip_y_max"; desc = ""; sw = rw; hw = r; reset = 0xFFF; } clip_y_max[23:12];
        field { name = "clip_y_min"; desc = ""; sw = rw; hw = r; reset = 0x0; } clip_y_min[11:0];
    } CLIP_Y_CONFIG @ 0xFC;
    reg {
        name = "CLIP_C_CONFIG";
        desc = "CLIP_C_CONFIG (offset 0x100 in this sub-block, absolute 0x13000900). Reset INIT 0x00FFF000. PROVEN: vendor register header. No call site in the vendor hal/drv C sources: access by register-name convention only (INFERRED). ";
        field { name = "rsv_34"; desc = ""; sw = r; hw = na; reset = 0x0; } rsv_34[31:24];
        field { name = "clip_c_max"; desc = ""; sw = rw; hw = r; reset = 0xFFF; } clip_c_max[23:12];
        field { name = "clip_c_min"; desc = ""; sw = rw; hw = r; reset = 0x0; } clip_c_min[11:0];
    } CLIP_C_CONFIG @ 0x100;
    reg {
        name = "PXL_CAP_CTRL";
        desc = "PXL_CAP_CTRL (offset 0x10C in this sub-block, absolute 0x1300090C). Reset INIT 0x00000000. PROVEN: vendor register header. No call site in the vendor hal/drv C sources: access by register-name convention only (INFERRED). ";
        field { name = "rsv_36"; desc = ""; sw = r; hw = na; reset = 0x0; } rsv_36[31:7];
        field { name = "cap_stat_error"; desc = ""; sw = rw; hw = r; reset = 0x0; } cap_stat_error[6:6];
        field { name = "cap_stat_busy"; desc = ""; sw = rw; hw = r; reset = 0x0; } cap_stat_busy[5:5];
        field { name = "cap_stat_done"; desc = ""; sw = rw; hw = r; reset = 0x0; } cap_stat_done[4:4];
        field { name = "rsv_35"; desc = ""; sw = r; hw = na; reset = 0x0; } rsv_35[3:3];
        field { name = "show_point_en"; desc = ""; sw = rw; hw = r; reset = 0x0; } show_point_en[2:2];
        field { name = "soft_trigger_en"; desc = ""; sw = rw; hw = r; reset = 0x0; } soft_trigger_en[1:1];
        field { name = "auto_trigger_en"; desc = ""; sw = rw; hw = r; reset = 0x0; } auto_trigger_en[0:0];
    } PXL_CAP_CTRL @ 0x10C;
    reg {
        name = "PXL_CAP_POSITION";
        desc = "PXL_CAP_POSITION (offset 0x110 in this sub-block, absolute 0x13000910). Reset INIT 0x00000000. PROVEN: vendor register header. No call site in the vendor hal/drv C sources: access by register-name convention only (INFERRED). ";
        field { name = "rsv_37"; desc = ""; sw = r; hw = na; reset = 0x0; } rsv_37[31:26];
        field { name = "cap_line_position"; desc = ""; sw = rw; hw = r; reset = 0x0; } cap_line_position[25:13];
        field { name = "cap_pixel_position"; desc = ""; sw = rw; hw = r; reset = 0x0; } cap_pixel_position[12:0];
    } PXL_CAP_POSITION @ 0x110;
    reg {
        name = "CAP_Y_VALUE";
        desc = "CAP_Y_VALUE (offset 0x114 in this sub-block, absolute 0x13000914). Reset INIT 0x00000000. PROVEN: vendor register header. No call site in the vendor hal/drv C sources: access by register-name convention only (INFERRED). ";
        field { name = "rsv_38"; desc = ""; sw = r; hw = na; reset = 0x0; } rsv_38[31:12];
        field { name = "capture_y_value"; desc = ""; sw = rw; hw = r; reset = 0x0; } capture_y_value[11:0];
    } CAP_Y_VALUE @ 0x114;
    reg {
        name = "CAP_CB_VALUE";
        desc = "CAP_CB_VALUE (offset 0x118 in this sub-block, absolute 0x13000918). Reset INIT 0x00000000. PROVEN: vendor register header. No call site in the vendor hal/drv C sources: access by register-name convention only (INFERRED). ";
        field { name = "rsv_39"; desc = ""; sw = r; hw = na; reset = 0x0; } rsv_39[31:12];
        field { name = "capture_cb_value"; desc = ""; sw = rw; hw = r; reset = 0x0; } capture_cb_value[11:0];
    } CAP_CB_VALUE @ 0x118;
    reg {
        name = "CAP_CR_VALUE";
        desc = "CAP_CR_VALUE (offset 0x11C in this sub-block, absolute 0x1300091C). Reset INIT 0x00000000. PROVEN: vendor register header. No call site in the vendor hal/drv C sources: access by register-name convention only (INFERRED). ";
        field { name = "rsv_40"; desc = ""; sw = r; hw = na; reset = 0x0; } rsv_40[31:12];
        field { name = "capture_cr_value"; desc = ""; sw = rw; hw = r; reset = 0x0; } capture_cr_value[11:0];
    } CAP_CR_VALUE @ 0x11C;
    reg {
        name = "MULTI_CSC_CTRL";
        desc = "MULTI_CSC_CTRL (offset 0x134 in this sub-block, absolute 0x13000934). Reset INIT 0x00000000. PROVEN: vendor register header. Driver usage (vendor hal/drv C, uncommented call sites): 7 Get, 5 Set (hdmi_hal_ctrl.c): read and written (RW). ";
        field { name = "rsv_41"; desc = ""; sw = r; hw = na; reset = 0x0; } rsv_41[31:12];
        field { name = "reg_csc_mode"; desc = ""; sw = rw; hw = r; reset = 0x0; } reg_csc_mode[11:4];
        field { name = "reg_csc_saturate_en"; desc = ""; sw = rw; hw = r; reset = 0x0; } reg_csc_saturate_en[3:3];
        field { name = "reg_csc_dither_en"; desc = ""; sw = rw; hw = r; reset = 0x0; } reg_csc_dither_en[2:2];
        field { name = "reg_csc_coef_ext"; desc = ""; sw = rw; hw = r; reset = 0x0; } reg_csc_coef_ext[1:1];
        field { name = "reg_csc_en"; desc = ""; sw = rw; hw = r; reset = 0x0; } reg_csc_en[0:0];
    } MULTI_CSC_CTRL @ 0x134;
    reg {
        name = "MULTI_CSC_COEFF11";
        desc = "MULTI_CSC_COEFF11 (offset 0x138 in this sub-block, absolute 0x13000938). Reset INIT 0x00000000. PROVEN: vendor register header. No call site in the vendor hal/drv C sources: access by register-name convention only (INFERRED). ";
        field { name = "rsv_42"; desc = ""; sw = r; hw = na; reset = 0x0; } rsv_42[31:16];
        field { name = "reg_csc_r1c1"; desc = ""; sw = rw; hw = r; reset = 0x0; } reg_csc_r1c1[15:0];
    } MULTI_CSC_COEFF11 @ 0x138;
    reg {
        name = "MULTI_CSC_COEFF12";
        desc = "MULTI_CSC_COEFF12 (offset 0x13C in this sub-block, absolute 0x1300093C). Reset INIT 0x00000000. PROVEN: vendor register header. No call site in the vendor hal/drv C sources: access by register-name convention only (INFERRED). ";
        field { name = "rsv_43"; desc = ""; sw = r; hw = na; reset = 0x0; } rsv_43[31:16];
        field { name = "reg_csc_r1c2"; desc = ""; sw = rw; hw = r; reset = 0x0; } reg_csc_r1c2[15:0];
    } MULTI_CSC_COEFF12 @ 0x13C;
    reg {
        name = "MULTI_CSC_COEFF13";
        desc = "MULTI_CSC_COEFF13 (offset 0x140 in this sub-block, absolute 0x13000940). Reset INIT 0x00000000. PROVEN: vendor register header. No call site in the vendor hal/drv C sources: access by register-name convention only (INFERRED). ";
        field { name = "rsv_44"; desc = ""; sw = r; hw = na; reset = 0x0; } rsv_44[31:16];
        field { name = "reg_csc_r1c3"; desc = ""; sw = rw; hw = r; reset = 0x0; } reg_csc_r1c3[15:0];
    } MULTI_CSC_COEFF13 @ 0x140;
    reg {
        name = "MULTI_CSC_COEFF21";
        desc = "MULTI_CSC_COEFF21 (offset 0x144 in this sub-block, absolute 0x13000944). Reset INIT 0x00000000. PROVEN: vendor register header. No call site in the vendor hal/drv C sources: access by register-name convention only (INFERRED). ";
        field { name = "rsv_45"; desc = ""; sw = r; hw = na; reset = 0x0; } rsv_45[31:16];
        field { name = "reg_csc_r2c1"; desc = ""; sw = rw; hw = r; reset = 0x0; } reg_csc_r2c1[15:0];
    } MULTI_CSC_COEFF21 @ 0x144;
    reg {
        name = "MULTI_CSC_COEFF22";
        desc = "MULTI_CSC_COEFF22 (offset 0x148 in this sub-block, absolute 0x13000948). Reset INIT 0x00000000. PROVEN: vendor register header. No call site in the vendor hal/drv C sources: access by register-name convention only (INFERRED). ";
        field { name = "rsv_46"; desc = ""; sw = r; hw = na; reset = 0x0; } rsv_46[31:16];
        field { name = "reg_csc_r2c2"; desc = ""; sw = rw; hw = r; reset = 0x0; } reg_csc_r2c2[15:0];
    } MULTI_CSC_COEFF22 @ 0x148;
    reg {
        name = "MULTI_CSC_COEFF23";
        desc = "MULTI_CSC_COEFF23 (offset 0x14C in this sub-block, absolute 0x1300094C). Reset INIT 0x00000000. PROVEN: vendor register header. No call site in the vendor hal/drv C sources: access by register-name convention only (INFERRED). ";
        field { name = "rsv_47"; desc = ""; sw = r; hw = na; reset = 0x0; } rsv_47[31:16];
        field { name = "reg_csc_r2c3"; desc = ""; sw = rw; hw = r; reset = 0x0; } reg_csc_r2c3[15:0];
    } MULTI_CSC_COEFF23 @ 0x14C;
    reg {
        name = "MULTI_CSC_COEFF31";
        desc = "MULTI_CSC_COEFF31 (offset 0x150 in this sub-block, absolute 0x13000950). Reset INIT 0x00000000. PROVEN: vendor register header. No call site in the vendor hal/drv C sources: access by register-name convention only (INFERRED). ";
        field { name = "rsv_48"; desc = ""; sw = r; hw = na; reset = 0x0; } rsv_48[31:16];
        field { name = "reg_csc_r3c1"; desc = ""; sw = rw; hw = r; reset = 0x0; } reg_csc_r3c1[15:0];
    } MULTI_CSC_COEFF31 @ 0x150;
    reg {
        name = "MULTI_CSC_COEFF32";
        desc = "MULTI_CSC_COEFF32 (offset 0x154 in this sub-block, absolute 0x13000954). Reset INIT 0x00000000. PROVEN: vendor register header. No call site in the vendor hal/drv C sources: access by register-name convention only (INFERRED). ";
        field { name = "rsv_49"; desc = ""; sw = r; hw = na; reset = 0x0; } rsv_49[31:16];
        field { name = "reg_csc_r3c2"; desc = ""; sw = rw; hw = r; reset = 0x0; } reg_csc_r3c2[15:0];
    } MULTI_CSC_COEFF32 @ 0x154;
    reg {
        name = "MULTI_CSC_COEFF33";
        desc = "MULTI_CSC_COEFF33 (offset 0x158 in this sub-block, absolute 0x13000958). Reset INIT 0x00000000. PROVEN: vendor register header. No call site in the vendor hal/drv C sources: access by register-name convention only (INFERRED). ";
        field { name = "rsv_50"; desc = ""; sw = r; hw = na; reset = 0x0; } rsv_50[31:16];
        field { name = "reg_csc_r3c3"; desc = ""; sw = rw; hw = r; reset = 0x0; } reg_csc_r3c3[15:0];
    } MULTI_CSC_COEFF33 @ 0x158;
    reg {
        name = "MULTI_CSC_INOFFSET_Y";
        desc = "MULTI_CSC_INOFFSET_Y (offset 0x15C in this sub-block, absolute 0x1300095C). Reset INIT 0x00000000. PROVEN: vendor register header. No call site in the vendor hal/drv C sources: access by register-name convention only (INFERRED). ";
        field { name = "rsv_51"; desc = ""; sw = r; hw = na; reset = 0x0; } rsv_51[31:13];
        field { name = "reg_csc_inoffset_y"; desc = ""; sw = rw; hw = r; reset = 0x0; } reg_csc_inoffset_y[12:0];
    } MULTI_CSC_INOFFSET_Y @ 0x15C;
    reg {
        name = "MULTI_CSC_INOFFSET_CB";
        desc = "MULTI_CSC_INOFFSET_CB (offset 0x160 in this sub-block, absolute 0x13000960). Reset INIT 0x00000000. PROVEN: vendor register header. No call site in the vendor hal/drv C sources: access by register-name convention only (INFERRED). ";
        field { name = "rsv_52"; desc = ""; sw = r; hw = na; reset = 0x0; } rsv_52[31:13];
        field { name = "reg_csc_inoffset_cb"; desc = ""; sw = rw; hw = r; reset = 0x0; } reg_csc_inoffset_cb[12:0];
    } MULTI_CSC_INOFFSET_CB @ 0x160;
    reg {
        name = "MULTI_CSC_INOFFSET_CR";
        desc = "MULTI_CSC_INOFFSET_CR (offset 0x164 in this sub-block, absolute 0x13000964). Reset INIT 0x00000000. PROVEN: vendor register header. No call site in the vendor hal/drv C sources: access by register-name convention only (INFERRED). ";
        field { name = "rsv_53"; desc = ""; sw = r; hw = na; reset = 0x0; } rsv_53[31:13];
        field { name = "reg_csc_inoffset_cr"; desc = ""; sw = rw; hw = r; reset = 0x0; } reg_csc_inoffset_cr[12:0];
    } MULTI_CSC_INOFFSET_CR @ 0x164;
    reg {
        name = "MULTI_CSC_OUTOFFSET_Y";
        desc = "MULTI_CSC_OUTOFFSET_Y (offset 0x168 in this sub-block, absolute 0x13000968). Reset INIT 0x00000000. PROVEN: vendor register header. No call site in the vendor hal/drv C sources: access by register-name convention only (INFERRED). ";
        field { name = "rsv_54"; desc = ""; sw = r; hw = na; reset = 0x0; } rsv_54[31:13];
        field { name = "reg_csc_outoffset_y"; desc = ""; sw = rw; hw = r; reset = 0x0; } reg_csc_outoffset_y[12:0];
    } MULTI_CSC_OUTOFFSET_Y @ 0x168;
    reg {
        name = "MULTI_CSC_OUTOFFSET_CB";
        desc = "MULTI_CSC_OUTOFFSET_CB (offset 0x16C in this sub-block, absolute 0x1300096C). Reset INIT 0x00000000. PROVEN: vendor register header. No call site in the vendor hal/drv C sources: access by register-name convention only (INFERRED). ";
        field { name = "rsv_55"; desc = ""; sw = r; hw = na; reset = 0x0; } rsv_55[31:13];
        field { name = "reg_csc_outoffset_cb"; desc = ""; sw = rw; hw = r; reset = 0x0; } reg_csc_outoffset_cb[12:0];
    } MULTI_CSC_OUTOFFSET_CB @ 0x16C;
    reg {
        name = "MULTI_CSC_OUTOFFSET_CR";
        desc = "MULTI_CSC_OUTOFFSET_CR (offset 0x170 in this sub-block, absolute 0x13000970). Reset INIT 0x00000000. PROVEN: vendor register header. No call site in the vendor hal/drv C sources: access by register-name convention only (INFERRED). ";
        field { name = "rsv_56"; desc = ""; sw = r; hw = na; reset = 0x0; } rsv_56[31:13];
        field { name = "reg_csc_outoffset_cr"; desc = ""; sw = rw; hw = r; reset = 0x0; } reg_csc_outoffset_cr[12:0];
    } MULTI_CSC_OUTOFFSET_CR @ 0x170;
    reg {
        name = "VIDEO_DWSM_CTRL";
        desc = "VIDEO_DWSM_CTRL (offset 0x180 in this sub-block, absolute 0x13000980). Reset INIT 0x00000008. PROVEN: vendor register header. Driver usage (vendor hal/drv C, uncommented call sites): 4 Get, 4 Set (hdmi_hal_ctrl.c): read and written (RW). ";
        field { name = "rsv_57"; desc = ""; sw = r; hw = na; reset = 0x0; } rsv_57[31:5];
        field { name = "reg_vert_cbcr_sel"; desc = ""; sw = rw; hw = r; reset = 0x0; } reg_vert_cbcr_sel[4:4];
        field { name = "reg_dwsm_vert_byp"; desc = ""; sw = rw; hw = r; reset = 0x1; } reg_dwsm_vert_byp[3:3];
        field { name = "reg_dwsm_vert_en"; desc = ""; sw = rw; hw = r; reset = 0x0; } reg_dwsm_vert_en[2:2];
        field { name = "reg_hori_filter_en"; desc = ""; sw = rw; hw = r; reset = 0x0; } reg_hori_filter_en[1:1];
        field { name = "reg_dwsm_hori_en"; desc = ""; sw = rw; hw = r; reset = 0x0; } reg_dwsm_hori_en[0:0];
    } VIDEO_DWSM_CTRL @ 0x180;
    reg {
        name = "DATA_ALIGN_CTRL";
        desc = "DATA_ALIGN_CTRL (offset 0x18C in this sub-block, absolute 0x1300098C). Reset INIT 0x00000000. PROVEN: vendor register header. Driver usage (vendor hal/drv C, uncommented call sites): 2 Get, 2 Set (hdmi_hal_ctrl.c): read and written (RW). ";
        field { name = "rsv_58"; desc = ""; sw = r; hw = na; reset = 0x0; } rsv_58[31:11];
        field { name = "reg_pxl_div_en"; desc = ""; sw = rw; hw = r; reset = 0x0; } reg_pxl_div_en[10:10];
        field { name = "reg_demux_cb_or_cr"; desc = ""; sw = rw; hw = r; reset = 0x0; } reg_demux_cb_or_cr[9:9];
        field { name = "reg_cbcr_order"; desc = ""; sw = rw; hw = r; reset = 0x0; } reg_cbcr_order[8:8];
        field { name = "reg_yc_mux_polarity"; desc = ""; sw = rw; hw = r; reset = 0x0; } reg_yc_mux_polarity[7:7];
        field { name = "reg_ddr_polarity"; desc = ""; sw = rw; hw = r; reset = 0x0; } reg_ddr_polarity[6:6];
        field { name = "reg_pixel_rate"; desc = ""; sw = rw; hw = r; reset = 0x0; } reg_pixel_rate[5:4];
        field { name = "reg_blank_replace_en"; desc = ""; sw = rw; hw = r; reset = 0x0; } reg_blank_replace_en[3:3];
        field { name = "reg_yc_mux_en"; desc = ""; sw = rw; hw = r; reset = 0x0; } reg_yc_mux_en[2:2];
        field { name = "reg_ddr_en"; desc = ""; sw = rw; hw = r; reset = 0x0; } reg_ddr_en[1:1];
        field { name = "reg_demux_420_en"; desc = ""; sw = rw; hw = r; reset = 0x0; } reg_demux_420_en[0:0];
    } DATA_ALIGN_CTRL @ 0x18C;
    reg {
        name = "BLANK_DATA_Y";
        desc = "BLANK_DATA_Y (offset 0x190 in this sub-block, absolute 0x13000990). Reset INIT 0x00000000. PROVEN: vendor register header. No call site in the vendor hal/drv C sources: access by register-name convention only (INFERRED). ";
        field { name = "rsv_59"; desc = ""; sw = r; hw = na; reset = 0x0; } rsv_59[31:12];
        field { name = "reg_blank_y"; desc = ""; sw = rw; hw = r; reset = 0x0; } reg_blank_y[11:0];
    } BLANK_DATA_Y @ 0x190;
    reg {
        name = "BLANK_DATA_CB";
        desc = "BLANK_DATA_CB (offset 0x194 in this sub-block, absolute 0x13000994). Reset INIT 0x00000000. PROVEN: vendor register header. No call site in the vendor hal/drv C sources: access by register-name convention only (INFERRED). ";
        field { name = "rsv_60"; desc = ""; sw = r; hw = na; reset = 0x0; } rsv_60[31:12];
        field { name = "reg_blank_cb"; desc = ""; sw = rw; hw = r; reset = 0x0; } reg_blank_cb[11:0];
    } BLANK_DATA_CB @ 0x194;
    reg {
        name = "BLANK_DATA_CR";
        desc = "BLANK_DATA_CR (offset 0x198 in this sub-block, absolute 0x13000998). Reset INIT 0x00000000. PROVEN: vendor register header. No call site in the vendor hal/drv C sources: access by register-name convention only (INFERRED). ";
        field { name = "rsv_61"; desc = ""; sw = r; hw = na; reset = 0x0; } rsv_61[31:12];
        field { name = "reg_blank_cr"; desc = ""; sw = rw; hw = r; reset = 0x0; } reg_blank_cr[11:0];
    } BLANK_DATA_CR @ 0x198;
    reg {
        name = "VIDEO_DMUX_CTRL";
        desc = "VIDEO_DMUX_CTRL (offset 0x1A8 in this sub-block, absolute 0x130009A8). Reset INIT 0x00000088. PROVEN: vendor register header. Driver usage (vendor hal/drv C, uncommented call sites): 4 Get, 8 Set (hdmi_hal_ctrl.c): read and written (RW). ";
        field { name = "rsv_62"; desc = ""; sw = r; hw = na; reset = 0x0; } rsv_62[31:29];
        field { name = "reg_inver_sync"; desc = ""; sw = rw; hw = r; reset = 0x0; } reg_inver_sync[28:25];
        field { name = "reg_syncmask_en"; desc = ""; sw = rw; hw = r; reset = 0x0; } reg_syncmask_en[24:21];
        field { name = "reg_datamask_en"; desc = ""; sw = rw; hw = r; reset = 0x0; } reg_datamask_en[20:18];
        field { name = "reg_bitrev_en"; desc = ""; sw = rw; hw = r; reset = 0x0; } reg_bitrev_en[17:15];
        field { name = "reg_bitmask_cr"; desc = ""; sw = rw; hw = r; reset = 0x0; } reg_bitmask_cr[14:13];
        field { name = "reg_bitmask_cb"; desc = ""; sw = rw; hw = r; reset = 0x0; } reg_bitmask_cb[12:11];
        field { name = "reg_bitmask_y"; desc = ""; sw = rw; hw = r; reset = 0x0; } reg_bitmask_y[10:9];
        field { name = "reg_vmux_cr_sel"; desc = ""; sw = rw; hw = r; reset = 0x2; } reg_vmux_cr_sel[8:6];
        field { name = "reg_vmux_cb_sel"; desc = ""; sw = rw; hw = r; reset = 0x1; } reg_vmux_cb_sel[5:3];
        field { name = "reg_vmux_y_sel"; desc = ""; sw = rw; hw = r; reset = 0x0; } reg_vmux_y_sel[2:0];
    } VIDEO_DMUX_CTRL @ 0x1A8;
};

regfile eHI3536D_HDMI_mcu {
    name = "HDMI TX mcu, Hi3536D V100 / HDMI v2 (hisiv100)";
    desc = "embedded 8051 MCU window (HDCP 2.x control, version and exchange registers). Offsets are relative to the sub-block base 0x1301C000 (HDMI TX window 0x13000000 + 0x1C000). Provenance: PROVEN (vendor code): register names, offsets, field names/bit ranges and reset (INIT) values come from the machine-generated register headers of the vendor HDMI v2 driver (nManager-generated hdmi_reg_mcu.h, product/hiosd/hdmi/hdmi_v2/drv/hal in the vendor U-Boot tree for the Hi3536D/Hi3536C/Hi3531D/Hi3521D family, source: sources/openipc-u-boot-hi3536dv100); the Hi3536D V100 maps the window at 0x13000000 per its hdmi_product_define.h and the closed hi3536dv100_hdmi.ko symbol names (HDMI_TX_S_*_REGS_TYPE_Init) agree. INFERRED: access types. Of the 503 register definitions in the vendor headers only 38 carry an ATTR (all RW); the others have none, so fields are modelled read/write except reserved/rsv fields and registers whose names mark them read-only by convention where the vendor hal/drv C sources call the accessors (203 registers) a register only ever read is modelled sw=r and the call-site counts are in each register description; for the other registers the name convention (SW_VER*, HW_INFO/HW_VERSION/HW_FEATURE, _STATUS, _STAT, _STATE, _OUT<n>: sw=r) is used. The 8051 MCU window (mcu sub-block) is modelled the same way and its function is inferred from the HDCP2X_* names only and hardware behavior; nothing run on hardware. NOT in the data sheet (no HDMI TX chapter)." ;
    reg {
        name = "HDCP2X_HW_VER_B0";
        desc = "HDCP2X_HW_VER_B0 (offset 0x0 in this sub-block, absolute 0x1301C000). Reset INIT 0x00000000. PROVEN: vendor register header. Driver usage (vendor hal/drv C, uncommented call sites): 0 Get, 1 Set (hdmi_hal_hdcp22.c): only written by the driver (kept RW: a write-only register cannot be told from an unread one). ";
        field { name = "hdcp2x_hw_ver_b0"; desc = ""; sw = rw; hw = r; reset = 0x0; } hdcp2x_hw_ver_b0[7:0];
    } HDCP2X_HW_VER_B0 @ 0x0;
    reg {
        name = "HDCP2X_HW_VER_B1";
        desc = "HDCP2X_HW_VER_B1 (offset 0x4 in this sub-block, absolute 0x1301C004). Reset INIT 0x00000000. PROVEN: vendor register header. Driver usage (vendor hal/drv C, uncommented call sites): 0 Get, 1 Set (hdmi_hal_hdcp22.c): only written by the driver (kept RW: a write-only register cannot be told from an unread one). ";
        field { name = "hdcp2x_hw_ver_b1"; desc = ""; sw = rw; hw = r; reset = 0x0; } hdcp2x_hw_ver_b1[7:0];
    } HDCP2X_HW_VER_B1 @ 0x4;
    reg {
        name = "HDCP2X_HW_VER_B2";
        desc = "HDCP2X_HW_VER_B2 (offset 0x8 in this sub-block, absolute 0x1301C008). Reset INIT 0x00000000. PROVEN: vendor register header. Driver usage (vendor hal/drv C, uncommented call sites): 0 Get, 1 Set (hdmi_hal_hdcp22.c): only written by the driver (kept RW: a write-only register cannot be told from an unread one). ";
        field { name = "hdcp2x_hw_ver_b2"; desc = ""; sw = rw; hw = r; reset = 0x0; } hdcp2x_hw_ver_b2[7:0];
    } HDCP2X_HW_VER_B2 @ 0x8;
    reg {
        name = "HDCP2X_HW_VER_B3";
        desc = "HDCP2X_HW_VER_B3 (offset 0xC in this sub-block, absolute 0x1301C00C). Reset INIT 0x00000000. PROVEN: vendor register header. Driver usage (vendor hal/drv C, uncommented call sites): 0 Get, 1 Set (hdmi_hal_hdcp22.c): only written by the driver (kept RW: a write-only register cannot be told from an unread one). ";
        field { name = "hdcp2x_hw_ver_b3"; desc = ""; sw = rw; hw = r; reset = 0x0; } hdcp2x_hw_ver_b3[7:0];
    } HDCP2X_HW_VER_B3 @ 0xC;
    reg {
        name = "HDCP2X_SW_VER_B0";
        desc = "HDCP2X_SW_VER_B0 (offset 0x10 in this sub-block, absolute 0x1301C010). Reset INIT 0x00000000. PROVEN: vendor register header. Driver usage (vendor hal/drv C, uncommented call sites): 1 Get, 0 Set (hdmi_hal_hdcp22.c): read-only by usage (INFERRED RO). ";
        field { name = "hdcp2x_sw_ver_b0"; desc = ""; sw = r; hw = w; reset = 0x0; } hdcp2x_sw_ver_b0[7:0];
    } HDCP2X_SW_VER_B0 @ 0x10;
    reg {
        name = "HDCP2X_SW_VER_B1";
        desc = "HDCP2X_SW_VER_B1 (offset 0x14 in this sub-block, absolute 0x1301C014). Reset INIT 0x00000000. PROVEN: vendor register header. Driver usage (vendor hal/drv C, uncommented call sites): 1 Get, 0 Set (hdmi_hal_hdcp22.c): read-only by usage (INFERRED RO). ";
        field { name = "hdcp2x_sw_ver_b1"; desc = ""; sw = r; hw = w; reset = 0x0; } hdcp2x_sw_ver_b1[7:0];
    } HDCP2X_SW_VER_B1 @ 0x14;
    reg {
        name = "HDCP2X_SW_VER_B2";
        desc = "HDCP2X_SW_VER_B2 (offset 0x18 in this sub-block, absolute 0x1301C018). Reset INIT 0x00000000. PROVEN: vendor register header. Driver usage (vendor hal/drv C, uncommented call sites): 1 Get, 0 Set (hdmi_hal_hdcp22.c): read-only by usage (INFERRED RO). ";
        field { name = "hdcp2x_sw_ver_b2"; desc = ""; sw = r; hw = w; reset = 0x0; } hdcp2x_sw_ver_b2[7:0];
    } HDCP2X_SW_VER_B2 @ 0x18;
    reg {
        name = "HDCP2X_SW_VER_B3";
        desc = "HDCP2X_SW_VER_B3 (offset 0x1C in this sub-block, absolute 0x1301C01C). Reset INIT 0x00000000. PROVEN: vendor register header. Driver usage (vendor hal/drv C, uncommented call sites): 1 Get, 0 Set (hdmi_hal_hdcp22.c): read-only by usage (INFERRED RO). ";
        field { name = "hdcp2x_sw_ver_b3"; desc = ""; sw = r; hw = w; reset = 0x0; } hdcp2x_sw_ver_b3[7:0];
    } HDCP2X_SW_VER_B3 @ 0x1C;
    reg {
        name = "HDCP2X_AUTH_CTRL";
        desc = "HDCP2X_AUTH_CTRL (offset 0x54 in this sub-block, absolute 0x1301C054). Reset INIT 0x00000000. PROVEN: vendor register header. Driver usage (vendor hal/drv C, uncommented call sites): 0 Get, 4 Set (hdmi_hal_hdcp22.c): only written by the driver (kept RW: a write-only register cannot be told from an unread one). ";
        field { name = "rsv_0"; desc = ""; sw = r; hw = na; reset = 0x0; } rsv_0[7:2];
        field { name = "mcu_auth_stop"; desc = ""; sw = rw; hw = r; reset = 0x0; } mcu_auth_stop[1:1];
        field { name = "mcu_auth_start"; desc = ""; sw = rw; hw = r; reset = 0x0; } mcu_auth_start[0:0];
    } HDCP2X_AUTH_CTRL @ 0x54;
    reg {
        name = "HDCP2X_SEC_INTR_B0";
        desc = "HDCP2X_SEC_INTR_B0 (offset 0x80 in this sub-block, absolute 0x1301C080). Reset INIT 0x00000000. PROVEN: vendor register header. No call site in the vendor hal/drv C sources: access by register-name convention only (INFERRED). ";
        field { name = "hdcp2x_sec_intr7"; desc = ""; sw = rw; hw = r; reset = 0x0; } hdcp2x_sec_intr7[7:7];
        field { name = "hdcp2x_sec_intr6"; desc = ""; sw = rw; hw = r; reset = 0x0; } hdcp2x_sec_intr6[6:6];
        field { name = "hdcp2x_sec_intr5"; desc = ""; sw = rw; hw = r; reset = 0x0; } hdcp2x_sec_intr5[5:5];
        field { name = "hdcp2x_sec_intr4"; desc = ""; sw = rw; hw = r; reset = 0x0; } hdcp2x_sec_intr4[4:4];
        field { name = "hdcp2x_sec_intr3"; desc = ""; sw = rw; hw = r; reset = 0x0; } hdcp2x_sec_intr3[3:3];
        field { name = "hdcp2x_sec_intr2"; desc = ""; sw = rw; hw = r; reset = 0x0; } hdcp2x_sec_intr2[2:2];
        field { name = "hdcp2x_sec_intr1"; desc = ""; sw = rw; hw = r; reset = 0x0; } hdcp2x_sec_intr1[1:1];
        field { name = "hdcp2x_sec_intr0"; desc = ""; sw = rw; hw = r; reset = 0x0; } hdcp2x_sec_intr0[0:0];
    } HDCP2X_SEC_INTR_B0 @ 0x80;
    reg {
        name = "HDCP2X_SEC_INTR_B1";
        desc = "HDCP2X_SEC_INTR_B1 (offset 0x84 in this sub-block, absolute 0x1301C084). Reset INIT 0x00000000. PROVEN: vendor register header. No call site in the vendor hal/drv C sources: access by register-name convention only (INFERRED). ";
        field { name = "hdcp2x_sec_intr15"; desc = ""; sw = rw; hw = r; reset = 0x0; } hdcp2x_sec_intr15[7:7];
        field { name = "hdcp2x_sec_intr14"; desc = ""; sw = rw; hw = r; reset = 0x0; } hdcp2x_sec_intr14[6:6];
        field { name = "hdcp2x_sec_intr13"; desc = ""; sw = rw; hw = r; reset = 0x0; } hdcp2x_sec_intr13[5:5];
        field { name = "hdcp2x_sec_intr12"; desc = ""; sw = rw; hw = r; reset = 0x0; } hdcp2x_sec_intr12[4:4];
        field { name = "hdcp2x_sec_intr11"; desc = ""; sw = rw; hw = r; reset = 0x0; } hdcp2x_sec_intr11[3:3];
        field { name = "hdcp2x_sec_intr10"; desc = ""; sw = rw; hw = r; reset = 0x0; } hdcp2x_sec_intr10[2:2];
        field { name = "hdcp2x_sec_intr9"; desc = ""; sw = rw; hw = r; reset = 0x0; } hdcp2x_sec_intr9[1:1];
        field { name = "hdcp2x_sec_intr8"; desc = ""; sw = rw; hw = r; reset = 0x0; } hdcp2x_sec_intr8[0:0];
    } HDCP2X_SEC_INTR_B1 @ 0x84;
    reg {
        name = "HDCP2X_SEC_MASK_B0";
        desc = "HDCP2X_SEC_MASK_B0 (offset 0x88 in this sub-block, absolute 0x1301C088). Reset INIT 0x00000000. PROVEN: vendor register header. No call site in the vendor hal/drv C sources: access by register-name convention only (INFERRED). ";
        field { name = "hdcp2x_sec_mask7"; desc = ""; sw = rw; hw = r; reset = 0x0; } hdcp2x_sec_mask7[7:7];
        field { name = "hdcp2x_sec_mask6"; desc = ""; sw = rw; hw = r; reset = 0x0; } hdcp2x_sec_mask6[6:6];
        field { name = "hdcp2x_sec_mask5"; desc = ""; sw = rw; hw = r; reset = 0x0; } hdcp2x_sec_mask5[5:5];
        field { name = "hdcp2x_sec_mask4"; desc = ""; sw = rw; hw = r; reset = 0x0; } hdcp2x_sec_mask4[4:4];
        field { name = "hdcp2x_sec_mask3"; desc = ""; sw = rw; hw = r; reset = 0x0; } hdcp2x_sec_mask3[3:3];
        field { name = "hdcp2x_sec_mask2"; desc = ""; sw = rw; hw = r; reset = 0x0; } hdcp2x_sec_mask2[2:2];
        field { name = "hdcp2x_sec_mask1"; desc = ""; sw = rw; hw = r; reset = 0x0; } hdcp2x_sec_mask1[1:1];
        field { name = "hdcp2x_sec_mask0"; desc = ""; sw = rw; hw = r; reset = 0x0; } hdcp2x_sec_mask0[0:0];
    } HDCP2X_SEC_MASK_B0 @ 0x88;
    reg {
        name = "HDCP2X_SEC_MASK_B1";
        desc = "HDCP2X_SEC_MASK_B1 (offset 0x8C in this sub-block, absolute 0x1301C08C). Reset INIT 0x00000000. PROVEN: vendor register header. No call site in the vendor hal/drv C sources: access by register-name convention only (INFERRED). ";
        field { name = "hdcp2x_sec_mask15"; desc = ""; sw = rw; hw = r; reset = 0x0; } hdcp2x_sec_mask15[7:7];
        field { name = "hdcp2x_sec_mask14"; desc = ""; sw = rw; hw = r; reset = 0x0; } hdcp2x_sec_mask14[6:6];
        field { name = "hdcp2x_sec_mask13"; desc = ""; sw = rw; hw = r; reset = 0x0; } hdcp2x_sec_mask13[5:5];
        field { name = "hdcp2x_sec_mask12"; desc = ""; sw = rw; hw = r; reset = 0x0; } hdcp2x_sec_mask12[4:4];
        field { name = "hdcp2x_sec_mask11"; desc = ""; sw = rw; hw = r; reset = 0x0; } hdcp2x_sec_mask11[3:3];
        field { name = "hdcp2x_sec_mask10"; desc = ""; sw = rw; hw = r; reset = 0x0; } hdcp2x_sec_mask10[2:2];
        field { name = "hdcp2x_sec_mask9"; desc = ""; sw = rw; hw = r; reset = 0x0; } hdcp2x_sec_mask9[1:1];
        field { name = "hdcp2x_sec_mask8"; desc = ""; sw = rw; hw = r; reset = 0x0; } hdcp2x_sec_mask8[0:0];
    } HDCP2X_SEC_MASK_B1 @ 0x8C;
    reg {
        name = "HDCP2X_MCU_INTR_B0";
        desc = "HDCP2X_MCU_INTR_B0 (offset 0xA4 in this sub-block, absolute 0x1301C0A4). Reset INIT 0x00000000. PROVEN: vendor register header. Driver usage (vendor hal/drv C, uncommented call sites): 16 Get, 16 Set (hdmi_hal_hdcp22.c): read and written (RW). ";
        field { name = "hdcp2x_mcu_intr7"; desc = ""; sw = rw; hw = r; reset = 0x0; } hdcp2x_mcu_intr7[7:7];
        field { name = "hdcp2x_mcu_intr6"; desc = ""; sw = rw; hw = r; reset = 0x0; } hdcp2x_mcu_intr6[6:6];
        field { name = "hdcp2x_mcu_intr5"; desc = ""; sw = rw; hw = r; reset = 0x0; } hdcp2x_mcu_intr5[5:5];
        field { name = "hdcp2x_mcu_intr4"; desc = ""; sw = rw; hw = r; reset = 0x0; } hdcp2x_mcu_intr4[4:4];
        field { name = "hdcp2x_mcu_intr3"; desc = ""; sw = rw; hw = r; reset = 0x0; } hdcp2x_mcu_intr3[3:3];
        field { name = "hdcp2x_mcu_intr2"; desc = ""; sw = rw; hw = r; reset = 0x0; } hdcp2x_mcu_intr2[2:2];
        field { name = "hdcp2x_mcu_intr1"; desc = ""; sw = rw; hw = r; reset = 0x0; } hdcp2x_mcu_intr1[1:1];
        field { name = "hdcp2x_mcu_intr0"; desc = ""; sw = rw; hw = r; reset = 0x0; } hdcp2x_mcu_intr0[0:0];
    } HDCP2X_MCU_INTR_B0 @ 0xA4;
    reg {
        name = "HDCP2X_MCU_INTR_B1";
        desc = "HDCP2X_MCU_INTR_B1 (offset 0xA8 in this sub-block, absolute 0x1301C0A8). Reset INIT 0x00000000. PROVEN: vendor register header. Driver usage (vendor hal/drv C, uncommented call sites): 16 Get, 16 Set (hdmi_hal_hdcp22.c): read and written (RW). ";
        field { name = "hdcp2x_mcu_intr15"; desc = ""; sw = rw; hw = r; reset = 0x0; } hdcp2x_mcu_intr15[7:7];
        field { name = "hdcp2x_mcu_intr14"; desc = ""; sw = rw; hw = r; reset = 0x0; } hdcp2x_mcu_intr14[6:6];
        field { name = "hdcp2x_mcu_intr13"; desc = ""; sw = rw; hw = r; reset = 0x0; } hdcp2x_mcu_intr13[5:5];
        field { name = "hdcp2x_mcu_intr12"; desc = ""; sw = rw; hw = r; reset = 0x0; } hdcp2x_mcu_intr12[4:4];
        field { name = "hdcp2x_mcu_intr11"; desc = ""; sw = rw; hw = r; reset = 0x0; } hdcp2x_mcu_intr11[3:3];
        field { name = "hdcp2x_mcu_intr10"; desc = ""; sw = rw; hw = r; reset = 0x0; } hdcp2x_mcu_intr10[2:2];
        field { name = "hdcp2x_mcu_intr9"; desc = ""; sw = rw; hw = r; reset = 0x0; } hdcp2x_mcu_intr9[1:1];
        field { name = "hdcp2x_mcu_intr8"; desc = ""; sw = rw; hw = r; reset = 0x0; } hdcp2x_mcu_intr8[0:0];
    } HDCP2X_MCU_INTR_B1 @ 0xA8;
    reg {
        name = "HDCP2X_MCU_INTR_B2";
        desc = "HDCP2X_MCU_INTR_B2 (offset 0xAC in this sub-block, absolute 0x1301C0AC). Reset INIT 0x00000000. PROVEN: vendor register header. Driver usage (vendor hal/drv C, uncommented call sites): 16 Get, 16 Set (hdmi_hal_hdcp22.c): read and written (RW). ";
        field { name = "hdcp2x_mcu_intr23"; desc = ""; sw = rw; hw = r; reset = 0x0; } hdcp2x_mcu_intr23[7:7];
        field { name = "hdcp2x_mcu_intr22"; desc = ""; sw = rw; hw = r; reset = 0x0; } hdcp2x_mcu_intr22[6:6];
        field { name = "hdcp2x_mcu_intr21"; desc = ""; sw = rw; hw = r; reset = 0x0; } hdcp2x_mcu_intr21[5:5];
        field { name = "hdcp2x_mcu_intr20"; desc = ""; sw = rw; hw = r; reset = 0x0; } hdcp2x_mcu_intr20[4:4];
        field { name = "hdcp2x_mcu_intr19"; desc = ""; sw = rw; hw = r; reset = 0x0; } hdcp2x_mcu_intr19[3:3];
        field { name = "hdcp2x_mcu_intr18"; desc = ""; sw = rw; hw = r; reset = 0x0; } hdcp2x_mcu_intr18[2:2];
        field { name = "hdcp2x_mcu_intr17"; desc = ""; sw = rw; hw = r; reset = 0x0; } hdcp2x_mcu_intr17[1:1];
        field { name = "hdcp2x_mcu_intr16"; desc = ""; sw = rw; hw = r; reset = 0x0; } hdcp2x_mcu_intr16[0:0];
    } HDCP2X_MCU_INTR_B2 @ 0xAC;
    reg {
        name = "HDCP2X_MCU_INTR_B3";
        desc = "HDCP2X_MCU_INTR_B3 (offset 0xB0 in this sub-block, absolute 0x1301C0B0). Reset INIT 0x00000000. PROVEN: vendor register header. Driver usage (vendor hal/drv C, uncommented call sites): 16 Get, 16 Set (hdmi_hal_hdcp22.c): read and written (RW). ";
        field { name = "hdcp2x_mcu_intr31"; desc = ""; sw = rw; hw = r; reset = 0x0; } hdcp2x_mcu_intr31[7:7];
        field { name = "hdcp2x_mcu_intr30"; desc = ""; sw = rw; hw = r; reset = 0x0; } hdcp2x_mcu_intr30[6:6];
        field { name = "hdcp2x_mcu_intr29"; desc = ""; sw = rw; hw = r; reset = 0x0; } hdcp2x_mcu_intr29[5:5];
        field { name = "hdcp2x_mcu_intr28"; desc = ""; sw = rw; hw = r; reset = 0x0; } hdcp2x_mcu_intr28[4:4];
        field { name = "hdcp2x_mcu_intr27"; desc = ""; sw = rw; hw = r; reset = 0x0; } hdcp2x_mcu_intr27[3:3];
        field { name = "hdcp2x_mcu_intr26"; desc = ""; sw = rw; hw = r; reset = 0x0; } hdcp2x_mcu_intr26[2:2];
        field { name = "hdcp2x_mcu_intr25"; desc = ""; sw = rw; hw = r; reset = 0x0; } hdcp2x_mcu_intr25[1:1];
        field { name = "hdcp2x_mcu_intr24"; desc = ""; sw = rw; hw = r; reset = 0x0; } hdcp2x_mcu_intr24[0:0];
    } HDCP2X_MCU_INTR_B3 @ 0xB0;
    reg {
        name = "HDCP2X_MCU_MASK_B0";
        desc = "HDCP2X_MCU_MASK_B0 (offset 0xB4 in this sub-block, absolute 0x1301C0B4). Reset INIT 0x00000000. PROVEN: vendor register header. No call site in the vendor hal/drv C sources: access by register-name convention only (INFERRED). ";
        field { name = "hdcp2x_mcu_mask7"; desc = ""; sw = rw; hw = r; reset = 0x0; } hdcp2x_mcu_mask7[7:7];
        field { name = "hdcp2x_mcu_mask6"; desc = ""; sw = rw; hw = r; reset = 0x0; } hdcp2x_mcu_mask6[6:6];
        field { name = "hdcp2x_mcu_mask5"; desc = ""; sw = rw; hw = r; reset = 0x0; } hdcp2x_mcu_mask5[5:5];
        field { name = "hdcp2x_mcu_mask4"; desc = ""; sw = rw; hw = r; reset = 0x0; } hdcp2x_mcu_mask4[4:4];
        field { name = "hdcp2x_mcu_mask3"; desc = ""; sw = rw; hw = r; reset = 0x0; } hdcp2x_mcu_mask3[3:3];
        field { name = "hdcp2x_mcu_mask2"; desc = ""; sw = rw; hw = r; reset = 0x0; } hdcp2x_mcu_mask2[2:2];
        field { name = "hdcp2x_mcu_mask1"; desc = ""; sw = rw; hw = r; reset = 0x0; } hdcp2x_mcu_mask1[1:1];
        field { name = "hdcp2x_mcu_mask0"; desc = ""; sw = rw; hw = r; reset = 0x0; } hdcp2x_mcu_mask0[0:0];
    } HDCP2X_MCU_MASK_B0 @ 0xB4;
    reg {
        name = "HDCP2X_MCU_MASK_B1";
        desc = "HDCP2X_MCU_MASK_B1 (offset 0xB8 in this sub-block, absolute 0x1301C0B8). Reset INIT 0x00000000. PROVEN: vendor register header. No call site in the vendor hal/drv C sources: access by register-name convention only (INFERRED). ";
        field { name = "hdcp2x_mcu_mask15"; desc = ""; sw = rw; hw = r; reset = 0x0; } hdcp2x_mcu_mask15[7:7];
        field { name = "hdcp2x_mcu_mask14"; desc = ""; sw = rw; hw = r; reset = 0x0; } hdcp2x_mcu_mask14[6:6];
        field { name = "hdcp2x_mcu_mask13"; desc = ""; sw = rw; hw = r; reset = 0x0; } hdcp2x_mcu_mask13[5:5];
        field { name = "hdcp2x_mcu_mask12"; desc = ""; sw = rw; hw = r; reset = 0x0; } hdcp2x_mcu_mask12[4:4];
        field { name = "hdcp2x_mcu_mask11"; desc = ""; sw = rw; hw = r; reset = 0x0; } hdcp2x_mcu_mask11[3:3];
        field { name = "hdcp2x_mcu_mask10"; desc = ""; sw = rw; hw = r; reset = 0x0; } hdcp2x_mcu_mask10[2:2];
        field { name = "hdcp2x_mcu_mask9"; desc = ""; sw = rw; hw = r; reset = 0x0; } hdcp2x_mcu_mask9[1:1];
        field { name = "hdcp2x_mcu_mask8"; desc = ""; sw = rw; hw = r; reset = 0x0; } hdcp2x_mcu_mask8[0:0];
    } HDCP2X_MCU_MASK_B1 @ 0xB8;
    reg {
        name = "HDCP2X_MCU_MASK_B2";
        desc = "HDCP2X_MCU_MASK_B2 (offset 0xBC in this sub-block, absolute 0x1301C0BC). Reset INIT 0x00000000. PROVEN: vendor register header. No call site in the vendor hal/drv C sources: access by register-name convention only (INFERRED). ";
        field { name = "hdcp2x_mcu_mask23"; desc = ""; sw = rw; hw = r; reset = 0x0; } hdcp2x_mcu_mask23[7:7];
        field { name = "hdcp2x_mcu_mask22"; desc = ""; sw = rw; hw = r; reset = 0x0; } hdcp2x_mcu_mask22[6:6];
        field { name = "hdcp2x_mcu_mask21"; desc = ""; sw = rw; hw = r; reset = 0x0; } hdcp2x_mcu_mask21[5:5];
        field { name = "hdcp2x_mcu_mask20"; desc = ""; sw = rw; hw = r; reset = 0x0; } hdcp2x_mcu_mask20[4:4];
        field { name = "hdcp2x_mcu_mask19"; desc = ""; sw = rw; hw = r; reset = 0x0; } hdcp2x_mcu_mask19[3:3];
        field { name = "hdcp2x_mcu_mask18"; desc = ""; sw = rw; hw = r; reset = 0x0; } hdcp2x_mcu_mask18[2:2];
        field { name = "hdcp2x_mcu_mask17"; desc = ""; sw = rw; hw = r; reset = 0x0; } hdcp2x_mcu_mask17[1:1];
        field { name = "hdcp2x_mcu_mask16"; desc = ""; sw = rw; hw = r; reset = 0x0; } hdcp2x_mcu_mask16[0:0];
    } HDCP2X_MCU_MASK_B2 @ 0xBC;
    reg {
        name = "HDCP2X_MCU_MASK_B3";
        desc = "HDCP2X_MCU_MASK_B3 (offset 0xC0 in this sub-block, absolute 0x1301C0C0). Reset INIT 0x00000000. PROVEN: vendor register header. No call site in the vendor hal/drv C sources: access by register-name convention only (INFERRED). ";
        field { name = "hdcp2x_mcu_mask31"; desc = ""; sw = rw; hw = r; reset = 0x0; } hdcp2x_mcu_mask31[7:7];
        field { name = "hdcp2x_mcu_mask30"; desc = ""; sw = rw; hw = r; reset = 0x0; } hdcp2x_mcu_mask30[6:6];
        field { name = "hdcp2x_mcu_mask29"; desc = ""; sw = rw; hw = r; reset = 0x0; } hdcp2x_mcu_mask29[5:5];
        field { name = "hdcp2x_mcu_mask28"; desc = ""; sw = rw; hw = r; reset = 0x0; } hdcp2x_mcu_mask28[4:4];
        field { name = "hdcp2x_mcu_mask27"; desc = ""; sw = rw; hw = r; reset = 0x0; } hdcp2x_mcu_mask27[3:3];
        field { name = "hdcp2x_mcu_mask26"; desc = ""; sw = rw; hw = r; reset = 0x0; } hdcp2x_mcu_mask26[2:2];
        field { name = "hdcp2x_mcu_mask25"; desc = ""; sw = rw; hw = r; reset = 0x0; } hdcp2x_mcu_mask25[1:1];
        field { name = "hdcp2x_mcu_mask24"; desc = ""; sw = rw; hw = r; reset = 0x0; } hdcp2x_mcu_mask24[0:0];
    } HDCP2X_MCU_MASK_B3 @ 0xC0;
    reg {
        name = "HDCP2X_MCU_STATE_B0";
        desc = "HDCP2X_MCU_STATE_B0 (offset 0xCC in this sub-block, absolute 0x1301C0CC). Reset INIT 0x00000000. PROVEN: vendor register header. No call site in the vendor hal/drv C sources: access by register-name convention only (INFERRED). ";
        field { name = "hdcp2x_mcu_state_b0"; desc = ""; sw = rw; hw = r; reset = 0x0; } hdcp2x_mcu_state_b0[7:0];
    } HDCP2X_MCU_STATE_B0 @ 0xCC;
    reg {
        name = "HDCP2X_MCU_STATE_B1";
        desc = "HDCP2X_MCU_STATE_B1 (offset 0xD0 in this sub-block, absolute 0x1301C0D0). Reset INIT 0x00000000. PROVEN: vendor register header. No call site in the vendor hal/drv C sources: access by register-name convention only (INFERRED). ";
        field { name = "hdcp2x_mcu_state_b1"; desc = ""; sw = rw; hw = r; reset = 0x0; } hdcp2x_mcu_state_b1[7:0];
    } HDCP2X_MCU_STATE_B1 @ 0xD0;
    reg {
        name = "HDCP2X_MCU_STATE_B2";
        desc = "HDCP2X_MCU_STATE_B2 (offset 0xD4 in this sub-block, absolute 0x1301C0D4). Reset INIT 0x00000000. PROVEN: vendor register header. No call site in the vendor hal/drv C sources: access by register-name convention only (INFERRED). ";
        field { name = "hdcp2x_mcu_state_b2"; desc = ""; sw = rw; hw = r; reset = 0x0; } hdcp2x_mcu_state_b2[7:0];
    } HDCP2X_MCU_STATE_B2 @ 0xD4;
    reg {
        name = "HDCP2X_MCU_STATE_B3";
        desc = "HDCP2X_MCU_STATE_B3 (offset 0xD8 in this sub-block, absolute 0x1301C0D8). Reset INIT 0x00000000. PROVEN: vendor register header. No call site in the vendor hal/drv C sources: access by register-name convention only (INFERRED). ";
        field { name = "hdcp2x_mcu_state_b3"; desc = ""; sw = rw; hw = r; reset = 0x0; } hdcp2x_mcu_state_b3[7:0];
    } HDCP2X_MCU_STATE_B3 @ 0xD8;
    reg {
        name = "HDCP2X_RX_AUTH_STATE";
        desc = "HDCP2X_RX_AUTH_STATE (offset 0xE8 in this sub-block, absolute 0x1301C0E8). Reset INIT 0x00000000. PROVEN: vendor register header. Driver usage (vendor hal/drv C, uncommented call sites): 8 Get, 0 Set (hdmi_hal_hdcp22.c): read-only by usage (INFERRED RO). ";
        field { name = "hdcp2x_send_sks_done"; desc = ""; sw = r; hw = w; reset = 0x0; } hdcp2x_send_sks_done[7:7];
        field { name = "hdcp2x_send_l_done"; desc = ""; sw = r; hw = w; reset = 0x0; } hdcp2x_send_l_done[6:6];
        field { name = "hdcp2x_lc_init_done"; desc = ""; sw = r; hw = w; reset = 0x0; } hdcp2x_lc_init_done[5:5];
        field { name = "hdcp2x_pairing_done"; desc = ""; sw = r; hw = w; reset = 0x0; } hdcp2x_pairing_done[4:4];
        field { name = "hdcp2x_send_h_done"; desc = ""; sw = r; hw = w; reset = 0x0; } hdcp2x_send_h_done[3:3];
        field { name = "hdcp2x_km_done"; desc = ""; sw = r; hw = w; reset = 0x0; } hdcp2x_km_done[2:2];
        field { name = "hdcp2x_send_cert_done"; desc = ""; sw = r; hw = w; reset = 0x0; } hdcp2x_send_cert_done[1:1];
        field { name = "hdcp2x_ake_init_done"; desc = ""; sw = r; hw = w; reset = 0x0; } hdcp2x_ake_init_done[0:0];
    } HDCP2X_RX_AUTH_STATE @ 0xE8;
    reg {
        name = "HDCP2X_RPT_AUTH_STATE";
        desc = "HDCP2X_RPT_AUTH_STATE (offset 0xEC in this sub-block, absolute 0x1301C0EC). Reset INIT 0x00000000. PROVEN: vendor register header. Driver usage (vendor hal/drv C, uncommented call sites): 4 Get, 0 Set (hdmi_hal_hdcp22.c): read-only by usage (INFERRED RO). ";
        field { name = "rsv_1"; desc = ""; sw = r; hw = na; reset = 0x0; } rsv_1[7:4];
        field { name = "hdcp2x_strm_rdy_done"; desc = ""; sw = r; hw = w; reset = 0x0; } hdcp2x_strm_rdy_done[3:3];
        field { name = "hdcp2x_strm_id_done"; desc = ""; sw = r; hw = w; reset = 0x0; } hdcp2x_strm_id_done[2:2];
        field { name = "hdcp2x_send_ack_done"; desc = ""; sw = r; hw = w; reset = 0x0; } hdcp2x_send_ack_done[1:1];
        field { name = "hdcp2x_id_list_done"; desc = ""; sw = r; hw = w; reset = 0x0; } hdcp2x_id_list_done[0:0];
    } HDCP2X_RPT_AUTH_STATE @ 0xEC;
    reg {
        name = "HDCP2X_AUTH_STATE0";
        desc = "HDCP2X_AUTH_STATE0 (offset 0xF0 in this sub-block, absolute 0x1301C0F0). Reset INIT 0x00000000. PROVEN: vendor register header. Driver usage (vendor hal/drv C, uncommented call sites): 1 Get, 0 Set (hdmi_hal_hdcp22.c): read-only by usage (INFERRED RO). ";
        field { name = "hdcp2x_auth_state0"; desc = ""; sw = r; hw = w; reset = 0x0; } hdcp2x_auth_state0[7:0];
    } HDCP2X_AUTH_STATE0 @ 0xF0;
    reg {
        name = "HDCP2X_AUTH_STATE1";
        desc = "HDCP2X_AUTH_STATE1 (offset 0xF4 in this sub-block, absolute 0x1301C0F4). Reset INIT 0x00000000. PROVEN: vendor register header. Driver usage (vendor hal/drv C, uncommented call sites): 1 Get, 0 Set (hdmi_hal_hdcp22.c): read-only by usage (INFERRED RO). ";
        field { name = "hdcp2x_auth_state1"; desc = ""; sw = r; hw = w; reset = 0x0; } hdcp2x_auth_state1[7:0];
    } HDCP2X_AUTH_STATE1 @ 0xF4;
    reg {
        name = "HDCP2X_AUTH_STATE2";
        desc = "HDCP2X_AUTH_STATE2 (offset 0xF8 in this sub-block, absolute 0x1301C0F8). Reset INIT 0x00000000. PROVEN: vendor register header. Driver usage (vendor hal/drv C, uncommented call sites): 1 Get, 0 Set (hdmi_hal_hdcp22.c): read-only by usage (INFERRED RO). ";
        field { name = "hdcp2x_auth_state2"; desc = ""; sw = r; hw = w; reset = 0x0; } hdcp2x_auth_state2[7:0];
    } HDCP2X_AUTH_STATE2 @ 0xF8;
    reg {
        name = "HDCP2X_AUTH_STATE3";
        desc = "HDCP2X_AUTH_STATE3 (offset 0xFC in this sub-block, absolute 0x1301C0FC). Reset INIT 0x00000000. PROVEN: vendor register header. Driver usage (vendor hal/drv C, uncommented call sites): 1 Get, 0 Set (hdmi_hal_hdcp22.c): read-only by usage (INFERRED RO). ";
        field { name = "hdcp2x_auth_state3"; desc = ""; sw = r; hw = w; reset = 0x0; } hdcp2x_auth_state3[7:0];
    } HDCP2X_AUTH_STATE3 @ 0xFC;
    reg {
        name = "HDCP2X_CERT_INFO";
        desc = "HDCP2X_CERT_INFO (offset 0x114 in this sub-block, absolute 0x1301C114). Reset INIT 0x00000000. PROVEN: vendor register header. Driver usage (vendor hal/drv C, uncommented call sites): 1 Get, 0 Set (hdmi_hal_hdcp22.c): read-only by usage (INFERRED RO). ";
        field { name = "rsv_2"; desc = ""; sw = r; hw = na; reset = 0x0; } rsv_2[7:1];
        field { name = "hdcp2x_cert_rpt"; desc = ""; sw = r; hw = w; reset = 0x0; } hdcp2x_cert_rpt[0:0];
    } HDCP2X_CERT_INFO @ 0x114;
    reg {
        name = "HDCP2X_CERT_VER";
        desc = "HDCP2X_CERT_VER (offset 0x118 in this sub-block, absolute 0x1301C118). Reset INIT 0x00000000. PROVEN: vendor register header. Driver usage (vendor hal/drv C, uncommented call sites): 1 Get, 0 Set (hdmi_hal_hdcp22.c): read-only by usage (INFERRED RO). ";
        field { name = "hdcp2x_cert_ver"; desc = ""; sw = r; hw = w; reset = 0x0; } hdcp2x_cert_ver[7:0];
    } HDCP2X_CERT_VER @ 0x118;
    reg {
        name = "HDCP2X_RPT_INFO";
        desc = "HDCP2X_RPT_INFO (offset 0x11C in this sub-block, absolute 0x1301C11C). Reset INIT 0x00000000. PROVEN: vendor register header. Driver usage (vendor hal/drv C, uncommented call sites): 4 Get, 0 Set (hdmi_hal_hdcp22.c): read-only by usage (INFERRED RO). ";
        field { name = "rsv_3"; desc = ""; sw = r; hw = na; reset = 0x0; } rsv_3[7:4];
        field { name = "hdcp2x_rpt_dev_exc"; desc = ""; sw = r; hw = w; reset = 0x0; } hdcp2x_rpt_dev_exc[3:3];
        field { name = "hdcp2x_rpt_cas_exc"; desc = ""; sw = r; hw = w; reset = 0x0; } hdcp2x_rpt_cas_exc[2:2];
        field { name = "hdcp20_rpt_on"; desc = ""; sw = r; hw = w; reset = 0x0; } hdcp20_rpt_on[1:1];
        field { name = "hdcp1x_dev_on"; desc = ""; sw = r; hw = w; reset = 0x0; } hdcp1x_dev_on[0:0];
    } HDCP2X_RPT_INFO @ 0x11C;
    reg {
        name = "HDCP2X_RPT_DEV";
        desc = "HDCP2X_RPT_DEV (offset 0x120 in this sub-block, absolute 0x1301C120). Reset INIT 0x00000000. PROVEN: vendor register header. Driver usage (vendor hal/drv C, uncommented call sites): 2 Get, 0 Set (hdmi_hal_hdcp22.c): read-only by usage (INFERRED RO). ";
        field { name = "hdcp2x_rpt_dep_cnt"; desc = ""; sw = r; hw = w; reset = 0x0; } hdcp2x_rpt_dep_cnt[7:5];
        field { name = "hdcp2x_rpt_dev_cnt"; desc = ""; sw = r; hw = w; reset = 0x0; } hdcp2x_rpt_dev_cnt[4:0];
    } HDCP2X_RPT_DEV @ 0x120;
    reg {
        name = "HDCP2X_RPT_V0";
        desc = "HDCP2X_RPT_V0 (offset 0x124 in this sub-block, absolute 0x1301C124). Reset INIT 0x00000000. PROVEN: vendor register header. Driver usage (vendor hal/drv C, uncommented call sites): 1 Get, 0 Set (hdmi_hal_hdcp22.c): read-only by usage (INFERRED RO). ";
        field { name = "hdcp2x_rpt_v0"; desc = ""; sw = r; hw = w; reset = 0x0; } hdcp2x_rpt_v0[7:0];
    } HDCP2X_RPT_V0 @ 0x124;
    reg {
        name = "HDCP2X_RPT_V1";
        desc = "HDCP2X_RPT_V1 (offset 0x128 in this sub-block, absolute 0x1301C128). Reset INIT 0x00000000. PROVEN: vendor register header. Driver usage (vendor hal/drv C, uncommented call sites): 1 Get, 0 Set (hdmi_hal_hdcp22.c): read-only by usage (INFERRED RO). ";
        field { name = "hdcp2x_rpt_v1"; desc = ""; sw = r; hw = w; reset = 0x0; } hdcp2x_rpt_v1[7:0];
    } HDCP2X_RPT_V1 @ 0x128;
    reg {
        name = "HDCP2X_RPT_V2";
        desc = "HDCP2X_RPT_V2 (offset 0x12C in this sub-block, absolute 0x1301C12C). Reset INIT 0x00000000. PROVEN: vendor register header. Driver usage (vendor hal/drv C, uncommented call sites): 1 Get, 0 Set (hdmi_hal_hdcp22.c): read-only by usage (INFERRED RO). ";
        field { name = "hdcp2x_rpt_v2"; desc = ""; sw = r; hw = w; reset = 0x0; } hdcp2x_rpt_v2[7:0];
    } HDCP2X_RPT_V2 @ 0x12C;
    reg {
        name = "HDCP2X_RPT_K0";
        desc = "HDCP2X_RPT_K0 (offset 0x130 in this sub-block, absolute 0x1301C130). Reset INIT 0x00000001. PROVEN: vendor register header. Driver usage (vendor hal/drv C, uncommented call sites): 1 Get, 1 Set (hdmi_hal_hdcp22.c): read and written (RW). ";
        field { name = "hdcp2x_rpt_k0"; desc = ""; sw = rw; hw = r; reset = 0x1; } hdcp2x_rpt_k0[7:0];
    } HDCP2X_RPT_K0 @ 0x130;
    reg {
        name = "HDCP2X_RPT_K1";
        desc = "HDCP2X_RPT_K1 (offset 0x134 in this sub-block, absolute 0x1301C134). Reset INIT 0x00000000. PROVEN: vendor register header. Driver usage (vendor hal/drv C, uncommented call sites): 1 Get, 1 Set (hdmi_hal_hdcp22.c): read and written (RW). ";
        field { name = "hdcp2x_rpt_k1"; desc = ""; sw = rw; hw = r; reset = 0x0; } hdcp2x_rpt_k1[7:0];
    } HDCP2X_RPT_K1 @ 0x134;
    reg {
        name = "HDCP2X_RPT_M0";
        desc = "HDCP2X_RPT_M0 (offset 0x138 in this sub-block, absolute 0x1301C138). Reset INIT 0x00000000. PROVEN: vendor register header. Driver usage (vendor hal/drv C, uncommented call sites): 1 Get, 1 Set (hdmi_hal_hdcp22.c): read and written (RW). ";
        field { name = "hdcp2x_rpt_m0"; desc = ""; sw = rw; hw = r; reset = 0x0; } hdcp2x_rpt_m0[7:0];
    } HDCP2X_RPT_M0 @ 0x138;
    reg {
        name = "HDCP2X_RPT_M1";
        desc = "HDCP2X_RPT_M1 (offset 0x13C in this sub-block, absolute 0x1301C13C). Reset INIT 0x00000000. PROVEN: vendor register header. Driver usage (vendor hal/drv C, uncommented call sites): 1 Get, 1 Set (hdmi_hal_hdcp22.c): read and written (RW). ";
        field { name = "hdcp2x_rpt_m1"; desc = ""; sw = rw; hw = r; reset = 0x0; } hdcp2x_rpt_m1[7:0];
    } HDCP2X_RPT_M1 @ 0x13C;
    reg {
        name = "HDCP2X_RPT_M2";
        desc = "HDCP2X_RPT_M2 (offset 0x140 in this sub-block, absolute 0x1301C140). Reset INIT 0x00000000. PROVEN: vendor register header. Driver usage (vendor hal/drv C, uncommented call sites): 1 Get, 1 Set (hdmi_hal_hdcp22.c): read and written (RW). ";
        field { name = "hdcp2x_rpt_m2"; desc = ""; sw = rw; hw = r; reset = 0x0; } hdcp2x_rpt_m2[7:0];
    } HDCP2X_RPT_M2 @ 0x140;
    reg {
        name = "HDCP2X_RPT_STRM_ID";
        desc = "HDCP2X_RPT_STRM_ID (offset 0x144 in this sub-block, absolute 0x1301C144). Reset INIT 0x00000000. PROVEN: vendor register header. Driver usage (vendor hal/drv C, uncommented call sites): 1 Get, 1 Set (hdmi_hal_hdcp22.c): read and written (RW). ";
        field { name = "hdcp2x_rpt_strm_id"; desc = ""; sw = rw; hw = r; reset = 0x0; } hdcp2x_rpt_strm_id[7:0];
    } HDCP2X_RPT_STRM_ID @ 0x144;
    reg {
        name = "HDCP2X_RPT_STRM_TPYE";
        desc = "HDCP2X_RPT_STRM_TPYE (offset 0x148 in this sub-block, absolute 0x1301C148). Reset INIT 0x00000001. PROVEN: vendor register header. Driver usage (vendor hal/drv C, uncommented call sites): 1 Get, 1 Set (hdmi_hal_hdcp22.c): read and written (RW). ";
        field { name = "hdcp2x_rpt_strm_type"; desc = ""; sw = rw; hw = r; reset = 0x1; } hdcp2x_rpt_strm_type[7:0];
    } HDCP2X_RPT_STRM_TPYE @ 0x148;
    reg {
        name = "HDCP2X_TIMING_CFG0";
        desc = "HDCP2X_TIMING_CFG0 (offset 0x1A4 in this sub-block, absolute 0x1301C1A4). Reset INIT 0x00000000. PROVEN: vendor register header. No call site in the vendor hal/drv C sources: access by register-name convention only (INFERRED). ";
        field { name = "hdcp2x_timing_cfg0"; desc = ""; sw = rw; hw = r; reset = 0x0; } hdcp2x_timing_cfg0[7:0];
    } HDCP2X_TIMING_CFG0 @ 0x1A4;
    reg {
        name = "HDCP2X_TIMING_CFG1";
        desc = "HDCP2X_TIMING_CFG1 (offset 0x1A8 in this sub-block, absolute 0x1301C1A8). Reset INIT 0x00000000. PROVEN: vendor register header. No call site in the vendor hal/drv C sources: access by register-name convention only (INFERRED). ";
        field { name = "hdcp2x_timing_cfg1"; desc = ""; sw = rw; hw = r; reset = 0x0; } hdcp2x_timing_cfg1[7:0];
    } HDCP2X_TIMING_CFG1 @ 0x1A8;
    reg {
        name = "HDCP2X_TIMING_CFG2";
        desc = "HDCP2X_TIMING_CFG2 (offset 0x1AC in this sub-block, absolute 0x1301C1AC). Reset INIT 0x00000000. PROVEN: vendor register header. No call site in the vendor hal/drv C sources: access by register-name convention only (INFERRED). ";
        field { name = "hdcp2x_timing_cfg2"; desc = ""; sw = rw; hw = r; reset = 0x0; } hdcp2x_timing_cfg2[7:0];
    } HDCP2X_TIMING_CFG2 @ 0x1AC;
    reg {
        name = "HDCP2X_TIMING_CFG3";
        desc = "HDCP2X_TIMING_CFG3 (offset 0x1B0 in this sub-block, absolute 0x1301C1B0). Reset INIT 0x00000000. PROVEN: vendor register header. No call site in the vendor hal/drv C sources: access by register-name convention only (INFERRED). ";
        field { name = "hdcp2x_timing_cfg3"; desc = ""; sw = rw; hw = r; reset = 0x0; } hdcp2x_timing_cfg3[7:0];
    } HDCP2X_TIMING_CFG3 @ 0x1B0;
    reg {
        name = "HDCP2X_TIMING_CFG4";
        desc = "HDCP2X_TIMING_CFG4 (offset 0x1B4 in this sub-block, absolute 0x1301C1B4). Reset INIT 0x00000000. PROVEN: vendor register header. No call site in the vendor hal/drv C sources: access by register-name convention only (INFERRED). ";
        field { name = "hdcp2x_timing_cfg4"; desc = ""; sw = rw; hw = r; reset = 0x0; } hdcp2x_timing_cfg4[7:0];
    } HDCP2X_TIMING_CFG4 @ 0x1B4;
    reg {
        name = "HDCP2X_TIMING_CFG5";
        desc = "HDCP2X_TIMING_CFG5 (offset 0x1B8 in this sub-block, absolute 0x1301C1B8). Reset INIT 0x00000000. PROVEN: vendor register header. No call site in the vendor hal/drv C sources: access by register-name convention only (INFERRED). ";
        field { name = "hdcp2x_timing_cfg5"; desc = ""; sw = rw; hw = r; reset = 0x0; } hdcp2x_timing_cfg5[7:0];
    } HDCP2X_TIMING_CFG5 @ 0x1B8;
    reg {
        name = "HDCP2X_TIMING_CFG6";
        desc = "HDCP2X_TIMING_CFG6 (offset 0x1BC in this sub-block, absolute 0x1301C1BC). Reset INIT 0x00000000. PROVEN: vendor register header. No call site in the vendor hal/drv C sources: access by register-name convention only (INFERRED). ";
        field { name = "hdcp2x_timing_cfg6"; desc = ""; sw = rw; hw = r; reset = 0x0; } hdcp2x_timing_cfg6[7:0];
    } HDCP2X_TIMING_CFG6 @ 0x1BC;
    reg {
        name = "HDCP2X_TIMING_CFG7";
        desc = "HDCP2X_TIMING_CFG7 (offset 0x1C0 in this sub-block, absolute 0x1301C1C0). Reset INIT 0x00000000. PROVEN: vendor register header. No call site in the vendor hal/drv C sources: access by register-name convention only (INFERRED). ";
        field { name = "hdcp2x_timing_cfg7"; desc = ""; sw = rw; hw = r; reset = 0x0; } hdcp2x_timing_cfg7[7:0];
    } HDCP2X_TIMING_CFG7 @ 0x1C0;
    reg {
        name = "HDCP2X_TIMING_CFG8";
        desc = "HDCP2X_TIMING_CFG8 (offset 0x1C4 in this sub-block, absolute 0x1301C1C4). Reset INIT 0x00000000. PROVEN: vendor register header. No call site in the vendor hal/drv C sources: access by register-name convention only (INFERRED). ";
        field { name = "hdcp2x_timing_cfg8"; desc = ""; sw = rw; hw = r; reset = 0x0; } hdcp2x_timing_cfg8[7:0];
    } HDCP2X_TIMING_CFG8 @ 0x1C4;
    reg {
        name = "HDCP2X_TIMING_CFG9";
        desc = "HDCP2X_TIMING_CFG9 (offset 0x1C8 in this sub-block, absolute 0x1301C1C8). Reset INIT 0x00000000. PROVEN: vendor register header. No call site in the vendor hal/drv C sources: access by register-name convention only (INFERRED). ";
        field { name = "hdcp2x_timing_cfg9"; desc = ""; sw = rw; hw = r; reset = 0x0; } hdcp2x_timing_cfg9[7:0];
    } HDCP2X_TIMING_CFG9 @ 0x1C8;
    reg {
        name = "HDCP2X_TIMING_CFG10";
        desc = "HDCP2X_TIMING_CFG10 (offset 0x1CC in this sub-block, absolute 0x1301C1CC). Reset INIT 0x00000000. PROVEN: vendor register header. No call site in the vendor hal/drv C sources: access by register-name convention only (INFERRED). ";
        field { name = "hdcp2x_timing_cfg10"; desc = ""; sw = rw; hw = r; reset = 0x0; } hdcp2x_timing_cfg10[7:0];
    } HDCP2X_TIMING_CFG10 @ 0x1CC;
    reg {
        name = "HDCP2X_TIMING_CFG11";
        desc = "HDCP2X_TIMING_CFG11 (offset 0x1D0 in this sub-block, absolute 0x1301C1D0). Reset INIT 0x00000000. PROVEN: vendor register header. No call site in the vendor hal/drv C sources: access by register-name convention only (INFERRED). ";
        field { name = "hdcp2x_timing_cfg11"; desc = ""; sw = rw; hw = r; reset = 0x0; } hdcp2x_timing_cfg11[7:0];
    } HDCP2X_TIMING_CFG11 @ 0x1D0;
    reg {
        name = "HDCP2X_TIMING_CFG12";
        desc = "HDCP2X_TIMING_CFG12 (offset 0x1D4 in this sub-block, absolute 0x1301C1D4). Reset INIT 0x00000000. PROVEN: vendor register header. No call site in the vendor hal/drv C sources: access by register-name convention only (INFERRED). ";
        field { name = "hdcp2x_timing_cfg12"; desc = ""; sw = rw; hw = r; reset = 0x0; } hdcp2x_timing_cfg12[7:0];
    } HDCP2X_TIMING_CFG12 @ 0x1D4;
    reg {
        name = "HDCP2X_TIMING_CFG13";
        desc = "HDCP2X_TIMING_CFG13 (offset 0x1D8 in this sub-block, absolute 0x1301C1D8). Reset INIT 0x00000000. PROVEN: vendor register header. No call site in the vendor hal/drv C sources: access by register-name convention only (INFERRED). ";
        field { name = "hdcp2x_timing_cfg13"; desc = ""; sw = rw; hw = r; reset = 0x0; } hdcp2x_timing_cfg13[7:0];
    } HDCP2X_TIMING_CFG13 @ 0x1D8;
    reg {
        name = "HDCP2X_TIMING_CFG14";
        desc = "HDCP2X_TIMING_CFG14 (offset 0x1DC in this sub-block, absolute 0x1301C1DC). Reset INIT 0x00000000. PROVEN: vendor register header. No call site in the vendor hal/drv C sources: access by register-name convention only (INFERRED). ";
        field { name = "hdcp2x_timing_cfg14"; desc = ""; sw = rw; hw = r; reset = 0x0; } hdcp2x_timing_cfg14[7:0];
    } HDCP2X_TIMING_CFG14 @ 0x1DC;
    reg {
        name = "HDCP2X_TIMING_CFG15";
        desc = "HDCP2X_TIMING_CFG15 (offset 0x1E0 in this sub-block, absolute 0x1301C1E0). Reset INIT 0x00000000. PROVEN: vendor register header. No call site in the vendor hal/drv C sources: access by register-name convention only (INFERRED). ";
        field { name = "hdcp2x_timing_cfg15"; desc = ""; sw = rw; hw = r; reset = 0x0; } hdcp2x_timing_cfg15[7:0];
    } HDCP2X_TIMING_CFG15 @ 0x1E0;
    reg {
        name = "HDCP2X_TIMING_CFG16";
        desc = "HDCP2X_TIMING_CFG16 (offset 0x1E4 in this sub-block, absolute 0x1301C1E4). Reset INIT 0x00000000. PROVEN: vendor register header. No call site in the vendor hal/drv C sources: access by register-name convention only (INFERRED). ";
        field { name = "hdcp2x_timing_cfg16"; desc = ""; sw = rw; hw = r; reset = 0x0; } hdcp2x_timing_cfg16[7:0];
    } HDCP2X_TIMING_CFG16 @ 0x1E4;
    reg {
        name = "HDCP2X_TIMING_CFG17";
        desc = "HDCP2X_TIMING_CFG17 (offset 0x1E8 in this sub-block, absolute 0x1301C1E8). Reset INIT 0x00000000. PROVEN: vendor register header. No call site in the vendor hal/drv C sources: access by register-name convention only (INFERRED). ";
        field { name = "hdcp2x_timing_cfg17"; desc = ""; sw = rw; hw = r; reset = 0x0; } hdcp2x_timing_cfg17[7:0];
    } HDCP2X_TIMING_CFG17 @ 0x1E8;
    reg {
        name = "HDCP2X_TIMING_CFG18";
        desc = "HDCP2X_TIMING_CFG18 (offset 0x1EC in this sub-block, absolute 0x1301C1EC). Reset INIT 0x00000000. PROVEN: vendor register header. No call site in the vendor hal/drv C sources: access by register-name convention only (INFERRED). ";
        field { name = "hdcp2x_timing_cfg18"; desc = ""; sw = rw; hw = r; reset = 0x0; } hdcp2x_timing_cfg18[7:0];
    } HDCP2X_TIMING_CFG18 @ 0x1EC;
    reg {
        name = "HDCP2X_TIMING_CFG19";
        desc = "HDCP2X_TIMING_CFG19 (offset 0x1F0 in this sub-block, absolute 0x1301C1F0). Reset INIT 0x00000000. PROVEN: vendor register header. No call site in the vendor hal/drv C sources: access by register-name convention only (INFERRED). ";
        field { name = "hdcp2x_timing_cfg19"; desc = ""; sw = rw; hw = r; reset = 0x0; } hdcp2x_timing_cfg19[7:0];
    } HDCP2X_TIMING_CFG19 @ 0x1F0;
    reg {
        name = "HDCP2X_TIMING_CFG20";
        desc = "HDCP2X_TIMING_CFG20 (offset 0x1F4 in this sub-block, absolute 0x1301C1F4). Reset INIT 0x00000000. PROVEN: vendor register header. No call site in the vendor hal/drv C sources: access by register-name convention only (INFERRED). ";
        field { name = "hdcp2x_timing_cfg20"; desc = ""; sw = rw; hw = r; reset = 0x0; } hdcp2x_timing_cfg20[7:0];
    } HDCP2X_TIMING_CFG20 @ 0x1F4;
    reg {
        name = "HDCP2X_TIMING_CFG21";
        desc = "HDCP2X_TIMING_CFG21 (offset 0x1F8 in this sub-block, absolute 0x1301C1F8). Reset INIT 0x00000000. PROVEN: vendor register header. No call site in the vendor hal/drv C sources: access by register-name convention only (INFERRED). ";
        field { name = "hdcp2x_timing_cfg21"; desc = ""; sw = rw; hw = r; reset = 0x0; } hdcp2x_timing_cfg21[7:0];
    } HDCP2X_TIMING_CFG21 @ 0x1F8;
    reg {
        name = "HDCP2X_TIMING_CFG22";
        desc = "HDCP2X_TIMING_CFG22 (offset 0x1FC in this sub-block, absolute 0x1301C1FC). Reset INIT 0x00000000. PROVEN: vendor register header. No call site in the vendor hal/drv C sources: access by register-name convention only (INFERRED). ";
        field { name = "hdcp2x_timing_cfg22"; desc = ""; sw = rw; hw = r; reset = 0x0; } hdcp2x_timing_cfg22[7:0];
    } HDCP2X_TIMING_CFG22 @ 0x1FC;
    reg {
        name = "HDCP2X_TIMING_CFG23";
        desc = "HDCP2X_TIMING_CFG23 (offset 0x200 in this sub-block, absolute 0x1301C200). Reset INIT 0x00000000. PROVEN: vendor register header. No call site in the vendor hal/drv C sources: access by register-name convention only (INFERRED). ";
        field { name = "hdcp2x_timing_cfg23"; desc = ""; sw = rw; hw = r; reset = 0x0; } hdcp2x_timing_cfg23[7:0];
    } HDCP2X_TIMING_CFG23 @ 0x200;
    reg {
        name = "HDCP2X_TIMING_CFG24";
        desc = "HDCP2X_TIMING_CFG24 (offset 0x204 in this sub-block, absolute 0x1301C204). Reset INIT 0x00000000. PROVEN: vendor register header. No call site in the vendor hal/drv C sources: access by register-name convention only (INFERRED). ";
        field { name = "hdcp2x_timing_cfg24"; desc = ""; sw = rw; hw = r; reset = 0x0; } hdcp2x_timing_cfg24[7:0];
    } HDCP2X_TIMING_CFG24 @ 0x204;
    reg {
        name = "HDCP2X_TIMING_CFG25";
        desc = "HDCP2X_TIMING_CFG25 (offset 0x208 in this sub-block, absolute 0x1301C208). Reset INIT 0x00000000. PROVEN: vendor register header. No call site in the vendor hal/drv C sources: access by register-name convention only (INFERRED). ";
        field { name = "hdcp2x_timing_cfg25"; desc = ""; sw = rw; hw = r; reset = 0x0; } hdcp2x_timing_cfg25[7:0];
    } HDCP2X_TIMING_CFG25 @ 0x208;
    reg {
        name = "HDCP2X_TIMING_CFG26";
        desc = "HDCP2X_TIMING_CFG26 (offset 0x20C in this sub-block, absolute 0x1301C20C). Reset INIT 0x00000000. PROVEN: vendor register header. No call site in the vendor hal/drv C sources: access by register-name convention only (INFERRED). ";
        field { name = "hdcp2x_timing_cfg26"; desc = ""; sw = rw; hw = r; reset = 0x0; } hdcp2x_timing_cfg26[7:0];
    } HDCP2X_TIMING_CFG26 @ 0x20C;
    reg {
        name = "HDCP2X_TIMING_CFG27";
        desc = "HDCP2X_TIMING_CFG27 (offset 0x210 in this sub-block, absolute 0x1301C210). Reset INIT 0x00000000. PROVEN: vendor register header. No call site in the vendor hal/drv C sources: access by register-name convention only (INFERRED). ";
        field { name = "hdcp2x_timing_cfg27"; desc = ""; sw = rw; hw = r; reset = 0x0; } hdcp2x_timing_cfg27[7:0];
    } HDCP2X_TIMING_CFG27 @ 0x210;
    reg {
        name = "HDCP2X_TIMING_CFG28";
        desc = "HDCP2X_TIMING_CFG28 (offset 0x214 in this sub-block, absolute 0x1301C214). Reset INIT 0x00000000. PROVEN: vendor register header. No call site in the vendor hal/drv C sources: access by register-name convention only (INFERRED). ";
        field { name = "hdcp2x_timing_cfg28"; desc = ""; sw = rw; hw = r; reset = 0x0; } hdcp2x_timing_cfg28[7:0];
    } HDCP2X_TIMING_CFG28 @ 0x214;
    reg {
        name = "HDCP2X_TIMING_CFG29";
        desc = "HDCP2X_TIMING_CFG29 (offset 0x218 in this sub-block, absolute 0x1301C218). Reset INIT 0x00000000. PROVEN: vendor register header. No call site in the vendor hal/drv C sources: access by register-name convention only (INFERRED). ";
        field { name = "hdcp2x_timing_cfg29"; desc = ""; sw = rw; hw = r; reset = 0x0; } hdcp2x_timing_cfg29[7:0];
    } HDCP2X_TIMING_CFG29 @ 0x218;
    reg {
        name = "HDCP2X_TIMING_CFG30";
        desc = "HDCP2X_TIMING_CFG30 (offset 0x21C in this sub-block, absolute 0x1301C21C). Reset INIT 0x00000000. PROVEN: vendor register header. No call site in the vendor hal/drv C sources: access by register-name convention only (INFERRED). ";
        field { name = "hdcp2x_timing_cfg30"; desc = ""; sw = rw; hw = r; reset = 0x0; } hdcp2x_timing_cfg30[7:0];
    } HDCP2X_TIMING_CFG30 @ 0x21C;
    reg {
        name = "HDCP2X_TIMING_CFG31";
        desc = "HDCP2X_TIMING_CFG31 (offset 0x220 in this sub-block, absolute 0x1301C220). Reset INIT 0x00000000. PROVEN: vendor register header. No call site in the vendor hal/drv C sources: access by register-name convention only (INFERRED). ";
        field { name = "hdcp2x_timing_cfg31"; desc = ""; sw = rw; hw = r; reset = 0x0; } hdcp2x_timing_cfg31[7:0];
    } HDCP2X_TIMING_CFG31 @ 0x220;
    reg {
        name = "HDCP2X_GEN_IN0";
        desc = "HDCP2X_GEN_IN0 (offset 0x224 in this sub-block, absolute 0x1301C224). Reset INIT 0x00000000. PROVEN: vendor register header. No call site in the vendor hal/drv C sources: access by register-name convention only (INFERRED). ";
        field { name = "hdcp2x_gen_in0"; desc = ""; sw = rw; hw = r; reset = 0x0; } hdcp2x_gen_in0[7:0];
    } HDCP2X_GEN_IN0 @ 0x224;
    reg {
        name = "HDCP2X_GEN_IN1";
        desc = "HDCP2X_GEN_IN1 (offset 0x228 in this sub-block, absolute 0x1301C228). Reset INIT 0x00000000. PROVEN: vendor register header. No call site in the vendor hal/drv C sources: access by register-name convention only (INFERRED). ";
        field { name = "hdcp2x_gen_in1"; desc = ""; sw = rw; hw = r; reset = 0x0; } hdcp2x_gen_in1[7:0];
    } HDCP2X_GEN_IN1 @ 0x228;
    reg {
        name = "HDCP2X_GEN_IN2";
        desc = "HDCP2X_GEN_IN2 (offset 0x22C in this sub-block, absolute 0x1301C22C). Reset INIT 0x00000000. PROVEN: vendor register header. No call site in the vendor hal/drv C sources: access by register-name convention only (INFERRED). ";
        field { name = "hdcp2x_gen_in2"; desc = ""; sw = rw; hw = r; reset = 0x0; } hdcp2x_gen_in2[7:0];
    } HDCP2X_GEN_IN2 @ 0x22C;
    reg {
        name = "HDCP2X_GEN_IN3";
        desc = "HDCP2X_GEN_IN3 (offset 0x230 in this sub-block, absolute 0x1301C230). Reset INIT 0x00000000. PROVEN: vendor register header. No call site in the vendor hal/drv C sources: access by register-name convention only (INFERRED). ";
        field { name = "hdcp2x_gen_in3"; desc = ""; sw = rw; hw = r; reset = 0x0; } hdcp2x_gen_in3[7:0];
    } HDCP2X_GEN_IN3 @ 0x230;
    reg {
        name = "HDCP2X_GEN_IN4";
        desc = "HDCP2X_GEN_IN4 (offset 0x234 in this sub-block, absolute 0x1301C234). Reset INIT 0x00000000. PROVEN: vendor register header. No call site in the vendor hal/drv C sources: access by register-name convention only (INFERRED). ";
        field { name = "hdcp2x_gen_in4"; desc = ""; sw = rw; hw = r; reset = 0x0; } hdcp2x_gen_in4[7:0];
    } HDCP2X_GEN_IN4 @ 0x234;
    reg {
        name = "HDCP2X_GEN_IN5";
        desc = "HDCP2X_GEN_IN5 (offset 0x238 in this sub-block, absolute 0x1301C238). Reset INIT 0x00000000. PROVEN: vendor register header. No call site in the vendor hal/drv C sources: access by register-name convention only (INFERRED). ";
        field { name = "hdcp2x_gen_in5"; desc = ""; sw = rw; hw = r; reset = 0x0; } hdcp2x_gen_in5[7:0];
    } HDCP2X_GEN_IN5 @ 0x238;
    reg {
        name = "HDCP2X_GEN_IN6";
        desc = "HDCP2X_GEN_IN6 (offset 0x23C in this sub-block, absolute 0x1301C23C). Reset INIT 0x00000000. PROVEN: vendor register header. No call site in the vendor hal/drv C sources: access by register-name convention only (INFERRED). ";
        field { name = "hdcp2x_gen_in6"; desc = ""; sw = rw; hw = r; reset = 0x0; } hdcp2x_gen_in6[7:0];
    } HDCP2X_GEN_IN6 @ 0x23C;
    reg {
        name = "HDCP2X_GEN_IN7";
        desc = "HDCP2X_GEN_IN7 (offset 0x240 in this sub-block, absolute 0x1301C240). Reset INIT 0x00000000. PROVEN: vendor register header. No call site in the vendor hal/drv C sources: access by register-name convention only (INFERRED). ";
        field { name = "hdcp2x_gen_in7"; desc = ""; sw = rw; hw = r; reset = 0x0; } hdcp2x_gen_in7[7:0];
    } HDCP2X_GEN_IN7 @ 0x240;
    reg {
        name = "HDCP2X_GEN_IN8";
        desc = "HDCP2X_GEN_IN8 (offset 0x244 in this sub-block, absolute 0x1301C244). Reset INIT 0x00000000. PROVEN: vendor register header. No call site in the vendor hal/drv C sources: access by register-name convention only (INFERRED). ";
        field { name = "hdcp2x_gen_in8"; desc = ""; sw = rw; hw = r; reset = 0x0; } hdcp2x_gen_in8[7:0];
    } HDCP2X_GEN_IN8 @ 0x244;
    reg {
        name = "HDCP2X_GEN_IN9";
        desc = "HDCP2X_GEN_IN9 (offset 0x248 in this sub-block, absolute 0x1301C248). Reset INIT 0x00000000. PROVEN: vendor register header. No call site in the vendor hal/drv C sources: access by register-name convention only (INFERRED). ";
        field { name = "hdcp2x_gen_in9"; desc = ""; sw = rw; hw = r; reset = 0x0; } hdcp2x_gen_in9[7:0];
    } HDCP2X_GEN_IN9 @ 0x248;
    reg {
        name = "HDCP2X_GEN_IN10";
        desc = "HDCP2X_GEN_IN10 (offset 0x24C in this sub-block, absolute 0x1301C24C). Reset INIT 0x00000000. PROVEN: vendor register header. No call site in the vendor hal/drv C sources: access by register-name convention only (INFERRED). ";
        field { name = "hdcp2x_gen_in10"; desc = ""; sw = rw; hw = r; reset = 0x0; } hdcp2x_gen_in10[7:0];
    } HDCP2X_GEN_IN10 @ 0x24C;
    reg {
        name = "HDCP2X_GEN_IN11";
        desc = "HDCP2X_GEN_IN11 (offset 0x250 in this sub-block, absolute 0x1301C250). Reset INIT 0x00000000. PROVEN: vendor register header. No call site in the vendor hal/drv C sources: access by register-name convention only (INFERRED). ";
        field { name = "hdcp2x_gen_in11"; desc = ""; sw = rw; hw = r; reset = 0x0; } hdcp2x_gen_in11[7:0];
    } HDCP2X_GEN_IN11 @ 0x250;
    reg {
        name = "HDCP2X_GEN_IN12";
        desc = "HDCP2X_GEN_IN12 (offset 0x254 in this sub-block, absolute 0x1301C254). Reset INIT 0x00000000. PROVEN: vendor register header. No call site in the vendor hal/drv C sources: access by register-name convention only (INFERRED). ";
        field { name = "hdcp2x_gen_in12"; desc = ""; sw = rw; hw = r; reset = 0x0; } hdcp2x_gen_in12[7:0];
    } HDCP2X_GEN_IN12 @ 0x254;
    reg {
        name = "HDCP2X_GEN_IN13";
        desc = "HDCP2X_GEN_IN13 (offset 0x258 in this sub-block, absolute 0x1301C258). Reset INIT 0x00000000. PROVEN: vendor register header. No call site in the vendor hal/drv C sources: access by register-name convention only (INFERRED). ";
        field { name = "hdcp2x_gen_in13"; desc = ""; sw = rw; hw = r; reset = 0x0; } hdcp2x_gen_in13[7:0];
    } HDCP2X_GEN_IN13 @ 0x258;
    reg {
        name = "HDCP2X_GEN_IN14";
        desc = "HDCP2X_GEN_IN14 (offset 0x25C in this sub-block, absolute 0x1301C25C). Reset INIT 0x00000000. PROVEN: vendor register header. No call site in the vendor hal/drv C sources: access by register-name convention only (INFERRED). ";
        field { name = "hdcp2x_gen_in14"; desc = ""; sw = rw; hw = r; reset = 0x0; } hdcp2x_gen_in14[7:0];
    } HDCP2X_GEN_IN14 @ 0x25C;
    reg {
        name = "HDCP2X_GEN_IN15";
        desc = "HDCP2X_GEN_IN15 (offset 0x260 in this sub-block, absolute 0x1301C260). Reset INIT 0x00000000. PROVEN: vendor register header. No call site in the vendor hal/drv C sources: access by register-name convention only (INFERRED). ";
        field { name = "hdcp2x_gen_in15"; desc = ""; sw = rw; hw = r; reset = 0x0; } hdcp2x_gen_in15[7:0];
    } HDCP2X_GEN_IN15 @ 0x260;
    reg {
        name = "HDCP2X_GEN_IN16";
        desc = "HDCP2X_GEN_IN16 (offset 0x264 in this sub-block, absolute 0x1301C264). Reset INIT 0x000000FF. PROVEN: vendor register header. No call site in the vendor hal/drv C sources: access by register-name convention only (INFERRED). ";
        field { name = "hdcp2x_gen_in16"; desc = ""; sw = rw; hw = r; reset = 0xFF; } hdcp2x_gen_in16[7:0];
    } HDCP2X_GEN_IN16 @ 0x264;
    reg {
        name = "HDCP2X_GEN_IN17";
        desc = "HDCP2X_GEN_IN17 (offset 0x268 in this sub-block, absolute 0x1301C268). Reset INIT 0x000000FF. PROVEN: vendor register header. No call site in the vendor hal/drv C sources: access by register-name convention only (INFERRED). ";
        field { name = "hdcp2x_gen_in17"; desc = ""; sw = rw; hw = r; reset = 0xFF; } hdcp2x_gen_in17[7:0];
    } HDCP2X_GEN_IN17 @ 0x268;
    reg {
        name = "HDCP2X_GEN_IN18";
        desc = "HDCP2X_GEN_IN18 (offset 0x26C in this sub-block, absolute 0x1301C26C). Reset INIT 0x000000FF. PROVEN: vendor register header. No call site in the vendor hal/drv C sources: access by register-name convention only (INFERRED). ";
        field { name = "hdcp2x_gen_in18"; desc = ""; sw = rw; hw = r; reset = 0xFF; } hdcp2x_gen_in18[7:0];
    } HDCP2X_GEN_IN18 @ 0x26C;
    reg {
        name = "HDCP2X_GEN_IN19";
        desc = "HDCP2X_GEN_IN19 (offset 0x270 in this sub-block, absolute 0x1301C270). Reset INIT 0x000000FF. PROVEN: vendor register header. No call site in the vendor hal/drv C sources: access by register-name convention only (INFERRED). ";
        field { name = "hdcp2x_gen_in19"; desc = ""; sw = rw; hw = r; reset = 0xFF; } hdcp2x_gen_in19[7:0];
    } HDCP2X_GEN_IN19 @ 0x270;
    reg {
        name = "HDCP2X_GEN_IN20";
        desc = "HDCP2X_GEN_IN20 (offset 0x274 in this sub-block, absolute 0x1301C274). Reset INIT 0x000000FF. PROVEN: vendor register header. No call site in the vendor hal/drv C sources: access by register-name convention only (INFERRED). ";
        field { name = "hdcp2x_gen_in20"; desc = ""; sw = rw; hw = r; reset = 0xFF; } hdcp2x_gen_in20[7:0];
    } HDCP2X_GEN_IN20 @ 0x274;
    reg {
        name = "HDCP2X_GEN_IN21";
        desc = "HDCP2X_GEN_IN21 (offset 0x278 in this sub-block, absolute 0x1301C278). Reset INIT 0x000000FF. PROVEN: vendor register header. No call site in the vendor hal/drv C sources: access by register-name convention only (INFERRED). ";
        field { name = "hdcp2x_gen_in21"; desc = ""; sw = rw; hw = r; reset = 0xFF; } hdcp2x_gen_in21[7:0];
    } HDCP2X_GEN_IN21 @ 0x278;
    reg {
        name = "HDCP2X_GEN_IN22";
        desc = "HDCP2X_GEN_IN22 (offset 0x27C in this sub-block, absolute 0x1301C27C). Reset INIT 0x000000FF. PROVEN: vendor register header. No call site in the vendor hal/drv C sources: access by register-name convention only (INFERRED). ";
        field { name = "hdcp2x_gen_in22"; desc = ""; sw = rw; hw = r; reset = 0xFF; } hdcp2x_gen_in22[7:0];
    } HDCP2X_GEN_IN22 @ 0x27C;
    reg {
        name = "HDCP2X_GEN_IN23";
        desc = "HDCP2X_GEN_IN23 (offset 0x280 in this sub-block, absolute 0x1301C280). Reset INIT 0x000000FF. PROVEN: vendor register header. No call site in the vendor hal/drv C sources: access by register-name convention only (INFERRED). ";
        field { name = "hdcp2x_gen_in23"; desc = ""; sw = rw; hw = r; reset = 0xFF; } hdcp2x_gen_in23[7:0];
    } HDCP2X_GEN_IN23 @ 0x280;
    reg {
        name = "HDCP2X_GEN_IN24";
        desc = "HDCP2X_GEN_IN24 (offset 0x284 in this sub-block, absolute 0x1301C284). Reset INIT 0x00000000. PROVEN: vendor register header. No call site in the vendor hal/drv C sources: access by register-name convention only (INFERRED). ";
        field { name = "hdcp2x_gen_in24"; desc = ""; sw = rw; hw = r; reset = 0x0; } hdcp2x_gen_in24[7:0];
    } HDCP2X_GEN_IN24 @ 0x284;
    reg {
        name = "HDCP2X_GEN_IN25";
        desc = "HDCP2X_GEN_IN25 (offset 0x288 in this sub-block, absolute 0x1301C288). Reset INIT 0x00000000. PROVEN: vendor register header. No call site in the vendor hal/drv C sources: access by register-name convention only (INFERRED). ";
        field { name = "hdcp2x_gen_in25"; desc = ""; sw = rw; hw = r; reset = 0x0; } hdcp2x_gen_in25[7:0];
    } HDCP2X_GEN_IN25 @ 0x288;
    reg {
        name = "HDCP2X_GEN_IN26";
        desc = "HDCP2X_GEN_IN26 (offset 0x28C in this sub-block, absolute 0x1301C28C). Reset INIT 0x00000000. PROVEN: vendor register header. No call site in the vendor hal/drv C sources: access by register-name convention only (INFERRED). ";
        field { name = "hdcp2x_gen_in26"; desc = ""; sw = rw; hw = r; reset = 0x0; } hdcp2x_gen_in26[7:0];
    } HDCP2X_GEN_IN26 @ 0x28C;
    reg {
        name = "HDCP2X_GEN_IN27";
        desc = "HDCP2X_GEN_IN27 (offset 0x290 in this sub-block, absolute 0x1301C290). Reset INIT 0x00000000. PROVEN: vendor register header. No call site in the vendor hal/drv C sources: access by register-name convention only (INFERRED). ";
        field { name = "hdcp2x_gen_in27"; desc = ""; sw = rw; hw = r; reset = 0x0; } hdcp2x_gen_in27[7:0];
    } HDCP2X_GEN_IN27 @ 0x290;
    reg {
        name = "HDCP2X_GEN_IN28";
        desc = "HDCP2X_GEN_IN28 (offset 0x294 in this sub-block, absolute 0x1301C294). Reset INIT 0x00000000. PROVEN: vendor register header. No call site in the vendor hal/drv C sources: access by register-name convention only (INFERRED). ";
        field { name = "hdcp2x_gen_in28"; desc = ""; sw = rw; hw = r; reset = 0x0; } hdcp2x_gen_in28[7:0];
    } HDCP2X_GEN_IN28 @ 0x294;
    reg {
        name = "HDCP2X_GEN_IN29";
        desc = "HDCP2X_GEN_IN29 (offset 0x298 in this sub-block, absolute 0x1301C298). Reset INIT 0x00000000. PROVEN: vendor register header. No call site in the vendor hal/drv C sources: access by register-name convention only (INFERRED). ";
        field { name = "hdcp2x_gen_in29"; desc = ""; sw = rw; hw = r; reset = 0x0; } hdcp2x_gen_in29[7:0];
    } HDCP2X_GEN_IN29 @ 0x298;
    reg {
        name = "HDCP2X_GEN_IN30";
        desc = "HDCP2X_GEN_IN30 (offset 0x29C in this sub-block, absolute 0x1301C29C). Reset INIT 0x00000000. PROVEN: vendor register header. No call site in the vendor hal/drv C sources: access by register-name convention only (INFERRED). ";
        field { name = "hdcp2x_gen_in30"; desc = ""; sw = rw; hw = r; reset = 0x0; } hdcp2x_gen_in30[7:0];
    } HDCP2X_GEN_IN30 @ 0x29C;
    reg {
        name = "HDCP2X_GEN_IN31";
        desc = "HDCP2X_GEN_IN31 (offset 0x2A0 in this sub-block, absolute 0x1301C2A0). Reset INIT 0x00000000. PROVEN: vendor register header. No call site in the vendor hal/drv C sources: access by register-name convention only (INFERRED). ";
        field { name = "hdcp2x_gen_in31"; desc = ""; sw = rw; hw = r; reset = 0x0; } hdcp2x_gen_in31[7:0];
    } HDCP2X_GEN_IN31 @ 0x2A0;
    reg {
        name = "HDCP2X_GEN_OUT0";
        desc = "HDCP2X_GEN_OUT0 (offset 0x2A4 in this sub-block, absolute 0x1301C2A4). Reset INIT 0x00000000. PROVEN: vendor register header. No call site in the vendor hal/drv C sources: access by register-name convention only (INFERRED). ";
        field { name = "hdcp2x_gen_out0"; desc = ""; sw = r; hw = w; reset = 0x0; } hdcp2x_gen_out0[7:0];
    } HDCP2X_GEN_OUT0 @ 0x2A4;
    reg {
        name = "HDCP2X_GEN_OUT1";
        desc = "HDCP2X_GEN_OUT1 (offset 0x2A8 in this sub-block, absolute 0x1301C2A8). Reset INIT 0x00000000. PROVEN: vendor register header. No call site in the vendor hal/drv C sources: access by register-name convention only (INFERRED). ";
        field { name = "hdcp2x_gen_out1"; desc = ""; sw = r; hw = w; reset = 0x0; } hdcp2x_gen_out1[7:0];
    } HDCP2X_GEN_OUT1 @ 0x2A8;
    reg {
        name = "HDCP2X_GEN_OUT2";
        desc = "HDCP2X_GEN_OUT2 (offset 0x2AC in this sub-block, absolute 0x1301C2AC). Reset INIT 0x00000000. PROVEN: vendor register header. No call site in the vendor hal/drv C sources: access by register-name convention only (INFERRED). ";
        field { name = "hdcp2x_gen_out2"; desc = ""; sw = r; hw = w; reset = 0x0; } hdcp2x_gen_out2[7:0];
    } HDCP2X_GEN_OUT2 @ 0x2AC;
    reg {
        name = "HDCP2X_GEN_OUT3";
        desc = "HDCP2X_GEN_OUT3 (offset 0x2B0 in this sub-block, absolute 0x1301C2B0). Reset INIT 0x00000000. PROVEN: vendor register header. No call site in the vendor hal/drv C sources: access by register-name convention only (INFERRED). ";
        field { name = "hdcp2x_gen_out3"; desc = ""; sw = r; hw = w; reset = 0x0; } hdcp2x_gen_out3[7:0];
    } HDCP2X_GEN_OUT3 @ 0x2B0;
    reg {
        name = "HDCP2X_GEN_OUT4";
        desc = "HDCP2X_GEN_OUT4 (offset 0x2B4 in this sub-block, absolute 0x1301C2B4). Reset INIT 0x00000000. PROVEN: vendor register header. No call site in the vendor hal/drv C sources: access by register-name convention only (INFERRED). ";
        field { name = "hdcp2x_gen_out4"; desc = ""; sw = r; hw = w; reset = 0x0; } hdcp2x_gen_out4[7:0];
    } HDCP2X_GEN_OUT4 @ 0x2B4;
    reg {
        name = "HDCP2X_GEN_OUT5";
        desc = "HDCP2X_GEN_OUT5 (offset 0x2B8 in this sub-block, absolute 0x1301C2B8). Reset INIT 0x00000000. PROVEN: vendor register header. No call site in the vendor hal/drv C sources: access by register-name convention only (INFERRED). ";
        field { name = "hdcp2x_gen_out5"; desc = ""; sw = r; hw = w; reset = 0x0; } hdcp2x_gen_out5[7:0];
    } HDCP2X_GEN_OUT5 @ 0x2B8;
    reg {
        name = "HDCP2X_GEN_OUT6";
        desc = "HDCP2X_GEN_OUT6 (offset 0x2BC in this sub-block, absolute 0x1301C2BC). Reset INIT 0x00000000. PROVEN: vendor register header. No call site in the vendor hal/drv C sources: access by register-name convention only (INFERRED). ";
        field { name = "hdcp2x_gen_out6"; desc = ""; sw = r; hw = w; reset = 0x0; } hdcp2x_gen_out6[7:0];
    } HDCP2X_GEN_OUT6 @ 0x2BC;
    reg {
        name = "HDCP2X_GEN_OUT7";
        desc = "HDCP2X_GEN_OUT7 (offset 0x2C0 in this sub-block, absolute 0x1301C2C0). Reset INIT 0x00000000. PROVEN: vendor register header. No call site in the vendor hal/drv C sources: access by register-name convention only (INFERRED). ";
        field { name = "hdcp2x_gen_out7"; desc = ""; sw = r; hw = w; reset = 0x0; } hdcp2x_gen_out7[7:0];
    } HDCP2X_GEN_OUT7 @ 0x2C0;
    reg {
        name = "HDCP2X_GEN_OUT8";
        desc = "HDCP2X_GEN_OUT8 (offset 0x2C4 in this sub-block, absolute 0x1301C2C4). Reset INIT 0x00000000. PROVEN: vendor register header. No call site in the vendor hal/drv C sources: access by register-name convention only (INFERRED). ";
        field { name = "hdcp2x_gen_out8"; desc = ""; sw = r; hw = w; reset = 0x0; } hdcp2x_gen_out8[7:0];
    } HDCP2X_GEN_OUT8 @ 0x2C4;
    reg {
        name = "HDCP2X_GEN_OUT9";
        desc = "HDCP2X_GEN_OUT9 (offset 0x2C8 in this sub-block, absolute 0x1301C2C8). Reset INIT 0x00000000. PROVEN: vendor register header. No call site in the vendor hal/drv C sources: access by register-name convention only (INFERRED). ";
        field { name = "hdcp2x_gen_out9"; desc = ""; sw = r; hw = w; reset = 0x0; } hdcp2x_gen_out9[7:0];
    } HDCP2X_GEN_OUT9 @ 0x2C8;
    reg {
        name = "HDCP2X_GEN_OUT10";
        desc = "HDCP2X_GEN_OUT10 (offset 0x2CC in this sub-block, absolute 0x1301C2CC). Reset INIT 0x00000000. PROVEN: vendor register header. No call site in the vendor hal/drv C sources: access by register-name convention only (INFERRED). ";
        field { name = "hdcp2x_gen_out10"; desc = ""; sw = r; hw = w; reset = 0x0; } hdcp2x_gen_out10[7:0];
    } HDCP2X_GEN_OUT10 @ 0x2CC;
    reg {
        name = "HDCP2X_GEN_OUT11";
        desc = "HDCP2X_GEN_OUT11 (offset 0x2D0 in this sub-block, absolute 0x1301C2D0). Reset INIT 0x00000000. PROVEN: vendor register header. No call site in the vendor hal/drv C sources: access by register-name convention only (INFERRED). ";
        field { name = "hdcp2x_gen_out11"; desc = ""; sw = r; hw = w; reset = 0x0; } hdcp2x_gen_out11[7:0];
    } HDCP2X_GEN_OUT11 @ 0x2D0;
    reg {
        name = "HDCP2X_GEN_OUT12";
        desc = "HDCP2X_GEN_OUT12 (offset 0x2D4 in this sub-block, absolute 0x1301C2D4). Reset INIT 0x00000000. PROVEN: vendor register header. No call site in the vendor hal/drv C sources: access by register-name convention only (INFERRED). ";
        field { name = "hdcp2x_gen_out12"; desc = ""; sw = r; hw = w; reset = 0x0; } hdcp2x_gen_out12[7:0];
    } HDCP2X_GEN_OUT12 @ 0x2D4;
    reg {
        name = "HDCP2X_GEN_OUT13";
        desc = "HDCP2X_GEN_OUT13 (offset 0x2D8 in this sub-block, absolute 0x1301C2D8). Reset INIT 0x00000000. PROVEN: vendor register header. No call site in the vendor hal/drv C sources: access by register-name convention only (INFERRED). ";
        field { name = "hdcp2x_gen_out13"; desc = ""; sw = r; hw = w; reset = 0x0; } hdcp2x_gen_out13[7:0];
    } HDCP2X_GEN_OUT13 @ 0x2D8;
    reg {
        name = "HDCP2X_GEN_OUT14";
        desc = "HDCP2X_GEN_OUT14 (offset 0x2DC in this sub-block, absolute 0x1301C2DC). Reset INIT 0x00000000. PROVEN: vendor register header. No call site in the vendor hal/drv C sources: access by register-name convention only (INFERRED). ";
        field { name = "hdcp2x_gen_out14"; desc = ""; sw = r; hw = w; reset = 0x0; } hdcp2x_gen_out14[7:0];
    } HDCP2X_GEN_OUT14 @ 0x2DC;
    reg {
        name = "HDCP2X_GEN_OUT15";
        desc = "HDCP2X_GEN_OUT15 (offset 0x2E0 in this sub-block, absolute 0x1301C2E0). Reset INIT 0x00000000. PROVEN: vendor register header. No call site in the vendor hal/drv C sources: access by register-name convention only (INFERRED). ";
        field { name = "hdcp2x_gen_out15"; desc = ""; sw = r; hw = w; reset = 0x0; } hdcp2x_gen_out15[7:0];
    } HDCP2X_GEN_OUT15 @ 0x2E0;
    reg {
        name = "HDCP2X_GEN_OUT16";
        desc = "HDCP2X_GEN_OUT16 (offset 0x2E4 in this sub-block, absolute 0x1301C2E4). Reset INIT 0x000000FF. PROVEN: vendor register header. No call site in the vendor hal/drv C sources: access by register-name convention only (INFERRED). ";
        field { name = "hdcp2x_gen_out16"; desc = ""; sw = r; hw = w; reset = 0xFF; } hdcp2x_gen_out16[7:0];
    } HDCP2X_GEN_OUT16 @ 0x2E4;
    reg {
        name = "HDCP2X_GEN_OUT17";
        desc = "HDCP2X_GEN_OUT17 (offset 0x2E8 in this sub-block, absolute 0x1301C2E8). Reset INIT 0x000000FF. PROVEN: vendor register header. No call site in the vendor hal/drv C sources: access by register-name convention only (INFERRED). ";
        field { name = "hdcp2x_gen_out17"; desc = ""; sw = r; hw = w; reset = 0xFF; } hdcp2x_gen_out17[7:0];
    } HDCP2X_GEN_OUT17 @ 0x2E8;
    reg {
        name = "HDCP2X_GEN_OUT18";
        desc = "HDCP2X_GEN_OUT18 (offset 0x2EC in this sub-block, absolute 0x1301C2EC). Reset INIT 0x000000FF. PROVEN: vendor register header. No call site in the vendor hal/drv C sources: access by register-name convention only (INFERRED). ";
        field { name = "hdcp2x_gen_out18"; desc = ""; sw = r; hw = w; reset = 0xFF; } hdcp2x_gen_out18[7:0];
    } HDCP2X_GEN_OUT18 @ 0x2EC;
    reg {
        name = "HDCP2X_GEN_OUT19";
        desc = "HDCP2X_GEN_OUT19 (offset 0x2F0 in this sub-block, absolute 0x1301C2F0). Reset INIT 0x000000FF. PROVEN: vendor register header. No call site in the vendor hal/drv C sources: access by register-name convention only (INFERRED). ";
        field { name = "hdcp2x_gen_out19"; desc = ""; sw = r; hw = w; reset = 0xFF; } hdcp2x_gen_out19[7:0];
    } HDCP2X_GEN_OUT19 @ 0x2F0;
    reg {
        name = "HDCP2X_GEN_OUT20";
        desc = "HDCP2X_GEN_OUT20 (offset 0x2F4 in this sub-block, absolute 0x1301C2F4). Reset INIT 0x000000FF. PROVEN: vendor register header. No call site in the vendor hal/drv C sources: access by register-name convention only (INFERRED). ";
        field { name = "hdcp2x_gen_out20"; desc = ""; sw = r; hw = w; reset = 0xFF; } hdcp2x_gen_out20[7:0];
    } HDCP2X_GEN_OUT20 @ 0x2F4;
    reg {
        name = "HDCP2X_GEN_OUT21";
        desc = "HDCP2X_GEN_OUT21 (offset 0x2F8 in this sub-block, absolute 0x1301C2F8). Reset INIT 0x000000FF. PROVEN: vendor register header. No call site in the vendor hal/drv C sources: access by register-name convention only (INFERRED). ";
        field { name = "hdcp2x_gen_out21"; desc = ""; sw = r; hw = w; reset = 0xFF; } hdcp2x_gen_out21[7:0];
    } HDCP2X_GEN_OUT21 @ 0x2F8;
    reg {
        name = "HDCP2X_GEN_OUT22";
        desc = "HDCP2X_GEN_OUT22 (offset 0x2FC in this sub-block, absolute 0x1301C2FC). Reset INIT 0x000000FF. PROVEN: vendor register header. No call site in the vendor hal/drv C sources: access by register-name convention only (INFERRED). ";
        field { name = "hdcp2x_gen_out22"; desc = ""; sw = r; hw = w; reset = 0xFF; } hdcp2x_gen_out22[7:0];
    } HDCP2X_GEN_OUT22 @ 0x2FC;
    reg {
        name = "HDCP2X_GEN_OUT23";
        desc = "HDCP2X_GEN_OUT23 (offset 0x300 in this sub-block, absolute 0x1301C300). Reset INIT 0x000000FF. PROVEN: vendor register header. No call site in the vendor hal/drv C sources: access by register-name convention only (INFERRED). ";
        field { name = "hdcp2x_gen_out23"; desc = ""; sw = r; hw = w; reset = 0xFF; } hdcp2x_gen_out23[7:0];
    } HDCP2X_GEN_OUT23 @ 0x300;
    reg {
        name = "HDCP2X_GEN_OUT24";
        desc = "HDCP2X_GEN_OUT24 (offset 0x304 in this sub-block, absolute 0x1301C304). Reset INIT 0x00000000. PROVEN: vendor register header. No call site in the vendor hal/drv C sources: access by register-name convention only (INFERRED). ";
        field { name = "hdcp2x_gen_out24"; desc = ""; sw = r; hw = w; reset = 0x0; } hdcp2x_gen_out24[7:0];
    } HDCP2X_GEN_OUT24 @ 0x304;
    reg {
        name = "HDCP2X_GEN_OUT25";
        desc = "HDCP2X_GEN_OUT25 (offset 0x308 in this sub-block, absolute 0x1301C308). Reset INIT 0x00000000. PROVEN: vendor register header. No call site in the vendor hal/drv C sources: access by register-name convention only (INFERRED). ";
        field { name = "hdcp2x_gen_out25"; desc = ""; sw = r; hw = w; reset = 0x0; } hdcp2x_gen_out25[7:0];
    } HDCP2X_GEN_OUT25 @ 0x308;
    reg {
        name = "HDCP2X_GEN_OUT26";
        desc = "HDCP2X_GEN_OUT26 (offset 0x30C in this sub-block, absolute 0x1301C30C). Reset INIT 0x00000000. PROVEN: vendor register header. No call site in the vendor hal/drv C sources: access by register-name convention only (INFERRED). ";
        field { name = "hdcp2x_gen_out26"; desc = ""; sw = r; hw = w; reset = 0x0; } hdcp2x_gen_out26[7:0];
    } HDCP2X_GEN_OUT26 @ 0x30C;
    reg {
        name = "HDCP2X_GEN_OUT27";
        desc = "HDCP2X_GEN_OUT27 (offset 0x310 in this sub-block, absolute 0x1301C310). Reset INIT 0x00000000. PROVEN: vendor register header. No call site in the vendor hal/drv C sources: access by register-name convention only (INFERRED). ";
        field { name = "hdcp2x_gen_out27"; desc = ""; sw = r; hw = w; reset = 0x0; } hdcp2x_gen_out27[7:0];
    } HDCP2X_GEN_OUT27 @ 0x310;
    reg {
        name = "HDCP2X_GEN_OUT28";
        desc = "HDCP2X_GEN_OUT28 (offset 0x314 in this sub-block, absolute 0x1301C314). Reset INIT 0x00000000. PROVEN: vendor register header. No call site in the vendor hal/drv C sources: access by register-name convention only (INFERRED). ";
        field { name = "hdcp2x_gen_out28"; desc = ""; sw = r; hw = w; reset = 0x0; } hdcp2x_gen_out28[7:0];
    } HDCP2X_GEN_OUT28 @ 0x314;
    reg {
        name = "HDCP2X_GEN_OUT29";
        desc = "HDCP2X_GEN_OUT29 (offset 0x318 in this sub-block, absolute 0x1301C318). Reset INIT 0x00000000. PROVEN: vendor register header. No call site in the vendor hal/drv C sources: access by register-name convention only (INFERRED). ";
        field { name = "hdcp2x_gen_out29"; desc = ""; sw = r; hw = w; reset = 0x0; } hdcp2x_gen_out29[7:0];
    } HDCP2X_GEN_OUT29 @ 0x318;
    reg {
        name = "HDCP2X_GEN_OUT30";
        desc = "HDCP2X_GEN_OUT30 (offset 0x31C in this sub-block, absolute 0x1301C31C). Reset INIT 0x00000000. PROVEN: vendor register header. No call site in the vendor hal/drv C sources: access by register-name convention only (INFERRED). ";
        field { name = "hdcp2x_gen_out30"; desc = ""; sw = r; hw = w; reset = 0x0; } hdcp2x_gen_out30[7:0];
    } HDCP2X_GEN_OUT30 @ 0x31C;
    reg {
        name = "HDCP2X_GEN_OUT31";
        desc = "HDCP2X_GEN_OUT31 (offset 0x320 in this sub-block, absolute 0x1301C320). Reset INIT 0x00000000. PROVEN: vendor register header. No call site in the vendor hal/drv C sources: access by register-name convention only (INFERRED). ";
        field { name = "hdcp2x_gen_out31"; desc = ""; sw = r; hw = w; reset = 0x0; } hdcp2x_gen_out31[7:0];
    } HDCP2X_GEN_OUT31 @ 0x320;
    reg {
        name = "HDCP2X_SEC_IN0";
        desc = "HDCP2X_SEC_IN0 (offset 0x380 in this sub-block, absolute 0x1301C380). Reset INIT 0x00000000. PROVEN: vendor register header. No call site in the vendor hal/drv C sources: access by register-name convention only (INFERRED). ";
        field { name = "hdcp2x_sec_in0"; desc = ""; sw = rw; hw = r; reset = 0x0; } hdcp2x_sec_in0[7:0];
    } HDCP2X_SEC_IN0 @ 0x380;
    reg {
        name = "HDCP2X_SEC_IN1";
        desc = "HDCP2X_SEC_IN1 (offset 0x384 in this sub-block, absolute 0x1301C384). Reset INIT 0x00000000. PROVEN: vendor register header. No call site in the vendor hal/drv C sources: access by register-name convention only (INFERRED). ";
        field { name = "hdcp2x_sec_in1"; desc = ""; sw = rw; hw = r; reset = 0x0; } hdcp2x_sec_in1[7:0];
    } HDCP2X_SEC_IN1 @ 0x384;
    reg {
        name = "HDCP2X_SEC_IN2";
        desc = "HDCP2X_SEC_IN2 (offset 0x388 in this sub-block, absolute 0x1301C388). Reset INIT 0x00000000. PROVEN: vendor register header. No call site in the vendor hal/drv C sources: access by register-name convention only (INFERRED). ";
        field { name = "hdcp2x_sec_in2"; desc = ""; sw = rw; hw = r; reset = 0x0; } hdcp2x_sec_in2[7:0];
    } HDCP2X_SEC_IN2 @ 0x388;
    reg {
        name = "HDCP2X_SEC_IN3";
        desc = "HDCP2X_SEC_IN3 (offset 0x38C in this sub-block, absolute 0x1301C38C). Reset INIT 0x00000000. PROVEN: vendor register header. No call site in the vendor hal/drv C sources: access by register-name convention only (INFERRED). ";
        field { name = "hdcp2x_sec_in3"; desc = ""; sw = rw; hw = r; reset = 0x0; } hdcp2x_sec_in3[7:0];
    } HDCP2X_SEC_IN3 @ 0x38C;
    reg {
        name = "HDCP2X_SEC_IN4";
        desc = "HDCP2X_SEC_IN4 (offset 0x390 in this sub-block, absolute 0x1301C390). Reset INIT 0x00000000. PROVEN: vendor register header. No call site in the vendor hal/drv C sources: access by register-name convention only (INFERRED). ";
        field { name = "hdcp2x_sec_in4"; desc = ""; sw = rw; hw = r; reset = 0x0; } hdcp2x_sec_in4[7:0];
    } HDCP2X_SEC_IN4 @ 0x390;
    reg {
        name = "HDCP2X_SEC_IN5";
        desc = "HDCP2X_SEC_IN5 (offset 0x394 in this sub-block, absolute 0x1301C394). Reset INIT 0x00000000. PROVEN: vendor register header. No call site in the vendor hal/drv C sources: access by register-name convention only (INFERRED). ";
        field { name = "hdcp2x_sec_in5"; desc = ""; sw = rw; hw = r; reset = 0x0; } hdcp2x_sec_in5[7:0];
    } HDCP2X_SEC_IN5 @ 0x394;
    reg {
        name = "HDCP2X_SEC_IN6";
        desc = "HDCP2X_SEC_IN6 (offset 0x398 in this sub-block, absolute 0x1301C398). Reset INIT 0x00000000. PROVEN: vendor register header. No call site in the vendor hal/drv C sources: access by register-name convention only (INFERRED). ";
        field { name = "hdcp2x_sec_in6"; desc = ""; sw = rw; hw = r; reset = 0x0; } hdcp2x_sec_in6[7:0];
    } HDCP2X_SEC_IN6 @ 0x398;
    reg {
        name = "HDCP2X_SEC_IN7";
        desc = "HDCP2X_SEC_IN7 (offset 0x39C in this sub-block, absolute 0x1301C39C). Reset INIT 0x00000000. PROVEN: vendor register header. No call site in the vendor hal/drv C sources: access by register-name convention only (INFERRED). ";
        field { name = "hdcp2x_sec_in7"; desc = ""; sw = rw; hw = r; reset = 0x0; } hdcp2x_sec_in7[7:0];
    } HDCP2X_SEC_IN7 @ 0x39C;
    reg {
        name = "HDCP2X_SEC_OUT0";
        desc = "HDCP2X_SEC_OUT0 (offset 0x3A0 in this sub-block, absolute 0x1301C3A0). Reset INIT 0x00000000. PROVEN: vendor register header. No call site in the vendor hal/drv C sources: access by register-name convention only (INFERRED). ";
        field { name = "hdcp2x_sec_out0"; desc = ""; sw = r; hw = w; reset = 0x0; } hdcp2x_sec_out0[7:0];
    } HDCP2X_SEC_OUT0 @ 0x3A0;
    reg {
        name = "HDCP2X_SEC_OUT1";
        desc = "HDCP2X_SEC_OUT1 (offset 0x3A4 in this sub-block, absolute 0x1301C3A4). Reset INIT 0x00000000. PROVEN: vendor register header. No call site in the vendor hal/drv C sources: access by register-name convention only (INFERRED). ";
        field { name = "hdcp2x_sec_out1"; desc = ""; sw = r; hw = w; reset = 0x0; } hdcp2x_sec_out1[7:0];
    } HDCP2X_SEC_OUT1 @ 0x3A4;
    reg {
        name = "HDCP2X_SEC_OUT2";
        desc = "HDCP2X_SEC_OUT2 (offset 0x3A8 in this sub-block, absolute 0x1301C3A8). Reset INIT 0x00000000. PROVEN: vendor register header. No call site in the vendor hal/drv C sources: access by register-name convention only (INFERRED). ";
        field { name = "hdcp2x_sec_out2"; desc = ""; sw = r; hw = w; reset = 0x0; } hdcp2x_sec_out2[7:0];
    } HDCP2X_SEC_OUT2 @ 0x3A8;
    reg {
        name = "HDCP2X_SEC_OUT3";
        desc = "HDCP2X_SEC_OUT3 (offset 0x3AC in this sub-block, absolute 0x1301C3AC). Reset INIT 0x00000000. PROVEN: vendor register header. No call site in the vendor hal/drv C sources: access by register-name convention only (INFERRED). ";
        field { name = "hdcp2x_sec_out3"; desc = ""; sw = r; hw = w; reset = 0x0; } hdcp2x_sec_out3[7:0];
    } HDCP2X_SEC_OUT3 @ 0x3AC;
    reg {
        name = "HDCP2X_SEC_OUT4";
        desc = "HDCP2X_SEC_OUT4 (offset 0x3B0 in this sub-block, absolute 0x1301C3B0). Reset INIT 0x00000000. PROVEN: vendor register header. No call site in the vendor hal/drv C sources: access by register-name convention only (INFERRED). ";
        field { name = "hdcp2x_sec_out4"; desc = ""; sw = r; hw = w; reset = 0x0; } hdcp2x_sec_out4[7:0];
    } HDCP2X_SEC_OUT4 @ 0x3B0;
    reg {
        name = "HDCP2X_SEC_OUT5";
        desc = "HDCP2X_SEC_OUT5 (offset 0x3B4 in this sub-block, absolute 0x1301C3B4). Reset INIT 0x00000000. PROVEN: vendor register header. No call site in the vendor hal/drv C sources: access by register-name convention only (INFERRED). ";
        field { name = "hdcp2x_sec_out5"; desc = ""; sw = r; hw = w; reset = 0x0; } hdcp2x_sec_out5[7:0];
    } HDCP2X_SEC_OUT5 @ 0x3B4;
    reg {
        name = "HDCP2X_SEC_OUT6";
        desc = "HDCP2X_SEC_OUT6 (offset 0x3B8 in this sub-block, absolute 0x1301C3B8). Reset INIT 0x00000000. PROVEN: vendor register header. No call site in the vendor hal/drv C sources: access by register-name convention only (INFERRED). ";
        field { name = "hdcp2x_sec_out6"; desc = ""; sw = r; hw = w; reset = 0x0; } hdcp2x_sec_out6[7:0];
    } HDCP2X_SEC_OUT6 @ 0x3B8;
    reg {
        name = "HDCP2X_SEC_OUT7";
        desc = "HDCP2X_SEC_OUT7 (offset 0x3BC in this sub-block, absolute 0x1301C3BC). Reset INIT 0x00000000. PROVEN: vendor register header. No call site in the vendor hal/drv C sources: access by register-name convention only (INFERRED). ";
        field { name = "hdcp2x_sec_out7"; desc = ""; sw = r; hw = w; reset = 0x0; } hdcp2x_sec_out7[7:0];
    } HDCP2X_SEC_OUT7 @ 0x3BC;
};

regfile eHI3536D_HDMI_dphy {
    name = "HDMI TX dphy, Hi3536D V100 / HDMI v2 (hisiv100)";
    desc = "TX digital PHY wrapper (SSC and PHY control), separate window at 0x13030000. Offsets are relative to the sub-block base 0x13000000 (HDMI TX window 0x13000000 + 0x0). Provenance: PROVEN (vendor code): register names, offsets, field names/bit ranges and reset (INIT) values come from the machine-generated register headers of the vendor HDMI v2 driver (nManager-generated hdmi_reg_dphy.h, product/hiosd/hdmi/hdmi_v2/drv/hal in the vendor U-Boot tree for the Hi3536D/Hi3536C/Hi3531D/Hi3521D family, source: sources/openipc-u-boot-hi3536dv100); the Hi3536D V100 maps the window at 0x13000000 per its hdmi_product_define.h and the closed hi3536dv100_hdmi.ko symbol names (HDMI_TX_S_*_REGS_TYPE_Init) agree. INFERRED: access types. Of the 503 register definitions in the vendor headers only 38 carry an ATTR (all RW); the others have none, so fields are modelled read/write except reserved/rsv fields and registers whose names mark them read-only by convention where the vendor hal/drv C sources call the accessors (203 registers) a register only ever read is modelled sw=r and the call-site counts are in each register description; for the other registers the name convention (SW_VER*, HW_INFO/HW_VERSION/HW_FEATURE, _STATUS, _STAT, _STATE, _OUT<n>: sw=r) is used. The 8051 MCU window (mcu sub-block) is modelled the same way and its function is inferred from the HDCP2X_* names only and hardware behavior; nothing run on hardware. NOT in the data sheet (no HDMI TX chapter)." ;
    reg {
        name = "HDMITX_INSSC_SET";
        desc = "HDMITX_INSSC_SET (offset 0x0 in this sub-block, absolute 0x13000000). Reset INIT 0xC0000000. PROVEN: vendor register header. Driver usage (vendor hal/drv C, uncommented call sites): 0 Get, 2 Set (hdmi_hal_phy.c): only written by the driver (kept RW: a write-only register cannot be told from an unread one). hdmi tx ssc in  ctrl0";
        field { name = "reg_sscin_bypass_en"; desc = ""; sw = rw; hw = r; reset = 0x1; } reg_sscin_bypass_en[31:31];
        field { name = "reg_pllfbmash111_en"; desc = ""; sw = rw; hw = r; reset = 0x1; } reg_pllfbmash111_en[30:30];
        field { name = "reg_ssc_mode"; desc = ""; sw = rw; hw = r; reset = 0x0; } reg_ssc_mode[29:29];
        field { name = "reg_deep_color"; desc = ""; sw = rw; hw = r; reset = 0x0; } reg_deep_color[28:27];
        field { name = "reg_sscfifo_depth_clr"; desc = ""; sw = rw; hw = r; reset = 0x0; } reg_sscfifo_depth_clr[26:26];
        field { name = "reg_sscfifo_tune_en"; desc = ""; sw = rw; hw = r; reset = 0x0; } reg_sscfifo_tune_en[25:25];
        field { name = "reg_set_load"; desc = ""; sw = rw; hw = r; reset = 0x0; } reg_set_load[24:24];
        field { name = "reg_set"; desc = ""; sw = rw; hw = r; reset = 0x0; } reg_set[23:0];
    } HDMITX_INSSC_SET @ 0x0;
    reg {
        name = "HDMITX_INSSC_FIFO";
        desc = "HDMITX_INSSC_FIFO (offset 0x4 in this sub-block, absolute 0x13000004). Reset INIT 0x01C01001. PROVEN: vendor register header. No call site in the vendor hal/drv C sources: access by register-name convention only (INFERRED). hdmi tx ssc  ctrl1";
        field { name = "rsv_0"; desc = ""; sw = r; hw = na; reset = 0x0; } rsv_0[31:30];
        field { name = "reg_ssc_sync"; desc = ""; sw = rw; hw = r; reset = 0x0; } reg_ssc_sync[29:29];
        field { name = "reg_tune_reverse"; desc = ""; sw = rw; hw = r; reset = 0x0; } reg_tune_reverse[28:28];
        field { name = "reg_sscfifo_upper_thresh"; desc = ""; sw = rw; hw = r; reset = 0x70; } reg_sscfifo_upper_thresh[27:18];
        field { name = "reg_sscfifo_lower_thresh"; desc = ""; sw = rw; hw = r; reset = 0x10; } reg_sscfifo_lower_thresh[17:8];
        field { name = "reg_tune_step"; desc = ""; sw = rw; hw = r; reset = 0x1; } reg_tune_step[7:0];
    } HDMITX_INSSC_FIFO @ 0x4;
    reg {
        name = "HDMITX_INSSC_STEP";
        desc = "HDMITX_INSSC_STEP (offset 0x8 in this sub-block, absolute 0x13000008). Reset INIT 0x00000000. PROVEN: vendor register header. No call site in the vendor hal/drv C sources: access by register-name convention only (INFERRED). hdmi tx ssc  ctrl2";
        field { name = "reg_testd"; desc = ""; sw = rw; hw = r; reset = 0x0; } reg_testd[31:24];
        field { name = "reg_span"; desc = ""; sw = rw; hw = r; reset = 0x0; } reg_span[23:10];
        field { name = "reg_step"; desc = ""; sw = rw; hw = r; reset = 0x0; } reg_step[9:0];
    } HDMITX_INSSC_STEP @ 0x8;
    reg {
        name = "HDMITX_INSSC_TUNE";
        desc = "HDMITX_INSSC_TUNE (offset 0xC in this sub-block, absolute 0x1300000C). Reset INIT 0x00000000. PROVEN: vendor register header. No call site in the vendor hal/drv C sources: access by register-name convention only (INFERRED). hdmi tx ssc  ctrl3";
        field { name = "reg_tune_interval"; desc = ""; sw = rw; hw = r; reset = 0x0; } reg_tune_interval[31:0];
    } HDMITX_INSSC_TUNE @ 0xC;
    reg {
        name = "HDMITX_SSC_HK";
        desc = "HDMITX_SSC_HK (offset 0x14 in this sub-block, absolute 0x13000014). Reset INIT 0x00000000. PROVEN: vendor register header. No call site in the vendor hal/drv C sources: access by register-name convention only (INFERRED). ";
        field { name = "rsv_1"; desc = ""; sw = r; hw = na; reset = 0x0; } rsv_1[31:7];
        field { name = "reg_mash111_hk_sel"; desc = ""; sw = rw; hw = r; reset = 0x0; } reg_mash111_hk_sel[6:6];
        field { name = "reg_hkmash_en"; desc = ""; sw = rw; hw = r; reset = 0x0; } reg_hkmash_en[5:5];
        field { name = "reg_dnum"; desc = ""; sw = rw; hw = r; reset = 0x0; } reg_dnum[4:0];
    } HDMITX_SSC_HK @ 0x14;
    reg {
        name = "HDMITX_SSCIN_STATUS0";
        desc = "HDMITX_SSCIN_STATUS0 (offset 0x20 in this sub-block, absolute 0x13000020). Reset INIT 0x00000000. PROVEN: vendor register header. No call site in the vendor hal/drv C sources: access by register-name convention only (INFERRED). SSC IN related status0";
        field { name = "rsv_2"; desc = ""; sw = r; hw = na; reset = 0x0; } rsv_2[31:24];
        field { name = "sscin_div"; desc = ""; sw = rw; hw = r; reset = 0x0; } sscin_div[23:19];
        field { name = "sscin_reverse_flag"; desc = ""; sw = rw; hw = r; reset = 0x0; } sscin_reverse_flag[18:18];
        field { name = "sscin_stop_flag"; desc = ""; sw = rw; hw = r; reset = 0x0; } sscin_stop_flag[17:17];
        field { name = "sscin_segment"; desc = ""; sw = rw; hw = r; reset = 0x0; } sscin_segment[16:15];
        field { name = "sscin_span_cnt"; desc = ""; sw = rw; hw = r; reset = 0x0; } sscin_span_cnt[14:0];
    } HDMITX_SSCIN_STATUS0 @ 0x20;
    reg {
        name = "HDMITX_SSCIN_STATUS1";
        desc = "HDMITX_SSCIN_STATUS1 (offset 0x24 in this sub-block, absolute 0x13000024). Reset INIT 0x00000000. PROVEN: vendor register header. No call site in the vendor hal/drv C sources: access by register-name convention only (INFERRED). SSC IN related status1";
        field { name = "rsv_3"; desc = ""; sw = r; hw = na; reset = 0x0; } rsv_3[31:24];
        field { name = "sscin_ssc_offset"; desc = ""; sw = rw; hw = r; reset = 0x0; } sscin_ssc_offset[23:0];
    } HDMITX_SSCIN_STATUS1 @ 0x24;
    reg {
        name = "HDMITX_SSCIN_STATUS2";
        desc = "HDMITX_SSCIN_STATUS2 (offset 0x28 in this sub-block, absolute 0x13000028). Reset INIT 0x00000000. PROVEN: vendor register header. No call site in the vendor hal/drv C sources: access by register-name convention only (INFERRED). SSC IN related status2";
        field { name = "rsv_4"; desc = ""; sw = r; hw = na; reset = 0x0; } rsv_4[31:20];
        field { name = "sscin_sscfifo_depth_min"; desc = ""; sw = rw; hw = r; reset = 0x0; } sscin_sscfifo_depth_min[19:10];
        field { name = "sscin_sscfifo_depth_max"; desc = ""; sw = rw; hw = r; reset = 0x0; } sscin_sscfifo_depth_max[9:0];
    } HDMITX_SSCIN_STATUS2 @ 0x28;
    reg {
        name = "HDMITX_SSCFB_STATUS0";
        desc = "HDMITX_SSCFB_STATUS0 (offset 0x2C in this sub-block, absolute 0x1300002C). Reset INIT 0x00000000. PROVEN: vendor register header. No call site in the vendor hal/drv C sources: access by register-name convention only (INFERRED). SSC PLL FB status0";
        field { name = "rsv_5"; desc = ""; sw = r; hw = na; reset = 0x0; } rsv_5[31:24];
        field { name = "sscfb_div"; desc = ""; sw = rw; hw = r; reset = 0x0; } sscfb_div[23:19];
        field { name = "sscfb_reverse_flag"; desc = ""; sw = rw; hw = r; reset = 0x0; } sscfb_reverse_flag[18:18];
        field { name = "sscfb_stop_flag"; desc = ""; sw = rw; hw = r; reset = 0x0; } sscfb_stop_flag[17:17];
        field { name = "sscfb_segment"; desc = ""; sw = rw; hw = r; reset = 0x0; } sscfb_segment[16:15];
        field { name = "sscfb_span_cnt"; desc = ""; sw = rw; hw = r; reset = 0x0; } sscfb_span_cnt[14:0];
    } HDMITX_SSCFB_STATUS0 @ 0x2C;
    reg {
        name = "HDMITX_SSCFB_STATUS1";
        desc = "HDMITX_SSCFB_STATUS1 (offset 0x30 in this sub-block, absolute 0x13000030). Reset INIT 0x00000000. PROVEN: vendor register header. No call site in the vendor hal/drv C sources: access by register-name convention only (INFERRED). SSC PLL FB status1";
        field { name = "rsv_6"; desc = ""; sw = r; hw = na; reset = 0x0; } rsv_6[31:24];
        field { name = "sscfb_ssc_offset"; desc = ""; sw = rw; hw = r; reset = 0x0; } sscfb_ssc_offset[23:0];
    } HDMITX_SSCFB_STATUS1 @ 0x30;
    reg {
        name = "HDMITX_SSCFB_STATUS2";
        desc = "HDMITX_SSCFB_STATUS2 (offset 0x34 in this sub-block, absolute 0x13000034). Reset INIT 0x00000000. PROVEN: vendor register header. No call site in the vendor hal/drv C sources: access by register-name convention only (INFERRED). SSC PLL FB status2";
        field { name = "rsv_7"; desc = ""; sw = r; hw = na; reset = 0x0; } rsv_7[31:20];
        field { name = "sscfb_sscfifo_depth_min"; desc = ""; sw = rw; hw = r; reset = 0x0; } sscfb_sscfifo_depth_min[19:10];
        field { name = "sscfb_sscfifo_depth_max"; desc = ""; sw = rw; hw = r; reset = 0x0; } sscfb_sscfifo_depth_max[9:0];
    } HDMITX_SSCFB_STATUS2 @ 0x34;
    reg {
        name = "HDMITX_SSCFBMASH111_STATUS0";
        desc = "HDMITX_SSCFBMASH111_STATUS0 (offset 0x38 in this sub-block, absolute 0x13000038). Reset INIT 0x00000000. PROVEN: vendor register header. No call site in the vendor hal/drv C sources: access by register-name convention only (INFERRED). SSC PLL FB MASH111 status0";
        field { name = "rsv_8"; desc = ""; sw = r; hw = na; reset = 0x0; } rsv_8[31:24];
        field { name = "fbmash_div"; desc = ""; sw = rw; hw = r; reset = 0x0; } fbmash_div[23:19];
        field { name = "fbmash_reverse_flag"; desc = ""; sw = rw; hw = r; reset = 0x0; } fbmash_reverse_flag[18:18];
        field { name = "fbmash_stop_flag"; desc = ""; sw = rw; hw = r; reset = 0x0; } fbmash_stop_flag[17:17];
        field { name = "fbmash_segment"; desc = ""; sw = rw; hw = r; reset = 0x0; } fbmash_segment[16:15];
        field { name = "fbmash_span_cnt"; desc = ""; sw = rw; hw = r; reset = 0x0; } fbmash_span_cnt[14:0];
    } HDMITX_SSCFBMASH111_STATUS0 @ 0x38;
    reg {
        name = "HDMITX_SSCFBMASH111_STATUS1";
        desc = "HDMITX_SSCFBMASH111_STATUS1 (offset 0x3C in this sub-block, absolute 0x1300003C). Reset INIT 0x00000000. PROVEN: vendor register header. No call site in the vendor hal/drv C sources: access by register-name convention only (INFERRED). SSC PLL FB MASH111 status1";
        field { name = "rsv_9"; desc = ""; sw = r; hw = na; reset = 0x0; } rsv_9[31:24];
        field { name = "fbmash_ssc_offset"; desc = ""; sw = rw; hw = r; reset = 0x0; } fbmash_ssc_offset[23:0];
    } HDMITX_SSCFBMASH111_STATUS1 @ 0x3C;
    reg {
        name = "HDMITX_SSCFBMASH111_STATUS2";
        desc = "HDMITX_SSCFBMASH111_STATUS2 (offset 0x40 in this sub-block, absolute 0x13000040). Reset INIT 0x00000000. PROVEN: vendor register header. No call site in the vendor hal/drv C sources: access by register-name convention only (INFERRED). SSC PLL FB MASH111 status2";
        field { name = "rsv_10"; desc = ""; sw = r; hw = na; reset = 0x0; } rsv_10[31:20];
        field { name = "fbmash_sscfifo_depth_min"; desc = ""; sw = rw; hw = r; reset = 0x0; } fbmash_sscfifo_depth_min[19:10];
        field { name = "fbmash_sscfifo_depth_max"; desc = ""; sw = rw; hw = r; reset = 0x0; } fbmash_sscfifo_depth_max[9:0];
    } HDMITX_SSCFBMASH111_STATUS2 @ 0x40;
    reg {
        name = "HDMITX_AFIFO_DATA_H";
        desc = "HDMITX_AFIFO_DATA_H (offset 0x4C in this sub-block, absolute 0x1300004C). Reset INIT 0x00000000. PROVEN: vendor register header. No call site in the vendor hal/drv C sources: access by register-name convention only (INFERRED). HDMITX AFIFO ctrl4";
        field { name = "rsv_11"; desc = ""; sw = r; hw = na; reset = 0x0; } rsv_11[31:30];
        field { name = "reg_aphy_data_ch2_h"; desc = ""; sw = rw; hw = r; reset = 0x0; } reg_aphy_data_ch2_h[29:20];
        field { name = "reg_aphy_data_ch1_h"; desc = ""; sw = rw; hw = r; reset = 0x0; } reg_aphy_data_ch1_h[19:10];
        field { name = "reg_aphy_data_ch0_h"; desc = ""; sw = rw; hw = r; reset = 0x0; } reg_aphy_data_ch0_h[9:0];
    } HDMITX_AFIFO_DATA_H @ 0x4C;
    reg {
        name = "HDMITX_AFIFO_DATA_SEL";
        desc = "HDMITX_AFIFO_DATA_SEL (offset 0x50 in this sub-block, absolute 0x13000050). Reset INIT 0x00003E00. PROVEN: vendor register header. Driver usage (vendor hal/drv C, uncommented call sites): 0 Get, 1 Set (hdmi_hal_phy.c): only written by the driver (kept RW: a write-only register cannot be told from an unread one). HDMITX AFIFO ctrl0";
        field { name = "rsv_12"; desc = ""; sw = r; hw = na; reset = 0x0; } rsv_12[31:19];
        field { name = "reg_aphy_data_clk_h"; desc = ""; sw = rw; hw = r; reset = 0x1F; } reg_aphy_data_clk_h[18:9];
        field { name = "txafifo_empt_status"; desc = ""; sw = rw; hw = r; reset = 0x0; } txafifo_empt_status[8:8];
        field { name = "txafifo_aempt_status"; desc = ""; sw = rw; hw = r; reset = 0x0; } txafifo_aempt_status[7:7];
        field { name = "txafifo_full_status"; desc = ""; sw = rw; hw = r; reset = 0x0; } txafifo_full_status[6:6];
        field { name = "txafifo_aful_status"; desc = ""; sw = rw; hw = r; reset = 0x0; } txafifo_aful_status[5:5];
        field { name = "reg_aphy_data_ch2_sel"; desc = ""; sw = rw; hw = r; reset = 0x0; } reg_aphy_data_ch2_sel[4:4];
        field { name = "reg_aphy_data_ch1_sel"; desc = ""; sw = rw; hw = r; reset = 0x0; } reg_aphy_data_ch1_sel[3:3];
        field { name = "reg_aphy_data_ch0_sel"; desc = ""; sw = rw; hw = r; reset = 0x0; } reg_aphy_data_ch0_sel[2:2];
        field { name = "reg_txafifo_rst"; desc = ""; sw = rw; hw = r; reset = 0x0; } reg_txafifo_rst[1:1];
        field { name = "reg_txafifo_status_rst"; desc = ""; sw = rw; hw = r; reset = 0x0; } reg_txafifo_status_rst[0:0];
    } HDMITX_AFIFO_DATA_SEL @ 0x50;
    reg {
        name = "HDMITX_AFIFO_CLK";
        desc = "HDMITX_AFIFO_CLK (offset 0x54 in this sub-block, absolute 0x13000054). Reset INIT 0x01F07C1F. PROVEN: vendor register header. Driver usage (vendor hal/drv C, uncommented call sites): 0 Get, 1 Set (hdmi_hal_phy.c): only written by the driver (kept RW: a write-only register cannot be told from an unread one). HDMITX AFIFO ctrl1";
        field { name = "rsv_13"; desc = ""; sw = r; hw = na; reset = 0x0; } rsv_13[31:30];
        field { name = "reg_aphy_data_clk_l"; desc = ""; sw = rw; hw = r; reset = 0x1F07C1F; } reg_aphy_data_clk_l[29:0];
    } HDMITX_AFIFO_CLK @ 0x54;
    reg {
        name = "HDMITX_AFIFO_DATA_L";
        desc = "HDMITX_AFIFO_DATA_L (offset 0x58 in this sub-block, absolute 0x13000058). Reset INIT 0x00000000. PROVEN: vendor register header. No call site in the vendor hal/drv C sources: access by register-name convention only (INFERRED). HDMITX AFIFO ctrl2";
        field { name = "rsv_14"; desc = ""; sw = r; hw = na; reset = 0x0; } rsv_14[31:30];
        field { name = "reg_aphy_data_ch2"; desc = ""; sw = rw; hw = r; reset = 0x0; } reg_aphy_data_ch2[29:20];
        field { name = "reg_aphy_data_ch1"; desc = ""; sw = rw; hw = r; reset = 0x0; } reg_aphy_data_ch1[19:10];
        field { name = "reg_aphy_data_ch0"; desc = ""; sw = rw; hw = r; reset = 0x0; } reg_aphy_data_ch0[9:0];
    } HDMITX_AFIFO_DATA_L @ 0x58;
    reg {
        name = "HDMITX_AFIFO_CHANNEL";
        desc = "HDMITX_AFIFO_CHANNEL (offset 0x5C in this sub-block, absolute 0x1300005C). Reset INIT 0x00003440. PROVEN: vendor register header. No call site in the vendor hal/drv C sources: access by register-name convention only (INFERRED). HDMITX AFIFO ctrl3";
        field { name = "rsv_15"; desc = ""; sw = r; hw = na; reset = 0x0; } rsv_15[31:15];
        field { name = "reg_d2_dataout_sel"; desc = ""; sw = rw; hw = r; reset = 0x3; } reg_d2_dataout_sel[14:12];
        field { name = "reg_d1_dataout_sel"; desc = ""; sw = rw; hw = r; reset = 0x2; } reg_d1_dataout_sel[11:9];
        field { name = "reg_d0_dataout_sel"; desc = ""; sw = rw; hw = r; reset = 0x1; } reg_d0_dataout_sel[8:6];
        field { name = "reg_ck_dataout_sel"; desc = ""; sw = rw; hw = r; reset = 0x0; } reg_ck_dataout_sel[5:3];
        field { name = "reg_prbs7_errinject"; desc = ""; sw = rw; hw = r; reset = 0x0; } reg_prbs7_errinject[2:2];
        field { name = "reg_prbs7_clr"; desc = ""; sw = rw; hw = r; reset = 0x0; } reg_prbs7_clr[1:1];
        field { name = "reg_prbs7_en"; desc = ""; sw = rw; hw = r; reset = 0x0; } reg_prbs7_en[0:0];
    } HDMITX_AFIFO_CHANNEL @ 0x5C;
    reg {
        name = "APHY_STATUS0";
        desc = "APHY_STATUS0 (offset 0x60 in this sub-block, absolute 0x13000060). Reset INIT 0x00000000. PROVEN: vendor register header. No call site in the vendor hal/drv C sources: access by register-name convention only (INFERRED). APHY output status signals";
        field { name = "rsv_16"; desc = ""; sw = r; hw = na; reset = 0x0; } rsv_16[31:3];
        field { name = "ad_txpll_lock"; desc = ""; sw = rw; hw = r; reset = 0x0; } ad_txpll_lock[2:2];
        field { name = "ad_txpll_hvflag"; desc = ""; sw = rw; hw = r; reset = 0x0; } ad_txpll_hvflag[1:1];
        field { name = "ad_rxsense"; desc = ""; sw = rw; hw = r; reset = 0x0; } ad_rxsense[0:0];
    } APHY_STATUS0 @ 0x60;
    reg {
        name = "APHY_TOP_PD";
        desc = "APHY_TOP_PD (offset 0x64 in this sub-block, absolute 0x13000064). Reset INIT 0x0017FFFF. PROVEN: vendor register header. Driver usage (vendor hal/drv C, uncommented call sites): 6 Get, 12 Set (hdmi_hal_phy.c): read and written (RW). APHY top misc control register";
        field { name = "rsv_17"; desc = ""; sw = r; hw = na; reset = 0x0; } rsv_17[31:23];
        field { name = "reg_divsel"; desc = ""; sw = rw; hw = r; reset = 0x0; } reg_divsel[22:21];
        field { name = "reg_gc_txpll_pd"; desc = ""; sw = rw; hw = r; reset = 0x1; } reg_gc_txpll_pd[20:20];
        field { name = "reg_gc_pd_rxsense"; desc = ""; sw = rw; hw = r; reset = 0x0; } reg_gc_pd_rxsense[19:19];
        field { name = "reg_gc_pd_rterm"; desc = ""; sw = rw; hw = r; reset = 0xFF; } reg_gc_pd_rterm[18:11];
        field { name = "reg_gc_pd_ldo"; desc = ""; sw = rw; hw = r; reset = 0x3; } reg_gc_pd_ldo[10:9];
        field { name = "reg_gc_pd_de"; desc = ""; sw = rw; hw = r; reset = 0xF; } reg_gc_pd_de[8:5];
        field { name = "reg_gc_pd_bist"; desc = ""; sw = rw; hw = r; reset = 0x1; } reg_gc_pd_bist[4:4];
        field { name = "reg_gc_pd"; desc = ""; sw = rw; hw = r; reset = 0xF; } reg_gc_pd[3:0];
    } APHY_TOP_PD @ 0x64;
    reg {
        name = "APHY_DRIVER_IMAIN";
        desc = "APHY_DRIVER_IMAIN (offset 0x68 in this sub-block, absolute 0x13000068). Reset INIT 0x00C71C60. PROVEN: vendor register header. Driver usage (vendor hal/drv C, uncommented call sites): 0 Get, 5 Set (hdmi_hal_phy.c): only written by the driver (kept RW: a write-only register cannot be told from an unread one). APHY driver related control0";
        field { name = "rsv_18"; desc = ""; sw = r; hw = na; reset = 0x0; } rsv_18[31:30];
        field { name = "reg_isel_main_de_clk"; desc = ""; sw = rw; hw = r; reset = 0x0; } reg_isel_main_de_clk[29:24];
        field { name = "reg_isel_main_d2"; desc = ""; sw = rw; hw = r; reset = 0x31; } reg_isel_main_d2[23:18];
        field { name = "reg_isel_main_d1"; desc = ""; sw = rw; hw = r; reset = 0x31; } reg_isel_main_d1[17:12];
        field { name = "reg_isel_main_d0"; desc = ""; sw = rw; hw = r; reset = 0x31; } reg_isel_main_d0[11:6];
        field { name = "reg_isel_main_clk"; desc = ""; sw = rw; hw = r; reset = 0x20; } reg_isel_main_clk[5:0];
    } APHY_DRIVER_IMAIN @ 0x68;
    reg {
        name = "APHY_DRIVER_IPRE";
        desc = "APHY_DRIVER_IPRE (offset 0x6C in this sub-block, absolute 0x1300006C). Reset INIT 0x18180000. PROVEN: vendor register header. Driver usage (vendor hal/drv C, uncommented call sites): 0 Get, 5 Set (hdmi_hal_phy.c): only written by the driver (kept RW: a write-only register cannot be told from an unread one). APHY driver related control1";
        field { name = "rsv_19"; desc = ""; sw = r; hw = na; reset = 0x0; } rsv_19[31:30];
        field { name = "reg_isel_pre_d0"; desc = ""; sw = rw; hw = r; reset = 0x18; } reg_isel_pre_d0[29:24];
        field { name = "reg_isel_pre_clk"; desc = ""; sw = rw; hw = r; reset = 0x6; } reg_isel_pre_clk[23:18];
        field { name = "reg_isel_main_de_d2"; desc = ""; sw = rw; hw = r; reset = 0x0; } reg_isel_main_de_d2[17:12];
        field { name = "reg_isel_main_de_d1"; desc = ""; sw = rw; hw = r; reset = 0x0; } reg_isel_main_de_d1[11:6];
        field { name = "reg_isel_main_de_d0"; desc = ""; sw = rw; hw = r; reset = 0x0; } reg_isel_main_de_d0[5:0];
    } APHY_DRIVER_IPRE @ 0x6C;
    reg {
        name = "APHY_DRIVER_IPREDE";
        desc = "APHY_DRIVER_IPREDE (offset 0x70 in this sub-block, absolute 0x13000070). Reset INIT 0x00000618. PROVEN: vendor register header. Driver usage (vendor hal/drv C, uncommented call sites): 0 Get, 5 Set (hdmi_hal_phy.c): only written by the driver (kept RW: a write-only register cannot be told from an unread one). APHY driver related control2";
        field { name = "rsv_20"; desc = ""; sw = r; hw = na; reset = 0x0; } rsv_20[31:30];
        field { name = "reg_isel_pre_de_d1"; desc = ""; sw = rw; hw = r; reset = 0x0; } reg_isel_pre_de_d1[29:24];
        field { name = "reg_isel_pre_de_d0"; desc = ""; sw = rw; hw = r; reset = 0x0; } reg_isel_pre_de_d0[23:18];
        field { name = "reg_isel_pre_de_clk"; desc = ""; sw = rw; hw = r; reset = 0x0; } reg_isel_pre_de_clk[17:12];
        field { name = "reg_isel_pre_d2"; desc = ""; sw = rw; hw = r; reset = 0x18; } reg_isel_pre_d2[11:6];
        field { name = "reg_isel_pre_d1"; desc = ""; sw = rw; hw = r; reset = 0x18; } reg_isel_pre_d1[5:0];
    } APHY_DRIVER_IPREDE @ 0x70;
    reg {
        name = "APHY_DRIVER_RPRE";
        desc = "APHY_DRIVER_RPRE (offset 0x74 in this sub-block, absolute 0x13000074). Reset INIT 0x0001B780. PROVEN: vendor register header. Driver usage (vendor hal/drv C, uncommented call sites): 0 Get, 9 Set (hdmi_hal_phy.c): only written by the driver (kept RW: a write-only register cannot be told from an unread one). APHY driver related control3";
        field { name = "rsv_21"; desc = ""; sw = r; hw = na; reset = 0x0; } rsv_21[31:30];
        field { name = "reg_rsel_pre_de_d2"; desc = ""; sw = rw; hw = r; reset = 0x0; } reg_rsel_pre_de_d2[29:27];
        field { name = "reg_rsel_pre_de_d1"; desc = ""; sw = rw; hw = r; reset = 0x0; } reg_rsel_pre_de_d1[26:24];
        field { name = "reg_rsel_pre_de_d0"; desc = ""; sw = rw; hw = r; reset = 0x0; } reg_rsel_pre_de_d0[23:21];
        field { name = "reg_rsel_pre_de_clk"; desc = ""; sw = rw; hw = r; reset = 0x0; } reg_rsel_pre_de_clk[20:18];
        field { name = "reg_rsel_pre_d2"; desc = ""; sw = rw; hw = r; reset = 0x3; } reg_rsel_pre_d2[17:15];
        field { name = "reg_rsel_pre_d1"; desc = ""; sw = rw; hw = r; reset = 0x3; } reg_rsel_pre_d1[14:12];
        field { name = "reg_rsel_pre_d0"; desc = ""; sw = rw; hw = r; reset = 0x3; } reg_rsel_pre_d0[11:9];
        field { name = "reg_rsel_pre_clk"; desc = ""; sw = rw; hw = r; reset = 0x6; } reg_rsel_pre_clk[8:6];
        field { name = "reg_isel_pre_de_d2"; desc = ""; sw = rw; hw = r; reset = 0x0; } reg_isel_pre_de_d2[5:0];
    } APHY_DRIVER_RPRE @ 0x74;
    reg {
        name = "APHY_RTERM_CTRL";
        desc = "APHY_RTERM_CTRL (offset 0x78 in this sub-block, absolute 0x13000078). Reset INIT 0x60606060. PROVEN: vendor register header. Driver usage (vendor hal/drv C, uncommented call sites): 0 Get, 4 Set (hdmi_hal_phy.c): only written by the driver (kept RW: a write-only register cannot be told from an unread one). APHY R term related control";
        field { name = "reg_rt_d2"; desc = ""; sw = rw; hw = r; reset = 0x60; } reg_rt_d2[31:24];
        field { name = "reg_rt_d1"; desc = ""; sw = rw; hw = r; reset = 0x60; } reg_rt_d1[23:16];
        field { name = "reg_rt_d0"; desc = ""; sw = rw; hw = r; reset = 0x60; } reg_rt_d0[15:8];
        field { name = "reg_rt_clk"; desc = ""; sw = rw; hw = r; reset = 0x60; } reg_rt_clk[7:0];
    } APHY_RTERM_CTRL @ 0x78;
    reg {
        name = "APHY_MISC_CTRL";
        desc = "APHY_MISC_CTRL (offset 0x7C in this sub-block, absolute 0x1300007C). Reset INIT 0x00000000. PROVEN: vendor register header. No call site in the vendor hal/drv C sources: access by register-name convention only (INFERRED). APHY misc control";
        field { name = "rsv_22"; desc = ""; sw = r; hw = na; reset = 0x0; } rsv_22[31:11];
        field { name = "reg_sr_clk"; desc = ""; sw = rw; hw = r; reset = 0x0; } reg_sr_clk[10:9];
        field { name = "reg_sel_rxsense"; desc = ""; sw = rw; hw = r; reset = 0x0; } reg_sel_rxsense[8:6];
        field { name = "reg_sel_ldo"; desc = ""; sw = rw; hw = r; reset = 0x0; } reg_sel_ldo[5:0];
    } APHY_MISC_CTRL @ 0x7C;
    reg {
        name = "APHY_TEST_CTRL";
        desc = "APHY_TEST_CTRL (offset 0x80 in this sub-block, absolute 0x13000080). Reset INIT 0x00000000. PROVEN: vendor register header. No call site in the vendor hal/drv C sources: access by register-name convention only (INFERRED). APHY test related control";
        field { name = "reg_test_dc"; desc = ""; sw = rw; hw = r; reset = 0x0; } reg_test_dc[31:16];
        field { name = "reg_test"; desc = ""; sw = rw; hw = r; reset = 0x0; } reg_test[15:0];
    } APHY_TEST_CTRL @ 0x80;
    reg {
        name = "APHY_TXPLL_CTRL";
        desc = "APHY_TXPLL_CTRL (offset 0x8C in this sub-block, absolute 0x1300008C). Reset INIT 0x0000C400. PROVEN: vendor register header. Driver usage (vendor hal/drv C, uncommented call sites): 0 Get, 5 Set (hdmi_hal_phy.c): only written by the driver (kept RW: a write-only register cannot be told from an unread one). APHY TXPLL related control";
        field { name = "rsv_23"; desc = ""; sw = r; hw = na; reset = 0x0; } rsv_23[31:20];
        field { name = "reg_gc_txpll_en_sscdiv"; desc = ""; sw = rw; hw = r; reset = 0x0; } reg_gc_txpll_en_sscdiv[19:19];
        field { name = "reg_gc_txpll_en_ref_fb_div2"; desc = ""; sw = rw; hw = r; reset = 0x0; } reg_gc_txpll_en_ref_fb_div2[18:18];
        field { name = "reg_txpll_icp_ictrl"; desc = ""; sw = rw; hw = r; reset = 0x3; } reg_txpll_icp_ictrl[17:14];
        field { name = "reg_txpll_divsel_post"; desc = ""; sw = rw; hw = r; reset = 0x0; } reg_txpll_divsel_post[13:12];
        field { name = "reg_txpll_divsel_loop"; desc = ""; sw = rw; hw = r; reset = 0x20; } reg_txpll_divsel_loop[11:5];
        field { name = "reg_txpll_divsel_in"; desc = ""; sw = rw; hw = r; reset = 0x0; } reg_txpll_divsel_in[4:2];
        field { name = "reg_txpll_clkin_sel"; desc = ""; sw = rw; hw = r; reset = 0x0; } reg_txpll_clkin_sel[1:0];
    } APHY_TXPLL_CTRL @ 0x8C;
    reg {
        name = "APHY_TXPLL_TEST";
        desc = "APHY_TXPLL_TEST (offset 0x90 in this sub-block, absolute 0x13000090). Reset INIT 0x00000000. PROVEN: vendor register header. Driver usage (vendor hal/drv C, uncommented call sites): 0 Get, 3 Set (hdmi_hal_phy.c): only written by the driver (kept RW: a write-only register cannot be told from an unread one). APHY TXPLL TEST related control";
        field { name = "rsv_24"; desc = ""; sw = r; hw = na; reset = 0x0; } rsv_24[31:20];
        field { name = "reg_txpll_test"; desc = ""; sw = rw; hw = r; reset = 0x0; } reg_txpll_test[19:0];
    } APHY_TXPLL_TEST @ 0x90;
    reg {
        name = "PLL_LOCK_CTRL";
        desc = "PLL_LOCK_CTRL (offset 0x94 in this sub-block, absolute 0x13000094). Reset INIT 0x0288080F. PROVEN: vendor register header. No call site in the vendor hal/drv C sources: access by register-name convention only (INFERRED). PLL_LOCK_CTRL";
        field { name = "rsv_25"; desc = ""; sw = r; hw = na; reset = 0x0; } rsv_25[31:27];
        field { name = "reg_pll_lock_times"; desc = ""; sw = rw; hw = r; reset = 0x0; } reg_pll_lock_times[26:26];
        field { name = "reg_pll_lockext_sel"; desc = ""; sw = rw; hw = r; reset = 0x5; } reg_pll_lockext_sel[25:23];
        field { name = "reg_pll_unlock_sel"; desc = ""; sw = rw; hw = r; reset = 0x0; } reg_pll_unlock_sel[22:22];
        field { name = "reg_pll_lock_sel"; desc = ""; sw = rw; hw = r; reset = 0x0; } reg_pll_lock_sel[21:20];
        field { name = "reg_ref_unlock_timer"; desc = ""; sw = rw; hw = r; reset = 0x80; } reg_ref_unlock_timer[19:12];
        field { name = "reg_ref_lock_timer"; desc = ""; sw = rw; hw = r; reset = 0x80; } reg_ref_lock_timer[11:4];
        field { name = "reg_fb_prd_sel"; desc = ""; sw = rw; hw = r; reset = 0x3; } reg_fb_prd_sel[3:2];
        field { name = "reg_fb_div_sel"; desc = ""; sw = rw; hw = r; reset = 0x3; } reg_fb_div_sel[1:0];
    } PLL_LOCK_CTRL @ 0x94;
    reg {
        name = "PLL_LOCK_STATUS";
        desc = "PLL_LOCK_STATUS (offset 0x98 in this sub-block, absolute 0x13000098). Reset INIT 0x00000000. PROVEN: vendor register header. No call site in the vendor hal/drv C sources: access by register-name convention only (INFERRED). PLL_LOCK_STATUS";
        field { name = "rsv_26"; desc = ""; sw = r; hw = na; reset = 0x0; } rsv_26[31:21];
        field { name = "hdmi_clk_lock"; desc = ""; sw = rw; hw = r; reset = 0x0; } hdmi_clk_lock[20:20];
        field { name = "pll_lock_oneshot"; desc = ""; sw = rw; hw = r; reset = 0x0; } pll_lock_oneshot[19:19];
        field { name = "test_pll_cnt"; desc = ""; sw = rw; hw = r; reset = 0x0; } test_pll_cnt[18:2];
        field { name = "pll_ena_edge"; desc = ""; sw = rw; hw = r; reset = 0x0; } pll_ena_edge[1:1];
        field { name = "clk_fb_exist"; desc = ""; sw = rw; hw = r; reset = 0x0; } clk_fb_exist[0:0];
    } PLL_LOCK_STATUS @ 0x98;
    reg {
        name = "REG_TXDPHY_DUMMY_CTRL";
        desc = "REG_TXDPHY_DUMMY_CTRL (offset 0x9C in this sub-block, absolute 0x1300009C). Reset INIT 0x00000000. PROVEN: vendor register header. No call site in the vendor hal/drv C sources: access by register-name convention only (INFERRED). ";
        field { name = "reg_txdphy_dummy_ctrl"; desc = ""; sw = rw; hw = r; reset = 0x0; } reg_txdphy_dummy_ctrl[31:0];
    } REG_TXDPHY_DUMMY_CTRL @ 0x9C;
    reg {
        name = "HDMITX_FBSSC_SET";
        desc = "HDMITX_FBSSC_SET (offset 0xB0 in this sub-block, absolute 0x130000B0). Reset INIT 0x01640000. PROVEN: vendor register header. Driver usage (vendor hal/drv C, uncommented call sites): 0 Get, 10 Set (hdmi_hal_phy.c): only written by the driver (kept RW: a write-only register cannot be told from an unread one). hdmi tx ssc fb  ctrl0";
        field { name = "rsv_27"; desc = ""; sw = r; hw = na; reset = 0x0; } rsv_27[31:28];
        field { name = "reg_ssc_mode_fb"; desc = ""; sw = rw; hw = r; reset = 0x0; } reg_ssc_mode_fb[27:27];
        field { name = "reg_sscfifo_depth_clr_fb"; desc = ""; sw = rw; hw = r; reset = 0x0; } reg_sscfifo_depth_clr_fb[26:26];
        field { name = "reg_sscfifo_tune_en_fb"; desc = ""; sw = rw; hw = r; reset = 0x0; } reg_sscfifo_tune_en_fb[25:25];
        field { name = "reg_set_load_fb"; desc = ""; sw = rw; hw = r; reset = 0x1; } reg_set_load_fb[24:24];
        field { name = "reg_set_fb"; desc = ""; sw = rw; hw = r; reset = 0x640000; } reg_set_fb[23:0];
    } HDMITX_FBSSC_SET @ 0xB0;
    reg {
        name = "HDMITX_FBSSC_FIFO";
        desc = "HDMITX_FBSSC_FIFO (offset 0xB4 in this sub-block, absolute 0x130000B4). Reset INIT 0x01C01001. PROVEN: vendor register header. No call site in the vendor hal/drv C sources: access by register-name convention only (INFERRED). hdmi tx ssc fb  ctrl1";
        field { name = "rsv_28"; desc = ""; sw = r; hw = na; reset = 0x0; } rsv_28[31:30];
        field { name = "reg_ssc_sync_fb"; desc = ""; sw = rw; hw = r; reset = 0x0; } reg_ssc_sync_fb[29:29];
        field { name = "reg_tune_reverse_fb"; desc = ""; sw = rw; hw = r; reset = 0x0; } reg_tune_reverse_fb[28:28];
        field { name = "reg_sscfifo_upper_thresh_fb"; desc = ""; sw = rw; hw = r; reset = 0x70; } reg_sscfifo_upper_thresh_fb[27:18];
        field { name = "reg_sscfifo_lower_thresh_fb"; desc = ""; sw = rw; hw = r; reset = 0x10; } reg_sscfifo_lower_thresh_fb[17:8];
        field { name = "reg_tune_step_fb"; desc = ""; sw = rw; hw = r; reset = 0x1; } reg_tune_step_fb[7:0];
    } HDMITX_FBSSC_FIFO @ 0xB4;
    reg {
        name = "HDMITX_FBSSC_STEP";
        desc = "HDMITX_FBSSC_STEP (offset 0xB8 in this sub-block, absolute 0x130000B8). Reset INIT 0x00074046. PROVEN: vendor register header. Driver usage (vendor hal/drv C, uncommented call sites): 2 Get, 4 Set (hdmi_hal_phy.c): read and written (RW). hdmi tx ssc fb  ctrl2";
        field { name = "reg_testd_fb"; desc = ""; sw = rw; hw = r; reset = 0x0; } reg_testd_fb[31:24];
        field { name = "reg_span_fb"; desc = ""; sw = rw; hw = r; reset = 0x1D0; } reg_span_fb[23:10];
        field { name = "reg_step_fb"; desc = ""; sw = rw; hw = r; reset = 0x46; } reg_step_fb[9:0];
    } HDMITX_FBSSC_STEP @ 0xB8;
    reg {
        name = "HDMITX_FBSSC_TUNE";
        desc = "HDMITX_FBSSC_TUNE (offset 0xBC in this sub-block, absolute 0x130000BC). Reset INIT 0x00000000. PROVEN: vendor register header. No call site in the vendor hal/drv C sources: access by register-name convention only (INFERRED). hdmi tx ssc fb  ctrl3";
        field { name = "reg_tune_interval_fb"; desc = ""; sw = rw; hw = r; reset = 0x0; } reg_tune_interval_fb[31:0];
    } HDMITX_FBSSC_TUNE @ 0xBC;
    // Registers skipped because the vendor header gives the same offset as an earlier register (alias or header duplicate): HDMITX_DPHY_RST = HDMITX_INSSC_TUNE at 0xC
};

`endif
