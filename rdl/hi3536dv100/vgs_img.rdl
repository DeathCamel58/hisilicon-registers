`ifndef HI3536D_VGS_IMG_RDL
`define HI3536D_VGS_IMG_RDL

regfile eHI3536D_VGS_IMG {
    name = "VGS job register image (DDR, NOT registers), Hi3536D V100";
    desc = "BOARD 2026-11-23 (docs/drivers/vgs-design.md section 14): the node images the driver builds (nodes built by the driver's own builder, equal to the vendor builder on 3393 host jobs) RUN on the block: 1:1 copy and crop (exact), scaling 2:1, 1:2, 5:4, 4:3, 4:5 (corner-aligned sampling grid, triangle taps, phase table read as built), 4:2:0 <-> 4:2:2 (vertical chroma table at the CHROMA line ratio), 90 / 180 / 270 degree rotation (two nodes for 90 / 270, one node with 0x68 bits 5:4 for 180: the direction is clockwise for 90), strides that are not the width (112 for 100), sizes 32 x 32 to 2048 x 4096 (BOARD run 2, 2026-11-23: 15x down, 16x up, a 480 x 256 -> 32 x 4096 cross pair, 4:2:2 -> 4:2:0 at 15x and 4:2:0 -> 4:2:2 at 16x all complete: the limits are inclusive; rotation 90 / 270 of 32 x 32, 2048 x 2048, 640 x 32 and 2048 x 32 exact, the horizontal step word 0x340 of a rotation node (wrapped to 0 for 2048 x 32) is ignored); 180 degrees also works with 4:2:2 and with a 4:2:2 -> 4:2:0 conversion in the same node. NV12 / NV21 and NV16 / NV61 need no format bit (the chroma pair is opaque). NOT A REGISTER FILE: the register image that VGS_DRV_SetVgsReg and VGS_DrvInitDefaultRegs of hi3536dv100_vgs.ko build in memory for one job; the job engine loads it (NEXT_NODE 0x2FC). 128 distinct words, offsets equal the engine register offsets. Generated by scripts/tools/arm-re (path-sensitive, --arg a0=IMG), documentation only. Provenance: PROVEN = offset, cleared bit extents, source expression and conditions read from the instruction stream; the source `stImgIn.x` / `stImgOut.x` names are INFERRED: a1[0x0] / a1[0x4] are taken to be pointers to the input / output VIDEO_FRAME_S of VGS_TASK_ATTR_S (member offsets from hi_comm_video.h, e.g. [0xC] = enPixelFormat); other a1[N] members belong to a driver-private job struct whose definition is not in the SDK (names UNKNOWN). Pixel-format fields hold PIXEL_FORMAT_E minus 0x17 (0 = YUV_SEMIPLANAR_420). Field extents are lower bounds. Not verified on hardware.";

    reg {
        name = "Task mode";
        desc = "Task mode word. PROVEN (dynamic): base value 0x80000008 for scale/crop/convert nodes (type 0, bypass, OSD-less); rotation tasks (types 5 = luma pass, 6 = chroma pass of VGS_AddRotateTask) add bits: 90 degrees = bit 22, 270 degrees = bits 22 and 21, plus bit 11 (luma pass, type 5) or bit 12 (chroma pass, type 6); 0 and 180 degrees leave the word at the base value. Other bits set by features this analysis did not use: bit 9 (bLTI, user option at +0x448), bit 5 (DCI, option at +0x468), bit 11 for a PIXEL_FORMAT 0x1D input. The type-5/6 passes of one picture are two nodes of one job. Provenance: DYNAMIC: the vendor node builder (VGS_DrvCommSubmitJobToVgs -> VGS_DrvCommPrepareNodes -> VGS_DRV_SetVgsReg, GenSclCfg, VGSSplitAndCrop) was run under qemu-arm with a fake register file and swept one input at a time (2026-11-23, scripts/tools/vgs-static/). Static source: hi3536dv100_vgs.ko (SDK 2.0.2.0 / Hi3536D_MPP_V1.0.1.0 B040, Dec 7 2017).";
        field {
            name = "const_3";
            desc = "always 1 [PROVEN value, meaning UNKNOWN]";
            sw = rw;
            hw = r;
        } const_3[3:3];
        field {
            name = "dci_en";
            desc = "DCI option on [PROVEN trigger, INFERRED meaning]";
            sw = rw;
            hw = r;
        } dci_en[5:5];
        field {
            name = "lti_en";
            desc = "bLTI option on [PROVEN trigger, INFERRED meaning]";
            sw = rw;
            hw = r;
        } lti_en[9:9];
        field {
            name = "rot_luma";
            desc = "luma plane pass of a 90/270 rotation [PROVEN trigger]";
            sw = rw;
            hw = r;
        } rot_luma[11:11];
        field {
            name = "rot_chroma";
            desc = "chroma plane pass of a 90/270 rotation [PROVEN trigger]";
            sw = rw;
            hw = r;
        } rot_chroma[12:12];
        field {
            name = "rot_dir";
            desc = "1 for 270 degrees [PROVEN trigger]";
            sw = rw;
            hw = r;
        } rot_dir[21:21];
        field {
            name = "rot_en";
            desc = "90 or 270 degree rotation [PROVEN trigger]";
            sw = rw;
            hw = r;
        } rot_en[22:22];
        field {
            name = "const_31";
            desc = "always 1 [PROVEN value, meaning UNKNOWN]";
            sw = rw;
            hw = r;
        } const_31[31:31];
    } W_000 @ 0x0;

    reg {
        name = "Image formats";
        desc = "Pixel formats of the pictures. PROVEN (dynamic): the field is 0 when the PIXEL_FORMAT_E value is 0x17 (SEMIPLANAR_420) and 1 for any other accepted value (22 = SEMIPLANAR_422; the vendor check VGS_CheckImage accepts 22, 23 and 29). Provenance: DYNAMIC: the vendor node builder (VGS_DrvCommSubmitJobToVgs -> VGS_DrvCommPrepareNodes -> VGS_DRV_SetVgsReg, GenSclCfg, VGSSplitAndCrop) was run under qemu-arm with a fake register file and swept one input at a time (2026-11-23, scripts/tools/vgs-static/). Static source: hi3536dv100_vgs.ko (SDK 2.0.2.0 / Hi3536D_MPP_V1.0.1.0 B040, Dec 7 2017).";
        field {
            name = "out_fmt";
            desc = "0 = semi-planar 4:2:0 output, 1 = other (4:2:2) [PROVEN]";
            sw = rw;
            hw = r;
        } out_fmt[15:12];
        field {
            name = "in_fmt";
            desc = "0 = semi-planar 4:2:0 input, 1 = other (4:2:2) [PROVEN]";
            sw = rw;
            hw = r;
        } in_fmt[20:16];
    } W_004 @ 0x4;

    reg {
        name = "Scaler enable";
        desc = "Word 0x8: base value 0x8 (bit 3) in scale/crop/convert nodes, 0 in 90/270 rotation nodes (PROVEN, dynamic). The static scan found further source bits (a1[0x25C] bit 3, a1[0xD0] bit 11, a1[0x1CC] bit 12): features this analysis did not exercise. Provenance: DYNAMIC: the vendor node builder (VGS_DrvCommSubmitJobToVgs -> VGS_DrvCommPrepareNodes -> VGS_DRV_SetVgsReg, GenSclCfg, VGSSplitAndCrop) was run under qemu-arm with a fake register file and swept one input at a time (2026-11-23, scripts/tools/vgs-static/). Static source: hi3536dv100_vgs.ko (SDK 2.0.2.0 / Hi3536D_MPP_V1.0.1.0 B040, Dec 7 2017).";
        field {
            name = "scaler_en";
            desc = "scaler path used: 1 in scale/crop/convert nodes, 0 in 90/270 rotation nodes [PROVEN value, INFERRED meaning]";
            sw = rw;
            hw = r;
        } scaler_en[3:3];
    } W_008 @ 0x8;

    reg {
        name = "Input size";
        desc = "Size of the (cropped) input rectangle minus one, type-0 task (scale/crop/convert), no split (width <= 2048). Provenance: DYNAMIC: the vendor node builder (VGS_DrvCommSubmitJobToVgs -> VGS_DrvCommPrepareNodes -> VGS_DRV_SetVgsReg, GenSclCfg, VGSSplitAndCrop) was run under qemu-arm with a fake register file and swept one input at a time (2026-11-23, scripts/tools/vgs-static/). Static source: hi3536dv100_vgs.ko (SDK 2.0.2.0 / Hi3536D_MPP_V1.0.1.0 B040, Dec 7 2017).";
        field {
            name = "in_w_m1";
            desc = "input width - 1 after crop [PROVEN]";
            sw = rw;
            hw = r;
        } in_w_m1[12:0];
        field {
            name = "in_h_m1";
            desc = "input height - 1 after crop [PROVEN]";
            sw = rw;
            hw = r;
        } in_h_m1[28:16];
    } W_00C @ 0xC;

    reg {
        name = "Input mode";
        desc = "Input picture mode. PROVEN (dynamic): base value 0x20; stImgIn.enCompressMode != 0 sets bit 0, enVideoFormat == 2 (TILE64) sets bit 6; linear = 0. Provenance: DYNAMIC: the vendor node builder (VGS_DrvCommSubmitJobToVgs -> VGS_DrvCommPrepareNodes -> VGS_DRV_SetVgsReg, GenSclCfg, VGSSplitAndCrop) was run under qemu-arm with a fake register file and swept one input at a time (2026-11-23, scripts/tools/vgs-static/). Static source: hi3536dv100_vgs.ko (SDK 2.0.2.0 / Hi3536D_MPP_V1.0.1.0 B040, Dec 7 2017).";
        field {
            name = "compressed";
            desc = "input is compressed (header addresses in 0x24/0x28) [PROVEN]";
            sw = rw;
            hw = r;
        } compressed[0:0];
        field {
            name = "const_5";
            desc = "always 1 in every node built [PROVEN value, meaning UNKNOWN]";
            sw = rw;
            hw = r;
        } const_5[5:5];
        field {
            name = "tile64";
            desc = "input uses the TILE64 layout [PROVEN]";
            sw = rw;
            hw = r;
        } tile64[6:6];
    } W_020 @ 0x20;

    reg {
        name = "Input header address Y";
        desc = "Physical address of the luma compression header of the input (stImgIn.u32HeaderPhyAddr[0]); written whatever the mode, 0 when unused. Provenance: DYNAMIC: the vendor node builder (VGS_DrvCommSubmitJobToVgs -> VGS_DrvCommPrepareNodes -> VGS_DRV_SetVgsReg, GenSclCfg, VGSSplitAndCrop) was run under qemu-arm with a fake register file and swept one input at a time (2026-11-23, scripts/tools/vgs-static/). Static source: hi3536dv100_vgs.ko (SDK 2.0.2.0 / Hi3536D_MPP_V1.0.1.0 B040, Dec 7 2017).";
        field {
            name = "hdr_y_addr";
            desc = "luma header address [PROVEN]";
            sw = rw;
            hw = r;
        } hdr_y_addr[31:0];
    } W_024 @ 0x24;

    reg {
        name = "Input header address C";
        desc = "Physical address of the chroma compression header of the input (stImgIn.u32HeaderPhyAddr[1]). Provenance: DYNAMIC: the vendor node builder (VGS_DrvCommSubmitJobToVgs -> VGS_DrvCommPrepareNodes -> VGS_DRV_SetVgsReg, GenSclCfg, VGSSplitAndCrop) was run under qemu-arm with a fake register file and swept one input at a time (2026-11-23, scripts/tools/vgs-static/). Static source: hi3536dv100_vgs.ko (SDK 2.0.2.0 / Hi3536D_MPP_V1.0.1.0 B040, Dec 7 2017).";
        field {
            name = "hdr_c_addr";
            desc = "chroma header address [PROVEN]";
            sw = rw;
            hw = r;
        } hdr_c_addr[31:0];
    } W_028 @ 0x28;

    reg {
        name = "Input luma address";
        desc = "Physical address of the first luma sample of the (cropped) input: stImgIn.u32PhyAddr[0] + crop_y * stride0 + crop_x (PROVEN, crop (16,8) gave +0x2810 with stride 1280). Provenance: DYNAMIC: the vendor node builder (VGS_DrvCommSubmitJobToVgs -> VGS_DrvCommPrepareNodes -> VGS_DRV_SetVgsReg, GenSclCfg, VGSSplitAndCrop) was run under qemu-arm with a fake register file and swept one input at a time (2026-11-23, scripts/tools/vgs-static/). Static source: hi3536dv100_vgs.ko (SDK 2.0.2.0 / Hi3536D_MPP_V1.0.1.0 B040, Dec 7 2017).";
        field {
            name = "in_y_addr";
            desc = "input luma address incl. crop offset [PROVEN]";
            sw = rw;
            hw = r;
        } in_y_addr[31:0];
    } W_02C @ 0x2C;

    reg {
        name = "Input chroma address";
        desc = "Physical address of the first chroma sample of the (cropped) input: stImgIn.u32PhyAddr[1] + (crop_y / 2 for 4:2:0) * stride1 + crop_x (PROVEN for 4:2:0: crop (16,8) gave +0x1410 with stride 1280). Provenance: DYNAMIC: the vendor node builder (VGS_DrvCommSubmitJobToVgs -> VGS_DrvCommPrepareNodes -> VGS_DRV_SetVgsReg, GenSclCfg, VGSSplitAndCrop) was run under qemu-arm with a fake register file and swept one input at a time (2026-11-23, scripts/tools/vgs-static/). Static source: hi3536dv100_vgs.ko (SDK 2.0.2.0 / Hi3536D_MPP_V1.0.1.0 B040, Dec 7 2017).";
        field {
            name = "in_c_addr";
            desc = "input chroma address incl. crop offset [PROVEN]";
            sw = rw;
            hw = r;
        } in_c_addr[31:0];
    } W_030 @ 0x30;

    reg {
        name = "Input strides";
        desc = "Line strides of the input planes in bytes. Provenance: DYNAMIC: the vendor node builder (VGS_DrvCommSubmitJobToVgs -> VGS_DrvCommPrepareNodes -> VGS_DRV_SetVgsReg, GenSclCfg, VGSSplitAndCrop) was run under qemu-arm with a fake register file and swept one input at a time (2026-11-23, scripts/tools/vgs-static/). Static source: hi3536dv100_vgs.ko (SDK 2.0.2.0 / Hi3536D_MPP_V1.0.1.0 B040, Dec 7 2017).";
        field {
            name = "in_stride_y";
            desc = "stImgIn.u32Stride[0] [PROVEN]";
            sw = rw;
            hw = r;
        } in_stride_y[15:0];
        field {
            name = "in_stride_c";
            desc = "stImgIn.u32Stride[1] [PROVEN]";
            sw = rw;
            hw = r;
        } in_stride_c[31:16];
    } W_034 @ 0x34;

    reg {
        name = "Flip / option word";
        desc = "Word 0x68. PROVEN (dynamic): a rotation task with angle 180 degrees (types 5 and 6 build identical nodes) sets bits 5:4 = 3 and nothing else changes (the node is a 1:1 scale node); user option u32 at +0x4B4 sets bit 8. INFERRED: bit 4 / bit 5 are the horizontal / vertical flip, which together make a 180 degree rotation. Provenance: DYNAMIC: the vendor node builder (VGS_DrvCommSubmitJobToVgs -> VGS_DrvCommPrepareNodes -> VGS_DRV_SetVgsReg, GenSclCfg, VGSSplitAndCrop) was run under qemu-arm with a fake register file and swept one input at a time (2026-11-23, scripts/tools/vgs-static/). Static source: hi3536dv100_vgs.ko (SDK 2.0.2.0 / Hi3536D_MPP_V1.0.1.0 B040, Dec 7 2017).";
        field {
            name = "flip_h";
            desc = "INFERRED horizontal flip (180 degree rotation sets both) [PROVEN trigger]";
            sw = rw;
            hw = r;
        } flip_h[4:4];
        field {
            name = "flip_v";
            desc = "INFERRED vertical flip [PROVEN trigger]";
            sw = rw;
            hw = r;
        } flip_v[5:5];
        field {
            name = "opt_b8";
            desc = "set by the user option at +0x4B4 [PROVEN trigger, meaning UNKNOWN]";
            sw = rw;
            hw = r;
        } opt_b8[8:8];
    } W_068 @ 0x68;

    reg {
        name = "Image word 0x6C";
        desc = "Image word 0x6C. PROVEN: written by VGS_DRV_SetVgsReg (3 records). Constants stored: none; ORed constants: none. Typical path conditions: stImgIn.enPixelFormat != 0x1D; a1[0x25C] != 0x0; a1[0x25C] == 0x0. Meaning UNKNOWN beyond the field sources.";
        field {
            name = "f_0_12";
            desc = "Field [12:0]. Sources (PROVEN expression, INFERRED naming): a1[0x25C]; a1[0x34].";
            sw = rw;
            hw = r;
        } f_0_12[12:0];
        field {
            name = "f_16_28";
            desc = "Field [28:16]. Sources (PROVEN expression, INFERRED naming): a1[0x25C]; a1[0x38].";
            sw = rw;
            hw = r;
        } f_16_28[28:16];
    } W_06C @ 0x6C;

    reg {
        name = "Output size";
        desc = "Output size minus one (the ROTATED size for 90/270 rotation tasks). Provenance: DYNAMIC: the vendor node builder (VGS_DrvCommSubmitJobToVgs -> VGS_DrvCommPrepareNodes -> VGS_DRV_SetVgsReg, GenSclCfg, VGSSplitAndCrop) was run under qemu-arm with a fake register file and swept one input at a time (2026-11-23, scripts/tools/vgs-static/). Static source: hi3536dv100_vgs.ko (SDK 2.0.2.0 / Hi3536D_MPP_V1.0.1.0 B040, Dec 7 2017).";
        field {
            name = "out_w_m1";
            desc = "output width - 1 [PROVEN]";
            sw = rw;
            hw = r;
        } out_w_m1[12:0];
        field {
            name = "out_h_m1";
            desc = "output height - 1 [PROVEN]";
            sw = rw;
            hw = r;
        } out_h_m1[28:16];
    } W_070 @ 0x70;

    reg {
        name = "Output luma address";
        desc = "Physical address of the output luma plane (stImgOut.u32PhyAddr[0]). Provenance: DYNAMIC: the vendor node builder (VGS_DrvCommSubmitJobToVgs -> VGS_DrvCommPrepareNodes -> VGS_DRV_SetVgsReg, GenSclCfg, VGSSplitAndCrop) was run under qemu-arm with a fake register file and swept one input at a time (2026-11-23, scripts/tools/vgs-static/). Static source: hi3536dv100_vgs.ko (SDK 2.0.2.0 / Hi3536D_MPP_V1.0.1.0 B040, Dec 7 2017).";
        field {
            name = "out_y_addr";
            desc = "output luma address [PROVEN]";
            sw = rw;
            hw = r;
        } out_y_addr[31:0];
    } W_074 @ 0x74;

    reg {
        name = "Output chroma address";
        desc = "Physical address of the output chroma plane (stImgOut.u32PhyAddr[1]). Provenance: DYNAMIC: the vendor node builder (VGS_DrvCommSubmitJobToVgs -> VGS_DrvCommPrepareNodes -> VGS_DRV_SetVgsReg, GenSclCfg, VGSSplitAndCrop) was run under qemu-arm with a fake register file and swept one input at a time (2026-11-23, scripts/tools/vgs-static/). Static source: hi3536dv100_vgs.ko (SDK 2.0.2.0 / Hi3536D_MPP_V1.0.1.0 B040, Dec 7 2017).";
        field {
            name = "out_c_addr";
            desc = "output chroma address [PROVEN]";
            sw = rw;
            hw = r;
        } out_c_addr[31:0];
    } W_078 @ 0x78;

    reg {
        name = "Output strides";
        desc = "Line strides of the output planes in bytes. Provenance: DYNAMIC: the vendor node builder (VGS_DrvCommSubmitJobToVgs -> VGS_DrvCommPrepareNodes -> VGS_DRV_SetVgsReg, GenSclCfg, VGSSplitAndCrop) was run under qemu-arm with a fake register file and swept one input at a time (2026-11-23, scripts/tools/vgs-static/). Static source: hi3536dv100_vgs.ko (SDK 2.0.2.0 / Hi3536D_MPP_V1.0.1.0 B040, Dec 7 2017).";
        field {
            name = "out_stride_y";
            desc = "stImgOut.u32Stride[0] [PROVEN]";
            sw = rw;
            hw = r;
        } out_stride_y[15:0];
        field {
            name = "out_stride_c";
            desc = "stImgOut.u32Stride[1] [PROVEN]";
            sw = rw;
            hw = r;
        } out_stride_c[31:16];
    } W_07C @ 0x7C;

    reg {
        name = "Input header strides";
        desc = "Strides of the compression headers (only meaningful for compressed input; 0 otherwise). Provenance: DYNAMIC: the vendor node builder (VGS_DrvCommSubmitJobToVgs -> VGS_DrvCommPrepareNodes -> VGS_DRV_SetVgsReg, GenSclCfg, VGSSplitAndCrop) was run under qemu-arm with a fake register file and swept one input at a time (2026-11-23, scripts/tools/vgs-static/). Static source: hi3536dv100_vgs.ko (SDK 2.0.2.0 / Hi3536D_MPP_V1.0.1.0 B040, Dec 7 2017).";
        field {
            name = "hdr_stride_y";
            desc = "stImgIn.u32HeaderStride[0] [PROVEN]";
            sw = rw;
            hw = r;
        } hdr_stride_y[9:0];
        field {
            name = "hdr_stride_c";
            desc = "stImgIn.u32HeaderStride[1] [PROVEN]";
            sw = rw;
            hw = r;
        } hdr_stride_c[25:16];
    } W_0D8 @ 0xD8;

    reg {
        name = "Image word 0xF0";
        desc = "Image word 0xF0. PROVEN: written by VGS_DRV_SetVgsReg (1 records). Constants stored: none; ORed constants: none. Typical path conditions: stImgIn.enPixelFormat != 0x1D; a7 != 0xFFFFFFFF. Meaning UNKNOWN beyond the field sources. BOARD run 3 2026-11-24: 0x10 and 0x80000 in a plain 2:1 scaling change nothing (output identical to the run without them); effect still unknown.";
        field {
            name = "word";
            desc = "32-bit word (no struct-member source found). BOARD run 3: no effect of 0x10 / 0x80000 on a 2:1 scaling.";
            sw = rw;
            hw = r;
        } word[31:0];
    } W_0F0 @ 0xF0;

    reg {
        name = "Node id";
        desc = "Node id: written by VGS_HAL_SetNodeID with the CPU address of the node image (VGS_DrvCommStartWaitlist: 0, 1, 2 ... along the nodes of one job); read back through MMIO 0xF4 in the interrupt handler. Provenance: DYNAMIC: the vendor node builder (VGS_DrvCommSubmitJobToVgs -> VGS_DrvCommPrepareNodes -> VGS_DRV_SetVgsReg, GenSclCfg, VGSSplitAndCrop) was run under qemu-arm with a fake register file and swept one input at a time (2026-11-23, scripts/tools/vgs-static/). Static source: hi3536dv100_vgs.ko (SDK 2.0.2.0 / Hi3536D_MPP_V1.0.1.0 B040, Dec 7 2017).";
        field {
            name = "node_id";
            desc = "id of the node in its job [PROVEN]";
            sw = rw;
            hw = r;
        } node_id[31:0];
    } W_0F4 @ 0xF4;

    reg {
        name = "Interrupt mask";
        desc = "Interrupt mask: written by VGS_HAL_SetMask with the CPU address of the node image: 0 on every node but the last of a job, 0x87 on the last node. Provenance: DYNAMIC: the vendor node builder (VGS_DrvCommSubmitJobToVgs -> VGS_DrvCommPrepareNodes -> VGS_DRV_SetVgsReg, GenSclCfg, VGSSplitAndCrop) was run under qemu-arm with a fake register file and swept one input at a time (2026-11-23, scripts/tools/vgs-static/). Static source: hi3536dv100_vgs.ko (SDK 2.0.2.0 / Hi3536D_MPP_V1.0.1.0 B040, Dec 7 2017).";
        field {
            name = "int_mask";
            desc = "0x87 on the last node of a job, 0 otherwise [PROVEN values, INFERRED meaning]";
            sw = rw;
            hw = r;
        } int_mask[31:0];
    } W_0FC @ 0xFC;

    reg {
        name = "Image word 0x110";
        desc = "Image word 0x110. PROVEN: written by VGS_DRV_SetVgsReg (3 records). Constants stored: none; ORed constants: none. Typical path conditions: stImgIn.enPixelFormat != 0x1D; a1[0x198] == 0x0; a1[0x1E8] != 0x0. Meaning UNKNOWN beyond the field sources.";
        field {
            name = "f_0_12";
            desc = "Field [12:0]. Sources (PROVEN expression, INFERRED naming): a1[0x88]; a1[0x8C].";
            sw = rw;
            hw = r;
        } f_0_12[12:0];
        field {
            name = "f_16_28";
            desc = "Field [28:16]. Sources (PROVEN expression, INFERRED naming): a1[0x88]; a1[0x90].";
            sw = rw;
            hw = r;
        } f_16_28[28:16];
    } W_110 @ 0x110;

    reg {
        name = "Image word 0x114";
        desc = "Image word 0x114. PROVEN: written by VGS_DRV_SetVgsReg (3 records). Constants stored: none; ORed constants: none. Typical path conditions: stImgIn.enPixelFormat != 0x1D; a1[0x198] == 0x0; a1[0x25C] != 0x0. Meaning UNKNOWN beyond the field sources.";
        field {
            name = "f_0_12";
            desc = "Field [12:0]. Sources (PROVEN expression, INFERRED naming): a1[0x88]; sub(a1[0x94],0x1).";
            sw = rw;
            hw = r;
        } f_0_12[12:0];
        field {
            name = "f_16_28";
            desc = "Field [28:16]. Sources (PROVEN expression, INFERRED naming): a1[0x88]; sub(a1[0x98],0x1).";
            sw = rw;
            hw = r;
        } f_16_28[28:16];
        field {
            name = "f_31_31";
            desc = "Field [31:31]. Sources (PROVEN expression, INFERRED naming): a1[0x88].";
            sw = rw;
            hw = r;
        } f_31_31[31:31];
    } W_114 @ 0x114;

    reg {
        name = "Image word 0x120";
        desc = "Image word 0x120. PROVEN: written by VGS_DRV_SetVgsReg (1 records). Constants stored: none; ORed constants: none. Typical path conditions: stImgIn.enPixelFormat != 0x1D; a1[0x70] != 0x1; a7 != 0xFFFFFFFF. Meaning UNKNOWN beyond the field sources.";
        field {
            name = "word";
            desc = "32-bit word (no struct-member source found).";
            sw = rw;
            hw = r;
        } word[31:0];
    } W_120 @ 0x120;

    reg {
        name = "Image word 0x124";
        desc = "Image word 0x124. PROVEN: written by VGS_DRV_SetVgsReg (1 records). Constants stored: none; ORed constants: none. Typical path conditions: stImgIn.enPixelFormat != 0x1D; a1[0x70] != 0x1; a7 != 0xFFFFFFFF. Meaning UNKNOWN beyond the field sources.";
        field {
            name = "word";
            desc = "32-bit word (no struct-member source found).";
            sw = rw;
            hw = r;
        } word[31:0];
    } W_124 @ 0x124;

    reg {
        name = "Image word 0x140";
        desc = "Image word 0x140. PROVEN: written by VGS_DRV_SetVgsReg (4 records). Constants stored: none; ORed constants: none. Typical path conditions: stImgIn.enPixelFormat != 0x1D; a1[0x198] == 0x0; a1[0x1CC] != 0x0. Meaning UNKNOWN beyond the field sources.";
        field {
            name = "f_0_12";
            desc = "Field [12:0]. Sources (PROVEN expression, INFERRED naming): a1[0x1CC]; a1[0x1D0]; sel(a1[0x1CC] != 0x0?and(sel(a1[0x1CC] == 0x0?a1[0x1CC]:sel(a1[0x1CC] != 0x0?a1[0x1D0]:sel; sel(a1[0x1CC] != 0x0?and(sel(a1[0x1CC] == 0x0?a1[0x1CC]:sel(a1[0x1CC] != 0x0?a1[0x1D0]:u)).";
            sw = rw;
            hw = r;
        } f_0_12[12:0];
        field {
            name = "f_16_28";
            desc = "Field [28:16]. Sources (PROVEN expression, INFERRED naming): a1[0x1CC]; a1[0x1D4]; sel(a1[0x1CC] != 0x0?and(sel(a1[0x1CC] != 0x0?a1[0x1D4]:a1[0x1CC]),0x1FFF):sel(a1[0x1CC] !.";
            sw = rw;
            hw = r;
        } f_16_28[28:16];
    } W_140 @ 0x140;

    reg {
        name = "Image word 0x144";
        desc = "Image word 0x144. PROVEN: written by VGS_DRV_SetVgsReg (3 records). Constants stored: none; ORed constants: none. Typical path conditions: stImgIn.enPixelFormat != 0x1D; a1[0x198] == 0x0; a1[0x1CC] != 0x0. Meaning UNKNOWN beyond the field sources.";
        field {
            name = "f_0_12";
            desc = "Field [12:0]. Sources (PROVEN expression, INFERRED naming): a1[0x1CC]; sub(a1[0x1D8],0x1).";
            sw = rw;
            hw = r;
        } f_0_12[12:0];
        field {
            name = "f_16_28";
            desc = "Field [28:16]. Sources (PROVEN expression, INFERRED naming): a1[0x1CC]; sub(a1[0x1DC],0x1).";
            sw = rw;
            hw = r;
        } f_16_28[28:16];
    } W_144 @ 0x144;

    reg {
        name = "Image word 0x150";
        desc = "Image word 0x150. PROVEN: written by VGS_DRV_SetVgsReg (4 records). Constants stored: none; ORed constants: none. Typical path conditions: stImgIn.enPixelFormat != 0x1D; a1[0x198] == 0x0; a1[0x1CC] != 0x0. Meaning UNKNOWN beyond the field sources.";
        field {
            name = "f_0_12";
            desc = "Field [12:0]. Sources (PROVEN expression, INFERRED naming): a1[0x25C]; sub(add(a6,lsl(a7,0x2))[0x9E4],0x1); sub(stImgOut.u32Width,0x1).";
            sw = rw;
            hw = r;
        } f_0_12[12:0];
        field {
            name = "f_16_28";
            desc = "Field [28:16]. Sources (PROVEN expression, INFERRED naming): a1[0x25C]; sub(stImgOut.u32Height,0x1).";
            sw = rw;
            hw = r;
        } f_16_28[28:16];
    } W_150 @ 0x150;

    reg {
        name = "Image word 0x154";
        desc = "Image word 0x154. PROVEN: written by VGS_DRV_SetVgsReg (4 records). Constants stored: none; ORed constants: none. Typical path conditions: stImgIn.enPixelFormat != 0x1D; a1[0x198] == 0x0; a1[0x25C] != 0x0. Meaning UNKNOWN beyond the field sources.";
        field {
            name = "f_0_12";
            desc = "Field [12:0]. Sources (PROVEN expression, INFERRED naming): a1[0x25C]; a1[0x260]; add(a6,lsl(add(a7,0x27C),0x2))[0x0].";
            sw = rw;
            hw = r;
        } f_0_12[12:0];
        field {
            name = "f_16_28";
            desc = "Field [28:16]. Sources (PROVEN expression, INFERRED naming): a1[0x25C]; a1[0x264].";
            sw = rw;
            hw = r;
        } f_16_28[28:16];
    } W_154 @ 0x154;

    reg {
        name = "Image word 0x158";
        desc = "Image word 0x158. PROVEN: written by VGS_DRV_SetVgsReg (7 records). Constants stored: none; ORed constants: none. Typical path conditions: stImgIn.enPixelFormat != 0x1D; a1[0x198] == 0x0; a1[0x1E8] != 0x0. Meaning UNKNOWN beyond the field sources.";
        field {
            name = "f_0_12";
            desc = "Field [12:0]. Sources (PROVEN expression, INFERRED naming): a1[0x25C]; sub(a1[0x268],0x1); sub(add(a6,lsl(a7,0x2))[0x9FC],0x1); sub(sel(a7 != 0xFFFFFFFF?add(a6,lsl(a7,0x2))[0x9FC]:sel(a7 == 0xFFFFFFFF?a1[0x268]:a1[0x25; sub(sel(a7 != 0xFFFFFFFF?sel(a7 != 0xFFFFFFFF?add(a6,lsl(a7,0x2)):a1[0x25C])[0x9FC]:sel(a7; sub(sel(a7 != 0xFFFFFFFF?u:sel(a7 == 0xFFFFFFFF?.";
            sw = rw;
            hw = r;
        } f_0_12[12:0];
        field {
            name = "f_16_28";
            desc = "Field [28:16]. Sources (PROVEN expression, INFERRED naming): a1[0x25C]; sub(a1[0x26C],0x1).";
            sw = rw;
            hw = r;
        } f_16_28[28:16];
    } W_158 @ 0x158;

    reg {
        name = "Image word 0x15C";
        desc = "Image word 0x15C. PROVEN: written by VGS_DRV_SetVgsReg (6 records). Constants stored: none; ORed constants: none. Typical path conditions: stImgIn.enPixelFormat != 0x1D; a1[0x198] == 0x0; a1[0x25C] != 0x0. Meaning UNKNOWN beyond the field sources.";
        field {
            name = "f_0_7";
            desc = "Field [7:0]. Sources (PROVEN expression, INFERRED naming): a1[0x25C]; a1[0x270]; sel(a1[0x25C] != 0x0?and(sel(a1[0x25C] != 0x0?a1[0x270]:a1[0x25C]),0xFF):sel(a1[0x25C] == .";
            sw = rw;
            hw = r;
        } f_0_7[7:0];
        field {
            name = "f_8_15";
            desc = "Field [15:8]. Sources (PROVEN expression, INFERRED naming): a1[0x25C]; lsr(a1[0x270],0x8); sel(a1[0x25C] != 0x0?and(lsr(sel(a1[0x25C] != 0x0?a1[0x270]:a1[0x25C]),0x8),0xFF):sel(a1[0.";
            sw = rw;
            hw = r;
        } f_8_15[15:8];
        field {
            name = "f_16_23";
            desc = "Field [23:16]. Sources (PROVEN expression, INFERRED naming): a1[0x25C]; lsr(a1[0x270],0x10); sel(a1[0x25C] != 0x0?and(lsr(sel(a1[0x25C] != 0x0?a1[0x270]:a1[0x25C]),0x10),0xFF):sel(a1[.";
            sw = rw;
            hw = r;
        } f_16_23[23:16];
        field {
            name = "f_24_31";
            desc = "Field [31:24]. Sources (PROVEN expression, INFERRED naming): a1[0x25C]; lsr(a1[0x270],0x18); sel(a1[0x25C] != 0x0?lsr(sel(a1[0x25C] != 0x0?a1[0x270]:a1[0x25C]),0x18):sel(a1[0x25C] != .";
            sw = rw;
            hw = r;
        } f_24_31[31:24];
    } W_15C @ 0x15C;

    reg {
        name = "Image word 0x1A0";
        desc = "Image word 0x1A0. PROVEN: written by VGS_DRV_SetVgsReg (2 records). Constants stored: none; ORed constants: none. Typical path conditions: stImgIn.enPixelFormat != 0x1D; a1[0x54] != 0x0; a1[0x54] == 0x0. Meaning UNKNOWN beyond the field sources.";
        field {
            name = "f_0_12";
            desc = "Field [12:0]. Sources (PROVEN expression, INFERRED naming): a1[0x54]; add(a6,lsl(a7,0x2))[0x9C].";
            sw = rw;
            hw = r;
        } f_0_12[12:0];
        field {
            name = "f_16_28";
            desc = "Field [28:16]. Sources (PROVEN expression, INFERRED naming): a1[0x54]; sub(add(a6,lsl(a7,0x2))[0x60],0x1).";
            sw = rw;
            hw = r;
        } f_16_28[28:16];
    } W_1A0 @ 0x1A0;

    reg {
        name = "Image word 0x1B0";
        desc = "Image word 0x1B0. PROVEN: written by VGS_DRV_SetVgsReg (7 records). Constants stored: 0x0; ORed constants: none. Typical path conditions: stImgIn.enPixelFormat != 0x1D; a1[0x198] == 0x0; a1[0x1E8] != 0x0. Meaning UNKNOWN beyond the field sources.";
        field {
            name = "f_0_3";
            desc = "Field [3:0]. Sources (PROVEN expression, INFERRED naming): sel(add(a7,0x1) >u 0x1?0x0:a1[0x54]); sel(add(a7,0x1) >u 0x1?0x0:and(add(a6,lsl(a7,0x2))[0x9C],0x1FFF)).";
            sw = rw;
            hw = r;
        } f_0_3[3:0];
        field {
            name = "f_4_7";
            desc = "Field [7:4]. Sources (PROVEN expression, INFERRED naming): a1[0x5C]; sel(sub(a6[0xB10],0x1) != a7?0x0:sel(sub(a6[0xB10],0x1) == a7?a1[0x5C]:sel(sub(a6[0xB10],0.";
            sw = rw;
            hw = r;
        } f_4_7[7:4];
        field {
            name = "f_8_11";
            desc = "Field [11:8]. Sources (PROVEN expression, INFERRED naming): a1[0x60].";
            sw = rw;
            hw = r;
        } f_8_11[11:8];
        field {
            name = "f_12_15";
            desc = "Field [15:12]. Sources (PROVEN expression, INFERRED naming): a1[0x64].";
            sw = rw;
            hw = r;
        } f_12_15[15:12];
    } W_1B0 @ 0x1B0;

    reg {
        name = "Image word 0x1B4";
        desc = "Image word 0x1B4. PROVEN: written by VGS_DRV_SetVgsReg (16 records). Constants stored: none; ORed constants: none. Typical path conditions: stImgIn.enPixelFormat != 0x1D; a1[0x198] == 0x0; a1[0x1E8] != 0x0. Meaning UNKNOWN beyond the field sources.";
        field {
            name = "f_0_7";
            desc = "Field [7:0]. Sources (PROVEN expression, INFERRED naming): lsr(a1[0x68],0x10); sel(a1[0x54] != 0x0?lsr(a1[0x68],0x10):sel(a1[0x25C] != 0x0?and(lsr(sel(a1[0x25C] != 0x0?a; sel(a1[0x54] != 0x0?lsr(a1[0x68],0x10):u); sel(a1[0x54] != 0x0?lsr(sel(a1[0x54] != 0x0?a1[0x68]:a1[0x54]),0x10):a1[0x25C]); sel(a1[0x54] != 0x0?lsr(sel(a1[0x54] != 0x0?a1[0x68]:a1[0x54]),0.";
            sw = rw;
            hw = r;
        } f_0_7[7:0];
        field {
            name = "f_8_15";
            desc = "Field [15:8]. Sources (PROVEN expression, INFERRED naming): lsr(a1[0x68],0x8); sel(a1[0x54] != 0x0?lsr(a1[0x68],0x8):a1[0x60]); sel(a1[0x54] != 0x0?lsr(sel(a1[0x54] != 0x0?a1[0x68]:a1[0x54]),0x8):a1[0x60]); sel(a1[0x54] != 0x0?lsr(sel(a1[0x54] != 0x0?a1[0x68]:a1[0x54]),0x8):and(add(a6,lsl(a7,0x2).";
            sw = rw;
            hw = r;
        } f_8_15[15:8];
        field {
            name = "f_16_23";
            desc = "Field [23:16]. Sources (PROVEN expression, INFERRED naming): a1[0x68]; sel(a1[0x54] != 0x0?a1[0x68]:a1[0x54]).";
            sw = rw;
            hw = r;
        } f_16_23[23:16];
    } W_1B4 @ 0x1B4;

    reg {
        name = "Enable word";
        desc = "Word 0x1D4: bit 31 is set in every node built (PROVEN, dynamic); bit 0 comes from the split/luma-statistics parameter table (zero in the single-node scale path). Provenance: DYNAMIC: the vendor node builder (VGS_DrvCommSubmitJobToVgs -> VGS_DrvCommPrepareNodes -> VGS_DRV_SetVgsReg, GenSclCfg, VGSSplitAndCrop) was run under qemu-arm with a fake register file and swept one input at a time (2026-11-23, scripts/tools/vgs-static/). Static source: hi3536dv100_vgs.ko (SDK 2.0.2.0 / Hi3536D_MPP_V1.0.1.0 B040, Dec 7 2017).";
        field {
            name = "opt_b0";
            desc = "zero in the scale/crop/convert nodes [PROVEN value, meaning UNKNOWN]";
            sw = rw;
            hw = r;
        } opt_b0[0:0];
        field {
            name = "const_31";
            desc = "always 1 [PROVEN value, meaning UNKNOWN]";
            sw = rw;
            hw = r;
        } const_31[31:31];
    } W_1D4 @ 0x1D4;

    reg {
        name = "Image word 0x1D8";
        desc = "Image word 0x1D8. PROVEN: written by VGS_DRV_SetVgsReg (1 records). Constants stored: none; ORed constants: none. Typical path conditions: stImgIn.enPixelFormat != 0x1D; a1[0x54] != 0x0; a1[0x70] != 0x1. Meaning UNKNOWN beyond the field sources.";
        field {
            name = "f_0_12";
            desc = "Field [12:0]. Sources (PROVEN expression, INFERRED naming): add(a6,lsl(a7,0x2))[0x834].";
            sw = rw;
            hw = r;
        } f_0_12[12:0];
        field {
            name = "f_13_25";
            desc = "Field [25:13]. Sources (PROVEN expression, INFERRED naming): a1[0x1C0].";
            sw = rw;
            hw = r;
        } f_13_25[25:13];
    } W_1D8 @ 0x1D8;

    reg {
        name = "Image word 0x1F8";
        desc = "Image word 0x1F8. PROVEN: written by VGS_DRV_SetVgsReg (1 records). Constants stored: none; ORed constants: none. Typical path conditions: stImgIn.enPixelFormat != 0x1D; a1[0x54] != 0x0; a1[0x70] != 0x1. Meaning UNKNOWN beyond the field sources.";
        field {
            name = "f_0_7";
            desc = "Field [7:0]. Sources (PROVEN expression, INFERRED naming): a1[0x1A4].";
            sw = rw;
            hw = r;
        } f_0_7[7:0];
    } W_1F8 @ 0x1F8;

    reg {
        name = "Coefficient table, horizontal luma";
        desc = "Physical address of the horizontal luma scaler coefficient table, as returned by SYS_DRV_GetScaleCoef of hi3536dv100_sys.ko (PROVEN: the sys module run under qemu-arm returns base + table offset of its 0x7D10 byte coefficient buffer; GenSclCfg copies the four results to 0x200..0x20C). Table format (PROVEN from the sys module output): 17 phases (positions 0..16 of 32, the hardware mirrors the other half: INFERRED), horizontal luma 6 taps = 3 words per phase, the other three tables 4 taps = 2 words per phase; taps are 10-bit two's complement in 16-bit lanes (lane 0 = bits 15:0 of word 0), unity gain 512 (every phase sums to 512), center sample at lane 2 (6-tap) / lane 1 (4-tap). Provenance: DYNAMIC: the vendor node builder (VGS_DrvCommSubmitJobToVgs -> VGS_DrvCommPrepareNodes -> VGS_DRV_SetVgsReg, GenSclCfg, VGSSplitAndCrop) was run under qemu-arm with a fake register file and swept one input at a time (2026-11-23, scripts/tools/vgs-static/). Static source: hi3536dv100_vgs.ko (SDK 2.0.2.0 / Hi3536D_MPP_V1.0.1.0 B040, Dec 7 2017).";
        field {
            name = "hor_luma_coef_addr";
            desc = "physical address of the table [PROVEN value, INFERRED that the engine reads it as a physical address]";
            sw = rw;
            hw = r;
        } hor_luma_coef_addr[31:0];
    } W_200 @ 0x200;

    reg {
        name = "Coefficient table, vertical luma";
        desc = "Physical address of the vertical luma coefficient table (4 taps, 17 phases, 2 words per phase). Same provenance as 0x200. Provenance: DYNAMIC: the vendor node builder (VGS_DrvCommSubmitJobToVgs -> VGS_DrvCommPrepareNodes -> VGS_DRV_SetVgsReg, GenSclCfg, VGSSplitAndCrop) was run under qemu-arm with a fake register file and swept one input at a time (2026-11-23, scripts/tools/vgs-static/). Static source: hi3536dv100_vgs.ko (SDK 2.0.2.0 / Hi3536D_MPP_V1.0.1.0 B040, Dec 7 2017).";
        field {
            name = "ver_luma_coef_addr";
            desc = "physical address of the table";
            sw = rw;
            hw = r;
        } ver_luma_coef_addr[31:0];
    } W_204 @ 0x204;

    reg {
        name = "Coefficient table, horizontal chroma";
        desc = "Physical address of the horizontal chroma coefficient table (4 taps, 17 phases). Same provenance as 0x200. Provenance: DYNAMIC: the vendor node builder (VGS_DrvCommSubmitJobToVgs -> VGS_DrvCommPrepareNodes -> VGS_DRV_SetVgsReg, GenSclCfg, VGSSplitAndCrop) was run under qemu-arm with a fake register file and swept one input at a time (2026-11-23, scripts/tools/vgs-static/). Static source: hi3536dv100_vgs.ko (SDK 2.0.2.0 / Hi3536D_MPP_V1.0.1.0 B040, Dec 7 2017).";
        field {
            name = "hor_chroma_coef_addr";
            desc = "physical address of the table";
            sw = rw;
            hw = r;
        } hor_chroma_coef_addr[31:0];
    } W_208 @ 0x208;

    reg {
        name = "Coefficient table, vertical chroma";
        desc = "Physical address of the vertical chroma coefficient table (4 taps, 17 phases). Same provenance as 0x200. Provenance: DYNAMIC: the vendor node builder (VGS_DrvCommSubmitJobToVgs -> VGS_DrvCommPrepareNodes -> VGS_DRV_SetVgsReg, GenSclCfg, VGSSplitAndCrop) was run under qemu-arm with a fake register file and swept one input at a time (2026-11-23, scripts/tools/vgs-static/). Static source: hi3536dv100_vgs.ko (SDK 2.0.2.0 / Hi3536D_MPP_V1.0.1.0 B040, Dec 7 2017).";
        field {
            name = "ver_chroma_coef_addr";
            desc = "physical address of the table";
            sw = rw;
            hw = r;
        } ver_chroma_coef_addr[31:0];
    } W_20C @ 0x20C;

    reg {
        name = "Parameter block pointer 0";
        desc = "Physical address of a parameter block INSIDE this node: node address + 0x340 (PROVEN, SetVgsReg argument a4 + 0x340). The words 0x340.. of the image are the contents of such blocks. Provenance: DYNAMIC: the vendor node builder (VGS_DrvCommSubmitJobToVgs -> VGS_DrvCommPrepareNodes -> VGS_DRV_SetVgsReg, GenSclCfg, VGSSplitAndCrop) was run under qemu-arm with a fake register file and swept one input at a time (2026-11-23, scripts/tools/vgs-static/). Static source: hi3536dv100_vgs.ko (SDK 2.0.2.0 / Hi3536D_MPP_V1.0.1.0 B040, Dec 7 2017).";
        field {
            name = "blk0_addr";
            desc = "node address + 0x340 [PROVEN]";
            sw = rw;
            hw = r;
        } blk0_addr[31:0];
    } W_240 @ 0x240;

    reg {
        name = "Parameter block pointer 1";
        desc = "node address + 0x5A0 (PROVEN). Provenance: DYNAMIC: the vendor node builder (VGS_DrvCommSubmitJobToVgs -> VGS_DrvCommPrepareNodes -> VGS_DRV_SetVgsReg, GenSclCfg, VGSSplitAndCrop) was run under qemu-arm with a fake register file and swept one input at a time (2026-11-23, scripts/tools/vgs-static/). Static source: hi3536dv100_vgs.ko (SDK 2.0.2.0 / Hi3536D_MPP_V1.0.1.0 B040, Dec 7 2017).";
        field {
            name = "blk1_addr";
            desc = "node address + 0x5A0 [PROVEN]";
            sw = rw;
            hw = r;
        } blk1_addr[31:0];
    } W_244 @ 0x244;

    reg {
        name = "Parameter block pointer 2";
        desc = "node address + 0x380 (PROVEN). Provenance: DYNAMIC: the vendor node builder (VGS_DrvCommSubmitJobToVgs -> VGS_DrvCommPrepareNodes -> VGS_DRV_SetVgsReg, GenSclCfg, VGSSplitAndCrop) was run under qemu-arm with a fake register file and swept one input at a time (2026-11-23, scripts/tools/vgs-static/). Static source: hi3536dv100_vgs.ko (SDK 2.0.2.0 / Hi3536D_MPP_V1.0.1.0 B040, Dec 7 2017).";
        field {
            name = "blk2_addr";
            desc = "node address + 0x380 [PROVEN]";
            sw = rw;
            hw = r;
        } blk2_addr[31:0];
    } W_248 @ 0x248;

    reg {
        name = "Parameter block pointer 3";
        desc = "node address + 0x620 (PROVEN). Provenance: DYNAMIC: the vendor node builder (VGS_DrvCommSubmitJobToVgs -> VGS_DrvCommPrepareNodes -> VGS_DRV_SetVgsReg, GenSclCfg, VGSSplitAndCrop) was run under qemu-arm with a fake register file and swept one input at a time (2026-11-23, scripts/tools/vgs-static/). Static source: hi3536dv100_vgs.ko (SDK 2.0.2.0 / Hi3536D_MPP_V1.0.1.0 B040, Dec 7 2017).";
        field {
            name = "blk3_addr";
            desc = "node address + 0x620 [PROVEN]";
            sw = rw;
            hw = r;
        } blk3_addr[31:0];
    } W_24C @ 0x24C;

    reg {
        name = "Image word 0x250";
        desc = "Image word 0x250. PROVEN: written by VGS_DRV_SetVgsReg (1 records). Constants stored: none; ORed constants: none. Typical path conditions: stImgIn.enPixelFormat != 0x1D; a1[0x54] != 0x0; a1[0x70] != 0x1. Meaning UNKNOWN beyond the field sources.";
        field {
            name = "word";
            desc = "32-bit word (no struct-member source found).";
            sw = rw;
            hw = r;
        } word[31:0];
    } W_250 @ 0x250;

    reg {
        name = "Parameter block pointer 4";
        desc = "node address + 0x420 (PROVEN). Provenance: DYNAMIC: the vendor node builder (VGS_DrvCommSubmitJobToVgs -> VGS_DrvCommPrepareNodes -> VGS_DRV_SetVgsReg, GenSclCfg, VGSSplitAndCrop) was run under qemu-arm with a fake register file and swept one input at a time (2026-11-23, scripts/tools/vgs-static/). Static source: hi3536dv100_vgs.ko (SDK 2.0.2.0 / Hi3536D_MPP_V1.0.1.0 B040, Dec 7 2017).";
        field {
            name = "blk4_addr";
            desc = "node address + 0x420 [PROVEN]";
            sw = rw;
            hw = r;
        } blk4_addr[31:0];
    } W_260 @ 0x260;

    reg {
        name = "Image word 0x264";
        desc = "Image word 0x264. PROVEN: written by VGS_DRV_SetVgsReg (1 records). Constants stored: none; ORed constants: none. Typical path conditions: stImgIn.enPixelFormat != 0x1D; a1[0x54] != 0x0; a1[0x70] != 0x1. Meaning UNKNOWN beyond the field sources.";
        field {
            name = "word";
            desc = "32-bit word (no struct-member source found).";
            sw = rw;
            hw = r;
        } word[31:0];
    } W_264 @ 0x264;

    reg {
        name = "Image word 0x268";
        desc = "Image word 0x268. PROVEN: written by VGS_DRV_SetVgsReg (1 records). Constants stored: none; ORed constants: none. Typical path conditions: stImgIn.enPixelFormat != 0x1D; a1[0x54] != 0x0; a1[0x70] != 0x1. Meaning UNKNOWN beyond the field sources.";
        field {
            name = "f_0_12";
            desc = "Field [12:0]. Sources (PROVEN expression, INFERRED naming): sub(add(a6,lsl(a7,0x2))[0xCC],0x1).";
            sw = rw;
            hw = r;
        } f_0_12[12:0];
        field {
            name = "f_16_28";
            desc = "Field [28:16]. Sources (PROVEN expression, INFERRED naming): add(a6,lsl(a7,0x2))[0x90].";
            sw = rw;
            hw = r;
        } f_16_28[28:16];
    } W_268 @ 0x268;

    reg {
        name = "Parameter block pointer 5";
        desc = "node address + 0x520 (PROVEN). Provenance: DYNAMIC: the vendor node builder (VGS_DrvCommSubmitJobToVgs -> VGS_DrvCommPrepareNodes -> VGS_DRV_SetVgsReg, GenSclCfg, VGSSplitAndCrop) was run under qemu-arm with a fake register file and swept one input at a time (2026-11-23, scripts/tools/vgs-static/). Static source: hi3536dv100_vgs.ko (SDK 2.0.2.0 / Hi3536D_MPP_V1.0.1.0 B040, Dec 7 2017).";
        field {
            name = "blk5_addr";
            desc = "node address + 0x520 [PROVEN]";
            sw = rw;
            hw = r;
        } blk5_addr[31:0];
    } W_270 @ 0x270;

    reg {
        name = "Image word 0x294";
        desc = "Image word 0x294. PROVEN: written by VGS_DRV_SetVgsReg (1 records). Constants stored: none; ORed constants: none. Typical path conditions: stImgIn.enPixelFormat != 0x1D; a1[0x54] != 0x0; a1[0x70] != 0x1. Meaning UNKNOWN beyond the field sources.";
        field {
            name = "word";
            desc = "32-bit word (no struct-member source found).";
            sw = rw;
            hw = r;
        } word[31:0];
    } W_294 @ 0x294;

    reg {
        name = "Image word 0x298";
        desc = "Image word 0x298. PROVEN: written by VGS_DRV_SetVgsReg (1 records). Constants stored: none; ORed constants: none. Typical path conditions: stImgIn.enPixelFormat != 0x1D; a1[0x54] != 0x0; a1[0x70] != 0x1. Meaning UNKNOWN beyond the field sources.";
        field {
            name = "word";
            desc = "32-bit word (no struct-member source found).";
            sw = rw;
            hw = r;
        } word[31:0];
    } W_298 @ 0x298;

    reg {
        name = "Next node address";
        desc = "Next node address of the job list: written by VGS_HAL_SetNext with the CPU address of the node image: physical address of the next node, 0 on the last node of a job. MMIO 0x2FC (vgs.rdl NEXT_NODE) takes the address of the first node. Provenance: DYNAMIC: the vendor node builder (VGS_DrvCommSubmitJobToVgs -> VGS_DrvCommPrepareNodes -> VGS_DRV_SetVgsReg, GenSclCfg, VGSSplitAndCrop) was run under qemu-arm with a fake register file and swept one input at a time (2026-11-23, scripts/tools/vgs-static/). Static source: hi3536dv100_vgs.ko (SDK 2.0.2.0 / Hi3536D_MPP_V1.0.1.0 B040, Dec 7 2017).";
        field {
            name = "next_node_addr";
            desc = "physical address of the next node, 0 = end of the list [PROVEN]";
            sw = rw;
            hw = r;
        } next_node_addr[31:0];
    } W_2FC @ 0x2FC;

    reg {
        name = "Horizontal scale";
        desc = "Horizontal scaler word of the first parameter block. PROVEN (dynamic): bits 23:0 = floor(in_width << 20 / out_width), i.e. input samples per output sample in Q20 (2:1 = 0x200000; width is the cropped input width); bits 31:30 are set when the horizontal filter is used (cleared when in_width == out_width and bForceHFilt is 0); bits 27:24 = 7 in every node built. Provenance: DYNAMIC: the vendor node builder (VGS_DrvCommSubmitJobToVgs -> VGS_DrvCommPrepareNodes -> VGS_DRV_SetVgsReg, GenSclCfg, VGSSplitAndCrop) was run under qemu-arm with a fake register file and swept one input at a time (2026-11-23, scripts/tools/vgs-static/). Static source: hi3536dv100_vgs.ko (SDK 2.0.2.0 / Hi3536D_MPP_V1.0.1.0 B040, Dec 7 2017).";
        field {
            name = "hstep";
            desc = "in/out horizontal ratio, Q20 [PROVEN]";
            sw = rw;
            hw = r;
        } hstep[23:0];
        field {
            name = "const_24_27";
            desc = "always 7 [PROVEN value, meaning UNKNOWN]";
            sw = rw;
            hw = r;
        } const_24_27[27:24];
        field {
            name = "hfilt_en";
            desc = "3 = horizontal filter on, 0 = off [PROVEN]";
            sw = rw;
            hw = r;
        } hfilt_en[31:30];
    } W_340 @ 0x340;

    reg {
        name = "Image word 0x344";
        desc = "Image word 0x344. PROVEN: written by VGS_DRV_SetVgsReg (1 records). Constants stored: none; ORed constants: none. Typical path conditions: stImgIn.enPixelFormat != 0x1D; a1[0x54] != 0x0; a1[0x70] != 0x1. Meaning UNKNOWN beyond the field sources. BOARD run 3 2026-11-24 (a plain 2:1 scaling with the word patched into the node): 8 changes nothing; 0x80000 (2^19) moves the horizontal sampling grid of the LUMA by +0.5 input sample (the output matches the model shifted by half a sample, 53.9 dB; vertical shifts do not fit): a horizontal START PHASE in Q20 input samples [PROVEN].";
        field {
            name = "f_0_29";
            desc = "Field [29:0]. Sources (PROVEN expression, INFERRED naming): add(a6,lsl(a7,0x2))[0x108]. BOARD run 3: horizontal luma start phase, Q20 input samples (0x80000 = +0.5 sample).";
            sw = rw;
            hw = r;
        } f_0_29[29:0];
    } W_344 @ 0x344;

    reg {
        name = "Image word 0x348";
        desc = "Image word 0x348. PROVEN: written by VGS_DRV_SetVgsReg (1 records). Constants stored: none; ORed constants: none. Typical path conditions: stImgIn.enPixelFormat != 0x1D; a1[0x54] != 0x0; a1[0x70] != 0x1. Meaning UNKNOWN beyond the field sources. BOARD run 3 2026-11-24: 0x40000 (with 0x344 = 0x80000) moves the horizontal sampling grid of the CHROMA by +0.25 chroma sample (the chroma output matches the model shifted by a quarter chroma sample bit exactly, 99.0 dB): the chroma twin of 0x344 (half the value for half the sample density), a horizontal START PHASE in Q20 chroma samples [PROVEN].";
        field {
            name = "f_0_29";
            desc = "Field [29:0]. Sources (PROVEN expression, INFERRED naming): lsr(add(a6,lsl(a7,0x2))[0x108],0x1). BOARD run 3: horizontal chroma start phase, Q20 chroma samples.";
            sw = rw;
            hw = r;
        } f_0_29[29:0];
    } W_348 @ 0x348;

    reg {
        name = "Scaler flags";
        desc = "Scaler flag word. PROVEN (dynamic): base 0xC1A80000; bit 31 = vertical filter on (cleared when in_height == out_height and bForceVFilt is 0); bit 19 = input is 4:2:0 (cleared for 4:2:2 input), bit 21 = output is 4:2:0 (cleared for 4:2:2 output); bits 30, 24, 23 set in every node built. Provenance: DYNAMIC: the vendor node builder (VGS_DrvCommSubmitJobToVgs -> VGS_DrvCommPrepareNodes -> VGS_DRV_SetVgsReg, GenSclCfg, VGSSplitAndCrop) was run under qemu-arm with a fake register file and swept one input at a time (2026-11-23, scripts/tools/vgs-static/). Static source: hi3536dv100_vgs.ko (SDK 2.0.2.0 / Hi3536D_MPP_V1.0.1.0 B040, Dec 7 2017).";
        field {
            name = "in_420";
            desc = "input chroma is vertically subsampled [PROVEN]";
            sw = rw;
            hw = r;
        } in_420[19:19];
        field {
            name = "out_420";
            desc = "output chroma is vertically subsampled [PROVEN]";
            sw = rw;
            hw = r;
        } out_420[21:21];
        field {
            name = "const_23";
            desc = "always 1 [PROVEN value]";
            sw = rw;
            hw = r;
        } const_23[23:23];
        field {
            name = "const_24";
            desc = "always 1 [PROVEN value]";
            sw = rw;
            hw = r;
        } const_24[24:24];
        field {
            name = "const_30";
            desc = "always 1 [PROVEN value]";
            sw = rw;
            hw = r;
        } const_30[30:30];
        field {
            name = "vfilt_en";
            desc = "vertical filter on [PROVEN]";
            sw = rw;
            hw = r;
        } vfilt_en[31:31];
    } W_34C @ 0x34C;

    reg {
        name = "Vertical scale";
        desc = "Vertical step. PROVEN (dynamic): bits 15:0 = floor(in_height << 12 / out_height), input lines per output line in Q12 (2:1 = 0x2000); zero in 90/270 rotation tasks. Provenance: DYNAMIC: the vendor node builder (VGS_DrvCommSubmitJobToVgs -> VGS_DrvCommPrepareNodes -> VGS_DRV_SetVgsReg, GenSclCfg, VGSSplitAndCrop) was run under qemu-arm with a fake register file and swept one input at a time (2026-11-23, scripts/tools/vgs-static/). Static source: hi3536dv100_vgs.ko (SDK 2.0.2.0 / Hi3536D_MPP_V1.0.1.0 B040, Dec 7 2017).";
        field {
            name = "vstep";
            desc = "in/out vertical ratio, Q12 [PROVEN]";
            sw = rw;
            hw = r;
        } vstep[15:0];
    } W_350 @ 0x350;

    reg {
        name = "Image word 0x354";
        desc = "Image word 0x354. PROVEN: written by VGS_DRV_SetVgsReg (1 records). Constants stored: none; ORed constants: none. Typical path conditions: stImgIn.enPixelFormat != 0x1D; a1[0x54] != 0x0; a1[0x70] != 0x1. Meaning UNKNOWN beyond the field sources.";
        field {
            name = "word";
            desc = "32-bit word (no struct-member source found).";
            sw = rw;
            hw = r;
        } word[31:0];
    } W_354 @ 0x354;

    reg {
        name = "Output size (scaler block)";
        desc = "Output size minus one, same layout as 0x70; zero in 90/270 rotation tasks. Provenance: DYNAMIC: the vendor node builder (VGS_DrvCommSubmitJobToVgs -> VGS_DrvCommPrepareNodes -> VGS_DRV_SetVgsReg, GenSclCfg, VGSSplitAndCrop) was run under qemu-arm with a fake register file and swept one input at a time (2026-11-23, scripts/tools/vgs-static/). Static source: hi3536dv100_vgs.ko (SDK 2.0.2.0 / Hi3536D_MPP_V1.0.1.0 B040, Dec 7 2017).";
        field {
            name = "out_w_m1";
            desc = "output width - 1 [PROVEN]";
            sw = rw;
            hw = r;
        } out_w_m1[12:0];
        field {
            name = "out_h_m1";
            desc = "output height - 1 [PROVEN]";
            sw = rw;
            hw = r;
        } out_h_m1[28:16];
    } W_358 @ 0x358;

    reg {
        name = "Input size (scaler block)";
        desc = "Input size minus one after crop, same layout as 0x0C; zero in 90/270 rotation tasks. Provenance: DYNAMIC: the vendor node builder (VGS_DrvCommSubmitJobToVgs -> VGS_DrvCommPrepareNodes -> VGS_DRV_SetVgsReg, GenSclCfg, VGSSplitAndCrop) was run under qemu-arm with a fake register file and swept one input at a time (2026-11-23, scripts/tools/vgs-static/). Static source: hi3536dv100_vgs.ko (SDK 2.0.2.0 / Hi3536D_MPP_V1.0.1.0 B040, Dec 7 2017).";
        field {
            name = "in_w_m1";
            desc = "input width - 1 [PROVEN]";
            sw = rw;
            hw = r;
        } in_w_m1[12:0];
        field {
            name = "in_h_m1";
            desc = "input height - 1 [PROVEN]";
            sw = rw;
            hw = r;
        } in_h_m1[28:16];
    } W_35C @ 0x35C;

    reg {
        name = "Image word 0x360";
        desc = "Image word 0x360. PROVEN: written by VGS_DRV_SetVgsReg (1 records). Constants stored: none; ORed constants: 0xff. Typical path conditions: stImgIn.enPixelFormat != 0x1D; a1[0x54] != 0x0; a1[0x70] != 0x1. Meaning UNKNOWN beyond the field sources.";
        field {
            name = "f_31_31";
            desc = "Field [31:31]. Sources (PROVEN expression, INFERRED naming): a1[0x4C].";
            sw = rw;
            hw = r;
        } f_31_31[31:31];
    } W_360 @ 0x360;

    reg {
        name = "Image word 0x364";
        desc = "Image word 0x364. PROVEN: written by VGS_DRV_SetVgsReg, VGS_DrvInitDefaultRegs (2 records). Constants stored: none; ORed constants: 0xfffe0000. Typical path conditions: stImgIn.enPixelFormat != 0x1D; a1[0x54] != 0x0; a1[0x70] != 0x1. Meaning UNKNOWN beyond the field sources.";
        field {
            name = "f_0_15";
            desc = "Field [15:0]. Sources (PROVEN expression, INFERRED naming): orr(bic(orr(bic(IMG[0x364],0xFF),0xED),0xFF00),0xF800).";
            sw = rw;
            hw = r;
        } f_0_15[15:0];
    } W_364 @ 0x364;

    reg {
        name = "Image word 0x368";
        desc = "Image word 0x368. PROVEN: written by VGS_DRV_SetVgsReg, VGS_DrvInitDefaultRegs (2 records). Constants stored: none; ORed constants: 0x206419. Typical path conditions: stImgIn.enPixelFormat != 0x1D; a1[0x54] != 0x0; a1[0x70] != 0x1. Meaning UNKNOWN beyond the field sources.";
        field {
            name = "word";
            desc = "32-bit word (no struct-member source found).";
            sw = rw;
            hw = r;
        } word[31:0];
    } W_368 @ 0x368;

    reg {
        name = "Image word 0x36C";
        desc = "Image word 0x36C. PROVEN: written by VGS_DRV_SetVgsReg, VGS_DrvInitDefaultRegs (2 records). Constants stored: none; ORed constants: 0x140000. Typical path conditions: stImgIn.enPixelFormat != 0x1D; a1[0x54] != 0x0; a1[0x70] != 0x1. Meaning UNKNOWN beyond the field sources.";
        field {
            name = "f_0_15";
            desc = "Field [15:0]. Sources (PROVEN expression, INFERRED naming): orr(bic(IMG[0x36C],0xFFFF),0xA).";
            sw = rw;
            hw = r;
        } f_0_15[15:0];
    } W_36C @ 0x36C;

    reg {
        name = "Image word 0x370";
        desc = "Image word 0x370. PROVEN: written by VGS_DRV_SetVgsReg, VGS_DrvInitDefaultRegs (2 records). Constants stored: none; ORed constants: 0x808080. Typical path conditions: stImgIn.enPixelFormat != 0x1D; a1[0x54] != 0x0; a1[0x70] != 0x1. Meaning UNKNOWN beyond the field sources.";
        field {
            name = "word";
            desc = "32-bit word (no struct-member source found).";
            sw = rw;
            hw = r;
        } word[31:0];
    } W_370 @ 0x370;

    reg {
        name = "Image word 0x374";
        desc = "Image word 0x374. PROVEN: written by VGS_DRV_SetVgsReg (1 records). Constants stored: none; ORed constants: 0x2008000. Typical path conditions: stImgIn.enPixelFormat != 0x1D; a1[0x54] != 0x0; a1[0x70] != 0x1. Meaning UNKNOWN beyond the field sources.";
        field {
            name = "f_31_31";
            desc = "Field [31:31]. Sources (PROVEN expression, INFERRED naming): a1[0x4C].";
            sw = rw;
            hw = r;
        } f_31_31[31:31];
    } W_374 @ 0x374;

    reg {
        name = "Image word 0x378";
        desc = "Image word 0x378. PROVEN: written by VGS_DRV_SetVgsReg, VGS_DrvInitDefaultRegs (2 records). Constants stored: none; ORed constants: 0xf5ebeb. Typical path conditions: stImgIn.enPixelFormat != 0x1D; a1[0x54] != 0x0; a1[0x70] != 0x1. Meaning UNKNOWN beyond the field sources.";
        field {
            name = "word";
            desc = "32-bit word (no struct-member source found).";
            sw = rw;
            hw = r;
        } word[31:0];
    } W_378 @ 0x378;

    reg {
        name = "Image word 0x37C";
        desc = "Image word 0x37C. PROVEN: written by VGS_DRV_SetVgsReg, VGS_DrvInitDefaultRegs (2 records). Constants stored: none; ORed constants: none. Typical path conditions: stImgIn.enPixelFormat != 0x1D; a1[0x54] != 0x0; a1[0x70] != 0x1. Meaning UNKNOWN beyond the field sources.";
        field {
            name = "word";
            desc = "32-bit word (no struct-member source found).";
            sw = rw;
            hw = r;
        } word[31:0];
    } W_37C @ 0x37C;

    reg {
        name = "Image word 0x380";
        desc = "Image word 0x380. PROVEN: written by VGS_DRV_SetVgsReg (2 records). Constants stored: none; ORed constants: 0x10000. Typical path conditions: stImgIn.enPixelFormat != 0x1D; a1[0x1AC] != 0xA; a1[0x1AC] == 0xA. Meaning UNKNOWN beyond the field sources.";
        field {
            name = "f_0_7";
            desc = "Field [7:0]. Sources (PROVEN expression, INFERRED naming): a1[0x1B8].";
            sw = rw;
            hw = r;
        } f_0_7[7:0];
        field {
            name = "f_8_15";
            desc = "Field [15:8]. Sources (PROVEN expression, INFERRED naming): a1[0x1B9].";
            sw = rw;
            hw = r;
        } f_8_15[15:8];
        field {
            name = "f_19_20";
            desc = "Field [20:19]. Sources (PROVEN expression, INFERRED naming): sel(a1[0x1AC] == 0xA?0x0:a1[0x1AC]); sel(sel(a1[0x1AC] == 0xA?0x0:a1[0x1AC]) == 0x5?0x2:sel(sel(a1[0x1AC] == 0xA?0x0:a1[0x1AC]).";
            sw = rw;
            hw = r;
        } f_19_20[20:19];
    } W_380 @ 0x380;

    reg {
        name = "Image word 0x384";
        desc = "Image word 0x384. PROVEN: written by VGS_DRV_SetVgsReg (1 records). Constants stored: none; ORed constants: none. Typical path conditions: stImgIn.enPixelFormat != 0x1D; a1[0x54] != 0x0; a1[0x70] != 0x1. Meaning UNKNOWN beyond the field sources.";
        field {
            name = "f_0_12";
            desc = "Field [12:0]. Sources (PROVEN expression, INFERRED naming): sub(add(a6,lsl(a7,0x2))[0x7D4],0x1).";
            sw = rw;
            hw = r;
        } f_0_12[12:0];
        field {
            name = "f_16_28";
            desc = "Field [28:16]. Sources (PROVEN expression, INFERRED naming): sub(a1[0x1C8],0x1).";
            sw = rw;
            hw = r;
        } f_16_28[28:16];
    } W_384 @ 0x384;

    reg {
        name = "Image word 0x388";
        desc = "Image word 0x388. PROVEN: written by VGS_DRV_SetVgsReg (1 records). Constants stored: none; ORed constants: none. Typical path conditions: stImgIn.enPixelFormat != 0x1D; a1[0x54] != 0x0; a1[0x70] != 0x1. Meaning UNKNOWN beyond the field sources.";
        field {
            name = "word";
            desc = "32-bit word (no struct-member source found).";
            sw = rw;
            hw = r;
        } word[31:0];
    } W_388 @ 0x388;

    reg {
        name = "Image word 0x38C";
        desc = "Image word 0x38C. PROVEN: written by VGS_DRV_SetVgsReg (1 records). Constants stored: none; ORed constants: none. Typical path conditions: stImgIn.enPixelFormat != 0x1D; a1[0x54] != 0x0; a1[0x70] != 0x1. Meaning UNKNOWN beyond the field sources.";
        field {
            name = "f_0_15";
            desc = "Field [15:0]. Sources (PROVEN expression, INFERRED naming): a1[0x1B0].";
            sw = rw;
            hw = r;
        } f_0_15[15:0];
    } W_38C @ 0x38C;

    reg {
        name = "Image word 0x400";
        desc = "Image word 0x400. PROVEN: written by VGS_DRV_SetVgsReg, VGS_DrvInitDefaultRegs (2 records). Constants stored: none; ORed constants: 0x8000000. Typical path conditions: stImgIn.enPixelFormat != 0x1D; a1[0x54] != 0x0; a1[0x70] != 0x1. Meaning UNKNOWN beyond the field sources.";
        field {
            name = "word";
            desc = "32-bit word (no struct-member source found).";
            sw = rw;
            hw = r;
        } word[31:0];
    } W_400 @ 0x400;

    reg {
        name = "Image word 0x404";
        desc = "Image word 0x404. PROVEN: written by VGS_DRV_SetVgsReg, VGS_DrvInitDefaultRegs (2 records). Constants stored: none; ORed constants: 0x10080, 0x410080. Typical path conditions: stImgIn.enPixelFormat != 0x1D; a1[0x54] != 0x0; a1[0x70] != 0x1. Meaning UNKNOWN beyond the field sources.";
        field {
            name = "word";
            desc = "32-bit word (no struct-member source found).";
            sw = rw;
            hw = r;
        } word[31:0];
    } W_404 @ 0x404;

    reg {
        name = "Image word 0x408";
        desc = "Image word 0x408. PROVEN: written by VGS_DRV_SetVgsReg, VGS_DrvInitDefaultRegs (2 records). Constants stored: none; ORed constants: 0x2590132. Typical path conditions: stImgIn.enPixelFormat != 0x1D; a1[0x54] != 0x0; a1[0x70] != 0x1. Meaning UNKNOWN beyond the field sources.";
        field {
            name = "word";
            desc = "32-bit word (no struct-member source found).";
            sw = rw;
            hw = r;
        } word[31:0];
    } W_408 @ 0x408;

    reg {
        name = "Image word 0x40C";
        desc = "Image word 0x40C. PROVEN: written by VGS_DRV_SetVgsReg, VGS_DrvInitDefaultRegs (2 records). Constants stored: none; ORed constants: 0x7f500074. Typical path conditions: stImgIn.enPixelFormat != 0x1D; a1[0x54] != 0x0; a1[0x70] != 0x1. Meaning UNKNOWN beyond the field sources.";
        field {
            name = "word";
            desc = "32-bit word (no struct-member source found).";
            sw = rw;
            hw = r;
        } word[31:0];
    } W_40C @ 0x40C;

    reg {
        name = "Image word 0x410";
        desc = "Image word 0x410. PROVEN: written by VGS_DRV_SetVgsReg, VGS_DrvInitDefaultRegs (2 records). Constants stored: none; ORed constants: 0x20b7ea5. Typical path conditions: stImgIn.enPixelFormat != 0x1D; a1[0x54] != 0x0; a1[0x70] != 0x1. Meaning UNKNOWN beyond the field sources.";
        field {
            name = "word";
            desc = "32-bit word (no struct-member source found).";
            sw = rw;
            hw = r;
        } word[31:0];
    } W_410 @ 0x410;

    reg {
        name = "Image word 0x414";
        desc = "Image word 0x414. PROVEN: written by VGS_DRV_SetVgsReg, VGS_DrvInitDefaultRegs (2 records). Constants stored: none; ORed constants: 0x7e4a020b. Typical path conditions: stImgIn.enPixelFormat != 0x1D; a1[0x54] != 0x0; a1[0x70] != 0x1. Meaning UNKNOWN beyond the field sources.";
        field {
            name = "word";
            desc = "32-bit word (no struct-member source found).";
            sw = rw;
            hw = r;
        } word[31:0];
    } W_414 @ 0x414;

    reg {
        name = "Image word 0x418";
        desc = "Image word 0x418. PROVEN: written by VGS_DRV_SetVgsReg, VGS_DrvInitDefaultRegs (2 records). Constants stored: none; ORed constants: 0x7fac. Typical path conditions: stImgIn.enPixelFormat != 0x1D; a1[0x54] != 0x0; a1[0x70] != 0x1. Meaning UNKNOWN beyond the field sources.";
        field {
            name = "word";
            desc = "32-bit word (no struct-member source found).";
            sw = rw;
            hw = r;
        } word[31:0];
    } W_418 @ 0x418;

    reg {
        name = "Image word 0x420";
        desc = "Image word 0x420. PROVEN: written by VGS_DRV_SetVgsReg (2 records). Constants stored: none; ORed constants: 0xf. Typical path conditions: stImgIn.enPixelFormat != 0x1D; a1[0x54] != 0x0; a1[0x70] != 0x1. Meaning UNKNOWN beyond the field sources.";
        field {
            name = "f_0_0";
            desc = "Field [0:0]. Sources (PROVEN expression, INFERRED naming): a1[0x1EC].";
            sw = rw;
            hw = r;
        } f_0_0[0:0];
        field {
            name = "f_1_1";
            desc = "Field [1:1]. Sources (PROVEN expression, INFERRED naming): a1[0x1F0].";
            sw = rw;
            hw = r;
        } f_1_1[1:1];
        field {
            name = "f_2_2";
            desc = "Field [2:2]. Sources (PROVEN expression, INFERRED naming): a1[0x1F4].";
            sw = rw;
            hw = r;
        } f_2_2[2:2];
        field {
            name = "f_3_3";
            desc = "Field [3:3]. Sources (PROVEN expression, INFERRED naming): a1[0x1F8].";
            sw = rw;
            hw = r;
        } f_3_3[3:3];
    } W_420 @ 0x420;

    reg {
        name = "Image word 0x424";
        desc = "Image word 0x424. PROVEN: written by VGS_DRV_SetVgsReg (2 records). Constants stored: none; ORed constants: none. Typical path conditions: stImgIn.enPixelFormat != 0x1D; a1[0x54] != 0x0; a1[0x70] != 0x1. Meaning UNKNOWN beyond the field sources.";
        field {
            name = "f_0_7";
            desc = "Field [7:0]. Sources (PROVEN expression, INFERRED naming): lsr(a1[0x210],0x10); lsr(a1[0xCC],0x10).";
            sw = rw;
            hw = r;
        } f_0_7[7:0];
        field {
            name = "f_8_15";
            desc = "Field [15:8]. Sources (PROVEN expression, INFERRED naming): lsr(a1[0x210],0x8); lsr(a1[0xCC],0x8).";
            sw = rw;
            hw = r;
        } f_8_15[15:8];
        field {
            name = "f_16_23";
            desc = "Field [23:16]. Sources (PROVEN expression, INFERRED naming): a1[0x210]; a1[0xCC].";
            sw = rw;
            hw = r;
        } f_16_23[23:16];
        field {
            name = "f_24_31";
            desc = "Field [31:24]. Sources (PROVEN expression, INFERRED naming): a1[0x20C]; a1[0xD4].";
            sw = rw;
            hw = r;
        } f_24_31[31:24];
    } W_424 @ 0x424;

    reg {
        name = "Image word 0x428";
        desc = "Image word 0x428. PROVEN: written by VGS_DRV_SetVgsReg (2 records). Constants stored: none; ORed constants: none. Typical path conditions: stImgIn.enPixelFormat != 0x1D; a1[0x54] != 0x0; a1[0x70] != 0x1. Meaning UNKNOWN beyond the field sources.";
        field {
            name = "f_0_15";
            desc = "Field [15:0]. Sources (PROVEN expression, INFERRED naming): a1[0x1FC]; a1[0xD8].";
            sw = rw;
            hw = r;
        } f_0_15[15:0];
        field {
            name = "f_16_31";
            desc = "Field [31:16]. Sources (PROVEN expression, INFERRED naming): a1[0x200]; a1[0xDC].";
            sw = rw;
            hw = r;
        } f_16_31[31:16];
    } W_428 @ 0x428;

    reg {
        name = "Image word 0x42C";
        desc = "Image word 0x42C. PROVEN: written by VGS_DRV_SetVgsReg (2 records). Constants stored: none; ORed constants: none. Typical path conditions: stImgIn.enPixelFormat != 0x1D; a1[0x54] != 0x0; a1[0x70] != 0x1. Meaning UNKNOWN beyond the field sources.";
        field {
            name = "f_0_15";
            desc = "Field [15:0]. Sources (PROVEN expression, INFERRED naming): a1[0x204]; a1[0xE0].";
            sw = rw;
            hw = r;
        } f_0_15[15:0];
        field {
            name = "f_16_31";
            desc = "Field [31:16]. Sources (PROVEN expression, INFERRED naming): a1[0x208]; a1[0xE4].";
            sw = rw;
            hw = r;
        } f_16_31[31:16];
    } W_42C @ 0x42C;

    reg {
        name = "Image word 0x430";
        desc = "Image word 0x430. PROVEN: written by VGS_DRV_SetVgsReg (2 records). Constants stored: none; ORed constants: none. Typical path conditions: stImgIn.enPixelFormat != 0x1D; a1[0x54] != 0x0; a1[0x70] != 0x1. Meaning UNKNOWN beyond the field sources.";
        field {
            name = "f_0_7";
            desc = "Field [7:0]. Sources (PROVEN expression, INFERRED naming): lsr(a1[0x228],0x10); lsr(a1[0xCC],0x10).";
            sw = rw;
            hw = r;
        } f_0_7[7:0];
        field {
            name = "f_8_15";
            desc = "Field [15:8]. Sources (PROVEN expression, INFERRED naming): lsr(a1[0x228],0x8); lsr(a1[0xCC],0x8).";
            sw = rw;
            hw = r;
        } f_8_15[15:8];
        field {
            name = "f_16_23";
            desc = "Field [23:16]. Sources (PROVEN expression, INFERRED naming): a1[0x228]; a1[0xCC].";
            sw = rw;
            hw = r;
        } f_16_23[23:16];
        field {
            name = "f_24_31";
            desc = "Field [31:24]. Sources (PROVEN expression, INFERRED naming): a1[0x224]; a1[0xD4].";
            sw = rw;
            hw = r;
        } f_24_31[31:24];
    } W_430 @ 0x430;

    reg {
        name = "Image word 0x434";
        desc = "Image word 0x434. PROVEN: written by VGS_DRV_SetVgsReg (2 records). Constants stored: none; ORed constants: none. Typical path conditions: stImgIn.enPixelFormat != 0x1D; a1[0x54] != 0x0; a1[0x70] != 0x1. Meaning UNKNOWN beyond the field sources.";
        field {
            name = "f_0_15";
            desc = "Field [15:0]. Sources (PROVEN expression, INFERRED naming): a1[0x214]; a1[0xE0].";
            sw = rw;
            hw = r;
        } f_0_15[15:0];
        field {
            name = "f_16_31";
            desc = "Field [31:16]. Sources (PROVEN expression, INFERRED naming): a1[0x218]; a1[0xE4].";
            sw = rw;
            hw = r;
        } f_16_31[31:16];
    } W_434 @ 0x434;

    reg {
        name = "Image word 0x438";
        desc = "Image word 0x438. PROVEN: written by VGS_DRV_SetVgsReg (2 records). Constants stored: none; ORed constants: none. Typical path conditions: stImgIn.enPixelFormat != 0x1D; a1[0x54] != 0x0; a1[0x70] != 0x1. Meaning UNKNOWN beyond the field sources.";
        field {
            name = "f_0_15";
            desc = "Field [15:0]. Sources (PROVEN expression, INFERRED naming): a1[0x21C]; a1[0xE8].";
            sw = rw;
            hw = r;
        } f_0_15[15:0];
        field {
            name = "f_16_31";
            desc = "Field [31:16]. Sources (PROVEN expression, INFERRED naming): a1[0x220]; a1[0xEC].";
            sw = rw;
            hw = r;
        } f_16_31[31:16];
    } W_438 @ 0x438;

    reg {
        name = "Image word 0x43C";
        desc = "Image word 0x43C. PROVEN: written by VGS_DRV_SetVgsReg (2 records). Constants stored: none; ORed constants: none. Typical path conditions: stImgIn.enPixelFormat != 0x1D; a1[0x54] != 0x0; a1[0x70] != 0x1. Meaning UNKNOWN beyond the field sources.";
        field {
            name = "f_0_7";
            desc = "Field [7:0]. Sources (PROVEN expression, INFERRED naming): lsr(a1[0x240],0x10); lsr(a1[0xCC],0x10).";
            sw = rw;
            hw = r;
        } f_0_7[7:0];
        field {
            name = "f_8_15";
            desc = "Field [15:8]. Sources (PROVEN expression, INFERRED naming): lsr(a1[0x240],0x8); lsr(a1[0xCC],0x8).";
            sw = rw;
            hw = r;
        } f_8_15[15:8];
        field {
            name = "f_16_23";
            desc = "Field [23:16]. Sources (PROVEN expression, INFERRED naming): a1[0x240]; a1[0xCC].";
            sw = rw;
            hw = r;
        } f_16_23[23:16];
        field {
            name = "f_24_31";
            desc = "Field [31:24]. Sources (PROVEN expression, INFERRED naming): a1[0x23C]; a1[0xD4].";
            sw = rw;
            hw = r;
        } f_24_31[31:24];
    } W_43C @ 0x43C;

    reg {
        name = "Image word 0x440";
        desc = "Image word 0x440. PROVEN: written by VGS_DRV_SetVgsReg (2 records). Constants stored: none; ORed constants: none. Typical path conditions: stImgIn.enPixelFormat != 0x1D; a1[0x54] != 0x0; a1[0x70] != 0x1. Meaning UNKNOWN beyond the field sources.";
        field {
            name = "f_0_15";
            desc = "Field [15:0]. Sources (PROVEN expression, INFERRED naming): a1[0x22C]; a1[0xE8].";
            sw = rw;
            hw = r;
        } f_0_15[15:0];
        field {
            name = "f_16_31";
            desc = "Field [31:16]. Sources (PROVEN expression, INFERRED naming): a1[0x230]; a1[0xEC].";
            sw = rw;
            hw = r;
        } f_16_31[31:16];
    } W_440 @ 0x440;

    reg {
        name = "Image word 0x444";
        desc = "Image word 0x444. PROVEN: written by VGS_DRV_SetVgsReg (2 records). Constants stored: none; ORed constants: none. Typical path conditions: stImgIn.enPixelFormat != 0x1D; a1[0x54] != 0x0; a1[0x70] != 0x1. Meaning UNKNOWN beyond the field sources.";
        field {
            name = "f_0_15";
            desc = "Field [15:0]. Sources (PROVEN expression, INFERRED naming): a1[0x234]; a1[0xF0].";
            sw = rw;
            hw = r;
        } f_0_15[15:0];
        field {
            name = "f_16_31";
            desc = "Field [31:16]. Sources (PROVEN expression, INFERRED naming): a1[0x238]; a1[0xF4].";
            sw = rw;
            hw = r;
        } f_16_31[31:16];
    } W_444 @ 0x444;

    reg {
        name = "Image word 0x448";
        desc = "Image word 0x448. PROVEN: written by VGS_DRV_SetVgsReg (2 records). Constants stored: none; ORed constants: none. Typical path conditions: stImgIn.enPixelFormat != 0x1D; a1[0x54] != 0x0; a1[0x70] != 0x1. Meaning UNKNOWN beyond the field sources.";
        field {
            name = "f_0_7";
            desc = "Field [7:0]. Sources (PROVEN expression, INFERRED naming): lsr(a1[0x258],0x10); lsr(a1[0xCC],0x10).";
            sw = rw;
            hw = r;
        } f_0_7[7:0];
        field {
            name = "f_8_15";
            desc = "Field [15:8]. Sources (PROVEN expression, INFERRED naming): lsr(a1[0x258],0x8); lsr(a1[0xCC],0x8).";
            sw = rw;
            hw = r;
        } f_8_15[15:8];
        field {
            name = "f_16_23";
            desc = "Field [23:16]. Sources (PROVEN expression, INFERRED naming): a1[0x258]; a1[0xCC].";
            sw = rw;
            hw = r;
        } f_16_23[23:16];
        field {
            name = "f_24_31";
            desc = "Field [31:24]. Sources (PROVEN expression, INFERRED naming): a1[0x254]; a1[0xD4].";
            sw = rw;
            hw = r;
        } f_24_31[31:24];
    } W_448 @ 0x448;

    reg {
        name = "Image word 0x44C";
        desc = "Image word 0x44C. PROVEN: written by VGS_DRV_SetVgsReg (2 records). Constants stored: none; ORed constants: none. Typical path conditions: stImgIn.enPixelFormat != 0x1D; a1[0x54] != 0x0; a1[0x70] != 0x1. Meaning UNKNOWN beyond the field sources.";
        field {
            name = "f_0_15";
            desc = "Field [15:0]. Sources (PROVEN expression, INFERRED naming): a1[0x244]; a1[0xF0].";
            sw = rw;
            hw = r;
        } f_0_15[15:0];
        field {
            name = "f_16_31";
            desc = "Field [31:16]. Sources (PROVEN expression, INFERRED naming): a1[0x248]; a1[0xF4].";
            sw = rw;
            hw = r;
        } f_16_31[31:16];
    } W_44C @ 0x44C;

    reg {
        name = "Image word 0x450";
        desc = "Image word 0x450. PROVEN: written by VGS_DRV_SetVgsReg (2 records). Constants stored: none; ORed constants: none. Typical path conditions: stImgIn.enPixelFormat != 0x1D; a1[0x54] != 0x0; a1[0x70] != 0x1. Meaning UNKNOWN beyond the field sources.";
        field {
            name = "f_0_15";
            desc = "Field [15:0]. Sources (PROVEN expression, INFERRED naming): a1[0x24C]; a1[0xD8].";
            sw = rw;
            hw = r;
        } f_0_15[15:0];
        field {
            name = "f_16_31";
            desc = "Field [31:16]. Sources (PROVEN expression, INFERRED naming): a1[0x250]; a1[0xDC].";
            sw = rw;
            hw = r;
        } f_16_31[31:16];
    } W_450 @ 0x450;

    reg {
        name = "Image word 0x560";
        desc = "Image word 0x560. PROVEN: written by VGS_DRV_SetVgsReg (1 records). Constants stored: none; ORed constants: 0x688. Typical path conditions: stImgIn.enPixelFormat != 0x1D; a1[0x54] != 0x0; a1[0x70] != 0x1. Meaning UNKNOWN beyond the field sources.";
        field {
            name = "f_12_12";
            desc = "Field [12:12]. Sources (PROVEN expression, INFERRED naming): add(a6,lsl(a7,0x2))[0x390].";
            sw = rw;
            hw = r;
        } f_12_12[12:12];
        field {
            name = "f_13_13";
            desc = "Field [13:13]. Sources (PROVEN expression, INFERRED naming): add(a6,lsl(a7,0x2))[0x3B4].";
            sw = rw;
            hw = r;
        } f_13_13[13:13];
        field {
            name = "f_14_14";
            desc = "Field [14:14]. Sources (PROVEN expression, INFERRED naming): add(a6,lsl(a7,0x2))[0x3D8].";
            sw = rw;
            hw = r;
        } f_14_14[14:14];
        field {
            name = "f_15_15";
            desc = "Field [15:15]. Sources (PROVEN expression, INFERRED naming): add(a6,lsl(a7,0x2))[0x3FC].";
            sw = rw;
            hw = r;
        } f_15_15[15:15];
    } W_560 @ 0x560;

    reg {
        name = "Image word 0x564";
        desc = "Image word 0x564. PROVEN: written by VGS_DRV_SetVgsReg (1 records). Constants stored: none; ORed constants: none. Typical path conditions: stImgIn.enPixelFormat != 0x1D; a1[0x54] != 0x0; a1[0x70] != 0x1. Meaning UNKNOWN beyond the field sources.";
        field {
            name = "f_0_12";
            desc = "Field [12:0]. Sources (PROVEN expression, INFERRED naming): add(a6,lsl(a7,0x2))[0x4B0].";
            sw = rw;
            hw = r;
        } f_0_12[12:0];
        field {
            name = "f_16_28";
            desc = "Field [28:16]. Sources (PROVEN expression, INFERRED naming): a1[0xDC].";
            sw = rw;
            hw = r;
        } f_16_28[28:16];
    } W_564 @ 0x564;

    reg {
        name = "Image word 0x568";
        desc = "Image word 0x568. PROVEN: written by VGS_DRV_SetVgsReg (1 records). Constants stored: none; ORed constants: none. Typical path conditions: stImgIn.enPixelFormat != 0x1D; a1[0x54] != 0x0; a1[0x70] != 0x1. Meaning UNKNOWN beyond the field sources.";
        field {
            name = "f_0_12";
            desc = "Field [12:0]. Sources (PROVEN expression, INFERRED naming): sub(add(a6,lsl(a7,0x2))[0x420],0x1).";
            sw = rw;
            hw = r;
        } f_0_12[12:0];
        field {
            name = "f_16_28";
            desc = "Field [28:16]. Sources (PROVEN expression, INFERRED naming): sub(sub(a1[0xEC],0x1),a1[0xDC]).";
            sw = rw;
            hw = r;
        } f_16_28[28:16];
    } W_568 @ 0x568;

    reg {
        name = "Image word 0x56C";
        desc = "Image word 0x56C. PROVEN: written by VGS_DRV_SetVgsReg (1 records). Constants stored: none; ORed constants: none. Typical path conditions: stImgIn.enPixelFormat != 0x1D; a1[0x54] != 0x0; a1[0x70] != 0x1. Meaning UNKNOWN beyond the field sources.";
        field {
            name = "f_0_7";
            desc = "Field [7:0]. Sources (PROVEN expression, INFERRED naming): a1[0xCC].";
            sw = rw;
            hw = r;
        } f_0_7[7:0];
        field {
            name = "f_8_15";
            desc = "Field [15:8]. Sources (PROVEN expression, INFERRED naming): lsr(a1[0xCC],0x8).";
            sw = rw;
            hw = r;
        } f_8_15[15:8];
        field {
            name = "f_16_23";
            desc = "Field [23:16]. Sources (PROVEN expression, INFERRED naming): lsr(a1[0xCC],0x10).";
            sw = rw;
            hw = r;
        } f_16_23[23:16];
    } W_56C @ 0x56C;

    reg {
        name = "Image word 0x570";
        desc = "Image word 0x570. PROVEN: written by VGS_DRV_SetVgsReg (1 records). Constants stored: none; ORed constants: none. Typical path conditions: stImgIn.enPixelFormat != 0x1D; a1[0x54] != 0x0; a1[0x70] != 0x1. Meaning UNKNOWN beyond the field sources.";
        field {
            name = "f_0_12";
            desc = "Field [12:0]. Sources (PROVEN expression, INFERRED naming): add(a6,lsl(a7,0x2))[0x4D4].";
            sw = rw;
            hw = r;
        } f_0_12[12:0];
        field {
            name = "f_16_28";
            desc = "Field [28:16]. Sources (PROVEN expression, INFERRED naming): a1[0x110].";
            sw = rw;
            hw = r;
        } f_16_28[28:16];
    } W_570 @ 0x570;

    reg {
        name = "Image word 0x574";
        desc = "Image word 0x574. PROVEN: written by VGS_DRV_SetVgsReg (1 records). Constants stored: none; ORed constants: none. Typical path conditions: stImgIn.enPixelFormat != 0x1D; a1[0x54] != 0x0; a1[0x70] != 0x1. Meaning UNKNOWN beyond the field sources.";
        field {
            name = "f_0_12";
            desc = "Field [12:0]. Sources (PROVEN expression, INFERRED naming): sub(add(a6,lsl(a7,0x2))[0x444],0x1).";
            sw = rw;
            hw = r;
        } f_0_12[12:0];
        field {
            name = "f_16_28";
            desc = "Field [28:16]. Sources (PROVEN expression, INFERRED naming): sub(sub(a1[0x120],0x1),a1[0x110]).";
            sw = rw;
            hw = r;
        } f_16_28[28:16];
    } W_574 @ 0x574;

    reg {
        name = "Image word 0x578";
        desc = "Image word 0x578. PROVEN: written by VGS_DRV_SetVgsReg (1 records). Constants stored: none; ORed constants: none. Typical path conditions: stImgIn.enPixelFormat != 0x1D; a1[0x54] != 0x0; a1[0x70] != 0x1. Meaning UNKNOWN beyond the field sources.";
        field {
            name = "f_0_7";
            desc = "Field [7:0]. Sources (PROVEN expression, INFERRED naming): a1[0x100].";
            sw = rw;
            hw = r;
        } f_0_7[7:0];
        field {
            name = "f_8_15";
            desc = "Field [15:8]. Sources (PROVEN expression, INFERRED naming): lsr(a1[0x100],0x8).";
            sw = rw;
            hw = r;
        } f_8_15[15:8];
        field {
            name = "f_16_23";
            desc = "Field [23:16]. Sources (PROVEN expression, INFERRED naming): lsr(a1[0x100],0x10).";
            sw = rw;
            hw = r;
        } f_16_23[23:16];
    } W_578 @ 0x578;

    reg {
        name = "Image word 0x57C";
        desc = "Image word 0x57C. PROVEN: written by VGS_DRV_SetVgsReg (1 records). Constants stored: none; ORed constants: none. Typical path conditions: stImgIn.enPixelFormat != 0x1D; a1[0x54] != 0x0; a1[0x70] != 0x1. Meaning UNKNOWN beyond the field sources.";
        field {
            name = "f_0_12";
            desc = "Field [12:0]. Sources (PROVEN expression, INFERRED naming): add(a6,lsl(a7,0x2))[0x4F8].";
            sw = rw;
            hw = r;
        } f_0_12[12:0];
        field {
            name = "f_16_28";
            desc = "Field [28:16]. Sources (PROVEN expression, INFERRED naming): a1[0x144].";
            sw = rw;
            hw = r;
        } f_16_28[28:16];
    } W_57C @ 0x57C;

    reg {
        name = "Image word 0x580";
        desc = "Image word 0x580. PROVEN: written by VGS_DRV_SetVgsReg (1 records). Constants stored: none; ORed constants: none. Typical path conditions: stImgIn.enPixelFormat != 0x1D; a1[0x54] != 0x0; a1[0x70] != 0x1. Meaning UNKNOWN beyond the field sources.";
        field {
            name = "f_0_12";
            desc = "Field [12:0]. Sources (PROVEN expression, INFERRED naming): sub(add(a6,lsl(a7,0x2))[0x468],0x1).";
            sw = rw;
            hw = r;
        } f_0_12[12:0];
        field {
            name = "f_16_28";
            desc = "Field [28:16]. Sources (PROVEN expression, INFERRED naming): sub(sub(a1[0x154],0x1),a1[0x144]).";
            sw = rw;
            hw = r;
        } f_16_28[28:16];
    } W_580 @ 0x580;

    reg {
        name = "Image word 0x584";
        desc = "Image word 0x584. PROVEN: written by VGS_DRV_SetVgsReg (1 records). Constants stored: none; ORed constants: none. Typical path conditions: stImgIn.enPixelFormat != 0x1D; a1[0x54] != 0x0; a1[0x70] != 0x1. Meaning UNKNOWN beyond the field sources.";
        field {
            name = "f_0_7";
            desc = "Field [7:0]. Sources (PROVEN expression, INFERRED naming): a1[0x134].";
            sw = rw;
            hw = r;
        } f_0_7[7:0];
        field {
            name = "f_8_15";
            desc = "Field [15:8]. Sources (PROVEN expression, INFERRED naming): lsr(a1[0x134],0x8).";
            sw = rw;
            hw = r;
        } f_8_15[15:8];
        field {
            name = "f_16_23";
            desc = "Field [23:16]. Sources (PROVEN expression, INFERRED naming): lsr(a1[0x134],0x10).";
            sw = rw;
            hw = r;
        } f_16_23[23:16];
    } W_584 @ 0x584;

    reg {
        name = "Image word 0x588";
        desc = "Image word 0x588. PROVEN: written by VGS_DRV_SetVgsReg (1 records). Constants stored: none; ORed constants: none. Typical path conditions: stImgIn.enPixelFormat != 0x1D; a1[0x54] != 0x0; a1[0x70] != 0x1. Meaning UNKNOWN beyond the field sources.";
        field {
            name = "f_0_12";
            desc = "Field [12:0]. Sources (PROVEN expression, INFERRED naming): add(a6,lsl(a7,0x2))[0x51C].";
            sw = rw;
            hw = r;
        } f_0_12[12:0];
        field {
            name = "f_16_28";
            desc = "Field [28:16]. Sources (PROVEN expression, INFERRED naming): a1[0x178].";
            sw = rw;
            hw = r;
        } f_16_28[28:16];
    } W_588 @ 0x588;

    reg {
        name = "Image word 0x58C";
        desc = "Image word 0x58C. PROVEN: written by VGS_DRV_SetVgsReg (1 records). Constants stored: none; ORed constants: none. Typical path conditions: stImgIn.enPixelFormat != 0x1D; a1[0x54] != 0x0; a1[0x70] != 0x1. Meaning UNKNOWN beyond the field sources.";
        field {
            name = "f_0_12";
            desc = "Field [12:0]. Sources (PROVEN expression, INFERRED naming): sub(add(a6,lsl(a7,0x2))[0x48C],0x1).";
            sw = rw;
            hw = r;
        } f_0_12[12:0];
        field {
            name = "f_16_28";
            desc = "Field [28:16]. Sources (PROVEN expression, INFERRED naming): sub(sub(a1[0x188],0x1),a1[0x178]).";
            sw = rw;
            hw = r;
        } f_16_28[28:16];
    } W_58C @ 0x58C;

    reg {
        name = "Image word 0x590";
        desc = "Image word 0x590. PROVEN: written by VGS_DRV_SetVgsReg (1 records). Constants stored: none; ORed constants: none. Typical path conditions: stImgIn.enPixelFormat != 0x1D; a1[0x54] != 0x0; a1[0x70] != 0x1. Meaning UNKNOWN beyond the field sources.";
        field {
            name = "f_0_7";
            desc = "Field [7:0]. Sources (PROVEN expression, INFERRED naming): a1[0x168].";
            sw = rw;
            hw = r;
        } f_0_7[7:0];
        field {
            name = "f_8_15";
            desc = "Field [15:8]. Sources (PROVEN expression, INFERRED naming): lsr(a1[0x168],0x8).";
            sw = rw;
            hw = r;
        } f_8_15[15:8];
        field {
            name = "f_16_23";
            desc = "Field [23:16]. Sources (PROVEN expression, INFERRED naming): lsr(a1[0x168],0x10).";
            sw = rw;
            hw = r;
        } f_16_23[23:16];
    } W_590 @ 0x590;

    reg {
        name = "Image word 0x5A0";
        desc = "Image word 0x5A0. PROVEN: written by VGS_DRV_SetVgsReg (1 records). Constants stored: none; ORed constants: 0xc0. Typical path conditions: stImgIn.enPixelFormat != 0x1D; a1[0x54] != 0x0; a1[0x70] != 0x1. Meaning UNKNOWN beyond the field sources.";
        field {
            name = "word";
            desc = "32-bit word (no struct-member source found).";
            sw = rw;
            hw = r;
        } word[31:0];
    } W_5A0 @ 0x5A0;

    reg {
        name = "Image word 0x5A4";
        desc = "Image word 0x5A4. PROVEN: written by VGS_DRV_SetVgsReg (1 records). Constants stored: none; ORed constants: 0x1. Typical path conditions: stImgIn.enPixelFormat != 0x1D; a1[0x54] != 0x0; a1[0x70] != 0x1. Meaning UNKNOWN beyond the field sources.";
        field {
            name = "word";
            desc = "32-bit word (no struct-member source found).";
            sw = rw;
            hw = r;
        } word[31:0];
    } W_5A4 @ 0x5A4;

    reg {
        name = "Image word 0x5B4";
        desc = "Image word 0x5B4. PROVEN: written by VGS_DRV_SetVgsReg (1 records). Constants stored: none; ORed constants: 0x800080. Typical path conditions: stImgIn.enPixelFormat != 0x1D; a1[0x54] != 0x0; a1[0x70] != 0x1. Meaning UNKNOWN beyond the field sources.";
        field {
            name = "word";
            desc = "32-bit word (no struct-member source found).";
            sw = rw;
            hw = r;
        } word[31:0];
    } W_5B4 @ 0x5B4;

    reg {
        name = "Image word 0x5B8";
        desc = "Image word 0x5B8. PROVEN: written by VGS_DRV_SetVgsReg (1 records). Constants stored: none; ORed constants: 0xc0405050. Typical path conditions: stImgIn.enPixelFormat != 0x1D; a1[0x54] != 0x0; a1[0x70] != 0x1. Meaning UNKNOWN beyond the field sources.";
        field {
            name = "word";
            desc = "32-bit word (no struct-member source found).";
            sw = rw;
            hw = r;
        } word[31:0];
    } W_5B8 @ 0x5B8;

    reg {
        name = "Image word 0x5BC";
        desc = "Image word 0x5BC. PROVEN: written by VGS_DRV_SetVgsReg (1 records). Constants stored: none; ORed constants: 0xc000. Typical path conditions: stImgIn.enPixelFormat != 0x1D; a1[0x54] != 0x0; a1[0x70] != 0x1. Meaning UNKNOWN beyond the field sources.";
        field {
            name = "word";
            desc = "32-bit word (no struct-member source found).";
            sw = rw;
            hw = r;
        } word[31:0];
    } W_5BC @ 0x5BC;

    reg {
        name = "Image word 0x5C0";
        desc = "Image word 0x5C0. PROVEN: written by VGS_DRV_SetVgsReg (1 records). Constants stored: none; ORed constants: 0x1. Typical path conditions: stImgIn.enPixelFormat != 0x1D; a1[0x54] != 0x0; a1[0x70] != 0x1. Meaning UNKNOWN beyond the field sources.";
        field {
            name = "word";
            desc = "32-bit word (no struct-member source found).";
            sw = rw;
            hw = r;
        } word[31:0];
    } W_5C0 @ 0x5C0;

    reg {
        name = "Image word 0x5D0";
        desc = "Image word 0x5D0. PROVEN: written by VGS_DRV_SetVgsReg (1 records). Constants stored: none; ORed constants: 0xff00ff. Typical path conditions: stImgIn.enPixelFormat != 0x1D; a1[0x54] != 0x0; a1[0x70] != 0x1. Meaning UNKNOWN beyond the field sources.";
        field {
            name = "word";
            desc = "32-bit word (no struct-member source found).";
            sw = rw;
            hw = r;
        } word[31:0];
    } W_5D0 @ 0x5D0;

    reg {
        name = "Image word 0x5D4";
        desc = "Image word 0x5D4. PROVEN: written by VGS_DRV_SetVgsReg (1 records). Constants stored: none; ORed constants: 0xc0405050. Typical path conditions: stImgIn.enPixelFormat != 0x1D; a1[0x54] != 0x0; a1[0x70] != 0x1. Meaning UNKNOWN beyond the field sources.";
        field {
            name = "word";
            desc = "32-bit word (no struct-member source found).";
            sw = rw;
            hw = r;
        } word[31:0];
    } W_5D4 @ 0x5D4;

    reg {
        name = "Image word 0x5D8";
        desc = "Image word 0x5D8. PROVEN: written by VGS_DRV_SetVgsReg (1 records). Constants stored: none; ORed constants: 0x1806060. Typical path conditions: stImgIn.enPixelFormat != 0x1D; a1[0x54] != 0x0; a1[0x70] != 0x1. Meaning UNKNOWN beyond the field sources.";
        field {
            name = "f_30_30";
            desc = "Field [30:30]. Sources (PROVEN expression, INFERRED naming): a1[0x4C].";
            sw = rw;
            hw = r;
        } f_30_30[30:30];
        field {
            name = "f_31_31";
            desc = "Field [31:31]. Sources (PROVEN expression, INFERRED naming): a1[0x4C].";
            sw = rw;
            hw = r;
        } f_31_31[31:31];
    } W_5D8 @ 0x5D8;

    reg {
        name = "Image word 0x5DC";
        desc = "Image word 0x5DC. PROVEN: written by VGS_DRV_SetVgsReg (1 records). Constants stored: none; ORed constants: 0x10040. Typical path conditions: stImgIn.enPixelFormat != 0x1D; a1[0x54] != 0x0; a1[0x70] != 0x1. Meaning UNKNOWN beyond the field sources.";
        field {
            name = "f_20_27";
            desc = "Field [27:20]. Sources (PROVEN expression, INFERRED naming): a1[0x50].";
            sw = rw;
            hw = r;
        } f_20_27[27:20];
    } W_5DC @ 0x5DC;

    reg {
        name = "Image word 0x620";
        desc = "Image word 0x620. PROVEN: written by VGS_DRV_SetVgsReg (1 records). Constants stored: none; ORed constants: 0x7. Typical path conditions: stImgIn.enPixelFormat != 0x1D; a1[0x54] != 0x0; a1[0x70] != 0x1. Meaning UNKNOWN beyond the field sources.";
        field {
            name = "f_12_12";
            desc = "Field [12:12]. Sources (PROVEN expression, INFERRED naming): sel(a7 != 0xFFFFFFFF?sel(a7 != 0xFFFFFFFF?add(a6,lsl(a7,0x2)):0x40)[0xB04]:sel(a7 == 0xFFF.";
            sw = rw;
            hw = r;
        } f_12_12[12:12];
    } W_620 @ 0x620;

    reg {
        name = "Image word 0x624";
        desc = "Image word 0x624. PROVEN: written by VGS_DRV_SetVgsReg (1 records). Constants stored: none; ORed constants: 0x40. Typical path conditions: stImgIn.enPixelFormat != 0x1D; a1[0x54] != 0x0; a1[0x70] != 0x1. Meaning UNKNOWN beyond the field sources.";
        field {
            name = "word";
            desc = "32-bit word (no struct-member source found).";
            sw = rw;
            hw = r;
        } word[31:0];
    } W_624 @ 0x624;

    reg {
        name = "Input width (block 3)";
        desc = "Cropped input width in bits 28:16 (not minus one). Provenance: DYNAMIC: the vendor node builder (VGS_DrvCommSubmitJobToVgs -> VGS_DrvCommPrepareNodes -> VGS_DRV_SetVgsReg, GenSclCfg, VGSSplitAndCrop) was run under qemu-arm with a fake register file and swept one input at a time (2026-11-23, scripts/tools/vgs-static/). Static source: hi3536dv100_vgs.ko (SDK 2.0.2.0 / Hi3536D_MPP_V1.0.1.0 B040, Dec 7 2017).";
        field {
            name = "in_w";
            desc = "cropped input width [PROVEN]";
            sw = rw;
            hw = r;
        } in_w[28:16];
    } W_628 @ 0x628;

    reg {
        name = "Input height (block 3)";
        desc = "Cropped input height in bits 28:16 (not minus one). Provenance: DYNAMIC: the vendor node builder (VGS_DrvCommSubmitJobToVgs -> VGS_DrvCommPrepareNodes -> VGS_DRV_SetVgsReg, GenSclCfg, VGSSplitAndCrop) was run under qemu-arm with a fake register file and swept one input at a time (2026-11-23, scripts/tools/vgs-static/). Static source: hi3536dv100_vgs.ko (SDK 2.0.2.0 / Hi3536D_MPP_V1.0.1.0 B040, Dec 7 2017).";
        field {
            name = "in_h";
            desc = "cropped input height [PROVEN]";
            sw = rw;
            hw = r;
        } in_h[28:16];
    } W_62C @ 0x62C;

    reg {
        name = "Image word 0x630";
        desc = "Image word 0x630. PROVEN: written by VGS_DRV_SetVgsReg (1 records). Constants stored: none; ORed constants: 0x11890. Typical path conditions: stImgIn.enPixelFormat != 0x1D; a1[0x54] != 0x0; a1[0x70] != 0x1. Meaning UNKNOWN beyond the field sources.";
        field {
            name = "f_1_3";
            desc = "Field [3:1]. Sources (PROVEN expression, INFERRED naming): sel(a1[0xAC] >=s 0x7?0x7:a1[0xAC]).";
            sw = rw;
            hw = r;
        } f_1_3[3:1];
    } W_630 @ 0x630;

    reg {
        name = "Image word 0x634";
        desc = "Image word 0x634. PROVEN: written by VGS_DRV_SetVgsReg (1 records). Constants stored: none; ORed constants: 0x421. Typical path conditions: stImgIn.enPixelFormat != 0x1D; a1[0x54] != 0x0; a1[0x70] != 0x1. Meaning UNKNOWN beyond the field sources.";
        field {
            name = "word";
            desc = "32-bit word (no struct-member source found).";
            sw = rw;
            hw = r;
        } word[31:0];
    } W_634 @ 0x634;

    reg {
        name = "Image word 0x638";
        desc = "Image word 0x638. PROVEN: written by VGS_DRV_SetVgsReg (1 records). Constants stored: none; ORed constants: none. Typical path conditions: stImgIn.enPixelFormat != 0x1D; a1[0x54] != 0x0; a1[0x70] != 0x1. Meaning UNKNOWN beyond the field sources.";
        field {
            name = "word";
            desc = "32-bit word (no struct-member source found).";
            sw = rw;
            hw = r;
        } word[31:0];
    } W_638 @ 0x638;

    reg {
        name = "Image word 0x63C";
        desc = "Image word 0x63C. PROVEN: written by VGS_DRV_SetVgsReg (1 records). Constants stored: none; ORed constants: 0x121212. Typical path conditions: stImgIn.enPixelFormat != 0x1D; a1[0x54] != 0x0; a1[0x70] != 0x1. Meaning UNKNOWN beyond the field sources.";
        field {
            name = "word";
            desc = "32-bit word (no struct-member source found).";
            sw = rw;
            hw = r;
        } word[31:0];
    } W_63C @ 0x63C;

    reg {
        name = "Image word 0x640";
        desc = "Image word 0x640. PROVEN: written by VGS_DRV_SetVgsReg (1 records). Constants stored: none; ORed constants: none. Typical path conditions: stImgIn.enPixelFormat != 0x1D; a1[0x54] != 0x0; a1[0x70] != 0x1. Meaning UNKNOWN beyond the field sources.";
        field {
            name = "word";
            desc = "32-bit word (no struct-member source found).";
            sw = rw;
            hw = r;
        } word[31:0];
    } W_640 @ 0x640;

    reg {
        name = "Image word 0x644";
        desc = "Image word 0x644. PROVEN: written by VGS_DRV_SetVgsReg (1 records). Constants stored: none; ORed constants: none. Typical path conditions: stImgIn.enPixelFormat != 0x1D; a1[0x54] != 0x0; a1[0x70] != 0x1. Meaning UNKNOWN beyond the field sources.";
        field {
            name = "word";
            desc = "32-bit word (no struct-member source found).";
            sw = rw;
            hw = r;
        } word[31:0];
    } W_644 @ 0x644;

    reg {
        name = "Image word 0x648";
        desc = "Image word 0x648. PROVEN: written by VGS_DRV_SetVgsReg (1 records). Constants stored: none; ORed constants: none. Typical path conditions: stImgIn.enPixelFormat != 0x1D; a1[0x54] != 0x0; a1[0x70] != 0x1. Meaning UNKNOWN beyond the field sources.";
        field {
            name = "f_0_5";
            desc = "Field [5:0]. Sources (PROVEN expression, INFERRED naming): a1[0xB0].";
            sw = rw;
            hw = r;
        } f_0_5[5:0];
        field {
            name = "f_6_11";
            desc = "Field [11:6]. Sources (PROVEN expression, INFERRED naming): a1[0xB0].";
            sw = rw;
            hw = r;
        } f_6_11[11:6];
        field {
            name = "f_12_17";
            desc = "Field [17:12]. Sources (PROVEN expression, INFERRED naming): a1[0xB0].";
            sw = rw;
            hw = r;
        } f_12_17[17:12];
    } W_648 @ 0x648;

    reg {
        name = "Image word 0x64C";
        desc = "Image word 0x64C. PROVEN: written by VGS_DRV_SetVgsReg (1 records). Constants stored: none; ORed constants: 0x2. Typical path conditions: stImgIn.enPixelFormat != 0x1D; a1[0x54] != 0x0; a1[0x70] != 0x1. Meaning UNKNOWN beyond the field sources.";
        field {
            name = "word";
            desc = "32-bit word (no struct-member source found).";
            sw = rw;
            hw = r;
        } word[31:0];
    } W_64C @ 0x64C;

    reg {
        name = "Image word 0x650";
        desc = "Image word 0x650. PROVEN: written by VGS_DRV_SetVgsReg (1 records). Constants stored: none; ORed constants: 0x51. Typical path conditions: stImgIn.enPixelFormat != 0x1D; a1[0x54] != 0x0; a1[0x70] != 0x1. Meaning UNKNOWN beyond the field sources.";
        field {
            name = "word";
            desc = "32-bit word (no struct-member source found).";
            sw = rw;
            hw = r;
        } word[31:0];
    } W_650 @ 0x650;

    reg {
        name = "Input width (block 3, copy)";
        desc = "Copy of 0x628. Provenance: DYNAMIC: the vendor node builder (VGS_DrvCommSubmitJobToVgs -> VGS_DrvCommPrepareNodes -> VGS_DRV_SetVgsReg, GenSclCfg, VGSSplitAndCrop) was run under qemu-arm with a fake register file and swept one input at a time (2026-11-23, scripts/tools/vgs-static/). Static source: hi3536dv100_vgs.ko (SDK 2.0.2.0 / Hi3536D_MPP_V1.0.1.0 B040, Dec 7 2017).";
        field {
            name = "in_w";
            desc = "cropped input width [PROVEN]";
            sw = rw;
            hw = r;
        } in_w[28:16];
    } W_654 @ 0x654;

    reg {
        name = "Input height (block 3, copy)";
        desc = "Copy of 0x62C. Provenance: DYNAMIC: the vendor node builder (VGS_DrvCommSubmitJobToVgs -> VGS_DrvCommPrepareNodes -> VGS_DRV_SetVgsReg, GenSclCfg, VGSSplitAndCrop) was run under qemu-arm with a fake register file and swept one input at a time (2026-11-23, scripts/tools/vgs-static/). Static source: hi3536dv100_vgs.ko (SDK 2.0.2.0 / Hi3536D_MPP_V1.0.1.0 B040, Dec 7 2017).";
        field {
            name = "in_h";
            desc = "cropped input height [PROVEN]";
            sw = rw;
            hw = r;
        } in_h[28:16];
    } W_658 @ 0x658;

};

addrmap aHI3536D_VGS_IMG {
    name = "VGS job image layout (placeholder window, NOT hardware)";
    desc = "Placeholder address 0x13150000 (reserved in the data sheet) only to show the DDR job image layout in the register browser.";
    eHI3536D_VGS_IMG IMG @ 0x0;
};

`endif
