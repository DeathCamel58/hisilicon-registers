`ifndef HI3536D_VGS_IMG_RDL
`define HI3536D_VGS_IMG_RDL

regfile eHI3536D_VGS_IMG {
    name = "VGS job register image (DDR, NOT registers), Hi3536D V100";
    desc = "NOT A REGISTER FILE: the register image that VGS_DRV_SetVgsReg and VGS_DrvInitDefaultRegs of hi3536dv100_vgs.ko build in memory for one job; the job engine loads it (NEXT_NODE 0x2FC). 128 distinct words, offsets equal the engine register offsets. Generated by scripts/tools/arm-re (path-sensitive, --arg a0=IMG), documentation only. Provenance: PROVEN = offset, cleared bit extents, source expression and conditions read from the instruction stream; the source `stImgIn.x` / `stImgOut.x` names are INFERRED: a1[0x0] / a1[0x4] are taken to be pointers to the input / output VIDEO_FRAME_S of VGS_TASK_ATTR_S (member offsets from hi_comm_video.h, e.g. [0xC] = enPixelFormat); other a1[N] members belong to a driver-private job struct whose definition is not in the SDK (names UNKNOWN). Pixel-format fields hold PIXEL_FORMAT_E minus 0x17 (0 = YUV_SEMIPLANAR_420). Field extents are lower bounds. Not verified on hardware.";

    reg {
        name = "Image word 0x0";
        desc = "Image word 0x0. PROVEN: written by VGS_DRV_SetVgsReg (1 records). Constants stored: none; ORed constants: none. Typical path conditions: none. Meaning UNKNOWN beyond the field sources.";
        field {
            name = "word";
            desc = "32-bit word (no struct-member source found).";
            sw = rw;
            hw = r;
        } word[31:0];
    } W_000 @ 0x0;

    reg {
        name = "Image word 0x4";
        desc = "Image word 0x4. PROVEN: written by VGS_DRV_SetVgsReg (4 records). Constants stored: none; ORed constants: 0x1000, 0x10000, 0x11000. Typical path conditions: stImgIn.enPixelFormat != 0x17; stImgIn.enPixelFormat == 0x17; stImgOut.enPixelFormat != 0x17. Meaning UNKNOWN beyond the field sources.";
        field {
            name = "f_12_15";
            desc = "Field [15:12]. Sources (PROVEN expression, INFERRED naming): sub(stImgOut.enPixelFormat,0x17).";
            sw = rw;
            hw = r;
        } f_12_15[15:12];
        field {
            name = "f_16_20";
            desc = "Field [20:16]. Sources (PROVEN expression, INFERRED naming): sub(stImgIn.enPixelFormat,0x17).";
            sw = rw;
            hw = r;
        } f_16_20[20:16];
    } W_004 @ 0x4;

    reg {
        name = "Image word 0x8";
        desc = "Image word 0x8. PROVEN: written by VGS_DRV_SetVgsReg (7 records). Constants stored: none; ORed constants: 0x8, 0x800, 0x808. Typical path conditions: stImgIn.enPixelFormat != 0x1D; a1[0x1CC] == 0x0; a1[0x1E8] == 0x0. Meaning UNKNOWN beyond the field sources.";
        field {
            name = "f_3_3";
            desc = "Field [3:3]. Sources (PROVEN expression, INFERRED naming): a1[0x25C].";
            sw = rw;
            hw = r;
        } f_3_3[3:3];
        field {
            name = "f_11_11";
            desc = "Field [11:11]. Sources (PROVEN expression, INFERRED naming): a1[0xD0].";
            sw = rw;
            hw = r;
        } f_11_11[11:11];
        field {
            name = "f_12_12";
            desc = "Field [12:12]. Sources (PROVEN expression, INFERRED naming): a1[0x1CC].";
            sw = rw;
            hw = r;
        } f_12_12[12:12];
        field {
            name = "f_13_13";
            desc = "Field [13:13]. Sources (PROVEN expression, INFERRED naming): add(a6,lsl(a7,0x2))[0x18C].";
            sw = rw;
            hw = r;
        } f_13_13[13:13];
    } W_008 @ 0x8;

    reg {
        name = "Image word 0xC";
        desc = "Image word 0xC. PROVEN: written by VGS_DRV_SetVgsReg (1 records). Constants stored: none; ORed constants: none. Typical path conditions: stImgIn.enPixelFormat != 0x1D; a7 != 0xFFFFFFFF. Meaning UNKNOWN beyond the field sources.";
        field {
            name = "f_0_12";
            desc = "Field [12:0]. Sources (PROVEN expression, INFERRED naming): sub(add(a6,lsl(a7,0x2))[0xC],0x1).";
            sw = rw;
            hw = r;
        } f_0_12[12:0];
        field {
            name = "f_16_28";
            desc = "Field [28:16]. Sources (PROVEN expression, INFERRED naming): sub(a1[0x30],0x1).";
            sw = rw;
            hw = r;
        } f_16_28[28:16];
    } W_00C @ 0xC;

    reg {
        name = "Image word 0x20";
        desc = "Image word 0x20. PROVEN: written by VGS_DRV_SetVgsReg (1 records). Constants stored: none; ORed constants: none. Typical path conditions: stImgIn.enPixelFormat != 0x1D; a7 != 0xFFFFFFFF. Meaning UNKNOWN beyond the field sources.";
        field {
            name = "word";
            desc = "32-bit word (no struct-member source found).";
            sw = rw;
            hw = r;
        } word[31:0];
    } W_020 @ 0x20;

    reg {
        name = "Image word 0x24";
        desc = "Image word 0x24. PROVEN: written by VGS_DRV_SetVgsReg (1 records). Constants stored: none; ORed constants: none. Typical path conditions: stImgIn.enPixelFormat != 0x1D; a1[0x54] != 0x0; a1[0x70] != 0x1. Meaning UNKNOWN beyond the field sources.";
        field {
            name = "word";
            desc = "32-bit word (no struct-member source found).";
            sw = rw;
            hw = r;
        } word[31:0];
    } W_024 @ 0x24;

    reg {
        name = "Image word 0x28";
        desc = "Image word 0x28. PROVEN: written by VGS_DRV_SetVgsReg (1 records). Constants stored: none; ORed constants: none. Typical path conditions: stImgIn.enPixelFormat != 0x1D; a1[0x54] != 0x0; a1[0x70] != 0x1. Meaning UNKNOWN beyond the field sources.";
        field {
            name = "word";
            desc = "32-bit word (no struct-member source found).";
            sw = rw;
            hw = r;
        } word[31:0];
    } W_028 @ 0x28;

    reg {
        name = "Image word 0x2C";
        desc = "Image word 0x2C. PROVEN: written by VGS_DRV_SetVgsReg (2 records). Constants stored: none; ORed constants: none. Typical path conditions: stImgIn.enVideoFormat == 0x0; stImgIn.enPixelFormat != 0x1D; a1[0x54] != 0x0. Meaning UNKNOWN beyond the field sources.";
        field {
            name = "word";
            desc = "32-bit word (no struct-member source found).";
            sw = rw;
            hw = r;
        } word[31:0];
    } W_02C @ 0x2C;

    reg {
        name = "Image word 0x30";
        desc = "Image word 0x30. PROVEN: written by VGS_DRV_SetVgsReg (2 records). Constants stored: none; ORed constants: none. Typical path conditions: stImgIn.enVideoFormat == 0x0; stImgIn.enPixelFormat != 0x1D; a1[0x54] != 0x0. Meaning UNKNOWN beyond the field sources.";
        field {
            name = "word";
            desc = "32-bit word (no struct-member source found).";
            sw = rw;
            hw = r;
        } word[31:0];
    } W_030 @ 0x30;

    reg {
        name = "Image word 0x34";
        desc = "Image word 0x34. PROVEN: written by VGS_DRV_SetVgsReg (1 records). Constants stored: none; ORed constants: none. Typical path conditions: stImgIn.enPixelFormat != 0x1D; a7 != 0xFFFFFFFF. Meaning UNKNOWN beyond the field sources.";
        field {
            name = "f_0_15";
            desc = "Field [15:0]. Sources (PROVEN expression, INFERRED naming): stImgIn.u32Stride[0].";
            sw = rw;
            hw = r;
        } f_0_15[15:0];
        field {
            name = "f_16_31";
            desc = "Field [31:16]. Sources (PROVEN expression, INFERRED naming): stImgIn.u32Stride[1].";
            sw = rw;
            hw = r;
        } f_16_31[31:16];
    } W_034 @ 0x34;

    reg {
        name = "Image word 0x68";
        desc = "Image word 0x68. PROVEN: written by VGS_DRV_SetVgsReg (1 records). Constants stored: none; ORed constants: none. Typical path conditions: stImgIn.enPixelFormat != 0x1D; a7 != 0xFFFFFFFF. Meaning UNKNOWN beyond the field sources.";
        field {
            name = "f_4_4";
            desc = "Field [4:4]. Sources (PROVEN expression, INFERRED naming): a1[0x7C].";
            sw = rw;
            hw = r;
        } f_4_4[4:4];
        field {
            name = "f_5_5";
            desc = "Field [5:5]. Sources (PROVEN expression, INFERRED naming): a1[0x80].";
            sw = rw;
            hw = r;
        } f_5_5[5:5];
        field {
            name = "f_8_8";
            desc = "Field [8:8]. Sources (PROVEN expression, INFERRED naming): a1[0x27C].";
            sw = rw;
            hw = r;
        } f_8_8[8:8];
    } W_068 @ 0x68;

    reg {
        name = "Image word 0x6C";
        desc = "Image word 0x6C. PROVEN: written by VGS_DRV_SetVgsReg (3 records). Constants stored: none; ORed constants: none. Typical path conditions: stImgIn.enPixelFormat != 0x1D; a1[0x25C] != 0x0; a1[0x25C] == 0x0. Meaning UNKNOWN beyond the field sources.";
        field {
            name = "f_0_12";
            desc = "Field [12:0]. Sources (PROVEN expression, INFERRED naming): a1[0x25C]; a1[0x34].";
            sw = rw;
            hw = r;
        } f_0_12[12:0];
        field {
            name = "f_16_28";
            desc = "Field [28:16]. Sources (PROVEN expression, INFERRED naming): a1[0x25C]; a1[0x38].";
            sw = rw;
            hw = r;
        } f_16_28[28:16];
    } W_06C @ 0x6C;

    reg {
        name = "Image word 0x70";
        desc = "Image word 0x70. PROVEN: written by VGS_DRV_SetVgsReg (2 records). Constants stored: none; ORed constants: none. Typical path conditions: stImgIn.enPixelFormat != 0x1D; a1[0x1E8] != 0x0; a1[0x25C] != 0x0. Meaning UNKNOWN beyond the field sources.";
        field {
            name = "f_0_12";
            desc = "Field [12:0]. Sources (PROVEN expression, INFERRED naming): sub(add(a6,lsl(a7,0x2))[0xA14],0x1); sub(add(a6,lsl(add(a7,0x36),0x2))[0x0],0x1).";
            sw = rw;
            hw = r;
        } f_0_12[12:0];
        field {
            name = "f_16_28";
            desc = "Field [28:16]. Sources (PROVEN expression, INFERRED naming): sub(stImgOut.u32Height,0x1).";
            sw = rw;
            hw = r;
        } f_16_28[28:16];
    } W_070 @ 0x70;

    reg {
        name = "Image word 0x74";
        desc = "Image word 0x74. PROVEN: written by VGS_DRV_SetVgsReg (2 records). Constants stored: none; ORed constants: none. Typical path conditions: stImgIn.enPixelFormat != 0x1D; a1[0x54] != 0x0; a1[0x70] != 0x1. Meaning UNKNOWN beyond the field sources.";
        field {
            name = "word";
            desc = "32-bit word (no struct-member source found).";
            sw = rw;
            hw = r;
        } word[31:0];
    } W_074 @ 0x74;

    reg {
        name = "Image word 0x78";
        desc = "Image word 0x78. PROVEN: written by VGS_DRV_SetVgsReg (2 records). Constants stored: none; ORed constants: none. Typical path conditions: stImgIn.enPixelFormat != 0x1D; a1[0x54] != 0x0; a1[0x70] != 0x1. Meaning UNKNOWN beyond the field sources.";
        field {
            name = "word";
            desc = "32-bit word (no struct-member source found).";
            sw = rw;
            hw = r;
        } word[31:0];
    } W_078 @ 0x78;

    reg {
        name = "Image word 0x7C";
        desc = "Image word 0x7C. PROVEN: written by VGS_DRV_SetVgsReg (1 records). Constants stored: none; ORed constants: none. Typical path conditions: stImgIn.enPixelFormat != 0x1D; a7 != 0xFFFFFFFF. Meaning UNKNOWN beyond the field sources.";
        field {
            name = "f_0_15";
            desc = "Field [15:0]. Sources (PROVEN expression, INFERRED naming): stImgOut.u32Stride[0].";
            sw = rw;
            hw = r;
        } f_0_15[15:0];
        field {
            name = "f_16_31";
            desc = "Field [31:16]. Sources (PROVEN expression, INFERRED naming): stImgOut.u32Stride[1].";
            sw = rw;
            hw = r;
        } f_16_31[31:16];
    } W_07C @ 0x7C;

    reg {
        name = "Image word 0xD8";
        desc = "Image word 0xD8. PROVEN: written by VGS_DRV_SetVgsReg (4 records). Constants stored: none; ORed constants: none. Typical path conditions: stImgIn.enPixelFormat != 0x1D; a1[0x54] != 0x0; a1[0x70] != 0x1. Meaning UNKNOWN beyond the field sources.";
        field {
            name = "f_0_9";
            desc = "Field [9:0]. Sources (PROVEN expression, INFERRED naming): a1[0x20].";
            sw = rw;
            hw = r;
        } f_0_9[9:0];
        field {
            name = "f_16_25";
            desc = "Field [25:16]. Sources (PROVEN expression, INFERRED naming): a1[0x24].";
            sw = rw;
            hw = r;
        } f_16_25[25:16];
    } W_0D8 @ 0xD8;

    reg {
        name = "Image word 0xF0";
        desc = "Image word 0xF0. PROVEN: written by VGS_DRV_SetVgsReg (1 records). Constants stored: none; ORed constants: none. Typical path conditions: stImgIn.enPixelFormat != 0x1D; a7 != 0xFFFFFFFF. Meaning UNKNOWN beyond the field sources.";
        field {
            name = "word";
            desc = "32-bit word (no struct-member source found).";
            sw = rw;
            hw = r;
        } word[31:0];
    } W_0F0 @ 0xF0;

    reg {
        name = "Image word 0xF4";
        desc = "Image word 0xF4. PROVEN: written by VGS_DRV_SetVgsReg (1 records). Constants stored: none; ORed constants: none. Typical path conditions: stImgIn.enPixelFormat != 0x1D; a1[0x54] != 0x0; a1[0x70] != 0x1. Meaning UNKNOWN beyond the field sources.";
        field {
            name = "word";
            desc = "32-bit word (no struct-member source found).";
            sw = rw;
            hw = r;
        } word[31:0];
    } W_0F4 @ 0xF4;

    reg {
        name = "Image word 0x110";
        desc = "Image word 0x110. PROVEN: written by VGS_DRV_SetVgsReg (3 records). Constants stored: none; ORed constants: none. Typical path conditions: stImgIn.enPixelFormat != 0x1D; a1[0x198] == 0x0; a1[0x1E8] != 0x0. Meaning UNKNOWN beyond the field sources.";
        field {
            name = "f_0_12";
            desc = "Field [12:0]. Sources (PROVEN expression, INFERRED naming): a1[0x88]; a1[0x8C].";
            sw = rw;
            hw = r;
        } f_0_12[12:0];
        field {
            name = "f_16_28";
            desc = "Field [28:16]. Sources (PROVEN expression, INFERRED naming): a1[0x88]; a1[0x90].";
            sw = rw;
            hw = r;
        } f_16_28[28:16];
    } W_110 @ 0x110;

    reg {
        name = "Image word 0x114";
        desc = "Image word 0x114. PROVEN: written by VGS_DRV_SetVgsReg (3 records). Constants stored: none; ORed constants: none. Typical path conditions: stImgIn.enPixelFormat != 0x1D; a1[0x198] == 0x0; a1[0x25C] != 0x0. Meaning UNKNOWN beyond the field sources.";
        field {
            name = "f_0_12";
            desc = "Field [12:0]. Sources (PROVEN expression, INFERRED naming): a1[0x88]; sub(a1[0x94],0x1).";
            sw = rw;
            hw = r;
        } f_0_12[12:0];
        field {
            name = "f_16_28";
            desc = "Field [28:16]. Sources (PROVEN expression, INFERRED naming): a1[0x88]; sub(a1[0x98],0x1).";
            sw = rw;
            hw = r;
        } f_16_28[28:16];
        field {
            name = "f_31_31";
            desc = "Field [31:31]. Sources (PROVEN expression, INFERRED naming): a1[0x88].";
            sw = rw;
            hw = r;
        } f_31_31[31:31];
    } W_114 @ 0x114;

    reg {
        name = "Image word 0x120";
        desc = "Image word 0x120. PROVEN: written by VGS_DRV_SetVgsReg (1 records). Constants stored: none; ORed constants: none. Typical path conditions: stImgIn.enPixelFormat != 0x1D; a1[0x70] != 0x1; a7 != 0xFFFFFFFF. Meaning UNKNOWN beyond the field sources.";
        field {
            name = "word";
            desc = "32-bit word (no struct-member source found).";
            sw = rw;
            hw = r;
        } word[31:0];
    } W_120 @ 0x120;

    reg {
        name = "Image word 0x124";
        desc = "Image word 0x124. PROVEN: written by VGS_DRV_SetVgsReg (1 records). Constants stored: none; ORed constants: none. Typical path conditions: stImgIn.enPixelFormat != 0x1D; a1[0x70] != 0x1; a7 != 0xFFFFFFFF. Meaning UNKNOWN beyond the field sources.";
        field {
            name = "word";
            desc = "32-bit word (no struct-member source found).";
            sw = rw;
            hw = r;
        } word[31:0];
    } W_124 @ 0x124;

    reg {
        name = "Image word 0x140";
        desc = "Image word 0x140. PROVEN: written by VGS_DRV_SetVgsReg (4 records). Constants stored: none; ORed constants: none. Typical path conditions: stImgIn.enPixelFormat != 0x1D; a1[0x198] == 0x0; a1[0x1CC] != 0x0. Meaning UNKNOWN beyond the field sources.";
        field {
            name = "f_0_12";
            desc = "Field [12:0]. Sources (PROVEN expression, INFERRED naming): a1[0x1CC]; a1[0x1D0]; sel(a1[0x1CC] != 0x0?and(sel(a1[0x1CC] == 0x0?a1[0x1CC]:sel(a1[0x1CC] != 0x0?a1[0x1D0]:sel; sel(a1[0x1CC] != 0x0?and(sel(a1[0x1CC] == 0x0?a1[0x1CC]:sel(a1[0x1CC] != 0x0?a1[0x1D0]:u)).";
            sw = rw;
            hw = r;
        } f_0_12[12:0];
        field {
            name = "f_16_28";
            desc = "Field [28:16]. Sources (PROVEN expression, INFERRED naming): a1[0x1CC]; a1[0x1D4]; sel(a1[0x1CC] != 0x0?and(sel(a1[0x1CC] != 0x0?a1[0x1D4]:a1[0x1CC]),0x1FFF):sel(a1[0x1CC] !.";
            sw = rw;
            hw = r;
        } f_16_28[28:16];
    } W_140 @ 0x140;

    reg {
        name = "Image word 0x144";
        desc = "Image word 0x144. PROVEN: written by VGS_DRV_SetVgsReg (3 records). Constants stored: none; ORed constants: none. Typical path conditions: stImgIn.enPixelFormat != 0x1D; a1[0x198] == 0x0; a1[0x1CC] != 0x0. Meaning UNKNOWN beyond the field sources.";
        field {
            name = "f_0_12";
            desc = "Field [12:0]. Sources (PROVEN expression, INFERRED naming): a1[0x1CC]; sub(a1[0x1D8],0x1).";
            sw = rw;
            hw = r;
        } f_0_12[12:0];
        field {
            name = "f_16_28";
            desc = "Field [28:16]. Sources (PROVEN expression, INFERRED naming): a1[0x1CC]; sub(a1[0x1DC],0x1).";
            sw = rw;
            hw = r;
        } f_16_28[28:16];
    } W_144 @ 0x144;

    reg {
        name = "Image word 0x150";
        desc = "Image word 0x150. PROVEN: written by VGS_DRV_SetVgsReg (4 records). Constants stored: none; ORed constants: none. Typical path conditions: stImgIn.enPixelFormat != 0x1D; a1[0x198] == 0x0; a1[0x1CC] != 0x0. Meaning UNKNOWN beyond the field sources.";
        field {
            name = "f_0_12";
            desc = "Field [12:0]. Sources (PROVEN expression, INFERRED naming): a1[0x25C]; sub(add(a6,lsl(a7,0x2))[0x9E4],0x1); sub(stImgOut.u32Width,0x1).";
            sw = rw;
            hw = r;
        } f_0_12[12:0];
        field {
            name = "f_16_28";
            desc = "Field [28:16]. Sources (PROVEN expression, INFERRED naming): a1[0x25C]; sub(stImgOut.u32Height,0x1).";
            sw = rw;
            hw = r;
        } f_16_28[28:16];
    } W_150 @ 0x150;

    reg {
        name = "Image word 0x154";
        desc = "Image word 0x154. PROVEN: written by VGS_DRV_SetVgsReg (4 records). Constants stored: none; ORed constants: none. Typical path conditions: stImgIn.enPixelFormat != 0x1D; a1[0x198] == 0x0; a1[0x25C] != 0x0. Meaning UNKNOWN beyond the field sources.";
        field {
            name = "f_0_12";
            desc = "Field [12:0]. Sources (PROVEN expression, INFERRED naming): a1[0x25C]; a1[0x260]; add(a6,lsl(add(a7,0x27C),0x2))[0x0].";
            sw = rw;
            hw = r;
        } f_0_12[12:0];
        field {
            name = "f_16_28";
            desc = "Field [28:16]. Sources (PROVEN expression, INFERRED naming): a1[0x25C]; a1[0x264].";
            sw = rw;
            hw = r;
        } f_16_28[28:16];
    } W_154 @ 0x154;

    reg {
        name = "Image word 0x158";
        desc = "Image word 0x158. PROVEN: written by VGS_DRV_SetVgsReg (7 records). Constants stored: none; ORed constants: none. Typical path conditions: stImgIn.enPixelFormat != 0x1D; a1[0x198] == 0x0; a1[0x1E8] != 0x0. Meaning UNKNOWN beyond the field sources.";
        field {
            name = "f_0_12";
            desc = "Field [12:0]. Sources (PROVEN expression, INFERRED naming): a1[0x25C]; sub(a1[0x268],0x1); sub(add(a6,lsl(a7,0x2))[0x9FC],0x1); sub(sel(a7 != 0xFFFFFFFF?add(a6,lsl(a7,0x2))[0x9FC]:sel(a7 == 0xFFFFFFFF?a1[0x268]:a1[0x25; sub(sel(a7 != 0xFFFFFFFF?sel(a7 != 0xFFFFFFFF?add(a6,lsl(a7,0x2)):a1[0x25C])[0x9FC]:sel(a7; sub(sel(a7 != 0xFFFFFFFF?u:sel(a7 == 0xFFFFFFFF?.";
            sw = rw;
            hw = r;
        } f_0_12[12:0];
        field {
            name = "f_16_28";
            desc = "Field [28:16]. Sources (PROVEN expression, INFERRED naming): a1[0x25C]; sub(a1[0x26C],0x1).";
            sw = rw;
            hw = r;
        } f_16_28[28:16];
    } W_158 @ 0x158;

    reg {
        name = "Image word 0x15C";
        desc = "Image word 0x15C. PROVEN: written by VGS_DRV_SetVgsReg (6 records). Constants stored: none; ORed constants: none. Typical path conditions: stImgIn.enPixelFormat != 0x1D; a1[0x198] == 0x0; a1[0x25C] != 0x0. Meaning UNKNOWN beyond the field sources.";
        field {
            name = "f_0_7";
            desc = "Field [7:0]. Sources (PROVEN expression, INFERRED naming): a1[0x25C]; a1[0x270]; sel(a1[0x25C] != 0x0?and(sel(a1[0x25C] != 0x0?a1[0x270]:a1[0x25C]),0xFF):sel(a1[0x25C] == .";
            sw = rw;
            hw = r;
        } f_0_7[7:0];
        field {
            name = "f_8_15";
            desc = "Field [15:8]. Sources (PROVEN expression, INFERRED naming): a1[0x25C]; lsr(a1[0x270],0x8); sel(a1[0x25C] != 0x0?and(lsr(sel(a1[0x25C] != 0x0?a1[0x270]:a1[0x25C]),0x8),0xFF):sel(a1[0.";
            sw = rw;
            hw = r;
        } f_8_15[15:8];
        field {
            name = "f_16_23";
            desc = "Field [23:16]. Sources (PROVEN expression, INFERRED naming): a1[0x25C]; lsr(a1[0x270],0x10); sel(a1[0x25C] != 0x0?and(lsr(sel(a1[0x25C] != 0x0?a1[0x270]:a1[0x25C]),0x10),0xFF):sel(a1[.";
            sw = rw;
            hw = r;
        } f_16_23[23:16];
        field {
            name = "f_24_31";
            desc = "Field [31:24]. Sources (PROVEN expression, INFERRED naming): a1[0x25C]; lsr(a1[0x270],0x18); sel(a1[0x25C] != 0x0?lsr(sel(a1[0x25C] != 0x0?a1[0x270]:a1[0x25C]),0x18):sel(a1[0x25C] != .";
            sw = rw;
            hw = r;
        } f_24_31[31:24];
    } W_15C @ 0x15C;

    reg {
        name = "Image word 0x1A0";
        desc = "Image word 0x1A0. PROVEN: written by VGS_DRV_SetVgsReg (2 records). Constants stored: none; ORed constants: none. Typical path conditions: stImgIn.enPixelFormat != 0x1D; a1[0x54] != 0x0; a1[0x54] == 0x0. Meaning UNKNOWN beyond the field sources.";
        field {
            name = "f_0_12";
            desc = "Field [12:0]. Sources (PROVEN expression, INFERRED naming): a1[0x54]; add(a6,lsl(a7,0x2))[0x9C].";
            sw = rw;
            hw = r;
        } f_0_12[12:0];
        field {
            name = "f_16_28";
            desc = "Field [28:16]. Sources (PROVEN expression, INFERRED naming): a1[0x54]; sub(add(a6,lsl(a7,0x2))[0x60],0x1).";
            sw = rw;
            hw = r;
        } f_16_28[28:16];
    } W_1A0 @ 0x1A0;

    reg {
        name = "Image word 0x1B0";
        desc = "Image word 0x1B0. PROVEN: written by VGS_DRV_SetVgsReg (7 records). Constants stored: 0x0; ORed constants: none. Typical path conditions: stImgIn.enPixelFormat != 0x1D; a1[0x198] == 0x0; a1[0x1E8] != 0x0. Meaning UNKNOWN beyond the field sources.";
        field {
            name = "f_0_3";
            desc = "Field [3:0]. Sources (PROVEN expression, INFERRED naming): sel(add(a7,0x1) >u 0x1?0x0:a1[0x54]); sel(add(a7,0x1) >u 0x1?0x0:and(add(a6,lsl(a7,0x2))[0x9C],0x1FFF)).";
            sw = rw;
            hw = r;
        } f_0_3[3:0];
        field {
            name = "f_4_7";
            desc = "Field [7:4]. Sources (PROVEN expression, INFERRED naming): a1[0x5C]; sel(sub(a6[0xB10],0x1) != a7?0x0:sel(sub(a6[0xB10],0x1) == a7?a1[0x5C]:sel(sub(a6[0xB10],0.";
            sw = rw;
            hw = r;
        } f_4_7[7:4];
        field {
            name = "f_8_11";
            desc = "Field [11:8]. Sources (PROVEN expression, INFERRED naming): a1[0x60].";
            sw = rw;
            hw = r;
        } f_8_11[11:8];
        field {
            name = "f_12_15";
            desc = "Field [15:12]. Sources (PROVEN expression, INFERRED naming): a1[0x64].";
            sw = rw;
            hw = r;
        } f_12_15[15:12];
    } W_1B0 @ 0x1B0;

    reg {
        name = "Image word 0x1B4";
        desc = "Image word 0x1B4. PROVEN: written by VGS_DRV_SetVgsReg (16 records). Constants stored: none; ORed constants: none. Typical path conditions: stImgIn.enPixelFormat != 0x1D; a1[0x198] == 0x0; a1[0x1E8] != 0x0. Meaning UNKNOWN beyond the field sources.";
        field {
            name = "f_0_7";
            desc = "Field [7:0]. Sources (PROVEN expression, INFERRED naming): lsr(a1[0x68],0x10); sel(a1[0x54] != 0x0?lsr(a1[0x68],0x10):sel(a1[0x25C] != 0x0?and(lsr(sel(a1[0x25C] != 0x0?a; sel(a1[0x54] != 0x0?lsr(a1[0x68],0x10):u); sel(a1[0x54] != 0x0?lsr(sel(a1[0x54] != 0x0?a1[0x68]:a1[0x54]),0x10):a1[0x25C]); sel(a1[0x54] != 0x0?lsr(sel(a1[0x54] != 0x0?a1[0x68]:a1[0x54]),0.";
            sw = rw;
            hw = r;
        } f_0_7[7:0];
        field {
            name = "f_8_15";
            desc = "Field [15:8]. Sources (PROVEN expression, INFERRED naming): lsr(a1[0x68],0x8); sel(a1[0x54] != 0x0?lsr(a1[0x68],0x8):a1[0x60]); sel(a1[0x54] != 0x0?lsr(sel(a1[0x54] != 0x0?a1[0x68]:a1[0x54]),0x8):a1[0x60]); sel(a1[0x54] != 0x0?lsr(sel(a1[0x54] != 0x0?a1[0x68]:a1[0x54]),0x8):and(add(a6,lsl(a7,0x2).";
            sw = rw;
            hw = r;
        } f_8_15[15:8];
        field {
            name = "f_16_23";
            desc = "Field [23:16]. Sources (PROVEN expression, INFERRED naming): a1[0x68]; sel(a1[0x54] != 0x0?a1[0x68]:a1[0x54]).";
            sw = rw;
            hw = r;
        } f_16_23[23:16];
    } W_1B4 @ 0x1B4;

    reg {
        name = "Image word 0x1D4";
        desc = "Image word 0x1D4. PROVEN: written by VGS_DRV_SetVgsReg (1 records). Constants stored: none; ORed constants: 0x80000000. Typical path conditions: stImgIn.enPixelFormat != 0x1D; a1[0x54] != 0x0; a1[0x70] != 0x1. Meaning UNKNOWN beyond the field sources.";
        field {
            name = "f_0_0";
            desc = "Field [0:0]. Sources (PROVEN expression, INFERRED naming): add(a6,lsl(a7,0x2))[0x654].";
            sw = rw;
            hw = r;
        } f_0_0[0:0];
    } W_1D4 @ 0x1D4;

    reg {
        name = "Image word 0x1D8";
        desc = "Image word 0x1D8. PROVEN: written by VGS_DRV_SetVgsReg (1 records). Constants stored: none; ORed constants: none. Typical path conditions: stImgIn.enPixelFormat != 0x1D; a1[0x54] != 0x0; a1[0x70] != 0x1. Meaning UNKNOWN beyond the field sources.";
        field {
            name = "f_0_12";
            desc = "Field [12:0]. Sources (PROVEN expression, INFERRED naming): add(a6,lsl(a7,0x2))[0x834].";
            sw = rw;
            hw = r;
        } f_0_12[12:0];
        field {
            name = "f_13_25";
            desc = "Field [25:13]. Sources (PROVEN expression, INFERRED naming): a1[0x1C0].";
            sw = rw;
            hw = r;
        } f_13_25[25:13];
    } W_1D8 @ 0x1D8;

    reg {
        name = "Image word 0x1F8";
        desc = "Image word 0x1F8. PROVEN: written by VGS_DRV_SetVgsReg (1 records). Constants stored: none; ORed constants: none. Typical path conditions: stImgIn.enPixelFormat != 0x1D; a1[0x54] != 0x0; a1[0x70] != 0x1. Meaning UNKNOWN beyond the field sources.";
        field {
            name = "f_0_7";
            desc = "Field [7:0]. Sources (PROVEN expression, INFERRED naming): a1[0x1A4].";
            sw = rw;
            hw = r;
        } f_0_7[7:0];
    } W_1F8 @ 0x1F8;

    reg {
        name = "Image word 0x200";
        desc = "Image word 0x200. PROVEN: written by VGS_DRV_SetVgsReg (1 records). Constants stored: none; ORed constants: none. Typical path conditions: stImgIn.enPixelFormat != 0x1D; a1[0x54] != 0x0; a1[0x70] != 0x1. Meaning UNKNOWN beyond the field sources.";
        field {
            name = "word";
            desc = "32-bit word (no struct-member source found).";
            sw = rw;
            hw = r;
        } word[31:0];
    } W_200 @ 0x200;

    reg {
        name = "Image word 0x204";
        desc = "Image word 0x204. PROVEN: written by VGS_DRV_SetVgsReg (1 records). Constants stored: none; ORed constants: none. Typical path conditions: stImgIn.enPixelFormat != 0x1D; a1[0x54] != 0x0; a1[0x70] != 0x1. Meaning UNKNOWN beyond the field sources.";
        field {
            name = "word";
            desc = "32-bit word (no struct-member source found).";
            sw = rw;
            hw = r;
        } word[31:0];
    } W_204 @ 0x204;

    reg {
        name = "Image word 0x208";
        desc = "Image word 0x208. PROVEN: written by VGS_DRV_SetVgsReg (1 records). Constants stored: none; ORed constants: none. Typical path conditions: stImgIn.enPixelFormat != 0x1D; a1[0x54] != 0x0; a1[0x70] != 0x1. Meaning UNKNOWN beyond the field sources.";
        field {
            name = "word";
            desc = "32-bit word (no struct-member source found).";
            sw = rw;
            hw = r;
        } word[31:0];
    } W_208 @ 0x208;

    reg {
        name = "Image word 0x20C";
        desc = "Image word 0x20C. PROVEN: written by VGS_DRV_SetVgsReg (1 records). Constants stored: none; ORed constants: none. Typical path conditions: stImgIn.enPixelFormat != 0x1D; a1[0x54] != 0x0; a1[0x70] != 0x1. Meaning UNKNOWN beyond the field sources.";
        field {
            name = "word";
            desc = "32-bit word (no struct-member source found).";
            sw = rw;
            hw = r;
        } word[31:0];
    } W_20C @ 0x20C;

    reg {
        name = "Image word 0x240";
        desc = "Image word 0x240. PROVEN: written by VGS_DRV_SetVgsReg (1 records). Constants stored: none; ORed constants: none. Typical path conditions: stImgIn.enPixelFormat != 0x1D; a1[0x54] != 0x0; a1[0x70] != 0x1. Meaning UNKNOWN beyond the field sources.";
        field {
            name = "word";
            desc = "32-bit word (no struct-member source found).";
            sw = rw;
            hw = r;
        } word[31:0];
    } W_240 @ 0x240;

    reg {
        name = "Image word 0x244";
        desc = "Image word 0x244. PROVEN: written by VGS_DRV_SetVgsReg (1 records). Constants stored: none; ORed constants: none. Typical path conditions: stImgIn.enPixelFormat != 0x1D; a1[0x54] != 0x0; a1[0x70] != 0x1. Meaning UNKNOWN beyond the field sources.";
        field {
            name = "word";
            desc = "32-bit word (no struct-member source found).";
            sw = rw;
            hw = r;
        } word[31:0];
    } W_244 @ 0x244;

    reg {
        name = "Image word 0x248";
        desc = "Image word 0x248. PROVEN: written by VGS_DRV_SetVgsReg (1 records). Constants stored: none; ORed constants: none. Typical path conditions: stImgIn.enPixelFormat != 0x1D; a1[0x54] != 0x0; a1[0x70] != 0x1. Meaning UNKNOWN beyond the field sources.";
        field {
            name = "word";
            desc = "32-bit word (no struct-member source found).";
            sw = rw;
            hw = r;
        } word[31:0];
    } W_248 @ 0x248;

    reg {
        name = "Image word 0x24C";
        desc = "Image word 0x24C. PROVEN: written by VGS_DRV_SetVgsReg (1 records). Constants stored: none; ORed constants: none. Typical path conditions: stImgIn.enPixelFormat != 0x1D; a1[0x54] != 0x0; a1[0x70] != 0x1. Meaning UNKNOWN beyond the field sources.";
        field {
            name = "word";
            desc = "32-bit word (no struct-member source found).";
            sw = rw;
            hw = r;
        } word[31:0];
    } W_24C @ 0x24C;

    reg {
        name = "Image word 0x250";
        desc = "Image word 0x250. PROVEN: written by VGS_DRV_SetVgsReg (1 records). Constants stored: none; ORed constants: none. Typical path conditions: stImgIn.enPixelFormat != 0x1D; a1[0x54] != 0x0; a1[0x70] != 0x1. Meaning UNKNOWN beyond the field sources.";
        field {
            name = "word";
            desc = "32-bit word (no struct-member source found).";
            sw = rw;
            hw = r;
        } word[31:0];
    } W_250 @ 0x250;

    reg {
        name = "Image word 0x260";
        desc = "Image word 0x260. PROVEN: written by VGS_DRV_SetVgsReg (1 records). Constants stored: none; ORed constants: none. Typical path conditions: stImgIn.enPixelFormat != 0x1D; a1[0x54] != 0x0; a1[0x70] != 0x1. Meaning UNKNOWN beyond the field sources.";
        field {
            name = "word";
            desc = "32-bit word (no struct-member source found).";
            sw = rw;
            hw = r;
        } word[31:0];
    } W_260 @ 0x260;

    reg {
        name = "Image word 0x264";
        desc = "Image word 0x264. PROVEN: written by VGS_DRV_SetVgsReg (1 records). Constants stored: none; ORed constants: none. Typical path conditions: stImgIn.enPixelFormat != 0x1D; a1[0x54] != 0x0; a1[0x70] != 0x1. Meaning UNKNOWN beyond the field sources.";
        field {
            name = "word";
            desc = "32-bit word (no struct-member source found).";
            sw = rw;
            hw = r;
        } word[31:0];
    } W_264 @ 0x264;

    reg {
        name = "Image word 0x268";
        desc = "Image word 0x268. PROVEN: written by VGS_DRV_SetVgsReg (1 records). Constants stored: none; ORed constants: none. Typical path conditions: stImgIn.enPixelFormat != 0x1D; a1[0x54] != 0x0; a1[0x70] != 0x1. Meaning UNKNOWN beyond the field sources.";
        field {
            name = "f_0_12";
            desc = "Field [12:0]. Sources (PROVEN expression, INFERRED naming): sub(add(a6,lsl(a7,0x2))[0xCC],0x1).";
            sw = rw;
            hw = r;
        } f_0_12[12:0];
        field {
            name = "f_16_28";
            desc = "Field [28:16]. Sources (PROVEN expression, INFERRED naming): add(a6,lsl(a7,0x2))[0x90].";
            sw = rw;
            hw = r;
        } f_16_28[28:16];
    } W_268 @ 0x268;

    reg {
        name = "Image word 0x270";
        desc = "Image word 0x270. PROVEN: written by VGS_DRV_SetVgsReg (1 records). Constants stored: none; ORed constants: none. Typical path conditions: stImgIn.enPixelFormat != 0x1D; a1[0x54] != 0x0; a1[0x70] != 0x1. Meaning UNKNOWN beyond the field sources.";
        field {
            name = "word";
            desc = "32-bit word (no struct-member source found).";
            sw = rw;
            hw = r;
        } word[31:0];
    } W_270 @ 0x270;

    reg {
        name = "Image word 0x294";
        desc = "Image word 0x294. PROVEN: written by VGS_DRV_SetVgsReg (1 records). Constants stored: none; ORed constants: none. Typical path conditions: stImgIn.enPixelFormat != 0x1D; a1[0x54] != 0x0; a1[0x70] != 0x1. Meaning UNKNOWN beyond the field sources.";
        field {
            name = "word";
            desc = "32-bit word (no struct-member source found).";
            sw = rw;
            hw = r;
        } word[31:0];
    } W_294 @ 0x294;

    reg {
        name = "Image word 0x298";
        desc = "Image word 0x298. PROVEN: written by VGS_DRV_SetVgsReg (1 records). Constants stored: none; ORed constants: none. Typical path conditions: stImgIn.enPixelFormat != 0x1D; a1[0x54] != 0x0; a1[0x70] != 0x1. Meaning UNKNOWN beyond the field sources.";
        field {
            name = "word";
            desc = "32-bit word (no struct-member source found).";
            sw = rw;
            hw = r;
        } word[31:0];
    } W_298 @ 0x298;

    reg {
        name = "Image word 0x340";
        desc = "Image word 0x340. PROVEN: written by VGS_DRV_SetVgsReg (1 records). Constants stored: none; ORed constants: 0xc7000000. Typical path conditions: stImgIn.enPixelFormat != 0x1D; a1[0x54] != 0x0; a1[0x70] != 0x1. Meaning UNKNOWN beyond the field sources.";
        field {
            name = "f_0_23";
            desc = "Field [23:0]. Sources (PROVEN expression, INFERRED naming): bic(a3[0x20],0xFF000000).";
            sw = rw;
            hw = r;
        } f_0_23[23:0];
    } W_340 @ 0x340;

    reg {
        name = "Image word 0x344";
        desc = "Image word 0x344. PROVEN: written by VGS_DRV_SetVgsReg (1 records). Constants stored: none; ORed constants: none. Typical path conditions: stImgIn.enPixelFormat != 0x1D; a1[0x54] != 0x0; a1[0x70] != 0x1. Meaning UNKNOWN beyond the field sources.";
        field {
            name = "f_0_29";
            desc = "Field [29:0]. Sources (PROVEN expression, INFERRED naming): add(a6,lsl(a7,0x2))[0x108].";
            sw = rw;
            hw = r;
        } f_0_29[29:0];
    } W_344 @ 0x344;

    reg {
        name = "Image word 0x348";
        desc = "Image word 0x348. PROVEN: written by VGS_DRV_SetVgsReg (1 records). Constants stored: none; ORed constants: none. Typical path conditions: stImgIn.enPixelFormat != 0x1D; a1[0x54] != 0x0; a1[0x70] != 0x1. Meaning UNKNOWN beyond the field sources.";
        field {
            name = "f_0_29";
            desc = "Field [29:0]. Sources (PROVEN expression, INFERRED naming): lsr(add(a6,lsl(a7,0x2))[0x108],0x1).";
            sw = rw;
            hw = r;
        } f_0_29[29:0];
    } W_348 @ 0x348;

    reg {
        name = "Image word 0x34C";
        desc = "Image word 0x34C. PROVEN: written by VGS_DRV_SetVgsReg (1 records). Constants stored: none; ORed constants: none. Typical path conditions: stImgIn.enPixelFormat != 0x1D; a1[0x54] != 0x0; a1[0x70] != 0x1. Meaning UNKNOWN beyond the field sources.";
        field {
            name = "word";
            desc = "32-bit word (no struct-member source found).";
            sw = rw;
            hw = r;
        } word[31:0];
    } W_34C @ 0x34C;

    reg {
        name = "Image word 0x350";
        desc = "Image word 0x350. PROVEN: written by VGS_DRV_SetVgsReg (1 records). Constants stored: none; ORed constants: none. Typical path conditions: stImgIn.enPixelFormat != 0x1D; a1[0x54] != 0x0; a1[0x70] != 0x1. Meaning UNKNOWN beyond the field sources.";
        field {
            name = "f_0_15";
            desc = "Field [15:0]. Sources (PROVEN expression, INFERRED naming): a3[0x24].";
            sw = rw;
            hw = r;
        } f_0_15[15:0];
    } W_350 @ 0x350;

    reg {
        name = "Image word 0x354";
        desc = "Image word 0x354. PROVEN: written by VGS_DRV_SetVgsReg (1 records). Constants stored: none; ORed constants: none. Typical path conditions: stImgIn.enPixelFormat != 0x1D; a1[0x54] != 0x0; a1[0x70] != 0x1. Meaning UNKNOWN beyond the field sources.";
        field {
            name = "word";
            desc = "32-bit word (no struct-member source found).";
            sw = rw;
            hw = r;
        } word[31:0];
    } W_354 @ 0x354;

    reg {
        name = "Image word 0x358";
        desc = "Image word 0x358. PROVEN: written by VGS_DRV_SetVgsReg (5 records). Constants stored: none; ORed constants: none. Typical path conditions: stImgIn.enPixelFormat != 0x1D; a1[0x25C] != 0x0; a1[0x25C] == 0x0. Meaning UNKNOWN beyond the field sources.";
        field {
            name = "f_0_12";
            desc = "Field [12:0]. Sources (PROVEN expression, INFERRED naming): a1[0x25C]; sel(a1[0x25C] == 0x0?a1[0x25C]:u); sub(a1[0x268],0x1); sub(add(a6,lsl(add(a7,0x18),0x2))[0x0],0x1); sub(sel(a7 != 0xFFFFFFFF?add(a6,lsl(sel(a7 != 0xFFFFFFFF?add(a7,0x18):a1[0x25C]),0x2))[0x0.";
            sw = rw;
            hw = r;
        } f_0_12[12:0];
        field {
            name = "f_16_28";
            desc = "Field [28:16]. Sources (PROVEN expression, INFERRED naming): a1[0x25C]; sub(a1[0x26C],0x1).";
            sw = rw;
            hw = r;
        } f_16_28[28:16];
    } W_358 @ 0x358;

    reg {
        name = "Image word 0x35C";
        desc = "Image word 0x35C. PROVEN: written by VGS_DRV_SetVgsReg (9 records). Constants stored: none; ORed constants: none. Typical path conditions: stImgIn.enPixelFormat != 0x1D; a1[0x198] != 0x0; a1[0x198] == 0x0. Meaning UNKNOWN beyond the field sources.";
        field {
            name = "f_0_12";
            desc = "Field [12:0]. Sources (PROVEN expression, INFERRED naming): a1[0x198]; a1[0x74]; a1[0xC0]; sel(a1[0xC0] != 0x0?0x0:a1[0xC0]); sel(a1[0xC0] != 0x0?sel(a1[0xC0] != 0x0?0x0:a1[0xC0]):a1[0x25C]); sel(a1[0xC0] != 0x0?sel(a1[0xC0] != 0x0?0x0:a1[0xC0]):sel(a1[0x25C] == 0x0?a1[0x25C]:u)); sub(add(a6,lsl(a7,0x2))[0xC],0x1).";
            sw = rw;
            hw = r;
        } f_0_12[12:0];
        field {
            name = "f_16_28";
            desc = "Field [28:16]. Sources (PROVEN expression, INFERRED naming): a1[0x198]; a1[0x74]; a1[0xC0]; sel(a1[0xC0] != 0x0?0x0:a1[0xC0]); sub(a1[0x40],0x1).";
            sw = rw;
            hw = r;
        } f_16_28[28:16];
    } W_35C @ 0x35C;

    reg {
        name = "Image word 0x360";
        desc = "Image word 0x360. PROVEN: written by VGS_DRV_SetVgsReg (1 records). Constants stored: none; ORed constants: 0xff. Typical path conditions: stImgIn.enPixelFormat != 0x1D; a1[0x54] != 0x0; a1[0x70] != 0x1. Meaning UNKNOWN beyond the field sources.";
        field {
            name = "f_31_31";
            desc = "Field [31:31]. Sources (PROVEN expression, INFERRED naming): a1[0x4C].";
            sw = rw;
            hw = r;
        } f_31_31[31:31];
    } W_360 @ 0x360;

    reg {
        name = "Image word 0x364";
        desc = "Image word 0x364. PROVEN: written by VGS_DRV_SetVgsReg, VGS_DrvInitDefaultRegs (2 records). Constants stored: none; ORed constants: 0xfffe0000. Typical path conditions: stImgIn.enPixelFormat != 0x1D; a1[0x54] != 0x0; a1[0x70] != 0x1. Meaning UNKNOWN beyond the field sources.";
        field {
            name = "f_0_15";
            desc = "Field [15:0]. Sources (PROVEN expression, INFERRED naming): orr(bic(orr(bic(IMG[0x364],0xFF),0xED),0xFF00),0xF800).";
            sw = rw;
            hw = r;
        } f_0_15[15:0];
    } W_364 @ 0x364;

    reg {
        name = "Image word 0x368";
        desc = "Image word 0x368. PROVEN: written by VGS_DRV_SetVgsReg, VGS_DrvInitDefaultRegs (2 records). Constants stored: none; ORed constants: 0x206419. Typical path conditions: stImgIn.enPixelFormat != 0x1D; a1[0x54] != 0x0; a1[0x70] != 0x1. Meaning UNKNOWN beyond the field sources.";
        field {
            name = "word";
            desc = "32-bit word (no struct-member source found).";
            sw = rw;
            hw = r;
        } word[31:0];
    } W_368 @ 0x368;

    reg {
        name = "Image word 0x36C";
        desc = "Image word 0x36C. PROVEN: written by VGS_DRV_SetVgsReg, VGS_DrvInitDefaultRegs (2 records). Constants stored: none; ORed constants: 0x140000. Typical path conditions: stImgIn.enPixelFormat != 0x1D; a1[0x54] != 0x0; a1[0x70] != 0x1. Meaning UNKNOWN beyond the field sources.";
        field {
            name = "f_0_15";
            desc = "Field [15:0]. Sources (PROVEN expression, INFERRED naming): orr(bic(IMG[0x36C],0xFFFF),0xA).";
            sw = rw;
            hw = r;
        } f_0_15[15:0];
    } W_36C @ 0x36C;

    reg {
        name = "Image word 0x370";
        desc = "Image word 0x370. PROVEN: written by VGS_DRV_SetVgsReg, VGS_DrvInitDefaultRegs (2 records). Constants stored: none; ORed constants: 0x808080. Typical path conditions: stImgIn.enPixelFormat != 0x1D; a1[0x54] != 0x0; a1[0x70] != 0x1. Meaning UNKNOWN beyond the field sources.";
        field {
            name = "word";
            desc = "32-bit word (no struct-member source found).";
            sw = rw;
            hw = r;
        } word[31:0];
    } W_370 @ 0x370;

    reg {
        name = "Image word 0x374";
        desc = "Image word 0x374. PROVEN: written by VGS_DRV_SetVgsReg (1 records). Constants stored: none; ORed constants: 0x2008000. Typical path conditions: stImgIn.enPixelFormat != 0x1D; a1[0x54] != 0x0; a1[0x70] != 0x1. Meaning UNKNOWN beyond the field sources.";
        field {
            name = "f_31_31";
            desc = "Field [31:31]. Sources (PROVEN expression, INFERRED naming): a1[0x4C].";
            sw = rw;
            hw = r;
        } f_31_31[31:31];
    } W_374 @ 0x374;

    reg {
        name = "Image word 0x378";
        desc = "Image word 0x378. PROVEN: written by VGS_DRV_SetVgsReg, VGS_DrvInitDefaultRegs (2 records). Constants stored: none; ORed constants: 0xf5ebeb. Typical path conditions: stImgIn.enPixelFormat != 0x1D; a1[0x54] != 0x0; a1[0x70] != 0x1. Meaning UNKNOWN beyond the field sources.";
        field {
            name = "word";
            desc = "32-bit word (no struct-member source found).";
            sw = rw;
            hw = r;
        } word[31:0];
    } W_378 @ 0x378;

    reg {
        name = "Image word 0x37C";
        desc = "Image word 0x37C. PROVEN: written by VGS_DRV_SetVgsReg, VGS_DrvInitDefaultRegs (2 records). Constants stored: none; ORed constants: none. Typical path conditions: stImgIn.enPixelFormat != 0x1D; a1[0x54] != 0x0; a1[0x70] != 0x1. Meaning UNKNOWN beyond the field sources.";
        field {
            name = "word";
            desc = "32-bit word (no struct-member source found).";
            sw = rw;
            hw = r;
        } word[31:0];
    } W_37C @ 0x37C;

    reg {
        name = "Image word 0x380";
        desc = "Image word 0x380. PROVEN: written by VGS_DRV_SetVgsReg (2 records). Constants stored: none; ORed constants: 0x10000. Typical path conditions: stImgIn.enPixelFormat != 0x1D; a1[0x1AC] != 0xA; a1[0x1AC] == 0xA. Meaning UNKNOWN beyond the field sources.";
        field {
            name = "f_0_7";
            desc = "Field [7:0]. Sources (PROVEN expression, INFERRED naming): a1[0x1B8].";
            sw = rw;
            hw = r;
        } f_0_7[7:0];
        field {
            name = "f_8_15";
            desc = "Field [15:8]. Sources (PROVEN expression, INFERRED naming): a1[0x1B9].";
            sw = rw;
            hw = r;
        } f_8_15[15:8];
        field {
            name = "f_19_20";
            desc = "Field [20:19]. Sources (PROVEN expression, INFERRED naming): sel(a1[0x1AC] == 0xA?0x0:a1[0x1AC]); sel(sel(a1[0x1AC] == 0xA?0x0:a1[0x1AC]) == 0x5?0x2:sel(sel(a1[0x1AC] == 0xA?0x0:a1[0x1AC]).";
            sw = rw;
            hw = r;
        } f_19_20[20:19];
    } W_380 @ 0x380;

    reg {
        name = "Image word 0x384";
        desc = "Image word 0x384. PROVEN: written by VGS_DRV_SetVgsReg (1 records). Constants stored: none; ORed constants: none. Typical path conditions: stImgIn.enPixelFormat != 0x1D; a1[0x54] != 0x0; a1[0x70] != 0x1. Meaning UNKNOWN beyond the field sources.";
        field {
            name = "f_0_12";
            desc = "Field [12:0]. Sources (PROVEN expression, INFERRED naming): sub(add(a6,lsl(a7,0x2))[0x7D4],0x1).";
            sw = rw;
            hw = r;
        } f_0_12[12:0];
        field {
            name = "f_16_28";
            desc = "Field [28:16]. Sources (PROVEN expression, INFERRED naming): sub(a1[0x1C8],0x1).";
            sw = rw;
            hw = r;
        } f_16_28[28:16];
    } W_384 @ 0x384;

    reg {
        name = "Image word 0x388";
        desc = "Image word 0x388. PROVEN: written by VGS_DRV_SetVgsReg (1 records). Constants stored: none; ORed constants: none. Typical path conditions: stImgIn.enPixelFormat != 0x1D; a1[0x54] != 0x0; a1[0x70] != 0x1. Meaning UNKNOWN beyond the field sources.";
        field {
            name = "word";
            desc = "32-bit word (no struct-member source found).";
            sw = rw;
            hw = r;
        } word[31:0];
    } W_388 @ 0x388;

    reg {
        name = "Image word 0x38C";
        desc = "Image word 0x38C. PROVEN: written by VGS_DRV_SetVgsReg (1 records). Constants stored: none; ORed constants: none. Typical path conditions: stImgIn.enPixelFormat != 0x1D; a1[0x54] != 0x0; a1[0x70] != 0x1. Meaning UNKNOWN beyond the field sources.";
        field {
            name = "f_0_15";
            desc = "Field [15:0]. Sources (PROVEN expression, INFERRED naming): a1[0x1B0].";
            sw = rw;
            hw = r;
        } f_0_15[15:0];
    } W_38C @ 0x38C;

    reg {
        name = "Image word 0x400";
        desc = "Image word 0x400. PROVEN: written by VGS_DRV_SetVgsReg, VGS_DrvInitDefaultRegs (2 records). Constants stored: none; ORed constants: 0x8000000. Typical path conditions: stImgIn.enPixelFormat != 0x1D; a1[0x54] != 0x0; a1[0x70] != 0x1. Meaning UNKNOWN beyond the field sources.";
        field {
            name = "word";
            desc = "32-bit word (no struct-member source found).";
            sw = rw;
            hw = r;
        } word[31:0];
    } W_400 @ 0x400;

    reg {
        name = "Image word 0x404";
        desc = "Image word 0x404. PROVEN: written by VGS_DRV_SetVgsReg, VGS_DrvInitDefaultRegs (2 records). Constants stored: none; ORed constants: 0x10080, 0x410080. Typical path conditions: stImgIn.enPixelFormat != 0x1D; a1[0x54] != 0x0; a1[0x70] != 0x1. Meaning UNKNOWN beyond the field sources.";
        field {
            name = "word";
            desc = "32-bit word (no struct-member source found).";
            sw = rw;
            hw = r;
        } word[31:0];
    } W_404 @ 0x404;

    reg {
        name = "Image word 0x408";
        desc = "Image word 0x408. PROVEN: written by VGS_DRV_SetVgsReg, VGS_DrvInitDefaultRegs (2 records). Constants stored: none; ORed constants: 0x2590132. Typical path conditions: stImgIn.enPixelFormat != 0x1D; a1[0x54] != 0x0; a1[0x70] != 0x1. Meaning UNKNOWN beyond the field sources.";
        field {
            name = "word";
            desc = "32-bit word (no struct-member source found).";
            sw = rw;
            hw = r;
        } word[31:0];
    } W_408 @ 0x408;

    reg {
        name = "Image word 0x40C";
        desc = "Image word 0x40C. PROVEN: written by VGS_DRV_SetVgsReg, VGS_DrvInitDefaultRegs (2 records). Constants stored: none; ORed constants: 0x7f500074. Typical path conditions: stImgIn.enPixelFormat != 0x1D; a1[0x54] != 0x0; a1[0x70] != 0x1. Meaning UNKNOWN beyond the field sources.";
        field {
            name = "word";
            desc = "32-bit word (no struct-member source found).";
            sw = rw;
            hw = r;
        } word[31:0];
    } W_40C @ 0x40C;

    reg {
        name = "Image word 0x410";
        desc = "Image word 0x410. PROVEN: written by VGS_DRV_SetVgsReg, VGS_DrvInitDefaultRegs (2 records). Constants stored: none; ORed constants: 0x20b7ea5. Typical path conditions: stImgIn.enPixelFormat != 0x1D; a1[0x54] != 0x0; a1[0x70] != 0x1. Meaning UNKNOWN beyond the field sources.";
        field {
            name = "word";
            desc = "32-bit word (no struct-member source found).";
            sw = rw;
            hw = r;
        } word[31:0];
    } W_410 @ 0x410;

    reg {
        name = "Image word 0x414";
        desc = "Image word 0x414. PROVEN: written by VGS_DRV_SetVgsReg, VGS_DrvInitDefaultRegs (2 records). Constants stored: none; ORed constants: 0x7e4a020b. Typical path conditions: stImgIn.enPixelFormat != 0x1D; a1[0x54] != 0x0; a1[0x70] != 0x1. Meaning UNKNOWN beyond the field sources.";
        field {
            name = "word";
            desc = "32-bit word (no struct-member source found).";
            sw = rw;
            hw = r;
        } word[31:0];
    } W_414 @ 0x414;

    reg {
        name = "Image word 0x418";
        desc = "Image word 0x418. PROVEN: written by VGS_DRV_SetVgsReg, VGS_DrvInitDefaultRegs (2 records). Constants stored: none; ORed constants: 0x7fac. Typical path conditions: stImgIn.enPixelFormat != 0x1D; a1[0x54] != 0x0; a1[0x70] != 0x1. Meaning UNKNOWN beyond the field sources.";
        field {
            name = "word";
            desc = "32-bit word (no struct-member source found).";
            sw = rw;
            hw = r;
        } word[31:0];
    } W_418 @ 0x418;

    reg {
        name = "Image word 0x420";
        desc = "Image word 0x420. PROVEN: written by VGS_DRV_SetVgsReg (2 records). Constants stored: none; ORed constants: 0xf. Typical path conditions: stImgIn.enPixelFormat != 0x1D; a1[0x54] != 0x0; a1[0x70] != 0x1. Meaning UNKNOWN beyond the field sources.";
        field {
            name = "f_0_0";
            desc = "Field [0:0]. Sources (PROVEN expression, INFERRED naming): a1[0x1EC].";
            sw = rw;
            hw = r;
        } f_0_0[0:0];
        field {
            name = "f_1_1";
            desc = "Field [1:1]. Sources (PROVEN expression, INFERRED naming): a1[0x1F0].";
            sw = rw;
            hw = r;
        } f_1_1[1:1];
        field {
            name = "f_2_2";
            desc = "Field [2:2]. Sources (PROVEN expression, INFERRED naming): a1[0x1F4].";
            sw = rw;
            hw = r;
        } f_2_2[2:2];
        field {
            name = "f_3_3";
            desc = "Field [3:3]. Sources (PROVEN expression, INFERRED naming): a1[0x1F8].";
            sw = rw;
            hw = r;
        } f_3_3[3:3];
    } W_420 @ 0x420;

    reg {
        name = "Image word 0x424";
        desc = "Image word 0x424. PROVEN: written by VGS_DRV_SetVgsReg (2 records). Constants stored: none; ORed constants: none. Typical path conditions: stImgIn.enPixelFormat != 0x1D; a1[0x54] != 0x0; a1[0x70] != 0x1. Meaning UNKNOWN beyond the field sources.";
        field {
            name = "f_0_7";
            desc = "Field [7:0]. Sources (PROVEN expression, INFERRED naming): lsr(a1[0x210],0x10); lsr(a1[0xCC],0x10).";
            sw = rw;
            hw = r;
        } f_0_7[7:0];
        field {
            name = "f_8_15";
            desc = "Field [15:8]. Sources (PROVEN expression, INFERRED naming): lsr(a1[0x210],0x8); lsr(a1[0xCC],0x8).";
            sw = rw;
            hw = r;
        } f_8_15[15:8];
        field {
            name = "f_16_23";
            desc = "Field [23:16]. Sources (PROVEN expression, INFERRED naming): a1[0x210]; a1[0xCC].";
            sw = rw;
            hw = r;
        } f_16_23[23:16];
        field {
            name = "f_24_31";
            desc = "Field [31:24]. Sources (PROVEN expression, INFERRED naming): a1[0x20C]; a1[0xD4].";
            sw = rw;
            hw = r;
        } f_24_31[31:24];
    } W_424 @ 0x424;

    reg {
        name = "Image word 0x428";
        desc = "Image word 0x428. PROVEN: written by VGS_DRV_SetVgsReg (2 records). Constants stored: none; ORed constants: none. Typical path conditions: stImgIn.enPixelFormat != 0x1D; a1[0x54] != 0x0; a1[0x70] != 0x1. Meaning UNKNOWN beyond the field sources.";
        field {
            name = "f_0_15";
            desc = "Field [15:0]. Sources (PROVEN expression, INFERRED naming): a1[0x1FC]; a1[0xD8].";
            sw = rw;
            hw = r;
        } f_0_15[15:0];
        field {
            name = "f_16_31";
            desc = "Field [31:16]. Sources (PROVEN expression, INFERRED naming): a1[0x200]; a1[0xDC].";
            sw = rw;
            hw = r;
        } f_16_31[31:16];
    } W_428 @ 0x428;

    reg {
        name = "Image word 0x42C";
        desc = "Image word 0x42C. PROVEN: written by VGS_DRV_SetVgsReg (2 records). Constants stored: none; ORed constants: none. Typical path conditions: stImgIn.enPixelFormat != 0x1D; a1[0x54] != 0x0; a1[0x70] != 0x1. Meaning UNKNOWN beyond the field sources.";
        field {
            name = "f_0_15";
            desc = "Field [15:0]. Sources (PROVEN expression, INFERRED naming): a1[0x204]; a1[0xE0].";
            sw = rw;
            hw = r;
        } f_0_15[15:0];
        field {
            name = "f_16_31";
            desc = "Field [31:16]. Sources (PROVEN expression, INFERRED naming): a1[0x208]; a1[0xE4].";
            sw = rw;
            hw = r;
        } f_16_31[31:16];
    } W_42C @ 0x42C;

    reg {
        name = "Image word 0x430";
        desc = "Image word 0x430. PROVEN: written by VGS_DRV_SetVgsReg (2 records). Constants stored: none; ORed constants: none. Typical path conditions: stImgIn.enPixelFormat != 0x1D; a1[0x54] != 0x0; a1[0x70] != 0x1. Meaning UNKNOWN beyond the field sources.";
        field {
            name = "f_0_7";
            desc = "Field [7:0]. Sources (PROVEN expression, INFERRED naming): lsr(a1[0x228],0x10); lsr(a1[0xCC],0x10).";
            sw = rw;
            hw = r;
        } f_0_7[7:0];
        field {
            name = "f_8_15";
            desc = "Field [15:8]. Sources (PROVEN expression, INFERRED naming): lsr(a1[0x228],0x8); lsr(a1[0xCC],0x8).";
            sw = rw;
            hw = r;
        } f_8_15[15:8];
        field {
            name = "f_16_23";
            desc = "Field [23:16]. Sources (PROVEN expression, INFERRED naming): a1[0x228]; a1[0xCC].";
            sw = rw;
            hw = r;
        } f_16_23[23:16];
        field {
            name = "f_24_31";
            desc = "Field [31:24]. Sources (PROVEN expression, INFERRED naming): a1[0x224]; a1[0xD4].";
            sw = rw;
            hw = r;
        } f_24_31[31:24];
    } W_430 @ 0x430;

    reg {
        name = "Image word 0x434";
        desc = "Image word 0x434. PROVEN: written by VGS_DRV_SetVgsReg (2 records). Constants stored: none; ORed constants: none. Typical path conditions: stImgIn.enPixelFormat != 0x1D; a1[0x54] != 0x0; a1[0x70] != 0x1. Meaning UNKNOWN beyond the field sources.";
        field {
            name = "f_0_15";
            desc = "Field [15:0]. Sources (PROVEN expression, INFERRED naming): a1[0x214]; a1[0xE0].";
            sw = rw;
            hw = r;
        } f_0_15[15:0];
        field {
            name = "f_16_31";
            desc = "Field [31:16]. Sources (PROVEN expression, INFERRED naming): a1[0x218]; a1[0xE4].";
            sw = rw;
            hw = r;
        } f_16_31[31:16];
    } W_434 @ 0x434;

    reg {
        name = "Image word 0x438";
        desc = "Image word 0x438. PROVEN: written by VGS_DRV_SetVgsReg (2 records). Constants stored: none; ORed constants: none. Typical path conditions: stImgIn.enPixelFormat != 0x1D; a1[0x54] != 0x0; a1[0x70] != 0x1. Meaning UNKNOWN beyond the field sources.";
        field {
            name = "f_0_15";
            desc = "Field [15:0]. Sources (PROVEN expression, INFERRED naming): a1[0x21C]; a1[0xE8].";
            sw = rw;
            hw = r;
        } f_0_15[15:0];
        field {
            name = "f_16_31";
            desc = "Field [31:16]. Sources (PROVEN expression, INFERRED naming): a1[0x220]; a1[0xEC].";
            sw = rw;
            hw = r;
        } f_16_31[31:16];
    } W_438 @ 0x438;

    reg {
        name = "Image word 0x43C";
        desc = "Image word 0x43C. PROVEN: written by VGS_DRV_SetVgsReg (2 records). Constants stored: none; ORed constants: none. Typical path conditions: stImgIn.enPixelFormat != 0x1D; a1[0x54] != 0x0; a1[0x70] != 0x1. Meaning UNKNOWN beyond the field sources.";
        field {
            name = "f_0_7";
            desc = "Field [7:0]. Sources (PROVEN expression, INFERRED naming): lsr(a1[0x240],0x10); lsr(a1[0xCC],0x10).";
            sw = rw;
            hw = r;
        } f_0_7[7:0];
        field {
            name = "f_8_15";
            desc = "Field [15:8]. Sources (PROVEN expression, INFERRED naming): lsr(a1[0x240],0x8); lsr(a1[0xCC],0x8).";
            sw = rw;
            hw = r;
        } f_8_15[15:8];
        field {
            name = "f_16_23";
            desc = "Field [23:16]. Sources (PROVEN expression, INFERRED naming): a1[0x240]; a1[0xCC].";
            sw = rw;
            hw = r;
        } f_16_23[23:16];
        field {
            name = "f_24_31";
            desc = "Field [31:24]. Sources (PROVEN expression, INFERRED naming): a1[0x23C]; a1[0xD4].";
            sw = rw;
            hw = r;
        } f_24_31[31:24];
    } W_43C @ 0x43C;

    reg {
        name = "Image word 0x440";
        desc = "Image word 0x440. PROVEN: written by VGS_DRV_SetVgsReg (2 records). Constants stored: none; ORed constants: none. Typical path conditions: stImgIn.enPixelFormat != 0x1D; a1[0x54] != 0x0; a1[0x70] != 0x1. Meaning UNKNOWN beyond the field sources.";
        field {
            name = "f_0_15";
            desc = "Field [15:0]. Sources (PROVEN expression, INFERRED naming): a1[0x22C]; a1[0xE8].";
            sw = rw;
            hw = r;
        } f_0_15[15:0];
        field {
            name = "f_16_31";
            desc = "Field [31:16]. Sources (PROVEN expression, INFERRED naming): a1[0x230]; a1[0xEC].";
            sw = rw;
            hw = r;
        } f_16_31[31:16];
    } W_440 @ 0x440;

    reg {
        name = "Image word 0x444";
        desc = "Image word 0x444. PROVEN: written by VGS_DRV_SetVgsReg (2 records). Constants stored: none; ORed constants: none. Typical path conditions: stImgIn.enPixelFormat != 0x1D; a1[0x54] != 0x0; a1[0x70] != 0x1. Meaning UNKNOWN beyond the field sources.";
        field {
            name = "f_0_15";
            desc = "Field [15:0]. Sources (PROVEN expression, INFERRED naming): a1[0x234]; a1[0xF0].";
            sw = rw;
            hw = r;
        } f_0_15[15:0];
        field {
            name = "f_16_31";
            desc = "Field [31:16]. Sources (PROVEN expression, INFERRED naming): a1[0x238]; a1[0xF4].";
            sw = rw;
            hw = r;
        } f_16_31[31:16];
    } W_444 @ 0x444;

    reg {
        name = "Image word 0x448";
        desc = "Image word 0x448. PROVEN: written by VGS_DRV_SetVgsReg (2 records). Constants stored: none; ORed constants: none. Typical path conditions: stImgIn.enPixelFormat != 0x1D; a1[0x54] != 0x0; a1[0x70] != 0x1. Meaning UNKNOWN beyond the field sources.";
        field {
            name = "f_0_7";
            desc = "Field [7:0]. Sources (PROVEN expression, INFERRED naming): lsr(a1[0x258],0x10); lsr(a1[0xCC],0x10).";
            sw = rw;
            hw = r;
        } f_0_7[7:0];
        field {
            name = "f_8_15";
            desc = "Field [15:8]. Sources (PROVEN expression, INFERRED naming): lsr(a1[0x258],0x8); lsr(a1[0xCC],0x8).";
            sw = rw;
            hw = r;
        } f_8_15[15:8];
        field {
            name = "f_16_23";
            desc = "Field [23:16]. Sources (PROVEN expression, INFERRED naming): a1[0x258]; a1[0xCC].";
            sw = rw;
            hw = r;
        } f_16_23[23:16];
        field {
            name = "f_24_31";
            desc = "Field [31:24]. Sources (PROVEN expression, INFERRED naming): a1[0x254]; a1[0xD4].";
            sw = rw;
            hw = r;
        } f_24_31[31:24];
    } W_448 @ 0x448;

    reg {
        name = "Image word 0x44C";
        desc = "Image word 0x44C. PROVEN: written by VGS_DRV_SetVgsReg (2 records). Constants stored: none; ORed constants: none. Typical path conditions: stImgIn.enPixelFormat != 0x1D; a1[0x54] != 0x0; a1[0x70] != 0x1. Meaning UNKNOWN beyond the field sources.";
        field {
            name = "f_0_15";
            desc = "Field [15:0]. Sources (PROVEN expression, INFERRED naming): a1[0x244]; a1[0xF0].";
            sw = rw;
            hw = r;
        } f_0_15[15:0];
        field {
            name = "f_16_31";
            desc = "Field [31:16]. Sources (PROVEN expression, INFERRED naming): a1[0x248]; a1[0xF4].";
            sw = rw;
            hw = r;
        } f_16_31[31:16];
    } W_44C @ 0x44C;

    reg {
        name = "Image word 0x450";
        desc = "Image word 0x450. PROVEN: written by VGS_DRV_SetVgsReg (2 records). Constants stored: none; ORed constants: none. Typical path conditions: stImgIn.enPixelFormat != 0x1D; a1[0x54] != 0x0; a1[0x70] != 0x1. Meaning UNKNOWN beyond the field sources.";
        field {
            name = "f_0_15";
            desc = "Field [15:0]. Sources (PROVEN expression, INFERRED naming): a1[0x24C]; a1[0xD8].";
            sw = rw;
            hw = r;
        } f_0_15[15:0];
        field {
            name = "f_16_31";
            desc = "Field [31:16]. Sources (PROVEN expression, INFERRED naming): a1[0x250]; a1[0xDC].";
            sw = rw;
            hw = r;
        } f_16_31[31:16];
    } W_450 @ 0x450;

    reg {
        name = "Image word 0x560";
        desc = "Image word 0x560. PROVEN: written by VGS_DRV_SetVgsReg (1 records). Constants stored: none; ORed constants: 0x688. Typical path conditions: stImgIn.enPixelFormat != 0x1D; a1[0x54] != 0x0; a1[0x70] != 0x1. Meaning UNKNOWN beyond the field sources.";
        field {
            name = "f_12_12";
            desc = "Field [12:12]. Sources (PROVEN expression, INFERRED naming): add(a6,lsl(a7,0x2))[0x390].";
            sw = rw;
            hw = r;
        } f_12_12[12:12];
        field {
            name = "f_13_13";
            desc = "Field [13:13]. Sources (PROVEN expression, INFERRED naming): add(a6,lsl(a7,0x2))[0x3B4].";
            sw = rw;
            hw = r;
        } f_13_13[13:13];
        field {
            name = "f_14_14";
            desc = "Field [14:14]. Sources (PROVEN expression, INFERRED naming): add(a6,lsl(a7,0x2))[0x3D8].";
            sw = rw;
            hw = r;
        } f_14_14[14:14];
        field {
            name = "f_15_15";
            desc = "Field [15:15]. Sources (PROVEN expression, INFERRED naming): add(a6,lsl(a7,0x2))[0x3FC].";
            sw = rw;
            hw = r;
        } f_15_15[15:15];
    } W_560 @ 0x560;

    reg {
        name = "Image word 0x564";
        desc = "Image word 0x564. PROVEN: written by VGS_DRV_SetVgsReg (1 records). Constants stored: none; ORed constants: none. Typical path conditions: stImgIn.enPixelFormat != 0x1D; a1[0x54] != 0x0; a1[0x70] != 0x1. Meaning UNKNOWN beyond the field sources.";
        field {
            name = "f_0_12";
            desc = "Field [12:0]. Sources (PROVEN expression, INFERRED naming): add(a6,lsl(a7,0x2))[0x4B0].";
            sw = rw;
            hw = r;
        } f_0_12[12:0];
        field {
            name = "f_16_28";
            desc = "Field [28:16]. Sources (PROVEN expression, INFERRED naming): a1[0xDC].";
            sw = rw;
            hw = r;
        } f_16_28[28:16];
    } W_564 @ 0x564;

    reg {
        name = "Image word 0x568";
        desc = "Image word 0x568. PROVEN: written by VGS_DRV_SetVgsReg (1 records). Constants stored: none; ORed constants: none. Typical path conditions: stImgIn.enPixelFormat != 0x1D; a1[0x54] != 0x0; a1[0x70] != 0x1. Meaning UNKNOWN beyond the field sources.";
        field {
            name = "f_0_12";
            desc = "Field [12:0]. Sources (PROVEN expression, INFERRED naming): sub(add(a6,lsl(a7,0x2))[0x420],0x1).";
            sw = rw;
            hw = r;
        } f_0_12[12:0];
        field {
            name = "f_16_28";
            desc = "Field [28:16]. Sources (PROVEN expression, INFERRED naming): sub(sub(a1[0xEC],0x1),a1[0xDC]).";
            sw = rw;
            hw = r;
        } f_16_28[28:16];
    } W_568 @ 0x568;

    reg {
        name = "Image word 0x56C";
        desc = "Image word 0x56C. PROVEN: written by VGS_DRV_SetVgsReg (1 records). Constants stored: none; ORed constants: none. Typical path conditions: stImgIn.enPixelFormat != 0x1D; a1[0x54] != 0x0; a1[0x70] != 0x1. Meaning UNKNOWN beyond the field sources.";
        field {
            name = "f_0_7";
            desc = "Field [7:0]. Sources (PROVEN expression, INFERRED naming): a1[0xCC].";
            sw = rw;
            hw = r;
        } f_0_7[7:0];
        field {
            name = "f_8_15";
            desc = "Field [15:8]. Sources (PROVEN expression, INFERRED naming): lsr(a1[0xCC],0x8).";
            sw = rw;
            hw = r;
        } f_8_15[15:8];
        field {
            name = "f_16_23";
            desc = "Field [23:16]. Sources (PROVEN expression, INFERRED naming): lsr(a1[0xCC],0x10).";
            sw = rw;
            hw = r;
        } f_16_23[23:16];
    } W_56C @ 0x56C;

    reg {
        name = "Image word 0x570";
        desc = "Image word 0x570. PROVEN: written by VGS_DRV_SetVgsReg (1 records). Constants stored: none; ORed constants: none. Typical path conditions: stImgIn.enPixelFormat != 0x1D; a1[0x54] != 0x0; a1[0x70] != 0x1. Meaning UNKNOWN beyond the field sources.";
        field {
            name = "f_0_12";
            desc = "Field [12:0]. Sources (PROVEN expression, INFERRED naming): add(a6,lsl(a7,0x2))[0x4D4].";
            sw = rw;
            hw = r;
        } f_0_12[12:0];
        field {
            name = "f_16_28";
            desc = "Field [28:16]. Sources (PROVEN expression, INFERRED naming): a1[0x110].";
            sw = rw;
            hw = r;
        } f_16_28[28:16];
    } W_570 @ 0x570;

    reg {
        name = "Image word 0x574";
        desc = "Image word 0x574. PROVEN: written by VGS_DRV_SetVgsReg (1 records). Constants stored: none; ORed constants: none. Typical path conditions: stImgIn.enPixelFormat != 0x1D; a1[0x54] != 0x0; a1[0x70] != 0x1. Meaning UNKNOWN beyond the field sources.";
        field {
            name = "f_0_12";
            desc = "Field [12:0]. Sources (PROVEN expression, INFERRED naming): sub(add(a6,lsl(a7,0x2))[0x444],0x1).";
            sw = rw;
            hw = r;
        } f_0_12[12:0];
        field {
            name = "f_16_28";
            desc = "Field [28:16]. Sources (PROVEN expression, INFERRED naming): sub(sub(a1[0x120],0x1),a1[0x110]).";
            sw = rw;
            hw = r;
        } f_16_28[28:16];
    } W_574 @ 0x574;

    reg {
        name = "Image word 0x578";
        desc = "Image word 0x578. PROVEN: written by VGS_DRV_SetVgsReg (1 records). Constants stored: none; ORed constants: none. Typical path conditions: stImgIn.enPixelFormat != 0x1D; a1[0x54] != 0x0; a1[0x70] != 0x1. Meaning UNKNOWN beyond the field sources.";
        field {
            name = "f_0_7";
            desc = "Field [7:0]. Sources (PROVEN expression, INFERRED naming): a1[0x100].";
            sw = rw;
            hw = r;
        } f_0_7[7:0];
        field {
            name = "f_8_15";
            desc = "Field [15:8]. Sources (PROVEN expression, INFERRED naming): lsr(a1[0x100],0x8).";
            sw = rw;
            hw = r;
        } f_8_15[15:8];
        field {
            name = "f_16_23";
            desc = "Field [23:16]. Sources (PROVEN expression, INFERRED naming): lsr(a1[0x100],0x10).";
            sw = rw;
            hw = r;
        } f_16_23[23:16];
    } W_578 @ 0x578;

    reg {
        name = "Image word 0x57C";
        desc = "Image word 0x57C. PROVEN: written by VGS_DRV_SetVgsReg (1 records). Constants stored: none; ORed constants: none. Typical path conditions: stImgIn.enPixelFormat != 0x1D; a1[0x54] != 0x0; a1[0x70] != 0x1. Meaning UNKNOWN beyond the field sources.";
        field {
            name = "f_0_12";
            desc = "Field [12:0]. Sources (PROVEN expression, INFERRED naming): add(a6,lsl(a7,0x2))[0x4F8].";
            sw = rw;
            hw = r;
        } f_0_12[12:0];
        field {
            name = "f_16_28";
            desc = "Field [28:16]. Sources (PROVEN expression, INFERRED naming): a1[0x144].";
            sw = rw;
            hw = r;
        } f_16_28[28:16];
    } W_57C @ 0x57C;

    reg {
        name = "Image word 0x580";
        desc = "Image word 0x580. PROVEN: written by VGS_DRV_SetVgsReg (1 records). Constants stored: none; ORed constants: none. Typical path conditions: stImgIn.enPixelFormat != 0x1D; a1[0x54] != 0x0; a1[0x70] != 0x1. Meaning UNKNOWN beyond the field sources.";
        field {
            name = "f_0_12";
            desc = "Field [12:0]. Sources (PROVEN expression, INFERRED naming): sub(add(a6,lsl(a7,0x2))[0x468],0x1).";
            sw = rw;
            hw = r;
        } f_0_12[12:0];
        field {
            name = "f_16_28";
            desc = "Field [28:16]. Sources (PROVEN expression, INFERRED naming): sub(sub(a1[0x154],0x1),a1[0x144]).";
            sw = rw;
            hw = r;
        } f_16_28[28:16];
    } W_580 @ 0x580;

    reg {
        name = "Image word 0x584";
        desc = "Image word 0x584. PROVEN: written by VGS_DRV_SetVgsReg (1 records). Constants stored: none; ORed constants: none. Typical path conditions: stImgIn.enPixelFormat != 0x1D; a1[0x54] != 0x0; a1[0x70] != 0x1. Meaning UNKNOWN beyond the field sources.";
        field {
            name = "f_0_7";
            desc = "Field [7:0]. Sources (PROVEN expression, INFERRED naming): a1[0x134].";
            sw = rw;
            hw = r;
        } f_0_7[7:0];
        field {
            name = "f_8_15";
            desc = "Field [15:8]. Sources (PROVEN expression, INFERRED naming): lsr(a1[0x134],0x8).";
            sw = rw;
            hw = r;
        } f_8_15[15:8];
        field {
            name = "f_16_23";
            desc = "Field [23:16]. Sources (PROVEN expression, INFERRED naming): lsr(a1[0x134],0x10).";
            sw = rw;
            hw = r;
        } f_16_23[23:16];
    } W_584 @ 0x584;

    reg {
        name = "Image word 0x588";
        desc = "Image word 0x588. PROVEN: written by VGS_DRV_SetVgsReg (1 records). Constants stored: none; ORed constants: none. Typical path conditions: stImgIn.enPixelFormat != 0x1D; a1[0x54] != 0x0; a1[0x70] != 0x1. Meaning UNKNOWN beyond the field sources.";
        field {
            name = "f_0_12";
            desc = "Field [12:0]. Sources (PROVEN expression, INFERRED naming): add(a6,lsl(a7,0x2))[0x51C].";
            sw = rw;
            hw = r;
        } f_0_12[12:0];
        field {
            name = "f_16_28";
            desc = "Field [28:16]. Sources (PROVEN expression, INFERRED naming): a1[0x178].";
            sw = rw;
            hw = r;
        } f_16_28[28:16];
    } W_588 @ 0x588;

    reg {
        name = "Image word 0x58C";
        desc = "Image word 0x58C. PROVEN: written by VGS_DRV_SetVgsReg (1 records). Constants stored: none; ORed constants: none. Typical path conditions: stImgIn.enPixelFormat != 0x1D; a1[0x54] != 0x0; a1[0x70] != 0x1. Meaning UNKNOWN beyond the field sources.";
        field {
            name = "f_0_12";
            desc = "Field [12:0]. Sources (PROVEN expression, INFERRED naming): sub(add(a6,lsl(a7,0x2))[0x48C],0x1).";
            sw = rw;
            hw = r;
        } f_0_12[12:0];
        field {
            name = "f_16_28";
            desc = "Field [28:16]. Sources (PROVEN expression, INFERRED naming): sub(sub(a1[0x188],0x1),a1[0x178]).";
            sw = rw;
            hw = r;
        } f_16_28[28:16];
    } W_58C @ 0x58C;

    reg {
        name = "Image word 0x590";
        desc = "Image word 0x590. PROVEN: written by VGS_DRV_SetVgsReg (1 records). Constants stored: none; ORed constants: none. Typical path conditions: stImgIn.enPixelFormat != 0x1D; a1[0x54] != 0x0; a1[0x70] != 0x1. Meaning UNKNOWN beyond the field sources.";
        field {
            name = "f_0_7";
            desc = "Field [7:0]. Sources (PROVEN expression, INFERRED naming): a1[0x168].";
            sw = rw;
            hw = r;
        } f_0_7[7:0];
        field {
            name = "f_8_15";
            desc = "Field [15:8]. Sources (PROVEN expression, INFERRED naming): lsr(a1[0x168],0x8).";
            sw = rw;
            hw = r;
        } f_8_15[15:8];
        field {
            name = "f_16_23";
            desc = "Field [23:16]. Sources (PROVEN expression, INFERRED naming): lsr(a1[0x168],0x10).";
            sw = rw;
            hw = r;
        } f_16_23[23:16];
    } W_590 @ 0x590;

    reg {
        name = "Image word 0x5A0";
        desc = "Image word 0x5A0. PROVEN: written by VGS_DRV_SetVgsReg (1 records). Constants stored: none; ORed constants: 0xc0. Typical path conditions: stImgIn.enPixelFormat != 0x1D; a1[0x54] != 0x0; a1[0x70] != 0x1. Meaning UNKNOWN beyond the field sources.";
        field {
            name = "word";
            desc = "32-bit word (no struct-member source found).";
            sw = rw;
            hw = r;
        } word[31:0];
    } W_5A0 @ 0x5A0;

    reg {
        name = "Image word 0x5A4";
        desc = "Image word 0x5A4. PROVEN: written by VGS_DRV_SetVgsReg (1 records). Constants stored: none; ORed constants: 0x1. Typical path conditions: stImgIn.enPixelFormat != 0x1D; a1[0x54] != 0x0; a1[0x70] != 0x1. Meaning UNKNOWN beyond the field sources.";
        field {
            name = "word";
            desc = "32-bit word (no struct-member source found).";
            sw = rw;
            hw = r;
        } word[31:0];
    } W_5A4 @ 0x5A4;

    reg {
        name = "Image word 0x5B4";
        desc = "Image word 0x5B4. PROVEN: written by VGS_DRV_SetVgsReg (1 records). Constants stored: none; ORed constants: 0x800080. Typical path conditions: stImgIn.enPixelFormat != 0x1D; a1[0x54] != 0x0; a1[0x70] != 0x1. Meaning UNKNOWN beyond the field sources.";
        field {
            name = "word";
            desc = "32-bit word (no struct-member source found).";
            sw = rw;
            hw = r;
        } word[31:0];
    } W_5B4 @ 0x5B4;

    reg {
        name = "Image word 0x5B8";
        desc = "Image word 0x5B8. PROVEN: written by VGS_DRV_SetVgsReg (1 records). Constants stored: none; ORed constants: 0xc0405050. Typical path conditions: stImgIn.enPixelFormat != 0x1D; a1[0x54] != 0x0; a1[0x70] != 0x1. Meaning UNKNOWN beyond the field sources.";
        field {
            name = "word";
            desc = "32-bit word (no struct-member source found).";
            sw = rw;
            hw = r;
        } word[31:0];
    } W_5B8 @ 0x5B8;

    reg {
        name = "Image word 0x5BC";
        desc = "Image word 0x5BC. PROVEN: written by VGS_DRV_SetVgsReg (1 records). Constants stored: none; ORed constants: 0xc000. Typical path conditions: stImgIn.enPixelFormat != 0x1D; a1[0x54] != 0x0; a1[0x70] != 0x1. Meaning UNKNOWN beyond the field sources.";
        field {
            name = "word";
            desc = "32-bit word (no struct-member source found).";
            sw = rw;
            hw = r;
        } word[31:0];
    } W_5BC @ 0x5BC;

    reg {
        name = "Image word 0x5C0";
        desc = "Image word 0x5C0. PROVEN: written by VGS_DRV_SetVgsReg (1 records). Constants stored: none; ORed constants: 0x1. Typical path conditions: stImgIn.enPixelFormat != 0x1D; a1[0x54] != 0x0; a1[0x70] != 0x1. Meaning UNKNOWN beyond the field sources.";
        field {
            name = "word";
            desc = "32-bit word (no struct-member source found).";
            sw = rw;
            hw = r;
        } word[31:0];
    } W_5C0 @ 0x5C0;

    reg {
        name = "Image word 0x5D0";
        desc = "Image word 0x5D0. PROVEN: written by VGS_DRV_SetVgsReg (1 records). Constants stored: none; ORed constants: 0xff00ff. Typical path conditions: stImgIn.enPixelFormat != 0x1D; a1[0x54] != 0x0; a1[0x70] != 0x1. Meaning UNKNOWN beyond the field sources.";
        field {
            name = "word";
            desc = "32-bit word (no struct-member source found).";
            sw = rw;
            hw = r;
        } word[31:0];
    } W_5D0 @ 0x5D0;

    reg {
        name = "Image word 0x5D4";
        desc = "Image word 0x5D4. PROVEN: written by VGS_DRV_SetVgsReg (1 records). Constants stored: none; ORed constants: 0xc0405050. Typical path conditions: stImgIn.enPixelFormat != 0x1D; a1[0x54] != 0x0; a1[0x70] != 0x1. Meaning UNKNOWN beyond the field sources.";
        field {
            name = "word";
            desc = "32-bit word (no struct-member source found).";
            sw = rw;
            hw = r;
        } word[31:0];
    } W_5D4 @ 0x5D4;

    reg {
        name = "Image word 0x5D8";
        desc = "Image word 0x5D8. PROVEN: written by VGS_DRV_SetVgsReg (1 records). Constants stored: none; ORed constants: 0x1806060. Typical path conditions: stImgIn.enPixelFormat != 0x1D; a1[0x54] != 0x0; a1[0x70] != 0x1. Meaning UNKNOWN beyond the field sources.";
        field {
            name = "f_30_30";
            desc = "Field [30:30]. Sources (PROVEN expression, INFERRED naming): a1[0x4C].";
            sw = rw;
            hw = r;
        } f_30_30[30:30];
        field {
            name = "f_31_31";
            desc = "Field [31:31]. Sources (PROVEN expression, INFERRED naming): a1[0x4C].";
            sw = rw;
            hw = r;
        } f_31_31[31:31];
    } W_5D8 @ 0x5D8;

    reg {
        name = "Image word 0x5DC";
        desc = "Image word 0x5DC. PROVEN: written by VGS_DRV_SetVgsReg (1 records). Constants stored: none; ORed constants: 0x10040. Typical path conditions: stImgIn.enPixelFormat != 0x1D; a1[0x54] != 0x0; a1[0x70] != 0x1. Meaning UNKNOWN beyond the field sources.";
        field {
            name = "f_20_27";
            desc = "Field [27:20]. Sources (PROVEN expression, INFERRED naming): a1[0x50].";
            sw = rw;
            hw = r;
        } f_20_27[27:20];
    } W_5DC @ 0x5DC;

    reg {
        name = "Image word 0x620";
        desc = "Image word 0x620. PROVEN: written by VGS_DRV_SetVgsReg (1 records). Constants stored: none; ORed constants: 0x7. Typical path conditions: stImgIn.enPixelFormat != 0x1D; a1[0x54] != 0x0; a1[0x70] != 0x1. Meaning UNKNOWN beyond the field sources.";
        field {
            name = "f_12_12";
            desc = "Field [12:12]. Sources (PROVEN expression, INFERRED naming): sel(a7 != 0xFFFFFFFF?sel(a7 != 0xFFFFFFFF?add(a6,lsl(a7,0x2)):0x40)[0xB04]:sel(a7 == 0xFFF.";
            sw = rw;
            hw = r;
        } f_12_12[12:12];
    } W_620 @ 0x620;

    reg {
        name = "Image word 0x624";
        desc = "Image word 0x624. PROVEN: written by VGS_DRV_SetVgsReg (1 records). Constants stored: none; ORed constants: 0x40. Typical path conditions: stImgIn.enPixelFormat != 0x1D; a1[0x54] != 0x0; a1[0x70] != 0x1. Meaning UNKNOWN beyond the field sources.";
        field {
            name = "word";
            desc = "32-bit word (no struct-member source found).";
            sw = rw;
            hw = r;
        } word[31:0];
    } W_624 @ 0x624;

    reg {
        name = "Image word 0x628";
        desc = "Image word 0x628. PROVEN: written by VGS_DRV_SetVgsReg (1 records). Constants stored: none; ORed constants: none. Typical path conditions: stImgIn.enPixelFormat != 0x1D; a1[0x54] != 0x0; a1[0x70] != 0x1. Meaning UNKNOWN beyond the field sources.";
        field {
            name = "f_0_12";
            desc = "Field [12:0]. Sources (PROVEN expression, INFERRED naming): sel(a7 != 0xFFFFFFFF?and(sel(a7 != 0xFFFFFFFF?and(sel(a7 == 0xFFFFFFFF?0x0:sel(a7 != 0xFFF.";
            sw = rw;
            hw = r;
        } f_0_12[12:0];
        field {
            name = "f_16_28";
            desc = "Field [28:16]. Sources (PROVEN expression, INFERRED naming): sel(a7 != 0xFFFFFFFF?add(sel(a7 != 0xFFFFFFFF?and(sel(a7 == 0xFFFFFFFF?0x0:sel(a7 != 0xFFF.";
            sw = rw;
            hw = r;
        } f_16_28[28:16];
    } W_628 @ 0x628;

    reg {
        name = "Image word 0x62C";
        desc = "Image word 0x62C. PROVEN: written by VGS_DRV_SetVgsReg (1 records). Constants stored: none; ORed constants: none. Typical path conditions: stImgIn.enPixelFormat != 0x1D; a1[0x54] != 0x0; a1[0x70] != 0x1. Meaning UNKNOWN beyond the field sources.";
        field {
            name = "f_16_28";
            desc = "Field [28:16]. Sources (PROVEN expression, INFERRED naming): a1[0x40].";
            sw = rw;
            hw = r;
        } f_16_28[28:16];
    } W_62C @ 0x62C;

    reg {
        name = "Image word 0x630";
        desc = "Image word 0x630. PROVEN: written by VGS_DRV_SetVgsReg (1 records). Constants stored: none; ORed constants: 0x11890. Typical path conditions: stImgIn.enPixelFormat != 0x1D; a1[0x54] != 0x0; a1[0x70] != 0x1. Meaning UNKNOWN beyond the field sources.";
        field {
            name = "f_1_3";
            desc = "Field [3:1]. Sources (PROVEN expression, INFERRED naming): sel(a1[0xAC] >=s 0x7?0x7:a1[0xAC]).";
            sw = rw;
            hw = r;
        } f_1_3[3:1];
    } W_630 @ 0x630;

    reg {
        name = "Image word 0x634";
        desc = "Image word 0x634. PROVEN: written by VGS_DRV_SetVgsReg (1 records). Constants stored: none; ORed constants: 0x421. Typical path conditions: stImgIn.enPixelFormat != 0x1D; a1[0x54] != 0x0; a1[0x70] != 0x1. Meaning UNKNOWN beyond the field sources.";
        field {
            name = "word";
            desc = "32-bit word (no struct-member source found).";
            sw = rw;
            hw = r;
        } word[31:0];
    } W_634 @ 0x634;

    reg {
        name = "Image word 0x638";
        desc = "Image word 0x638. PROVEN: written by VGS_DRV_SetVgsReg (1 records). Constants stored: none; ORed constants: none. Typical path conditions: stImgIn.enPixelFormat != 0x1D; a1[0x54] != 0x0; a1[0x70] != 0x1. Meaning UNKNOWN beyond the field sources.";
        field {
            name = "word";
            desc = "32-bit word (no struct-member source found).";
            sw = rw;
            hw = r;
        } word[31:0];
    } W_638 @ 0x638;

    reg {
        name = "Image word 0x63C";
        desc = "Image word 0x63C. PROVEN: written by VGS_DRV_SetVgsReg (1 records). Constants stored: none; ORed constants: 0x121212. Typical path conditions: stImgIn.enPixelFormat != 0x1D; a1[0x54] != 0x0; a1[0x70] != 0x1. Meaning UNKNOWN beyond the field sources.";
        field {
            name = "word";
            desc = "32-bit word (no struct-member source found).";
            sw = rw;
            hw = r;
        } word[31:0];
    } W_63C @ 0x63C;

    reg {
        name = "Image word 0x640";
        desc = "Image word 0x640. PROVEN: written by VGS_DRV_SetVgsReg (1 records). Constants stored: none; ORed constants: none. Typical path conditions: stImgIn.enPixelFormat != 0x1D; a1[0x54] != 0x0; a1[0x70] != 0x1. Meaning UNKNOWN beyond the field sources.";
        field {
            name = "word";
            desc = "32-bit word (no struct-member source found).";
            sw = rw;
            hw = r;
        } word[31:0];
    } W_640 @ 0x640;

    reg {
        name = "Image word 0x644";
        desc = "Image word 0x644. PROVEN: written by VGS_DRV_SetVgsReg (1 records). Constants stored: none; ORed constants: none. Typical path conditions: stImgIn.enPixelFormat != 0x1D; a1[0x54] != 0x0; a1[0x70] != 0x1. Meaning UNKNOWN beyond the field sources.";
        field {
            name = "word";
            desc = "32-bit word (no struct-member source found).";
            sw = rw;
            hw = r;
        } word[31:0];
    } W_644 @ 0x644;

    reg {
        name = "Image word 0x648";
        desc = "Image word 0x648. PROVEN: written by VGS_DRV_SetVgsReg (1 records). Constants stored: none; ORed constants: none. Typical path conditions: stImgIn.enPixelFormat != 0x1D; a1[0x54] != 0x0; a1[0x70] != 0x1. Meaning UNKNOWN beyond the field sources.";
        field {
            name = "f_0_5";
            desc = "Field [5:0]. Sources (PROVEN expression, INFERRED naming): a1[0xB0].";
            sw = rw;
            hw = r;
        } f_0_5[5:0];
        field {
            name = "f_6_11";
            desc = "Field [11:6]. Sources (PROVEN expression, INFERRED naming): a1[0xB0].";
            sw = rw;
            hw = r;
        } f_6_11[11:6];
        field {
            name = "f_12_17";
            desc = "Field [17:12]. Sources (PROVEN expression, INFERRED naming): a1[0xB0].";
            sw = rw;
            hw = r;
        } f_12_17[17:12];
    } W_648 @ 0x648;

    reg {
        name = "Image word 0x64C";
        desc = "Image word 0x64C. PROVEN: written by VGS_DRV_SetVgsReg (1 records). Constants stored: none; ORed constants: 0x2. Typical path conditions: stImgIn.enPixelFormat != 0x1D; a1[0x54] != 0x0; a1[0x70] != 0x1. Meaning UNKNOWN beyond the field sources.";
        field {
            name = "word";
            desc = "32-bit word (no struct-member source found).";
            sw = rw;
            hw = r;
        } word[31:0];
    } W_64C @ 0x64C;

    reg {
        name = "Image word 0x650";
        desc = "Image word 0x650. PROVEN: written by VGS_DRV_SetVgsReg (1 records). Constants stored: none; ORed constants: 0x51. Typical path conditions: stImgIn.enPixelFormat != 0x1D; a1[0x54] != 0x0; a1[0x70] != 0x1. Meaning UNKNOWN beyond the field sources.";
        field {
            name = "word";
            desc = "32-bit word (no struct-member source found).";
            sw = rw;
            hw = r;
        } word[31:0];
    } W_650 @ 0x650;

    reg {
        name = "Image word 0x654";
        desc = "Image word 0x654. PROVEN: written by VGS_DRV_SetVgsReg (1 records). Constants stored: none; ORed constants: none. Typical path conditions: stImgIn.enPixelFormat != 0x1D; a1[0x54] != 0x0; a1[0x70] != 0x1. Meaning UNKNOWN beyond the field sources.";
        field {
            name = "f_0_15";
            desc = "Field [15:0]. Sources (PROVEN expression, INFERRED naming): sel(a7 == 0xFFFFFFFF?and(sel(a7 == 0xFFFFFFFF?IMG[0x628]:sel(a7 != 0xFFFFFFFF?0x0:orr(bic(.";
            sw = rw;
            hw = r;
        } f_0_15[15:0];
        field {
            name = "f_16_31";
            desc = "Field [31:16]. Sources (PROVEN expression, INFERRED naming): sel(a7 == 0xFFFFFFFF?and(lsr(sel(a7 != 0xFFFFFFFF?sel(a7 == 0xFFFFFFFF?IMG[0x628]:sel(a7 !.";
            sw = rw;
            hw = r;
        } f_16_31[31:16];
    } W_654 @ 0x654;

    reg {
        name = "Image word 0x658";
        desc = "Image word 0x658. PROVEN: written by VGS_DRV_SetVgsReg (1 records). Constants stored: none; ORed constants: none. Typical path conditions: stImgIn.enPixelFormat != 0x1D; a1[0x54] != 0x0; a1[0x70] != 0x1. Meaning UNKNOWN beyond the field sources.";
        field {
            name = "f_0_12";
            desc = "Field [12:0]. Sources (PROVEN expression, INFERRED naming): IMG[0x62C].";
            sw = rw;
            hw = r;
        } f_0_12[12:0];
        field {
            name = "f_16_28";
            desc = "Field [28:16]. Sources (PROVEN expression, INFERRED naming): lsr(IMG[0x62C],0x10).";
            sw = rw;
            hw = r;
        } f_16_28[28:16];
    } W_658 @ 0x658;

};

addrmap aHI3536D_VGS_IMG {
    name = "VGS job image layout (placeholder window, NOT hardware)";
    desc = "Placeholder address 0x13150000 (reserved in the data sheet) only to show the DDR job image layout in the register browser.";
    eHI3536D_VGS_IMG IMG @ 0x0;
};

`endif
