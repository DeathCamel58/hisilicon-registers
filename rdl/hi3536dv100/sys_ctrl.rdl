`ifndef HI3536D_SYS_CTRL_RDL
`define HI3536D_SYS_CTRL_RDL
regfile eHI3536D_SYS_CTRL {
    name = "System controller (SC), Hi3536D V100";
    desc = "System controller (SC) of the Hi3536D V100 at base 0x12050000. 9 registers extracted programmatically from the Hi3536D V100 data sheet (Issue 00B04, 2017-12-13, Table 3-9, chapter 3.3), register descriptions and field tables; reset values are the data sheet total reset values split onto the fields. Source: dl/research-hi3536 ReleaseDoc (unofficial copy of the HiSilicon SDK documentation; facts only). Field names, bit ranges, access types and reset values are exact; the free-text descriptions are attributed to fields from the PDF text layout (title sentence above the bit row, enumerations below) and can be shifted by one field where a sentence wraps: check the data sheet page when a description matters. Hardware not yet verified (no Hi3536D board on the bench).";
    reg {
        name = "SC_CTRL";
        desc = "SC_CTRL (offset 0x0, total reset 0x00000212; PROVEN: Hi3536D V100 data sheet).";
        field {
            name = "timeren7ov";
            desc = "Timer 7 count clock select 0: 3 MHz clock 1: periapb bus clock";
            sw = rw; hw = r;
            reset = 0x0;
        } timeren7ov[31:31];
        field {
            name = "reserved_30_30";
            desc = "Reserved";
            sw = rw; hw = r;
            reset = 0x0;
        } reserved_30_30[30:30];
        field {
            name = "timeren6ov";
            desc = "Timer 6 count clock select 0: 3 MHz clock 1: periapb bus clock";
            sw = rw; hw = r;
            reset = 0x0;
        } timeren6ov[29:29];
        field {
            name = "reserved_28_28";
            desc = "Reserved";
            sw = rw; hw = r;
            reset = 0x0;
        } reserved_28_28[28:28];
        field {
            name = "timeren5ov";
            desc = "Timer 5 count clock select 0: 3 MHz clock 1: periapb bus clock";
            sw = rw; hw = r;
            reset = 0x0;
        } timeren5ov[27:27];
        field {
            name = "reserved_26_26";
            desc = "Reserved";
            sw = rw; hw = r;
            reset = 0x0;
        } reserved_26_26[26:26];
        field {
            name = "timeren4ov";
            desc = "Timer 4 count clock select 0: 3 MHz clock 1: periapb bus clock";
            sw = rw; hw = r;
            reset = 0x0;
        } timeren4ov[25:25];
        field {
            name = "reserved_24_23";
            desc = "Reserved";
            sw = rw; hw = r;
            reset = 0x0;
        } reserved_24_23[24:23];
        field {
            name = "timeren3ov";
            desc = "Timer 3 count clock select 0: 3 MHz clock 1: periapb bus clock";
            sw = rw; hw = r;
            reset = 0x0;
        } timeren3ov[22:22];
        field {
            name = "reserved_21_21";
            desc = "Reserved";
            sw = rw; hw = r;
            reset = 0x0;
        } reserved_21_21[21:21];
        field {
            name = "timeren2ov";
            desc = "Timer 2 count clock select 0: 3 MHz clock 1: periapb bus clock";
            sw = rw; hw = r;
            reset = 0x0;
        } timeren2ov[20:20];
        field {
            name = "reserved_19_19";
            desc = "Reserved";
            sw = rw; hw = r;
            reset = 0x0;
        } reserved_19_19[19:19];
        field {
            name = "timeren1ov";
            desc = "Timer 1 count clock select 0: 3 MHz clock 1: periapb bus clock";
            sw = rw; hw = r;
            reset = 0x0;
        } timeren1ov[18:18];
        field {
            name = "reserved_17_17";
            desc = "Reserved";
            sw = rw; hw = r;
            reset = 0x0;
        } reserved_17_17[17:17];
        field {
            name = "timeren0ov";
            desc = "Timer 0 count clock select 0: 3 MHz clock 1: periapb bus clock";
            sw = rw; hw = r;
            reset = 0x0;
        } timeren0ov[16:16];
        field {
            name = "reserved_15_10";
            desc = "Reserved 0: The address is not remapped.";
            sw = rw; hw = r;
            reset = 0x0;
        } reserved_15_10[15:10];
        field {
            name = "remapstat";
            desc = "Address remap status 1: The address is remapped. The BOOTROM or SFC CS 0 is remapped to address 0. 0: The remap status is retained.";
            sw = r; hw = w;
            reset = 0x1;
        } remapstat[9:9];
        field {
            name = "remapclear";
            desc = "Address remap clear 1: The remap status is cleared.";
            sw = rw; hw = r;
            reset = 0x0;
        } remapclear[8:8];
        field {
            name = "reserved_7_0";
            desc = "For details about the address mappings before and after remapping is cleared, see Table 1-2 'Address space mapping' in chapter 1 'Product Description.' Reserved. Reading this field returns 0, and writing to this field has no effect.";
            sw = r; hw = na;
            reset = 0x12;
        } reserved_7_0[7:0];
    } SC_CTRL @ 0x0;
    reg {
        name = "SC_SYSRES";
        desc = "SC_SYSRES (offset 0x4, total reset 0x00000002; PROVEN: Hi3536D V100 data sheet).";
        field {
            name = "softresreq";
            desc = "Writing any value to this register soft-resets the system.";
            sw = w; hw = r;
            reset = 0x2;
        } softresreq[31:0];
    } SC_SYSRES @ 0x4;
    reg {
        name = "SOFTTYPE";
        desc = "SOFTTYPE (offset 0x20, total reset 0x00000000; PROVEN: Hi3536D V100 data sheet).";
        field {
            name = "software_int_vector";
            desc = "Software interrupt vector";
            sw = rw; hw = r;
            reset = 0x0;
        } software_int_vector[31:0];
    } SOFTTYPE @ 0x20;
    reg {
        name = "SC_LOCKEN";
        desc = "SC_LOCKEN (offset 0x44, total reset 0x00000000; PROVEN: Hi3536D V100 data sheet).";
        field {
            name = "scper_lockl";
            desc = "Register for locking key system control registers. The key registers include SC_CTRL, SC_SYSRES. When 0x1ACC_E551 is written to SC_LOCKEN, the write permission for all registers is enabled; when any other value is written to SC_LOCKEN, the write permission is disabled. Reading this register returns the lock status but not the written value. 0x0000_0000: The write permission is enabled (unlocked). ";
            sw = rw; hw = r;
            reset = 0x0;
        } scper_lockl[31:0];
    } SC_LOCKEN @ 0x44;
    reg {
        name = "SYSSTAT";
        desc = "SYSSTAT is a system status register. (offset 0x8C, total reset 0x00000000; PROVEN: Hi3536D V100 data sheet).";
        field {
            name = "bootrom_sel";
            desc = "Whether the system boots from the BOOTROM 0: Boot from an off-chip SPI flash. 1: Boot from the on-chip BOOTROM.";
            sw = r; hw = w;
            reset = 0x0;
        } bootrom_sel[31:31];
        field {
            name = "reserved_30_9";
            desc = "Reserved";
            sw = r; hw = w;
            reset = 0x0;
        } reserved_30_9[30:9];
        field {
            name = "sfc_device_mode";
            desc = "SPI flash type 0: SPI NOR flash 1: SPI NAND flash sfc_device_mode is 0. 0: 3-byte address mode 1: 4-byte address mode";
            sw = r; hw = w;
            reset = 0x0;
        } sfc_device_mode[8:8];
        field {
            name = "sfc_addr_mode";
            desc = "This bit indicates the SPI NOR flash boot address mode when sfc_device_mode is 1. 0: 1-wire mode 1: 4-wire mode";
            sw = r; hw = w;
            reset = 0x0;
        } sfc_addr_mode[7:7];
        field {
            name = "reserved_6_0";
            desc = "This bit indicates the SPI NAND flash boot mode when Reserved";
            sw = rw; hw = r;
            reset = 0x0;
        } reserved_6_0[6:0];
    } SYSSTAT @ 0x8C;
    reg {
        name = "SCSYSID0";
        desc = "SCSYSID0 (offset 0xEE0, total reset 0x00000000; PROVEN: Hi3536D V100 data sheet).";
        field {
            name = "chipid";
            desc = "Chip version. Reading this register returns TBD.";
            sw = r; hw = w;
            reset = 0x0;
        } chipid[31:24];
        field {
            name = "reserved_23_8";
            desc = "Reserved";
            sw = r; hw = w;
            reset = 0x0;
        } reserved_23_8[23:8];
        field {
            name = "sysid0";
            desc = "Reading this register returns 0x00.";
            sw = r; hw = w;
            reset = 0x0;
        } sysid0[7:0];
    } SCSYSID0 @ 0xEE0;
    reg {
        name = "SCSYSID1";
        desc = "SCSYSID1 is chip ID register 1. (offset 0xEE4, total reset 0x000000D1; PROVEN: Hi3536D V100 data sheet).";
        field {
            name = "sysid1";
            desc = "Reading this register returns 0xD1.";
            sw = r; hw = w;
            reset = 0xd1;
        } sysid1[7:0];
    } SCSYSID1 @ 0xEE4;
    reg {
        name = "SCSYSID2";
        desc = "SCSYSID2 is chip ID register 2. (offset 0xEE8, total reset 0x00000036; PROVEN: Hi3536D V100 data sheet).";
        field {
            name = "sysid2";
            desc = "Reading this register returns 0x36. Issue 00B04 (2017-12-13)                                                                                                                                3-64";
            sw = r; hw = w;
            reset = 0x36;
        } sysid2[7:0];
    } SCSYSID2 @ 0xEE8;
    reg {
        name = "SCSYSID3";
        desc = "SCSYSID3 is chip ID register 3. (offset 0xEEC, total reset 0x00000035; PROVEN: Hi3536D V100 data sheet).";
        field {
            name = "sysid3";
            desc = "Reading this register returns 0x35. 3.5.5 Peripheral Control Registers 3.5.5.1 Register Summary Table 3-10 describes peripheral control registers. Table 3-10 Summary of peripheral control registers (base address: 0x1212_0000) 0x0008                MISC_CTRL2           Peripheral function selection register 0          3-66 0x0050                MISC_CTRL20          USB 2.0 control register 0       ";
            sw = r; hw = w;
            reset = 0x35;
        } sysid3[7:0];
    } SCSYSID3 @ 0xEEC;
};

`endif
