`ifndef HI3536D_ACODEC_RDL
`define HI3536D_ACODEC_RDL
regfile eHI3536D_ACODEC {
    name = "Integrated audio DAC/CODEC, Hi3536D V100";
    desc = "Integrated audio DAC/CODEC of the Hi3536D V100 at base 0x13050000. 2 registers extracted programmatically from the Hi3536D V100 data sheet (Issue 00B04, 2017-12-13, Table 10-3), register descriptions and field tables; reset values are the data sheet total reset values split onto the fields. Source: dl/research-hi3536 ReleaseDoc (unofficial copy of the HiSilicon SDK documentation; facts only). Field names, bit ranges, access types and reset values are exact; the free-text descriptions are attributed to fields from the PDF text layout (title sentence above the bit row, enumerations below) and can be shifted by one field where a sentence wraps: check the data sheet page when a description matters. Hardware not yet verified (no Hi3536D board on the bench).";
    reg {
        name = "AUDIO_DAC";
        desc = "AUDIO_DAC (offset 0xD0, total reset 0xF8400606; PROVEN: Hi3536D V100 data sheet).";
        field {
            name = "pd_dacl";
            desc = "Power-down control for the DAC audio-left channel 0: The digital and analog parts work properly. 1: The digital part outputs 0, whereas the analog part is powered down. 0: The digital and analog parts work properly.";
            sw = rw; hw = r;
            reset = 0x1;
        } pd_dacl[31:31];
        field {
            name = "pd_dacr";
            desc = "Power-down control for the DAC audio-right channel 1: The digital part outputs 0, whereas the analog part is powered down.";
            sw = rw; hw = r;
            reset = 0x1;
        } pd_dacr[30:30];
        field {
            name = "mute_dacl";
            desc = "Mute control for the DAC audio-left channel 0: The digital and analog audio-left channels work properly. 1: The digital and analog audio-left channels are muted.";
            sw = rw; hw = r;
            reset = 0x1;
        } mute_dacl[29:29];
        field {
            name = "mute_dacr";
            desc = "Mute control for the DAC audio-right channel 0: The digital and analog audio-right channels work properly. 1: The digital and analog audio-right channels are muted.";
            sw = rw; hw = r;
            reset = 0x1;
        } mute_dacr[28:28];
        field {
            name = "reserved_27_15";
            desc = "Reserved 0x00: +6 dB 0x01: +5 dB";
            sw = r; hw = na;
            reset = 0x1080;
        } reserved_27_15[27:15];
        field {
            name = "dacl_vol";
            desc = "Output volume of the audio-left channel 0x06: 0 dB … (The step is 1 dB.) 0x7F: –121 dB";
            sw = rw; hw = r;
            reset = 0x6;
        } dacl_vol[14:8];
        field {
            name = "reserved_7_7";
            desc = "Reserved 0x00: +6 dB 0x01: +5 dB";
            sw = rw; hw = r;
            reset = 0x0;
        } reserved_7_7[7:7];
        field {
            name = "dacr_vol";
            desc = "Output volume of the audio-right channel 0x06: 0 dB … (The step is 1 dB.) 0x7F: –121 dB";
            sw = rw; hw = r;
            reset = 0x6;
        } dacr_vol[6:0];
    } AUDIO_DAC @ 0xD0;
    reg {
        name = "AUDIO_DAC1";
        desc = "AUDIO_DAC1 is ADAC configuration register 1. (offset 0xD4, total reset 0x00E06755; PROVEN: Hi3536D V100 data sheet).";
        field {
            name = "smutel";
            desc = "Soft mute control for the audio-left channel 0: Soft mute is disabled. 1: Soft mute is enabled.";
            sw = rw; hw = r;
            reset = 0x0;
        } smutel[31:31];
        field {
            name = "smuter";
            desc = "Soft mute control for the audio-right channel 0: Soft mute is disabled 1: Soft mute is enabled";
            sw = rw; hw = r;
            reset = 0x0;
        } smuter[30:30];
        field {
            name = "sunmutel";
            desc = "Soft unmute control for the audio-left channel of the digital circuit 0: Soft unmute is disabled 1: Soft unmute is enabled circuit";
            sw = rw; hw = r;
            reset = 0x0;
        } sunmutel[29:29];
        field {
            name = "sunmuter";
            desc = "Soft unmute control for the audio-right channel of the digital 0: Soft unmute is disabled 1: Soft unmute is enabled channels 0: The gains of the audio-left and audio-right channels remain";
            sw = rw; hw = r;
            reset = 0x0;
        } sunmuter[28:28];
        field {
            name = "dacvu";
            desc = "Synchronization of the digital volume of audio-left and audio-right unchanged. 1: The volumes of audio-left and audio-right channels are synchronized. 00: fs/2";
            sw = rw; hw = r;
            reset = 0x0;
        } dacvu[27:27];
        field {
            name = "mute_rate";
            desc = "Volume gain step when the audio-right and audio-left channels are soft muted or soft unmuted 01: fs/8 10: fs/32 11: fs/64";
            sw = rw; hw = r;
            reset = 0x0;
        } mute_rate[26:25];
        field {
            name = "reserved_24_24";
            desc = "Reserved 00: 16 bits";
            sw = rw; hw = r;
            reset = 0x0;
        } reserved_24_24[24:24];
        field {
            name = "data_bits";
            desc = "Number of interface data bits 11: 24 bits Other values: reserved";
            sw = rw; hw = r;
            reset = 0x3;
        } data_bits[23:22];
        field {
            name = "reserved_21_13";
            desc = "Reserved";
            sw = r; hw = na;
            reset = 0x103;
        } reserved_21_13[21:13];
        field {
            name = "rst";
            desc = "DAC_ANA reset signal 0: normal work mode 1: reset";
            sw = rw; hw = r;
            reset = 0x0;
        } rst[12:12];
        field {
            name = "reserved_11_0";
            desc = "Reserved 11 Peripherals ...............................................................................................................................11-1 11.1 I2C Controller ............................................................................................................................................ 11-1 11.1.1 Overview ..............................................................";
            sw = r; hw = na;
            reset = 0x755;
        } reserved_11_0[11:0];
    } AUDIO_DAC1 @ 0xD4;
};

`endif
