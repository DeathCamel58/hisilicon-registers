`ifndef HI3536D_ACODEC_RDL
`define HI3536D_ACODEC_RDL
regfile eHI3536D_ACODEC {
    name = "Integrated audio DAC/CODEC, Hi3536D V100";
    desc = "Integrated audio DAC/CODEC, Hi3536D V100 of the Hi3536D V100 at base 0x1305_0000. 2 registers extracted programmatically from the Hi3536D V100 data sheet (Issue 00B04, 2017-12-13) (Table 10-3 Summary of audio DAC registers (base address: 0x1305_0000)): register headings, offsets, total reset values, field bit ranges, access types, names, reset values and descriptions, with PDF page numbers in each register description. Field names, bit ranges, access types and offsets are exact; the free-text descriptions are taken from the cell text of the field table and were checked by sampling only. Hardware not verified.";
    reg {
        name = "AUDIO_DAC";
        desc = "AUDIO_DAC is ADAC configuration register 0. (offset 0xD0; total reset 0xF8400606; PROVEN: Hi3536D V100 data sheet (Issue 00B04, 2017-12-13), section 10.2.2, PDF page 634).";
        field {
            name = "pd_dacl";
            desc = "Power-down control for the DAC audio-left channel
- 0: The digital and analog parts work properly.
- 1: The digital part outputs 0, whereas the analog part is powered down.";
            sw = rw; hw = r;
            reset = 0x1;
        } pd_dacl[31:31];
        field {
            name = "pd_dacr";
            desc = "Power-down control for the DAC audio-right channel
- 0: The digital and analog parts work properly.
- 1: The digital part outputs 0, whereas the analog part is powered down.";
            sw = rw; hw = r;
            reset = 0x1;
        } pd_dacr[30:30];
        field {
            name = "mute_dacl";
            desc = "Mute control for the DAC audio-left channel
- 0: The digital and analog audio-left channels work properly.
- 1: The digital and analog audio-left channels are muted.";
            sw = rw; hw = r;
            reset = 0x1;
        } mute_dacl[29:29];
        field {
            name = "mute_dacr";
            desc = "Mute control for the DAC audio-right channel
- 0: The digital and analog audio-right channels work properly.
- 1: The digital and analog audio-right channels are muted.";
            sw = rw; hw = r;
            reset = 0x1;
        } mute_dacr[28:28];
        field {
            name = "reserved";
            desc = "Reserved";
            sw = rw; hw = r;
            reset = 0x1080;
        } reserved_27_15[27:15];
        field {
            name = "dacl_vol";
            desc = "Output volume of the audio-left channel
- 0x00: +6 dB
- 0x01: +5 dB
- 0x06: 0 dB … (The step is 1 dB.)
- 0x7F: -121 dB";
            sw = rw; hw = r;
            reset = 0x6;
        } dacl_vol[14:8];
        field {
            name = "reserved";
            desc = "Reserved";
            sw = rw; hw = r;
            reset = 0x0;
        } reserved_7_7[7:7];
        field {
            name = "dacr_vol";
            desc = "Output volume of the audio-right channel
- 0x00: +6 dB
- 0x01: +5 dB
- 0x06: 0 dB … (The step is 1 dB.)
- 0x7F: -121 dB";
            sw = rw; hw = r;
            reset = 0x6;
        } dacr_vol[6:0];
    } AUDIO_DAC @ 0xD0;
    reg {
        name = "AUDIO_CODEC_REG1";
        desc = "AUDIO_DAC1 is ADAC configuration register 1. (offset 0xD4; total reset 0x00E06755; PROVEN: Hi3536D V100 data sheet (Issue 00B04, 2017-12-13), section 10.2.2, PDF page 635).";
        field {
            name = "smutel";
            desc = "Soft mute control for the audio-left channel
- 0: Soft mute is disabled.
- 1: Soft mute is enabled.";
            sw = rw; hw = r;
            reset = 0x0;
        } smutel[31:31];
        field {
            name = "smuter";
            desc = "Soft mute control for the audio-right channel
- 0: Soft mute is disabled
- 1: Soft mute is enabled";
            sw = rw; hw = r;
            reset = 0x0;
        } smuter[30:30];
        field {
            name = "sunmutel";
            desc = "Soft unmute control for the audio-left channel of the digital circuit
- 0: Soft unmute is disabled
- 1: Soft unmute is enabled";
            sw = rw; hw = r;
            reset = 0x0;
        } sunmutel[29:29];
        field {
            name = "sunmuter";
            desc = "Soft unmute control for the audio-right channel of the digital circuit
- 0: Soft unmute is disabled
- 1: Soft unmute is enabled";
            sw = rw; hw = r;
            reset = 0x0;
        } sunmuter[28:28];
        field {
            name = "dacvu";
            desc = "Synchronization of the digital volume of audio-left and audio-right channels
- 0: The gains of the audio-left and audio-right channels remain unchanged.
- 1: The volumes of audio-left and audio-right channels are synchronized.";
            sw = rw; hw = r;
            reset = 0x0;
        } dacvu[27:27];
        field {
            name = "mute_rate";
            desc = "Volume gain step when the audio-right and audio-left channels are soft muted or soft unmuted
- 00: fs/2
- 01: fs/8
- 10: fs/32
- 11: fs/64";
            sw = rw; hw = r;
            reset = 0x0;
        } mute_rate[26:25];
        field {
            name = "reserved";
            desc = "Reserved";
            sw = rw; hw = r;
            reset = 0x0;
        } reserved_24_24[24:24];
        field {
            name = "data_bits";
            desc = "Number of interface data bits
- 00: 16 bits
- 11: 24 bits

Other values: reserved";
            sw = rw; hw = r;
            reset = 0x3;
        } data_bits[23:22];
        field {
            name = "reserved";
            desc = "Reserved";
            sw = rw; hw = r;
            reset = 0x103;
        } reserved_21_13[21:13];
        field {
            name = "rst";
            desc = "DAC_ANA reset signal
- 0: normal work mode
- 1: reset";
            sw = rw; hw = r;
            reset = 0x0;
        } rst[12:12];
        field {
            name = "reserved";
            desc = "Reserved Contents";
            sw = rw; hw = r;
            reset = 0x755;
        } reserved_11_0[11:0];
    } AUDIO_CODEC_REG1 @ 0xD4;
};
`endif
