`ifndef HI3536D_DDRC_QOSB_RDL
`define HI3536D_DDRC_QOSB_RDL
regfile eHI3536D_DDRC_QOSB {
    name = "DDRC QoS buffer registers, Hi3536D V100";
    desc = "DDRC QoS buffer registers, Hi3536D V100 of the Hi3536D V100 at base 0x1211_4000. 26 registers extracted programmatically from the Hi3536D V100 data sheet (Issue 00B04, 2017-12-13) (Table 4-5 Summary of QoSBuf registers (base address: 0x1211_4000)): register headings, offsets, total reset values, field bit ranges, access types, names, reset values and descriptions, with PDF page numbers in each register description. Field names, bit ranges, access types and offsets are exact; the free-text descriptions are taken from the cell text of the field table and were checked by sampling only. Hardware not verified.";
    reg {
        name = "QOSB_ADPT_CTRL";
        desc = "QOSB_ADPT_CTRL is a QoSBuf adaptation configuration register. (offset 0x4; total reset 0x00000FF0; PROVEN: Hi3536D V100 data sheet (Issue 00B04, 2017-12-13), section 4.1.6.2, PDF page 289).";
        field {
            name = "reserved";
            desc = "Reserved";
            sw = r; hw = w;
            reset = 0x0;
        } reserved_31_20[31:20];
        field {
            name = "adpt_share_cnt";
            desc = "Adapt counter for lower bits. When the value of this counter decreases to 0, the counter for upper bits corresponding to each CMD decreases by 1.";
            sw = rw; hw = r;
            reset = 0xff;
        } adpt_share_cnt[19:4];
        field {
            name = "reserved";
            desc = "Reserved";
            sw = r; hw = w;
            reset = 0x0;
        } reserved_3_1[3:1];
        field {
            name = "adpt_en";
            desc = "Adapt enable
- 0: disabled
- 1: enabled";
            sw = rw; hw = r;
            reset = 0x0;
        } adpt_en[0:0];
    } QOSB_ADPT_CTRL @ 0x4;
    reg {
        name = "QOSB_BUF_BYP";
        desc = "QOSB_BUF_BYP is a QoSBuf bypass control register. (offset 0x88; total reset 0x00000000; PROVEN: Hi3536D V100 data sheet (Issue 00B04, 2017-12-13), section 4.1.6.2, PDF page 290).";
        field {
            name = "reserved";
            desc = "Reserved";
            sw = r; hw = w;
            reset = 0x0;
        } reserved_31_2[31:2];
        field {
            name = "qos_buf_byp";
            desc = "QoSBuf bypass control x0: forcible non-bypass mode. That is, all the commands enter the QoSBuf module when the value is set to 00 or 10.
- 01: whether to bypass depends on the queue status in the DMC
- 11: forcible bypass mode. None of the commands enter the

QoSBuf module. These modes need to be configured before the access. The dynamic configuration is forbidden during the access.";
            sw = rw; hw = r;
            reset = 0x0;
        } qos_buf_byp[1:0];
    } QOSB_BUF_BYP @ 0x88;
    reg {
        name = "QOSB_WRTOUT0";
        desc = "QOSB_WRTOUT0 is QoSBuf write command timeout period register 0. (offset 0x9C; total reset 0x00000000; PROVEN: Hi3536D V100 data sheet (Issue 00B04, 2017-12-13), section 4.1.6.2, PDF page 290).";
        field {
            name = "wr_tout3";
            desc = "Write command timeout period (level 3) The configuration mode is the same as that of wr_tout0.";
            sw = rw; hw = r;
            reset = 0x0;
        } wr_tout3[31:24];
        field {
            name = "wr_tout2";
            desc = "Write command timeout period (level 2) The configuration mode is the same as that of wr_tout0.";
            sw = rw; hw = r;
            reset = 0x0;
        } wr_tout2[23:16];
        field {
            name = "wr_tout1";
            desc = "Write command timeout period (level 1) The configuration mode is the same as that of wr_tout0.";
            sw = rw; hw = r;
            reset = 0x0;
        } wr_tout1[15:8];
        field {
            name = "wr_tout0";
            desc = "Write command timeout period (level 0)
- 0x0: The timeout function is disabled. 0x1-0xFF: n x 4 clock cycles

When the timeout period is set to 8 bits, the actual count value is 10 bits. That is, the lower two bits are fixed at 0.";
            sw = rw; hw = r;
            reset = 0x0;
        } wr_tout0[7:0];
    } QOSB_WRTOUT0 @ 0x9C;
    reg {
        name = "QOSB_WRTOUT1";
        desc = "QOSB_WRTOUT1 is QoSBuf write command timeout period register 1. (offset 0xA0; total reset 0x00000000; PROVEN: Hi3536D V100 data sheet (Issue 00B04, 2017-12-13), section 4.1.6.2, PDF page 291).";
        field {
            name = "wr_tout7";
            desc = "Write command timeout period (level 7) The configuration mode is the same as that of wr_tout0.";
            sw = rw; hw = r;
            reset = 0x0;
        } wr_tout7[31:24];
        field {
            name = "wr_tout6";
            desc = "Write command timeout period (level 6) The configuration mode is the same as that of wr_tout0.";
            sw = rw; hw = r;
            reset = 0x0;
        } wr_tout6[23:16];
        field {
            name = "wr_tout5";
            desc = "Write command timeout period (level 5) The configuration mode is the same as that of wr_tout0.";
            sw = rw; hw = r;
            reset = 0x0;
        } wr_tout5[15:8];
        field {
            name = "wr_tout4";
            desc = "Write command timeout period (level 4) The configuration mode is the same as that of wr_tout0.";
            sw = rw; hw = r;
            reset = 0x0;
        } wr_tout4[7:0];
    } QOSB_WRTOUT1 @ 0xA0;
    reg {
        name = "QOSB_WRTOUT2";
        desc = "QOSB_WRTOUT2 is QoSBuf write command timeout period register 2. (offset 0xA4; total reset 0x00000000; PROVEN: Hi3536D V100 data sheet (Issue 00B04, 2017-12-13), section 4.1.6.2, PDF page 292).";
        field {
            name = "wr_tout11";
            desc = "Write command timeout period (level 11) The configuration mode is the same as that of wr_tout0.";
            sw = rw; hw = r;
            reset = 0x0;
        } wr_tout11[31:24];
        field {
            name = "wr_tout10";
            desc = "Write command timeout period (level 10) The configuration mode is the same as that of wr_tout0.";
            sw = rw; hw = r;
            reset = 0x0;
        } wr_tout10[23:16];
        field {
            name = "wr_tout9";
            desc = "Write command timeout period (level 9) The configuration mode is the same as that of wr_tout0.";
            sw = rw; hw = r;
            reset = 0x0;
        } wr_tout9[15:8];
        field {
            name = "wr_tout8";
            desc = "Write command timeout period (level 8) The configuration mode is the same as that of wr_tout0.";
            sw = rw; hw = r;
            reset = 0x0;
        } wr_tout8[7:0];
    } QOSB_WRTOUT2 @ 0xA4;
    reg {
        name = "QOSB_WRTOUT3";
        desc = "QOSB_WRTOUT3 is QoSBuf write command timeout period register 3. (offset 0xA8; total reset 0x00000000; PROVEN: Hi3536D V100 data sheet (Issue 00B04, 2017-12-13), section 4.1.6.2, PDF page 292).";
        field {
            name = "wr_tout15";
            desc = "Write command timeout period (level 15) The configuration mode is the same as that of wr_tout0.";
            sw = rw; hw = r;
            reset = 0x0;
        } wr_tout15[31:24];
        field {
            name = "wr_tout14";
            desc = "Write command timeout period (level 14) The configuration mode is the same as that of wr_tout0.";
            sw = rw; hw = r;
            reset = 0x0;
        } wr_tout14[23:16];
        field {
            name = "wr_tout13";
            desc = "Write command timeout period (level 13) The configuration mode is the same as that of wr_tout0.";
            sw = rw; hw = r;
            reset = 0x0;
        } wr_tout13[15:8];
        field {
            name = "wr_tout12";
            desc = "Write command timeout period (level 12) The configuration mode is the same as that of wr_tout0.";
            sw = rw; hw = r;
            reset = 0x0;
        } wr_tout12[7:0];
    } QOSB_WRTOUT3 @ 0xA8;
    reg {
        name = "QOSB_RDTOUT0";
        desc = "QOSB_RDTOUT0 is QoSBuf read command timeout period register 0. (offset 0xAC; total reset 0x00000000; PROVEN: Hi3536D V100 data sheet (Issue 00B04, 2017-12-13), section 4.1.6.2, PDF page 293).";
        field {
            name = "rd_tout3";
            desc = "Read command timeout period (level 3) The configuration mode is the same as that of rd_tout0.";
            sw = rw; hw = r;
            reset = 0x0;
        } rd_tout3[31:24];
        field {
            name = "rd_tout2";
            desc = "Read command timeout period (level 2) The configuration mode is the same as that of rd_tout0.";
            sw = rw; hw = r;
            reset = 0x0;
        } rd_tout2[23:16];
        field {
            name = "rd_tout1";
            desc = "Read command timeout period (level 1) The configuration mode is the same as that of rd_tout0.";
            sw = rw; hw = r;
            reset = 0x0;
        } rd_tout1[15:8];
        field {
            name = "rd_tout0";
            desc = "Read command timeout period (level 0)
- 0x0: The timeout function is disabled. 0x1-0xFF: n x 4 clock cycles

When the timeout period is set to 8 bits, the actual count value is 10 bits. That is, the lower two bits are fixed at 0.";
            sw = rw; hw = r;
            reset = 0x0;
        } rd_tout0[7:0];
    } QOSB_RDTOUT0 @ 0xAC;
    reg {
        name = "QOSB_RDTOUT1";
        desc = "QOSB_RDTOUT1 is QoSBuf read command timeout period register 1. (offset 0xB0; total reset 0x00000000; PROVEN: Hi3536D V100 data sheet (Issue 00B04, 2017-12-13), section 4.1.6.2, PDF page 293).";
        field {
            name = "rd_tout7";
            desc = "Read command timeout period (level 7) The configuration mode is the same as that of rd_tout0.";
            sw = rw; hw = r;
            reset = 0x0;
        } rd_tout7[31:24];
        field {
            name = "rd_tout6";
            desc = "Read command timeout period (level 6) The configuration mode is the same as that of rd_tout0.";
            sw = rw; hw = r;
            reset = 0x0;
        } rd_tout6[23:16];
        field {
            name = "rd_tout5";
            desc = "Read command timeout period (level 5) The configuration mode is the same as that of rd_tout0.";
            sw = rw; hw = r;
            reset = 0x0;
        } rd_tout5[15:8];
        field {
            name = "rd_tout4";
            desc = "Read command timeout period (level 4) The configuration mode is the same as that of rd_tout0.";
            sw = rw; hw = r;
            reset = 0x0;
        } rd_tout4[7:0];
    } QOSB_RDTOUT1 @ 0xB0;
    reg {
        name = "QOSB_RDTOUT2";
        desc = "QOSB_RDTOUT2 is QoSBuf read command timeout period register 2. (offset 0xB4; total reset 0x00000000; PROVEN: Hi3536D V100 data sheet (Issue 00B04, 2017-12-13), section 4.1.6.2, PDF page 294).";
        field {
            name = "rd_tout11";
            desc = "Read command timeout period (level 11) The configuration mode is the same as that of rd_tout0.";
            sw = rw; hw = r;
            reset = 0x0;
        } rd_tout11[31:24];
        field {
            name = "rd_tout10";
            desc = "Read command timeout period (level 10) The configuration mode is the same as that of rd_tout0.";
            sw = rw; hw = r;
            reset = 0x0;
        } rd_tout10[23:16];
        field {
            name = "rd_tout9";
            desc = "Read command timeout period (level 9) The configuration mode is the same as that of rd_tout0.";
            sw = rw; hw = r;
            reset = 0x0;
        } rd_tout9[15:8];
        field {
            name = "rd_tout8";
            desc = "Read command timeout period (level 8) The configuration mode is the same as that of rd_tout0.";
            sw = rw; hw = r;
            reset = 0x0;
        } rd_tout8[7:0];
    } QOSB_RDTOUT2 @ 0xB4;
    reg {
        name = "QOSB_RDTOUT3";
        desc = "QOSB_RDTOUT3 is QoSBuf read command timeout period register 3. (offset 0xB8; total reset 0x00000000; PROVEN: Hi3536D V100 data sheet (Issue 00B04, 2017-12-13), section 4.1.6.2, PDF page 294).";
        field {
            name = "rd_tout15";
            desc = "Read command timeout period (level 15) The configuration mode is the same as that ofrd_tout0.";
            sw = rw; hw = r;
            reset = 0x0;
        } rd_tout15[31:24];
        field {
            name = "rd_tout14";
            desc = "Read command timeout period (level 14) The configuration mode is the same as that ofrd_tout0.";
            sw = rw; hw = r;
            reset = 0x0;
        } rd_tout14[23:16];
        field {
            name = "rd_tout13";
            desc = "Read command timeout period (level 13) The configuration mode is the same as that ofrd_tout0.";
            sw = rw; hw = r;
            reset = 0x0;
        } rd_tout13[15:8];
        field {
            name = "rd_tout12";
            desc = "Read command timeout period (level 12) The configuration mode is the same as that ofrd_tout0.";
            sw = rw; hw = r;
            reset = 0x0;
        } rd_tout12[7:0];
    } QOSB_RDTOUT3 @ 0xB8;
    reg {
        name = "QOSB_WRTOUT_MAP";
        desc = "QOSB_WRTOUT_MAP is a QoSBuf write command timeout mapping mode control register. (offset 0xBC; total reset 0x00000000; PROVEN: Hi3536D V100 data sheet (Issue 00B04, 2017-12-13), section 4.1.6.2, PDF page 295).";
        field {
            name = "reserved";
            desc = "Reserved";
            sw = r; hw = w;
            reset = 0x0;
        } reserved_31_29[31:29];
        field {
            name = "wrtout_map3";
            desc = "There are 16 levels of timeout periods. Four bits are selected from the ID and the level is determined based on the four bits. wrtout_map3 indicates the position of bit 3 in the ID.";
            sw = rw; hw = r;
            reset = 0x0;
        } wrtout_map3[28:24];
        field {
            name = "reserved";
            desc = "Reserved";
            sw = r; hw = w;
            reset = 0x0;
        } reserved_23_21[23:21];
        field {
            name = "wrtout_map2";
            desc = "There are 16 levels of timeout periods. Four bits are selected from the ID and the level is determined based on the four bits. wrtout_map2 indicates the position of bit 2 in the ID.";
            sw = rw; hw = r;
            reset = 0x0;
        } wrtout_map2[20:16];
        field {
            name = "reserved";
            desc = "Reserved";
            sw = r; hw = w;
            reset = 0x0;
        } reserved_15_13[15:13];
        field {
            name = "wrtout_map1";
            desc = "There are 16 levels of timeout periods. Four bits are selected from the ID and the level is determined based on the four bits. wrtout_map1 indicates the position of bit 1 in the ID.";
            sw = rw; hw = r;
            reset = 0x0;
        } wrtout_map1[12:8];
        field {
            name = "reserved";
            desc = "Reserved";
            sw = r; hw = w;
            reset = 0x0;
        } reserved_7_5[7:5];
        field {
            name = "wrtout_map0";
            desc = "There are 16 levels of timeout periods. Four bits are selected from the ID and the level is determined based on the four bits. wrtout_map0 indicates the position of bit 0 in the ID.";
            sw = rw; hw = r;
            reset = 0x0;
        } wrtout_map0[4:0];
    } QOSB_WRTOUT_MAP @ 0xBC;
    reg {
        name = "QOSB_RDTOUT_MAP";
        desc = "QOSB_RDTOUT_MAP is a QoSBuf read command timeout mapping mode control register. (offset 0xD0; total reset 0x00000000; PROVEN: Hi3536D V100 data sheet (Issue 00B04, 2017-12-13), section 4.1.6.2, PDF page 296).";
        field {
            name = "reserved";
            desc = "Reserved";
            sw = r; hw = w;
            reset = 0x0;
        } reserved_31_29[31:29];
        field {
            name = "rdtout_map3";
            desc = "There are 16 levels of timeout periods. Four bits are selected from the ID and the level is determined based on the four bits. rdtout_map3 indicates the position of bit 3 in the ID.";
            sw = rw; hw = r;
            reset = 0x0;
        } rdtout_map3[28:24];
        field {
            name = "reserved";
            desc = "Reserved";
            sw = r; hw = w;
            reset = 0x0;
        } reserved_23_21[23:21];
        field {
            name = "rdtout_map2";
            desc = "There are 16 levels of timeout periods. Four bits are selected from the ID and the level is determined based on the four bits. rdtout_map2 indicates the position of bit 2 in the ID.";
            sw = rw; hw = r;
            reset = 0x0;
        } rdtout_map2[20:16];
        field {
            name = "reserved";
            desc = "Reserved";
            sw = r; hw = w;
            reset = 0x0;
        } reserved_15_13[15:13];
        field {
            name = "rdtout_map1";
            desc = "There are 16 levels of timeout periods. Four bits are selected from the ID and the level is determined based on the four bits. rdtout_map1 indicates the position of bit 1 in the ID.";
            sw = rw; hw = r;
            reset = 0x0;
        } rdtout_map1[12:8];
        field {
            name = "reserved";
            desc = "Reserved";
            sw = r; hw = w;
            reset = 0x0;
        } reserved_7_5[7:5];
        field {
            name = "rdtout_map0";
            desc = "There are 16 levels of timeout periods. Four bits are selected from the ID and the level is determined based on the four bits. rdtout_map0 indicates the position of bit 0 in the ID.";
            sw = rw; hw = r;
            reset = 0x0;
        } rdtout_map0[4:0];
    } QOSB_RDTOUT_MAP @ 0xD0;
    reg {
        name = "QOSB_CKG_CFG";
        desc = "QOSB_CKG_CFG is a QoSBuf clock control register. (offset 0x108; total reset 0x00000001; PROVEN: Hi3536D V100 data sheet (Issue 00B04, 2017-12-13), section 4.1.6.2, PDF page 297).";
        field {
            name = "reserved";
            desc = "Reserved";
            sw = r; hw = w;
            reset = 0x0;
        } reserved_31_1[31:1];
        field {
            name = "dyn_ck_gate";
            desc = "Dynamic clock gating for the QoSBuf module
- 0: The clock is always enabled.
- 1: The clock gating is automatic when the module is idle.";
            sw = rw; hw = r;
            reset = 0x1;
        } dyn_ck_gate[0:0];
    } QOSB_CKG_CFG @ 0x108;
    reg {
        name = "QOSB_DMC_LVL";
        desc = "QOSB_DMC_LVL is a QoSBuf threshold control register for commands that enter the DMC module. (offset 0x10C; total reset 0x0000000F; PROVEN: Hi3536D V100 data sheet (Issue 00B04, 2017-12-13), section 4.1.6.2, PDF page 297).";
        field {
            name = "reserved";
            desc = "Reserved";
            sw = r; hw = w;
            reset = 0x0;
        } reserved_31_5[31:5];
        field {
            name = "dmc_cmd_full_lvl";
            desc = "Number of QoSBuf commands that enter the DMC module. When this threshold is reached, the DMC queue is full. When this field is set to N, the actual number of commands that enter the DMC module is (N + 1) because of the pipeline issue. This register cannot be dynamically configured when it is being accessed.";
            sw = rw; hw = r;
            reset = 0xf;
        } dmc_cmd_full_lvl[4:0];
    } QOSB_DMC_LVL @ 0x10C;
    reg {
        name = "QOSB_CFG_PERF";
        desc = "QOSB_CFG_PERF is a QoSBuf performance statistical mode register. (offset 0x120; total reset 0x00000000; PROVEN: Hi3536D V100 data sheet (Issue 00B04, 2017-12-13), section 4.1.6.2, PDF page 298).";
        field {
            name = "reserved";
            desc = "Reserved";
            sw = r; hw = w;
            reset = 0x0;
        } reserved_31_30[31:30];
        field {
            name = "perf_en";
            desc = "Performance statistics enable
- 1: enabled
- 0: disabled

When perf_mode is 0 and this bit is enabled, the performance statistics register starts the cyclic count. When perf_mode is 1, this bit is automatically cleared after the counting is complete.";
            sw = rw; hw = r;
            reset = 0x0;
        } perf_en[29:29];
        field {
            name = "perf_mode";
            desc = "Performance statistical mode
- 0: continuous trigger mode. Counters related to performance statistics keep counting to ensure that no data overflows within 1s.
- 1: single trigger mode. When the performance statistical period reaches the value of perf_prd, the statistical result retains and the counting stops.

The maximum statistical result retains after an overflow occurs.";
            sw = rw; hw = r;
            reset = 0x0;
        } perf_mode[28:28];
        field {
            name = "perf_prd";
            desc = "Performance statistical cycle
- 0x0: invalid 0x1-0xFFFFFFF: statistical cycle

The actual statistical cycle is (perf_prd x 16 x tclk). tclk is the bus clock cycle of the DDRC. This configuration is valid only when perf_mode is 1. When perf_mode is 0, counters related to performance statistics keep counting.";
            sw = rw; hw = r;
            reset = 0x0;
        } perf_prd[27:0];
    } QOSB_CFG_PERF @ 0x120;
    reg {
        name = "QOSB_CMD_SUM";
        desc = "QOSB_CMD_SUM is a QoSBuf accumulated command count register. (offset 0x124; total reset 0x00000000; PROVEN: Hi3536D V100 data sheet (Issue 00B04, 2017-12-13), section 4.1.6.2, PDF page 299).";
        field {
            name = "qos_cmd_sum";
            desc = "Accumulated value of the commands that are temporarily stored in the QoSBuf in the cycle. The value is wrapped if an overflow occurs.";
            sw = r; hw = w;
            reset = 0x0;
        } qos_cmd_sum[31:0];
    } QOSB_CMD_SUM @ 0x124;
    reg {
        name = "QOSB_CMD_CNT";
        desc = "QOSB_CMD_CNT is a QoSBuf command statistics register. (offset 0x180; total reset 0x00000000; PROVEN: Hi3536D V100 data sheet (Issue 00B04, 2017-12-13), section 4.1.6.2, PDF page 299).";
        field {
            name = "reserved";
            desc = "Reserved";
            sw = r; hw = w;
            reset = 0x0;
        } reserved_31_8[31:8];
        field {
            name = "qos_cmd_cnt";
            desc = "Number of commands in the QoSBuf, including those on the pipeline

Access type INT (interrupt status) in the data sheet.";
            sw = r; hw = w;
            reset = 0x0;
        } qos_cmd_cnt[7:0];
    } QOSB_CMD_CNT @ 0x180;
    reg {
        name = "QOSB_RNK_CNT";
        desc = "QOSB_RNK_CNT is a QoSBuf command (in each rank) statistics register. (offset 0x190; total reset 0x00000000; PROVEN: Hi3536D V100 data sheet (Issue 00B04, 2017-12-13), section 4.1.6.2, PDF page 299).";
        field {
            name = "reserved";
            desc = "Reserved";
            sw = r; hw = w;
            reset = 0x0;
        } reserved_31_8[31:8];
        field {
            name = "rnk0_cmd_cnt";
            desc = "Number of rank 0 commands in the current channel in the QoSBuf";
            sw = r; hw = w;
            reset = 0x0;
        } rnk0_cmd_cnt[7:0];
    } QOSB_RNK_CNT @ 0x190;
    reg {
        name = "QOSB_BNK_CNT0";
        desc = "QOSB_BNK_CNT0 is a QoSBuf command (in each bank) statistics register. (offset 0x1A0; total reset 0x00000000; PROVEN: Hi3536D V100 data sheet (Issue 00B04, 2017-12-13), section 4.1.6.2, PDF page 300).";
        field {
            name = "bnk3_cmd_cnt";
            desc = "Number of bank 3 commands in the current channel in the DMC";
            sw = r; hw = w;
            reset = 0x0;
        } bnk3_cmd_cnt[31:24];
        field {
            name = "bnk2_cmd_cnt";
            desc = "Number of bank 2 commands in the current channel in the DMC";
            sw = r; hw = w;
            reset = 0x0;
        } bnk2_cmd_cnt[23:16];
        field {
            name = "bnk1_cmd_cnt";
            desc = "Number of bank 1 commands in the current channel in the DMC";
            sw = r; hw = w;
            reset = 0x0;
        } bnk1_cmd_cnt[15:8];
        field {
            name = "bnk0_cmd_cnt";
            desc = "Number of bank 0 commands in the current channel in the DMC";
            sw = r; hw = w;
            reset = 0x0;
        } bnk0_cmd_cnt[7:0];
    } QOSB_BNK_CNT0 @ 0x1A0;
    reg {
        name = "QOSB_BNK_CNT1";
        desc = "QOSB_BNK_CNT1 is a QoSBuf command (in each bank) statistics register. (offset 0x1B0; total reset 0x00000000; PROVEN: Hi3536D V100 data sheet (Issue 00B04, 2017-12-13), section 4.1.6.2, PDF page 300).";
        field {
            name = "bnk7_cmd_cnt";
            desc = "Number of bank 7 commands in the current channel in the DMC";
            sw = r; hw = w;
            reset = 0x0;
        } bnk7_cmd_cnt[31:24];
        field {
            name = "bnk6_cmd_cnt";
            desc = "Number of bank 6 commands in the current channel in the DMC";
            sw = r; hw = w;
            reset = 0x0;
        } bnk6_cmd_cnt[23:16];
        field {
            name = "bnk5_cmd_cnt";
            desc = "Number of bank 5 commands in the current channel in the DMC";
            sw = r; hw = w;
            reset = 0x0;
        } bnk5_cmd_cnt[15:8];
        field {
            name = "bnk4_cmd_cnt";
            desc = "Number of bank 4 commands in the current channel in the DMC";
            sw = r; hw = w;
            reset = 0x0;
        } bnk4_cmd_cnt[7:0];
    } QOSB_BNK_CNT1 @ 0x1B0;
    reg {
        name = "QOSB_BNK_CNT2";
        desc = "QOSB_BNK_CNT2 is a QoSBuf command (in each bank) statistics register. (offset 0x1C0; total reset 0x00000000; PROVEN: Hi3536D V100 data sheet (Issue 00B04, 2017-12-13), section 4.1.6.2, PDF page 301).";
        field {
            name = "bnk11_cmd_cnt";
            desc = "Number of bank 11 commands in the current channel in the DMC";
            sw = r; hw = w;
            reset = 0x0;
        } bnk11_cmd_cnt[31:24];
        field {
            name = "bnk10_cmd_cnt";
            desc = "Number of bank 10 commands in the current channel in the DMC";
            sw = r; hw = w;
            reset = 0x0;
        } bnk10_cmd_cnt[23:16];
        field {
            name = "bnk9_cmd_cnt";
            desc = "Number of bank 9 commands in the current channel in the DMC";
            sw = r; hw = w;
            reset = 0x0;
        } bnk9_cmd_cnt[15:8];
        field {
            name = "bnk8_cmd_cnt";
            desc = "Number of bank 8 commands in the current channel in the DMC";
            sw = r; hw = w;
            reset = 0x0;
        } bnk8_cmd_cnt[7:0];
    } QOSB_BNK_CNT2 @ 0x1C0;
    reg {
        name = "QOSB_BNK_CNT3";
        desc = "QOSB_BNK_CNT3 is a QoSBuf command (in each bank) statistics register. (offset 0x1D0; total reset 0x00000000; PROVEN: Hi3536D V100 data sheet (Issue 00B04, 2017-12-13), section 4.1.6.2, PDF page 301).";
        field {
            name = "bnk15_cmd_cnt";
            desc = "Number of bank 15 commands in the current channel in the DMC";
            sw = r; hw = w;
            reset = 0x0;
        } bnk15_cmd_cnt[31:24];
        field {
            name = "bnk14_cmd_cnt";
            desc = "Number of bank 14 commands in the current channel in the DMC";
            sw = r; hw = w;
            reset = 0x0;
        } bnk14_cmd_cnt[23:16];
        field {
            name = "bnk13_cmd_cnt";
            desc = "Number of bank 13 commands in the current channel in the DMC";
            sw = r; hw = w;
            reset = 0x0;
        } bnk13_cmd_cnt[15:8];
        field {
            name = "bnk12_cmd_cnt";
            desc = "Number of bank 12 commands in the current channel in the DMC";
            sw = r; hw = w;
            reset = 0x0;
        } bnk12_cmd_cnt[7:0];
    } QOSB_BNK_CNT3 @ 0x1D0;
    reg {
        name = "QOSB_OSTD_CNT";
        desc = "QOSB_OSTD_CNT is a QoSBuf OSTD command (in each channel) statistics register. (offset 0x1E0; total reset 0x00000000; PROVEN: Hi3536D V100 data sheet (Issue 00B04, 2017-12-13), section 4.1.6.2, PDF page 302).";
        field {
            name = "reserved";
            desc = "Reserved";
            sw = r; hw = w;
            reset = 0x0;
        } reserved_31_8[31:8];
        field {
            name = "ch0_cmd_ostd";
            desc = "Number of OSTD commands in channel 0 in the QoSBuf";
            sw = r; hw = w;
            reset = 0x0;
        } ch0_cmd_ostd[7:0];
    } QOSB_OSTD_CNT @ 0x1E0;
    reg {
        name = "QOSB_WR_CMD_SUM";
        desc = "QOSB_WR_CMD_SUM is a QoSBuf accumulated write command count register. (offset 0x1E4; total reset 0x00000000; PROVEN: Hi3536D V100 data sheet (Issue 00B04, 2017-12-13), section 4.1.6.2, PDF page 302).";
        field {
            name = "qos_wr_cmd_sum";
            desc = "Accumulated value of the write commands that are temporarily stored in the QoSBuf in the cycle. The value is wrapped if an overflow occurs.";
            sw = r; hw = w;
            reset = 0x0;
        } qos_wr_cmd_sum[31:0];
    } QOSB_WR_CMD_SUM @ 0x1E4;
    reg {
        name = "QOSB_RD_CMD_SUM";
        desc = "QOSB_RD_CMD_SUM is a QoSBuf accumulated read command count register. (offset 0x1E8; total reset 0x00000000; PROVEN: Hi3536D V100 data sheet (Issue 00B04, 2017-12-13), section 4.1.6.2, PDF page 302).";
        field {
            name = "qos_rd_cmd_sum";
            desc = "Accumulated value of the read commands that are temporarily stored in the QoSBuf in the cycle. The value is wrapped if an overflow occurs.";
            sw = r; hw = w;
            reset = 0x0;
        } qos_rd_cmd_sum[31:0];
    } QOSB_RD_CMD_SUM @ 0x1E8;
    reg {
        name = "QOSB_TIMEOUT_MODE";
        desc = "QOSB_TIMEOUT_MODE is a QoSBuf timeout mode selection register. (offset 0x1F0; total reset 0x00000000; PROVEN: Hi3536D V100 data sheet (Issue 00B04, 2017-12-13), section 4.1.6.2, PDF page 303).";
        field {
            name = "reserved";
            desc = "Reserved";
            sw = r; hw = w;
            reset = 0x0;
        } reserved_31_1[31:1];
        field {
            name = "timeout_mode";
            desc = "Read/Write command timeout mapping mode select
- 0: Reserved
- 1: The timeout mode is mapped by using the priority and there are eight levels of timeout periods. The levels in the priority mapping table are the same as the lower eight levels in the ID mapping table.";
            sw = rw; hw = r;
            reset = 0x0;
        } timeout_mode[0:0];
    } QOSB_TIMEOUT_MODE @ 0x1F0;
    reg {
        name = "QOSB_PUSH_CTRL";
        desc = "QOSB_PUSH_CTRL: DT comment qosb_push_ctrl, value 0x2 (offset 0x0). Provenance: PROVEN offset and written value (vendor Linux 4.9 demo device tree node sysctrl-ddr,pins, device-trees-hisilicon openipc-branches hi3536dv100-demb); bit layout NOT in the data sheet; name is the vendor DT comment / a GUESS.";
        field { sw = rw; hw = r; } value[31:0];
    } QOSB_PUSH_CTRL @ 0x0;
    reg {
        name = "QOSB_WBUF_CTRL0";
        desc = "QOSB_WBUF_CTRL0: DT comment qosb_wbuf_ctrl, value 0xb3032010 (offset 0x8C). Provenance: PROVEN offset and written value (vendor Linux 4.9 demo device tree node sysctrl-ddr,pins, device-trees-hisilicon openipc-branches hi3536dv100-demb); bit layout NOT in the data sheet; name is the vendor DT comment / a GUESS.";
        field { sw = rw; hw = r; } value[31:0];
    } QOSB_WBUF_CTRL0 @ 0x8C;
    reg {
        name = "QOSB_WBUF_CTRL1";
        desc = "QOSB_WBUF_CTRL1: DT comment qosb_wbuf_ctrl, value 0xb3032010 (offset 0x90). Provenance: PROVEN offset and written value (vendor Linux 4.9 demo device tree node sysctrl-ddr,pins, device-trees-hisilicon openipc-branches hi3536dv100-demb); bit layout NOT in the data sheet; name is the vendor DT comment / a GUESS.";
        field { sw = rw; hw = r; } value[31:0];
    } QOSB_WBUF_CTRL1 @ 0x90;
    reg {
        name = "QOSB_ROWHIT_EC";
        desc = "QOSB_ROWHIT_EC: DT comment row-hit, value 0x44 (offset 0xEC). Provenance: PROVEN offset and written value (vendor Linux 4.9 demo device tree node sysctrl-ddr,pins, device-trees-hisilicon openipc-branches hi3536dv100-demb); bit layout NOT in the data sheet; name is the vendor DT comment / a GUESS.";
        field { sw = rw; hw = r; } value[31:0];
    } QOSB_ROWHIT_EC @ 0xEC;
    reg {
        name = "QOSB_ROWHIT_F0";
        desc = "QOSB_ROWHIT_F0: DT comment row-hit, value 0x3333 (offset 0xF0). Provenance: PROVEN offset and written value (vendor Linux 4.9 demo device tree node sysctrl-ddr,pins, device-trees-hisilicon openipc-branches hi3536dv100-demb); bit layout NOT in the data sheet; name is the vendor DT comment / a GUESS.";
        field { sw = rw; hw = r; } value[31:0];
    } QOSB_ROWHIT_F0 @ 0xF0;
    reg {
        name = "QOSB_ROWHIT_F4";
        desc = "QOSB_ROWHIT_F4: DT comment row-hit enable, value 0x33 (offset 0xF4). Provenance: PROVEN offset and written value (vendor Linux 4.9 demo device tree node sysctrl-ddr,pins, device-trees-hisilicon openipc-branches hi3536dv100-demb); bit layout NOT in the data sheet; name is the vendor DT comment / a GUESS.";
        field { sw = rw; hw = r; } value[31:0];
    } QOSB_ROWHIT_F4 @ 0xF4;
    reg {
        name = "QOSB_DMC_LVL1";
        desc = "QOSB_DMC_LVL1: DT comment qosb_dmc_lvl, value 0xa (offset 0x110). Provenance: PROVEN offset and written value (vendor Linux 4.9 demo device tree node sysctrl-ddr,pins, device-trees-hisilicon openipc-branches hi3536dv100-demb); bit layout NOT in the data sheet; name is the vendor DT comment / a GUESS.";
        field { sw = rw; hw = r; } value[31:0];
    } QOSB_DMC_LVL1 @ 0x110;
    reg {
        name = "QOSB_WBUF_PRI_CTRL";
        desc = "QOSB_WBUF_PRI_CTRL: DT comment qosb_wbuf_pri_ctrl, value 0 (offset 0x1F4). Provenance: PROVEN offset and written value (vendor Linux 4.9 demo device tree node sysctrl-ddr,pins, device-trees-hisilicon openipc-branches hi3536dv100-demb); bit layout NOT in the data sheet; name is the vendor DT comment / a GUESS.";
        field { sw = rw; hw = r; } value[31:0];
    } QOSB_WBUF_PRI_CTRL @ 0x1F4;
    reg {
        name = "QOSB_RHIT_CTRL";
        desc = "QOSB_RHIT_CTRL: DT comment qosb_rhit_ctrl open_window=128 close_window=2, value 0x00800002 (offset 0x1F8). Provenance: PROVEN offset and written value (vendor Linux 4.9 demo device tree node sysctrl-ddr,pins, device-trees-hisilicon openipc-branches hi3536dv100-demb); bit layout NOT in the data sheet; name is the vendor DT comment / a GUESS.";
        field { sw = rw; hw = r; } value[31:0];
    } QOSB_RHIT_CTRL @ 0x1F8;
};
`endif
