`ifndef HI3536D_DDRC_QOSB_RDL
`define HI3536D_DDRC_QOSB_RDL
regfile eHI3536D_DDRC_QOSB {
    name = "DDRC QoS buffer registers, Hi3536D V100";
    desc = "DDRC QoS buffer registers of the Hi3536D V100 at base 0x12114000. 20 registers extracted programmatically from the Hi3536D V100 data sheet (Issue 00B04, 2017-12-13, Table 4-5), register descriptions and field tables; reset values are the data sheet total reset values split onto the fields. Source: dl/research-hi3536 ReleaseDoc (unofficial copy of the HiSilicon SDK documentation; facts only). Field names, bit ranges, access types and reset values are exact; the free-text descriptions are attributed to fields from the PDF text layout (title sentence above the bit row, enumerations below) and can be shifted by one field where a sentence wraps: check the data sheet page when a description matters. Hardware not yet verified (no Hi3536D board on the bench).";
    reg {
        name = "QOSB_ADPT_CTRL";
        desc = "QOSB_ADPT_CTRL is a QoSBuf adaptation configuration register. (offset 0x4, total reset 0x00000FF0; PROVEN: Hi3536D V100 data sheet).";
        field {
            name = "reserved_31_20";
            desc = "Reserved";
            sw = r; hw = w;
            reset = 0x0;
        } reserved_31_20[31:20];
        field {
            name = "adpt_share_cnt";
            desc = "Adapt counter for lower bits. When the value of this counter decreases to 0, the counter for upper bits corresponding to each";
            sw = rw; hw = r;
            reset = 0xff;
        } adpt_share_cnt[19:4];
        field {
            name = "reserved_3_1";
            desc = "CMD decreases by 1. Reserved";
            sw = r; hw = w;
            reset = 0x0;
        } reserved_3_1[3:1];
        field {
            name = "adpt_en";
            desc = "Adapt enable 0: disabled 1: enabled";
            sw = rw; hw = r;
            reset = 0x0;
        } adpt_en[0:0];
    } QOSB_ADPT_CTRL @ 0x4;
    reg {
        name = "QOSB_BUF_BYP";
        desc = "QOSB_BUF_BYP (offset 0x88, total reset 0x00000000; PROVEN: Hi3536D V100 data sheet).";
        field {
            name = "reserved_31_2";
            desc = "Reserved x0: forcible non-bypass mode. That is, all the commands enter the 01: whether to bypass depends on the queue status in the DMC";
            sw = r; hw = w;
            reset = 0x0;
        } reserved_31_2[31:2];
        field {
            name = "qos_buf_byp";
            desc = "QoSBuf bypass control QoSBuf module when the value is set to 00 or 10. 11: forcible bypass mode. None of the commands enter the configuration is forbidden during the access. QoSBuf module. These modes need to be configured before the access. The dynamic";
            sw = rw; hw = r;
            reset = 0x0;
        } qos_buf_byp[1:0];
    } QOSB_BUF_BYP @ 0x88;
    reg {
        name = "QOSB_WRTOUT0";
        desc = "QOSB_WRTOUT0 is QoSBuf write command timeout period register 0. (offset 0x9C, total reset 0x00000000; PROVEN: Hi3536D V100 data sheet).";
        field {
            name = "wr_tout3";
            desc = "Write command timeout period (level 3)";
            sw = rw; hw = r;
            reset = 0x0;
        } wr_tout3[31:24];
        field {
            name = "wr_tout2";
            desc = "The configuration mode is the same as that of wr_tout0. Write command timeout period (level 2)";
            sw = rw; hw = r;
            reset = 0x0;
        } wr_tout2[23:16];
        field {
            name = "wr_tout1";
            desc = "The configuration mode is the same as that of wr_tout0. Write command timeout period (level 1) 0x0: The timeout function is disabled.";
            sw = rw; hw = r;
            reset = 0x0;
        } wr_tout1[15:8];
        field {
            name = "wr_tout0";
            desc = "The configuration mode is the same as that of wr_tout0. Write command timeout period (level 0) 0x1−0xFF: n x 4 clock cycles When the timeout period is set to 8 bits, the actual count value is 10 bits. That is, the lower two bits are fixed at 0.";
            sw = rw; hw = r;
            reset = 0x0;
        } wr_tout0[7:0];
    } QOSB_WRTOUT0 @ 0x9C;
    reg {
        name = "QOSB_WRTOUT1";
        desc = "QOSB_WRTOUT1 is QoSBuf write command timeout period register 1. (offset 0xA0, total reset 0x00000000; PROVEN: Hi3536D V100 data sheet).";
        field {
            name = "wr_tout7";
            desc = "Write command timeout period (level 7)";
            sw = rw; hw = r;
            reset = 0x0;
        } wr_tout7[31:24];
        field {
            name = "wr_tout6";
            desc = "The configuration mode is the same as that of wr_tout0. Write command timeout period (level 6)";
            sw = rw; hw = r;
            reset = 0x0;
        } wr_tout6[23:16];
        field {
            name = "wr_tout5";
            desc = "The configuration mode is the same as that of wr_tout0. Write command timeout period (level 5)";
            sw = rw; hw = r;
            reset = 0x0;
        } wr_tout5[15:8];
        field {
            name = "wr_tout4";
            desc = "The configuration mode is the same as that of wr_tout0. Write command timeout period (level 4) The configuration mode is the same as that of wr_tout0.";
            sw = rw; hw = r;
            reset = 0x0;
        } wr_tout4[7:0];
    } QOSB_WRTOUT1 @ 0xA0;
    reg {
        name = "QOSB_WRTOUT2";
        desc = "QOSB_WRTOUT2 (offset 0xA4, total reset 0x00000000; PROVEN: Hi3536D V100 data sheet).";
        field {
            name = "wr_tout11";
            desc = "Write command timeout period (level 11)";
            sw = rw; hw = r;
            reset = 0x0;
        } wr_tout11[31:24];
        field {
            name = "wr_tout10";
            desc = "The configuration mode is the same as that of wr_tout0. Write command timeout period (level 10)";
            sw = rw; hw = r;
            reset = 0x0;
        } wr_tout10[23:16];
        field {
            name = "wr_tout9";
            desc = "The configuration mode is the same as that of wr_tout0. Write command timeout period (level 9)";
            sw = rw; hw = r;
            reset = 0x0;
        } wr_tout9[15:8];
        field {
            name = "wr_tout8";
            desc = "The configuration mode is the same as that of wr_tout0. Write command timeout period (level 8) The configuration mode is the same as that of wr_tout0.";
            sw = rw; hw = r;
            reset = 0x0;
        } wr_tout8[7:0];
    } QOSB_WRTOUT2 @ 0xA4;
    reg {
        name = "QOSB_WRTOUT3";
        desc = "QOSB_WRTOUT3 is QoSBuf write command timeout period register 3. (offset 0xA8, total reset 0x00000000; PROVEN: Hi3536D V100 data sheet).";
        field {
            name = "wr_tout15";
            desc = "Write command timeout period (level 15)";
            sw = rw; hw = r;
            reset = 0x0;
        } wr_tout15[31:24];
        field {
            name = "wr_tout14";
            desc = "The configuration mode is the same as that of wr_tout0. Write command timeout period (level 14)";
            sw = rw; hw = r;
            reset = 0x0;
        } wr_tout14[23:16];
        field {
            name = "wr_tout13";
            desc = "The configuration mode is the same as that of wr_tout0. Write command timeout period (level 13)";
            sw = rw; hw = r;
            reset = 0x0;
        } wr_tout13[15:8];
        field {
            name = "wr_tout12";
            desc = "The configuration mode is the same as that of wr_tout0. Write command timeout period (level 12) The configuration mode is the same as that of wr_tout0.";
            sw = rw; hw = r;
            reset = 0x0;
        } wr_tout12[7:0];
    } QOSB_WRTOUT3 @ 0xA8;
    reg {
        name = "QOSB_RDTOUT0";
        desc = "QOSB_RDTOUT0 is QoSBuf read command timeout period register 0. (offset 0xAC, total reset 0x00000000; PROVEN: Hi3536D V100 data sheet).";
        field {
            name = "rd_tout3";
            desc = "Read command timeout period (level 3)";
            sw = rw; hw = r;
            reset = 0x0;
        } rd_tout3[31:24];
        field {
            name = "rd_tout2";
            desc = "The configuration mode is the same as that of rd_tout0. Read command timeout period (level 2)";
            sw = rw; hw = r;
            reset = 0x0;
        } rd_tout2[23:16];
        field {
            name = "rd_tout1";
            desc = "The configuration mode is the same as that of rd_tout0. Read command timeout period (level 1) 0x0: The timeout function is disabled.";
            sw = rw; hw = r;
            reset = 0x0;
        } rd_tout1[15:8];
        field {
            name = "rd_tout0";
            desc = "The configuration mode is the same as that of rd_tout0. Read command timeout period (level 0) 0x1−0xFF: n x 4 clock cycles When the timeout period is set to 8 bits, the actual count value is 10 bits. That is, the lower two bits are fixed at 0.";
            sw = rw; hw = r;
            reset = 0x0;
        } rd_tout0[7:0];
    } QOSB_RDTOUT0 @ 0xAC;
    reg {
        name = "QOSB_RDTOUT1";
        desc = "QOSB_RDTOUT1 is QoSBuf read command timeout period register 1. (offset 0xB0, total reset 0x00000000; PROVEN: Hi3536D V100 data sheet).";
        field {
            name = "rd_tout7";
            desc = "Read command timeout period (level 7)";
            sw = rw; hw = r;
            reset = 0x0;
        } rd_tout7[31:24];
        field {
            name = "rd_tout6";
            desc = "The configuration mode is the same as that of rd_tout0. Read command timeout period (level 6)";
            sw = rw; hw = r;
            reset = 0x0;
        } rd_tout6[23:16];
        field {
            name = "rd_tout5";
            desc = "The configuration mode is the same as that of rd_tout0. Read command timeout period (level 5)";
            sw = rw; hw = r;
            reset = 0x0;
        } rd_tout5[15:8];
        field {
            name = "rd_tout4";
            desc = "The configuration mode is the same as that of rd_tout0. Read command timeout period (level 4) The configuration mode is the same as that of rd_tout0.";
            sw = rw; hw = r;
            reset = 0x0;
        } rd_tout4[7:0];
    } QOSB_RDTOUT1 @ 0xB0;
    reg {
        name = "QOSB_RDTOUT2";
        desc = "QOSB_RDTOUT2 is QoSBuf read command timeout period register 2. (offset 0xB4, total reset 0x00000000; PROVEN: Hi3536D V100 data sheet).";
        field {
            name = "rd_tout11";
            desc = "Read command timeout period (level 11)";
            sw = rw; hw = r;
            reset = 0x0;
        } rd_tout11[31:24];
        field {
            name = "rd_tout10";
            desc = "The configuration mode is the same as that of rd_tout0. Read command timeout period (level 10)";
            sw = rw; hw = r;
            reset = 0x0;
        } rd_tout10[23:16];
        field {
            name = "rd_tout9";
            desc = "The configuration mode is the same as that of rd_tout0. Read command timeout period (level 9)";
            sw = rw; hw = r;
            reset = 0x0;
        } rd_tout9[15:8];
        field {
            name = "rd_tout8";
            desc = "The configuration mode is the same as that of rd_tout0. Read command timeout period (level 8) The configuration mode is the same as that of rd_tout0.";
            sw = rw; hw = r;
            reset = 0x0;
        } rd_tout8[7:0];
    } QOSB_RDTOUT2 @ 0xB4;
    reg {
        name = "QOSB_RDTOUT3";
        desc = "QOSB_RDTOUT3 is QoSBuf read command timeout period register 3. (offset 0xB8, total reset 0x00000000; PROVEN: Hi3536D V100 data sheet).";
        field {
            name = "rd_tout15";
            desc = "Read command timeout period (level 15)";
            sw = rw; hw = r;
            reset = 0x0;
        } rd_tout15[31:24];
        field {
            name = "rd_tout14";
            desc = "The configuration mode is the same as that ofrd_tout0. Read command timeout period (level 14)";
            sw = rw; hw = r;
            reset = 0x0;
        } rd_tout14[23:16];
        field {
            name = "rd_tout13";
            desc = "The configuration mode is the same as that ofrd_tout0. Read command timeout period (level 13)";
            sw = rw; hw = r;
            reset = 0x0;
        } rd_tout13[15:8];
        field {
            name = "rd_tout12";
            desc = "The configuration mode is the same as that ofrd_tout0. Read command timeout period (level 12) The configuration mode is the same as that ofrd_tout0.";
            sw = rw; hw = r;
            reset = 0x0;
        } rd_tout12[7:0];
    } QOSB_RDTOUT3 @ 0xB8;
    reg {
        name = "QOSB_WRTOUT_MAP";
        desc = "QOSB_WRTOUT_MAP is a QoSBuf write command timeout mapping mode control register. (offset 0xBC, total reset 0x00000000; PROVEN: Hi3536D V100 data sheet).";
        field {
            name = "reserved_31_29";
            desc = "Reserved";
            sw = r; hw = w;
            reset = 0x0;
        } reserved_31_29[31:29];
        field {
            name = "wrtout_map3";
            desc = "There are 16 levels of timeout periods. Four bits are selected from the ID and the level is determined based on the four bits. wrtout_map3 indicates the position of bit 3 in the ID.";
            sw = rw; hw = r;
            reset = 0x0;
        } wrtout_map3[28:24];
        field {
            name = "reserved_23_21";
            desc = "Reserved";
            sw = r; hw = w;
            reset = 0x0;
        } reserved_23_21[23:21];
        field {
            name = "wrtout_map2";
            desc = "There are 16 levels of timeout periods. Four bits are selected from the ID and the level is determined based on the four bits. wrtout_map2 indicates the position of bit 2 in the ID.";
            sw = rw; hw = r;
            reset = 0x0;
        } wrtout_map2[20:16];
        field {
            name = "reserved_15_13";
            desc = "Reserved";
            sw = r; hw = w;
            reset = 0x0;
        } reserved_15_13[15:13];
        field {
            name = "wrtout_map1";
            desc = "There are 16 levels of timeout periods. Four bits are selected from the ID and the level is determined based on the four bits. wrtout_map1 indicates the position of bit 1 in the ID.";
            sw = rw; hw = r;
            reset = 0x0;
        } wrtout_map1[12:8];
        field {
            name = "reserved_7_5";
            desc = "Reserved";
            sw = r; hw = w;
            reset = 0x0;
        } reserved_7_5[7:5];
        field {
            name = "wrtout_map0";
            desc = "There are 16 levels of timeout periods. Four bits are selected from the ID and the level is determined based on the four bits. wrtout_map0 indicates the position of bit 0 in the ID.";
            sw = rw; hw = r;
            reset = 0x0;
        } wrtout_map0[4:0];
    } QOSB_WRTOUT_MAP @ 0xBC;
    reg {
        name = "QOSB_RDTOUT_MAP";
        desc = "QOSB_RDTOUT_MAP is a QoSBuf read command timeout mapping mode control register. (offset 0xD0, total reset 0x00000000; PROVEN: Hi3536D V100 data sheet).";
        field {
            name = "reserved_31_29";
            desc = "Reserved";
            sw = r; hw = w;
            reset = 0x0;
        } reserved_31_29[31:29];
        field {
            name = "rdtout_map3";
            desc = "There are 16 levels of timeout periods. Four bits are selected from the ID and the level is determined based on the four bits.";
            sw = rw; hw = r;
            reset = 0x0;
        } rdtout_map3[28:24];
        field {
            name = "reserved_23_21";
            desc = "rdtout_map3 indicates the position of bit 3 in the ID. Reserved";
            sw = r; hw = w;
            reset = 0x0;
        } reserved_23_21[23:21];
        field {
            name = "rdtout_map2";
            desc = "There are 16 levels of timeout periods. Four bits are selected from the ID and the level is determined based on the four bits.";
            sw = rw; hw = r;
            reset = 0x0;
        } rdtout_map2[20:16];
        field {
            name = "reserved_15_13";
            desc = "rdtout_map2 indicates the position of bit 2 in the ID. Reserved";
            sw = r; hw = w;
            reset = 0x0;
        } reserved_15_13[15:13];
        field {
            name = "rdtout_map1";
            desc = "There are 16 levels of timeout periods. Four bits are selected from the ID and the level is determined based on the four bits.";
            sw = rw; hw = r;
            reset = 0x0;
        } rdtout_map1[12:8];
        field {
            name = "reserved_7_5";
            desc = "rdtout_map1 indicates the position of bit 1 in the ID. Reserved";
            sw = r; hw = w;
            reset = 0x0;
        } reserved_7_5[7:5];
        field {
            name = "rdtout_map0";
            desc = "There are 16 levels of timeout periods. Four bits are selected from the ID and the level is determined based on the four bits. rdtout_map0 indicates the position of bit 0 in the ID.";
            sw = rw; hw = r;
            reset = 0x0;
        } rdtout_map0[4:0];
    } QOSB_RDTOUT_MAP @ 0xD0;
    reg {
        name = "QOSB_CKG_CFG";
        desc = "QOSB_CKG_CFG (offset 0x108, total reset 0x00000001; PROVEN: Hi3536D V100 data sheet).";
        field {
            name = "reserved_31_1";
            desc = "Reserved";
            sw = r; hw = w;
            reset = 0x0;
        } reserved_31_1[31:1];
        field {
            name = "dyn_ck_gate";
            desc = "Dynamic clock gating for the QoSBuf module 0: The clock is always enabled. 1: The clock gating is automatic when the module is idle.";
            sw = rw; hw = r;
            reset = 0x1;
        } dyn_ck_gate[0:0];
    } QOSB_CKG_CFG @ 0x108;
    reg {
        name = "QOSB_CFG_PERF";
        desc = "QOSB_CFG_PERF is a QoSBuf performance statistical mode register. (offset 0x120, total reset 0x00000000; PROVEN: Hi3536D V100 data sheet).";
        field {
            name = "reserved_31_30";
            desc = "Reserved 1: enabled 0: disabled";
            sw = r; hw = w;
            reset = 0x0;
        } reserved_31_30[31:30];
        field {
            name = "perf_en";
            desc = "Performance statistics enable register starts the cyclic count. When perf_mode is 1, this bit is automatically cleared after the counting is complete. 0: continuous trigger mode. Counters related to performance statistics keep counting to ensure that no data overflows within 1s. 1: single trigger mode. When the performance statistical period";
            sw = rw; hw = r;
            reset = 0x0;
        } perf_en[29:29];
        field {
            name = "perf_mode";
            desc = "When perf_mode is 0 and this bit is enabled, the performance statistics Performance statistical mode reaches the value of perf_prd, the statistical result retains and the counting stops. 0x0: invalid 0x1−0xFFFFFFF: statistical cycle";
            sw = rw; hw = r;
            reset = 0x0;
        } perf_mode[28:28];
        field {
            name = "perf_prd";
            desc = "The maximum statistical result retains after an overflow occurs. Performance statistical cycle The actual statistical cycle is (perf_prd x 16 x tclk). tclk is the bus clock cycle of the DDRC. This configuration is valid only when perf_mode is 1. When perf_mode is 0, counters related to performance statistics keep counting.";
            sw = rw; hw = r;
            reset = 0x0;
        } perf_prd[27:0];
    } QOSB_CFG_PERF @ 0x120;
    reg {
        name = "QOSB_CMD_SUM";
        desc = "QOSB_CMD_SUM (offset 0x124, total reset 0x00000000; PROVEN: Hi3536D V100 data sheet).";
        field {
            name = "qos_cmd_sum";
            desc = "Accumulated value of the commands that are temporarily stored in the QoSBuf in the cycle. The value is wrapped if an overflow occurs.";
            sw = r; hw = w;
            reset = 0x0;
        } qos_cmd_sum[31:0];
    } QOSB_CMD_SUM @ 0x124;
    reg {
        name = "QOSB_CMD_CNT";
        desc = "QOSB_CMD_CNT is a QoSBuf command statistics register. (offset 0x180, total reset 0x00000000; PROVEN: Hi3536D V100 data sheet).";
        field {
            name = "reserved_31_8";
            desc = "Reserved";
            sw = r; hw = w;
            reset = 0x0;
        } reserved_31_8[31:8];
        field {
            name = "qos_cmd_cnt";
            desc = "Number of commands in the QoSBuf, including those on the pipeline";
            sw = rw; hw = r;
            reset = 0x0;
        } qos_cmd_cnt[7:0];
    } QOSB_CMD_CNT @ 0x180;
    reg {
        name = "QOSB_OSTD_CNT";
        desc = "QOSB_OSTD_CNT (offset 0x1E0, total reset 0x00000000; PROVEN: Hi3536D V100 data sheet).";
        field {
            name = "reserved_31_8";
            desc = "Reserved";
            sw = r; hw = w;
            reset = 0x0;
        } reserved_31_8[31:8];
        field {
            name = "ch0_cmd_ostd";
            desc = "Number of OSTD commands in channel 0 in the QoSBuf";
            sw = r; hw = w;
            reset = 0x0;
        } ch0_cmd_ostd[7:0];
    } QOSB_OSTD_CNT @ 0x1E0;
    reg {
        name = "QOSB_WR_CMD_SUM";
        desc = "QOSB_WR_CMD_SUM is a QoSBuf accumulated write command count register. (offset 0x1E4, total reset 0x00000000; PROVEN: Hi3536D V100 data sheet).";
        field {
            name = "qos_wr_cmd_sum";
            desc = "Accumulated value of the write commands that are temporarily stored in the QoSBuf in the cycle. The value is wrapped if an overflow occurs.";
            sw = r; hw = w;
            reset = 0x0;
        } qos_wr_cmd_sum[31:0];
    } QOSB_WR_CMD_SUM @ 0x1E4;
    reg {
        name = "QOSB_RD_CMD_SUM";
        desc = "QOSB_RD_CMD_SUM is a QoSBuf accumulated read command count register. (offset 0x1E8, total reset 0x00000000; PROVEN: Hi3536D V100 data sheet).";
        field {
            name = "qos_rd_cmd_sum";
            desc = "Accumulated value of the read commands that are temporarily stored in the QoSBuf in the cycle. The value is wrapped if an overflow occurs.";
            sw = r; hw = w;
            reset = 0x0;
        } qos_rd_cmd_sum[31:0];
    } QOSB_RD_CMD_SUM @ 0x1E8;
    reg {
        name = "QOSB_TIMEOUT_MODE";
        desc = "QOSB_TIMEOUT_MODE is a QoSBuf timeout mode selection register. (offset 0x1F0, total reset 0x00000000; PROVEN: Hi3536D V100 data sheet).";
        field {
            name = "reserved_31_1";
            desc = "Reserved 0: Reserved";
            sw = r; hw = w;
            reset = 0x0;
        } reserved_31_1[31:1];
        field {
            name = "timeout_mode";
            desc = "Read/Write command timeout mapping mode select 1: The timeout mode is mapped by using the priority and there are eight levels of timeout periods. The levels in the priority mapping table are the same as the lower eight levels in the ID mapping table. 4.1.7 DMC Registers of the DDRC 4.1.7.1 Register Summary Table 4-7 describes DMC registers. Table 4-7 Summary of DMC registers (DMC0 base address: 0x";
            sw = rw; hw = r;
            reset = 0x0;
        } timeout_mode[0:0];
    } QOSB_TIMEOUT_MODE @ 0x1F0;
};

`endif
