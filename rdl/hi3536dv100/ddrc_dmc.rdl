`ifndef HI3536D_DDRC_DMC_RDL
`define HI3536D_DDRC_DMC_RDL
regfile eHI3536D_DDRC_DMC {
    name = "DDRC DMC registers (DMC0), Hi3536D V100";
    desc = "DDRC DMC registers (DMC0) of the Hi3536D V100 at base 0x12118000. 18 registers extracted programmatically from the Hi3536D V100 data sheet (Issue 00B04, 2017-12-13, Table 4-7), register descriptions and field tables; reset values are the data sheet total reset values split onto the fields. Source: dl/research-hi3536 ReleaseDoc (unofficial copy of the HiSilicon SDK documentation; facts only). Field names, bit ranges, access types and reset values are exact; the free-text descriptions are attributed to fields from the PDF text layout (title sentence above the bit row, enumerations below) and can be shifted by one field where a sentence wraps: check the data sheet page when a description matters. Hardware not yet verified (no Hi3536D board on the bench).";
    reg {
        name = "DDRC_CTRL_SREF";
        desc = "DDRC_CTRL_SREF (offset 0x0, total reset 0x00000001; PROVEN: Hi3536D V100 data sheet).";
        field {
            name = "reserved_31_2";
            desc = "Reserved 0: normal operating mode";
            sw = r; hw = w;
            reset = 0x0;
        } reserved_31_2[31:2];
        field {
            name = "sref_done";
            desc = "DDR PHY self-refresh done 1: The transition from 0 to 1 indicates that the DDR PHY completes all required operations after exiting the self-refresh status and the DMC can accept new requests.";
            sw = rw; hw = r;
            reset = 0x0;
        } sref_done[1:1];
        field {
            name = "sref_req";
            desc = "SDRAM self-refresh request 0: exit the self-refresh status 1: enter the self-refresh status";
            sw = rw; hw = r;
            reset = 0x1;
        } sref_req[0:0];
    } DDRC_CTRL_SREF @ 0x0;
    reg {
        name = "DDRC_CTRL_SFC";
        desc = "DDRC_CTRL_SFC is a DDRC software configuration command start register. (offset 0xC, total reset 0x00000000; PROVEN: Hi3536D V100 data sheet).";
        field {
            name = "reserved_31_1";
            desc = "Reserved 0: The command is not executed or the parameter is automatically";
            sw = r; hw = w;
            reset = 0x0;
        } reserved_31_1[31:1];
        field {
            name = "cmd_req";
            desc = "Request of executing the configuration command of the DDRC cleared after the command is executed. 1: The command is requested to be executed.";
            sw = rw; hw = r;
            reset = 0x0;
        } cmd_req[0:0];
    } DDRC_CTRL_SFC @ 0xC;
    reg {
        name = "DDRC_CTRL_PERF";
        desc = "DDRC_CTRL_PERF is a DDRC performance statistics enable register. (offset 0x10, total reset 0x0014F000; PROVEN: Hi3536D V100 data sheet).";
        field {
            name = "reserved_31_1";
            desc = "Reserved 0: disabled 1: enabled";
            sw = r; hw = na;
            reset = 0xa7800;
        } reserved_31_1[31:1];
        field {
            name = "perf_en";
            desc = "Performance statistical mode register starts cyclic counting. When perf_mode is 1, this bit is automatically cleared after the counting is complete. When perf_mode is 0 and this bit is enabled, the performance statistics";
            sw = rw; hw = r;
            reset = 0x0;
        } perf_en[0:0];
    } DDRC_CTRL_PERF @ 0x10;
    reg {
        name = "DDRC_CFG_SREF";
        desc = "DDRC_CFG_SREF is a DDRC self-refresh configuration register. (offset 0x20, total reset 0x00000000; PROVEN: Hi3536D V100 data sheet).";
        field {
            name = "asref_en";
            desc = "SDRAM automatic self-refresh enable 0: disabled 1: enabled self-refresh status only when DDRC_CFG_PD[PD_EN] and the asref_en corresponding to the rank are valid.";
            sw = r; hw = w;
            reset = 0x0;
        } asref_en[31:16];
        field {
            name = "sref_arefnum";
            desc = "Each rank corresponds to one control bit. The rank automatically enters the This function is not supported in this version. Number of self-refresh operations initiated after DDR3 SDRAM exits the self-refresh status during the DFS process 0x0: No self-refresh operation is initiated.";
            sw = rw; hw = r;
            reset = 0x0;
        } sref_arefnum[15:12];
        field {
            name = "reserved_11_9";
            desc = "0x1–0xF: n Reserved interface command when the DDRC enters the low-power status (DDR self-refresh)";
            sw = r; hw = w;
            reset = 0x0;
        } reserved_11_9[11:9];
        field {
            name = "clk_switch";
            desc = "DDRC low-power clock switch. Whether to back press AXI 0: The interface commands are not back pressed, and an error is returned directly. 1: The interface commands are back pressed, and the original command is executed after the clock is switched.";
            sw = rw; hw = r;
            reset = 0x0;
        } clk_switch[8:8];
        field {
            name = "reserved_7_5";
            desc = "Reserved mode 0: enabled 1: disabled";
            sw = r; hw = w;
            reset = 0x0;
        } reserved_7_5[7:5];
        field {
            name = "sref_odis";
            desc = "Output disable for the DDR command and data I/O in self-refresh be set to 1 to disable the output of the DDR command and data I/O after the DDR enters the self-refresh status. It is recommended that this bit be set to 0 to enable the output of the DDR command and data I/O before the DDR exits the self-refresh status.";
            sw = rw; hw = r;
            reset = 0x0;
        } sref_odis[4:4];
        field {
            name = "reserved_3_1";
            desc = "The configuration is a static configuration. It is recommended that this bit Reserved";
            sw = r; hw = w;
            reset = 0x0;
        } reserved_3_1[3:1];
        field {
            name = "sref_cc";
            desc = "SDRAM clock control in self-refresh mode 0: The SDRAM clock is enabled. 1: The SDRAM clock is disabled.";
            sw = rw; hw = r;
            reset = 0x0;
        } sref_cc[0:0];
    } DDRC_CFG_SREF @ 0x20;
    reg {
        name = "DDRC_CFG_PD";
        desc = "DDRC_CFG_PD (offset 0x28, total reset 0x00000000; PROVEN: Hi3536D V100 data sheet).";
        field {
            name = "asref_prd";
            desc = "SDRAM self-refresh cycle. When the DDRC does not receive any command in consecutive asref_prd cycles, it forces the SDRAM to enter the self-refresh status. When a command is received, the DDRC forces the SDRAM to exit the self-refresh status.";
            sw = r; hw = w;
            reset = 0x0;
        } asref_prd[31:20];
        field {
            name = "t_clk_cke";
            desc = "0x0−0xFFF: (n x 16) clock cycles This field is valid only when asref_en is 1. Relationship between CLK and CKE 0x0−0x7: Delay relative to CKE when the DDR PHY disables the DDR3 clock. The delay is related to the DDR PHY.";
            sw = rw; hw = r;
            reset = 0x0;
        } t_clk_cke[19:16];
        field {
            name = "pd_prd";
            desc = "This field can be set to 0 when the clock is disabled. SDRAM power-down cycle. When the DDRC does not receive any command in consecutive pd_prd cycles, it forces the SDRAM to enter the power-down status. When a command is received, the DDRC forces the SDRAM to exit the power-down status. 0x00: not enter the power-down status 0x01−0xFFF: n clock cycles";
            sw = rw; hw = r;
            reset = 0x0;
        } pd_prd[15:4];
        field {
            name = "reserved_3_2";
            desc = "This field is valid only when pd_en is 1. Reserved 1: disable the pin output 0: enable the pin output";
            sw = r; hw = w;
            reset = 0x0;
        } reserved_3_2[3:2];
        field {
            name = "pd_ac";
            desc = "SDRAM address command dynamic disable in power-down mode";
            sw = rw; hw = r;
            reset = 0x0;
        } pd_ac[1:1];
        field {
            name = "pd_en";
            desc = "This field is valid when pd_en is enabled. The control pins do not include CKE, ODT, CSN, and RESET_N. Automatic power-down enable for the SDRAM 1: enabled 0: disabled";
            sw = rw; hw = r;
            reset = 0x0;
        } pd_en[0:0];
    } DDRC_CFG_PD @ 0x28;
    reg {
        name = "DDRC_CFG_AREF";
        desc = "DDRC_CFG_AREF is a DDRC auto-refresh mode register. (offset 0x2C, total reset 0x00000000; PROVEN: Hi3536D V100 data sheet).";
        field {
            name = "reserved_31_16";
            desc = "Reserved number of auto-refresh commands cannot be transmitted.";
            sw = r; hw = w;
            reset = 0x0;
        } reserved_31_16[31:16];
        field {
            name = "aref_alarm_num";
            desc = "The auto-refresh command is forced to be transmitted if a specific 0x0–0xFF: lack of (n + 1) auto-refresh commands upper bits are lost after the bits of the 8-bit counter are carried.";
            sw = rw; hw = r;
            reset = 0x0;
        } aref_alarm_num[15:8];
        field {
            name = "reserved_7_5";
            desc = "Only one auto-refresh command is considered when n is 255 because the In optimization mode (when aref_opt is 1), an alarm is generated when the number of postponed commands is greater than or equal to 15. Reserved";
            sw = r; hw = w;
            reset = 0x0;
        } reserved_7_5[7:5];
        field {
            name = "aref_alarm_en";
            desc = "Auto-refresh loss alarm enable (AREF function) 0: disabled 1: enabled";
            sw = rw; hw = r;
            reset = 0x0;
        } aref_alarm_en[4:4];
        field {
            name = "aref_dual_rank";
            desc = "REF command transmit mode select 0: The REF commands are transmitted to only one rank each time. 1: The REF commands are transmitted to two ranks each time.";
            sw = rw; hw = r;
            reset = 0x0;
        } aref_dual_rank[3:3];
        field {
            name = "reserved_2_2";
            desc = "Reserved 00: An auto-refresh operation is performed every one tREFI cycle. 01: Three auto-refresh operations are performed every three tREFI cycles.";
            sw = rw; hw = r;
            reset = 0x0;
        } reserved_2_2[2:2];
        field {
            name = "aref_mode";
            desc = "Auto-refresh mode selection 10: Four auto-refresh operations are performed every five tREFI cycles. 11: Eight auto-refresh operations are performed every nine tREFI cycles.";
            sw = rw; hw = r;
            reset = 0x0;
        } aref_mode[1:0];
    } DDRC_CFG_AREF @ 0x2C;
    reg {
        name = "DDRC_CFG_WORKMODE";
        desc = "DDRC_CFG_WORKMODE is a DDRC operating mode register. (offset 0x40, total reset 0x00000000; PROVEN: Hi3536D V100 data sheet).";
        field {
            name = "reserved_31_14";
            desc = "Reserved 0: SDR mode";
            sw = r; hw = w;
            reset = 0x0;
        } reserved_31_14[31:14];
        field {
            name = "hdr_mode";
            desc = "DFI interface mode select 1: HDR mode";
            sw = rw; hw = r;
            reset = 0x0;
        } hdr_mode[13:13];
        field {
            name = "read_mode";
            desc = "The Hi3536D V100 supports only the HDR mode. DDRC read mode 0: associated read mode 1: delay read mode 00: The address is set to all 1s when the DDR is idle. 01: The status of the previous command is retained when the DDR";
            sw = rw; hw = r;
            reset = 0x0;
        } read_mode[12:12];
        field {
            name = "addr_mode";
            desc = "DDR address line reverse mode select is idle. 10: The status opposite to the previous status is restored when the DDR is idle. 11: reserved 0: disabled";
            sw = rw; hw = r;
            reset = 0x0;
        } addr_mode[11:10];
        field {
            name = "intlv_en";
            desc = "DMC burst interleave enable 1: enabled";
            sw = rw; hw = r;
            reset = 0x0;
        } intlv_en[9:9];
        field {
            name = "wrap_en";
            desc = "It is recommended that this field be set to 0. Wrap command optimization enable 0: disabled 1: enabled";
            sw = rw; hw = r;
            reset = 0x0;
        } wrap_en[8:8];
        field {
            name = "reserved_7_5";
            desc = "Reserved";
            sw = r; hw = w;
            reset = 0x0;
        } reserved_7_5[7:5];
        field {
            name = "apre_en";
            desc = "Auto-precharge enable 0: disabled 1: enabled";
            sw = rw; hw = r;
            reset = 0x0;
        } apre_en[4:4];
        field {
            name = "func_clkon";
            desc = "Functional module clock enable 0: The clock is internally controlled. 1: The clock is forcibly enabled.";
            sw = rw; hw = r;
            reset = 0x0;
        } func_clkon[3:3];
        field {
            name = "data_clkon";
            desc = "Data channel clock enable 0: The clock is internally controlled. 1: The clock is forcibly enabled.";
            sw = rw; hw = r;
            reset = 0x0;
        } data_clkon[2:2];
        field {
            name = "cmd_clkon";
            desc = "Command channel clock enable 0: The clock is internally controlled. 1: The clock is forcibly enabled. 0: The ratio of the DDRC frequency to the PHY frequency is 1:1. 1: The ratio of the frequency of the DDRC to the frequency of the";
            sw = rw; hw = r;
            reset = 0x0;
        } cmd_clkon[1:1];
        field {
            name = "clk_ratio";
            desc = "Operating mode of the DDRC PHY is 1:2. This field is fixed at 1 in this version.";
            sw = rw; hw = r;
            reset = 0x0;
        } clk_ratio[0:0];
    } DDRC_CFG_WORKMODE @ 0x40;
    reg {
        name = "DDRC_CFG_DDRMODE";
        desc = "DDRC_CFG_DDRMODE is a DDR operating mode register. (offset 0x50, total reset 0x00000000; PROVEN: Hi3536D V100 data sheet).";
        field {
            name = "reserved_31_31";
            desc = "Reserved 000: 8-byte banks are interleaved. 001: 16-byte banks are interleaved. 111: 1 KB banks are interleaved. 000: 16-byte banks are interleaved. 001: 32-byte banks are interleaved. 111: 2 KB banks are interleaved.";
            sw = r; hw = w;
            reset = 0x0;
        } reserved_31_31[31:31];
        field {
            name = "bank_mode";
            desc = "Bank interleaving mode For 8-bit bus width: … For 16-bit bus width: … For 32-bit bus width: 000: 32-byte banks are interleaved. 001: 64-byte banks are interleaved. 111: 4 KB banks are interleaved. 000: 64-byte banks are interleaved. 001: 128-byte banks are interleaved. 111: 8 KB banks are interleaved.";
            sw = rw; hw = r;
            reset = 0x0;
        } bank_mode[30:28];
        field {
            name = "reserved_27_26";
            desc = "… For 64-bit bus width: …  The current version supports only the 16-bit bus width.  When the AXI is set to a non-zero value, this field must be set to 000 and the AXI configuration mode is used. When the AXI is set to 000, the DMC configuration mode is used. Reserved";
            sw = r; hw = w;
            reset = 0x0;
        } reserved_27_26[27:26];
        field {
            name = "bank_xor";
            desc = "Scrambling enable for the bank address and row address";
            sw = rw; hw = r;
            reset = 0x0;
        } bank_xor[25:24];
        field {
            name = "asref_zqc_en";
            desc = "SDRAM ZQ enable when the ASREF exits. 0: disabled 1: enabled 0: disabled 1: enabled";
            sw = rw; hw = r;
            reset = 0x0;
        } asref_zqc_en[23:23];
        field {
            name = "sref_zqc_en";
            desc = "SDRAM ZQ enable when the SREF exits.";
            sw = rw; hw = r;
            reset = 0x0;
        } sref_zqc_en[22:22];
        field {
            name = "rank";
            desc = " This field is set to 0 by default.  In addition, the value of this field cannot be dynamically changed during the self-refresh exit process. Number of DDRC ranks 00: 1 Other values: reserved";
            sw = rw; hw = r;
            reset = 0x0;
        } rank[21:20];
        field {
            name = "rank_mode";
            desc = "Rank interleaving mode 00: single rank mode Other values: reserved";
            sw = rw; hw = r;
            reset = 0x0;
        } rank_mode[19:18];
        field {
            name = "odt_on";
            desc = "Whether the ODT signal output to the SDRAM is fixed 0: The signal is automatically controlled by the DDRC. 1: The output is fixed at the wodt configuration of rank 0.";
            sw = rw; hw = r;
            reset = 0x0;
        } odt_on[17:17];
        field {
            name = "zqc_en";
            desc = "AREF ZQ command enable 0: disabled 1: enabled";
            sw = rw; hw = r;
            reset = 0x0;
        } zqc_en[16:16];
        field {
            name = "reserved_15_15";
            desc = "Reserved using the address, and exclusive ORed with the data to reduce";
            sw = r; hw = w;
            reset = 0x0;
        } reserved_15_15[15:15];
        field {
            name = "scramb_en";
            desc = "Data scrambling enable (The scrambling code is generated by synchronous inversion). 0: disabled 1: enabled";
            sw = rw; hw = r;
            reset = 0x0;
        } scramb_en[14:14];
        field {
            name = "reserved_13_13";
            desc = "Reserved";
            sw = r; hw = w;
            reset = 0x0;
        } reserved_13_13[13:13];
        field {
            name = "bc_en";
            desc = "DDR3 burst chop mode 0: disabled 1: enabled";
            sw = rw; hw = r;
            reset = 0x0;
        } bc_en[12:12];
        field {
            name = "reserved_11_11";
            desc = "Reserved This bit must be fixed at 1'b0.";
            sw = r; hw = w;
            reset = 0x0;
        } reserved_11_11[11:11];
        field {
            name = "reserved_10_9";
            desc = "Reserved 1: BL8 0: BL4 1: BL32";
            sw = r; hw = w;
            reset = 0x0;
        } reserved_10_9[10:9];
        field {
            name = "brstlen";
            desc = "Burst length of the DDRC When brstlen2 is set to 0: When brstlen2 is set to 1: 0: BL16 burst length is BLx/n (x indicates the burst type, that is, 4, 8, 16, or 32. n indicates that the clock ratio of the DMC to the PHY is 1:n). For example, when the clock ratio is 1:2, to set the DDRC burst length to BL32, set brstlen to 0 and brstlen2 to 1. 1: extended mode";
            sw = rw; hw = r;
            reset = 0x0;
        } brstlen[8:8];
        field {
            name = "brstlen2";
            desc = "The burst length of the DDR3SDRAM can be set to only burst 8. The burst length is related to the clock ratio of the DMC to the PHY. The Burst length 2 of the DDRC 0: basic mode";
            sw = rw; hw = r;
            reset = 0x0;
        } brstlen2[7:7];
        field {
            name = "reserved_6_6";
            desc = "This field works with brstlen. Reserved 00: 8 bits";
            sw = r; hw = w;
            reset = 0x0;
        } reserved_6_6[6:6];
        field {
            name = "mem_width";
            desc = " 01: 16 bits Other values: reserved";
            sw = rw; hw = r;
            reset = 0x0;
        } mem_width[5:4];
        field {
            name = "dram_type";
            desc = "External memory type 110: DDR3 Other values: reserved";
            sw = rw; hw = r;
            reset = 0x0;
        } dram_type[3:0];
    } DDRC_CFG_DDRMODE @ 0x50;
    reg {
        name = "DDRC_CFG_SCRAMB";
        desc = "DDRC_CFG_SCRAMB is a DDR data scrambling configuration register. (offset 0x58, total reset 0x00000000; PROVEN: Hi3536D V100 data sheet).";
        field {
            name = "reserved_31_19";
            desc = "Reserved";
            sw = r; hw = w;
            reset = 0x0;
        } reserved_31_19[31:19];
        field {
            name = "dbi_low_act";
            desc = "DBI active level 0: active high 1: active low";
            sw = rw; hw = r;
            reset = 0x0;
        } dbi_low_act[18:18];
        field {
            name = "rd_dbi_en";
            desc = "Read DBI enable 0: disabled 1: enabled";
            sw = rw; hw = r;
            reset = 0x0;
        } rd_dbi_en[17:17];
        field {
            name = "wr_dbi_en";
            desc = "Read DBI enable 0: disabled 1: enabled";
            sw = rw; hw = r;
            reset = 0x0;
        } wr_dbi_en[16:16];
        field {
            name = "reserved_15_5";
            desc = "Reserved";
            sw = r; hw = w;
            reset = 0x0;
        } reserved_15_5[15:5];
        field {
            name = "scramb_seed_type";
            desc = "Address mode for scrambling 0: Use the CS and BA for scrambling. 1: Use the CS, BA, and low bits of the row address for scrambling.";
            sw = rw; hw = r;
            reset = 0x0;
        } scramb_seed_type[4:4];
        field {
            name = "reserved_3_0";
            desc = "Reserved";
            sw = r; hw = w;
            reset = 0x0;
        } reserved_3_0[3:0];
    } DDRC_CFG_SCRAMB @ 0x58;
    reg {
        name = "DDRC_CFG_TIMING0";
        desc = "DDRC_CFG_TIMING0 is DDRC timing parameter register 0. (offset 0x100, total reset 0xFFFFFF3F; PROVEN: Hi3536D V100 data sheet).";
        field {
            name = "tmrd";
            desc = "Number of wait cycles for the load mode register (LMR) command. The value is tMRD for the DDR3.";
            sw = rw; hw = r;
            reset = 0xf;
        } tmrd[31:28];
        field {
            name = "trrd";
            desc = "0x0–0x1: 1 clock cycle 0x2–0xF: n clock cycles Number of wait cycles from ACT bank A to ACT bank B 0x0–0x1: 1 clock cycle 0x2–0xF: n clock cycles";
            sw = rw; hw = r;
            reset = 0xf;
        } trrd[27:24];
        field {
            name = "trp";
            desc = "Number of wait cycles for the disable command (PRE period) 0x0–0x1: 1 clock cycle 0x2–0xF: n clock cycles or write command";
            sw = rw; hw = r;
            reset = 0x1f;
        } trp[23:19];
        field {
            name = "trcd";
            desc = "Number of wait cycles from the ACT bank command to the read 0x0–0x3: 3 clock cycles 0x4–0xF: n clock cycles";
            sw = rw; hw = r;
            reset = 0x1f;
        } trcd[18:14];
        field {
            name = "trc";
            desc = "Number of wait cycles from an ACT bank command to the next ACT bank command 0x00–0x01: 1 clock cycle 0x02–0x3F: n clock cycles";
            sw = rw; hw = r;
            reset = 0x3f;
        } trc[13:8];
        field {
            name = "reserved_7_6";
            desc = "Reserved disable command (PRE)";
            sw = r; hw = w;
            reset = 0x0;
        } reserved_7_6[7:6];
        field {
            name = "tras";
            desc = "Number of wait cycles from the ACT bank command to the 0x0–0x1: 1 clock cycle 0x2–0xF: n clock cycles Others: Reserved";
            sw = rw; hw = r;
            reset = 0x3f;
        } tras[5:0];
    } DDRC_CFG_TIMING0 @ 0x100;
    reg {
        name = "DDRC_CFG_TIMING1";
        desc = "DDRC_CFG_TIMING1 (offset 0x84, total reset 0xFF2215FF; PROVEN: Hi3536D V100 data sheet).";
        field {
            name = "tsre";
            desc = "Number of wait cycles from the self-refresh exit command to the read command 0x0: reserved 0x01–0xFF: (n x 4) clock cycles the DDR3 SDRAM.";
            sw = rw; hw = r;
            reset = 0xff;
        } tsre[31:24];
        field {
            name = "trtw";
            desc = "This field is set to the larger value between tXSDLL and tXS for Delay from the last read data command to the first write data command 0x0–0x1: 1 clock cycle 0x2–0xF: (n + 1) clock cycles package, and I/O.";
            sw = rw; hw = r;
            reset = 0x2;
        } trtw[23:20];
        field {
            name = "twl";
            desc = "In DDR3 mode, the field value depends on the latency of the board, Number of wait cycles from the write command to the write data command 0x0–0x1: 1 clock cycle 0x2–0xF: n clock cycles the read data operation 0x0–0x1: 1 clock cycle";
            sw = rw; hw = r;
            reset = 0x4;
        } twl[19:15];
        field {
            name = "tcl";
            desc = "For example, 0x3 indicates three clock cycles. The clock cycle is the DDR3 clock cycle. Column address strobe (CAS) latency from the read command to 0x2–0xF: n clock cycles";
            sw = rw; hw = r;
            reset = 0x5;
        } tcl[14:10];
        field {
            name = "reserved_9_9";
            desc = "The clock cycle is the DDR3 clock cycle. Reserved command. The field value is set to the maximum value of";
            sw = r; hw = w;
            reset = 0x0;
        } reserved_9_9[9:9];
        field {
            name = "trfc";
            desc = "Number of wait cycles for the AREF period or AREF to the ACT max{trfc, tzqcs}. 0x00: reserved 0x01–0x1FF: n clock cycles";
            sw = rw; hw = r;
            reset = 0x1ff;
        } trfc[8:0];
    } DDRC_CFG_TIMING1 @ 0x84;
    reg {
        name = "DDRC_CFG_TIMING2";
        desc = "DDRC_CFG_TIMING2 is DDRC timing parameter register 2. (offset 0x108, total reset 0xF303F000; PROVEN: Hi3536D V100 data sheet).";
        field {
            name = "tcke";
            desc = "Minimum cycle of retaining the self-refresh mode 0x0: reserved 0x1–0xF: n clock cycles tCKSRE, tCKSRX, and tCKE.";
            sw = rw; hw = r;
            reset = 0xf;
        } tcke[31:28];
        field {
            name = "twtr";
            desc = "The field value must be the maximum value among tCKESR, Number of wait cycles for the last write data to the write-to-read command 0x0–0x1: 1 clock cycle 0x2–0xF: n clock cycles";
            sw = rw; hw = r;
            reset = 0x3;
        } twtr[27:24];
        field {
            name = "reserved_23_18";
            desc = "For example, 0x3 indicates three clock cycles. Reserved";
            sw = r; hw = w;
            reset = 0x0;
        } reserved_23_18[23:18];
        field {
            name = "tfaw";
            desc = "Number of clock cycles for four consecutive activation commands 0x00–0x3F: n clock cycles";
            sw = rw; hw = r;
            reset = 0x3f;
        } tfaw[17:12];
        field {
            name = "reserved_11_11";
            desc = "For example, 0x14 indicates 20 clock cycles. Reserved 0x000: forbidden 0x001–0x7FF: The auto-refresh cycle of the SDRAM is (16 x n)";
            sw = r; hw = w;
            reset = 0x0;
        } reserved_11_11[11:11];
        field {
            name = "taref";
            desc = "Number of auto-refresh cycles clock cycles. For example, 0x008 indicates 128 (16 x 8) clock cycles. The interval tREFI is 7800/16/tclk. Tclk is twice the running cycle of the SDRAM.";
            sw = rw; hw = r;
            reset = 0x0;
        } taref[10:0];
    } DDRC_CFG_TIMING2 @ 0x108;
    reg {
        name = "DDRC_CFG_TIMING3";
        desc = "DDRC_CFG_TIMING3 (offset 0x10C, total reset 0xFFFFE0F2; PROVEN: Hi3536D V100 data sheet).";
        field {
            name = "tzq_prd";
            desc = "Number of ZQCS command cycles 0x000: The ZQCS command is forbidden. 0x001–0x3FF: (n x 128) AREF cycles clock cycles.";
            sw = rw; hw = r;
            reset = 0x3ff;
        } tzq_prd[31:22];
        field {
            name = "tzqinit";
            desc = "The number of ZQCS command cycles is equal to (n x 128) taref Number of ZQ initialization delay cycles 0x0–0x1FF: (n x 4) clock cycles tDLLK.";
            sw = rw; hw = r;
            reset = 0x1ff;
        } tzqinit[21:13];
        field {
            name = "taond";
            desc = "The value needs to be set to the larger value between tZQINIT and Number of ODT enable/disable cycles In DDR3 mode, this value is set to tWL – 2 (tWL is DDRC_CFG_TIMING1[twl]).";
            sw = rw; hw = r;
            reset = 0x0;
        } taond[12:8];
        field {
            name = "txard";
            desc = "Number of wait cycles of exiting the DDR low-power mode 0x0–0xF: n clock cycles (in decimal) For example, 0x7 indicates seven clock cycles. The field value is the maximum value among tXP, tXARD, tXARDS, and tXS.";
            sw = rw; hw = r;
            reset = 0xf;
        } txard[7:4];
        field {
            name = "trtp";
            desc = "In DDR3 mode, the field value is the larger value between tXP and tCKE. Wait delay from the read command to the disable command 000–010: 2 clock cycles 011–111: n clock cycles Trtp is calculated as follows: Trtp = AL + BL/2 + Max (trtp, 2) – 2";
            sw = rw; hw = r;
            reset = 0x2;
        } trtp[3:0];
    } DDRC_CFG_TIMING3 @ 0x10C;
    reg {
        name = "DDRC_CFG_TIMING4";
        desc = "DDRC_CFG_TIMING4 (offset 0x110, total reset 0x01FF2000; PROVEN: Hi3536D V100 data sheet).";
        field {
            name = "reserved_31_25";
            desc = "Reserved";
            sw = r; hw = w;
            reset = 0x0;
        } reserved_31_25[31:25];
        field {
            name = "tmod";
            desc = "Delay from the MRS command to ODT and ZQCL validity 0x0–0x1: 1 clock cycle 0x2–0x1F: n clock cycles";
            sw = rw; hw = r;
            reset = 0x1f;
        } tmod[24:20];
        field {
            name = "reserved_19_0";
            desc = "Reserved";
            sw = r; hw = na;
            reset = 0xf2000;
        } reserved_19_0[19:0];
    } DDRC_CFG_TIMING4 @ 0x110;
    reg {
        name = "DDRC_CFG_TIMING5";
        desc = "DDRC_CFG_TIMING5 is DDRC timing parameter register 5. (offset 0x114, total reset 0x1113FF1F; PROVEN: Hi3536D V100 data sheet).";
        field {
            name = "reserved_31_16";
            desc = "Reserved 0x0−0xFF: (n x 2) clock cycles";
            sw = r; hw = na;
            reset = 0x1113;
        } reserved_31_16[31:16];
        field {
            name = "tzqcs";
            desc = "ZQCS calibration delay cycle the DMC design.";
            sw = rw; hw = r;
            reset = 0xff;
        } tzqcs[15:8];
        field {
            name = "reserved_7_5";
            desc = "The field value must be greater than or equal to 10 because of Reserved 0x0−0x1: one clock cycle 0x2−0x1F: n clock cycles";
            sw = r; hw = w;
            reset = 0x0;
        } reserved_7_5[7:5];
        field {
            name = "twr";
            desc = "Number of wait cycles of write recovery frequency that may be used. tWR cannot be changed when the DDR frequency changes. When the DFS is required, tWR must be set based on the highest chip";
            sw = rw; hw = r;
            reset = 0x1f;
        } twr[4:0];
    } DDRC_CFG_TIMING5 @ 0x114;
    reg {
        name = "DDRC_CFG_TIMING6";
        desc = "DDRC_CFG_TIMING6 is DDRC timing parameter register 6. (offset 0x118, total reset 0x000000FF; PROVEN: Hi3536D V100 data sheet).";
        field {
            name = "reserved_31_24";
            desc = "Reserved";
            sw = r; hw = w;
            reset = 0x0;
        } reserved_31_24[31:24];
        field {
            name = "trrd_l";
            desc = "Number of trrd wait cycles between bank groups 0x0−0x1: one clock cycle 0x2−0xF: n clock cycles";
            sw = rw; hw = r;
            reset = 0x0;
        } trrd_l[23:20];
        field {
            name = "twtr_l";
            desc = "Number of twtr wait cycles between bank groups 0x0−0x1: one clock cycle 0x2−0xF: n clock cycles";
            sw = rw; hw = r;
            reset = 0x0;
        } twtr_l[19:16];
        field {
            name = "tccd_l";
            desc = "Number of tccd wait cycles between bank groups 0x0−0x1: one clock cycle 0x2−0xF: n clock cycles";
            sw = rw; hw = r;
            reset = 0x0;
        } tccd_l[15:12];
        field {
            name = "reserved_11_8";
            desc = "Reserved tCKSRX for the DDR3. Number of advanced valid beats before the DDR exits the self-refresh status.";
            sw = r; hw = w;
            reset = 0x0;
        } reserved_11_8[11:8];
        field {
            name = "tcksrx";
            desc = "";
            sw = rw; hw = r;
            reset = 0xf;
        } tcksrx[7:4];
        field {
            name = "tcksre";
            desc = "0x0−0x1: one clock cycle 0x2−0xF: n clock cycles tCKSRE for the DDR3. Number of beats to be retained after the DDR enters the self-refresh status. 0x0−0x1: one clock cycle 0x2−0xF: n clock cycles";
            sw = rw; hw = r;
            reset = 0xf;
        } tcksre[3:0];
    } DDRC_CFG_TIMING6 @ 0x118;
    reg {
        name = "DDRC_CFG_BLDATA";
        desc = "DDRC_CFG_BLDATA is a DDRC pre-received write data configuration register. (offset 0x140, total reset 0x00000002; PROVEN: Hi3536D V100 data sheet).";
        field {
            name = "reserved_31_4";
            desc = "Reserved";
            sw = r; hw = w;
            reset = 0x0;
        } reserved_31_4[31:4];
        field {
            name = "bl_data";
            desc = "Number of DMC data segments corresponding to each DDR command in the current mode 0x0–0xF: n data segments";
            sw = rw; hw = r;
            reset = 0x2;
        } bl_data[3:0];
    } DDRC_CFG_BLDATA @ 0x140;
    reg {
        name = "DDRC_CFG_DMCLVL";
        desc = "DDRC_CFG_DMCLVL is a DDRC command queue depth threshold configuration register. (offset 0x144, total reset 0x00000008; PROVEN: Hi3536D V100 data sheet).";
        field {
            name = "reserved_31_13";
            desc = "Reserved";
            sw = r; hw = w;
            reset = 0x0;
        } reserved_31_13[31:13];
        field {
            name = "mbist_que_level";
            desc = "Number of command buffers started by the DMC when the MTEST or MCLR function is used 0x0: 1 0x1−0x10: 1−16. The maximum value is related to the code.";
            sw = rw; hw = r;
            reset = 0x0;
        } mbist_que_level[12:8];
        field {
            name = "reserved_7_5";
            desc = "Reserved";
            sw = r; hw = w;
            reset = 0x0;
        } reserved_7_5[7:5];
        field {
            name = "que_level";
            desc = "Depth of the command register FIFO in the DMC 0x1−0x10: depth of n commands Other values: reserved DDRC_CFG_DDR PHY DDRC_CFG_DDR PHY is a DDR I/O configuration register.";
            sw = rw; hw = r;
            reset = 0x8;
        } que_level[4:0];
    } DDRC_CFG_DMCLVL @ 0x144;
};

`endif
