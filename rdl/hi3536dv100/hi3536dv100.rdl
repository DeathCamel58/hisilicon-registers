`include "defines.rdl"

`include "../common/ARM_GIC400.rdl"
`include "../common/ARM_PL011.rdl"
`include "../common/ARM_PL061.rdl"
`include "../common/HISI_CIPHER_MC.rdl"
`include "../common/HISI_DMAC.rdl"
`include "../common/HISI_FEMAC.rdl"
`include "../common/HISI_FMC.rdl"
`include "../common/HISI_IR.rdl"
`include "../common/HISI_JPGD.rdl"
`include "../common/HISI_JPGE.rdl"
`include "../common/HISI_RTC_SPI_IF.rdl"
`include "../common/HISI_SCD_AV300.rdl"
`include "../common/HISI_TDE.rdl"
`include "../common/HISI_TIMER_SP804.rdl"
`include "../common/HISI_USB_HOST.rdl"
`include "../common/HISI_WDG_SP805.rdl"

// Chip-local blocks generated from the Hi3536D V100 data sheet (Issue 00B04).
`include "crg.rdl"
`include "sys_ctrl.rdl"
`include "misc_ctrl.rdl"
`include "pmc.rdl"
`include "ddrc.rdl"
`include "ddrc_qosb.rdl"
`include "ddrc_dmc.rdl"
`include "ddrc_phy.rdl"
`include "vou.rdl"
`include "aiao.rdl"
`include "acodec.rdl"
`include "io_config.rdl"
`include "hdmi_tx.rdl"
`include "vdh.rdl"
`include "vgs.rdl"
`include "vgs_img.rdl"
`include "sata.rdl"
`include "tde_node.rdl"

addrmap hi3536dv100 {
    name = "hi3536dv100 registers";
    desc = "
        ## Status

        Address map and block selection of the Hi3536D V100 (NVR decoder SoC, ARM Cortex-A7, H.264/H.265 decoder, 4K VO/HDMI, SATA, USB 2.0, FEMAC).
        The CRG, SYS_CTRL, MISC_CTRL, PMC, DDRC (AXI, QoS buffer, DMC, PHY), VOU, AIAO and ACODEC blocks were generated on 2026-11-11 and regenerated on 2026-11-15 (older extractor: lost field names, dropped fields, shifted descriptions) from the vendor Hi3536D V100 data sheet (Issue 00B04, 2017-12-13; see each file); everything else below was established without it from vendor code (SDK 2.0.2.0 U-Boot, the Linux 4.9.37 device tree
        and drivers, the closed MPP kernel modules disassembled statically) and from firmware images. Nothing was verified on hardware. Each row of the table and each
        instance carries a confidence label: PROVEN (address or offset appears literally in vendor code or the vendor device tree), INFERRED (a layout taken from the
        same IP on another chip because offsets or behavior agree), GUESS (nothing but a name). Blocks whose register layout is unknown are not instantiated.

        Instances: blocks reused from other chips are PROVEN for the base address and INFERRED for the register layout unless the block description says otherwise
        (CIPHER and the SCD offsets were checked against vendor register tables and disassembly; see docs/research/hi3536dv100-blocks.md of the workspace).

        ## Addresses

        | Start Address | End Address | Description | Confidence | Evidence |
        |---------------|-------------|-------------|------------|----------|
        | 0x04000000 | 0x0400FFFF | BOOTROM | INFERRED | U-Boot start.S / reg_init: RAM_START_ADRS 0x04010500, STACK_TRAINING 0x04018000 (boot RAM) |
        | 0x10000000 | 0x1000FFFF | FMC (SPI NOR / SPI NAND controller) registers | PROVEN | vendor U-Boot FMC_REG_BASE, DT fmc reg |
        | 0x10010000 | 0x1001FFFF | FEMAC Ethernet MAC (MDIO at +0x1100, GLB at +0x1300) | PROVEN | DT hisi_femac0 / mdio0, vendor U-Boot hisfv300 (REG_BASE_SF) |
        | 0x10030000 | 0x1003FFFF | SATA AHCI controller (+0x100 port 0); PHY in the same window | PROVEN | DT ahci/sata_phy, phy-hi3536dv100-sata.c |
        | 0x10300000 | 0x1030FFFF | GIC (distributor +0x1000, CPU interface +0x2000) | PROVEN | DT gic |
        | 0x11000000 | 0x1100FFFF | USB 2.0 OHCI | PROVEN | DT ohci, U-Boot HIUSB_OHCI_BASE |
        | 0x11010000 | 0x1101FFFF | USB 2.0 EHCI | PROVEN | DT ehci |
        | 0x11020000 | 0x1102FFFF | DMAC (PL080 style, channels at +0x100 + n x 0x20) | PROVEN | DT hidmac, hidmac_hi3536dv100.h |
        | 0x11030000 | 0x1103FFFF | CIPHER (8-channel, same layout as the Hi3520D) | PROVEN | vendor cipher_reg.h (REG_CI_BASE_ADDR_PHY), DT cipher |
        | 0x12000000 | 0x1203FFFF | Timers 0-7 (SP804, four dual timers 0x10000 apart) | PROVEN | platform.h TIMERn_REG_BASE, DT dual_timer0-3 |
        | 0x12040000 | 0x1204FFFF | CRG | PROVEN | platform.h CRG_REG_BASE |
        | 0x12050000 | 0x1205FFFF | SYS_CTRL (SC_CTRL 0x0, SC_SYSRES 0x4, SYSSTAT 0x8C, SC_GEN0-4 0x138-0x148, SC_SYSID0 0xEE0) | PROVEN | platform.h, lowlevel_init_v300.c |
        | 0x12070000 | 0x1207FFFF | WDG (SP805) | PROVEN | platform.h WDG_REG_BASE, hi_wdt.c |
        | 0x12080000 | 0x120AFFFF | UART0-2 (PL011) | PROVEN | platform.h, DT |
        | 0x120B0000 | 0x120BFFFF | RTC: SPI-bridged macro, APB part SPI_CLK_DIV 0x0 and SPI_RW 0x4 (`RTC`); the internal register map behind the bridge is the shared `eHISI_RTC_SPI_INTERNAL_V3` map (no CPU address, not instantiated) | PROVEN (base, APB registers and internal map: data sheet 00B04 section 3.10; vendor hibvt driver) | DT rtc, platform.h RTC_REG_BASE, data sheet |
        | 0x120C0000 | 0x120CFFFF | I2C0 (hibvt-i2c) | PROVEN (base), layout not modelled | DT i2c_bus0 |
        | 0x120E0000 | 0x120EFFFF | PWM (core/CPU voltage regulator control for SVB) | PROVEN (base), not modelled | lowlevel_init_v300.c: PWM_REG_BASE 0x120e0000, CPU_VOL_REG +4 |
        | 0x120F0000 | 0x120FFFFF | IO_CONFIG: pin mux (0x000-0x3A8) and pad control (0x800-0x8F4) | PROVEN (base and ranges); modelled from the pin-out workbook (muxctrl_reg0-46, padctrl_reg0-61) | reg_info, DT pmux, Hi3536DV100_PINOUT_EN.xlsx |
        | 0x12110000 | 0x1211FFFF | DDRC: AXI/QoS ports at 0x12110000+, DDR QoS buffer 0x12114000, DMC 0x12118000, DDR PHY 0x1211C000 | PROVEN (bases), not modelled | reg_info, lowlevel_init_v300.c |
        | 0x12120000 | 0x1212FFFF | MISC_CTRL (DDR master priorities 0x78-0x94, USB 0x50/0x54, FEPHY 0x64, SATA PHY 0x58, HPM data 0x12122000) | PROVEN (base), not modelled | platform.h, demb.dts sysctrl-ddr,pins, lowlevel_init_v300.c |
        | 0x12140000 | 0x1214FFFF | IR receiver | PROVEN | hiir.c IR_REG_BASE |
        | 0x12150000 | 0x121AFFFF | GPIO0-5 (PL061, 0x10000 apart) | PROVEN | data sheet address map and interrupt table (GPIO0-5 only; 0x121B0000-0x1222FFFF reserved), DT; the vendor U-Boot platform.h defines GPIO6-13 but they do not exist |
        | 0x13000000 | 0x1303FFFF | HDMI TX (HDMI v2 hisiv100 core): ctrl 0x13000000, video path +0x800, audio path +0x1000, HDMI core +0x1800, HDCP1 +0x2000, AON +0x4000, CEC +0x4800, MCU (8051) +0x1C000 (modelled, function inferred), digital PHY 0x13030000, colour-bar generator 0x1302C400 | PROVEN (bases, register layouts from the vendor HDMI v2 register headers), INFERRED (access types) | vendor U-Boot hdmi_v2 drv/hal/ctrl/hisiv100/regs and phy regs, hdmi_product_define.h, hi3536dv100_hdmi.ko |
        | 0x13020000 | 0x1302FFFF | VOU (video output unit, 4K, HDMI) | PROVEN (base, IRQ), layout not modelled | DT vou, open_vou |
        | 0x13040000 | 0x1304FFFF | AIAO (audio interface) | PROVEN (base), layout not modelled | DT audio, open_aio; acodec at 0x130500D0 |
        | 0x13100000 | 0x1310FFFF | VGS (video graphics scaler) | PROVEN (base, IRQ), registers from hi3536dv100_vgs.ko disassembly (vgs.rdl) | DT vgs, data sheet table 3-8 |
        | 0x13110000 | 0x1311FFFF | JPGD (JPEG decoder) | PROVEN (base) | DT jpgd, open_jpegd; register layout = HISI_JPGD of the Hi3520D, checked against the SDK libjpeg6b.so (2026-11-22) |
        | 0x13120000 | 0x1312FFFF | JPGE (JPEG encoder) | PROVEN (base) | DT jpege, open_jpege |
        | 0x13130000 | 0x1313FFFF | TDE (2D engine) | PROVEN (base) | DT tde, open_tde TdeHalInit |
        | 0x13200000 | 0x1320BFFF | VDH (video decoder, H.264/H.265, V400R001 HAL) | PROVEN (base, IRQ, offsets used by the module), names INFERRED from V400R004 (vdh.rdl) | DT vdec vdm window, hi3536dv100_vfmw.ko OpenHAL |
        | 0x1320C000 | 0x1320FFFF | SCD (start code detector) top registers (+0x4 EMAR_ID) and SCD registers at +0x800 | PROVEN (offsets), INFERRED (names) | hi3536dv100_vfmw.ko SM_OpenSCDDrv, WriteScdVtrlReg |
        | 0x14000000 | 0x14FFFFFF | FMC memory (16 MiB flash window) | PROVEN | platform.h FMC_MEM_BASE |
        | 0x80000000 | 0x9FFFFFFF | DDR (512 MiB max, 2 Gbit x4) | PROVEN | platform.h DDR_MEM_BASE, demb.dts memory |

        <!-- overview:begin -->

        ### Diagrams

        ![Logic block diagram](assets/diagrams/hi3536dv100-logic.svg)

        ![Register blocks by function](assets/diagrams/hi3536dv100-blocks.svg)

        ![Clock tree](assets/diagrams/hi3536dv100-clocks.svg)

        ![Boot flow](assets/diagrams/hi3536dv100-boot.svg)

        ![Video pipeline](assets/diagrams/hi3536dv100-video.svg)

        ![Interrupt topology](assets/diagrams/hi3536dv100-irq.svg)

        ![Reset tree](assets/diagrams/hi3536dv100-resets.svg)

        ![CRG register map](assets/diagrams/hi3536dv100-crgmap.svg)

        ![bus clock domains](assets/diagrams/hi3536dv100-bus.svg)

        ![IP edition per chip](assets/diagrams/hi3536dv100-family.svg)

        ### Chip ID

        | Chip | System controller ID registers (0xEE0 .. 0xEEC) | Value read as SC_SYSID |
        |---|---|---|
        | hi3536dv100 | SYSID0..3 reset values from the RDL | 0x3536D100 (data sheet 3.5.3; the RDL has no reset value for the lowest ID byte, SCSYSID0) |

        The four 8-bit registers form the 32-bit chip ID (SYSID3 is the most significant byte). The values are the reset values of the register descriptions: one data sheet documents one ID for all chips it covers, so the chips of a shared data sheet are not distinguished here (the real value of each variant is not stated).

        ### Key specifications (data sheet chapter 1, Issue 00B04, 2017-12-13)

        The data sheet covers the Hi3536D V100 H.265/H.264 decoder processor (a decode-only NVR chip; the Hi3536C V100 has no separate data sheet in the workspace). SC_SYSID reads 0x3536D100.

        | | Hi3536D V100 |
        |---|---|
        | CPU | one Cortex-A7, 850 MHz, NEON and FPU; 32 KB L1 I + 32 KB L1 D, 128 KB L2 (8-way, 64-byte lines), 128-bit ACE bus interface, GIC with 96 sources (64 external) |
        | DDR | one 16-bit DDR3/DDR3L controller, up to 800 MHz, ODT, up to 512 MB |
        | Decode | H.265 Main Profile L4.1, H.264 BP/MP/HP L4.2, MJPEG/JPEG baseline decode; JPEG baseline encode |
        | Performance | 4x1080p@20 H.265/H.264 decode; 4x960p (1280x960)@30 H.265/H.264 decode; 4x720p@30 JPEG decode |
        | Video output | one HDMI 1.4b, one VGA (same source, up to 1080p@60); one HD video layer with 16-picture output, one HD PIP layer, one ARGB1555/ARGB8888 graphics layer, one 256x256 hardware cursor |
        | Image processing | sharpen/contrast, 1/15x to 16x video scaling, 1/2x to 2x graphics scaling, cover regions, OSD overlay (VGS, TDE) |
        | Audio | two unidirectional I2S/PCM (1 in, 1 out), integrated audio DAC (48/44.1/32 kHz, stereo line out); audio codecs in software |
        | Network | one fast Ethernet MAC with integrated FE PHY (PHY/RMII/MII, 10/100, TSO) |
        | Peripherals | one SATA 2.0 (port multiplier, eSATA), 2 USB 2.0 host, 3 UART (one 4-wire), IR, I2C, GPIO0-5, DMAC (4 channels), CIPHER (AES/DES/3DES), RTC with separate battery supply |
        | Flash | SPI NOR/NAND on the FMC: 1/2/4 wire, 2 chip selects (64 MB each NOR, 512 MB each SPI NAND, 2/4 KB pages, 8/16/24/28 bit per KB ECC), 4 KB BOOTROM, 32 KB on-chip RAM (implemented, memory map) |
        | SDK | Linux 4.9 based |
        | Package | TFBGA, 13 x 13 mm, 0.65 mm pitch, 143 I/O pins; 1.6 W typical; core 1.1 V, CPU 1.26 V, I/O 3.3 V, DDR3 1.5 V / DDR3L 1.35 V; 0 to 70 C |

        ### Boot (data sheet 1.3, Table 1-1)

        | BOOTROM_SEL | Boot mode |
        |---|---|
        | 1 | BOOTROM: serial download over the UART (HiBurn tool); if the serial link times out the chip boots from the external SPI NOR/NAND flash |
        | 0 | external SPI NOR or SPI NAND flash on the FMC |

        BOOTROM_SEL is multiplexed with pin MDCK. There is no second strap (the Hi3535 has BOOT_SEL1/BOOT_SEL0 for NAND and PCIe slave mode). Diagram: boot flow.

        ### Memory map notes (data sheet 1.3, Table 1-2)

        * 0x00000000-0x03FFFFFF (64 MB): boot address space while the remap is active, on-chip RAM after the remap is cleared. BOOTROM window 0x04000000 (4 KB implemented), RAM window 0x04010000 (32 KB implemented).
        * SFC (FMC) NAND/NOR memory window 0x14000000-0x14FFFFFF (16 MB); FMC registers 0x10000000.
        * DDR: 0x80000000-0xFFFFFFFF (2 GB window, 512 MB maximum device).
        * AHB peripherals: ETH 0x10010000, SATA 0x10030000, USB OHCI 0x11000000, EHCI 0x11010000, DMAC 0x11020000, CIPHER 0x11030000; APB blocks 0x12000000-0x121A0000 (timers 0x12000000-0x1203FFFF, CRG 0x12040000, system controller 0x12050000, WDG, UART0-2, RTC, I2C, PMC, pin mux 0x120F0000 / pin control 0x120F0800, DDRT, DDRC, peripheral control 0x12120000, IR 0x12140000, GPIO0-5 0x12150000-0x121A0000); video/audio blocks 0x13000000-0x13200000 (HDMI, VDP, HDMI PHY, AIAO, AUDIO codec, VGS, JPGD, JPGE, TDE, VDH 0x13200000).
        * The interrupt controller is a GIC (the RDL instance GIC models the ARM GIC-400 style block).

        ### DMA request lines (data sheet 3.6, Table 3-11)

        One DMAC (PL080-style, block DMAC at 0x11020000, interrupt 46): 4 channels with fixed priority (channel 0 highest), 2 AHB masters, 16 hardware request lines, burst and single requests per peripheral, LLI support. The request-line numbers are written into src_periph / dest_periph of DMAC_Cn_CONFIG.

        | Line | Peripheral | Line | Peripheral |
        |---|---|---|---|
        | 0 | UART0 RX | 6 | I2C RX |
        | 1 | UART0 TX | 7 | I2C TX |
        | 2 | UART1 RX | 8-15 | Reserved |
        | 3 | UART1 TX | | |
        | 4 | UART2 RX | | |
        | 5 | UART2 TX | | |

        Memory has no request line. Idle cycles are inserted after each bus operation on channels 2 and 3, so memory-to-memory transfers should use those channels.

        ### Pin multiplexing summary (IO_CONFIG at 0x120F0000)

        Generated from the pin mux registers of this description (register offsets are relative to the block base; the function lists are the value-ordered choices of each register). Pads that repeat a pattern in consecutive registers are merged into one row.

        | Pads | Mux register (offset from 0x120F0000) | Function choices (value 0, 1, ...) |
        |---|---|---|
        | VGA_HS | muxctrl_reg0 @0x000 | 0=GPIO2_4 / 1=VGA_HS |
        | VGA_VS | muxctrl_reg1 @0x004 | 0=GPIO2_5 / 1=VGA_VS |
        | PWM_SVB_CORE | muxctrl_reg2 @0x008 | 0=PWM_SVB_CORE / 1=GPIO2_6 |
        | PWM_SVB_CPU | muxctrl_reg3 @0x00C | 0=PWM_SVB_CPU / 1=GPIO2_7 |
        | PWM_FREE | muxctrl_reg4 @0x010 | 0=GPIO5_7 / 1=PWM_FREE |
        | I2C_SDA | muxctrl_reg5 @0x014 | 0=GPIO3_0 / 1=I2C_SDA |
        | I2C_SCL | muxctrl_reg6 @0x018 | 0=GPIO3_1 / 1=I2C_SCL |
        | UART1_RXD | muxctrl_reg7 @0x01C | 0=GPIO4_0 / 1=UART1_RXD |
        | UART1_TXD | muxctrl_reg8 @0x020 | 0=GPIO4_1 / 1=UART1_TXD |
        | UART1_RTSN | muxctrl_reg9 @0x024 | 0=GPIO4_2 / 1=UART1_RTSN |
        | UART1_CTSN | muxctrl_reg10 @0x028 | 0=GPIO4_3 / 1=UART1_CTSN |
        | UART2_RXD | muxctrl_reg11 @0x02C | 0=GPIO4_4 / 1=UART2_RXD |
        | UART2_TXD | muxctrl_reg12 @0x030 | 0=GPIO4_5 / 1=UART2_TXD |
        | ETH_LINK_LED | muxctrl_reg13 @0x034 | 0=GPIO4_6 / 1=ETH_LINK_LED |
        | ETH_SPD_LED | muxctrl_reg14 @0x038 | 0=GPIO4_7 / 1=ETH_SPD_LED |
        | IR_IN | muxctrl_reg15 @0x03C | 0=GPIO3_2 / 1=IR_IN |
        | JTAG_TRSTN | muxctrl_reg16 @0x040 | 0=GPIO5_0 / 1=I2S_SD_RX |
        | JTAG_TCK | muxctrl_reg17 @0x044 | 0=GPIO5_1 / 1=I2S_MCLK |
        | JTAG_TMS | muxctrl_reg18 @0x048 | 0=GPIO5_2 / 1=I2S_WS |
        | JTAG_TDO | muxctrl_reg19 @0x04C | 0=GPIO5_3 / 1=I2S_BCLK |
        | JTAG_TDI | muxctrl_reg20 @0x050 | 0=GPIO5_4 / 1=I2S_SD_TX |
        | USB2_PWREN0 ... USB2_PWREN1 (2) | muxctrl_reg21 ... muxctrl_reg22 @0x054 ... 0x058 | 0=GPIO5_5 / 1=USB2_PWREN0 (first pad; others the same pattern with the pad's own number) |
        | HDMI_HOTPLUG | muxctrl_reg23 @0x05C | 0=GPIO3_3 / 1=HDMI_HOTPLUG |
        | HDMI_SDA | muxctrl_reg24 @0x060 | 0=GPIO3_4 / 1=HDMI_SDA |
        | HDMI_SCL | muxctrl_reg25 @0x064 | 0=GPIO3_5 / 1=HDMI_SCL |
        | SATA_LED_N | muxctrl_reg26 @0x068 | 0=GPIO3_6 / 1=SATA_LED_N |
        | GPIO0_0 | muxctrl_reg27 @0x06C | 0=GPIO0_0 / 1=MII_RXDV |
        | GPIO0_1 | muxctrl_reg28 @0x070 | 0=GPIO0_1 / 1=MII_RXD3 / 2=I2S_WS |
        | GPIO0_2 | muxctrl_reg29 @0x074 | 0=GPIO0_2 / 1=MII_RXD2 |
        | GPIO0_3 | muxctrl_reg30 @0x078 | 0=GPIO0_3 / 1=MII_RXD1 / 2=I2S_BCLK |
        | GPIO0_4 | muxctrl_reg31 @0x07C | 0=GPIO0_4 / 1=MII_RXD0 / 2=I2S_MCLK |
        | GPIO0_5 | muxctrl_reg32 @0x080 | 0=GPIO0_5 / 1=MII_RXCK |
        | GPIO0_6 | muxctrl_reg33 @0x084 | 0=GPIO0_6 / 1=MII_TXEN |
        | GPIO0_7 ... GPIO1_0 (2) | muxctrl_reg34 ... muxctrl_reg35 @0x088 ... 0x08C | 0=GPIO0_7 / 1=MII_TXD3 (first pad; others the same pattern with the pad's own number) |
        | GPIO1_1 | muxctrl_reg36 @0x090 | 0=GPIO1_1 / 1=MII_TXD1 / 2=I2S_SD_RX |
        | GPIO1_2 | muxctrl_reg37 @0x094 | 0=GPIO1_2 / 1=MII_TXD0 / 2=I2S_SD_TX |
        | GPIO1_3 | muxctrl_reg38 @0x098 | 0=GPIO1_3 / 1=MII_TXCK / 2=RMII_CLK |
        | GPIO1_4 | muxctrl_reg39 @0x09C | 0=GPIO1_4 / 1=MII_CRS |
        | GPIO1_5 | muxctrl_reg40 @0x0A0 | 0=GPIO1_5 / 1=MII_COL |
        | GPIO1_6 | muxctrl_reg41 @0x0A4 | 0=GPIO1_6 / 1=MII_RXER |
        | GPIO1_7 | muxctrl_reg42 @0x0A8 | 0=GPIO1_7 / 1=MII_TXER |
        | GPIO2_0 | muxctrl_reg43 @0x0AC | 0=TEST_CLK / 1=EPHY_CLK / 2=GPIO2_0 |
        | GPIO2_1 | muxctrl_reg44 @0x0B0 | 0=GPIO2_1 / 1=EPHY_RSTN |
        | MDCK | muxctrl_reg45 @0x0B4 | 0=GPIO2_2 / 1=MDCK |
        | MDIO | muxctrl_reg46 @0x0B8 | 0=GPIO2_3 / 1=MDIO |

        The Hi3536D data sheet has no pin multiplexing register tables (they are in a separate pin-out workbook, per the data sheet); the function lists above come from that workbook as recorded in the RDL (PROVEN: pin-out workbook sheet 3, field width INFERRED).

        Pad drive-strength and pull controls are in the separate pad control registers of the same description (not repeated here).

        ### Power, reset and clock modes (data sheet 3.1, 3.2, 3.12)

        * Resets: npor from the RSTN pin or the internal POR module (low pulse above 12 XIN cycles, XIN stable); global soft reset sys_rst_n from the system controller (the reset is released at least 131 ms after the request, and a second request within 131 ms leaves the system in an undefined state); per-module soft resets xx_rst_n from the CRG, hold-until-cleared. Diagram: reset tree.
        * Clock selects after power-on: A7/DDR/bus run from the 24 MHz crystal; PLLs may be reprogrammed only in that state (stable after 0.1 ms; lock bits PERI_CRG52[5:0]).
        * A7/DDR/bus selects: PERI_CRG20 a7_sc_sel [7:6], ddr_sc_sel [5:4], sysbus_sc_sel [3:2], mdaapb_sc_sel [1], sysapb_sc_sel [0].
        * Module power control (3.12.3): USB 2.0 host clock PERI_CRG47 bit 0 = 0, SATA PHY clock PERI_CRG44 bit 0 = 0, unused VDAC channels (VDP registers), PLL power-down bits in PERI_CRG_PLLn. DDR: self-refresh through DDRC_CTRL_SREF.sr_seq, frequency changes under self-refresh. PMC (0x120E0000) is the power-management block.
        * The data sheet has no separate power-domain table.

        ### Interrupts (Cortex-A7 GIC interrupt IDs, data sheet Table 3-8, Issue 00B04); Reserved rows kept, IDs 0-31 are private to the A7

        The ID is the GIC interrupt number (SPI number + 32).

        | # | Source | # | Source | # | Source |
        |---|---|---|---|---|---|
        | 0-31 | For internal use of the A7 | 49 | SATA | 70 | DDRT |
        | 32 | Watchdog | 50 | USB2_OHCI | 71 | DDRC_ERR_INT |
        | 33 | Timer0/Timer1 | 51 | USB2_EHCI | 72 | SOFTWARE_INT |
        | 34 | Timer2/Timer3 | 52 | Reserved | 73 | Reserved |
        | 35 | Timer4/Timer5 | 53 | VDH_NORM_INT | 74 | FEPHY_INT |
        | 36 | Timer6/Timer7 | 54 | Reserved | 75-83 | Reserved |
        | 37 | RTC | 55 | VDH_SCD_NORM_INT | 84 | A7_COMMTX |
        | 38 | UART0 | 56-59 | Reserved | 85 | A7_COMMRX |
        | 39 | UART1 | 60 | VGS | 86 | A7_PMUIRQ |
        | 40 | UART2 | 61 | TDE | 87 | GPIO0 |
        | 41 | IR | 62 | JPGE | 88 | GPIO1 |
        | 42 | I2C | 63 | JPGD | 89 | GPIO2 |
        | 43 | ETH | 64 | AIAO | 90 | GPIO3 |
        | 44 | Reserved | 65 | Reserved | 91 | GPIO4 |
        | 45 | CIPHER | 66 | VDP0 | 92 | GPIO5 |
        | 46 | DMAC | 67 | VDP1 | 93-95 | Reserved |
        | 47 | FMC | 68 | HDMI_TX_AON |  |  |
        | 48 | Reserved | 69 | HDMI_TX_PWD |  |  |

        ### Clock-gate and reset map (generated from the CRG registers)

        | Offset | Register | Description | Gate / reset fields |
        |---|---|---|---|
        | 0x084 | PERI_CRG33 | PERI_CRG33 | ddr_apb_cken, ddr_hipack_cken, ddr_cfg_cken, ddr_apb_srst_req, ddr_hipack_srst_req |
        | 0x088 | PERI_CRG34 | PERI_CRG34 | vo_srst_req, hd_dac_cken, vou_hcken, vou_hd0_cken, vou_cken |
        | 0x08C | PERI_CRG35 | PERI_CRG35 | ssc_in_cken, ssc_bypass_cken, hdmitx_ctrl_osc_24m_cken, hdmitx_ctrl_bus_srst_req, hdmitx_ctrl_srst_req, hdmitx_ssc_srst_req, hdmitx_pxl_cken |
        | 0x090 | PERI_CRG36 | PERI_CRG36 | phy_tmds_cken, hdmitx_phy_srst_req, phy_tmds_srst_req |
        | 0x094 | PERI_CRG37 | PERI_CRG37 | tde_srst_req, tde_cken |
        | 0x098 | PERI_CRG38 | PERI_CRG38 | vgs_srst_req, vgs_cken |
        | 0x09C | PERI_CRG39 | PERI_CRG39 | jpge_srst_req, jpge_cken |
        | 0x0A0 | PERI_CRG40 | PERI_CRG40 | jpgd_srst_req, jpgd_cken |
        | 0x0A4 | PERI_CRG41 | PERI_CRG41 | vdh_cken, vdh_mfd_srst_req, vdh_scd_srst_req, vdh_all_srst_req |
        | 0x0A8 | PERI_CRG42 | PERI_CRG42 | cipher_srst_req, cipher_cken |
        | 0x0AC | PERI_CRG43 | PERI_CRG43 | aiao_srst_req, aiao_cken, codec_srst_req, codec_cken |
        | 0x0B0 | PERI_CRG44 | PERI_CRG44 | sataphy0_ref_cken, sataphy0_lane_srst_req |
        | 0x0B4 | PERI_CRG45 | PERI_CRG45 | sata_bus_cken, sata_rx0_cken, sata_cko_alive_cken, sata_tx0_cken, sata_bus_srst_req, sata_cko_alive_srst_req, sata_rx0_srst_req, sata0_srst_req |
        | 0x0B8 | PERI_CRG46 | PERI_CRG46 | usb2_bus_cken, usb2_ohci48m_cken, usb2_ohci12m_cken, usb2_hst_phy_cken, usb2_utmi0_cken, usb2_utmi1_cken, usb2_bus_srst_req, usb2_utmi0_srst_req, usb2_utmi1_srst_req, usb2_hst_phy_srst_req |
        | 0x0BC | PERI_CRG47 | PERI_CRG47 | usb2_phy_cken, usb2_phy_test_srst_req |
        | 0x0C0 | PERI_CRG48 | PERI_CRG48 | fmc_srst_req, fmc_cken |
        | 0x0C4 | PERI_CRG49 | PERI_CRG49 | hrst_eth_s, eth_cken, ext_fephy_srst_req, int_fephy_srst_req, int_fephy_cken |
        | 0x0C8 | PERI_CRG50 | PERI_CRG50 | ddrtest_srst_req, ddrtest_cken, dmac_srst_req, dmac_cken |
        | 0x0CC | PERI_CRG51 | PERI_CRG51 | test_clk_en, i2c_srst_req, rtc_srst_req, ir_srst_req, uart0_srst_req, uart1_srst_req, uart2_srst_req, ir_cken, uart0_cken, uart1_cken, ... |
        | 0x0F4 | PERI_CRG_PLL61 | PERI_CRG_PLL61 | vdh_scd_rst_ok, vdh_mfd_rst_ok, vdh_all_rst_ok |

        Only fields whose names contain a clock-enable or reset keyword are listed; the field descriptions in the register pages give the polarity and the clocks they gate.

        ### Register blocks (generated from this description)

        | Base | Instance | Block | Register space |
        |---|---|---|---|
        | 0x10000000 | FMC | HiSilicon flash memory controller v100 (SPI NOR / SPI NAND) | 224 B |
        | 0x10010000 | ETH | HiSilicon femac v2 Fast Ethernet MAC with MDIO | 5184 B |
        | 0x10030000 | SATA | SATA AHCI 1.3 controller (one port), Hi3536D V100 | 384 B |
        | 0x10300000 | GIC | Generic interrupt controller (ARM GIC-400, GICv2) | 12292 B |
        | 0x11000000 | OHCI | HiSilicon USB 2.0 host controller - OHCI | 92 B |
        | 0x11010000 | EHCI | HiSilicon USB 2.0 host controller - EHCI | 176 B |
        | 0x11020000 | DMAC | HiSilicon DMA controller (PL080-compatible, 4 or 8 channels) | 384 B |
        | 0x11030000 | CIPHER | CIPHER (8 channels) | 5184 B |
        | 0x12000000 | TIMER0 | Timer Registers | 28 B |
        | 0x12000020 | TIMER1 | Timer Registers | 28 B |
        | 0x12010000 | TIMER2 | Timer Registers | 28 B |
        | 0x12010020 | TIMER3 | Timer Registers | 28 B |
        | 0x12020000 | TIMER4 | Timer Registers | 28 B |
        | 0x12020020 | TIMER5 | Timer Registers | 28 B |
        | 0x12030000 | TIMER6 | Timer Registers | 28 B |
        | 0x12030020 | TIMER7 | Timer Registers | 28 B |
        | 0x12040000 | CRG | Clock and reset generator (CRG), Hi3536D V100 | 248 B |
        | 0x12050000 | SYS_CTRL | System controller (SC), Hi3536D V100 | 3824 B |
        | 0x12070000 | WDG | Watchdog Registers | 3076 B |
        | 0x12080000 | UART0 | UART (ARM PrimeCell PL011) | 4 KB |
        | 0x12090000 | UART1 | UART (ARM PrimeCell PL011) | 4 KB |
        | 0x120A0000 | UART2 | UART (ARM PrimeCell PL011) | 4 KB |
        | 0x120E0000 | PMC | Power management control (PMC / PWM + HPM) registers, Hi3536D V100 | 300 B |
        | 0x120F0000 | IO_CONFIG | IO_CONFIG pin multiplexing (0x000) and pad control (0x800), Hi3536D V100 | 2296 B |
        | 0x12110000 | DDRC_AXI | DDRC AXI bus interface registers, Hi3536D V100 | 1888 B |
        | 0x12114000 | DDRC_QOSB | DDRC QoS buffer registers, Hi3536D V100 | 508 B |
        | 0x12118000 | DDRC_DMC | DDRC DMC registers (DMC0), Hi3536D V100 | 516 B |
        | 0x1211C000 | DDRC_PHY | DDR PHY registers, Hi3536D V100 | 116 B |
        | 0x12120000 | MISC_CTRL | Peripheral control (MISC) incl. USB 2.0 PHY and FE PHY trim, Hi3536D V100 | 33804 B |
        | 0x12140000 | IR | HiSilicon IR receiver | 56 B |
        | 0x12150000 | GPIO0 | ARM PL061 | 1053 B |
        | 0x12160000 | GPIO1 | ARM PL061 | 1053 B |
        | 0x12170000 | GPIO2 | ARM PL061 | 1053 B |
        | 0x12180000 | GPIO3 | ARM PL061 | 1053 B |
        | 0x12190000 | GPIO4 | ARM PL061 | 1053 B |
        | 0x121A0000 | GPIO5 | ARM PL061 | 1053 B |
        | 0x13000000 | HDMI_CTRL | HDMI TX ctrl, Hi3536D V100 / HDMI v2 (hisiv100) | 308 B |
        | 0x13000800 | HDMI_VIDEO | HDMI TX video_path, Hi3536D V100 / HDMI v2 (hisiv100) | 428 B |
        | 0x13001000 | HDMI_AUDIO | HDMI TX audio_path, Hi3536D V100 / HDMI v2 (hisiv100) | 84 B |
        | 0x13001800 | HDMI_TX | HDMI TX tx, Hi3536D V100 / HDMI v2 (hisiv100) | 616 B |
        | 0x13002000 | HDMI_HDCP | HDMI TX hdcp, Hi3536D V100 / HDMI v2 (hisiv100) | 252 B |
        | 0x13004000 | HDMI_AON | HDMI TX aon, Hi3536D V100 / HDMI v2 (hisiv100) | 100 B |
        | 0x13004800 | HDMI_CEC | HDMI TX cec, Hi3536D V100 / HDMI v2 (hisiv100) | 104 B |
        | 0x1301C000 | HDMI_MCU | HDMI TX mcu, Hi3536D V100 / HDMI v2 (hisiv100) | 960 B |
        | 0x13020000 | VOU | Video output unit (VDP), HD/SD display, graphics, interfaces, Hi3536D V100 | 62152 B |
        | 0x13030000 | HDMI_DPHY | HDMI TX dphy, Hi3536D V100 / HDMI v2 (hisiv100) | 192 B |
        | 0x13040000 | AIAO | Audio interface (AIAO), Hi3536D V100 | 8880 B |
        | 0x13050000 | ACODEC | Integrated audio DAC/CODEC, Hi3536D V100 | 216 B |
        | 0x13100000 | VGS | VGS video graphics scaler, Hi3536D V100 | 1032 B |
        | 0x13110000 | JPGD | HiSilicon JPEG decoder (Hi3520D layout, matches the Hi3536D SDK libjpeg6b.so) | 1728 B |
        | 0x13120000 | JPGE | HiSilicon JPEG encoder (JPGE, r004 register layout) | 4288 B |
        | 0x13130000 | TDE | HiSilicon TDE, Hi3516A/D and Hi3518E V200 / Hi3516C V200 generation (vendor-derived) | 2160 B |
        | 0x13140000 | TDE_NODE | TDE G2 job node layout (DDR, NOT hardware), Hi3536D V100 | 168 B |
        | 0x13150000 | VGS_IMG | VGS job image layout (placeholder window, NOT hardware) | 1628 B |
        | 0x13200000 | VDH | VDH video decoder, V400R001 generation (H.264 / H.265), Hi3536D V100 | 47184 B |
        | 0x1320C000 | VDH_TOP | VDH top / SCD glue registers (0x1320C000 window), Hi3536D V100 | 16 B |
        | 0x1320C800 | SCD | HiSilicon SCD start-code detector, second generation (Hi3516A V300 layout: interrupt test in SCD_OVER, reset through PERI_CRG41 bit 5; vendor-derived, UNVERIFIED on hardware) | 96 B |
        | 0x13210000 | VDH_MSG | VDH HEVC DDR message layouts (placeholder window, NOT hardware) | 8208 B |

        The table is generated from the elaborated root (instances at their absolute addresses; register space is the span of the block's registers, not the data sheet window).

        <!-- overview:end -->
    ";

    eHI3536D_CRG        CRG             @ 0x12040000;
    eHI3536D_SYS_CTRL   SYS_CTRL        @ 0x12050000;
    eHI3536D_PMC        PMC             @ 0x120E0000;
    eHI3536D_DDRC_AXI   DDRC_AXI        @ 0x12110000;
    eHI3536D_DDRC_QOSB  DDRC_QOSB       @ 0x12114000;
    eHI3536D_DDRC_DMC   DDRC_DMC        @ 0x12118000;
    eHI3536D_DDRC_PHY   DDRC_PHY        @ 0x1211C000;
    eHI3536D_IO_CONFIG  IO_CONFIG       @ 0x120F0000;
    eHI3536D_MISC_CTRL  MISC_CTRL       @ 0x12120000;
    eHI3536D_HDMI_ctrl       HDMI_CTRL       @ 0x13000000;
    eHI3536D_HDMI_video_path HDMI_VIDEO      @ 0x13000800;
    eHI3536D_HDMI_audio_path HDMI_AUDIO      @ 0x13001000;
    eHI3536D_HDMI_tx         HDMI_TX         @ 0x13001800;
    eHI3536D_HDMI_hdcp       HDMI_HDCP       @ 0x13002000;
    eHI3536D_HDMI_aon        HDMI_AON        @ 0x13004000;
    eHI3536D_HDMI_cec        HDMI_CEC        @ 0x13004800;
    eHI3536D_HDMI_mcu        HDMI_MCU        @ 0x1301C000;
    eHI3536D_HDMI_dphy       HDMI_DPHY       @ 0x13030000;
    eHI3536D_VOU        VOU             @ 0x13020000;
    eHI3536D_AIAO       AIAO            @ 0x13040000;
    eHI3536D_ACODEC     ACODEC          @ 0x13050000;
    eHISI_FMC           FMC             @ 0x10000000;
    eHISI_FEMAC         ETH             @ 0x10010000;
    eHI3536D_SATA       SATA            @ 0x10030000;
    eARM_GIC400         GIC             @ 0x10300000;
    eHISI_USB_OHCI      OHCI            @ 0x11000000;
    eHISI_USB_EHCI      EHCI            @ 0x11010000;
    eHISI_DMAC          DMAC            @ 0x11020000;
    eHISI_CIPHER_MC     CIPHER          @ 0x11030000;
    eHISI_TIMER_SP804   TIMER0          @ 0x12000000;
    eHISI_TIMER_SP804   TIMER1          @ 0x12000020;
    eHISI_TIMER_SP804   TIMER2          @ 0x12010000;
    eHISI_TIMER_SP804   TIMER3          @ 0x12010020;
    eHISI_TIMER_SP804   TIMER4          @ 0x12020000;
    eHISI_TIMER_SP804   TIMER5          @ 0x12020020;
    eHISI_TIMER_SP804   TIMER6          @ 0x12030000;
    eHISI_TIMER_SP804   TIMER7          @ 0x12030020;
    eHISI_WDG_SP805     WDG             @ 0x12070000;
    eARM_PL011          UART0           @ 0x12080000;
    eARM_PL011          UART1           @ 0x12090000;
    eARM_PL011          UART2           @ 0x120A0000;
    eHISI_RTC_SPI_IF    RTC             @ 0x120B0000;
    eHISI_IR            IR              @ 0x12140000;
    eARM_PL061          GPIO0           @ 0x12150000;
    eARM_PL061          GPIO1           @ 0x12160000;
    eARM_PL061          GPIO2           @ 0x12170000;
    eARM_PL061          GPIO3           @ 0x12180000;
    eARM_PL061          GPIO4           @ 0x12190000;
    eARM_PL061          GPIO5           @ 0x121A0000;
    eHISI_JPGD          JPGD            @ 0x13110000;
    eHISI_JPGE          JPGE            @ 0x13120000;
    eHISI_TDE_G2        TDE             @ 0x13130000;
    aHI3536D_TDE_NODE   TDE_NODE        @ 0x13140000;
    eHI3536D_VGS        VGS             @ 0x13100000;
    aHI3536D_VGS_IMG    VGS_IMG         @ 0x13150000;
    eHI3536D_VDH        VDH             @ 0x13200000;
    eHI3536D_VDH_TOP    VDH_TOP         @ 0x1320C000;
    eHISI_SCD_AV300     SCD             @ 0x1320C800;
    aHI3536D_VDH_MSG    VDH_MSG         @ 0x13210000;
};
