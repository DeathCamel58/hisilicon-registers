`include "defines.rdl"

`include "../common/ARM_GIC400.rdl"
`include "../common/ARM_PL011.rdl"
`include "../common/ARM_PL061.rdl"
`include "../common/HISI_CIPHER_MC.rdl"
`include "../common/HISI_DMAC.rdl"
`include "../common/HISI_FEMAC.rdl"
`include "../common/HISI_FMC.rdl"
`include "../common/HISI_IR.rdl"
`include "../common/HISI_JPGD.rdl"
`include "../common/HISI_JPGE.rdl"
`include "../common/HISI_SCD.rdl"
`include "../common/HISI_TDE.rdl"
`include "../common/HISI_TIMER_SP804.rdl"
`include "../common/HISI_USB_HOST.rdl"
`include "../common/HISI_WDG_SP805.rdl"

// Chip-local blocks generated from the Hi3536D V100 data sheet (Issue 00B04).
`include "crg.rdl"
`include "sys_ctrl.rdl"
`include "misc_ctrl.rdl"
`include "pmc.rdl"
`include "ddrc.rdl"
`include "ddrc_qosb.rdl"
`include "ddrc_dmc.rdl"
`include "ddrc_phy.rdl"
`include "vou.rdl"
`include "aiao.rdl"
`include "acodec.rdl"
`include "io_config.rdl"
`include "hdmi_tx.rdl"
`include "vdh.rdl"
`include "vgs.rdl"
`include "vgs_img.rdl"
`include "sata.rdl"
`include "tde_node.rdl"

addrmap hi3536dv100 {
    name = "hi3536dv100 registers";
    desc = "
        ## Status

        Address map and block selection of the Hi3536D V100 (NVR decoder SoC, ARM Cortex-A7, H.264/H.265 decoder, 4K VO/HDMI, SATA, USB 2.0, FEMAC).
        The CRG, SYS_CTRL, MISC_CTRL, PMC, DDRC (AXI, QoS buffer, DMC, PHY), VOU, AIAO and ACODEC blocks were generated on 2026-11-11 and regenerated on 2026-11-15 (older extractor: lost field names, dropped fields, shifted descriptions) from the vendor Hi3536D V100 data sheet (Issue 00B04, 2017-12-13; see each file); everything else below was established without it from vendor code (SDK 2.0.2.0 U-Boot, the Linux 4.9.37 device tree
        and drivers, the closed MPP kernel modules disassembled statically) and from firmware images. Nothing was verified on hardware. Each row of the table and each
        instance carries a confidence label: PROVEN (address or offset appears literally in vendor code or the vendor device tree), INFERRED (a layout taken from the
        same IP on another chip because offsets or behavior agree), GUESS (nothing but a name). Blocks whose register layout is unknown are not instantiated.

        Instances: blocks reused from other chips are PROVEN for the base address and INFERRED for the register layout unless the block description says otherwise
        (CIPHER and the SCD offsets were checked against vendor register tables and disassembly; see docs/research/hi3536dv100-blocks.md of the workspace).

        ## Addresses

        | Start Address | End Address | Description | Confidence | Evidence |
        |---------------|-------------|-------------|------------|----------|
        | 0x04000000 | 0x0400FFFF | BOOTROM | INFERRED | U-Boot start.S / reg_init: RAM_START_ADRS 0x04010500, STACK_TRAINING 0x04018000 (boot RAM) |
        | 0x10000000 | 0x1000FFFF | FMC (SPI NOR / SPI NAND controller) registers | PROVEN | vendor U-Boot FMC_REG_BASE, DT fmc reg |
        | 0x10010000 | 0x1001FFFF | FEMAC Ethernet MAC (MDIO at +0x1100, GLB at +0x1300) | PROVEN | DT hisi_femac0 / mdio0, vendor U-Boot hisfv300 (REG_BASE_SF) |
        | 0x10030000 | 0x1003FFFF | SATA AHCI controller (+0x100 port 0); PHY in the same window | PROVEN | DT ahci/sata_phy, phy-hi3536dv100-sata.c |
        | 0x10300000 | 0x1030FFFF | GIC (distributor +0x1000, CPU interface +0x2000) | PROVEN | DT gic |
        | 0x11000000 | 0x1100FFFF | USB 2.0 OHCI | PROVEN | DT ohci, U-Boot HIUSB_OHCI_BASE |
        | 0x11010000 | 0x1101FFFF | USB 2.0 EHCI | PROVEN | DT ehci |
        | 0x11020000 | 0x1102FFFF | DMAC (PL080 style, channels at +0x100 + n x 0x20) | PROVEN | DT hidmac, hidmac_hi3536dv100.h |
        | 0x11030000 | 0x1103FFFF | CIPHER (8-channel, same layout as the Hi3520D) | PROVEN | vendor cipher_reg.h (REG_CI_BASE_ADDR_PHY), DT cipher |
        | 0x12000000 | 0x1203FFFF | Timers 0-7 (SP804, four dual timers 0x10000 apart) | PROVEN | platform.h TIMERn_REG_BASE, DT dual_timer0-3 |
        | 0x12040000 | 0x1204FFFF | CRG | PROVEN | platform.h CRG_REG_BASE |
        | 0x12050000 | 0x1205FFFF | SYS_CTRL (SC_CTRL 0x0, SC_SYSRES 0x4, SYSSTAT 0x8C, SC_GEN0-4 0x138-0x148, SC_SYSID0 0xEE0) | PROVEN | platform.h, lowlevel_init_v300.c |
        | 0x12070000 | 0x1207FFFF | WDG (SP805) | PROVEN | platform.h WDG_REG_BASE, hi_wdt.c |
        | 0x12080000 | 0x120AFFFF | UART0-2 (PL011) | PROVEN | platform.h, DT |
        | 0x120B0000 | 0x120BFFFF | RTC (MPP rtc module) | PROVEN (base), layout GUESS | DT rtc, platform.h RTC_REG_BASE; not modelled |
        | 0x120C0000 | 0x120CFFFF | I2C0 (hibvt-i2c) | PROVEN (base), layout not modelled | DT i2c_bus0 |
        | 0x120E0000 | 0x120EFFFF | PWM (core/CPU voltage regulator control for SVB) | PROVEN (base), not modelled | lowlevel_init_v300.c: PWM_REG_BASE 0x120e0000, CPU_VOL_REG +4 |
        | 0x120F0000 | 0x120FFFFF | IO_CONFIG: pin mux (0x000-0x3A8) and pad control (0x800-0x8F4) | PROVEN (base and ranges); modelled from the pin-out workbook (muxctrl_reg0-46, padctrl_reg0-61) | reg_info, DT pmux, Hi3536DV100_PINOUT_EN.xlsx |
        | 0x12110000 | 0x1211FFFF | DDRC: AXI/QoS ports at 0x12110000+, DDR QoS buffer 0x12114000, DMC 0x12118000, DDR PHY 0x1211C000 | PROVEN (bases), not modelled | reg_info, lowlevel_init_v300.c |
        | 0x12120000 | 0x1212FFFF | MISC_CTRL (DDR master priorities 0x78-0x94, USB 0x50/0x54, FEPHY 0x64, SATA PHY 0x58, HPM data 0x12122000) | PROVEN (base), not modelled | platform.h, demb.dts sysctrl-ddr,pins, lowlevel_init_v300.c |
        | 0x12140000 | 0x1214FFFF | IR receiver | PROVEN | hiir.c IR_REG_BASE |
        | 0x12150000 | 0x121AFFFF | GPIO0-5 (PL061, 0x10000 apart) | PROVEN | data sheet address map and interrupt table (GPIO0-5 only; 0x121B0000-0x1222FFFF reserved), DT; the vendor U-Boot platform.h defines GPIO6-13 but they do not exist |
        | 0x13000000 | 0x1303FFFF | HDMI TX (HDMI v2 hisiv100 core): ctrl 0x13000000, video path +0x800, audio path +0x1000, HDMI core +0x1800, HDCP1 +0x2000, AON +0x4000, CEC +0x4800, MCU (8051) +0x1C000 (modelled, function inferred), digital PHY 0x13030000, colour-bar generator 0x1302C400 | PROVEN (bases, register layouts from the vendor HDMI v2 register headers), INFERRED (access types) | vendor U-Boot hdmi_v2 drv/hal/ctrl/hisiv100/regs and phy regs, hdmi_product_define.h, hi3536dv100_hdmi.ko |
        | 0x13020000 | 0x1302FFFF | VOU (video output unit, 4K, HDMI) | PROVEN (base, IRQ), layout not modelled | DT vou, open_vou |
        | 0x13040000 | 0x1304FFFF | AIAO (audio interface) | PROVEN (base), layout not modelled | DT audio, open_aio; acodec at 0x130500D0 |
        | 0x13100000 | 0x1310FFFF | VGS (video graphics scaler) | PROVEN (base, IRQ), registers from hi3536dv100_vgs.ko disassembly (vgs.rdl) | DT vgs, data sheet table 3-8 |
        | 0x13110000 | 0x1311FFFF | JPGD (JPEG decoder) | PROVEN (base) | DT jpgd, open_jpegd |
        | 0x13120000 | 0x1312FFFF | JPGE (JPEG encoder) | PROVEN (base) | DT jpege, open_jpege |
        | 0x13130000 | 0x1313FFFF | TDE (2D engine) | PROVEN (base) | DT tde, open_tde TdeHalInit |
        | 0x13200000 | 0x1320BFFF | VDH (video decoder, H.264/H.265, V400R001 HAL) | PROVEN (base, IRQ, offsets used by the module), names INFERRED from V400R004 (vdh.rdl) | DT vdec vdm window, hi3536dv100_vfmw.ko OpenHAL |
        | 0x1320C000 | 0x1320FFFF | SCD (start code detector) top registers (+0x4 EMAR_ID) and SCD registers at +0x800 | PROVEN (offsets), INFERRED (names) | hi3536dv100_vfmw.ko SM_OpenSCDDrv, WriteScdVtrlReg |
        | 0x14000000 | 0x14FFFFFF | FMC memory (16 MiB flash window) | PROVEN | platform.h FMC_MEM_BASE |
        | 0x80000000 | 0x9FFFFFFF | DDR (512 MiB max, 2 Gbit x4) | PROVEN | platform.h DDR_MEM_BASE, demb.dts memory |
    ";

    eHI3536D_CRG        CRG             @ 0x12040000;
    eHI3536D_SYS_CTRL   SYS_CTRL        @ 0x12050000;
    eHI3536D_PMC        PMC             @ 0x120E0000;
    eHI3536D_DDRC_AXI   DDRC_AXI        @ 0x12110000;
    eHI3536D_DDRC_QOSB  DDRC_QOSB       @ 0x12114000;
    eHI3536D_DDRC_DMC   DDRC_DMC        @ 0x12118000;
    eHI3536D_DDRC_PHY   DDRC_PHY        @ 0x1211C000;
    eHI3536D_IO_CONFIG  IO_CONFIG       @ 0x120F0000;
    eHI3536D_MISC_CTRL  MISC_CTRL       @ 0x12120000;
    eHI3536D_HDMI_ctrl       HDMI_CTRL       @ 0x13000000;
    eHI3536D_HDMI_video_path HDMI_VIDEO      @ 0x13000800;
    eHI3536D_HDMI_audio_path HDMI_AUDIO      @ 0x13001000;
    eHI3536D_HDMI_tx         HDMI_TX         @ 0x13001800;
    eHI3536D_HDMI_hdcp       HDMI_HDCP       @ 0x13002000;
    eHI3536D_HDMI_aon        HDMI_AON        @ 0x13004000;
    eHI3536D_HDMI_cec        HDMI_CEC        @ 0x13004800;
    eHI3536D_HDMI_mcu        HDMI_MCU        @ 0x1301C000;
    eHI3536D_HDMI_dphy       HDMI_DPHY       @ 0x13030000;
    eHI3536D_VOU        VOU             @ 0x13020000;
    eHI3536D_AIAO       AIAO            @ 0x13040000;
    eHI3536D_ACODEC     ACODEC          @ 0x13050000;
    eHISI_FMC           FMC             @ 0x10000000;
    eHISI_FEMAC         ETH             @ 0x10010000;
    eHI3536D_SATA       SATA            @ 0x10030000;
    eARM_GIC400         GIC             @ 0x10300000;
    eHISI_USB_OHCI      OHCI            @ 0x11000000;
    eHISI_USB_EHCI      EHCI            @ 0x11010000;
    eHISI_DMAC          DMAC            @ 0x11020000;
    eHISI_CIPHER_MC     CIPHER          @ 0x11030000;
    eHISI_TIMER_SP804   TIMER0          @ 0x12000000;
    eHISI_TIMER_SP804   TIMER1          @ 0x12000020;
    eHISI_TIMER_SP804   TIMER2          @ 0x12010000;
    eHISI_TIMER_SP804   TIMER3          @ 0x12010020;
    eHISI_TIMER_SP804   TIMER4          @ 0x12020000;
    eHISI_TIMER_SP804   TIMER5          @ 0x12020020;
    eHISI_TIMER_SP804   TIMER6          @ 0x12030000;
    eHISI_TIMER_SP804   TIMER7          @ 0x12030020;
    eHISI_WDG_SP805     WDG             @ 0x12070000;
    eARM_PL011          UART0           @ 0x12080000;
    eARM_PL011          UART1           @ 0x12090000;
    eARM_PL011          UART2           @ 0x120A0000;
    eHISI_IR            IR              @ 0x12140000;
    eARM_PL061          GPIO0           @ 0x12150000;
    eARM_PL061          GPIO1           @ 0x12160000;
    eARM_PL061          GPIO2           @ 0x12170000;
    eARM_PL061          GPIO3           @ 0x12180000;
    eARM_PL061          GPIO4           @ 0x12190000;
    eARM_PL061          GPIO5           @ 0x121A0000;
    eHISI_JPGD          JPGD            @ 0x13110000;
    eHISI_JPGE          JPGE            @ 0x13120000;
    eHISI_TDE_G2        TDE             @ 0x13130000;
    aHI3536D_TDE_NODE   TDE_NODE        @ 0x13140000;
    eHI3536D_VGS        VGS             @ 0x13100000;
    aHI3536D_VGS_IMG    VGS_IMG         @ 0x13150000;
    eHI3536D_VDH        VDH             @ 0x13200000;
    eHI3536D_VDH_TOP    VDH_TOP         @ 0x1320C000;
    eHISI_SCD           SCD             @ 0x1320C800;
    aHI3536D_VDH_MSG    VDH_MSG         @ 0x13210000;
};
