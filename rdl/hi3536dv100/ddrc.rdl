`ifndef HI3536D_DDRC_AXI_RDL
`define HI3536D_DDRC_AXI_RDL
regfile eHI3536D_DDRC_AXI {
    name = "DDRC AXI bus interface registers, Hi3536D V100";
    desc = "DDRC AXI bus interface registers, Hi3536D V100 of the Hi3536D V100 at base 0x1211_0000. 22 registers extracted programmatically from the Hi3536D V100 data sheet (Issue 00B04, 2017-12-13) (Table 4-3 Summary of AXI registers (base address: 0x1211_0000)): register headings, offsets, total reset values, field bit ranges, access types, names, reset values and descriptions, with PDF page numbers in each register description. Field names, bit ranges, access types and offsets are exact; the free-text descriptions are taken from the cell text of the field table and were checked by sampling only. Hardware not verified.";
    reg {
        name = "AXI_CFG_LOCK";
        desc = "AXI_CFG_LOCK is a lock control register. (offset 0x4; total reset 0x00000000; PROVEN: Hi3536D V100 data sheet (Issue 00B04, 2017-12-13), section 4.1.5.2, PDF page 263).";
        field {
            name = "reserved";
            desc = "Reserved";
            sw = r; hw = w;
            reset = 0x0;
        } reserved_31_1[31:1];
        field {
            name = "apb_cfg_lock";
            desc = "Lock control of all the register configuration modules (AXI_IF/SEC/DMC/PUB) in the MDDRC
- 0: unlocked
- 1: locked (None of the AXI_IF configuration registers can be accessed except this register. Therefore, the power consumption is reduced.)";
            sw = rw; hw = r;
            reset = 0x0;
        } apb_cfg_lock[0:0];
    } AXI_CFG_LOCK @ 0x4;
    reg {
        name = "AXI_CKG";
        desc = "AXI_CKG is a module clock gating register. (offset 0x8; total reset 0x000F1FFF; PROVEN: Hi3536D V100 data sheet (Issue 00B04, 2017-12-13), section 4.1.5.2, PDF page 264).";
        field {
            name = "reserved";
            desc = "Reserved";
            sw = r; hw = w;
            reset = 0x0;
        } reserved_31_20[31:20];
        field {
            name = "sta_ckg_dmc";
            desc = "Static clock gating for each DMC When sta_ckg_dmc[n] is 0, the clocks for the DMCn and the corresponding PHY utility block (PUB) are disabled. When sta_ckg_dmc[n] is 1, the clocks for the DMCn and the corresponding PUB are enabled. n = 2 or 3: reserved";
            sw = rw; hw = r;
            reset = 0xf;
        } sta_ckg_dmc[19:16];
        field {
            name = "reserved";
            desc = "Reserved";
            sw = r; hw = w;
            reset = 0x0;
        } reserved_15_13[15:13];
        field {
            name = "dyn_ckg_rdr";
            desc = "Dynamic clock gating for the reorder module
- 0: The clock is always enabled.
- 1: The clock is automatically disabled when the module is idle.";
            sw = rw; hw = r;
            reset = 0x1;
        } dyn_ckg_rdr[12:12];
        field {
            name = "dyn_ckg_axi";
            desc = "Dynamic clock gating for each AXI port When dyn_ckg_axi[n] is 0, the clock for AXI port n is always enabled. When dyn_ckg_axi[n] is 1, the clock is automatically disabled when modules in AXI port n are idle.";
            sw = rw; hw = r;
            reset = 0xfff;
        } dyn_ckg_axi[11:0];
    } AXI_CKG @ 0x8;
    reg {
        name = "AXI_ACTION";
        desc = "AXI_ACTION is an AXI operating mode register. (offset 0x20; total reset 0x00000003; PROVEN: Hi3536D V100 data sheet (Issue 00B04, 2017-12-13), section 4.1.5.2, PDF page 265).";
        field {
            name = "reserved";
            desc = "Reserved";
            sw = r; hw = w;
            reset = 0x0;
        } reserved_31_20[31:20];
        field {
            name = "wr_rcv_mode";
            desc = "Anti-deadlock mode enable When wr_rcv_mode[n] is 0, the anti-deadlock mode for port n is disabled. When wr_rcv_mode[n] is 1, the anti-deadlock mode for port n is enabled. Whether to enable the anti-deadlock mode depends on bus architecture requirements When the anti-deadlock mode is enabled, the OSTD of the write command is restricted to 1.";
            sw = rw; hw = r;
            reset = 0x0;
        } wr_rcv_mode[19:8];
        field {
            name = "reserved";
            desc = "Reserved";
            sw = r; hw = w;
            reset = 0x0;
        } reserved_7_2[7:2];
        field {
            name = "rd_wrap_split_en";
            desc = "Wrap read command split enable
- 0: no split. The address is wrapped by the DMC.
- 1: split";
            sw = rw; hw = r;
            reset = 0x1;
        } rd_wrap_split_en[1:1];
        field {
            name = "exclusive_en";
            desc = "Exclusive command enable
- 0: disabled
- 1: enabled";
            sw = rw; hw = r;
            reset = 0x1;
        } exclusive_en[0:0];
    } AXI_ACTION @ 0x20;
    reg {
        name = "AXI_FLUX_STAT";
        desc = "AXI_FLUX_STAT is a port traffic monitoring enable register. (offset 0x30; total reset 0x00000000; PROVEN: Hi3536D V100 data sheet (Issue 00B04, 2017-12-13), section 4.1.5.2, PDF page 266).";
        field {
            name = "reserved";
            desc = "Reserved";
            sw = r; hw = w;
            reset = 0x0;
        } reserved_31_12[31:12];
        field {
            name = "flux_stat_en";
            desc = "Port traffic monitoring enable If flux_stat_en[n] is 0, the traffic monitoring function of port n is disabled. If flux_stat_en[n] is 1, the traffic monitoring function of port n is enabled. Note the following: The traffic statistics of each port is recorded in the traffic registers AXI_FLUX_STAT_RDn and AXI_FLUX_STAT_WRn. The traffic register is wrapped after it is full. The traffic register is automatically cleared when flux_stat_en is set to 1 (traffic monitoring is enabled).";
            sw = rw; hw = r;
            reset = 0x0;
        } flux_stat_en[11:0];
    } AXI_FLUX_STAT @ 0x30;
    reg AXI_REGION_MAP_t {
        name = "AXI_REGION_MAP";
        desc = "AXI_REGION_MAP is an address area mapping register. (offset 0x100, 4 instances at stride 0x10; total reset 0x00000000; PROVEN: Hi3536D V100 data sheet (Issue 00B04, 2017-12-13), section 4.1.5.2, PDF page 266).";
        field {
            name = "reserved";
            desc = "Reserved";
            sw = r; hw = w;
            reset = 0x0;
        } reserved_31_13[31:13];
        field {
            name = "rgn_en";
            desc = "Current address area enable
- 0: disabled
- 1: enabled";
            sw = rw; hw = r;
            reset = 0x0;
        } rgn_en[12:12];
        field {
            name = "reserved";
            desc = "Reserved";
            sw = r; hw = w;
            reset = 0x0;
        } reserved_11_11[11:11];
        field {
            name = "rgn_size";
            desc = "Size of the current address area
- 0x0: 16 MB
- 0x1: 32 MB. In this case, rgn_base_addr/ch_offset[0] must be set to 0.
- 0x2: 64 MB. In this case, rgn_base_addr/ch_offset[1:0] must be set to 0.
- 0x3: 128 MB. In this case, rgn_base_addr/ ch _offset[2:0] must be set to 0.
- 0x4: 256 MB. In this case, rgn_base_addr/ ch _offset[3:0] must be set to 0.
- 0x5: 512 MB. In this case, rgn_base_addr/ ch _offset[4:0] must be set to 0.
- 0x6: 1 GB. In this case, rgn_base_addr/ ch _offset[5:0] must be set to 0.
- 0x7: 2 GB. In this case, rgn_base_addr/ ch _offset[6:0] must be set to 0.

The preceding configuration is valid when the address bit width is 32 bits. The meaning of the configured value varies according to the address bit width. For example, when the address bit width is 40 bits, if this field is set to 0x3, the size of the current address area is 32 GB. In this case, rgn_base_addr[2:0] must be set to 0. Only the 32-bit address bit width is supported in this version.";
            sw = rw; hw = r;
            reset = 0x0;
        } rgn_size[10:8];
        field {
            name = "rgn_base_addr";
            desc = "Base address of the current address area (upper eight bits) The area address alignment granularity varies according to the address bit width because only the upper eight bits of the address can be configured. When the address bit width is 32 bits, the lower 24 bits of the base address of the address area are 0 and the area address is 16-MB-aligned. When the address bit width is 40 bits, the lower 32 bits of the base address of the address area are 0 and the area address is 4-GB-aligned. Only the 32-bit address bit width is supported in this version.";
            sw = rw; hw = r;
            reset = 0x0;
        } rgn_base_addr[7:0];
    };
    AXI_REGION_MAP_t AXI_REGION_MAP_0 @ 0x100;
    AXI_REGION_MAP_t AXI_REGION_MAP_1 @ 0x110;
    AXI_REGION_MAP_t AXI_REGION_MAP_2 @ 0x120;
    AXI_REGION_MAP_t AXI_REGION_MAP_3 @ 0x130;
    reg AXI_REGION_ATTRIB_t {
        name = "AXI_REGION_ATTRIB";
        desc = "AXI_REGION_ATTRIB is an address area attribute register. (offset 0x104, 4 instances at stride 0x10; total reset 0x00010004; PROVEN: Hi3536D V100 data sheet (Issue 00B04, 2017-12-13), section 4.1.5.2, PDF page 268).";
        field {
            name = "reserved";
            desc = "Reserved";
            sw = r; hw = w;
            reset = 0x0;
        } reserved_31_31[31:31];
        field {
            name = "bnk_mod";
            desc = "Bank interleaving granularity in the channel of the current address area (the interleaving granularity varies according to the component) 8 bytes * 2^n (8-bit components) 16 bytes * 2^n (16-bit components) 32 bytes * 2^n (32-bit components) 64 bytes * 2^n (64-bit components) n = 0-7 The bank interleaving granularity must be greater than or equal to the address alignment granularity (addr_aligned).";
            sw = rw; hw = r;
            reset = 0x0;
        } bnk_mod[30:28];
        field {
            name = "reserved";
            desc = "Reserved";
            sw = r; hw = w;
            reset = 0x0;
        } reserved_27_26[27:26];
        field {
            name = "rnk_mod";
            desc = "Rank interleaving mode of the channel of the current address area
- 0x0: The configuration in the DMC is used.
- 0x1: a single independent rank address
- 0x2: Two rank addresses are interleaved.
- 0x3: Four rank addresses are interleaved.

Only the single channel (DMC0) is supported in this version and the channel supports only one rank.";
            sw = rw; hw = r;
            reset = 0x0;
        } rnk_mod[25:24];
        field {
            name = "reserved";
            desc = "Reserved";
            sw = r; hw = w;
            reset = 0x0;
        } reserved_23_19[23:19];
        field {
            name = "addr_aligned";
            desc = "Address boundary alignment granularity of the current address area
- 0x1: 16 bytes
- 0x2: 32 bytes
- 0x3: 64 bytes
- 0x4: 128 bytes
- 0x5: 256 bytes
- 0x6: 512 bytes
- 0x7: 1 KB

Other values: reserved Commands that cross the address alignment boundary will be split. The address alignment granularity must be less than or equal to the bank interleaving granularity (bnk_mod). When addresses are interleaved, the address alignment granularity must be less than or equal to the address interleaving granularity (ch_intlv). When the address is independent, the address alignment granularity must be less than or equal to the page size of the DDR.";
            sw = rw; hw = r;
            reset = 0x1;
        } addr_aligned[18:16];
        field {
            name = "ch_offset";
            desc = "Offset address of the current address area in the channel (upper eight bits) The offset address is used to replace the upper eight bits of the address in the channel to implement the offset of the mapping address in the channel. The offset address varies according to the address bit width. Bits [31:24] of the 32-bit address after channel mapping can be replaced. Bits [39:32] of the 40-bit address after channel mapping can be replaced. Only the 32-bit address bit width is supported in this version.";
            sw = rw; hw = r;
            reset = 0x0;
        } ch_offset[15:8];
        field {
            name = "reserved";
            desc = "Reserved";
            sw = r; hw = w;
            reset = 0x0;
        } reserved_7_6[7:6];
        field {
            name = "ch_intlv";
            desc = "Address interleaving granularity of the current address area (invalid in single independent channel address mode)
- 0x0: 128 bytes
- 0x1: 256 bytes
- 0x2: 512 bytes
- 0x3: 1 KB

Commands are alternately sent to multiple channels based on this granularity. When channels are interleaved, the address interleaving granularity must be greater than or equal to the address alignment granularity (addr_aligned).";
            sw = rw; hw = r;
            reset = 0x0;
        } ch_intlv[5:4];
        field {
            name = "ch_mode";
            desc = "Channel mapping mode of the current address area
- 0x0: no mapping
- 0x1: The address of a single channel is mapped to the channel, and the address is independent
- 0x2: The addresses of two channels are mapped to the channel, and the addresses are interleaved.
- 0x3: The addresses of four channels are mapped to the channel, and the addresses are interleaved.

Commands that attempt to access the unmapped address areas are processed as incorrect commands. In this case, interrupts are reported, command information is recorded, and the SLVERR response is returned from the AXI bus. Only the single channel (DMC0) is supported in this version.";
            sw = rw; hw = r;
            reset = 0x1;
        } ch_mode[3:2];
        field {
            name = "ch_start";
            desc = "Mapping start channel of the current address area
- 0x0: channel 0
- 0x1: channel 1
- 0x2: channel 2
- 0x3: channel 3

In single-channel mapping mode, the mapping start channel can be any channel. In dual-channel mapping mode, the mapping start channel must be channel 0 (addresses of channel 0 and channel 1 are interleaved) or channel 2 (addresses of channel 2 and channel 3 are interleaved). In quad-channel mapping mode, the mapping start channel must be channel 0 (addresses of channels 0-3 are interleaved). Only the single channel (DMC0) is supported in this version.";
            sw = rw; hw = r;
            reset = 0x0;
        } ch_start[1:0];
    };
    AXI_REGION_ATTRIB_t AXI_REGION_ATTRIB_0 @ 0x104;
    AXI_REGION_ATTRIB_t AXI_REGION_ATTRIB_1 @ 0x114;
    AXI_REGION_ATTRIB_t AXI_REGION_ATTRIB_2 @ 0x124;
    AXI_REGION_ATTRIB_t AXI_REGION_ATTRIB_3 @ 0x134;
    reg AXI_QOS_MAP_t {
        name = "AXI_QOS_MAP";
        desc = "AXI_QOS_MAP is a command priority mapping mode register. (offset 0x200, 6 instances at stride 0x10; total reset 0x00000000; PROVEN: Hi3536D V100 data sheet (Issue 00B04, 2017-12-13), section 4.1.5.2, PDF page 271).";
        field {
            name = "reserved";
            desc = "Reserved";
            sw = r; hw = w;
            reset = 0x0;
        } reserved_31_22[31:22];
        field {
            name = "qos_rever";
            desc = "QoS inversion enable (for the priority arbitration of the read and write commands from the same port)
- 0: Priority 0 (axqos = 0) is the lowest priority.
- 1: Priority 0 (axqos = 0) is the highest priority.

This register is valid only when rw_arb_mode is 1.";
            sw = rw; hw = r;
            reset = 0x0;
        } qos_rever[21:21];
        field {
            name = "rw_arb_mode";
            desc = "Arbitration mode for the read and write commands from the same port
- 0: The arbitration is based on the command read/write type.

The command that arrives first is arbitrated first. When the read and write commands arrive simultaneously (or the backpressure is imposed on them simultaneously), the read command is arbitrated before the write command.
- 1: The arbitration is based on the command priority.

The command that arrives first is arbitrated first. When the read and write commands arrive simultaneously (or the backpressure is imposed on them simultaneously), the command with a higher priority is arbitrated first. If the priorities of the read and write commands are the same, the command that is not arbitrated last time is arbitrated according to the least recently used (LRU) rule.";
            sw = rw; hw = r;
            reset = 0x0;
        } rw_arb_mode[20:20];
        field {
            name = "reserved";
            desc = "Reserved";
            sw = r; hw = w;
            reset = 0x0;
        } reserved_19_17[19:17];
        field {
            name = "pri_push_en";
            desc = "Port priority deliver enable
- 0: disabled
- 1: enabled

When the port priority deliver function is enabled, among the multiple commands in the port pipeline and external commands, the one with the highest priority is transferred to the command that is involved in port arbitration. This enables the command to be arbitrated instantly. However, the priority of the transferred command remains unchanged.";
            sw = rw; hw = r;
            reset = 0x0;
        } pri_push_en[16:16];
        field {
            name = "reserved";
            desc = "Reserved";
            sw = r; hw = w;
            reset = 0x0;
        } reserved_15_13[15:13];
        field {
            name = "pri_map_mode";
            desc = "Priority mapping mode of the read/write command
- 0: Any three bits in the command ID or associated signal are used as the mapping index.
- 1: Any three bits in the lower 16 bits of the command ID are used as the mapping index.

The mapping index is obtained by using either of the preceding methods, and the command priority is obtained by mapping the index to the priority lookup table. The lookup table indicates the description of AXI_QOS_WRPRI or AXI_QOS_RDPRI.";
            sw = rw; hw = r;
            reset = 0x0;
        } pri_map_mode[12:12];
        field {
            name = "id_map_idx";
            desc = "Three methods for selecting bits in the command ID as the mapping index when the command ID is used to map the priority id_map_idx[11:8]: Any one bit in the lower 16 bits of the command ID is selected as idx[2]. id_map_idx[7:4]: Any one bit in the lower 16 bits of the command ID is selected as idx[1]. id_map_idx[3:0]: Any one bit in the lower 16 bits of the command ID is selected as idx[0]. For example, if id_map_idx is set to 0x3A0, ID[3], ID[10], and ID[0] of the command form idx[2:0], which is used to map the command priority from the priority lookup table. The lookup table indicates the description of AXI_QOS_WRPRI or AXI_QOS_RDPRI. The command ID indicates the original command ID.";
            sw = rw; hw = r;
            reset = 0x0;
        } id_map_idx[11:0];
    };
    AXI_QOS_MAP_t AXI_QOS_MAP_0 @ 0x200;
    AXI_QOS_MAP_t AXI_QOS_MAP_1 @ 0x210;
    AXI_QOS_MAP_t AXI_QOS_MAP_2 @ 0x220;
    AXI_QOS_MAP_t AXI_QOS_MAP_3 @ 0x230;
    AXI_QOS_MAP_t AXI_QOS_MAP_4 @ 0x240;
    AXI_QOS_MAP_t AXI_QOS_MAP_5 @ 0x250;
    reg AXI_QOS_WRPRIn_t {
        name = "AXI_QOS_WRPRIn";
        desc = "AXI_QOS_WRPRIn is a write command priority mapping table register. (offset 0x204, 6 instances at stride 0x10; total reset 0x00000000; PROVEN: Hi3536D V100 data sheet (Issue 00B04, 2017-12-13), section 4.1.5.2, PDF page 273).";
        field {
            name = "reserved";
            desc = "Reserved";
            sw = r; hw = w;
            reset = 0x0;
        } reserved_31_31[31:31];
        field {
            name = "wr_pri7";
            desc = "Priority of the write command when the mapping index is 7
- 0x0: highest priority …
- 0x7: lowest priority";
            sw = rw; hw = r;
            reset = 0x0;
        } wr_pri7[30:28];
        field {
            name = "reserved";
            desc = "Reserved";
            sw = r; hw = w;
            reset = 0x0;
        } reserved_27_27[27:27];
        field {
            name = "wr_pri6";
            desc = "Priority of the write command when the mapping index is 6
- 0x0: highest priority …
- 0x7: lowest priority";
            sw = rw; hw = r;
            reset = 0x0;
        } wr_pri6[26:24];
        field {
            name = "reserved";
            desc = "Reserved";
            sw = r; hw = w;
            reset = 0x0;
        } reserved_23_23[23:23];
        field {
            name = "wr_pri5";
            desc = "Priority of the write command when the mapping index is 5
- 0x0: highest priority …
- 0x7: lowest priority";
            sw = rw; hw = r;
            reset = 0x0;
        } wr_pri5[22:20];
        field {
            name = "reserved";
            desc = "Reserved";
            sw = r; hw = w;
            reset = 0x0;
        } reserved_19_19[19:19];
        field {
            name = "wr_pri4";
            desc = "Priority of the write command when the mapping index is 4
- 0x0: highest priority …
- 0x7: lowest priority";
            sw = rw; hw = r;
            reset = 0x0;
        } wr_pri4[18:16];
        field {
            name = "reserved";
            desc = "Reserved";
            sw = r; hw = w;
            reset = 0x0;
        } reserved_15_15[15:15];
        field {
            name = "wr_pri3";
            desc = "Priority of the write command when the mapping index is 3
- 0x0: highest priority …
- 0x7: lowest priority";
            sw = rw; hw = r;
            reset = 0x0;
        } wr_pri3[14:12];
        field {
            name = "reserved";
            desc = "Reserved";
            sw = r; hw = w;
            reset = 0x0;
        } reserved_11_11[11:11];
        field {
            name = "wr_pri2";
            desc = "Priority of the write command when the mapping index is 2
- 0x0: highest priority …
- 0x7: lowest priority";
            sw = rw; hw = r;
            reset = 0x0;
        } wr_pri2[10:8];
        field {
            name = "reserved";
            desc = "Reserved";
            sw = r; hw = w;
            reset = 0x0;
        } reserved_7_7[7:7];
        field {
            name = "wr_pri1";
            desc = "Priority of the write command when the mapping index is 1
- 0x0: highest priority …
- 0x7: lowest priority";
            sw = rw; hw = r;
            reset = 0x0;
        } wr_pri1[6:4];
        field {
            name = "reserved";
            desc = "Reserved";
            sw = r; hw = w;
            reset = 0x0;
        } reserved_3_3[3:3];
        field {
            name = "wr_pri0";
            desc = "Priority of the write command when the mapping index is 0
- 0x0: highest priority …
- 0x7: lowest priority";
            sw = rw; hw = r;
            reset = 0x0;
        } wr_pri0[2:0];
    };
    AXI_QOS_WRPRIn_t AXI_QOS_WRPRI0 @ 0x204;
    AXI_QOS_WRPRIn_t AXI_QOS_WRPRI1 @ 0x214;
    AXI_QOS_WRPRIn_t AXI_QOS_WRPRI2 @ 0x224;
    AXI_QOS_WRPRIn_t AXI_QOS_WRPRI3 @ 0x234;
    AXI_QOS_WRPRIn_t AXI_QOS_WRPRI4 @ 0x244;
    AXI_QOS_WRPRIn_t AXI_QOS_WRPRI5 @ 0x254;
    reg AXI_QOS_RDPRIn_t {
        name = "AXI_QOS_RDPRIn";
        desc = "AXI_QOS_RDPRIn is a read command priority mapping table register. (offset 0x208, 6 instances at stride 0x10; total reset 0x00000000; PROVEN: Hi3536D V100 data sheet (Issue 00B04, 2017-12-13), section 4.1.5.2, PDF page 274).";
        field {
            name = "reserved";
            desc = "Reserved";
            sw = r; hw = w;
            reset = 0x0;
        } reserved_31_31[31:31];
        field {
            name = "rd_pri7";
            desc = "Priority of the read command when the mapping index is 7
- 0x0: highest priority …
- 0x7: lowest priority";
            sw = rw; hw = r;
            reset = 0x0;
        } rd_pri7[30:28];
        field {
            name = "reserved";
            desc = "Reserved";
            sw = r; hw = w;
            reset = 0x0;
        } reserved_27_27[27:27];
        field {
            name = "rd_pri6";
            desc = "Priority of the read command when the mapping index is 6
- 0x0: highest priority …
- 0x7: lowest priority";
            sw = rw; hw = r;
            reset = 0x0;
        } rd_pri6[26:24];
        field {
            name = "reserved";
            desc = "Reserved";
            sw = r; hw = w;
            reset = 0x0;
        } reserved_23_23[23:23];
        field {
            name = "rd_pri5";
            desc = "Priority of the read command when the mapping index is 5
- 0x0: highest priority …
- 0x7: lowest priority";
            sw = rw; hw = r;
            reset = 0x0;
        } rd_pri5[22:20];
        field {
            name = "reserved";
            desc = "Reserved";
            sw = r; hw = w;
            reset = 0x0;
        } reserved_19_19[19:19];
        field {
            name = "rd_pri4";
            desc = "Priority of the read command when the mapping index is 4
- 0x0: highest priority …
- 0x7: lowest priority";
            sw = rw; hw = r;
            reset = 0x0;
        } rd_pri4[18:16];
        field {
            name = "reserved";
            desc = "Reserved";
            sw = r; hw = w;
            reset = 0x0;
        } reserved_15_15[15:15];
        field {
            name = "rd_pri3";
            desc = "Priority of the read command when the mapping index is 3
- 0x0: highest priority …
- 0x7: lowest priority";
            sw = rw; hw = r;
            reset = 0x0;
        } rd_pri3[14:12];
        field {
            name = "reserved";
            desc = "Reserved";
            sw = r; hw = w;
            reset = 0x0;
        } reserved_11_11[11:11];
        field {
            name = "rd_pri2";
            desc = "Priority of the read command when the mapping index is 2
- 0x0: highest priority …
- 0x7: lowest priority";
            sw = rw; hw = r;
            reset = 0x0;
        } rd_pri2[10:8];
        field {
            name = "reserved";
            desc = "Reserved";
            sw = r; hw = w;
            reset = 0x0;
        } reserved_7_7[7:7];
        field {
            name = "rd_pri1";
            desc = "Priority of the read command when the mapping index is 1
- 0x0: highest priority …
- 0x7: lowest priority";
            sw = rw; hw = r;
            reset = 0x0;
        } rd_pri1[6:4];
        field {
            name = "reserved";
            desc = "Reserved";
            sw = r; hw = w;
            reset = 0x0;
        } reserved_3_3[3:3];
        field {
            name = "rd_pri0";
            desc = "Priority of the read command when the mapping index is 0
- 0x0: highest priority …
- 0x7: lowest priority";
            sw = rw; hw = r;
            reset = 0x0;
        } rd_pri0[2:0];
    };
    AXI_QOS_RDPRIn_t AXI_QOS_RDPRI0 @ 0x208;
    AXI_QOS_RDPRIn_t AXI_QOS_RDPRI1 @ 0x218;
    AXI_QOS_RDPRIn_t AXI_QOS_RDPRI2 @ 0x228;
    AXI_QOS_RDPRIn_t AXI_QOS_RDPRI3 @ 0x238;
    AXI_QOS_RDPRIn_t AXI_QOS_RDPRI4 @ 0x248;
    AXI_QOS_RDPRIn_t AXI_QOS_RDPRI5 @ 0x258;
    reg AXI_OSTD_PRTn_t {
        name = "AXI_OSTD_PRTn";
        desc = "AXI_OSTD_PRTn is a port command OSTD restriction register. (offset 0x300, 6 instances at stride 0x10; total reset 0x00000000; PROVEN: Hi3536D V100 data sheet (Issue 00B04, 2017-12-13), section 4.1.5.2, PDF page 276).";
        field {
            name = "reserved";
            desc = "Reserved";
            sw = r; hw = w;
            reset = 0x0;
        } reserved_31_14[31:14];
        field {
            name = "prt_wrostd_lvl";
            desc = "Write command OSTD threshold of a port
- 0x00: The number of command OSTDs of a port is not limited. 0x01-0x7F: maximum number of command OSTDs allowed by the port

In this document, the number of OSTDs is the number of commands in the back-end module QoSBuf. In this document, the threshold cannot be greater than the command queue depth of the QoSBuf that is specified by setting parameters. The split commands, rather than AXI original commands, are collected for statistics. In extreme cases, the actual split commands may be two more than the commands specified by the OSTD threshold, which needs to be considered during the OSTD setting.";
            sw = rw; hw = r;
            reset = 0x0;
        } prt_wrostd_lvl[13:7];
        field {
            name = "prt_ostd_lvl";
            desc = "Command OSTD threshold of a port
- 0x00: The number of command OSTDs of a port is not limited. 0x01-0x7F: maximum number of command OSTDs allowed by the port

In this document, the number of OSTDs is the number of commands in the back-end module QoSBuf. In this document, the threshold cannot be greater than the command queue depth of the QoSBuf that is specified by setting parameters. The split commands, rather than AXI original commands, are collected for statistics. In extreme cases, the actual split commands may be two more than the commands specified by the OSTD threshold, which needs to be considered during the OSTD setting.";
            sw = rw; hw = r;
            reset = 0x0;
        } prt_ostd_lvl[6:4];
        field {
            name = "reserved";
            desc = "Reserved";
            sw = rw; hw = r;
            reset = 0x0;
        } reserved_3_0[3:0];
    };
    AXI_OSTD_PRTn_t AXI_OSTD_PRT0 @ 0x300;
    AXI_OSTD_PRTn_t AXI_OSTD_PRT1 @ 0x310;
    AXI_OSTD_PRTn_t AXI_OSTD_PRT2 @ 0x320;
    AXI_OSTD_PRTn_t AXI_OSTD_PRT3 @ 0x330;
    AXI_OSTD_PRTn_t AXI_OSTD_PRT4 @ 0x340;
    AXI_OSTD_PRTn_t AXI_OSTD_PRT5 @ 0x350;
    reg AXI_OSTD_PRT_STn_t {
        name = "AXI_OSTD_PRT_STn";
        desc = "AXI_OSTD_PRT_STn is a port command OSTD statistics register. (offset 0x304, 6 instances at stride 0x10; total reset 0x00000000; PROVEN: Hi3536D V100 data sheet (Issue 00B04, 2017-12-13), section 4.1.5.2, PDF page 277).";
        field {
            name = "reserved";
            desc = "Reserved";
            sw = r; hw = w;
            reset = 0x0;
        } reserved_31_7[31:7];
        field {
            name = "prt_ostd_st";
            desc = "Command OSTD statistics of a port";
            sw = r; hw = w;
            reset = 0x0;
        } prt_ostd_st[6:0];
    };
    AXI_OSTD_PRT_STn_t AXI_OSTD_PRT_ST0 @ 0x304;
    AXI_OSTD_PRT_STn_t AXI_OSTD_PRT_ST1 @ 0x314;
    AXI_OSTD_PRT_STn_t AXI_OSTD_PRT_ST2 @ 0x324;
    AXI_OSTD_PRT_STn_t AXI_OSTD_PRT_ST3 @ 0x334;
    AXI_OSTD_PRT_STn_t AXI_OSTD_PRT_ST4 @ 0x344;
    AXI_OSTD_PRT_STn_t AXI_OSTD_PRT_ST5 @ 0x354;
    reg AXI_OSTD_GROUPn_t {
        name = "AXI_OSTD_GROUPn";
        desc = "AXI_OSTD_GROUPn is a command OSTD register for the port group. (offset 0x400, 4 instances at stride 0x10; total reset 0x00000000; PROVEN: Hi3536D V100 data sheet (Issue 00B04, 2017-12-13), section 4.1.5.2, PDF page 277).";
        field {
            name = "reserved";
            desc = "Reserved";
            sw = r; hw = w;
            reset = 0x0;
        } reserved_31_28[31:28];
        field {
            name = "group_ostd_sel";
            desc = "Port select of a group When group_ostd_sel[n] is 0, port n is not selected. When group_ostd_sel[n] is 1, port n is selected. Only the selected ports are involved in the OSTD statistics of the port group.";
            sw = rw; hw = r;
            reset = 0x0;
        } group_ostd_sel[27:16];
        field {
            name = "reserved";
            desc = "Reserved";
            sw = r; hw = w;
            reset = 0x0;
        } reserved_15_15[15:15];
        field {
            name = "group_wrostd_sel";
            desc = "Write command OSTD threshold of a port group
- 0x00: The number of write command OSTDs of the port group is not limited. 0x01-0x7F: maximum number of accumulated write command

OSTDs allowed by the port group The number of the write command OSTDs of a port group is the sum of the write command OSTDs of all the ports selected by the port group. When the number of command OSTDs exceeds the threshold, all the ports in the port group are blocked. The split commands, rather than AXI original commands, are collected for statistics. In extreme cases, the actual split commands may be two more than the commands specified by the OSTD threshold, which needs to be considered during the OSTD setting.";
            sw = rw; hw = r;
            reset = 0x0;
        } group_wrostd_sel[14:8];
        field {
            name = "reserved";
            desc = "Reserved";
            sw = r; hw = w;
            reset = 0x0;
        } reserved_7_7[7:7];
        field {
            name = "group_ostd_lvl";
            desc = "Command OSTD threshold of a port group
- 0x00: The number of command OSTDs of the port group is not limited. 0x01-0x7F: maximum number of accumulated command OSTDs allowed by the port group

The number of the command OSTDs of a port group is the sum of the command OSTDs of all the ports selected by the port group. When the number of command OSTDs exceeds the threshold, all the ports in the port group are blocked. The split commands, rather than AXI original commands, are collected for statistics. In extreme cases, the actual split commands may be two more than the commands specified by the OSTD threshold, which needs to be considered during the OSTD setting.";
            sw = rw; hw = r;
            reset = 0x0;
        } group_ostd_lvl[6:0];
    };
    AXI_OSTD_GROUPn_t AXI_OSTD_GROUP0 @ 0x400;
    AXI_OSTD_GROUPn_t AXI_OSTD_GROUP1 @ 0x410;
    AXI_OSTD_GROUPn_t AXI_OSTD_GROUP2 @ 0x420;
    AXI_OSTD_GROUPn_t AXI_OSTD_GROUP3 @ 0x430;
    reg AXI_OSTD_PRIn0_t {
        name = "AXI_OSTD_PRIn0";
        desc = "AXI_OSTD_PRIn0 is priority-based port group command OSTD restriction register 0. (offset 0x404, 4 instances at stride 0x10; total reset 0x00000000; PROVEN: Hi3536D V100 data sheet (Issue 00B04, 2017-12-13), section 4.1.5.2, PDF page 279).";
        field {
            name = "reserved";
            desc = "Reserved";
            sw = r; hw = w;
            reset = 0x0;
        } reserved_31_31[31:31];
        field {
            name = "pri3_ostd_lvl";
            desc = "Priority 3 command OSTD threshold 00x00: The number of accumulated command OSTDs of the selected port group is not limited. 0x01-0x7F: When the number of accumulated command OSTDs of the selected port group reaches the threshold, only the commands whose priorities are higher than 1 are allowed. The command OSTD statistics and restriction are based on the port group. If the priority deliver function is enabled, the commands with low priorities may not be blocked because their priorities are increased.";
            sw = rw; hw = r;
            reset = 0x0;
        } pri3_ostd_lvl[30:24];
        field {
            name = "reserved";
            desc = "Reserved";
            sw = r; hw = w;
            reset = 0x0;
        } reserved_23_23[23:23];
        field {
            name = "pri2_ostd_lvl";
            desc = "Priority 2 command OSTD threshold
- 0x00: The number of accumulated command OSTDs of the selected port group is not limited. 0x01-0x7F: When the number of accumulated command OSTDs of the selected port group reaches the threshold, only the commands whose priorities are higher than 1 are allowed.

The command OSTD statistics and restriction are based on the port group. If the priority deliver function is enabled, the commands with low priorities may not be blocked because their priorities are increased.";
            sw = rw; hw = r;
            reset = 0x0;
        } pri2_ostd_lvl[22:16];
        field {
            name = "reserved";
            desc = "Reserved";
            sw = r; hw = w;
            reset = 0x0;
        } reserved_15_15[15:15];
        field {
            name = "pri1_ostd_lvl";
            desc = "Priority 1 command OSTD threshold
- 0x00: The number of accumulated command OSTDs of the selected port group is not limited. 0x01-0x7F: When the number of accumulated command OSTDs of the selected port group reaches the threshold, only the commands whose priorities are higher than 1 are allowed.

The command OSTD statistics and restriction are based on the port group. If the priority deliver function is enabled, the commands with low priorities may not be blocked because their priorities are increased.";
            sw = rw; hw = r;
            reset = 0x0;
        } pri1_ostd_lvl[14:8];
        field {
            name = "reserved";
            desc = "Reserved";
            sw = r; hw = w;
            reset = 0x0;
        } reserved_7_0[7:0];
    };
    AXI_OSTD_PRIn0_t AXI_OSTD_PRIn0_0 @ 0x404;
    AXI_OSTD_PRIn0_t AXI_OSTD_PRIn0_1 @ 0x414;
    AXI_OSTD_PRIn0_t AXI_OSTD_PRIn0_2 @ 0x424;
    AXI_OSTD_PRIn0_t AXI_OSTD_PRIn0_3 @ 0x434;
    reg AXI_OSTD_PRIn1_t {
        name = "AXI_OSTD_PRIn1";
        desc = "AXI_OSTD_PRIn1 is priority-based port group command OSTD restriction register 1. (offset 0x408, 4 instances at stride 0x10; total reset 0x00000000; PROVEN: Hi3536D V100 data sheet (Issue 00B04, 2017-12-13), section 4.1.5.2, PDF page 280).";
        field {
            name = "reserved";
            desc = "Reserved";
            sw = r; hw = w;
            reset = 0x0;
        } reserved_31_31[31:31];
        field {
            name = "pri7_ostd_lvl";
            desc = "Priority 7 command OSTD threshold
- 0x00: The number of accumulated command OSTDs of the selected port group is not limited. 0x01-0x7F: When the number of accumulated command OSTDs of the selected port group reaches the threshold, only the commands whose priorities are higher than 1 are allowed.

The command OSTD statistics and restriction are based on the port group. If the priority deliver function is enabled, the commands with low priorities may not be blocked because their priorities are increased.";
            sw = rw; hw = r;
            reset = 0x0;
        } pri7_ostd_lvl[30:24];
        field {
            name = "reserved";
            desc = "Reserved";
            sw = r; hw = w;
            reset = 0x0;
        } reserved_23_23[23:23];
        field {
            name = "pri6_ostd_lvl";
            desc = "Priority 6 command OSTD threshold
- 0x00: The number of accumulated command OSTDs of the selected port group is not limited. 0x01-0x7F: When the number of accumulated command OSTDs of the selected port group reaches the threshold, only the commands whose priorities are higher than 1 are allowed.

The command OSTD statistics and restriction are based on the port group. If the priority deliver function is enabled, the commands with low priorities may not be blocked because their priorities are increased.";
            sw = rw; hw = r;
            reset = 0x0;
        } pri6_ostd_lvl[22:16];
        field {
            name = "reserved";
            desc = "Reserved";
            sw = r; hw = w;
            reset = 0x0;
        } reserved_15_15[15:15];
        field {
            name = "pri5_ostd_lvl";
            desc = "Priority 5 command OSTD threshold
- 0x00: The number of accumulated command OSTDs of the selected port group is not limited. 0x01-0x7F: When the number of accumulated command OSTDs of the selected port group reaches the threshold, only the commands whose priorities are higher than 1 are allowed.

The command OSTD statistics and restriction are based on the port group. If the priority deliver function is enabled, the commands with low priorities may not be blocked because their priorities are increased.";
            sw = rw; hw = r;
            reset = 0x0;
        } pri5_ostd_lvl[14:8];
        field {
            name = "reserved";
            desc = "Reserved";
            sw = r; hw = w;
            reset = 0x0;
        } reserved_7_7[7:7];
        field {
            name = "pri4_ostd_lvl";
            desc = "Priority 4 command OSTD threshold
- 0x00: The number of accumulated command OSTDs of the selected port group is not limited. 0x01-0x7F: When the number of accumulated command OSTDs of the selected port group reaches the threshold, only the commands whose priorities are higher than 1 are allowed.

The command OSTD statistics and restriction are based on the port group. If the priority deliver function is enabled, the commands with low priorities may not be blocked because their priorities are increased.";
            sw = rw; hw = r;
            reset = 0x0;
        } pri4_ostd_lvl[6:0];
    };
    AXI_OSTD_PRIn1_t AXI_OSTD_PRIn1_0 @ 0x408;
    AXI_OSTD_PRIn1_t AXI_OSTD_PRIn1_1 @ 0x418;
    AXI_OSTD_PRIn1_t AXI_OSTD_PRIn1_2 @ 0x428;
    AXI_OSTD_PRIn1_t AXI_OSTD_PRIn1_3 @ 0x438;
    reg AXI_OSTD_GROUP_STn_t {
        name = "AXI_OSTD_GROUP_STn";
        desc = "AXI_OSTD_GROUP_STn is a command OSTD statistics register for the port group. (offset 0x40C, 4 instances at stride 0x10; total reset 0x00000000; PROVEN: Hi3536D V100 data sheet (Issue 00B04, 2017-12-13), section 4.1.5.2, PDF page 282).";
        field {
            name = "reserved";
            desc = "Reserved";
            sw = r; hw = w;
            reset = 0x0;
        } reserved_31_7[31:7];
        field {
            name = "group_ostd_st";
            desc = "Command OSTD statistics of a port group";
            sw = r; hw = w;
            reset = 0x0;
        } group_ostd_st[6:0];
    };
    AXI_OSTD_GROUP_STn_t AXI_OSTD_GROUP_ST0 @ 0x40C;
    AXI_OSTD_GROUP_STn_t AXI_OSTD_GROUP_ST1 @ 0x41C;
    AXI_OSTD_GROUP_STn_t AXI_OSTD_GROUP_ST2 @ 0x42C;
    AXI_OSTD_GROUP_STn_t AXI_OSTD_GROUP_ST3 @ 0x43C;
    reg AXI_PUSH_WRMIDn_t {
        name = "AXI_PUSH_WRMIDn";
        desc = "AXI_PUSH_WRMIDn is a priority deliver enable register for write commands with the same MIDs. (offset 0x500, 6 instances at stride 0x10; total reset 0x00000000; PROVEN: Hi3536D V100 data sheet (Issue 00B04, 2017-12-13), section 4.1.5.2, PDF page 282).";
        field {
            name = "wr_mid_sel";
            desc = "Bit match select of the write command MID (the lowest five bits) When wr_mid_sel[n] is 0, the priority deliver function is disabled for write commands with MID n in the QoSBuf. When wr_mid_sel[n] is 1, the priority deliver function is enabled for write commands with MID n in the QoSBuf.";
            sw = rw; hw = r;
            reset = 0x0;
        } wr_mid_sel[31:0];
    };
    AXI_PUSH_WRMIDn_t AXI_PUSH_WRMID0 @ 0x500;
    AXI_PUSH_WRMIDn_t AXI_PUSH_WRMID1 @ 0x510;
    AXI_PUSH_WRMIDn_t AXI_PUSH_WRMID2 @ 0x520;
    AXI_PUSH_WRMIDn_t AXI_PUSH_WRMID3 @ 0x530;
    AXI_PUSH_WRMIDn_t AXI_PUSH_WRMID4 @ 0x540;
    AXI_PUSH_WRMIDn_t AXI_PUSH_WRMID5 @ 0x550;
    reg AXI_PUSH_RDMIDn_t {
        name = "AXI_PUSH_RDMIDn";
        desc = "AXI_PUSH_RDMIDn is a priority deliver enable register for read commands with the same MIDs. (offset 0x504, 6 instances at stride 0x10; total reset 0x00000000; PROVEN: Hi3536D V100 data sheet (Issue 00B04, 2017-12-13), section 4.1.5.2, PDF page 283).";
        field {
            name = "rd_mid_sel";
            desc = "Bit match select of the read command MID (the lowest five bits) When rd_mid_sel[n] is 0, the priority deliver function is disabled for read commands with MID n in the QoSBuf. When rd_mid_sel[n] is 1, the priority deliver function is enabled for read commands with MID n in the QoSBuf.";
            sw = rw; hw = r;
            reset = 0x0;
        } rd_mid_sel[31:0];
    };
    AXI_PUSH_RDMIDn_t AXI_PUSH_RDMID0 @ 0x504;
    AXI_PUSH_RDMIDn_t AXI_PUSH_RDMID1 @ 0x514;
    AXI_PUSH_RDMIDn_t AXI_PUSH_RDMID2 @ 0x524;
    AXI_PUSH_RDMIDn_t AXI_PUSH_RDMID3 @ 0x534;
    AXI_PUSH_RDMIDn_t AXI_PUSH_RDMID4 @ 0x544;
    AXI_PUSH_RDMIDn_t AXI_PUSH_RDMID5 @ 0x554;
    reg AXI_QOS_WRADPT_MID_t {
        name = "AXI_QOS_WRADPT_MID";
        desc = "AXI_QOS_WRADPT_MID is a write command priority adaptation MID register. (offset 0x600, 6 instances at stride 0x10; total reset 0x00000000; PROVEN: Hi3536D V100 data sheet (Issue 00B04, 2017-12-13), section 4.1.5.2, PDF page 283).";
        field {
            name = "reserved";
            desc = "Reserved";
            sw = r; hw = w;
            reset = 0x0;
        } reserved_31_29[31:29];
        field {
            name = "wr_adpt_mid3";
            desc = "If the MID of the write command is wr_adpt_mid3, the adaptation is mapped to wr_adpt_cnt3.";
            sw = rw; hw = r;
            reset = 0x0;
        } wr_adpt_mid3[28:24];
        field {
            name = "reserved";
            desc = "Reserved";
            sw = r; hw = w;
            reset = 0x0;
        } reserved_23_21[23:21];
        field {
            name = "wr_adpt_mid2";
            desc = "If the MID of the write command is wr_adpt_mid2, the adaptation is mapped to wr_adpt_cnt2.";
            sw = rw; hw = r;
            reset = 0x0;
        } wr_adpt_mid2[20:16];
        field {
            name = "reserved";
            desc = "Reserved";
            sw = r; hw = w;
            reset = 0x0;
        } reserved_15_13[15:13];
        field {
            name = "wr_adpt_mid1";
            desc = "If the MID of the write command is wr_adpt_mid1, the adaptation is mapped to wr_adpt_cnt1.";
            sw = rw; hw = r;
            reset = 0x0;
        } wr_adpt_mid1[12:8];
        field {
            name = "reserved";
            desc = "Reserved";
            sw = r; hw = w;
            reset = 0x0;
        } reserved_7_5[7:5];
        field {
            name = "wr_adpt_mid0";
            desc = "If the MID of the write command is wr_adpt_mid0, the adaptation is mapped to wr_adpt_cnt0.";
            sw = rw; hw = r;
            reset = 0x0;
        } wr_adpt_mid0[4:0];
    };
    AXI_QOS_WRADPT_MID_t AXI_QOS_WRADPT_MID_0 @ 0x600;
    AXI_QOS_WRADPT_MID_t AXI_QOS_WRADPT_MID_1 @ 0x610;
    AXI_QOS_WRADPT_MID_t AXI_QOS_WRADPT_MID_2 @ 0x620;
    AXI_QOS_WRADPT_MID_t AXI_QOS_WRADPT_MID_3 @ 0x630;
    AXI_QOS_WRADPT_MID_t AXI_QOS_WRADPT_MID_4 @ 0x640;
    AXI_QOS_WRADPT_MID_t AXI_QOS_WRADPT_MID_5 @ 0x650;
    reg AXI_QOS_RDADPT_MID_t {
        name = "AXI_QOS_RDADPT_MID";
        desc = "AXI_QOS_RDADPT_MID is a read command priority adaptation MID register. (offset 0x604, 6 instances at stride 0x10; total reset 0x00000000; PROVEN: Hi3536D V100 data sheet (Issue 00B04, 2017-12-13), section 4.1.5.2, PDF page 284).";
        field {
            name = "reserved";
            desc = "Reserved";
            sw = r; hw = w;
            reset = 0x0;
        } reserved_31_29[31:29];
        field {
            name = "rd_adpt_mid3";
            desc = "If the MID of the read command is rd_adpt_mid3, the adaptation is mapped to rd_adpt_cnt3.";
            sw = rw; hw = r;
            reset = 0x0;
        } rd_adpt_mid3[28:24];
        field {
            name = "reserved";
            desc = "Reserved";
            sw = r; hw = w;
            reset = 0x0;
        } reserved_23_21[23:21];
        field {
            name = "rd_adpt_mid2";
            desc = "If the MID of the read command is rd_adpt_mid2, the adaptation is mapped to rd_adpt_cnt2.";
            sw = rw; hw = r;
            reset = 0x0;
        } rd_adpt_mid2[20:16];
        field {
            name = "reserved";
            desc = "Reserved";
            sw = r; hw = w;
            reset = 0x0;
        } reserved_15_13[15:13];
        field {
            name = "rd_adpt_mid1";
            desc = "If the MID of the read command is rd_adpt_mid1, the adaptation is mapped to rd_adpt_cnt1.";
            sw = rw; hw = r;
            reset = 0x0;
        } rd_adpt_mid1[12:8];
        field {
            name = "reserved";
            desc = "Reserved";
            sw = r; hw = w;
            reset = 0x0;
        } reserved_7_5[7:5];
        field {
            name = "rd_adpt_mid0";
            desc = "If the MID of the read command is rd_adpt_mid0, the adaptation is mapped to rd_adpt_cnt0.";
            sw = rw; hw = r;
            reset = 0x0;
        } rd_adpt_mid0[4:0];
    };
    AXI_QOS_RDADPT_MID_t AXI_QOS_RDADPT_MID_0 @ 0x604;
    AXI_QOS_RDADPT_MID_t AXI_QOS_RDADPT_MID_1 @ 0x614;
    AXI_QOS_RDADPT_MID_t AXI_QOS_RDADPT_MID_2 @ 0x624;
    AXI_QOS_RDADPT_MID_t AXI_QOS_RDADPT_MID_3 @ 0x634;
    AXI_QOS_RDADPT_MID_t AXI_QOS_RDADPT_MID_4 @ 0x644;
    AXI_QOS_RDADPT_MID_t AXI_QOS_RDADPT_MID_5 @ 0x654;
    reg AXI_QOS_ADPT_CNT_t {
        name = "AXI_QOS_ADPT_CNT";
        desc = "AXI_QOS_ADPT_CNT is a read/write priority adaptation counter register. (offset 0x608, 6 instances at stride 0x10; total reset 0x00000000; PROVEN: Hi3536D V100 data sheet (Issue 00B04, 2017-12-13), section 4.1.5.2, PDF page 284).";
        field {
            name = "rd_adpt_cnt3";
            desc = "adpt_cnt mapped after the MID of the fourth group of read commands is matched";
            sw = rw; hw = r;
            reset = 0x0;
        } rd_adpt_cnt3[31:28];
        field {
            name = "rd_adpt_cnt2";
            desc = "adpt_cnt mapped after the MID of the third group of read commands is matched";
            sw = rw; hw = r;
            reset = 0x0;
        } rd_adpt_cnt2[27:24];
        field {
            name = "rd_adpt_cnt1";
            desc = "adpt_cnt mapped after the MID of the second group of read commands is matched";
            sw = rw; hw = r;
            reset = 0x0;
        } rd_adpt_cnt1[23:21];
        field {
            name = "rd_adpt_cnt0";
            desc = "adpt_cnt mapped after the MID of the first group of read commands is matched";
            sw = rw; hw = r;
            reset = 0x0;
        } rd_adpt_cnt0[20:16];
        field {
            name = "wr_adpt_cnt3";
            desc = "adpt_cnt mapped after the MID of the fourth group of write commands is matched";
            sw = rw; hw = r;
            reset = 0x0;
        } wr_adpt_cnt3[15:13];
        field {
            name = "wr_adpt_cnt2";
            desc = "adpt_cnt mapped after the MID of the third group of write commands is matched";
            sw = rw; hw = r;
            reset = 0x0;
        } wr_adpt_cnt2[12:8];
        field {
            name = "wr_adpt_cnt1";
            desc = "adpt_cnt mapped after the MID of the second group of write commands is matched";
            sw = rw; hw = r;
            reset = 0x0;
        } wr_adpt_cnt1[7:5];
        field {
            name = "wr_adpt_cnt0";
            desc = "adpt_cnt mapped after the MID of the first group of write commands is matched";
            sw = rw; hw = r;
            reset = 0x0;
        } wr_adpt_cnt0[4:0];
    };
    AXI_QOS_ADPT_CNT_t AXI_QOS_ADPT_CNT_0 @ 0x608;
    AXI_QOS_ADPT_CNT_t AXI_QOS_ADPT_CNT_1 @ 0x618;
    AXI_QOS_ADPT_CNT_t AXI_QOS_ADPT_CNT_2 @ 0x628;
    AXI_QOS_ADPT_CNT_t AXI_QOS_ADPT_CNT_3 @ 0x638;
    AXI_QOS_ADPT_CNT_t AXI_QOS_ADPT_CNT_4 @ 0x648;
    AXI_QOS_ADPT_CNT_t AXI_QOS_ADPT_CNT_5 @ 0x658;
    reg AXI_FLUX_STAT_RD_t {
        name = "AXI_FLUX_STAT_RD";
        desc = "AXI_FLUX_STAT_RDn is a port read traffic statistics register. (offset 0x708, 6 instances at stride 0x10; total reset 0x00000000; PROVEN: Hi3536D V100 data sheet (Issue 00B04, 2017-12-13), section 4.1.5.2, PDF page 286).";
        field {
            name = "flux_stat_rd";
            desc = "Read traffic statistics of the current port (this register must work with AXI_FLUX_STAT) Note the following: The data traffic corresponding to all read commands is accumulated, and the unit is byte. This field is cleared when the next statistics start.";
            sw = r; hw = w;
            reset = 0x0;
        } flux_stat_rd[31:0];
    };
    AXI_FLUX_STAT_RD_t AXI_FLUX_STAT_RD_0 @ 0x708;
    AXI_FLUX_STAT_RD_t AXI_FLUX_STAT_RD_1 @ 0x718;
    AXI_FLUX_STAT_RD_t AXI_FLUX_STAT_RD_2 @ 0x728;
    AXI_FLUX_STAT_RD_t AXI_FLUX_STAT_RD_3 @ 0x738;
    AXI_FLUX_STAT_RD_t AXI_FLUX_STAT_RD_4 @ 0x748;
    AXI_FLUX_STAT_RD_t AXI_FLUX_STAT_RD_5 @ 0x758;
    reg AXI_FLUX_STAT_WR_t {
        name = "AXI_FLUX_STAT_WR";
        desc = "AXI_FLUX_STAT_WRn is a port write traffic statistics register. (offset 0x70C, 6 instances at stride 0x10; total reset 0x00000000; PROVEN: Hi3536D V100 data sheet (Issue 00B04, 2017-12-13), section 4.1.5.2, PDF page 287).";
        field {
            name = "flux_stat_wr";
            desc = "Write traffic statistics of the current port (this register must work with AXI_FLUX_STAT) Note the following: The data traffic corresponding to all write commands is accumulated, and the unit is byte. This field is cleared when the next statistics start.";
            sw = r; hw = w;
            reset = 0x0;
        } flux_stat_wr[31:0];
    };
    AXI_FLUX_STAT_WR_t AXI_FLUX_STAT_WR_0 @ 0x70C;
    AXI_FLUX_STAT_WR_t AXI_FLUX_STAT_WR_1 @ 0x71C;
    AXI_FLUX_STAT_WR_t AXI_FLUX_STAT_WR_2 @ 0x72C;
    AXI_FLUX_STAT_WR_t AXI_FLUX_STAT_WR_3 @ 0x73C;
    AXI_FLUX_STAT_WR_t AXI_FLUX_STAT_WR_4 @ 0x74C;
    AXI_FLUX_STAT_WR_t AXI_FLUX_STAT_WR_5 @ 0x75C;
    reg {
        name = "AXI_PORT6_CFG0";
        desc = "AXI_PORT6_CFG0: vendor-only: written by the vendor device tree sysctrl-ddr,pins (value 0x00300000) for port 6; bits undocumented in the data sheet; name is a GUESS (DT comment ports6) (offset 0x260). Provenance: PROVEN offset and written value (vendor Linux 4.9 demo device tree node sysctrl-ddr,pins, device-trees-hisilicon openipc-branches hi3536dv100-demb); bit layout NOT in the data sheet; name is the vendor DT comment / a GUESS.";
        field { sw = rw; hw = r; } value[31:0];
    } AXI_PORT6_CFG0 @ 0x260;
    reg {
        name = "AXI_PORT6_CFG1";
        desc = "AXI_PORT6_CFG1: vendor-only: written by the vendor device tree sysctrl-ddr,pins (value 0x76543210) for port 6; bits undocumented in the data sheet; name is a GUESS (DT comment ports6) (offset 0x264). Provenance: PROVEN offset and written value (vendor Linux 4.9 demo device tree node sysctrl-ddr,pins, device-trees-hisilicon openipc-branches hi3536dv100-demb); bit layout NOT in the data sheet; name is the vendor DT comment / a GUESS.";
        field { sw = rw; hw = r; } value[31:0];
    } AXI_PORT6_CFG1 @ 0x264;
    reg {
        name = "AXI_PORT6_CFG2";
        desc = "AXI_PORT6_CFG2: vendor-only: written by the vendor device tree sysctrl-ddr,pins (value 0x76543210) for port 6; bits undocumented in the data sheet; name is a GUESS (DT comment ports6) (offset 0x268). Provenance: PROVEN offset and written value (vendor Linux 4.9 demo device tree node sysctrl-ddr,pins, device-trees-hisilicon openipc-branches hi3536dv100-demb); bit layout NOT in the data sheet; name is the vendor DT comment / a GUESS.";
        field { sw = rw; hw = r; } value[31:0];
    } AXI_PORT6_CFG2 @ 0x268;
    reg {
        name = "AXI_PORT7_CFG0";
        desc = "AXI_PORT7_CFG0: vendor-only: written by the vendor device tree sysctrl-ddr,pins (value 0x00300000) for port 7; bits undocumented in the data sheet; name is a GUESS (DT comment ports7) (offset 0x270). Provenance: PROVEN offset and written value (vendor Linux 4.9 demo device tree node sysctrl-ddr,pins, device-trees-hisilicon openipc-branches hi3536dv100-demb); bit layout NOT in the data sheet; name is the vendor DT comment / a GUESS.";
        field { sw = rw; hw = r; } value[31:0];
    } AXI_PORT7_CFG0 @ 0x270;
    reg {
        name = "AXI_PORT7_CFG1";
        desc = "AXI_PORT7_CFG1: vendor-only: written by the vendor device tree sysctrl-ddr,pins (value 0x76543210) for port 7; bits undocumented in the data sheet; name is a GUESS (DT comment ports7) (offset 0x274). Provenance: PROVEN offset and written value (vendor Linux 4.9 demo device tree node sysctrl-ddr,pins, device-trees-hisilicon openipc-branches hi3536dv100-demb); bit layout NOT in the data sheet; name is the vendor DT comment / a GUESS.";
        field { sw = rw; hw = r; } value[31:0];
    } AXI_PORT7_CFG1 @ 0x274;
    reg {
        name = "AXI_PORT7_CFG2";
        desc = "AXI_PORT7_CFG2: vendor-only: written by the vendor device tree sysctrl-ddr,pins (value 0x76543210) for port 7; bits undocumented in the data sheet; name is a GUESS (DT comment ports7) (offset 0x278). Provenance: PROVEN offset and written value (vendor Linux 4.9 demo device tree node sysctrl-ddr,pins, device-trees-hisilicon openipc-branches hi3536dv100-demb); bit layout NOT in the data sheet; name is the vendor DT comment / a GUESS.";
        field { sw = rw; hw = r; } value[31:0];
    } AXI_PORT7_CFG2 @ 0x278;
};
`endif
