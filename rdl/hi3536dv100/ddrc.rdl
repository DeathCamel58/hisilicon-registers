`ifndef HI3536D_DDRC_RDL
`define HI3536D_DDRC_RDL
regfile eHI3536D_DDRC_AXI {
    name = "DDRC AXI bus interface registers, Hi3536D V100";
    desc = "DDRC AXI bus interface registers of the Hi3536D V100 at base 0x12110000. 6 registers extracted programmatically from the Hi3536D V100 data sheet (Issue 00B04, 2017-12-13, Table 4-3), register descriptions and field tables; reset values are the data sheet total reset values split onto the fields. Source: dl/research-hi3536 ReleaseDoc (unofficial copy of the HiSilicon SDK documentation; facts only). Field names, bit ranges, access types and reset values are exact; the free-text descriptions are attributed to fields from the PDF text layout (title sentence above the bit row, enumerations below) and can be shifted by one field where a sentence wraps: check the data sheet page when a description matters. Hardware not yet verified (no Hi3536D board on the bench).";
    reg {
        name = "AXI_CFG_LOCK";
        desc = "AXI_CFG_LOCK is a lock control register. (offset 0x4, total reset 0x00000000; PROVEN: Hi3536D V100 data sheet).";
        field {
            name = "reserved_31_1";
            desc = "Reserved (AXI_IF/SEC/DMC/PUB) in the MDDRC 0: unlocked";
            sw = r; hw = w;
            reset = 0x0;
        } reserved_31_1[31:1];
        field {
            name = "apb_cfg_lock";
            desc = "Lock control of all the register configuration modules 1: locked (None of the AXI_IF configuration registers can be accessed except this register. Therefore, the power consumption is reduced.)";
            sw = rw; hw = r;
            reset = 0x0;
        } apb_cfg_lock[0:0];
    } AXI_CFG_LOCK @ 0x4;
    reg {
        name = "AXI_CKG";
        desc = "AXI_CKG (offset 0x8, total reset 0x000F1FFF; PROVEN: Hi3536D V100 data sheet).";
        field {
            name = "reserved_31_20";
            desc = "Reserved corresponding PHY utility block (PUB) are disabled.";
            sw = r; hw = w;
            reset = 0x0;
        } reserved_31_20[31:20];
        field {
            name = "sta_ckg_dmc";
            desc = "Static clock gating for each DMC When sta_ckg_dmc[n] is 0, the clocks for the DMCn and the corresponding PUB are enabled.";
            sw = rw; hw = r;
            reset = 0xf;
        } sta_ckg_dmc[19:16];
        field {
            name = "reserved_15_13";
            desc = "When sta_ckg_dmc[n] is 1, the clocks for the DMCn and the n = 2 or 3: reserved Reserved";
            sw = r; hw = w;
            reset = 0x0;
        } reserved_15_13[15:13];
        field {
            name = "dyn_ckg_rdr";
            desc = "Dynamic clock gating for the reorder module 0: The clock is always enabled. 1: The clock is automatically disabled when the module is idle.";
            sw = rw; hw = r;
            reset = 0x1;
        } dyn_ckg_rdr[12:12];
        field {
            name = "dyn_ckg_axi";
            desc = "Dynamic clock gating for each AXI port When dyn_ckg_axi[n] is 0, the clock for AXI port n is always enabled. When dyn_ckg_axi[n] is 1, the clock is automatically disabled when modules in AXI port n are idle.";
            sw = rw; hw = r;
            reset = 0xfff;
        } dyn_ckg_axi[11:0];
    } AXI_CKG @ 0x8;
    reg {
        name = "AXI_ACTION";
        desc = "AXI_ACTION (offset 0x20, total reset 0x00000003; PROVEN: Hi3536D V100 data sheet).";
        field {
            name = "reserved_31_20";
            desc = "Reserved disabled.";
            sw = r; hw = w;
            reset = 0x0;
        } reserved_31_20[31:20];
        field {
            name = "wr_rcv_mode";
            desc = "Anti-deadlock mode enable When wr_rcv_mode[n] is 0, the anti-deadlock mode for port n is When wr_rcv_mode[n] is 1, the anti-deadlock mode for port n is enabled.";
            sw = rw; hw = r;
            reset = 0x0;
        } wr_rcv_mode[19:8];
        field {
            name = "reserved_7_2";
            desc = " Whether to enable the anti-deadlock mode depends on bus architecture requirements  When the anti-deadlock mode is enabled, the OSTD of the write command is restricted to 1. Reserved";
            sw = r; hw = w;
            reset = 0x0;
        } reserved_7_2[7:2];
        field {
            name = "rd_wrap_split_en";
            desc = "Wrap read command split enable 0: no split. The address is wrapped by the DMC. 1: split";
            sw = rw; hw = r;
            reset = 0x1;
        } rd_wrap_split_en[1:1];
        field {
            name = "exclusive_en";
            desc = "Exclusive command enable 0: disabled 1: enabled";
            sw = rw; hw = r;
            reset = 0x1;
        } exclusive_en[0:0];
    } AXI_ACTION @ 0x20;
    reg {
        name = "AXI_FLUX_STAT";
        desc = "AXI_FLUX_STAT (offset 0x30, total reset 0x00000000; PROVEN: Hi3536D V100 data sheet).";
        field {
            name = "reserved_31_12";
            desc = "Reserved disabled.";
            sw = r; hw = w;
            reset = 0x0;
        } reserved_31_12[31:12];
        field {
            name = "flux_stat_en";
            desc = "Port traffic monitoring enable If flux_stat_en[n] is 0, the traffic monitoring function of port n is If flux_stat_en[n] is 1, the traffic monitoring function of port n is enabled. Note the following:    The traffic statistics of each port is recorded in the traffic registers AXI_FLUX_STAT_RDn and    The traffic register is wrapped after it is full. AXI_FLUX_STAT_WRn.    The traffic register is ";
            sw = rw; hw = r;
            reset = 0x0;
        } flux_stat_en[11:0];
    } AXI_FLUX_STAT @ 0x30;
    reg {
        name = "AXI_STATUS";
        desc = "AXI_STATUS is a port operating mode register. (offset 0x600, total reset 0x00000000; PROVEN: Hi3536D V100 data sheet).";
        field {
            name = "reserved_31_12";
            desc = "Reserved";
            sw = r; hw = w;
            reset = 0x0;
        } reserved_31_12[31:12];
        field {
            name = "axi_if_busy";
            desc = "Operating mode of each AXI port When axi_prt_busy[n] is 0, AXI port n is idle. When axi_prt_busy[n] is 1, AXI port n is processing commands or data.";
            sw = r; hw = w;
            reset = 0x0;
        } axi_if_busy[11:0];
    } AXI_STATUS @ 0x600;
    reg {
        name = "AXI_INT_STATUS";
        desc = "AXI_INT_STATUS is an interrupt status register. (offset 0x610, total reset 0x00000000; PROVEN: Hi3536D V100 data sheet).";
        field {
            name = "reserved_31_12";
            desc = "Reserved";
            sw = r; hw = w;
            reset = 0x0;
        } reserved_31_12[31:12];
        field {
            name = "int_ports";
            desc = "Interrupt source indicator 0x708 + 0x10 x ports (ports = 0–5) must work with AXI_FLUX_STAT)";
            sw = r; hw = w;
            reset = 0x0;
        } int_ports[11:0];
    } AXI_INT_STATUS @ 0x610;
};

`endif
