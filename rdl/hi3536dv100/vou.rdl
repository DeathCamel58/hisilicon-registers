`ifndef HI3536D_VOU_RDL
`define HI3536D_VOU_RDL
regfile eHI3536D_VOU {
    name = "Video output unit (VDP), HD/SD display, graphics, interfaces, Hi3536D V100";
    desc = "Video output unit (VDP), HD/SD display, graphics, interfaces, Hi3536D V100 of the Hi3536D V100 at base 0x1302_0000. 146 registers extracted programmatically from the Hi3536D V100 data sheet (Issue 00B04, 2017-12-13) (Table 9-1 Summary of VDP registers (base address: 0x1302_0000)): register headings, offsets, total reset values, field bit ranges, access types, names, reset values and descriptions, with PDF page numbers in each register description. Field names, bit ranges, access types and offsets are exact; the free-text descriptions are taken from the cell text of the field table and were checked by sampling only. Hardware not verified.";
    reg {
        name = "VOCTRL";
        desc = "VOCTRL is a VO control register. It is used to configure the arbitration mode of surface bus requests. (offset 0x0; total reset 0x00000000; PROVEN: Hi3536D V100 data sheet (Issue 00B04, 2017-12-13), section 9.1.6, PDF page 497).";
        field {
            name = "vo_ck_gt_en";
            desc = "VDP clock gating enable
- 0: disabled
- 1: enabled";
            sw = rw; hw = r;
            reset = 0x0;
        } vo_ck_gt_en[31:31];
        field {
            name = "chk_sum_en";
            desc = "Checksum enable
- 0: disabled
- 1: enabled";
            sw = rw; hw = r;
            reset = 0x0;
        } chk_sum_en[30:30];
        field {
            name = "reserved";
            desc = "Reserved";
            sw = r; hw = w;
            reset = 0x0;
        } reserved_29_4[29:4];
        field {
            name = "m0_arb_mode";
            desc = "Arbitration mode of internal surface bus data requests of VO MAC0
- 0x0: The polling mode is used.
- 0x1: The graphics layer takes priority.

Other values: reserved";
            sw = rw; hw = r;
            reset = 0x0;
        } m0_arb_mode[3:0];
    } VOCTRL @ 0x0;
    reg {
        name = "VOINTSTA";
        desc = "VOINTSTA is a VO interrupt status register (read-only). (offset 0x4; total reset 0x00000044; PROVEN: Hi3536D V100 data sheet (Issue 00B04, 2017-12-13), section 9.1.6, PDF page 498).";
        field {
            name = "reserved";
            desc = "Reserved";
            sw = r; hw = w;
            reset = 0x0;
        } reserved_31_31[31:31];
        field {
            name = "m0_be_int";
            desc = "AXI master 0 bus error interrupt
- 0: No interrupt is generated.
- 1: An interrupt is generated.";
            sw = r; hw = w;
            reset = 0x0;
        } m0_be_int[30:30];
        field {
            name = "reserved";
            desc = "Reserved";
            sw = r; hw = w;
            reset = 0x0;
        } reserved_29_27[29:27];
        field {
            name = "g4rr_int";
            desc = "G4 register update interrupt
- 0: No interrupt is generated.
- 1: An interrupt is generated.";
            sw = r; hw = w;
            reset = 0x0;
        } g4rr_int[26:26];
        field {
            name = "reserved";
            desc = "Reserved";
            sw = r; hw = w;
            reset = 0x0;
        } reserved_25_25[25:25];
        field {
            name = "g2rr_int";
            desc = "G2 register update interrupt
- 0: No interrupt is generated.
- 1: An interrupt is generated.";
            sw = r; hw = w;
            reset = 0x0;
        } g2rr_int[24:24];
        field {
            name = "reserved";
            desc = "Reserved";
            sw = r; hw = w;
            reset = 0x0;
        } reserved_23_23[23:23];
        field {
            name = "reserved";
            desc = "Reserved";
            sw = r; hw = w;
            reset = 0x0;
        } reserved_22_22[22:22];
        field {
            name = "reserved";
            desc = "Reserved";
            sw = r; hw = w;
            reset = 0x0;
        } reserved_21_21[21:21];
        field {
            name = "v4rr_int";
            desc = "V3 register update interrupt
- 0: No interrupt is generated.
- 1: An interrupt is generated.";
            sw = r; hw = w;
            reset = 0x0;
        } v4rr_int[20:20];
        field {
            name = "v3rr_int";
            desc = "V1 register update interrupt
- 0: No interrupt is generated.
- 1: An interrupt is generated.";
            sw = r; hw = w;
            reset = 0x0;
        } v3rr_int[19:19];
        field {
            name = "reserved";
            desc = "Reserved";
            sw = r; hw = w;
            reset = 0x0;
        } reserved_18_18[18:18];
        field {
            name = "reserved";
            desc = "Reserved";
            sw = r; hw = w;
            reset = 0x0;
        } reserved_17_17[17:17];
        field {
            name = "reserved";
            desc = "Reserved";
            sw = r; hw = w;
            reset = 0x0;
        } reserved_16_16[16:16];
        field {
            name = "reserved";
            desc = "Reserved";
            sw = r; hw = w;
            reset = 0x0;
        } reserved_15_15[15:15];
        field {
            name = "vdac2_unload_int";
            desc = "VDAC2 non-loaded interrupt
- 0: No interrupt is generated.
- 1: An interrupt is generated.";
            sw = r; hw = w;
            reset = 0x0;
        } vdac2_unload_int[14:14];
        field {
            name = "vdac1_unload_int";
            desc = "VDAC1 non-loaded interrupt
- 0: No interrupt is generated.
- 1: An interrupt is generated.";
            sw = r; hw = w;
            reset = 0x0;
        } vdac1_unload_int[13:13];
        field {
            name = "vdac0_unload_int";
            desc = "VDAC0 non-loaded interrupt
- 0: No interrupt is generated.
- 1: An interrupt is generated.";
            sw = r; hw = w;
            reset = 0x0;
        } vdac0_unload_int[12:12];
        field {
            name = "-";
            desc = "Reserved";
            sw = r; hw = w;
            reset = 0x0;
        } f[11:10];
        field {
            name = "reserved";
            desc = "Reserved";
            sw = r; hw = w;
            reset = 0x0;
        } reserved_9_9[9:9];
        field {
            name = "reserved";
            desc = "Reserved";
            sw = r; hw = w;
            reset = 0x0;
        } reserved_8_8[8:8];
        field {
            name = "dhd1uf_int";
            desc = "HD1 low-bandwidth alarm interrupt
- 0: No interrupt is generated.
- 1: An interrupt is generated.";
            sw = r; hw = w;
            reset = 0x0;
        } dhd1uf_int[7:7];
        field {
            name = "dhd1vtthd3_int";
            desc = "HD1 vertical timing interrupt 3
- 0: No interrupt is generated.
- 1: An interrupt is generated.";
            sw = r; hw = w;
            reset = 0x1;
        } dhd1vtthd3_int[6:6];
        field {
            name = "dhd1vtthd2_int";
            desc = "HD1 vertical timing interrupt 2
- 0: No interrupt is generated.
- 1: An interrupt is generated.";
            sw = r; hw = w;
            reset = 0x0;
        } dhd1vtthd2_int[5:5];
        field {
            name = "dhd1vtthd1_int";
            desc = "HD1 vertical timing interrupt 1
- 0: No interrupt is generated.
- 1: An interrupt is generated.";
            sw = r; hw = w;
            reset = 0x0;
        } dhd1vtthd1_int[4:4];
        field {
            name = "reserved";
            desc = "Reserved";
            sw = r; hw = w;
            reset = 0x0;
        } reserved_3_3[3:3];
        field {
            name = "reserved";
            desc = "Reserved";
            sw = r; hw = w;
            reset = 0x1;
        } reserved_2_2[2:2];
        field {
            name = "reserved";
            desc = "Reserved";
            sw = r; hw = w;
            reset = 0x0;
        } reserved_1_1[1:1];
        field {
            name = "reserved";
            desc = "Reserved";
            sw = r; hw = w;
            reset = 0x0;
        } reserved_0_0[0:0];
    } VOINTSTA @ 0x4;
    reg {
        name = "VOMSKINTSTA";
        desc = "VOMSKINTSTA is a VO masked interrupt status register. Writing 1 clears this register. (offset 0x8; total reset 0x00000000; PROVEN: Hi3536D V100 data sheet (Issue 00B04, 2017-12-13), section 9.1.6, PDF page 500).";
        field {
            name = "reserved";
            desc = "Reserved";
            sw = r; hw = w;
            reset = 0x0;
        } reserved_31_31[31:31];
        field {
            name = "m0_be_clr";
            desc = "AXI master 0 bus error interrupt
- 0: The interrupt is not cleared.
- 1: The interrupt is cleared.

Access type WC in the data sheet: written 1 clears the bit.";
            sw = rw; hw = w; onwrite = woclr;
            reset = 0x0;
        } m0_be_clr[30:30];
        field {
            name = "reserved";
            desc = "Reserved";
            sw = r; hw = w;
            reset = 0x0;
        } reserved_29_27[29:27];
        field {
            name = "g4rr_clr";
            desc = "G4 register update interrupt
- 0: The interrupt is not cleared.
- 1: The interrupt is cleared.

Access type WC in the data sheet: written 1 clears the bit.";
            sw = rw; hw = w; onwrite = woclr;
            reset = 0x0;
        } g4rr_clr[26:26];
        field {
            name = "reserved";
            desc = "Reserved";
            sw = r; hw = w;
            reset = 0x0;
        } reserved_25_25[25:25];
        field {
            name = "g2rr_clr";
            desc = "G2 register update interrupt
- 0: The interrupt is not cleared.
- 1: The interrupt is cleared.

Access type WC in the data sheet: written 1 clears the bit.";
            sw = rw; hw = w; onwrite = woclr;
            reset = 0x0;
        } g2rr_clr[24:24];
        field {
            name = "reserved";
            desc = "Reserved";
            sw = r; hw = w;
            reset = 0x0;
        } reserved_23_23[23:23];
        field {
            name = "reserved";
            desc = "Reserved";
            sw = r; hw = w;
            reset = 0x0;
        } reserved_22_22[22:22];
        field {
            name = "reserved";
            desc = "Reserved";
            sw = r; hw = w;
            reset = 0x0;
        } reserved_21_21[21:21];
        field {
            name = "v4rr_clr";
            desc = "V3 register update interrupt
- 0: The interrupt is not cleared.
- 1: The interrupt is cleared.

Access type WC in the data sheet: written 1 clears the bit.";
            sw = rw; hw = w; onwrite = woclr;
            reset = 0x0;
        } v4rr_clr[20:20];
        field {
            name = "v3rr_clr";
            desc = "V1 register update interrupt
- 0: The interrupt is not cleared.
- 1: The interrupt is cleared.

Access type WC in the data sheet: written 1 clears the bit.";
            sw = rw; hw = w; onwrite = woclr;
            reset = 0x0;
        } v3rr_clr[19:19];
        field {
            name = "reserved";
            desc = "Reserved";
            sw = r; hw = w;
            reset = 0x0;
        } reserved_18_15[18:15];
        field {
            name = "vdac2_unload_int";
            desc = "VDAC2 non-loaded interrupt
- 0: The interrupt is not cleared.
- 1: The interrupt is cleared.";
            sw = r; hw = w;
            reset = 0x0;
        } vdac2_unload_int[14:14];
        field {
            name = "vdac1_unload_int";
            desc = "VDAC1 non-loaded interrupt
- 0: The interrupt is not cleared.
- 1: The interrupt is cleared.";
            sw = r; hw = w;
            reset = 0x0;
        } vdac1_unload_int[13:13];
        field {
            name = "vdac0_unload_int";
            desc = "VDAC0 non-loaded interrupt
- 0: The interrupt is not cleared.
- 1: The interrupt is cleared.";
            sw = r; hw = w;
            reset = 0x0;
        } vdac0_unload_int[12:12];
        field {
            name = "g4wbc_vte_clr";
            desc = "G4 WBC task completion interrupt
- 0: The interrupt is not cleared.
- 1: The interrupt is cleared.";
            sw = r; hw = w;
            reset = 0x0;
        } g4wbc_vte_clr[11:11];
        field {
            name = "reserved";
            desc = "Reserved";
            sw = r; hw = w;
            reset = 0x0;
        } reserved_10_8[10:8];
        field {
            name = "dhd1uf_clr";
            desc = "HD1 low-bandwidth alarm interrupt
- 0: The interrupt is not cleared.
- 1: The interrupt is cleared.

Access type WC in the data sheet: written 1 clears the bit.";
            sw = rw; hw = w; onwrite = woclr;
            reset = 0x0;
        } dhd1uf_clr[7:7];
        field {
            name = "dhd1vtthd3_clr";
            desc = "HD1 vertical timing interrupt 3
- 0: The interrupt is not cleared.
- 1: The interrupt is cleared.

Access type WC in the data sheet: written 1 clears the bit.";
            sw = rw; hw = w; onwrite = woclr;
            reset = 0x0;
        } dhd1vtthd3_clr[6:6];
        field {
            name = "dhd1vtthd2_clr";
            desc = "HD1 vertical timing interrupt 2
- 0: The interrupt is not cleared.
- 1: The interrupt is cleared.

Access type WC in the data sheet: written 1 clears the bit.";
            sw = rw; hw = w; onwrite = woclr;
            reset = 0x0;
        } dhd1vtthd2_clr[5:5];
        field {
            name = "dhd1vtthd1_clr";
            desc = "HD1 vertical timing interrupt 1
- 0: The interrupt is not cleared.
- 1: The interrupt is cleared.

Access type WC in the data sheet: written 1 clears the bit.";
            sw = rw; hw = w; onwrite = woclr;
            reset = 0x0;
        } dhd1vtthd1_clr[4:4];
        field {
            name = "reserved";
            desc = "Reserved";
            sw = r; hw = w;
            reset = 0x0;
        } reserved_3_0[3:0];
    } VOMSKINTSTA @ 0x8;
    reg {
        name = "VOINTMSK";
        desc = "VOINTMSK is a VDP interrupt mask register. It corresponds to VOINTSTA. When the corresponding bit is set to 1, the interrupt is enabled; when the corresponding bit is set to 0, the interrupt is masked. (offset 0xC; total reset 0x00000000; PROVEN: Hi3536D V100 data sheet (Issue 00B04, 2017-12-13), section 9.1.6, PDF page 502).";
        field {
            name = "reserved";
            desc = "Reserved";
            sw = r; hw = w;
            reset = 0x0;
        } reserved_31_31[31:31];
        field {
            name = "m0_be_intmsk";
            desc = "AXI master 0 bus error interrupt
- 0: masked
- 1: enabled";
            sw = rw; hw = r;
            reset = 0x0;
        } m0_be_intmsk[30:30];
        field {
            name = "reserved";
            desc = "Reserved";
            sw = r; hw = w;
            reset = 0x0;
        } reserved_29_27[29:27];
        field {
            name = "g4rr_intmsk";
            desc = "G4 register update interrupt
- 0: masked
- 1: enabled";
            sw = rw; hw = r;
            reset = 0x0;
        } g4rr_intmsk[26:26];
        field {
            name = "reserved";
            desc = "Reserved";
            sw = r; hw = w;
            reset = 0x0;
        } reserved_25_25[25:25];
        field {
            name = "g2rr_intmsk";
            desc = "G2 register update interrupt
- 0: masked
- 1: enabled";
            sw = rw; hw = r;
            reset = 0x0;
        } g2rr_intmsk[24:24];
        field {
            name = "reserved";
            desc = "Reserved";
            sw = r; hw = w;
            reset = 0x0;
        } reserved_23_23[23:23];
        field {
            name = "reserved";
            desc = "Reserved";
            sw = r; hw = w;
            reset = 0x0;
        } reserved_22_22[22:22];
        field {
            name = "reserved";
            desc = "Reserved";
            sw = r; hw = w;
            reset = 0x0;
        } reserved_21_21[21:21];
        field {
            name = "v3rr_intmsk";
            desc = "V3 register update interrupt
- 0: masked
- 1: enabled";
            sw = rw; hw = r;
            reset = 0x0;
        } v3rr_intmsk[20:20];
        field {
            name = "v1rr_intmsk";
            desc = "V1 register update interrupt
- 0: masked
- 1: enabled";
            sw = rw; hw = r;
            reset = 0x0;
        } v1rr_intmsk[19:19];
        field {
            name = "reserved";
            desc = "Reserved";
            sw = r; hw = w;
            reset = 0x0;
        } reserved_18_15[18:15];
        field {
            name = "vdac2_unload_intmsk";
            desc = "VDAC2 non-loaded interrupt
- 0: masked
- 1: enabled";
            sw = rw; hw = r;
            reset = 0x0;
        } vdac2_unload_intmsk[14:14];
        field {
            name = "vdac1_unload_intmsk";
            desc = "VDAC1 non-loaded interrupt
- 0: masked
- 1: enabled";
            sw = rw; hw = r;
            reset = 0x0;
        } vdac1_unload_intmsk[13:13];
        field {
            name = "vdac0_unload_intmsk";
            desc = "VDAC0 non-loaded interrupt
- 0: masked
- 1: enabled";
            sw = rw; hw = r;
            reset = 0x0;
        } vdac0_unload_intmsk[12:12];
        field {
            name = "g4wbc_vte_intmsk";
            desc = "G4 WBC task completion interrupt
- 0: No interrupt is generated.
- 1: An interrupt is generated.";
            sw = rw; hw = r;
            reset = 0x0;
        } g4wbc_vte_intmsk[11:11];
        field {
            name = "reserved";
            desc = "Reserved";
            sw = r; hw = w;
            reset = 0x0;
        } reserved_10_8[10:8];
        field {
            name = "dhd1uf_intmsk";
            desc = "HD1 low-bandwidth alarm interrupt
- 0: masked
- 1: enabled";
            sw = rw; hw = r;
            reset = 0x0;
        } dhd1uf_intmsk[7:7];
        field {
            name = "dhd1vtthd3_intmsk";
            desc = "HD1 vertical timing interrupt 3
- 0: masked
- 1: enabled";
            sw = rw; hw = r;
            reset = 0x0;
        } dhd1vtthd3_intmsk[6:6];
        field {
            name = "dhd1vtthd2_intmsk";
            desc = "HD1 vertical timing interrupt 2
- 0: masked
- 1: enabled";
            sw = rw; hw = r;
            reset = 0x0;
        } dhd1vtthd2_intmsk[5:5];
        field {
            name = "dhd1vtthd1_intmsk";
            desc = "HD1 vertical timing interrupt 1
- 0: masked
- 1: enabled";
            sw = rw; hw = r;
            reset = 0x0;
        } dhd1vtthd1_intmsk[4:4];
        field {
            name = "reserved";
            desc = "Reserved";
            sw = r; hw = w;
            reset = 0x0;
        } reserved_3_0[3:0];
    } VOINTMSK @ 0xC;
    reg {
        name = "VOAXICTRL";
        desc = "VOAXICTRL is a VO AXI bus configuration register. (offset 0x34; total reset 0x01110111; PROVEN: Hi3536D V100 data sheet (Issue 00B04, 2017-12-13), section 9.1.6, PDF page 503).";
        field {
            name = "reserved";
            desc = "Reserved";
            sw = r; hw = w;
            reset = 0x111;
        } reserved_31_16[31:16];
        field {
            name = "m0_id_sel";
            desc = "AXI master 0 multi-ID enable
- 0: disabled
- 1: enabled";
            sw = rw; hw = r;
            reset = 0x0;
        } m0_id_sel[15:15];
        field {
            name = "reserved";
            desc = "Reserved";
            sw = r; hw = w;
            reset = 0x0;
        } reserved_14_12[14:12];
        field {
            name = "m0_wr_ostd";
            desc = "Write ID outstanding of AXI master 0. The value ranges from 1 to 15.";
            sw = rw; hw = r;
            reset = 0x1;
        } m0_wr_ostd[11:8];
        field {
            name = "m0_outstd_rid1";
            desc = "Read ID 1 outstanding of AXI master 0. The value ranges from 1 to 15.";
            sw = rw; hw = r;
            reset = 0x1;
        } m0_outstd_rid1[7:4];
        field {
            name = "m0_outstd_rid0";
            desc = "Read ID 0 outstanding of AXI master 0. The value ranges from 1 to 15.";
            sw = rw; hw = r;
            reset = 0x1;
        } m0_outstd_rid0[3:0];
    } VOAXICTRL @ 0x34;
    reg {
        name = "VORDLATENCY";
        desc = "VORDLATENCY is a maximum latency statistics register for the AXI read port. (offset 0x48; total reset 0x00000000; PROVEN: Hi3536D V100 data sheet (Issue 00B04, 2017-12-13), section 9.1.6, PDF page 504).";
        field {
            name = "rd_max_latency";
            desc = "Maximum latency statistics for the AXI read port";
            sw = r; hw = w;
            reset = 0x0;
        } rd_max_latency[31:0];
    } VORDLATENCY @ 0x48;
    reg {
        name = "VOWRLATENCY";
        desc = "VOWRLATENCY is a maximum latency statistics register for the AXI write port. (offset 0x4C; total reset 0x00000000; PROVEN: Hi3536D V100 data sheet (Issue 00B04, 2017-12-13), section 9.1.6, PDF page 505).";
        field {
            name = "wr_max_latency";
            desc = "Maximum latency statistics for the AXI write port";
            sw = r; hw = w;
            reset = 0x0;
        } wr_max_latency[31:0];
    } VOWRLATENCY @ 0x4C;
    reg {
        name = "VOLOWPOWER_CTRL";
        desc = "VOLOWPOWER_CTRL is a VDP low-power control register. (offset 0x60; total reset 0x0000D222; PROVEN: Hi3536D V100 data sheet (Issue 00B04, 2017-12-13), section 9.1.6, PDF page 505).";
        field {
            name = "reserved";
            desc = "Reserved";
            sw = r; hw = w;
            reset = 0x0;
        } reserved_31_16[31:16];
        field {
            name = "rft_colldisn";
            desc = "COLLDISN";
            sw = rw; hw = r;
            reset = 0x1;
        } rft_colldisn[15:15];
        field {
            name = "rft_ret1n";
            desc = "RFT_RET1N This bit must be set to 1.";
            sw = rw; hw = r;
            reset = 0x1;
        } rft_ret1n[14:14];
        field {
            name = "rft_emab";
            desc = "RFT_EMAB";
            sw = rw; hw = r;
            reset = 0x2;
        } rft_emab[13:11];
        field {
            name = "rft_emaa";
            desc = "RFT_EMAA";
            sw = rw; hw = r;
            reset = 0x2;
        } rft_emaa[10:8];
        field {
            name = "reserved";
            desc = "Reserved";
            sw = r; hw = w;
            reset = 0x0;
        } reserved_7_6[7:6];
        field {
            name = "rfs_ret1n";
            desc = "RFS_RET1N This bit must be set to 1.";
            sw = rw; hw = r;
            reset = 0x1;
        } rfs_ret1n[5:5];
        field {
            name = "rfs_emaw";
            desc = "RFS_EMAW";
            sw = rw; hw = r;
            reset = 0x0;
        } rfs_emaw[4:3];
        field {
            name = "rfs_ema";
            desc = "RFS_EMA";
            sw = rw; hw = r;
            reset = 0x2;
        } rfs_ema[2:0];
    } VOLOWPOWER_CTRL @ 0x60;
    reg {
        name = "VORDFRMLTC";
        desc = "VORDFRMLTC is a statistics register for the number of clock beats required for one frame of the AXI read port. (offset 0x70; total reset 0x00000000; PROVEN: Hi3536D V100 data sheet (Issue 00B04, 2017-12-13), section 9.1.6, PDF page 506).";
        field {
            name = "rd_frm_ltc";
            desc = "A statistics register for the number of clock beats required for one frame of the AXI read port";
            sw = r; hw = w;
            reset = 0x0;
        } rd_frm_ltc[31:0];
    } VORDFRMLTC @ 0x70;
    reg {
        name = "VORDFRMCMD";
        desc = "VORDFRMCMD is a statistics register for the number of commands in one frame of the AXI read port. (offset 0x74; total reset 0x00000000; PROVEN: Hi3536D V100 data sheet (Issue 00B04, 2017-12-13), section 9.1.6, PDF page 506).";
        field {
            name = "rd_frm_cmd";
            desc = "A statistics register for the number of commands in one frame of the AXI read port";
            sw = r; hw = w;
            reset = 0x0;
        } rd_frm_cmd[31:0];
    } VORDFRMCMD @ 0x74;
    reg {
        name = "VOWRFRMLTC";
        desc = "VOWRFRMLTC is a statistics register for the number of clock beats required for one frame of the AXI write port. (offset 0x78; total reset 0x00000000; PROVEN: Hi3536D V100 data sheet (Issue 00B04, 2017-12-13), section 9.1.6, PDF page 507).";
        field {
            name = "wr_frm_ltc";
            desc = "A statistics register for the number of clock beats required for one frame of the AXI write port";
            sw = r; hw = w;
            reset = 0x0;
        } wr_frm_ltc[31:0];
    } VOWRFRMLTC @ 0x78;
    reg {
        name = "VOWRFRMCMD";
        desc = "VORDFRMCMD is a statistics register for the number of commands in one frame of the AXI write port. (offset 0x7C; total reset 0x00000000; PROVEN: Hi3536D V100 data sheet (Issue 00B04, 2017-12-13), section 9.1.6, PDF page 507).";
        field {
            name = "wr_frm_cmd";
            desc = "A statistics register for the number of commands in one frame of the AXI write port";
            sw = r; hw = w;
            reset = 0x0;
        } wr_frm_cmd[31:0];
    } VOWRFRMCMD @ 0x7C;
    reg {
        name = "VO_MUX";
        desc = "VO_MUX is a VO interface multiplexing register. (offset 0x100; total reset 0x00000100; PROVEN: Hi3536D V100 data sheet (Issue 00B04, 2017-12-13), section 9.1.6, PDF page 507).";
        field {
            name = "reserved";
            desc = "Reserved";
            sw = r; hw = w;
            reset = 0x0;
        } reserved_31_16[31:16];
        field {
            name = "hdmi_sel";
            desc = "HDMI data select
- 0: reserved
- 1: DHD1 HDMI

This field must be set to 1 in this version.";
            sw = rw; hw = r;
            reset = 0x0;
        } hdmi_sel[15:12];
        field {
            name = "vga_sel";
            desc = "VGA data select
- 0: reserved
- 1: DHD1 VGA

This field must be set to 1 in this version.";
            sw = rw; hw = r;
            reset = 0x1;
        } vga_sel[11:8];
        field {
            name = "reserved";
            desc = "Reserved";
            sw = r; hw = w;
            reset = 0x0;
        } reserved_7_4[7:4];
        field {
            name = "reserved";
            desc = "Reserved";
            sw = r; hw = w;
            reset = 0x0;
        } reserved_3_0[3:0];
    } VO_MUX @ 0x100;
    reg {
        name = "VO_MUX_DAC";
        desc = "VO_MUX_DAC is a VO DAC interface multiplexing register. (offset 0x104; total reset 0x00000987; PROVEN: Hi3536D V100 data sheet (Issue 00B04, 2017-12-13), section 9.1.6, PDF page 508).";
        field {
            name = "reserved";
            desc = "Reserved";
            sw = r; hw = w;
            reset = 0x0;
        } reserved_31_12[31:12];
        field {
            name = "dac2_sel";
            desc = "DAC2 output selection. The default value is 0x0.
- 0x7: VGA video R component
- 0x8: VGA video G component
- 0x9: VGA video B component

Other values: reserved";
            sw = rw; hw = r;
            reset = 0x9;
        } dac2_sel[11:8];
        field {
            name = "dac1_sel";
            desc = "DAC1 output selection. The default value is 0x0.
- 0x7: VGA video R component
- 0x8: VGA video G component
- 0x9: VGA video B component

Other values: reserved";
            sw = rw; hw = r;
            reset = 0x8;
        } dac1_sel[7:4];
        field {
            name = "dac0_sel";
            desc = "DAC0 output selection. The default value is 0x0.
- 0x7: VGA video R component
- 0x8: VGA video G component
- 0x9: VGA video B component

Other values: reserved";
            sw = rw; hw = r;
            reset = 0x7;
        } dac0_sel[3:0];
    } VO_MUX_DAC @ 0x104;
    reg {
        name = "VO_MUX_TESTSYNC";
        desc = "VO_MUX_TESTSYNC is a VO interface test register. (offset 0x108; total reset 0x00000000; PROVEN: Hi3536D V100 data sheet (Issue 00B04, 2017-12-13), section 9.1.6, PDF page 509).";
        field {
            name = "vo_test_en";
            desc = "VDP output interface test mode enable
- 0: disabled
- 1: enabled";
            sw = rw; hw = r;
            reset = 0x0;
        } vo_test_en[31:31];
        field {
            name = "reserved";
            desc = "Reserved";
            sw = r; hw = w;
            reset = 0x0;
        } reserved_30_4[30:4];
        field {
            name = "test_field";
            desc = "Test value of the field signal";
            sw = rw; hw = r;
            reset = 0x0;
        } test_field[3:3];
        field {
            name = "test_vsync";
            desc = "Test value of the vsync signal";
            sw = rw; hw = r;
            reset = 0x0;
        } test_vsync[2:2];
        field {
            name = "test_hsync";
            desc = "Test value of the hsync signal";
            sw = rw; hw = r;
            reset = 0x0;
        } test_hsync[1:1];
        field {
            name = "test_dv";
            desc = "Test value of the dv signal";
            sw = rw; hw = r;
            reset = 0x0;
        } test_dv[0:0];
    } VO_MUX_TESTSYNC @ 0x108;
    reg {
        name = "VO_MUX_TESTDATA";
        desc = "VO_MUX_TESTDATA is a VO interface test data register. (offset 0x10C; total reset 0x00000000; PROVEN: Hi3536D V100 data sheet (Issue 00B04, 2017-12-13), section 9.1.6, PDF page 509).";
        field {
            name = "reserved";
            desc = "Reserved";
            sw = r; hw = w;
            reset = 0x0;
        } reserved_31_30[31:30];
        field {
            name = "test_data";
            desc = "Output data in test mode The output of DAC0-2 channels is the lower 10 bits of the register value.";
            sw = rw; hw = r;
            reset = 0x0;
        } test_data[29:0];
    } VO_MUX_TESTDATA @ 0x10C;
    reg {
        name = "VO_DAC_CTRL";
        desc = "VO_DAC_CTRL is a VO DAC control register. (offset 0x120; total reset 0x00000000; PROVEN: Hi3536D V100 data sheet (Issue 00B04, 2017-12-13), section 9.1.6, PDF page 510).";
        field {
            name = "reserved";
            desc = "Reserved";
            sw = r; hw = w;
            reset = 0x0;
        } reserved_31_23[31:23];
        field {
            name = "envbg";
            desc = "VBG reference voltage enable
- 0: disabled
- 1: enabled";
            sw = rw; hw = r;
            reset = 0x0;
        } envbg[22:22];
        field {
            name = "pdchopper";
            desc = "VBG chopper enable
- 0: enabled
- 1: disabled";
            sw = rw; hw = r;
            reset = 0x0;
        } pdchopper[21:21];
        field {
            name = "enextref";
            desc = "VBG output test enable
- 0: The internal VBG is used. The VBG is not output to the test pin.
- 1: The VBG is output for external tests.";
            sw = rw; hw = r;
            reset = 0x0;
        } enextref[20:20];
        field {
            name = "reserved";
            desc = "Reserved";
            sw = r; hw = w;
            reset = 0x0;
        } reserved_19_16[19:16];
        field {
            name = "dac_reg_rev";
            desc = "The test is reserved.";
            sw = rw; hw = r;
            reset = 0x0;
        } dac_reg_rev[15:0];
    } VO_DAC_CTRL @ 0x120;
    reg {
        name = "VO_DAC_R_CTRL";
        desc = "VO_DAC_R_CTRL is a VO DAC R channel control register. (offset 0x134; total reset 0x00000000; PROVEN: Hi3536D V100 data sheet (Issue 00B04, 2017-12-13), section 9.1.6, PDF page 511).";
        field {
            name = "endac";
            desc = "DAC enable
- 0: disabled
- 1: enabled";
            sw = rw; hw = r;
            reset = 0x0;
        } endac[31:31];
        field {
            name = "reserved";
            desc = "Reserved";
            sw = r; hw = w;
            reset = 0x0;
        } reserved_30_10[30:10];
        field {
            name = "dacgc";
            desc = "DAC output amplitude control The output voltage of the DAC at full scale ranges from 0.52 V to 1.37 V. The output amplitude is adjusted in 64 phases.";
            sw = rw; hw = r;
            reset = 0x0;
        } dacgc[9:4];
        field {
            name = "reserved";
            desc = "Reserved";
            sw = r; hw = w;
            reset = 0x0;
        } reserved_3_2[3:2];
        field {
            name = "cablectr";
            desc = "DAC VREF_CABLE reference voltage adjustment
- 00: normal by default
- 01: -10%
- 10: -20%
- 11: +10%";
            sw = rw; hw = r;
            reset = 0x0;
        } cablectr[1:0];
    } VO_DAC_R_CTRL @ 0x134;
    reg {
        name = "VO_DAC_G_CTRL";
        desc = "VO_DAC_G_CTRL is a VO DAC G channel control register. (offset 0x138; total reset 0x00000000; PROVEN: Hi3536D V100 data sheet (Issue 00B04, 2017-12-13), section 1.37, PDF page 512).";
        field {
            name = "dac_en";
            desc = "DAC enable
- 0: disabled
- 1: enabled";
            sw = rw; hw = r;
            reset = 0x0;
        } dac_en[31:31];
        field {
            name = "reserved";
            desc = "Reserved";
            sw = r; hw = w;
            reset = 0x0;
        } reserved_30_10[30:10];
        field {
            name = "dacgc";
            desc = "DAC output amplitude control The output voltage of the DAC at full scale ranges from 0.52 V to 1.37 V. The output amplitude is adjusted in 64 phases.";
            sw = rw; hw = r;
            reset = 0x0;
        } dacgc[9:4];
        field {
            name = "reserved";
            desc = "Reserved";
            sw = r; hw = w;
            reset = 0x0;
        } reserved_3_2[3:2];
        field {
            name = "cablectr";
            desc = "DAC VREF_CABLE reference voltage adjustment
- 00: normal by default
- 01: -10%
- 10: -20%
- 11: +10%";
            sw = rw; hw = r;
            reset = 0x0;
        } cablectr[1:0];
    } VO_DAC_G_CTRL @ 0x138;
    reg {
        name = "VO_DAC_B_CTRL";
        desc = "VO_DAC_B_CTRL is a VO DAC B channel control register. (offset 0x13C; total reset 0x00000000; PROVEN: Hi3536D V100 data sheet (Issue 00B04, 2017-12-13), section 1.37, PDF page 513).";
        field {
            name = "dac_en";
            desc = "DAC enable
- 0: disabled
- 1: enabled";
            sw = rw; hw = r;
            reset = 0x0;
        } dac_en[31:31];
        field {
            name = "reserved";
            desc = "Reserved";
            sw = r; hw = w;
            reset = 0x0;
        } reserved_30_10[30:10];
        field {
            name = "dacgc";
            desc = "DAC output amplitude control The output voltage of the DAC at full scale ranges from 0.52 V to 1.37 V. The output amplitude is adjusted in 64 phases.";
            sw = rw; hw = r;
            reset = 0x0;
        } dacgc[9:4];
        field {
            name = "reserved";
            desc = "Reserved";
            sw = r; hw = w;
            reset = 0x0;
        } reserved_3_2[3:2];
        field {
            name = "cablectr";
            desc = "DAC VREF_CABLE reference voltage adjustment
- 00: normal by default
- 01: -10%
- 10: -20%
- 11: +10%";
            sw = rw; hw = r;
            reset = 0x0;
        } cablectr[1:0];
    } VO_DAC_B_CTRL @ 0x13C;
    reg {
        name = "GDC_CORRESP";
        desc = "GDC_CORRESP is a graphics layer binding relationship register. (offset 0x30C; total reset 0x00011100; PROVEN: Hi3536D V100 data sheet (Issue 00B04, 2017-12-13), section 1.37, PDF page 513).";
        field {
            name = "reserved";
            desc = "Reserved";
            sw = r; hw = w;
            reset = 0x11;
        } reserved_31_12[31:12];
        field {
            name = "g2_corresp";
            desc = "G2 binding relationship
- 0x2: G2 is bound to MIXHD1.

Other values: reserved";
            sw = rw; hw = r;
            reset = 0x1;
        } g2_corresp[11:8];
        field {
            name = "reserved";
            desc = "Reserved";
            sw = r; hw = w;
            reset = 0x0;
        } reserved_7_0[7:0];
    } GDC_CORRESP @ 0x30C;
    reg {
        name = "V3_CTRL";
        desc = "V3_CTRL is a V3 configuration register (non-instant register). (offset 0x3800; total reset 0x00000400; PROVEN: Hi3536D V100 data sheet (Issue 00B04, 2017-12-13), section 1.37, PDF page 514).";
        field {
            name = "surface_en";
            desc = "Surface enable (non-instant register)
- 0: disabled
- 1: enabled";
            sw = rw; hw = r;
            reset = 0x0;
        } surface_en[31:31];
        field {
            name = "reserved";
            desc = "Reserved";
            sw = r; hw = w;
            reset = 0x0;
        } reserved_30_28[30:28];
        field {
            name = "mute_en";
            desc = "V3 mute enable (non-instant register)
- 0: disabled
- 1: enabled";
            sw = rw; hw = r;
            reset = 0x0;
        } mute_en[27:27];
        field {
            name = "reserved";
            desc = "Reserved";
            sw = r; hw = w;
            reset = 0x0;
        } reserved_26_20[26:20];
        field {
            name = "ifir_mode";
            desc = "Horizontal chrominance IFIR mode
- 00: reserved
- 01: chrominance IFIR replication mode
- 10: bilinear interpolation
- 11: 6-tap FIR";
            sw = rw; hw = r;
            reset = 0x0;
        } ifir_mode[19:18];
        field {
            name = "reserved";
            desc = "Reserved";
            sw = r; hw = w;
            reset = 0x0;
        } reserved_17_17[17:17];
        field {
            name = "reserved";
            desc = "Reserved";
            sw = r; hw = w;
            reset = 0x0;
        } reserved_16_16[16:16];
        field {
            name = "lm_rmode";
            desc = "Luminance read mode
- 00: The read mode is bound to the interface.
- 01: The frame buffer data is read in progressive mode.
- 10: The top field is read in interlaced mode.
- 11: The bottom field is read in interlaced mode.";
            sw = rw; hw = r;
            reset = 0x0;
        } lm_rmode[15:14];
        field {
            name = "chm_rmode";
            desc = "Chrominance read mode
- 00: The read mode is bound to the interface.
- 01: The frame buffer data is read in progressive mode.
- 10: The top field is read in interlaced mode.
- 11: The bottom field is read in interlaced mode.";
            sw = rw; hw = r;
            reset = 0x0;
        } chm_rmode[13:12];
        field {
            name = "reserved";
            desc = "Reserved";
            sw = r; hw = w;
            reset = 0x4;
        } reserved_11_8[11:8];
        field {
            name = "req_ctrl";
            desc = "Register for controlling the number of 16-burst requested consecutively at a time
- 0x0: One 16-burst is requested consecutively at a time.
- 0x1: Two 16-burst are requested consecutively at a time.

Other values: reserved";
            sw = rw; hw = r;
            reset = 0x0;
        } req_ctrl[7:5];
        field {
            name = "reserved";
            desc = "Reserved";
            sw = r; hw = w;
            reset = 0x0;
        } reserved_4_4[4:4];
        field {
            name = "ifmt";
            desc = "Format of the input data
- 0x3: semi-planar YCbCr420
- 0x4: semi-planar YCbCr422

Other values: reserved";
            sw = rw; hw = r;
            reset = 0x0;
        } ifmt[3:0];
    } V3_CTRL @ 0x3800;
    reg {
        name = "V3_UPD";
        desc = "V3_UPD is a V3 channel update enable register. (offset 0x3804; total reset 0x00000000; PROVEN: Hi3536D V100 data sheet (Issue 00B04, 2017-12-13), section 1.37, PDF page 515).";
        field {
            name = "reserved";
            desc = "Reserved";
            sw = r; hw = w;
            reset = 0x0;
        } reserved_31_1[31:1];
        field {
            name = "regup";
            desc = "Surface register update. After the registers at this layer are configured, the registers are updated when the value 1 is written to this bit. After updates, this bit is automatically cleared by the hardware.

Access type WC in the data sheet: written 1 clears the bit.";
            sw = rw; hw = w; onwrite = woclr;
            reset = 0x0;
        } regup[0:0];
    } V3_UPD @ 0x3804;
    reg {
        name = "V3_PRERD";
        desc = "V3_PRERD is a V3 prefetch enable register. (offset 0x3820; total reset 0x80000000; PROVEN: Hi3536D V100 data sheet (Issue 00B04, 2017-12-13), section 1.37, PDF page 516).";
        field {
            name = "pre_rd_en";
            desc = "Prefetch enable register
- 0: disabled
- 1: enabled";
            sw = rw; hw = r;
            reset = 0x1;
        } pre_rd_en[31:31];
        field {
            name = "reserved";
            desc = "Reserved";
            sw = r; hw = w;
            reset = 0x0;
        } reserved_30_0[30:0];
    } V3_PRERD @ 0x3820;
    reg {
        name = "V3_IRESO";
        desc = "V3_IRESO is a V3 input resolution register (non-instant register). (offset 0x3828; total reset 0x00000000; PROVEN: Hi3536D V100 data sheet (Issue 00B04, 2017-12-13), section 1.37, PDF page 516).";
        field {
            name = "reserved";
            desc = "Reserved";
            sw = r; hw = w;
            reset = 0x0;
        } reserved_31_24[31:24];
        field {
            name = "ih";
            desc = "Height (in line). The value is the actual height minus 1. The frame height is referenced and the unit is line.";
            sw = rw; hw = r;
            reset = 0x0;
        } ih[23:12];
        field {
            name = "iw";
            desc = "Width (in pixel). The value is the actual width minus 1.";
            sw = rw; hw = r;
            reset = 0x0;
        } iw[11:0];
    } V3_IRESO @ 0x3828;
    reg {
        name = "V3_ORESO";
        desc = "V3_ORESO is a V3 output resolution register (non-instant register). (offset 0x382C; total reset 0x00000000; PROVEN: Hi3536D V100 data sheet (Issue 00B04, 2017-12-13), section 1.37, PDF page 517).";
        field {
            name = "reserved";
            desc = "Reserved";
            sw = r; hw = w;
            reset = 0x0;
        } reserved_31_24[31:24];
        field {
            name = "oh";
            desc = "Height (in line). The value is the actual height minus 1. The frame height is referenced and the unit is line.";
            sw = rw; hw = r;
            reset = 0x0;
        } oh[23:12];
        field {
            name = "ow";
            desc = "Width (in pixel). The value is the actual width minus 1.";
            sw = rw; hw = r;
            reset = 0x0;
        } ow[11:0];
    } V3_ORESO @ 0x382C;
    reg {
        name = "V3_CBMPARA";
        desc = "V3_CBMPARA is a V3 overlay parameter register (non-instant register). (offset 0x3838; total reset 0x00000000; PROVEN: Hi3536D V100 data sheet (Issue 00B04, 2017-12-13), section 1.37, PDF page 517).";
        field {
            name = "reserved";
            desc = "Reserved";
            sw = r; hw = w;
            reset = 0x0;
        } reserved_31_8[31:8];
        field {
            name = "galpha";
            desc = "Overlay global alpha value. The value ranges from 0 to 128. The value 128 indicates opaque, and the value 0 indicates full transparent.";
            sw = rw; hw = r;
            reset = 0x0;
        } galpha[7:0];
    } V3_CBMPARA @ 0x3838;
    reg {
        name = "V3_CSC_IDC";
        desc = "V3_CSC_IDC is a V3 CSC input DC component register (instant register). (offset 0x3880; total reset 0x00000000; PROVEN: Hi3536D V100 data sheet (Issue 00B04, 2017-12-13), section 1.37, PDF page 518).";
        field {
            name = "reserved";
            desc = "Reserved";
            sw = r; hw = w;
            reset = 0x0;
        } reserved_31_27[31:27];
        field {
            name = "csc_mode";
            desc = "This field is valid only when the CSC coefficients of V1 and V3 are fixed.
- 0x8: YUV_709_LIMIT_2_YUV_709_FULL
- 0x9: YUV_601_LIMIT_2_YUV_709_FULL
- 0xA: YUV_709_FULL_2_YUV_709_FULL
- 0xB: YUV_601_FULL_2_YUV_709_FULL

Other values: reserved";
            sw = rw; hw = r;
            reset = 0x0;
        } csc_mode[26:23];
        field {
            name = "csc_en";
            desc = "CSC enable.
- 0: disabled
- 1: enabled";
            sw = rw; hw = r;
            reset = 0x0;
        } csc_en[22:22];
        field {
            name = "cscidc1";
            desc = "DC parameter of the input 1 component. The MSB is the signed bit. The coefficient is represented by a complement.";
            sw = rw; hw = r;
            reset = 0x0;
        } cscidc1[21:11];
        field {
            name = "cscidc0";
            desc = "DC parameter of the input 0 component. The MSB is the signed bit. The coefficient is represented by a complement.";
            sw = rw; hw = r;
            reset = 0x0;
        } cscidc0[10:0];
    } V3_CSC_IDC @ 0x3880;
    reg {
        name = "V3_CSC_ODC";
        desc = "V3_CSC_ODC is a V3 CSC output DC component register (instant register). (offset 0x3884; total reset 0x00000000; PROVEN: Hi3536D V100 data sheet (Issue 00B04, 2017-12-13), section 1.37, PDF page 519).";
        field {
            name = "reserved";
            desc = "Reserved";
            sw = r; hw = w;
            reset = 0x0;
        } reserved_31_23[31:23];
        field {
            name = "csc_sign_mode";
            desc = "CSC output mode
- 0: The CSC output is a 10-bit unsigned number.
- 1: The CSC output is a 12-bit signed number.";
            sw = rw; hw = r;
            reset = 0x0;
        } csc_sign_mode[22:22];
        field {
            name = "cscodc1";
            desc = "DC parameter of output component 1. The MSB is the signed bit. The value is expressed as a complement.";
            sw = rw; hw = r;
            reset = 0x0;
        } cscodc1[21:11];
        field {
            name = "cscodc0";
            desc = "DC parameter of output component 0. The MSB is the signed bit. The value is expressed as a complement.";
            sw = rw; hw = r;
            reset = 0x0;
        } cscodc0[10:0];
    } V3_CSC_ODC @ 0x3884;
    reg {
        name = "V3_CSC_IODC";
        desc = "V3_CSC_IODC is a CSC input/output DC component register (instant register). (offset 0x3888; total reset 0x00000000; PROVEN: Hi3536D V100 data sheet (Issue 00B04, 2017-12-13), section 1.37, PDF page 519).";
        field {
            name = "reserved";
            desc = "Reserved";
            sw = r; hw = w;
            reset = 0x0;
        } reserved_31_22[31:22];
        field {
            name = "cscodc2";
            desc = "DC parameter of output component 2. The MSB is the signed bit. The value is expressed as a complement.";
            sw = r; hw = w;
            reset = 0x0;
        } cscodc2[21:11];
        field {
            name = "cscidc2";
            desc = "DC parameter of input component 2. The MSB is the signed bit. The value is expressed as a complement.";
            sw = r; hw = w;
            reset = 0x0;
        } cscidc2[10:0];
    } V3_CSC_IODC @ 0x3888;
    reg {
        name = "V3_CSC_P0";
        desc = "V3_CSC_P0 is a CSC parameter 0 register (instant register). (offset 0x388C; total reset 0x00000000; PROVEN: Hi3536D V100 data sheet (Issue 00B04, 2017-12-13), section 1.37, PDF page 520).";
        field {
            name = "reserved";
            desc = "Reserved";
            sw = r; hw = w;
            reset = 0x0;
        } reserved_31_31[31:31];
        field {
            name = "cscp01";
            desc = "s(5.10) data format: signed number, 1 sign bit, 4 integer bits, and 10 decimal bits. The value is represented by a complement.";
            sw = r; hw = w;
            reset = 0x0;
        } cscp01[30:16];
        field {
            name = "reserved";
            desc = "Reserved";
            sw = r; hw = w;
            reset = 0x0;
        } reserved_15_15[15:15];
        field {
            name = "cscp00";
            desc = "s(5.10) data format: signed number, 1 sign bit, 4 integer bits, and 10 decimal bits. The value is represented by a complement.";
            sw = r; hw = w;
            reset = 0x0;
        } cscp00[14:0];
    } V3_CSC_P0 @ 0x388C;
    reg {
        name = "V3_CSC_P1";
        desc = "V3_CSC_P1 is a CSC parameter 1 register (instant register). (offset 0x3890; total reset 0x00000000; PROVEN: Hi3536D V100 data sheet (Issue 00B04, 2017-12-13), section 1.37, PDF page 520).";
        field {
            name = "reserved";
            desc = "Reserved";
            sw = r; hw = w;
            reset = 0x0;
        } reserved_31_31[31:31];
        field {
            name = "cscp10";
            desc = "s(5.10) data format: signed number, 1 sign bit, 4 integer bits, and 10 decimal bits. The value is represented by a complement.";
            sw = r; hw = w;
            reset = 0x0;
        } cscp10[30:16];
        field {
            name = "reserved";
            desc = "Reserved";
            sw = r; hw = w;
            reset = 0x0;
        } reserved_15_15[15:15];
        field {
            name = "cscp02";
            desc = "s(5.10) data format: signed number, 1 sign bit, 4 integer bits, and 10 decimal bits. The value is represented by a complement.";
            sw = r; hw = w;
            reset = 0x0;
        } cscp02[14:0];
    } V3_CSC_P1 @ 0x3890;
    reg {
        name = "V3_CSC_P2";
        desc = "V3_CSC_P2 is a CSC parameter 2 register (instant register). (offset 0x3894; total reset 0x00000000; PROVEN: Hi3536D V100 data sheet (Issue 00B04, 2017-12-13), section 1.37, PDF page 521).";
        field {
            name = "reserved";
            desc = "Reserved";
            sw = r; hw = w;
            reset = 0x0;
        } reserved_31_31[31:31];
        field {
            name = "cscp12";
            desc = "s(5.10) data format: signed number, 1 sign bit, 4 integer bits, and 10 decimal bits. The value is represented by a complement.";
            sw = r; hw = w;
            reset = 0x0;
        } cscp12[30:16];
        field {
            name = "reserved";
            desc = "Reserved";
            sw = r; hw = w;
            reset = 0x0;
        } reserved_15_15[15:15];
        field {
            name = "cscp11";
            desc = "s(5.10) data format: signed number, 1 sign bit, 4 integer bits, and 10 decimal bits. The value is represented by a complement.";
            sw = r; hw = w;
            reset = 0x0;
        } cscp11[14:0];
    } V3_CSC_P2 @ 0x3894;
    reg {
        name = "V3_CSC_P3";
        desc = "V3_CSC_P3 is a CSC parameter 3 register (instant register). (offset 0x3898; total reset 0x00000000; PROVEN: Hi3536D V100 data sheet (Issue 00B04, 2017-12-13), section 1.37, PDF page 521).";
        field {
            name = "reserved";
            desc = "Reserved";
            sw = r; hw = w;
            reset = 0x0;
        } reserved_31_31[31:31];
        field {
            name = "cscp21";
            desc = "s(5.10) data format: signed number, 1 sign bit, 4 integer bits, and 10 decimal bits. The value is represented by a complement.";
            sw = r; hw = w;
            reset = 0x0;
        } cscp21[30:16];
        field {
            name = "reserved";
            desc = "Reserved";
            sw = r; hw = w;
            reset = 0x0;
        } reserved_15_15[15:15];
        field {
            name = "cscp20";
            desc = "s(5.10) data format: signed number, 1 sign bit, 4 integer bits, and 10 decimal bits. The value is represented by a complement.";
            sw = r; hw = w;
            reset = 0x0;
        } cscp20[14:0];
    } V3_CSC_P3 @ 0x3898;
    reg {
        name = "V3_CSC_P4";
        desc = "V3_CSC_P4 is a CSC parameter 4 register (instant register). (offset 0x389C; total reset 0x00000000; PROVEN: Hi3536D V100 data sheet (Issue 00B04, 2017-12-13), section 1.37, PDF page 522).";
        field {
            name = "reserved";
            desc = "Reserved";
            sw = r; hw = w;
            reset = 0x0;
        } reserved_31_15[31:15];
        field {
            name = "cscp22";
            desc = "s(5.10) data format: signed number, 1 sign bit, 4 integer bits, and 10 decimal bits. The value is represented by a complement.";
            sw = r; hw = w;
            reset = 0x0;
        } cscp22[14:0];
    } V3_CSC_P4 @ 0x389C;
    reg {
        name = "V3_VSP";
        desc = "V3_VSP is a V3 vertical scaling parameter register. (offset 0x38D8; total reset 0x00000000; PROVEN: Hi3536D V100 data sheet (Issue 00B04, 2017-12-13), section 1.37, PDF page 522).";
        field {
            name = "reserved";
            desc = "Reserved";
            sw = r; hw = w;
            reset = 0x0;
        } reserved_31_31[31:31];
        field {
            name = "vchmsc_en";
            desc = "Vertical chrominance scaling enable
- 0: disabled
- 1: enabled";
            sw = rw; hw = r;
            reset = 0x0;
        } vchmsc_en[30:30];
        field {
            name = "reserved";
            desc = "Reserved";
            sw = r; hw = w;
            reset = 0x0;
        } reserved_29_29[29:29];
        field {
            name = "vchmid_en";
            desc = "Median filtering enable for vertical chrominance scaling. This bit is invalid when vchfir_en is invalid.
- 0: disabled
- 1: enabled";
            sw = rw; hw = r;
            reset = 0x0;
        } vchmid_en[28:28];
        field {
            name = "reserved";
            desc = "Reserved";
            sw = r; hw = w;
            reset = 0x0;
        } reserved_27_27[27:27];
        field {
            name = "vsc_chroma_tap";
            desc = "Vertical chrominance scaling tap
- 0: 4-tap FIR
- 1: 2-tap FIR";
            sw = rw; hw = r;
            reset = 0x0;
        } vsc_chroma_tap[26:26];
        field {
            name = "reserved";
            desc = "Reserved";
            sw = r; hw = w;
            reset = 0x0;
        } reserved_25_25[25:25];
        field {
            name = "reserved";
            desc = "Reserved";
            sw = r; hw = w;
            reset = 0x0;
        } reserved_24_24[24:24];
        field {
            name = "vchfir_en";
            desc = "Vertical chrominance scaling mode
- 0: replication mode (filtering disabled)
- 1: filtering mode (filtering enabled)";
            sw = rw; hw = r;
            reset = 0x0;
        } vchfir_en[23:23];
        field {
            name = "zme_out_fmt";
            desc = "Output data format for scaling
- 0: semi-planar YCbCr 422
- 1: semi-planar YCbCr 420";
            sw = rw; hw = r;
            reset = 0x0;
        } zme_out_fmt[22:21];
        field {
            name = "zme_in_fmt";
            desc = "Input data format for scaling
- 0: semi-planar YCbCr 422
- 1: semi-planar YCbCr 420";
            sw = rw; hw = r;
            reset = 0x0;
        } zme_in_fmt[20:19];
        field {
            name = "reserved";
            desc = "Reserved";
            sw = r; hw = w;
            reset = 0x0;
        } reserved_18_0[18:0];
    } V3_VSP @ 0x38D8;
    reg {
        name = "V3_VSR";
        desc = "V3_VSR is a vertical luminance scaling ratio register (non-instant register). Scaling ratio = Input height/Output height (offset 0x38DC; total reset 0x00001000; PROVEN: Hi3536D V100 data sheet (Issue 00B04, 2017-12-13), section 1.37, PDF page 523).";
        field {
            name = "reserved";
            desc = "Reserved";
            sw = r; hw = w;
            reset = 0x0;
        } reserved_31_16[31:16];
        field {
            name = "vratio";
            desc = "Vertical scaling ratio u(4.12) data format: unsigned number, 4 integer bits, and 12 decimal bits. The value is expressed as a complement.";
            sw = rw; hw = r;
            reset = 0x1000;
        } vratio[15:0];
    } V3_VSR @ 0x38DC;
    reg {
        name = "V3_VOFFSET";
        desc = "V3_VOFFSET is a V3 vertical luminance scaling offset register. The vertical scaling offset is affected by the field offset during pan-scan and the field offset when repeated frames occur. If no field offset occurs, vluma_offset is the lowest integral part plus the decimal part of offset_pan-scan. In YCbCr422 format, vchroma_offset is equal to vluma_offset; in YCbCr420 format, vchroma_offset is calculated as follows: vchroma_offset = scaling_chroma/2 - 0.25. If the field offset is required (such as static frames or repeated frames) and the bottom field is repeated, the values of vluma_offset and vchroma_offset configured for the top field are the same as those in the case of no field offset. The field offset must be considered when coefficients are configured for the bottom field. (offset 0x38E0; total reset 0x00000000; PROVEN: Hi3536D V100 data sheet (Issue 00B04, 2017-12-13), section 1.37, PDF page 524).";
        field {
            name = "vluma_offset";
            desc = "Vertical luminance offset s(4.12) data format: signed number, 1 sign bit, 3 integer bits, and 12 decimal bits. The value is expressed as a complement.";
            sw = rw; hw = r;
            reset = 0x0;
        } vluma_offset[31:16];
        field {
            name = "vchroma_offset";
            desc = "Vertical chrominance offset s(4.12) data format: signed number, 1 sign bit, 3 integer bits, and 12 decimal bits. The value is expressed as a complement.";
            sw = rw; hw = r;
            reset = 0x0;
        } vchroma_offset[15:0];
    } V3_VOFFSET @ 0x38E0;
    reg {
        name = "V3_VBOFFSET";
        desc = "V3_VBOFFSET is a V3 vertical luminance scaling offset register for the bottom field. The vertical scaling offset is affected by the field offset during pan-scan and the field offset when repeated frames occur. If no field offset occurs, vluma_offset is the lowest integral part plus the decimal part of offset_pan-scan. In YCbCr422 format, vchroma_offset is equal to vluma_offset; in YCbCr420 format, vchroma_offset is calculated as follows: vchroma_offset = scaling_chroma/2 - 0.25. If the field offset is required (such as static frames or repeated frames) and the bottom field is repeated, the values of vluma_offset and vchroma_offset configured for the top field are the same as those in the case of no field offset. The field offset must be considered when coefficients are configured for the bottom field. (offset 0x38E4; total reset 0x00000000; PROVEN: Hi3536D V100 data sheet (Issue 00B04, 2017-12-13), section 1.37, PDF page 525).";
        field {
            name = "vbluma_offset";
            desc = "Vertical luminance offset s(4.12) data format: signed number, 1 sign bit, 3 integer bits, and 12 decimal bits. The value is expressed as a complement.";
            sw = rw; hw = r;
            reset = 0x0;
        } vbluma_offset[31:16];
        field {
            name = "vbchroma_offset";
            desc = "Vertical chrominance offset s(4.12) data format: signed number, 1 sign bit, 3 integer bits, and 12 decimal bits. The value is expressed as a complement.";
            sw = rw; hw = r;
            reset = 0x0;
        } vbchroma_offset[15:0];
    } V3_VBOFFSET @ 0x38E4;
    reg {
        name = "V3_VCOEF0";
        desc = "V3_VCOEF0 is a V3 scaling vertical coefficient 0 register. (offset 0x38F0; total reset 0x0007FC00; PROVEN: Hi3536D V100 data sheet (Issue 00B04, 2017-12-13), section 1.37, PDF page 525).";
        field {
            name = "reserved";
            desc = "Reserved";
            sw = r; hw = w;
            reset = 0x0;
        } reserved_31_30[31:30];
        field {
            name = "vccoef00";
            desc = "Vertical chrominance scaling phase 0 coefficient 0";
            sw = rw; hw = r;
            reset = 0x0;
        } vccoef00[29:20];
        field {
            name = "vccoef01";
            desc = "Vertical chrominance scaling phase 0 coefficient 1";
            sw = rw; hw = r;
            reset = 0x1ff;
        } vccoef01[19:10];
        field {
            name = "vccoef02";
            desc = "Vertical chrominance scaling phase 0 coefficient 2";
            sw = rw; hw = r;
            reset = 0x0;
        } vccoef02[9:0];
    } V3_VCOEF0 @ 0x38F0;
    reg {
        name = "V3_VCOEF1";
        desc = "V3_VCOEF1 is a V3 scaling vertical coefficient 1 register. (offset 0x38F4; total reset 0x000EB553; PROVEN: Hi3536D V100 data sheet (Issue 00B04, 2017-12-13), section 1.37, PDF page 526).";
        field {
            name = "reserved";
            desc = "Reserved";
            sw = r; hw = w;
            reset = 0x0;
        } reserved_31_30[31:30];
        field {
            name = "vccoef03";
            desc = "Vertical chrominance scaling phase 0 coefficient 3";
            sw = rw; hw = r;
            reset = 0x0;
        } vccoef03[29:20];
        field {
            name = "vccoef10";
            desc = "Vertical chrominance scaling phase 0.5 coefficient 0";
            sw = rw; hw = r;
            reset = 0x3ad;
        } vccoef10[19:10];
        field {
            name = "vccoef11";
            desc = "Vertical chrominance scaling phase 0.5 coefficient 1";
            sw = rw; hw = r;
            reset = 0x153;
        } vccoef11[9:0];
    } V3_VCOEF1 @ 0x38F4;
    reg {
        name = "V3_VCOEF2";
        desc = "V3_VCOEF2 is a V3 scaling vertical coefficient 2 register. (offset 0x38F8; total reset 0x00054FAD; PROVEN: Hi3536D V100 data sheet (Issue 00B04, 2017-12-13), section 1.37, PDF page 526).";
        field {
            name = "reserved";
            desc = "Reserved";
            sw = r; hw = w;
            reset = 0x0;
        } reserved_31_20[31:20];
        field {
            name = "vccoef12";
            desc = "Vertical chrominance scaling phase 0.5 coefficient 2";
            sw = rw; hw = r;
            reset = 0x153;
        } vccoef12[19:10];
        field {
            name = "vccoef13";
            desc = "Vertical chrominance scaling phase 0.5 coefficient 3";
            sw = rw; hw = r;
            reset = 0x3ad;
        } vccoef13[9:0];
    } V3_VCOEF2 @ 0x38F8;
    reg {
        name = "V3_DFPOS";
        desc = "V3_DFPOS is a V3 surface start position (in the display window) register (non-instant register). The position unit is pixel. (offset 0x3900; total reset 0x00000000; PROVEN: Hi3536D V100 data sheet (Issue 00B04, 2017-12-13), section 1.37, PDF page 527).";
        field {
            name = "reserved";
            desc = "Reserved";
            sw = r; hw = w;
            reset = 0x0;
        } reserved_31_24[31:24];
        field {
            name = "disp_yfpos";
            desc = "Start coordinates of the display column The frame height is referenced and the unit is line.";
            sw = rw; hw = r;
            reset = 0x0;
        } disp_yfpos[23:12];
        field {
            name = "disp_xfpos";
            desc = "Start coordinates of the display row";
            sw = rw; hw = r;
            reset = 0x0;
        } disp_xfpos[11:0];
    } V3_DFPOS @ 0x3900;
    reg {
        name = "V3_DLPOS";
        desc = "V3_DLPOS is a V3 surface end position (in the display window) register (non-instant register). The position unit is pixel. (offset 0x3904; total reset 0x00000000; PROVEN: Hi3536D V100 data sheet (Issue 00B04, 2017-12-13), section 1.37, PDF page 527).";
        field {
            name = "reserved";
            desc = "Reserved";
            sw = r; hw = w;
            reset = 0x0;
        } reserved_31_24[31:24];
        field {
            name = "disp_ylpos";
            desc = "End coordinates of the display column The frame height is referenced and the unit is line.";
            sw = rw; hw = r;
            reset = 0x0;
        } disp_ylpos[23:12];
        field {
            name = "disp_xlpos";
            desc = "End coordinates of the display row";
            sw = rw; hw = r;
            reset = 0x0;
        } disp_xlpos[11:0];
    } V3_DLPOS @ 0x3904;
    reg {
        name = "V3_VFPOS";
        desc = "V3_VFPOS is a V3 surface content start position (in the display window) register (non-instant register). The position unit is pixel. (offset 0x3908; total reset 0x00000000; PROVEN: Hi3536D V100 data sheet (Issue 00B04, 2017-12-13), section 1.37, PDF page 528).";
        field {
            name = "reserved";
            desc = "Reserved";
            sw = r; hw = w;
            reset = 0x0;
        } reserved_31_24[31:24];
        field {
            name = "video_yfpos";
            desc = "Start coordinates of the video column The frame height is referenced and the unit is line.";
            sw = rw; hw = r;
            reset = 0x0;
        } video_yfpos[23:12];
        field {
            name = "video_xfpos";
            desc = "Start coordinates of the video row";
            sw = rw; hw = r;
            reset = 0x0;
        } video_xfpos[11:0];
    } V3_VFPOS @ 0x3908;
    reg {
        name = "V3_VLPOS";
        desc = "V3_VLPOS is a V3 surface content end position (in the display window) register (non-instant register). The position unit is pixel. (offset 0x390C; total reset 0x00000000; PROVEN: Hi3536D V100 data sheet (Issue 00B04, 2017-12-13), section 1.37, PDF page 528).";
        field {
            name = "reserved";
            desc = "Reserved";
            sw = r; hw = w;
            reset = 0x0;
        } reserved_31_24[31:24];
        field {
            name = "video_ylpos";
            desc = "End coordinates of the video column The frame height is referenced and the unit is line.";
            sw = rw; hw = r;
            reset = 0x0;
        } video_ylpos[23:12];
        field {
            name = "video_xlpos";
            desc = "End coordinates of the video row";
            sw = rw; hw = r;
            reset = 0x0;
        } video_xlpos[11:0];
    } V3_VLPOS @ 0x390C;
    reg {
        name = "V3_BK";
        desc = "V3_BK is a V3 background color register. (offset 0x3910; total reset 0x00000000; PROVEN: Hi3536D V100 data sheet (Issue 00B04, 2017-12-13), section 1.37, PDF page 529).";
        field {
            name = "reserved";
            desc = "Reserved";
            sw = r; hw = w;
            reset = 0x0;
        } reserved_31_30[31:30];
        field {
            name = "vbk_y";
            desc = "Y component";
            sw = rw; hw = r;
            reset = 0x0;
        } vbk_y[29:20];
        field {
            name = "vbk_cb";
            desc = "Cb component";
            sw = rw; hw = r;
            reset = 0x0;
        } vbk_cb[19:10];
        field {
            name = "vbk_cr";
            desc = "Cr component";
            sw = rw; hw = r;
            reset = 0x0;
        } vbk_cr[9:0];
    } V3_BK @ 0x3910;
    reg {
        name = "V3_ALPHA";
        desc = "V3_ALPHA is a V3 background filling color alpha register. (offset 0x3914; total reset 0x00000000; PROVEN: Hi3536D V100 data sheet (Issue 00B04, 2017-12-13), section 1.37, PDF page 529).";
        field {
            name = "reserved";
            desc = "Reserved";
            sw = r; hw = w;
            reset = 0x0;
        } reserved_31_8[31:8];
        field {
            name = "vbk_alpha";
            desc = "Levels 0-255 of the background filling color for the video layer";
            sw = rw; hw = r;
            reset = 0x0;
        } vbk_alpha[7:0];
    } V3_ALPHA @ 0x3914;
    reg {
        name = "V3_RIMWIDTH";
        desc = "V3_RIMWIDTH is a V3 RIM width register (non-instant register). (offset 0x3918; total reset 0x00000000; PROVEN: Hi3536D V100 data sheet (Issue 00B04, 2017-12-13), section 1.37, PDF page 530).";
        field {
            name = "reserved";
            desc = "Reserved";
            sw = r; hw = w;
            reset = 0x0;
        } reserved_31_3[31:3];
        field {
            name = "v3_rim_width";
            desc = "Thickness of all the region borders
- 00: The border width is 0.
- 01: The border width is 1.
- 10: The border width is 2.
- 11: The border width is 4.";
            sw = rw; hw = r;
            reset = 0x0;
        } v3_rim_width[2:0];
    } V3_RIMWIDTH @ 0x3918;
    reg {
        name = "V3_RIMCOL0";
        desc = "V3_RIMCOL0 is a RIM color 0 register (non-instant register) for the upper 32 regions at the V3 video layer. (offset 0x391C; total reset 0x00000000; PROVEN: Hi3536D V100 data sheet (Issue 00B04, 2017-12-13), section 1.37, PDF page 530).";
        field {
            name = "reserved";
            desc = "Reserved";
            sw = rw; hw = r;
            reset = 0x0;
        } reserved_31_30[31:30];
        field {
            name = "v3_rim_y0";
            desc = "RIM color 0, R component";
            sw = rw; hw = r;
            reset = 0x0;
        } v3_rim_y0[29:20];
        field {
            name = "v3_rim_u0";
            desc = "RIM color 0, G component";
            sw = rw; hw = r;
            reset = 0x0;
        } v3_rim_u0[19:10];
        field {
            name = "v3_rim_v0";
            desc = "RIM color 0, B component";
            sw = rw; hw = r;
            reset = 0x0;
        } v3_rim_v0[9:0];
    } V3_RIMCOL0 @ 0x391C;
    reg {
        name = "V3_RIMCOL1";
        desc = "V3_RIMCOL1 is a RIM color 1 register (non-instant register) for the upper 32 regions at the V3 video layer. (offset 0x3920; total reset 0x00000000; PROVEN: Hi3536D V100 data sheet (Issue 00B04, 2017-12-13), section 1.37, PDF page 531).";
        field {
            name = "reserved";
            desc = "Reserved";
            sw = rw; hw = r;
            reset = 0x0;
        } reserved_31_30[31:30];
        field {
            name = "v3_rim_y1";
            desc = "RIM color 1, R component";
            sw = rw; hw = r;
            reset = 0x0;
        } v3_rim_y1[29:20];
        field {
            name = "v3_rim_u1";
            desc = "RIM color 1, G component";
            sw = rw; hw = r;
            reset = 0x0;
        } v3_rim_u1[19:10];
        field {
            name = "v3_rim_v1";
            desc = "RIM color 1, B component";
            sw = rw; hw = r;
            reset = 0x0;
        } v3_rim_v1[9:0];
    } V3_RIMCOL1 @ 0x3920;
    reg {
        name = "V3_IFIRCOEF01";
        desc = "V3_IFIRCOEF01 is an IFIR filtering coefficient 0/1 register. (offset 0x3980; total reset 0x000F03F5; PROVEN: Hi3536D V100 data sheet (Issue 00B04, 2017-12-13), section 1.37, PDF page 531).";
        field {
            name = "reserved";
            desc = "Reserved";
            sw = r; hw = w;
            reset = 0x0;
        } reserved_31_26[31:26];
        field {
            name = "coef1";
            desc = "IFIR filtering coefficient 1";
            sw = rw; hw = r;
            reset = 0xf;
        } coef1[25:16];
        field {
            name = "reserved";
            desc = "Reserved";
            sw = r; hw = w;
            reset = 0x0;
        } reserved_15_10[15:10];
        field {
            name = "coef0";
            desc = "IFIR filtering coefficient 0";
            sw = rw; hw = r;
            reset = 0x3f5;
        } coef0[9:0];
    } V3_IFIRCOEF01 @ 0x3980;
    reg {
        name = "V3_IFIRCOEF23";
        desc = "V3_IFIRCOEF23 is an IFIR filtering coefficient 2/3 register. (offset 0x3984; total reset 0x001C03EC; PROVEN: Hi3536D V100 data sheet (Issue 00B04, 2017-12-13), section 1.37, PDF page 532).";
        field {
            name = "reserved";
            desc = "Reserved";
            sw = r; hw = w;
            reset = 0x0;
        } reserved_31_26[31:26];
        field {
            name = "coef3";
            desc = "IFIR filtering coefficient 3";
            sw = rw; hw = r;
            reset = 0x1c;
        } coef3[25:16];
        field {
            name = "reserved";
            desc = "Reserved";
            sw = r; hw = w;
            reset = 0x0;
        } reserved_15_10[15:10];
        field {
            name = "coef2";
            desc = "IFIR filtering coefficient 2";
            sw = rw; hw = r;
            reset = 0x3ec;
        } coef2[9:0];
    } V3_IFIRCOEF23 @ 0x3984;
    reg {
        name = "V3_IFIRCOEF45";
        desc = "V3_IFIRCOEF45 is an IFIR filtering coefficient 4/5 register. (offset 0x3988; total reset 0x003D03D8; PROVEN: Hi3536D V100 data sheet (Issue 00B04, 2017-12-13), section 1.37, PDF page 532).";
        field {
            name = "reserved";
            desc = "Reserved";
            sw = r; hw = w;
            reset = 0x0;
        } reserved_31_26[31:26];
        field {
            name = "coef5";
            desc = "IFIR filtering coefficient 5";
            sw = rw; hw = r;
            reset = 0x3d;
        } coef5[25:16];
        field {
            name = "reserved";
            desc = "Reserved";
            sw = r; hw = w;
            reset = 0x0;
        } reserved_15_10[15:10];
        field {
            name = "coef4";
            desc = "IFIR filtering coefficient 4";
            sw = rw; hw = r;
            reset = 0x3d8;
        } coef4[9:0];
    } V3_IFIRCOEF45 @ 0x3988;
    reg {
        name = "V3_IFIRCOEF67";
        desc = "V3_IFIRCOEF67 is an IFIR filtering coefficient 6/7 register. (offset 0x398C; total reset 0x014A0395; PROVEN: Hi3536D V100 data sheet (Issue 00B04, 2017-12-13), section 1.37, PDF page 533).";
        field {
            name = "reserved";
            desc = "Reserved";
            sw = r; hw = w;
            reset = 0x0;
        } reserved_31_26[31:26];
        field {
            name = "coef7";
            desc = "IFIR filtering coefficient 7";
            sw = rw; hw = r;
            reset = 0x14a;
        } coef7[25:16];
        field {
            name = "reserved";
            desc = "Reserved";
            sw = r; hw = w;
            reset = 0x0;
        } reserved_15_10[15:10];
        field {
            name = "coef6";
            desc = "IFIR filtering coefficient 6";
            sw = rw; hw = r;
            reset = 0x395;
        } coef6[9:0];
    } V3_IFIRCOEF67 @ 0x398C;
    reg {
        name = "V3_P0RESO";
        desc = "V3_P0RESO is V3 region 0 resolution register (non-instant register). (offset 0x3A00; total reset 0x00000000; PROVEN: Hi3536D V100 data sheet (Issue 00B04, 2017-12-13), section 1.37, PDF page 533).";
        field {
            name = "reserved";
            desc = "Reserved";
            sw = r; hw = w;
            reset = 0x0;
        } reserved_31_12[31:12];
        field {
            name = "w";
            desc = "Width (in pixel). The value is the actual width minus 1. Note: The actual width must be an even number.";
            sw = rw; hw = r;
            reset = 0x0;
        } w_f[11:0];
    } V3_P0RESO @ 0x3A00;
    reg {
        name = "V3_P0LADDR";
        desc = "V3_P0LADDR is a V3 region 0 luminance address register. (offset 0x3A04; total reset 0x00000000; PROVEN: Hi3536D V100 data sheet (Issue 00B04, 2017-12-13), section 1.37, PDF page 534).";
        field {
            name = "surface_addr";
            desc = "Luminance start address for VHD region 0";
            sw = rw; hw = r;
            reset = 0x0;
        } surface_addr[31:0];
    } V3_P0LADDR @ 0x3A04;
    reg {
        name = "V3_P0CADDR";
        desc = "V3_P0CADDR is a V3 region 0 chrominance address register. (offset 0x3A08; total reset 0x00000000; PROVEN: Hi3536D V100 data sheet (Issue 00B04, 2017-12-13), section 1.37, PDF page 534).";
        field {
            name = "surface_addr";
            desc = "Chrominance start address for VHD region 0";
            sw = rw; hw = r;
            reset = 0x0;
        } surface_addr[31:0];
    } V3_P0CADDR @ 0x3A08;
    reg {
        name = "V3_P0STRIDE";
        desc = "V3_P0STRIDE is a V3 region 0 stride register. (offset 0x3A0C; total reset 0x00000000; PROVEN: Hi3536D V100 data sheet (Issue 00B04, 2017-12-13), section 1.37, PDF page 534).";
        field {
            name = "surface_cstride";
            desc = "Stride of the chrominance buffer of VHD region 0 (valid in semi- planar format), 128-bit alignment";
            sw = rw; hw = r;
            reset = 0x0;
        } surface_cstride[31:16];
        field {
            name = "surface_stride";
            desc = "Luminance stride of the luminance buffer of VHD region 0 (valid in semi-planar format), 128-bit alignment";
            sw = rw; hw = r;
            reset = 0x0;
        } surface_stride[15:0];
    } V3_P0STRIDE @ 0x3A0C;
    reg {
        name = "V3_P0VFPOS";
        desc = "V3_P0VFPOS is a video content start position (in the display window) register (non-instant) for V3 region 0. The position unit is pixel. (offset 0x3A10; total reset 0x00000000; PROVEN: Hi3536D V100 data sheet (Issue 00B04, 2017-12-13), section 1.37, PDF page 535).";
        field {
            name = "reserved";
            desc = "Reserved";
            sw = r; hw = w;
            reset = 0x0;
        } reserved_31_24[31:24];
        field {
            name = "video_yfpos";
            desc = "Start coordinates of the video column The frame height is referenced and the unit is line.";
            sw = rw; hw = r;
            reset = 0x0;
        } video_yfpos[23:12];
        field {
            name = "video_xfpos";
            desc = "Start coordinates of the video row";
            sw = rw; hw = r;
            reset = 0x0;
        } video_xfpos[11:0];
    } V3_P0VFPOS @ 0x3A10;
    reg {
        name = "V3_P0VLPOS";
        desc = "V3_P0VLPOS is a video content end position (in the display window) register (non-instant) for V3 region 0. The position unit is pixel. (offset 0x3A14; total reset 0x00000000; PROVEN: Hi3536D V100 data sheet (Issue 00B04, 2017-12-13), section 1.37, PDF page 535).";
        field {
            name = "reserved";
            desc = "Reserved";
            sw = r; hw = w;
            reset = 0x0;
        } reserved_31_24[31:24];
        field {
            name = "video_ylpos";
            desc = "Start coordinates of the video column The frame height is referenced and the unit is line.";
            sw = rw; hw = r;
            reset = 0x0;
        } video_ylpos[23:12];
        field {
            name = "video_xlpos";
            desc = "Start coordinates of the video row";
            sw = rw; hw = r;
            reset = 0x0;
        } video_xlpos[11:0];
    } V3_P0VLPOS @ 0x3A14;
    reg {
        name = "V3_P0CTRL";
        desc = "V3_P0CTRL is a V3 region 0 control register. (offset 0x3A18; total reset 0x00000000; PROVEN: Hi3536D V100 data sheet (Issue 00B04, 2017-12-13), section 1.37, PDF page 536).";
        field {
            name = "reserved";
            desc = "Reserved";
            sw = r; hw = w;
            reset = 0x0;
        } reserved_31_7[31:7];
        field {
            name = "mute_en";
            desc = "Region 0 mute enable
- 0: disabled
- 1: enabled";
            sw = rw; hw = r;
            reset = 0x0;
        } mute_en[6:6];
        field {
            name = "p0_en";
            desc = "Region 0 enable
- 0: disabled
- 1: enabled";
            sw = rw; hw = r;
            reset = 0x0;
        } p0_en[5:5];
        field {
            name = "p0_dcmp_en";
            desc = "Region 0 decompression enable
- 0: disabled
- 1: enabled";
            sw = rw; hw = r;
            reset = 0x0;
        } p0_dcmp_en[4:4];
        field {
            name = "p0_l_loss_en";
            desc = "Region 0 luminance loss enable
- 0: disabled
- 1: enabled";
            sw = rw; hw = r;
            reset = 0x0;
        } p0_l_loss_en[3:3];
        field {
            name = "p0_c_loss_en";
            desc = "Region 0 chrominance loss enable
- 0: disabled
- 1: enabled";
            sw = rw; hw = r;
            reset = 0x0;
        } p0_c_loss_en[2:2];
        field {
            name = "p0_rim_en";
            desc = "Region 0 rim filling enable
- 0: disabled
- 1: enabled";
            sw = rw; hw = r;
            reset = 0x0;
        } p0_rim_en[1:1];
        field {
            name = "p0_rim_col_mod";
            desc = "Region 0 rim filling mode selection
- 0: color 0
- 1: color 1";
            sw = rw; hw = r;
            reset = 0x0;
        } p0_rim_col_mod[0:0];
    } V3_P0CTRL @ 0x3A18;
    reg {
        name = "V3_MULTI_MODE";
        desc = "V3_MULTI_MODE is a multi-region mode enable register. This register must be enabled when there are multiple regions. (offset 0x4230; total reset 0x00000001; PROVEN: Hi3536D V100 data sheet (Issue 00B04, 2017-12-13), section 1.37, PDF page 537).";
        field {
            name = "reserved";
            desc = "Reserved";
            sw = r; hw = w;
            reset = 0x0;
        } reserved_31_1[31:1];
        field {
            name = "mrg_mode";
            desc = "Multi-region mode enable (valid only for V3)
- 0: single-region mode (with letterbox)
- 1: multi-region mode (without letterbox)";
            sw = rw; hw = r;
            reset = 0x1;
        } mrg_mode[0:0];
    } V3_MULTI_MODE @ 0x4230;
    reg {
        name = "V3_FDRFIFOTHD";
        desc = "V3_FDRFIFOTHD is a V3 FDR FIFO threshold register (non-instant register). (offset 0x4250; total reset 0x00000020; PROVEN: Hi3536D V100 data sheet (Issue 00B04, 2017-12-13), section 1.37, PDF page 537).";
        field {
            name = "reserved";
            desc = "Reserved";
            sw = r; hw = w;
            reset = 0x0;
        } reserved_31_10[31:10];
        field {
            name = "ff_thd";
            desc = "FDR FIFO threshold. The minimum value is 32. The value must be 2 to the power of n.";
            sw = rw; hw = r;
            reset = 0x20;
        } ff_thd[9:0];
    } V3_FDRFIFOTHD @ 0x4250;
    reg {
        name = "V3_MRGERRCLR";
        desc = "V3_MRGERRCLR is a V3 multi-region register operation error status clear register. Writing 1 clears this register. (offset 0x4350; total reset 0x00000000; PROVEN: Hi3536D V100 data sheet (Issue 00B04, 2017-12-13), section 1.37, PDF page 538).";
        field {
            name = "reserved";
            desc = "Reserved";
            sw = r; hw = w;
            reset = 0x0;
        } reserved_31_1[31:1];
        field {
            name = "mrg_errclr";
            desc = "V3 multi-region register operation error status clear register
- 0: not cleared
- 1: cleared";
            sw = rw; hw = r;
            reset = 0x0;
        } mrg_errclr[0:0];
    } V3_MRGERRCLR @ 0x4350;
    reg {
        name = "V3_MRG_ERR";
        desc = "V3_MRG_ERR is a V3 multi-region register operation error signal register. (offset 0x4354; total reset 0x00000000; PROVEN: Hi3536D V100 data sheet (Issue 00B04, 2017-12-13), section 1.37, PDF page 538).";
        field {
            name = "reserved";
            desc = "Reserved";
            sw = r; hw = w;
            reset = 0x0;
        } reserved_31_1[31:1];
        field {
            name = "mrg_wrong";
            desc = "V3 multi-region register operation error signal register
- 0: The multi-region register operation is correct.
- 1: The multi-region register operation is incorrect.";
            sw = r; hw = w;
            reset = 0x0;
        } mrg_wrong[0:0];
    } V3_MRG_ERR @ 0x4354;
    reg {
        name = "G4_CTRL";
        desc = "G4_CTRL is a G4 layer information configuration register. (offset 0x8000; total reset 0x40000000; PROVEN: Hi3536D V100 data sheet (Issue 00B04, 2017-12-13), section 1.37, PDF page 539).";
        field {
            name = "surface_en";
            desc = "Surface enable (non-instant register)
- 0: disabled
- 1: enabled";
            sw = rw; hw = r;
            reset = 0x0;
        } surface_en[31:31];
        field {
            name = "reserved";
            desc = "Reserved";
            sw = r; hw = w;
            reset = 0x1;
        } reserved_30_30[30:30];
        field {
            name = "reserved";
            desc = "Reserved";
            sw = r; hw = w;
            reset = 0x0;
        } reserved_29_29[29:29];
        field {
            name = "reserved";
            desc = "Reserved";
            sw = r; hw = w;
            reset = 0x0;
        } reserved_28_28[28:28];
        field {
            name = "upd_mode";
            desc = "Update mode
- 0: update by frame
- 1: update by field";
            sw = rw; hw = r;
            reset = 0x0;
        } upd_mode[27:27];
        field {
            name = "read_mode";
            desc = "Data read mode
- 0: The read mode is automatically selected based on the interface read mode. That is, the progressive read mode is selected in progressive display mode, and the interlaced read mode is selected in interlaced display mode.
- 1: The progressive read mode is selected forcibly.";
            sw = rw; hw = r;
            reset = 0x0;
        } read_mode[26:26];
        field {
            name = "dcmp_en";
            desc = "Decompression enable
- 0: disabled
- 1: enabled";
            sw = rw; hw = r;
            reset = 0x0;
        } dcmp_en[25:25];
        field {
            name = "reserved";
            desc = "Reserved";
            sw = r; hw = w;
            reset = 0x0;
        } reserved_24_24[24:24];
        field {
            name = "lossless";
            desc = "Compression mode selection
- 0: lossy compression
- 1: lossless compression";
            sw = rw; hw = r;
            reset = 0x0;
        } lossless[23:23];
        field {
            name = "lossless_a";
            desc = "Compression mode selection for alpha
- 0: lossy compression of alpha
- 1: lossless compression of alpha";
            sw = rw; hw = r;
            reset = 0x0;
        } lossless_a[22:22];
        field {
            name = "cmp_mode";
            desc = "Compressed data type
- 1: RAW mode
- 0: compression mode";
            sw = rw; hw = r;
            reset = 0x0;
        } cmp_mode[21:21];
        field {
            name = "reserved";
            desc = "Reserved";
            sw = r; hw = w;
            reset = 0x0;
        } reserved_20_15[20:15];
        field {
            name = "req_ctrl";
            desc = "Register for controlling the number of 16-burst requested consecutively at a time
- 0x0: One 16-burst is requested consecutively at a time.
- 0x1: Two 16-burst are requested consecutively at a time.
- 0x2: Four 16-burst are requested consecutively at a time.
- 0x3: Eight 16-burst are requested consecutively at a time.

Other values: reserved";
            sw = rw; hw = r;
            reset = 0x0;
        } req_ctrl[14:12];
        field {
            name = "reserved";
            desc = "Reserved";
            sw = r; hw = w;
            reset = 0x0;
        } reserved_11_10[11:10];
        field {
            name = "bitext";
            desc = "Bit extend mode of the input bitmap
- 00: extend 0s to lower bits
- 01: reserved
- 10: extend the value of the MSB to a lower bit
- 11: extend the values of upper bits to lower bits";
            sw = rw; hw = r;
            reset = 0x0;
        } bitext[9:8];
        field {
            name = "ifmt";
            desc = "Format of the input data
- 0x49: ARGB1555
- 0x68: ARGB8888

Other values: reserved";
            sw = rw; hw = r;
            reset = 0x0;
        } ifmt[7:0];
    } G4_CTRL @ 0x8000;
    reg {
        name = "G4_UPD";
        desc = "G4_UPD is a G4 update enable register. (offset 0x8004; total reset 0x00000000; PROVEN: Hi3536D V100 data sheet (Issue 00B04, 2017-12-13), section 1.37, PDF page 540).";
        field {
            name = "reserved";
            desc = "Reserved";
            sw = r; hw = w;
            reset = 0x0;
        } reserved_31_1[31:1];
        field {
            name = "regup";
            desc = "Surface register update. After the registers at this layer are configured, the registers are updated when the value 1 is written to this bit. After updates, this bit is automatically cleared by the hardware.";
            sw = w; hw = r;
            reset = 0x0;
        } regup[0:0];
    } G4_UPD @ 0x8004;
    reg {
        name = "G4_ADDR";
        desc = "G4_ADDR is a G4 address register. When the horizontal pixel offsets, you need to calculate the address by following the description of G4_SFPOS. (offset 0x8010; total reset 0x00000000; PROVEN: Hi3536D V100 data sheet (Issue 00B04, 2017-12-13), section 1.37, PDF page 541).";
        field {
            name = "surface_addr";
            desc = "Address for the surface frame buffer";
            sw = rw; hw = r;
            reset = 0x0;
        } surface_addr[31:0];
    } G4_ADDR @ 0x8010;
    reg {
        name = "G4_STRIDE";
        desc = "G4_STRIDE is a G4 stride register. (offset 0x801C; total reset 0x00000000; PROVEN: Hi3536D V100 data sheet (Issue 00B04, 2017-12-13), section 1.37, PDF page 541).";
        field {
            name = "reserved";
            desc = "Reserved";
            sw = r; hw = w;
            reset = 0x0;
        } reserved_31_16[31:16];
        field {
            name = "surface_stride";
            desc = "Frame buffer stride";
            sw = rw; hw = r;
            reset = 0x0;
        } surface_stride[15:0];
    } G4_STRIDE @ 0x801C;
    reg {
        name = "G4_IRESO";
        desc = "G4_IRESO is a G4 input resolution register (non-instant register). (offset 0x8020; total reset 0x00000000; PROVEN: Hi3536D V100 data sheet (Issue 00B04, 2017-12-13), section 1.37, PDF page 541).";
        field {
            name = "reserved";
            desc = "Reserved";
            sw = r; hw = w;
            reset = 0x0;
        } reserved_31_24[31:24];
        field {
            name = "ih";
            desc = "Height (in line). The value is the actual height minus 1. Note: In interlaced output mode, the actual layer height must be an even number. There is no such limitation in progressive output mode.";
            sw = rw; hw = r;
            reset = 0x0;
        } ih[23:12];
        field {
            name = "iw";
            desc = "Width (in pixel). The value is the actual width minus 1. Note: The actual layer width must be an even number.";
            sw = rw; hw = r;
            reset = 0x0;
        } iw[11:0];
    } G4_IRESO @ 0x8020;
    reg {
        name = "G4_SFPOS";
        desc = "G4_SFPOS is a G4 surface read data start position (in the source bitmap) register (non-instant register). If the read position is not 128-bit-word-aligned, this register indicates the number of pixels required for completing a 128-bit word. Note: The start position offset must be less than or equal to a 128-bit word. The exceeded part is expressed by an address. The details are as follows: The following assumes that the start address for the graphics layer of the source picture is addr_ori, the address configured for the logical graphics layer is addr_offset, the graphics layer offset is offsetp (in pixel), and the data format at the graphics layer is bpp (for example, the bpp for ARGB8888 is 32). The formulas are as follows: G4ADDR = addr_offset = addr_ori + int (offset x bpp/128) G4SFPOS = offset%128 where int indicates the rounding operation, and % indicates the modulo operation. (offset 0x8024; total reset 0x00000000; PROVEN: Hi3536D V100 data sheet (Issue 00B04, 2017-12-13), section 1.37, PDF page 542).";
        field {
            name = "reserved";
            desc = "Reserved";
            sw = r; hw = w;
            reset = 0x0;
        } reserved_31_7[31:7];
        field {
            name = "src_xfpos";
            desc = "Start horizontal coordinate of the source picture. The value 0 indicates the first pixel of a line.";
            sw = rw; hw = r;
            reset = 0x0;
        } src_xfpos[6:0];
    } G4_SFPOS @ 0x8024;
    reg {
        name = "G4_CBMPARA";
        desc = "G4_CBMPARA is a G4 overlay parameter register (non-instant register). (offset 0x8030; total reset 0x00000000; PROVEN: Hi3536D V100 data sheet (Issue 00B04, 2017-12-13), section 1.37, PDF page 543).";
        field {
            name = "reserved";
            desc = "Reserved";
            sw = r; hw = w;
            reset = 0x0;
        } reserved_31_16[31:16];
        field {
            name = "key_mode";
            desc = "Colorkey mode
- 0: The color is regarded as the colorkey when the following condition is met: Keymin ≤ Pixel ≤ Keymax
- 1: The color is regarded as the colorkey when either of the following conditions is met: Pixel ≤ Keymin or Pixel ≥ Keymax";
            sw = rw; hw = r;
            reset = 0x0;
        } key_mode[15:15];
        field {
            name = "key_en";
            desc = "Colorkey enable
- 0: disabled
- 1: enabled";
            sw = rw; hw = r;
            reset = 0x0;
        } key_en[14:14];
        field {
            name = "premult_en";
            desc = "Whether the input bitmap is a premultiplied bitmap
- 0: non-premultiplied bitmap
- 1: premultiplied bitmap";
            sw = rw; hw = r;
            reset = 0x0;
        } premult_en[13:13];
        field {
            name = "palpha_en";
            desc = "Pixel alpha enable
- 0: disabled
- 1: enabled";
            sw = rw; hw = r;
            reset = 0x0;
        } palpha_en[12:12];
        field {
            name = "reserved";
            desc = "Reserved";
            sw = r; hw = w;
            reset = 0x0;
        } reserved_11_11[11:11];
        field {
            name = "reserved";
            desc = "Reserved";
            sw = r; hw = w;
            reset = 0x0;
        } reserved_10_10[10:10];
        field {
            name = "reserved";
            desc = "Reserved";
            sw = r; hw = w;
            reset = 0x0;
        } reserved_9_9[9:9];
        field {
            name = "palpha_range";
            desc = "Pixel alpha range selection
- 0: The pixel alpha range is 0-128.
- 1: The pixel alpha range is 0-255.";
            sw = rw; hw = r;
            reset = 0x0;
        } palpha_range[8:8];
        field {
            name = "galpha";
            desc = "Overlay global alpha value. The value ranges from 0 to 128. The value 128 indicates opaque, and the value 0 indicates full transparent.";
            sw = rw; hw = r;
            reset = 0x0;
        } galpha[7:0];
    } G4_CBMPARA @ 0x8030;
    reg {
        name = "G4_CKEYMAX";
        desc = "G4_CKEYMAX is a G4 maximum colorkey register (non-instant register). (offset 0x8034; total reset 0x00000000; PROVEN: Hi3536D V100 data sheet (Issue 00B04, 2017-12-13), section 1.37, PDF page 544).";
        field {
            name = "va0";
            desc = "Alpha0 value. When the data format is ARGB1555 and the alpha value is 0, the alpha0 value is used.";
            sw = rw; hw = r;
            reset = 0x0;
        } va0[31:24];
        field {
            name = "keyr_max";
            desc = "Maximum value of the colorkey R component";
            sw = rw; hw = r;
            reset = 0x0;
        } keyr_max[23:16];
        field {
            name = "keyg_max";
            desc = "Maximum value of the colorkey G component";
            sw = rw; hw = r;
            reset = 0x0;
        } keyg_max[15:8];
        field {
            name = "keyb_max";
            desc = "Maximum value of the colorkey B component";
            sw = rw; hw = r;
            reset = 0x0;
        } keyb_max[7:0];
    } G4_CKEYMAX @ 0x8034;
    reg {
        name = "G4_CKEYMIN";
        desc = "G4_CKEYMIN is a G4 minimum colorkey register (non-instant register). (offset 0x8038; total reset 0x00000000; PROVEN: Hi3536D V100 data sheet (Issue 00B04, 2017-12-13), section 1.37, PDF page 544).";
        field {
            name = "va1";
            desc = "Alpha1 value. When the data format is ARGB1555 and the alpha value is 1, the alpha1 value is used.";
            sw = rw; hw = r;
            reset = 0x0;
        } va1[31:24];
        field {
            name = "keyr_min";
            desc = "Minimum value of the colorkey R component";
            sw = rw; hw = r;
            reset = 0x0;
        } keyr_min[23:16];
        field {
            name = "keyg_min";
            desc = "Minimum value of the colorkey G component";
            sw = rw; hw = r;
            reset = 0x0;
        } keyg_min[15:8];
        field {
            name = "keyb_min";
            desc = "Minimum value of the colorkey B component";
            sw = rw; hw = r;
            reset = 0x0;
        } keyb_min[7:0];
    } G4_CKEYMIN @ 0x8038;
    reg {
        name = "G4_CMASK";
        desc = "G4_CMASK is a G4 masked colorkey register (non-instant register). The value 1 indicates that the bit corresponding to a pixel is retained during colorkey comparison; the value 0 indicates that the bit corresponding to a pixel is forcibly set to 0 during color comparison no matter whether the bit is 0 or 1. (offset 0x803C; total reset 0xFFFFFFFF; PROVEN: Hi3536D V100 data sheet (Issue 00B04, 2017-12-13), section 1.37, PDF page 545).";
        field {
            name = "reserved";
            desc = "Reserved";
            sw = r; hw = w;
            reset = 0xff;
        } reserved_31_24[31:24];
        field {
            name = "kmsk_r";
            desc = "R component of the masked colorkey";
            sw = rw; hw = r;
            reset = 0xff;
        } kmsk_r[23:16];
        field {
            name = "kmsk_g";
            desc = "G component of the masked colorkey";
            sw = rw; hw = r;
            reset = 0xff;
        } kmsk_g[15:8];
        field {
            name = "kmsk_b";
            desc = "B component of the masked colorkey";
            sw = rw; hw = r;
            reset = 0xff;
        } kmsk_b[7:0];
    } G4_CMASK @ 0x803C;
    reg {
        name = "G4_DCMP_DBG";
        desc = "G4_DCMP_DBG is a debugging signal register for the DCMP module. (offset 0x8060; total reset 0x00000000; PROVEN: Hi3536D V100 data sheet (Issue 00B04, 2017-12-13), section 1.37, PDF page 545).";
        field {
            name = "dcmp_dbg";
            desc = "Status information about the DCMP module. The initial value can be changed.";
            sw = r; hw = w;
            reset = 0x0;
        } dcmp_dbg[31:0];
    } G4_DCMP_DBG @ 0x8060;
    reg {
        name = "G4_DCMP_INTER";
        desc = "G4_DCMP_INTER is an error interrupt information register for the DCMP module. (offset 0x8070; total reset 0x00000000; PROVEN: Hi3536D V100 data sheet (Issue 00B04, 2017-12-13), section 1.37, PDF page 546).";
        field {
            name = "reserved";
            desc = "Reserved";
            sw = r; hw = w;
            reset = 0x0;
        } reserved_31_2[31:2];
        field {
            name = "widthlen_crr";
            desc = "Whether to perform the clear operation on the interrupt register status when the length of the header information is greater than the stride in compression mode
- 1: cleared
- 0: not cleared

Access type WC in the data sheet: written 1 clears the bit.";
            sw = rw; hw = w; onwrite = woclr;
            reset = 0x0;
        } widthlen_crr[1:1];
        field {
            name = "gdccerrclr";
            desc = "An interrupt register indicating whether the output of the DCMP module is correct. When an error occurs, an interrupt is generated. Writing 1 to this bit clears the register.

Access type WC in the data sheet: written 1 clears the bit.";
            sw = rw; hw = w; onwrite = woclr;
            reset = 0x0;
        } gdccerrclr[0:0];
    } G4_DCMP_INTER @ 0x8070;
    reg {
        name = "G4_DFPOS";
        desc = "G4_DFPOS is a G4 surface start position (in the display window) register (non-instant register). The position unit is pixel. (offset 0x8080; total reset 0x00000000; PROVEN: Hi3536D V100 data sheet (Issue 00B04, 2017-12-13), section 1.37, PDF page 546).";
        field {
            name = "reserved";
            desc = "Reserved";
            sw = r; hw = w;
            reset = 0x0;
        } reserved_31_24[31:24];
        field {
            name = "disp_yfpos";
            desc = "Column start coordinates";
            sw = rw; hw = r;
            reset = 0x0;
        } disp_yfpos[23:12];
        field {
            name = "disp_xfpos";
            desc = "Row start coordinates";
            sw = rw; hw = r;
            reset = 0x0;
        } disp_xfpos[11:0];
    } G4_DFPOS @ 0x8080;
    reg {
        name = "G4_DLPOS";
        desc = "G4_DLPOS is a G4 surface end position (in the display window) register (non-instant register). The position unit is pixel. (offset 0x8084; total reset 0x00000000; PROVEN: Hi3536D V100 data sheet (Issue 00B04, 2017-12-13), section 1.37, PDF page 547).";
        field {
            name = "reserved";
            desc = "Reserved";
            sw = r; hw = w;
            reset = 0x0;
        } reserved_31_24[31:24];
        field {
            name = "disp_ylpos";
            desc = "Column end coordinates";
            sw = rw; hw = r;
            reset = 0x0;
        } disp_ylpos[23:12];
        field {
            name = "disp_xlpos";
            desc = "Row end coordinates";
            sw = rw; hw = r;
            reset = 0x0;
        } disp_xlpos[11:0];
    } G4_DLPOS @ 0x8084;
    reg {
        name = "G4_CSC_IDC";
        desc = "G4_CSC_IDC is a G4 CSC input DC component register (instant register). (offset 0x80C0; total reset 0x00000000; PROVEN: Hi3536D V100 data sheet (Issue 00B04, 2017-12-13), section 1.37, PDF page 547).";
        field {
            name = "reserved";
            desc = "Reserved";
            sw = r; hw = w;
            reset = 0x0;
        } reserved_31_27[31:27];
        field {
            name = "csc_mode";
            desc = "- 0xC: RGB_2_YUV_709_FULL

Other values: reserved";
            sw = rw; hw = r;
            reset = 0x0;
        } csc_mode[26:23];
        field {
            name = "csc_en";
            desc = "CSC enable
- 0: disabled
- 1: enabled";
            sw = rw; hw = r;
            reset = 0x0;
        } csc_en[22:22];
        field {
            name = "cscidc1";
            desc = "DC parameter of input component 1. The MSB is the signed bit. The value is expressed as a complement.";
            sw = rw; hw = r;
            reset = 0x0;
        } cscidc1[21:11];
        field {
            name = "cscidc0";
            desc = "DC parameter of input component 0. The MSB is the signed bit. The value is expressed as a complement.";
            sw = rw; hw = r;
            reset = 0x0;
        } cscidc0[10:0];
    } G4_CSC_IDC @ 0x80C0;
    reg {
        name = "G4_CSC_ODC";
        desc = "G4_CSC_ODC is a G4 CSC output DC component register (instant register). (offset 0x80C4; total reset 0x00000000; PROVEN: Hi3536D V100 data sheet (Issue 00B04, 2017-12-13), section 1.37, PDF page 548).";
        field {
            name = "reserved";
            desc = "Reserved";
            sw = r; hw = w;
            reset = 0x0;
        } reserved_31_23[31:23];
        field {
            name = "csc_sign_mode";
            desc = "CSC output mode
- 0: The CSC output is a 10-bit unsigned number.
- 1: The CSC output is a 12-bit signed number.";
            sw = rw; hw = r;
            reset = 0x0;
        } csc_sign_mode[22:22];
        field {
            name = "cscodc1";
            desc = "DC parameter of output component 1. The MSB is the signed bit. The value is expressed as a complement.";
            sw = rw; hw = r;
            reset = 0x0;
        } cscodc1[21:11];
        field {
            name = "cscodc0";
            desc = "DC parameter of output component 0. The MSB is the signed bit. The value is expressed as a complement.";
            sw = rw; hw = r;
            reset = 0x0;
        } cscodc0[10:0];
    } G4_CSC_ODC @ 0x80C4;
    reg {
        name = "G4_CSC_IODC";
        desc = "G4_CSC_IODC is a G4 CSC input/output DC component register (instant register). (offset 0x80C8; total reset 0x00000000; PROVEN: Hi3536D V100 data sheet (Issue 00B04, 2017-12-13), section 1.37, PDF page 548).";
        field {
            name = "reserved";
            desc = "Reserved";
            sw = r; hw = w;
            reset = 0x0;
        } reserved_31_22[31:22];
        field {
            name = "cscodc2";
            desc = "DC parameter of output component 2. The MSB is the signed bit. The value is expressed as a complement.";
            sw = rw; hw = r;
            reset = 0x0;
        } cscodc2[21:11];
        field {
            name = "cscidc2";
            desc = "DC parameter of input component 2. The MSB is the signed bit. The value is expressed as a complement.";
            sw = rw; hw = r;
            reset = 0x0;
        } cscidc2[10:0];
    } G4_CSC_IODC @ 0x80C8;
    reg {
        name = "G4_CSC_P0";
        desc = "G4_CSC_P0 is a G4 CSC parameter 0 register (instant register). (offset 0x80CC; total reset 0x00000000; PROVEN: Hi3536D V100 data sheet (Issue 00B04, 2017-12-13), section 1.37, PDF page 549).";
        field {
            name = "reserved";
            desc = "Reserved";
            sw = r; hw = w;
            reset = 0x0;
        } reserved_31_31[31:31];
        field {
            name = "cscp01";
            desc = "s(5.10) data format: signed number, 1 sign bit, 4 integer bits, and 10 decimal bits. The value is expressed as a complement.";
            sw = rw; hw = r;
            reset = 0x0;
        } cscp01[30:16];
        field {
            name = "reserved";
            desc = "Reserved";
            sw = r; hw = w;
            reset = 0x0;
        } reserved_15_15[15:15];
        field {
            name = "cscp00";
            desc = "s(5.10) data format: signed number, 1 sign bit, 4 integer bits, and 10 decimal bits. The value is expressed as a complement.";
            sw = rw; hw = r;
            reset = 0x0;
        } cscp00[14:0];
    } G4_CSC_P0 @ 0x80CC;
    reg {
        name = "G4_CSC_P1";
        desc = "G4_CSC_P1 is a G4 CSC parameter 1 register (instant register). (offset 0x80D0; total reset 0x00000000; PROVEN: Hi3536D V100 data sheet (Issue 00B04, 2017-12-13), section 1.37, PDF page 549).";
        field {
            name = "reserved";
            desc = "Reserved";
            sw = r; hw = w;
            reset = 0x0;
        } reserved_31_31[31:31];
        field {
            name = "cscp10";
            desc = "s(5.10) data format: signed number, 1 sign bit, 4 integer bits, and 10 decimal bits. The value is expressed as a complement.";
            sw = rw; hw = r;
            reset = 0x0;
        } cscp10[30:16];
        field {
            name = "reserved";
            desc = "Reserved";
            sw = r; hw = w;
            reset = 0x0;
        } reserved_15_15[15:15];
        field {
            name = "cscp02";
            desc = "s(5.10) data format: signed number, 1 sign bit, 4 integer bits, and 10 decimal bits. The value is expressed as a complement.";
            sw = rw; hw = r;
            reset = 0x0;
        } cscp02[14:0];
    } G4_CSC_P1 @ 0x80D0;
    reg {
        name = "G4_CSC_P2";
        desc = "G4_CSC_P2 is a G4 CSC parameter 2 register (instant register). (offset 0x80D4; total reset 0x00000000; PROVEN: Hi3536D V100 data sheet (Issue 00B04, 2017-12-13), section 1.37, PDF page 550).";
        field {
            name = "reserved";
            desc = "Reserved";
            sw = r; hw = w;
            reset = 0x0;
        } reserved_31_31[31:31];
        field {
            name = "cscp12";
            desc = "s(5.10) data format: signed number, 1 sign bit, 4 integer bits, and 10 decimal bits. The value is expressed as a complement.";
            sw = rw; hw = r;
            reset = 0x0;
        } cscp12[30:16];
        field {
            name = "reserved";
            desc = "Reserved";
            sw = r; hw = w;
            reset = 0x0;
        } reserved_15_15[15:15];
        field {
            name = "cscp11";
            desc = "s(5.10) data format: signed number, 1 sign bit, 4 integer bits, and 10 decimal bits. The value is expressed as a complement.";
            sw = rw; hw = r;
            reset = 0x0;
        } cscp11[14:0];
    } G4_CSC_P2 @ 0x80D4;
    reg {
        name = "G4_CSC_P3";
        desc = "G4_CSC_P3 is a G4 CSC parameter 3 register (instant register). (offset 0x80D8; total reset 0x00000000; PROVEN: Hi3536D V100 data sheet (Issue 00B04, 2017-12-13), section 1.37, PDF page 550).";
        field {
            name = "reserved";
            desc = "Reserved";
            sw = r; hw = w;
            reset = 0x0;
        } reserved_31_31[31:31];
        field {
            name = "cscp21";
            desc = "s(5.10) data format: signed number, 1 sign bit, 4 integer bits, and 10 decimal bits. The value is expressed as a complement.";
            sw = rw; hw = r;
            reset = 0x0;
        } cscp21[30:16];
        field {
            name = "reserved";
            desc = "Reserved";
            sw = r; hw = w;
            reset = 0x0;
        } reserved_15_15[15:15];
        field {
            name = "cscp20";
            desc = "s(5.10) data format: signed number, 1 sign bit, 4 integer bits, and 10 decimal bits. The value is expressed as a complement.";
            sw = rw; hw = r;
            reset = 0x0;
        } cscp20[14:0];
    } G4_CSC_P3 @ 0x80D8;
    reg {
        name = "G4_CSC_P4";
        desc = "G4_CSC_P4 is a G4 CSC parameter 4 register (instant register). (offset 0x80DC; total reset 0x00000000; PROVEN: Hi3536D V100 data sheet (Issue 00B04, 2017-12-13), section 1.37, PDF page 551).";
        field {
            name = "reserved";
            desc = "Reserved";
            sw = r; hw = w;
            reset = 0x0;
        } reserved_31_15[31:15];
        field {
            name = "cscp22";
            desc = "s(5.10) data format: signed number, 1 sign bit, 4 integer bits, and 10 decimal bits. The value is expressed as a complement.";
            sw = r; hw = w;
            reset = 0x0;
        } cscp22[14:0];
    } G4_CSC_P4 @ 0x80DC;
    reg {
        name = "WBC_G4_CTRL";
        desc = "WBC_G4_CTRL is a WBC control register (non-instant register). (offset 0xA400; total reset 0x00000000; PROVEN: Hi3536D V100 data sheet (Issue 00B04, 2017-12-13), section 1.37, PDF page 551).";
        field {
            name = "wbc_en";
            desc = "WBC enable
- 0: disable
- 1: enable";
            sw = rw; hw = r;
            reset = 0x0;
        } wbc_en[31:31];
        field {
            name = "reserved";
            desc = "Reserved";
            sw = r; hw = w;
            reset = 0x0;
        } reserved_30_11[30:11];
        field {
            name = "auto_stop_en";
            desc = "When the bandwidth is low due to the rapid WBC, WBC is automatically disabled.";
            sw = rw; hw = r;
            reset = 0x0;
        } auto_stop_en[10:10];
        field {
            name = "reserved";
            desc = "Reserved";
            sw = r; hw = w;
            reset = 0x0;
        } reserved_9_0[9:0];
    } WBC_G4_CTRL @ 0xA400;
    reg {
        name = "WBC_G4_UPD";
        desc = "WBC_G4_UPD is a WBC channel update enable register. (offset 0xA404; total reset 0x00000000; PROVEN: Hi3536D V100 data sheet (Issue 00B04, 2017-12-13), section 1.37, PDF page 552).";
        field {
            name = "reserved";
            desc = "Reserved";
            sw = r; hw = w;
            reset = 0x0;
        } reserved_31_1[31:1];
        field {
            name = "regup";
            desc = "Capture register update. After the registers at this layer are configured, the registers are updated when the value 1 is written to this bit. After updates, this bit is automatically cleared by the hardware.

Access type WC in the data sheet: written 1 clears the bit.";
            sw = rw; hw = w; onwrite = woclr;
            reset = 0x0;
        } regup[0:0];
    } WBC_G4_UPD @ 0xA404;
    reg {
        name = "WBC_G4_ADDR";
        desc = "WBC_G4_ADDR is a capture luminance write address register. (offset 0xA410; total reset 0x00000000; PROVEN: Hi3536D V100 data sheet (Issue 00B04, 2017-12-13), section 1.37, PDF page 552).";
        field {
            name = "wbcaddr";
            desc = "Start address for compressing the WBC data";
            sw = rw; hw = r;
            reset = 0x0;
        } wbcaddr[31:0];
    } WBC_G4_ADDR @ 0xA410;
    reg {
        name = "WBC_G4_STRIDE";
        desc = "WBC_G4_STRIDE is a capture stride register. (offset 0xA418; total reset 0x00000000; PROVEN: Hi3536D V100 data sheet (Issue 00B04, 2017-12-13), section 1.37, PDF page 553).";
        field {
            name = "reserved";
            desc = "Reserved";
            sw = r; hw = w;
            reset = 0x0;
        } reserved_31_16[31:16];
        field {
            name = "wbcstride";
            desc = "Frame buffer stride, 16-byte-aligned";
            sw = rw; hw = r;
            reset = 0x0;
        } wbcstride[15:0];
    } WBC_G4_STRIDE @ 0xA418;
    reg {
        name = "WBC_G4_ORESO";
        desc = "WBC_G4_ORESO is an output resolution register (non-instant register). (offset 0xA420; total reset 0x00000000; PROVEN: Hi3536D V100 data sheet (Issue 00B04, 2017-12-13), section 1.37, PDF page 553).";
        field {
            name = "reserved";
            desc = "Reserved";
            sw = r; hw = w;
            reset = 0x0;
        } reserved_31_24[31:24];
        field {
            name = "oh";
            desc = "Height (in line). The value is the actual height minus 1. Note: In interlaced output mode, the actual layer height must be an even number. There is no such limitation in progressive output mode.";
            sw = rw; hw = r;
            reset = 0x0;
        } oh[23:12];
        field {
            name = "ow";
            desc = "Width (in pixel). The value is the actual width minus 1. Note: The actual layer width must be an even number.";
            sw = rw; hw = r;
            reset = 0x0;
        } ow[11:0];
    } WBC_G4_ORESO @ 0xA420;
    reg {
        name = "WBC_G4_YCROP";
        desc = "WBC_G4_YCROP is an input picture crop start/end vertical coordinate register (non-instant register). (offset 0xA424; total reset 0x00000000; PROVEN: Hi3536D V100 data sheet (Issue 00B04, 2017-12-13), section 1.37, PDF page 554).";
        field {
            name = "reserved";
            desc = "Reserved";
            sw = r; hw = w;
            reset = 0x0;
        } reserved_31_24[31:24];
        field {
            name = "ylcrop";
            desc = "End vertical coordinate for cropping";
            sw = rw; hw = r;
            reset = 0x0;
        } ylcrop[23:12];
        field {
            name = "yfcrop";
            desc = "Start vertical coordinate for cropping";
            sw = rw; hw = r;
            reset = 0x0;
        } yfcrop[11:0];
    } WBC_G4_YCROP @ 0xA424;
    reg {
        name = "WBC_G4_CSTR_ERR";
        desc = "WBC_G4_CSTR_ERR is a compressed picture stride configuration error status register. This register is read-only. (offset 0xA434; total reset 0x00000000; PROVEN: Hi3536D V100 data sheet (Issue 00B04, 2017-12-13), section 1.37, PDF page 554).";
        field {
            name = "reserved";
            desc = "Reserved";
            sw = r; hw = w;
            reset = 0x0;
        } reserved_31_1[31:1];
        field {
            name = "str_err_flag";
            desc = "When the configured stride length is less than the length of the header information, str_err_flag is pulled up.";
            sw = r; hw = w;
            reset = 0x0;
        } str_err_flag[0:0];
    } WBC_G4_CSTR_ERR @ 0xA434;
    reg {
        name = "WBC_G4_CLR_CSTR_ERR";
        desc = "WBC_G4_CLR_CSTR_ERR is a compressed picture stride configuration error status clear register. This register is write-only. (offset 0xA438; total reset 0x00000000; PROVEN: Hi3536D V100 data sheet (Issue 00B04, 2017-12-13), section 1.37, PDF page 555).";
        field {
            name = "reserved";
            desc = "Reserved";
            sw = r; hw = w;
            reset = 0x0;
        } reserved_31_1[31:1];
        field {
            name = "clr_err_flag";
            desc = "Compressed picture stride configuration error status clear register Writing 1 clears the compressed picture stride configuration error status register (WBC_G4_CSTR_ERR).";
            sw = w; hw = r;
            reset = 0x0;
        } clr_err_flag[0:0];
    } WBC_G4_CLR_CSTR_ERR @ 0xA438;
    reg {
        name = "WBC_G4_GLB_INFO";
        desc = "WBC_G4_GLB_INFO is an LCMP global control information register. (offset 0xA480; total reset 0x00000040; PROVEN: Hi3536D V100 data sheet (Issue 00B04, 2017-12-13), section 1.37, PDF page 555).";
        field {
            name = "reserved";
            desc = "Reserved";
            sw = r; hw = w;
            reset = 0x0;
        } reserved_31_9[31:9];
        field {
            name = "part_num";
            desc = "Number of split partitions";
            sw = rw; hw = r;
            reset = 0x1;
        } part_num[8:6];
        field {
            name = "partition_en";
            desc = "Whether to split compression
- 0: no spit
- 1: split";
            sw = rw; hw = r;
            reset = 0x0;
        } partition_en[5:5];
        field {
            name = "osd_mode";
            desc = "OSD mode
- 00: 8888
- 10: 1555

Other values: reserved";
            sw = rw; hw = r;
            reset = 0x0;
        } osd_mode[4:3];
        field {
            name = "cmp_mode";
            desc = "Compression mode
- 0: compression
- 1: RAW mode";
            sw = rw; hw = r;
            reset = 0x0;
        } cmp_mode[2:2];
        field {
            name = "is_lossless_alpha";
            desc = "Whether the compression mode of alpha is lossless compression
- 0: lossy compression
- 1: lossless compression";
            sw = rw; hw = r;
            reset = 0x0;
        } is_lossless_alpha[1:1];
        field {
            name = "is_lossless";
            desc = "Whether the compression mode is lossless compression mode
- 0: lossy compression mode
- 1: lossless compression mode";
            sw = rw; hw = r;
            reset = 0x0;
        } is_lossless[0:0];
    } WBC_G4_GLB_INFO @ 0xA480;
    reg {
        name = "WBC_G4_FRAME_SIZE";
        desc = "WBC_G4_FRAME_SIZE is a picture size register. (offset 0xA484; total reset 0x0437077F; PROVEN: Hi3536D V100 data sheet (Issue 00B04, 2017-12-13), section 1.37, PDF page 556).";
        field {
            name = "reserved";
            desc = "Reserved";
            sw = r; hw = w;
            reset = 0x0;
        } reserved_31_29[31:29];
        field {
            name = "frame_height";
            desc = "Height (in line). The configured value is the actual height minus 1.";
            sw = rw; hw = r;
            reset = 0x437;
        } frame_height[28:16];
        field {
            name = "reserved";
            desc = "Reserved";
            sw = r; hw = w;
            reset = 0x0;
        } reserved_15_13[15:13];
        field {
            name = "frame_width";
            desc = "Width (in pixel). The configured value is the actual width minus 1.";
            sw = rw; hw = r;
            reset = 0x77f;
        } frame_width[12:0];
    } WBC_G4_FRAME_SIZE @ 0xA484;
    reg {
        name = "WBC_G4_RC_CFG0";
        desc = "WBC_G4_RC_CFG0 is an RC parameter 0 register. (offset 0xA488; total reset 0x017701F4; PROVEN: Hi3536D V100 data sheet (Issue 00B04, 2017-12-13), section 1.37, PDF page 557).";
        field {
            name = "reserved";
            desc = "Reserved";
            sw = r; hw = w;
            reset = 0x0;
        } reserved_31_26[31:26];
        field {
            name = "min_mb_bits";
            desc = "Minimum number of bits that can be allocated during rate control";
            sw = rw; hw = r;
            reset = 0x177;
        } min_mb_bits[25:16];
        field {
            name = "reserved";
            desc = "Reserved";
            sw = rw; hw = r;
            reset = 0x0;
        } reserved_15_10[15:10];
        field {
            name = "budget_bits_mb";
            desc = "Number of rated bits for an RC unit";
            sw = rw; hw = r;
            reset = 0x1f4;
        } budget_bits_mb[9:0];
    } WBC_G4_RC_CFG0 @ 0xA488;
    reg {
        name = "WBC_G4_RC_CFG1";
        desc = "WBC_G4_RC_CFG1 is an RC parameter 1 register. (offset 0xA48C; total reset 0x00000000; PROVEN: Hi3536D V100 data sheet (Issue 00B04, 2017-12-13), section 1.37, PDF page 557).";
        field {
            name = "reserved";
            desc = "Reserved";
            sw = r; hw = w;
            reset = 0x0;
        } reserved_31_10[31:10];
        field {
            name = "budget_bits_mb_cap";
            desc = "Number of rated bits for an RC unit";
            sw = rw; hw = r;
            reset = 0x0;
        } budget_bits_mb_cap[9:0];
    } WBC_G4_RC_CFG1 @ 0xA48C;
    reg {
        name = "WBC_G4_RC_CFG2";
        desc = "WBC_G4_RC_CFG2 is an RC parameter 2 register. (offset 0xA490; total reset 0x04040A25; PROVEN: Hi3536D V100 data sheet (Issue 00B04, 2017-12-13), section 1.37, PDF page 558).";
        field {
            name = "reserved";
            desc = "Reserved";
            sw = r; hw = w;
            reset = 0x0;
        } reserved_31_28[31:28];
        field {
            name = "special_bit_gain";
            desc = "Gain coefficient of special bits";
            sw = rw; hw = r;
            reset = 0x4;
        } special_bit_gain[27:24];
        field {
            name = "reserved";
            desc = "Reserved";
            sw = r; hw = w;
            reset = 0x0;
        } reserved_23_19[23:19];
        field {
            name = "rc_smth_ngain";
            desc = "Steady factor of the RC quality and bandwidth";
            sw = rw; hw = r;
            reset = 0x4;
        } rc_smth_ngain[18:16];
        field {
            name = "reserved";
            desc = "Reserved";
            sw = r; hw = w;
            reset = 0x0;
        } reserved_15_12[15:12];
        field {
            name = "sad_bits_ngain";
            desc = "Number of allocated bits corresponding to the complexity";
            sw = rw; hw = r;
            reset = 0xa;
        } sad_bits_ngain[11:8];
        field {
            name = "smth_qp";
            desc = "Reserved";
            sw = rw; hw = r;
            reset = 0x2;
        } smth_qp[7:4];
        field {
            name = "max_qp";
            desc = "Maximum quantization level";
            sw = rw; hw = r;
            reset = 0x5;
        } max_qp[3:0];
    } WBC_G4_RC_CFG2 @ 0xA490;
    reg {
        name = "WBC_G4_RC_CFG3";
        desc = "WBC_G4_RC_CFG3 is an RC parameter 3 register. (offset 0xA494; total reset 0x000C0040; PROVEN: Hi3536D V100 data sheet (Issue 00B04, 2017-12-13), section 1.37, PDF page 558).";
        field {
            name = "reserved";
            desc = "Reserved";
            sw = r; hw = w;
            reset = 0x0;
        } reserved_31_23[31:23];
        field {
            name = "min_sad_thr";
            desc = "Minimum SAD threshold";
            sw = rw; hw = r;
            reset = 0xc;
        } min_sad_thr[22:16];
        field {
            name = "reserved";
            desc = "Reserved";
            sw = r; hw = w;
            reset = 0x0;
        } reserved_15_7[15:7];
        field {
            name = "max_sad_thr";
            desc = "Maximum SAD threshold";
            sw = rw; hw = r;
            reset = 0x40;
        } max_sad_thr[6:0];
    } WBC_G4_RC_CFG3 @ 0xA494;
    reg {
        name = "WBC_G4_RC_CFG4";
        desc = "WBC_G4_RC_CFG4 is an RC parameter 4 register. (offset 0xA498; total reset 0x00100103; PROVEN: Hi3536D V100 data sheet (Issue 00B04, 2017-12-13), section 1.37, PDF page 559).";
        field {
            name = "reserved";
            desc = "Reserved";
            sw = r; hw = w;
            reset = 0x0;
        } reserved_31_26[31:26];
        field {
            name = "big_grad_thr";
            desc = "Large gradient threshold";
            sw = rw; hw = r;
            reset = 0x10;
        } big_grad_thr[25:16];
        field {
            name = "reserved";
            desc = "Reserved";
            sw = r; hw = w;
            reset = 0x0;
        } reserved_15_15[15:15];
        field {
            name = "still_thr";
            desc = "Static region threshold";
            sw = rw; hw = r;
            reset = 0x1;
        } still_thr[14:8];
        field {
            name = "reserved";
            desc = "Reserved";
            sw = r; hw = w;
            reset = 0x0;
        } reserved_7_7[7:7];
        field {
            name = "smth_thr";
            desc = "Smooth region threshold";
            sw = rw; hw = r;
            reset = 0x3;
        } smth_thr[6:0];
    } WBC_G4_RC_CFG4 @ 0xA498;
    reg {
        name = "WBC_G4_RC_CFG5";
        desc = "WBC_G4_RC_CFG3 is an RC parameter 5 register. (offset 0xA49C; total reset 0x0A180306; PROVEN: Hi3536D V100 data sheet (Issue 00B04, 2017-12-13), section 1.37, PDF page 559).";
        field {
            name = "reserved";
            desc = "Reserved";
            sw = r; hw = w;
            reset = 0x0;
        } reserved_31_30[31:30];
        field {
            name = "large_smth_pix_num_thr";
            desc = "Threshold for determining whether a region is a large smooth region";
            sw = rw; hw = r;
            reset = 0xa;
        } large_smth_pix_num_thr[29:24];
        field {
            name = "reserved";
            desc = "Reserved";
            sw = r; hw = w;
            reset = 0x0;
        } reserved_23_22[23:22];
        field {
            name = "noise_pix_num_thr";
            desc = "Threshold for determining whether a region is a noise region";
            sw = rw; hw = r;
            reset = 0x18;
        } noise_pix_num_thr[21:16];
        field {
            name = "reserved";
            desc = "Reserved";
            sw = r; hw = w;
            reset = 0x0;
        } reserved_15_14[15:14];
        field {
            name = "still_pix_num_thr";
            desc = "Threshold for determining whether a region is a static region";
            sw = rw; hw = r;
            reset = 0x3;
        } still_pix_num_thr[13:8];
        field {
            name = "reserved";
            desc = "Reserved";
            sw = r; hw = w;
            reset = 0x0;
        } reserved_7_6[7:6];
        field {
            name = "smth_pix_num_thr";
            desc = "Threshold for determining whether a region is a smooth region";
            sw = rw; hw = r;
            reset = 0x6;
        } smth_pix_num_thr[5:0];
    } WBC_G4_RC_CFG5 @ 0xA49C;
    reg {
        name = "WBC_G4_RC_CFG6";
        desc = "WBC_G4_RC_CFG6 is an RC parameter 6 register. (offset 0xA4A0; total reset 0x00320020; PROVEN: Hi3536D V100 data sheet (Issue 00B04, 2017-12-13), section 1.37, PDF page 560).";
        field {
            name = "reserved";
            desc = "Reserved";
            sw = r; hw = w;
            reset = 0x0;
        } reserved_31_25[31:25];
        field {
            name = "pix_diff_thr";
            desc = "Diff threshold";
            sw = rw; hw = r;
            reset = 0x32;
        } pix_diff_thr[24:16];
        field {
            name = "reserved";
            desc = "Reserved";
            sw = r; hw = w;
            reset = 0x0;
        } reserved_15_7[15:7];
        field {
            name = "noise_sad";
            desc = "SAD of the noise region";
            sw = rw; hw = r;
            reset = 0x20;
        } noise_sad[6:0];
    } WBC_G4_RC_CFG6 @ 0xA4A0;
    reg {
        name = "WBC_G4_RC_CFG7";
        desc = "WBC_G4_RC_CFG7 is an RC parameter 7 register. (offset 0xA4A4; total reset 0x00000A1E; PROVEN: Hi3536D V100 data sheet (Issue 00B04, 2017-12-13), section 1.37, PDF page 560).";
        field {
            name = "reserved";
            desc = "Reserved";
            sw = r; hw = w;
            reset = 0x0;
        } reserved_31_16[31:16];
        field {
            name = "max_trow_bits";
            desc = "Maximum number of bits in the previous row";
            sw = rw; hw = r;
            reset = 0xa;
        } max_trow_bits[15:8];
        field {
            name = "reserved";
            desc = "Reserved";
            sw = r; hw = w;
            reset = 0x0;
        } reserved_7_7[7:7];
        field {
            name = "adj_sad_bits_thr";
            desc = "Number of adjusted bits for SAD";
            sw = rw; hw = r;
            reset = 0x1e;
        } adj_sad_bits_thr[6:0];
    } WBC_G4_RC_CFG7 @ 0xA4A4;
    reg {
        name = "WBC_G4_RC_CFG8";
        desc = "WBC_G4_RC_CFG8 is an RC parameter 8 register. (offset 0xA4A8; total reset 0x825A2832; PROVEN: Hi3536D V100 data sheet (Issue 00B04, 2017-12-13), section 1.37, PDF page 561).";
        field {
            name = "qp_dec3_bits_thr";
            desc = "Threshold 3 for the number of bits adjusted to decrease the QP value";
            sw = rw; hw = r;
            reset = 0x82;
        } qp_dec3_bits_thr[31:24];
        field {
            name = "qp_dec2_bits_thr";
            desc = "Threshold 2 for the number of bits adjusted to decrease the QP value";
            sw = rw; hw = r;
            reset = 0x5a;
        } qp_dec2_bits_thr[23:16];
        field {
            name = "qp_dec1_bits_thr";
            desc = "Threshold 1 for the number of bits adjusted to decrease the QP value";
            sw = rw; hw = r;
            reset = 0x28;
        } qp_dec1_bits_thr[15:8];
        field {
            name = "qp_inc1_bits_thr";
            desc = "Threshold for the number of bits adjusted to increase the QP value";
            sw = rw; hw = r;
            reset = 0x32;
        } qp_inc1_bits_thr[7:0];
    } WBC_G4_RC_CFG8 @ 0xA4A8;
    reg {
        name = "WBC_G4_RC_CFG9";
        desc = "WBC_G4_RC_CFG9 is an RC parameter 9 register. (offset 0xA4AC; total reset 0x00140046; PROVEN: Hi3536D V100 data sheet (Issue 00B04, 2017-12-13), section 1.37, PDF page 561).";
        field {
            name = "reserved";
            desc = "Reserved";
            sw = r; hw = w;
            reset = 0x0;
        } reserved_31_26[31:26];
        field {
            name = "force_qp_thr_cap";
            desc = "Threshold for forcible qp_cap variance";
            sw = rw; hw = r;
            reset = 0x14;
        } force_qp_thr_cap[25:16];
        field {
            name = "reserved";
            desc = "Reserved";
            sw = r; hw = w;
            reset = 0x0;
        } reserved_15_10[15:10];
        field {
            name = "force_qp_thr";
            desc = "Threshold for forcible QP variance";
            sw = rw; hw = r;
            reset = 0x46;
        } force_qp_thr[9:0];
    } WBC_G4_RC_CFG9 @ 0xA4AC;
    reg {
        name = "WBC_G4_MAX_ROW_LEN";
        desc = "WBC_G4_MAX_ROW_LEN is a 128-bit unit register for the row with the lowest compression ratio. (offset 0xA4B0; total reset 0x00000000; PROVEN: Hi3536D V100 data sheet (Issue 00B04, 2017-12-13), section 1.37, PDF page 562).";
        field {
            name = "reserved";
            desc = "Reserved";
            sw = r; hw = w;
            reset = 0x0;
        } reserved_31_10[31:10];
        field {
            name = "max_row_len";
            desc = "128-bit unit occupied by the row with the lowest compression ratio";
            sw = rw; hw = r;
            reset = 0x0;
        } max_row_len[9:0];
    } WBC_G4_MAX_ROW_LEN @ 0xA4B0;
    reg {
        name = "CBM_BKG2";
        desc = "CBM_BKG2 is a CBM mixer 2 overlay background color register. (offset 0xB420; total reset 0x00000000; PROVEN: Hi3536D V100 data sheet (Issue 00B04, 2017-12-13), section 1.37, PDF page 562).";
        field {
            name = "reserved";
            desc = "Reserved";
            sw = r; hw = w;
            reset = 0x0;
        } reserved_31_30[31:30];
        field {
            name = "cbm_bkgy2";
            desc = "Overlay background color of CBM mixer 2, Y component";
            sw = rw; hw = r;
            reset = 0x0;
        } cbm_bkgy2[29:20];
        field {
            name = "cbm_bkgcb2";
            desc = "Overlay background color of CBM mixer 2, Cb component";
            sw = rw; hw = r;
            reset = 0x0;
        } cbm_bkgcb2[19:10];
        field {
            name = "cbm_bkgcr2";
            desc = "Overlay background color of CBM mixer 2, Cr component";
            sw = rw; hw = r;
            reset = 0x0;
        } cbm_bkgcr2[9:0];
    } CBM_BKG2 @ 0xB420;
    reg {
        name = "CBM_MIX2";
        desc = "CBM_MIX2 is a CBM mixer 2 priority configuration register (instant register). The register configuration takes effect only when the VSYNC signal is valid. mixer_prio_x is the overlay layer priority x. (offset 0xB428; total reset 0x00000000; PROVEN: Hi3536D V100 data sheet (Issue 00B04, 2017-12-13), section 1.37, PDF page 563).";
        field {
            name = "reserved";
            desc = "Reserved";
            sw = r; hw = w;
            reset = 0x0;
        } reserved_31_20[31:20];
        field {
            name = "mixer_prio4";
            desc = "Drive layer of CBM mixer 2 with priority 4
- 0000: no drive layer
- 0011: V3
- 0100: G4
- 1001: V1
- 1010: HC0

Other values: reserved";
            sw = rw; hw = r;
            reset = 0x0;
        } mixer_prio4[19:16];
        field {
            name = "mixer_prio3";
            desc = "Drive layer of CBM mixer 2 with priority 3
- 0000: no drive layer
- 0011: V3
- 0100: G4
- 1001: V1
- 1010: HC0

Other values: reserved";
            sw = rw; hw = r;
            reset = 0x0;
        } mixer_prio3[15:12];
        field {
            name = "mixer_prio2";
            desc = "Drive layer of CBM mixer 2 with priority 2
- 0000: no drive layer
- 0011: V3
- 0100: G4
- 1001: V1
- 1010: HC0

Other values: reserved";
            sw = rw; hw = r;
            reset = 0x0;
        } mixer_prio2[11:8];
        field {
            name = "mixer_prio1";
            desc = "Drive layer of CBM mixer 2 with priority 1
- 0000: no drive layer
- 0011: V3
- 0100: G4
- 1001: V1
- 1010: HC0

Other values: reserved";
            sw = rw; hw = r;
            reset = 0x0;
        } mixer_prio1[7:4];
        field {
            name = "mixer_prio0";
            desc = "Drive layer of CBM mixer 2 with priority 0
- 0000: no drive layer
- 0011: V3
- 0100: G4
- 1001: V1
- 1010: HC0

Other values: reserved";
            sw = rw; hw = r;
            reset = 0x0;
        } mixer_prio0[3:0];
    } CBM_MIX2 @ 0xB428;
    reg {
        name = "DHD1_CTRL";
        desc = "DHD1_CTRL is a display channel global control register. You must configure any bit of this register before configuring DHD1_CTRL[intf_en]. Otherwise, the configuration does not take effect. (offset 0xC400; total reset 0x00000000; PROVEN: Hi3536D V100 data sheet (Issue 00B04, 2017-12-13), section 1.37, PDF page 564).";
        field {
            name = "intf_en";
            desc = "Display interface enable (instant register). Data is output over the interface only when this field is enabled.
- 0: disabled
- 1: enabled";
            sw = rw; hw = r;
            reset = 0x0;
        } intf_en[31:31];
        field {
            name = "cbar_en";
            desc = "Color bar enable. The color bar is output over the interface when this field is enabled.
- 0: disabled
- 1: enabled";
            sw = rw; hw = r;
            reset = 0x0;
        } cbar_en[30:30];
        field {
            name = "cbar_sel";
            desc = "Color space select for the output color bar (instant register)
- 0: RGB
- 1: YPbPr";
            sw = rw; hw = r;
            reset = 0x0;
        } cbar_sel[29:29];
        field {
            name = "reserved";
            desc = "Reserved";
            sw = r; hw = w;
            reset = 0x0;
        } reserved_28_5[28:5];
        field {
            name = "iop";
            desc = "Progressive or interlaced display (non-instant register)
- 0: interlaced display
- 1: progressive display";
            sw = rw; hw = r;
            reset = 0x0;
        } iop[4:4];
        field {
            name = "reserved";
            desc = "Reserved";
            sw = r; hw = w;
            reset = 0x0;
        } reserved_3_1[3:1];
        field {
            name = "regup";
            desc = "Surface register update. After the registers at this layer are configured, the registers are updated when the value 1 is written to this bit. After updates, this bit is automatically cleared by the hardware.

Access type WC in the data sheet: written 1 clears the bit.";
            sw = rw; hw = w; onwrite = woclr;
            reset = 0x0;
        } regup[0:0];
    } DHD1_CTRL @ 0xC400;
    reg {
        name = "DHD1_VSYNC";
        desc = "DHD1_VSYNC is a top field vertical sync timing register in interlaced output mode or frame vertical sync timing register in progressive output mode. This register is a non-instant register. (offset 0xC404; total reset 0x0011321B; PROVEN: Hi3536D V100 data sheet (Issue 00B04, 2017-12-13), section 1.37, PDF page 565).";
        field {
            name = "reserved";
            desc = "Reserved";
            sw = r; hw = w;
            reset = 0x0;
        } reserved_31_28[31:28];
        field {
            name = "vfb";
            desc = "In interlaced output mode: top vertical front blanking (TVFB) In progressive output mode: vertical front blanking (VFB)";
            sw = rw; hw = r;
            reset = 0x1;
        } vfb[27:20];
        field {
            name = "vbb";
            desc = "In interlaced output mode: top vertical back blanking (TVBB) In progressive output mode: vertical back blanking (VBB)+vertical pulse width (VPW)";
            sw = rw; hw = r;
            reset = 0x13;
        } vbb[19:12];
        field {
            name = "vact";
            desc = "In interlaced output mode: height of active picture on the top field In progressive output mode: height of an active picture in a frame. The register value is the actual value minus 1.";
            sw = rw; hw = r;
            reset = 0x21b;
        } vact[11:0];
    } DHD1_VSYNC @ 0xC404;
    reg {
        name = "DHD1_HSYNC1";
        desc = "DHD1_HSYNC1 is horizontal sync configuration register 1 in interlaced or progressive output mode (non-instant register). (offset 0xC408; total reset 0x00BF077F; PROVEN: Hi3536D V100 data sheet (Issue 00B04, 2017-12-13), section 1.37, PDF page 565).";
        field {
            name = "hbb";
            desc = "Horizontal back blanking (HBB), in pixel";
            sw = rw; hw = r;
            reset = 0xbf;
        } hbb[31:16];
        field {
            name = "hact";
            desc = "Number of horizontal pixels in an active region";
            sw = rw; hw = r;
            reset = 0x77f;
        } hact[15:0];
    } DHD1_HSYNC1 @ 0xC408;
    reg {
        name = "DHD1_HSYNC2";
        desc = "DHD1_HSYNC2 is horizontal sync configuration register 2 in interlaced or progressive output mode (non-instant register). (offset 0xC40C; total reset 0x0000020F; PROVEN: Hi3536D V100 data sheet (Issue 00B04, 2017-12-13), section 1.37, PDF page 566).";
        field {
            name = "hmid";
            desc = "Bottom vertical sync active pixel (active region)";
            sw = rw; hw = r;
            reset = 0x0;
        } hmid[31:16];
        field {
            name = "hfb";
            desc = "Horizontal front blanking (HFB), in pixel";
            sw = rw; hw = r;
            reset = 0x20f;
        } hfb[15:0];
    } DHD1_HSYNC2 @ 0xC40C;
    reg {
        name = "DHD1_VPLUS";
        desc = "DHD1_VPLUS is a bottom field vertical sync timing in interlaced output mode (non-instant register). (offset 0xC410; total reset 0x0021321B; PROVEN: Hi3536D V100 data sheet (Issue 00B04, 2017-12-13), section 1.37, PDF page 566).";
        field {
            name = "reserved";
            desc = "Reserved";
            sw = r; hw = w;
            reset = 0x0;
        } reserved_31_28[31:28];
        field {
            name = "bvfb";
            desc = "Bottom vertical front blanking (BVFB) in interlaced output mode";
            sw = rw; hw = r;
            reset = 0x2;
        } bvfb[27:20];
        field {
            name = "bvbb";
            desc = "Bottom vertical back blanking (BVBB)+VPW in interlaced output mode";
            sw = rw; hw = r;
            reset = 0x13;
        } bvbb[19:12];
        field {
            name = "bvact";
            desc = "Height of an active picture in the bottom field in interlaced output mode The register value is the actual value minus 1.";
            sw = rw; hw = r;
            reset = 0x21b;
        } bvact[11:0];
    } DHD1_VPLUS @ 0xC410;
    reg {
        name = "DHD1_PWR";
        desc = "DHD1_PWR is a sync signal pulse width register (non-instant register). (offset 0xC414; total reset 0x00000000; PROVEN: Hi3536D V100 data sheet (Issue 00B04, 2017-12-13), section 1.37, PDF page 567).";
        field {
            name = "reserved";
            desc = "Reserved";
            sw = r; hw = w;
            reset = 0x0;
        } reserved_31_24[31:24];
        field {
            name = "vpw";
            desc = "VPW minus 1.";
            sw = rw; hw = r;
            reset = 0x0;
        } vpw[23:16];
        field {
            name = "hpw";
            desc = "Horizontal pulse width (HPW) minus 1.";
            sw = rw; hw = r;
            reset = 0x0;
        } hpw[15:0];
    } DHD1_PWR @ 0xC414;
    reg {
        name = "DHD1_VTTHD3";
        desc = "DHD1_VTTHD3 is a vertical timing threshold register (instant register). It can be used to set two thresholds for generating two interrupts separately. (offset 0xC418; total reset 0x00000000; PROVEN: Hi3536D V100 data sheet (Issue 00B04, 2017-12-13), section 1.37, PDF page 567).";
        field {
            name = "thd4_mode";
            desc = "Mode of generating threshold 4
- 0: frame mode. The threshold count is in the unit of frame.
- 1: field mode. The threshold count is in the unit of field during interlaced displaying.";
            sw = rw; hw = r;
            reset = 0x0;
        } thd4_mode[31:31];
        field {
            name = "reserved";
            desc = "Reserved";
            sw = r; hw = w;
            reset = 0x0;
        } reserved_30_29[30:29];
        field {
            name = "vtmgthd4";
            desc = "Vertical timing threshold 4 for simultaneously triggering DHD and DSD. The start time of the DSD interface timing is later than that of the DHD interface timing and is equal to the number of lines configured in vtmgthd4.";
            sw = rw; hw = r;
            reset = 0x0;
        } vtmgthd4[28:16];
        field {
            name = "thd3_mode";
            desc = "Mode of generating threshold 3
- 0: frame mode. The threshold count is in the unit of frame.
- 1: field mode. The threshold count is in the unit of field during interlaced displaying.";
            sw = rw; hw = r;
            reset = 0x0;
        } thd3_mode[15:15];
        field {
            name = "reserved";
            desc = "Reserved";
            sw = r; hw = w;
            reset = 0x0;
        } reserved_14_13[14:13];
        field {
            name = "vtmgthd3";
            desc = "Vertical timing threshold 3. When the vertical timing counter reaches this threshold, the VOINTSTA[dhdvtthd3_int] interrupt is triggered.";
            sw = rw; hw = r;
            reset = 0x0;
        } vtmgthd3[12:0];
    } DHD1_VTTHD3 @ 0xC418;
    reg {
        name = "DHD1_VTTHD";
        desc = "DHD1_VTTHD is a vertical timing threshold register (instant register). It can be used to set two thresholds for generating two interrupts separately. (offset 0xC41C; total reset 0x00010001; PROVEN: Hi3536D V100 data sheet (Issue 00B04, 2017-12-13), section 1.37, PDF page 568).";
        field {
            name = "thd2_mode";
            desc = "Mode of generating threshold 2
- 0: frame mode. The threshold count is in the unit of frame.
- 1: field mode. The threshold count is in the unit of field during interlaced displaying.";
            sw = rw; hw = r;
            reset = 0x0;
        } thd2_mode[31:31];
        field {
            name = "reserved";
            desc = "Reserved";
            sw = r; hw = w;
            reset = 0x0;
        } reserved_30_29[30:29];
        field {
            name = "vtmgthd2";
            desc = "Vertical timing threshold 2. When the vertical timing counter reaches this threshold, the VOINTSTA[dhdvtthd2_int] interrupt is triggered.";
            sw = rw; hw = r;
            reset = 0x1;
        } vtmgthd2[28:16];
        field {
            name = "thd1_mode";
            desc = "Mode of generating threshold 1
- 0: frame mode. The threshold count is in the unit of frame.
- 1: field mode. The threshold count is in the unit of field during interlaced displaying.";
            sw = rw; hw = r;
            reset = 0x0;
        } thd1_mode[15:15];
        field {
            name = "reserved";
            desc = "Reserved";
            sw = r; hw = w;
            reset = 0x0;
        } reserved_14_13[14:13];
        field {
            name = "vtmgthd1";
            desc = "Vertical timing threshold 1. When the vertical timing counter reaches this threshold, the VOINTSTA[dhdvtthd_int1] interrupt is triggered.";
            sw = rw; hw = r;
            reset = 0x1;
        } vtmgthd1[12:0];
    } DHD1_VTTHD @ 0xC41C;
    reg {
        name = "DHD1_AFFTHD";
        desc = "DHD1_AFFTHD is a DHD buffer FIFO register. (offset 0xC430; total reset 0x00000020; PROVEN: Hi3536D V100 data sheet (Issue 00B04, 2017-12-13), section 1.37, PDF page 569).";
        field {
            name = "reserved";
            desc = "Reserved";
            sw = r; hw = w;
            reset = 0x0;
        } reserved_31_11[31:11];
        field {
            name = "dhd_aff_thd";
            desc = "DHD buffer FIFO register";
            sw = rw; hw = r;
            reset = 0x20;
        } dhd_aff_thd[10:0];
    } DHD1_AFFTHD @ 0xC430;
    reg {
        name = "DHD1_ABUFTHD";
        desc = "DHD1_ABUFTHD is a DHD buffer register. (offset 0xC434; total reset 0x00000073; PROVEN: Hi3536D V100 data sheet (Issue 00B04, 2017-12-13), section 1.37, PDF page 569).";
        field {
            name = "reserved";
            desc = "Reserved";
            sw = r; hw = w;
            reset = 0x0;
        } reserved_31_11[31:11];
        field {
            name = "dhd_buf_thd";
            desc = "DHD buffer register";
            sw = rw; hw = r;
            reset = 0x73;
        } dhd_buf_thd[10:0];
    } DHD1_ABUFTHD @ 0xC434;
    reg {
        name = "DHD1_VGA_DACDET1";
        desc = "DHD1_DACDET1 is DAC automatic detection register 1. (offset 0xC438; total reset 0x000D0303; PROVEN: Hi3536D V100 data sheet (Issue 00B04, 2017-12-13), section 1.37, PDF page 569).";
        field {
            name = "reserved";
            desc = "Reserved";
            sw = r; hw = w;
            reset = 0x0;
        } reserved_31_26[31:26];
        field {
            name = "det_line";
            desc = "Line of the detected level";
            sw = rw; hw = r;
            reset = 0xd;
        } det_line[25:16];
        field {
            name = "reserved";
            desc = "Reserved";
            sw = r; hw = w;
            reset = 0x0;
        } reserved_15_10[15:10];
        field {
            name = "vdac_det_high";
            desc = "Detected level";
            sw = rw; hw = r;
            reset = 0x303;
        } vdac_det_high[9:0];
    } DHD1_VGA_DACDET1 @ 0xC438;
    reg {
        name = "DHD1_VGA_DACDET2";
        desc = "DHD1_DACDET2 is DAC automatic detection register 2. (offset 0xC43C; total reset 0x00300118; PROVEN: Hi3536D V100 data sheet (Issue 00B04, 2017-12-13), section 1.37, PDF page 570).";
        field {
            name = "vdac_det_en";
            desc = "DAC automatic detection enable
- 0: disabled
- 1: enabled";
            sw = rw; hw = r;
            reset = 0x0;
        } vdac_det_en[31:31];
        field {
            name = "reserved";
            desc = "Reserved";
            sw = r; hw = w;
            reset = 0x0;
        } reserved_30_27[30:27];
        field {
            name = "det_pixel_wid";
            desc = "Level width";
            sw = rw; hw = r;
            reset = 0x30;
        } det_pixel_wid[26:16];
        field {
            name = "reserved";
            desc = "Reserved";
            sw = r; hw = w;
            reset = 0x0;
        } reserved_15_11[15:11];
        field {
            name = "det_pixel_sta";
            desc = "Start position of a line";
            sw = rw; hw = r;
            reset = 0x118;
        } det_pixel_sta[10:0];
    } DHD1_VGA_DACDET2 @ 0xC43C;
    reg {
        name = "DHD1_STATE";
        desc = "DHD1_STATE is a DHD1 status register. (offset 0xC4F0; total reset 0x00000006; PROVEN: Hi3536D V100 data sheet (Issue 00B04, 2017-12-13), section 1.37, PDF page 571).";
        field {
            name = "reserved";
            desc = "Reserved";
            sw = r; hw = w;
            reset = 0x0;
        } reserved_31_24[31:24];
        field {
            name = "count_int";
            desc = "DHD1 interrupt count. The interrupt count is increased by 1 each time a vertical timing interrupt is reported.";
            sw = r; hw = w;
            reset = 0x0;
        } count_int[23:16];
        field {
            name = "vcnt";
            desc = "Active display line count of DHD1";
            sw = r; hw = w;
            reset = 0x0;
        } vcnt[15:3];
        field {
            name = "bottom_field";
            desc = "DHD1 top/bottom field display flag
- 0: top field
- 1: bottom field";
            sw = r; hw = w;
            reset = 0x1;
        } bottom_field[2:2];
        field {
            name = "vblank";
            desc = "DHD1 blanking region display flag
- 0: active region
- 1: blanking region";
            sw = r; hw = w;
            reset = 0x1;
        } vblank[1:1];
        field {
            name = "vback_blank";
            desc = "DHD1 back blanking region display flag
- 0: non-back blanking region
- 1: blanking region";
            sw = r; hw = w;
            reset = 0x0;
        } vback_blank[0:0];
    } DHD1_STATE @ 0xC4F0;
    reg {
        name = "INTF_CTRL";
        desc = "INTF_CTRL is an output interface control register. (offset 0xD000; total reset 0x00000000; PROVEN: Hi3536D V100 data sheet (Issue 00B04, 2017-12-13), section 1.37, PDF page 572).";
        field {
            name = "hdmi_mode";
            desc = "Color space select for the output HDMI data (non-instant register)
- 0: YUV
- 1: RGB";
            sw = rw; hw = r;
            reset = 0x0;
        } hdmi_mode[31:31];
        field {
            name = "reserved";
            desc = "Reserved";
            sw = r; hw = w;
            reset = 0x0;
        } reserved_30_0[30:0];
    } INTF_CTRL @ 0xD000;
    reg {
        name = "INTF_SYNC_INV";
        desc = "INTF_SYNC_INV is sync signal polarity configuration register in external sync timing output mode. The setting of this register takes effect immediately after configuration. That is, the polarity of the corresponding sync signal is immediately affected. (offset 0xD008; total reset 0x00000000; PROVEN: Hi3536D V100 data sheet (Issue 00B04, 2017-12-13), section 1.37, PDF page 572).";
        field {
            name = "reserved";
            desc = "Reserved";
            sw = r; hw = w;
            reset = 0x0;
        } reserved_31_4[31:4];
        field {
            name = "f_inv";
            desc = "Output phase reverse enable for the odd/even field indicator signal (instant register)
- 0: disabled
- 1: enabled";
            sw = rw; hw = r;
            reset = 0x0;
        } f_inv[3:3];
        field {
            name = "vs_inv";
            desc = "Output phase reverse enable for the vertical sync pulse (instant register)
- 0: disabled
- 1: enabled";
            sw = rw; hw = r;
            reset = 0x0;
        } vs_inv[2:2];
        field {
            name = "hs_inv";
            desc = "Output phase reverse enable for the horizontal sync pulse (instant register)
- 0: disabled
- 1: enabled";
            sw = rw; hw = r;
            reset = 0x0;
        } hs_inv[1:1];
        field {
            name = "dv_inv";
            desc = "Output phase reverse enable for the data validity signal (instant register)
- 0: disabled
- 1: enabled";
            sw = rw; hw = r;
            reset = 0x0;
        } dv_inv[0:0];
    } INTF_SYNC_INV @ 0xD008;
    reg {
        name = "INTF_CLIP0_L";
        desc = "INTF_CLIP0_L is a clip lowest threshold register (instant register). (offset 0xD010; total reset 0x01004010; PROVEN: Hi3536D V100 data sheet (Issue 00B04, 2017-12-13), section 1.37, PDF page 573).";
        field {
            name = "reserved";
            desc = "Reserved";
            sw = r; hw = w;
            reset = 0x0;
        } reserved_31_30[31:30];
        field {
            name = "clip_cl2";
            desc = "Lowest threshold Y/R of component 2, unsigned integer";
            sw = rw; hw = r;
            reset = 0x10;
        } clip_cl2[29:20];
        field {
            name = "clip_cl1";
            desc = "Lowest threshold Cb/G of component 1, unsigned integer";
            sw = rw; hw = r;
            reset = 0x10;
        } clip_cl1[19:10];
        field {
            name = "clip_cl0";
            desc = "Lowest threshold Cr/B of component 0, unsigned integer";
            sw = rw; hw = r;
            reset = 0x10;
        } clip_cl0[9:0];
    } INTF_CLIP0_L @ 0xD010;
    reg {
        name = "INTF_CLIP0_H";
        desc = "INTF_CLIP0_H is a clip highest threshold register (instant register). For example, the output data needs to be clipped in BT.656 output mode. (offset 0xD014; total reset 0x3FFFFFFF; PROVEN: Hi3536D V100 data sheet (Issue 00B04, 2017-12-13), section 1.37, PDF page 574).";
        field {
            name = "reserved";
            desc = "Reserved";
            sw = r; hw = w;
            reset = 0x0;
        } reserved_31_30[31:30];
        field {
            name = "clip_ch2";
            desc = "Highest threshold Y/R of component 2, unsigned integer";
            sw = rw; hw = r;
            reset = 0x3ff;
        } clip_ch2[29:20];
        field {
            name = "clip_ch1";
            desc = "Highest threshold Cb/G of component 1, unsigned integer";
            sw = rw; hw = r;
            reset = 0x3ff;
        } clip_ch1[19:10];
        field {
            name = "clip_ch0";
            desc = "Highest threshold Cr/B of component 0, unsigned integer";
            sw = rw; hw = r;
            reset = 0x3ff;
        } clip_ch0[9:0];
    } INTF_CLIP0_H @ 0xD014;
    reg {
        name = "INTF_CSC_IDC";
        desc = "INTF_CSC_IDC is a CSC input DC component register (instant register). (offset 0xD020; total reset 0x00000000; PROVEN: Hi3536D V100 data sheet (Issue 00B04, 2017-12-13), section 1.37, PDF page 574).";
        field {
            name = "reserved";
            desc = "Reserved";
            sw = r; hw = w;
            reset = 0x0;
        } reserved_31_23[31:23];
        field {
            name = "csc_en";
            desc = "CSC enable
- 0: disabled
- 1: enabled";
            sw = rw; hw = r;
            reset = 0x0;
        } csc_en[22:22];
        field {
            name = "cscidc1";
            desc = "DC parameter of the input component 1. The MSB is the signed bit. The value is expressed as a complement.";
            sw = rw; hw = r;
            reset = 0x0;
        } cscidc1[21:11];
        field {
            name = "cscidc0";
            desc = "DC parameter of the input component 0. The MSB is the signed bit. The value is expressed as a complement.";
            sw = rw; hw = r;
            reset = 0x0;
        } cscidc0[10:0];
    } INTF_CSC_IDC @ 0xD020;
    reg {
        name = "INTF_CSC_ODC";
        desc = "INTF_CSC_ODC is a CSC output DC component register (instant register). (offset 0xD024; total reset 0x00000000; PROVEN: Hi3536D V100 data sheet (Issue 00B04, 2017-12-13), section 1.37, PDF page 575).";
        field {
            name = "reserved";
            desc = "Reserved";
            sw = r; hw = w;
            reset = 0x0;
        } reserved_31_23[31:23];
        field {
            name = "csc_sign_mode";
            desc = "CSC output mode
- 0: The CSC output is a 10-bit unsigned number.
- 1: The CSC output is a 12-bit signed number.";
            sw = rw; hw = r;
            reset = 0x0;
        } csc_sign_mode[22:22];
        field {
            name = "cscodc1";
            desc = "DC parameter of the output component 1. The MSB is the signed bit. The value is expressed as a complement.";
            sw = rw; hw = r;
            reset = 0x0;
        } cscodc1[21:11];
        field {
            name = "cscodc0";
            desc = "DC parameter of the output component 0. The MSB is the signed bit. The value is expressed as a complement.";
            sw = rw; hw = r;
            reset = 0x0;
        } cscodc0[10:0];
    } INTF_CSC_ODC @ 0xD024;
    reg {
        name = "INTF_CSC_IODC";
        desc = "INTF_CSC_IODC is a CSC input/output DC component register (instant register). (offset 0xD028; total reset 0x00000000; PROVEN: Hi3536D V100 data sheet (Issue 00B04, 2017-12-13), section 1.37, PDF page 575).";
        field {
            name = "reserved";
            desc = "Reserved";
            sw = r; hw = w;
            reset = 0x0;
        } reserved_31_22[31:22];
        field {
            name = "cscodc2";
            desc = "DC parameter of the output component 2. The MSB is the signed bit. The value is expressed as a complement.";
            sw = rw; hw = r;
            reset = 0x0;
        } cscodc2[21:11];
        field {
            name = "cscidc2";
            desc = "DC parameter of the input component 2. The MSB is the signed bit. The value is expressed as a complement.";
            sw = rw; hw = r;
            reset = 0x0;
        } cscidc2[10:0];
    } INTF_CSC_IODC @ 0xD028;
    reg {
        name = "INTF_CSC_P0";
        desc = "INTF_CSC_P0 is a CSC parameter 0 register (instant register). (offset 0xD02C; total reset 0x00000000; PROVEN: Hi3536D V100 data sheet (Issue 00B04, 2017-12-13), section 1.37, PDF page 576).";
        field {
            name = "reserved";
            desc = "Reserved";
            sw = r; hw = w;
            reset = 0x0;
        } reserved_31_31[31:31];
        field {
            name = "cscp01";
            desc = "s(5.10) data format: signed number, 1 sign bit, 4 integer bits, and 10 decimal bits. The value is represented by a complement.";
            sw = rw; hw = r;
            reset = 0x0;
        } cscp01[30:16];
        field {
            name = "reserved";
            desc = "Reserved";
            sw = r; hw = w;
            reset = 0x0;
        } reserved_15_15[15:15];
        field {
            name = "cscp00";
            desc = "s(5.10) data format: signed number, 1 sign bit, 4 integer bits, and 10 decimal bits. The value is represented by a complement.";
            sw = rw; hw = r;
            reset = 0x0;
        } cscp00[14:0];
    } INTF_CSC_P0 @ 0xD02C;
    reg {
        name = "INTF_CSC_P1";
        desc = "INTF_CSC_P1 is a CSC parameter 1 register (instant register). (offset 0xD030; total reset 0x00000000; PROVEN: Hi3536D V100 data sheet (Issue 00B04, 2017-12-13), section 1.37, PDF page 576).";
        field {
            name = "reserved";
            desc = "Reserved";
            sw = r; hw = w;
            reset = 0x0;
        } reserved_31_31[31:31];
        field {
            name = "cscp10";
            desc = "s(5.10) data format: signed number, 1 sign bit, 4 integer bits, and 10 decimal bits. The value is represented by a complement.";
            sw = rw; hw = r;
            reset = 0x0;
        } cscp10[30:16];
        field {
            name = "reserved";
            desc = "Reserved";
            sw = r; hw = w;
            reset = 0x0;
        } reserved_15_15[15:15];
        field {
            name = "cscp02";
            desc = "s(5.10) data format: signed number, 1 sign bit, 4 integer bits, and 10 decimal bits. The value is represented by a complement.";
            sw = rw; hw = r;
            reset = 0x0;
        } cscp02[14:0];
    } INTF_CSC_P1 @ 0xD030;
    reg {
        name = "INTF_CSC_P2";
        desc = "INTF_CSC_P2 is a CSC parameter 2 register (instant register). (offset 0xD034; total reset 0x00000000; PROVEN: Hi3536D V100 data sheet (Issue 00B04, 2017-12-13), section 1.37, PDF page 577).";
        field {
            name = "reserved";
            desc = "Reserved";
            sw = r; hw = w;
            reset = 0x0;
        } reserved_31_31[31:31];
        field {
            name = "cscp12";
            desc = "s(5.10) data format: signed number, 1 sign bit, 4 integer bits, and 10 decimal bits. The value is represented by a complement.";
            sw = rw; hw = r;
            reset = 0x0;
        } cscp12[30:16];
        field {
            name = "reserved";
            desc = "Reserved";
            sw = r; hw = w;
            reset = 0x0;
        } reserved_15_15[15:15];
        field {
            name = "cscp11";
            desc = "s(5.10) data format: signed number, 1 sign bit, 4 integer bits, and 10 decimal bits. The value is represented by a complement.";
            sw = rw; hw = r;
            reset = 0x0;
        } cscp11[14:0];
    } INTF_CSC_P2 @ 0xD034;
    reg {
        name = "INTF_CSC_P3";
        desc = "INTF_CSC_P3 is a CSC parameter 3 register (instant register). (offset 0xD038; total reset 0x00000000; PROVEN: Hi3536D V100 data sheet (Issue 00B04, 2017-12-13), section 1.37, PDF page 577).";
        field {
            name = "reserved";
            desc = "Reserved";
            sw = r; hw = w;
            reset = 0x0;
        } reserved_31_31[31:31];
        field {
            name = "cscp21";
            desc = "s(5.10) data format: signed number, 1 sign bit, 4 integer bits, and 10 decimal bits. The value is represented by a complement.";
            sw = rw; hw = r;
            reset = 0x0;
        } cscp21[30:16];
        field {
            name = "reserved";
            desc = "Reserved";
            sw = r; hw = w;
            reset = 0x0;
        } reserved_15_15[15:15];
        field {
            name = "cscp20";
            desc = "s(5.10) data format: signed number, 1 sign bit, 4 integer bits, and 10 decimal bits. The value is represented by a complement.";
            sw = rw; hw = r;
            reset = 0x0;
        } cscp20[14:0];
    } INTF_CSC_P3 @ 0xD038;
    reg {
        name = "INTF_CSC_P4";
        desc = "INTF_CSC_P4 is a CSC parameter 4 register (instant register). (offset 0xD03C; total reset 0x00000000; PROVEN: Hi3536D V100 data sheet (Issue 00B04, 2017-12-13), section 1.37, PDF page 578).";
        field {
            name = "reserved";
            desc = "Reserved";
            sw = r; hw = w;
            reset = 0x0;
        } reserved_31_15[31:15];
        field {
            name = "cscp22";
            desc = "s(5.10) data format: signed number, 1 sign bit, 4 integer bits, and 10 decimal bits. The value is represented by a complement.";
            sw = rw; hw = r;
            reset = 0x0;
        } cscp22[14:0];
    } INTF_CSC_P4 @ 0xD03C;
    reg {
        name = "INTF_HSPCFG0";
        desc = "INTF_HSPCFG0 is HSP configuration register 0 (instant register). (offset 0xD040; total reset 0x00000000; PROVEN: Hi3536D V100 data sheet (Issue 00B04, 2017-12-13), section 1.37, PDF page 578).";
        field {
            name = "hsp_hf0_tmp3";
            desc = "High-frequency filtering coefficient 3, signed number";
            sw = rw; hw = r;
            reset = 0x0;
        } hsp_hf0_tmp3[31:24];
        field {
            name = "hsp_hf0_tmp2";
            desc = "High-frequency filtering coefficient 2, signed number";
            sw = rw; hw = r;
            reset = 0x0;
        } hsp_hf0_tmp2[23:16];
        field {
            name = "hsp_hf0_tmp1";
            desc = "High-frequency filtering coefficient 1, signed number";
            sw = rw; hw = r;
            reset = 0x0;
        } hsp_hf0_tmp1[15:8];
        field {
            name = "hsp_hf0_tmp0";
            desc = "High-frequency filtering coefficient 0, signed number";
            sw = rw; hw = r;
            reset = 0x0;
        } hsp_hf0_tmp0[7:0];
    } INTF_HSPCFG0 @ 0xD040;
    reg {
        name = "INTF_HSPCFG1";
        desc = "INTF_HSPCFG1 is HSP configuration register 1 (instant register). (offset 0xD044; total reset 0x00000000; PROVEN: Hi3536D V100 data sheet (Issue 00B04, 2017-12-13), section 1.37, PDF page 579).";
        field {
            name = "hsp_en";
            desc = "HSP enable
- 0: disabled
- 1: enabled";
            sw = rw; hw = r;
            reset = 0x0;
        } hsp_en[31:31];
        field {
            name = "reserved";
            desc = "Reserved";
            sw = r; hw = w;
            reset = 0x0;
        } reserved_30_8[30:8];
        field {
            name = "hsp_hf0_coring";
            desc = "High-frequency coring coefficient, unsigned number";
            sw = rw; hw = r;
            reset = 0x0;
        } hsp_hf0_coring[7:0];
    } INTF_HSPCFG1 @ 0xD044;
    reg {
        name = "INTF_HSPCFG5";
        desc = "INTF_HSPCFG5 is HSP configuration register 5 (instant register). (offset 0xD054; total reset 0x00000000; PROVEN: Hi3536D V100 data sheet (Issue 00B04, 2017-12-13), section 1.37, PDF page 579).";
        field {
            name = "reserved";
            desc = "Reserved";
            sw = r; hw = w;
            reset = 0x0;
        } reserved_31_27[31:27];
        field {
            name = "hsp_hf0_gainneg";
            desc = "Negative polarity coefficient of the high-frequency gain, s (3, 8) data format: signed number, 1-bit sign part, 2-bit integer part, 8-bit decimal part. The coefficient is represented by a complement.";
            sw = rw; hw = r;
            reset = 0x0;
        } hsp_hf0_gainneg[26:16];
        field {
            name = "reserved";
            desc = "Reserved";
            sw = rw; hw = r;
            reset = 0x0;
        } reserved_15_11[15:11];
        field {
            name = "hsp_hf0_gainpos";
            desc = "Positive polarity coefficient of the high-frequency gain, s (3, 8) data format: signed number, 1-bit sign part, 2-bit integer part, 8-bit decimal part. The coefficient is represented by a complement.";
            sw = rw; hw = r;
            reset = 0x0;
        } hsp_hf0_gainpos[10:0];
    } INTF_HSPCFG5 @ 0xD054;
    reg {
        name = "INTF_HSPCFG6";
        desc = "INTF_HSPCFG6 is HSP configuration register 6 (instant register). (offset 0xD058; total reset 0x00000000; PROVEN: Hi3536D V100 data sheet (Issue 00B04, 2017-12-13), section 1.37, PDF page 580).";
        field {
            name = "hsp_hf0_adpshoot_en";
            desc = "High-frequency adjustment threshold enable";
            sw = rw; hw = r;
            reset = 0x0;
        } hsp_hf0_adpshoot_en[31:31];
        field {
            name = "hsp_hf0_winsize";
            desc = "High-frequency window size, unsigned number. The value range is 0-4.";
            sw = rw; hw = r;
            reset = 0x0;
        } hsp_hf0_winsize[30:28];
        field {
            name = "reserved";
            desc = "Reserved";
            sw = rw; hw = r;
            reset = 0x0;
        } reserved_27_24[27:24];
        field {
            name = "hsp_hf0_mixratio";
            desc = "High-frequency adjustment threshold ratio, u (1, 7) data format: unsigned number, 1-bit integer part, 7-bit decimal part. The coefficient is represented by a complement.";
            sw = rw; hw = r;
            reset = 0x0;
        } hsp_hf0_mixratio[23:16];
        field {
            name = "hsp_hf0_underth";
            desc = "Under threshold for high-frequency adjustment, unsigned number";
            sw = rw; hw = r;
            reset = 0x0;
        } hsp_hf0_underth[15:8];
        field {
            name = "hsp_hf0_overth";
            desc = "Over threshold for high-frequency adjustment, unsigned number";
            sw = rw; hw = r;
            reset = 0x0;
        } hsp_hf0_overth[7:0];
    } INTF_HSPCFG6 @ 0xD058;
    reg {
        name = "INTF_HSPCFG7";
        desc = "INTF_HSPCFG7 is HSP configuration register 7 (instant register). (offset 0xD05C; total reset 0x00000000; PROVEN: Hi3536D V100 data sheet (Issue 00B04, 2017-12-13), section 1.37, PDF page 580).";
        field {
            name = "hsp_hf1_tmp3";
            desc = "High-frequency filtering coefficient 3, signed number";
            sw = rw; hw = r;
            reset = 0x0;
        } hsp_hf1_tmp3[31:24];
        field {
            name = "hsp_hf1_tmp2";
            desc = "High-frequency filtering coefficient 2, signed number";
            sw = rw; hw = r;
            reset = 0x0;
        } hsp_hf1_tmp2[23:16];
        field {
            name = "hsp_hf1_tmp1";
            desc = "High-frequency filtering coefficient 1, signed number";
            sw = rw; hw = r;
            reset = 0x0;
        } hsp_hf1_tmp1[15:8];
        field {
            name = "hsp_hf1_tmp0";
            desc = "High-frequency filtering coefficient 0, signed number";
            sw = rw; hw = r;
            reset = 0x0;
        } hsp_hf1_tmp0[7:0];
    } INTF_HSPCFG7 @ 0xD05C;
    reg {
        name = "INTF_HSPCFG8";
        desc = "INTF_HSPCFG8 is HSP configuration register 8 (instant register). (offset 0xD060; total reset 0x00000000; PROVEN: Hi3536D V100 data sheet (Issue 00B04, 2017-12-13), section 1.37, PDF page 581).";
        field {
            name = "reserved";
            desc = "Reserved";
            sw = r; hw = w;
            reset = 0x0;
        } reserved_31_8[31:8];
        field {
            name = "hsp_hf1_coring";
            desc = "High-frequency coring coefficient, unsigned number";
            sw = rw; hw = r;
            reset = 0x0;
        } hsp_hf1_coring[7:0];
    } INTF_HSPCFG8 @ 0xD060;
    reg {
        name = "INTF_HSPCFG12";
        desc = "INTF_HSPCFG12 is HSP configuration register 12 (instant register). (offset 0xD070; total reset 0x00000000; PROVEN: Hi3536D V100 data sheet (Issue 00B04, 2017-12-13), section 1.37, PDF page 581).";
        field {
            name = "reserved";
            desc = "Reserved";
            sw = r; hw = w;
            reset = 0x0;
        } reserved_31_27[31:27];
        field {
            name = "hsp_hf1_gainneg";
            desc = "Negative polarity coefficient of the high-frequency gain, s (3, 8) data format: signed number, 1-bit sign part, 2-bit integer part, 8-bit decimal part. The coefficient is represented by a complement.";
            sw = rw; hw = r;
            reset = 0x0;
        } hsp_hf1_gainneg[26:16];
        field {
            name = "reserved";
            desc = "Reserved";
            sw = rw; hw = r;
            reset = 0x0;
        } reserved_15_11[15:11];
        field {
            name = "hsp_hf1_gainpos";
            desc = "Positive polarity coefficient of the high-frequency gain, s (3, 8) data format: signed number, 1-bit sign part, 2-bit integer part, 8-bit decimal part. The coefficient is represented by a complement.";
            sw = rw; hw = r;
            reset = 0x0;
        } hsp_hf1_gainpos[10:0];
    } INTF_HSPCFG12 @ 0xD070;
    reg {
        name = "INTF_HSPCFG13";
        desc = "INTF_HSPCFG13 is HSP configuration register 13 (instant register). (offset 0xD074; total reset 0x00000000; PROVEN: Hi3536D V100 data sheet (Issue 00B04, 2017-12-13), section 1.37, PDF page 582).";
        field {
            name = "hsp_hf1_adpshoot_en";
            desc = "High-frequency adjustment threshold enable";
            sw = rw; hw = r;
            reset = 0x0;
        } hsp_hf1_adpshoot_en[31:31];
        field {
            name = "hsp_hf1_winsize";
            desc = "High-frequency window size, unsigned number. The value range is 0-4.";
            sw = rw; hw = r;
            reset = 0x0;
        } hsp_hf1_winsize[30:28];
        field {
            name = "reserved";
            desc = "Reserved";
            sw = rw; hw = r;
            reset = 0x0;
        } reserved_27_24[27:24];
        field {
            name = "hsp_hf1_mixratio";
            desc = "High-frequency adjustment threshold ratio, u (1, 7) data format: unsigned number, 1-bit integer part, 7-bit decimal part. The coefficient is represented by a complement.";
            sw = rw; hw = r;
            reset = 0x0;
        } hsp_hf1_mixratio[23:16];
        field {
            name = "hsp_hf1_underth";
            desc = "Under threshold for high-frequency adjustment, unsigned number";
            sw = rw; hw = r;
            reset = 0x0;
        } hsp_hf1_underth[15:8];
        field {
            name = "hsp_hf1_overth";
            desc = "Over threshold for high-frequency adjustment, unsigned number";
            sw = rw; hw = r;
            reset = 0x0;
        } hsp_hf1_overth[7:0];
    } INTF_HSPCFG13 @ 0xD074;
    reg {
        name = "INTF_HSPCFG14";
        desc = "INTF_HSPCFG14 is HSP configuration register 14 (instant register). (offset 0xD078; total reset 0x00000000; PROVEN: Hi3536D V100 data sheet (Issue 00B04, 2017-12-13), section 1.37, PDF page 583).";
        field {
            name = "hsp_h0_en";
            desc = "High-frequency filtering 0 enable";
            sw = rw; hw = r;
            reset = 0x0;
        } hsp_h0_en[31:31];
        field {
            name = "hsp_h1_en";
            desc = "High-frequency filtering 1 enable";
            sw = rw; hw = r;
            reset = 0x0;
        } hsp_h1_en[30:30];
        field {
            name = "hsp_ltih_en";
            desc = "Horizontal LTI enable";
            sw = rw; hw = r;
            reset = 0x0;
        } hsp_ltih_en[29:29];
        field {
            name = "hsp_ctih_en";
            desc = "Horizontal CTI enable";
            sw = rw; hw = r;
            reset = 0x0;
        } hsp_ctih_en[28:28];
        field {
            name = "reserved";
            desc = "Reserved";
            sw = rw; hw = r;
            reset = 0x0;
        } reserved_27_27[27:27];
        field {
            name = "hsp_hf_shootdiv";
            desc = "High-frequency adjustment shift coefficient, unsigned number. The value range is 1-7.";
            sw = rw; hw = r;
            reset = 0x0;
        } hsp_hf_shootdiv[26:24];
        field {
            name = "hsp_lti_ratio";
            desc = "Luminance enhancement ratio, u (1, 7) data format: unsigned number, 1-bit integer part, 7-bit decimal part. The coefficient is represented by a complement.";
            sw = rw; hw = r;
            reset = 0x0;
        } hsp_lti_ratio[23:16];
        field {
            name = "hsp_ldti_gain";
            desc = "Luminance enhancement gain coefficient, u (1, 7) data format: unsigned number, 1-bit integer part, 7-bit decimal part. The coefficient is represented by a complement.";
            sw = rw; hw = r;
            reset = 0x0;
        } hsp_ldti_gain[15:8];
        field {
            name = "hsp_cdti_gain";
            desc = "Chrominance enhancement gain coefficient, u (1, 7) data format: unsigned number, 1-bit integer part, 7-bit decimal part. The coefficient is represented by a complement.";
            sw = rw; hw = r;
            reset = 0x0;
        } hsp_cdti_gain[7:0];
    } INTF_HSPCFG14 @ 0xD078;
    reg {
        name = "INTF_HSPCFG15";
        desc = "INTF_HSPCFG15 is HSP configuration register 15 (instant register). (offset 0xD07C; total reset 0x00000000; PROVEN: Hi3536D V100 data sheet (Issue 00B04, 2017-12-13), section 1.37, PDF page 584).";
        field {
            name = "reserved";
            desc = "Reserved";
            sw = r; hw = w;
            reset = 0x0;
        } reserved_31_28[31:28];
        field {
            name = "hsp_peak_ratio";
            desc = "Luminance enhancement ratio, u (1, 7) data format: unsigned number, 1-bit integer part, 7-bit decimal part. The coefficient is represented by a complement.";
            sw = rw; hw = r;
            reset = 0x0;
        } hsp_peak_ratio[27:20];
        field {
            name = "reserved";
            desc = "Reserved";
            sw = rw; hw = r;
            reset = 0x0;
        } reserved_19_19[19:19];
        field {
            name = "hsp_glb_overth";
            desc = "Global high threshold for luminance enhancement, unsigned number";
            sw = rw; hw = r;
            reset = 0x0;
        } hsp_glb_overth[18:10];
        field {
            name = "reserved";
            desc = "Reserved";
            sw = rw; hw = r;
            reset = 0x0;
        } reserved_9_9[9:9];
        field {
            name = "hsp_glb_underth";
            desc = "Global low threshold for luminance enhancement, unsigned number Contents";
            sw = rw; hw = r;
            reset = 0x0;
        } hsp_glb_underth[8:0];
    } INTF_HSPCFG15 @ 0xD07C;
    reg {
        name = "INTF_VGA_CTRL";
        desc = "VGA interface (HAL interface id 4, Vou_GetIntfAbsAddr adds 0x100): copy of INTF_CTRL at +0x100 (offset 0xD100). Provenance: PROVEN offsets (hi3536dv100_vou.ko Vou_GetIntfAbsAddr adds the per-interface base and the HAL_DISP_SetIntf* functions pass the same in-block offsets for every interface); INFERRED that the layout is identical; the data sheet documents only the HDMI interface block at 0xD000.";
        field { sw = rw; hw = r; reset = 0x0; } value[31:0];
    } INTF_VGA_CTRL @ 0xD100;
    reg {
        name = "INTF_CVBS_CTRL";
        desc = "CVBS interface (HAL interface id 1, adds 0x300; the Hi3536D has no CVBS output, GUESS the copy is unused): copy of INTF_CTRL at +0x300 (offset 0xD300). Provenance: PROVEN offsets (hi3536dv100_vou.ko Vou_GetIntfAbsAddr adds the per-interface base and the HAL_DISP_SetIntf* functions pass the same in-block offsets for every interface); INFERRED that the layout is identical; the data sheet documents only the HDMI interface block at 0xD000.";
        field { sw = rw; hw = r; reset = 0x0; } value[31:0];
    } INTF_CVBS_CTRL @ 0xD300;
    reg {
        name = "INTF_VGA_SYNC_INV";
        desc = "VGA interface (HAL interface id 4, Vou_GetIntfAbsAddr adds 0x100): copy of INTF_SYNC_INV at +0x100 (offset 0xD108). Provenance: PROVEN offsets (hi3536dv100_vou.ko Vou_GetIntfAbsAddr adds the per-interface base and the HAL_DISP_SetIntf* functions pass the same in-block offsets for every interface); INFERRED that the layout is identical; the data sheet documents only the HDMI interface block at 0xD000.";
        field { sw = rw; hw = r; reset = 0x0; } value[31:0];
    } INTF_VGA_SYNC_INV @ 0xD108;
    reg {
        name = "INTF_CVBS_SYNC_INV";
        desc = "CVBS interface (HAL interface id 1, adds 0x300; the Hi3536D has no CVBS output, GUESS the copy is unused): copy of INTF_SYNC_INV at +0x300 (offset 0xD308). Provenance: PROVEN offsets (hi3536dv100_vou.ko Vou_GetIntfAbsAddr adds the per-interface base and the HAL_DISP_SetIntf* functions pass the same in-block offsets for every interface); INFERRED that the layout is identical; the data sheet documents only the HDMI interface block at 0xD000.";
        field { sw = rw; hw = r; reset = 0x0; } value[31:0];
    } INTF_CVBS_SYNC_INV @ 0xD308;
    reg {
        name = "INTF_VGA_CLIP0_L";
        desc = "VGA interface (HAL interface id 4, Vou_GetIntfAbsAddr adds 0x100): copy of INTF_CLIP0_L at +0x100 (offset 0xD110). Provenance: PROVEN offsets (hi3536dv100_vou.ko Vou_GetIntfAbsAddr adds the per-interface base and the HAL_DISP_SetIntf* functions pass the same in-block offsets for every interface); INFERRED that the layout is identical; the data sheet documents only the HDMI interface block at 0xD000.";
        field { sw = rw; hw = r; reset = 0x1004010; } value[31:0];
    } INTF_VGA_CLIP0_L @ 0xD110;
    reg {
        name = "INTF_CVBS_CLIP0_L";
        desc = "CVBS interface (HAL interface id 1, adds 0x300; the Hi3536D has no CVBS output, GUESS the copy is unused): copy of INTF_CLIP0_L at +0x300 (offset 0xD310). Provenance: PROVEN offsets (hi3536dv100_vou.ko Vou_GetIntfAbsAddr adds the per-interface base and the HAL_DISP_SetIntf* functions pass the same in-block offsets for every interface); INFERRED that the layout is identical; the data sheet documents only the HDMI interface block at 0xD000.";
        field { sw = rw; hw = r; reset = 0x1004010; } value[31:0];
    } INTF_CVBS_CLIP0_L @ 0xD310;
    reg {
        name = "INTF_VGA_CLIP0_H";
        desc = "VGA interface (HAL interface id 4, Vou_GetIntfAbsAddr adds 0x100): copy of INTF_CLIP0_H at +0x100 (offset 0xD114). Provenance: PROVEN offsets (hi3536dv100_vou.ko Vou_GetIntfAbsAddr adds the per-interface base and the HAL_DISP_SetIntf* functions pass the same in-block offsets for every interface); INFERRED that the layout is identical; the data sheet documents only the HDMI interface block at 0xD000.";
        field { sw = rw; hw = r; reset = 0x3fffffff; } value[31:0];
    } INTF_VGA_CLIP0_H @ 0xD114;
    reg {
        name = "INTF_CVBS_CLIP0_H";
        desc = "CVBS interface (HAL interface id 1, adds 0x300; the Hi3536D has no CVBS output, GUESS the copy is unused): copy of INTF_CLIP0_H at +0x300 (offset 0xD314). Provenance: PROVEN offsets (hi3536dv100_vou.ko Vou_GetIntfAbsAddr adds the per-interface base and the HAL_DISP_SetIntf* functions pass the same in-block offsets for every interface); INFERRED that the layout is identical; the data sheet documents only the HDMI interface block at 0xD000.";
        field { sw = rw; hw = r; reset = 0x3fffffff; } value[31:0];
    } INTF_CVBS_CLIP0_H @ 0xD314;
    reg {
        name = "INTF_VGA_CSC_IDC";
        desc = "VGA interface (HAL interface id 4, Vou_GetIntfAbsAddr adds 0x100): copy of INTF_CSC_IDC at +0x100 (offset 0xD120). Provenance: PROVEN offsets (hi3536dv100_vou.ko Vou_GetIntfAbsAddr adds the per-interface base and the HAL_DISP_SetIntf* functions pass the same in-block offsets for every interface); INFERRED that the layout is identical; the data sheet documents only the HDMI interface block at 0xD000.";
        field { sw = rw; hw = r; reset = 0x0; } value[31:0];
    } INTF_VGA_CSC_IDC @ 0xD120;
    reg {
        name = "INTF_CVBS_CSC_IDC";
        desc = "CVBS interface (HAL interface id 1, adds 0x300; the Hi3536D has no CVBS output, GUESS the copy is unused): copy of INTF_CSC_IDC at +0x300 (offset 0xD320). Provenance: PROVEN offsets (hi3536dv100_vou.ko Vou_GetIntfAbsAddr adds the per-interface base and the HAL_DISP_SetIntf* functions pass the same in-block offsets for every interface); INFERRED that the layout is identical; the data sheet documents only the HDMI interface block at 0xD000.";
        field { sw = rw; hw = r; reset = 0x0; } value[31:0];
    } INTF_CVBS_CSC_IDC @ 0xD320;
    reg {
        name = "INTF_VGA_CSC_ODC";
        desc = "VGA interface (HAL interface id 4, Vou_GetIntfAbsAddr adds 0x100): copy of INTF_CSC_ODC at +0x100 (offset 0xD124). Provenance: PROVEN offsets (hi3536dv100_vou.ko Vou_GetIntfAbsAddr adds the per-interface base and the HAL_DISP_SetIntf* functions pass the same in-block offsets for every interface); INFERRED that the layout is identical; the data sheet documents only the HDMI interface block at 0xD000.";
        field { sw = rw; hw = r; reset = 0x0; } value[31:0];
    } INTF_VGA_CSC_ODC @ 0xD124;
    reg {
        name = "INTF_CVBS_CSC_ODC";
        desc = "CVBS interface (HAL interface id 1, adds 0x300; the Hi3536D has no CVBS output, GUESS the copy is unused): copy of INTF_CSC_ODC at +0x300 (offset 0xD324). Provenance: PROVEN offsets (hi3536dv100_vou.ko Vou_GetIntfAbsAddr adds the per-interface base and the HAL_DISP_SetIntf* functions pass the same in-block offsets for every interface); INFERRED that the layout is identical; the data sheet documents only the HDMI interface block at 0xD000.";
        field { sw = rw; hw = r; reset = 0x0; } value[31:0];
    } INTF_CVBS_CSC_ODC @ 0xD324;
    reg {
        name = "INTF_VGA_CSC_IODC";
        desc = "VGA interface (HAL interface id 4, Vou_GetIntfAbsAddr adds 0x100): copy of INTF_CSC_IODC at +0x100 (offset 0xD128). Provenance: PROVEN offsets (hi3536dv100_vou.ko Vou_GetIntfAbsAddr adds the per-interface base and the HAL_DISP_SetIntf* functions pass the same in-block offsets for every interface); INFERRED that the layout is identical; the data sheet documents only the HDMI interface block at 0xD000.";
        field { sw = rw; hw = r; reset = 0x0; } value[31:0];
    } INTF_VGA_CSC_IODC @ 0xD128;
    reg {
        name = "INTF_CVBS_CSC_IODC";
        desc = "CVBS interface (HAL interface id 1, adds 0x300; the Hi3536D has no CVBS output, GUESS the copy is unused): copy of INTF_CSC_IODC at +0x300 (offset 0xD328). Provenance: PROVEN offsets (hi3536dv100_vou.ko Vou_GetIntfAbsAddr adds the per-interface base and the HAL_DISP_SetIntf* functions pass the same in-block offsets for every interface); INFERRED that the layout is identical; the data sheet documents only the HDMI interface block at 0xD000.";
        field { sw = rw; hw = r; reset = 0x0; } value[31:0];
    } INTF_CVBS_CSC_IODC @ 0xD328;
    reg {
        name = "INTF_VGA_CSC_P0";
        desc = "VGA interface (HAL interface id 4, Vou_GetIntfAbsAddr adds 0x100): copy of INTF_CSC_P0 at +0x100 (offset 0xD12C). Provenance: PROVEN offsets (hi3536dv100_vou.ko Vou_GetIntfAbsAddr adds the per-interface base and the HAL_DISP_SetIntf* functions pass the same in-block offsets for every interface); INFERRED that the layout is identical; the data sheet documents only the HDMI interface block at 0xD000.";
        field { sw = rw; hw = r; reset = 0x0; } value[31:0];
    } INTF_VGA_CSC_P0 @ 0xD12C;
    reg {
        name = "INTF_CVBS_CSC_P0";
        desc = "CVBS interface (HAL interface id 1, adds 0x300; the Hi3536D has no CVBS output, GUESS the copy is unused): copy of INTF_CSC_P0 at +0x300 (offset 0xD32C). Provenance: PROVEN offsets (hi3536dv100_vou.ko Vou_GetIntfAbsAddr adds the per-interface base and the HAL_DISP_SetIntf* functions pass the same in-block offsets for every interface); INFERRED that the layout is identical; the data sheet documents only the HDMI interface block at 0xD000.";
        field { sw = rw; hw = r; reset = 0x0; } value[31:0];
    } INTF_CVBS_CSC_P0 @ 0xD32C;
    reg {
        name = "INTF_VGA_CSC_P1";
        desc = "VGA interface (HAL interface id 4, Vou_GetIntfAbsAddr adds 0x100): copy of INTF_CSC_P1 at +0x100 (offset 0xD130). Provenance: PROVEN offsets (hi3536dv100_vou.ko Vou_GetIntfAbsAddr adds the per-interface base and the HAL_DISP_SetIntf* functions pass the same in-block offsets for every interface); INFERRED that the layout is identical; the data sheet documents only the HDMI interface block at 0xD000.";
        field { sw = rw; hw = r; reset = 0x0; } value[31:0];
    } INTF_VGA_CSC_P1 @ 0xD130;
    reg {
        name = "INTF_CVBS_CSC_P1";
        desc = "CVBS interface (HAL interface id 1, adds 0x300; the Hi3536D has no CVBS output, GUESS the copy is unused): copy of INTF_CSC_P1 at +0x300 (offset 0xD330). Provenance: PROVEN offsets (hi3536dv100_vou.ko Vou_GetIntfAbsAddr adds the per-interface base and the HAL_DISP_SetIntf* functions pass the same in-block offsets for every interface); INFERRED that the layout is identical; the data sheet documents only the HDMI interface block at 0xD000.";
        field { sw = rw; hw = r; reset = 0x0; } value[31:0];
    } INTF_CVBS_CSC_P1 @ 0xD330;
    reg {
        name = "INTF_VGA_CSC_P2";
        desc = "VGA interface (HAL interface id 4, Vou_GetIntfAbsAddr adds 0x100): copy of INTF_CSC_P2 at +0x100 (offset 0xD134). Provenance: PROVEN offsets (hi3536dv100_vou.ko Vou_GetIntfAbsAddr adds the per-interface base and the HAL_DISP_SetIntf* functions pass the same in-block offsets for every interface); INFERRED that the layout is identical; the data sheet documents only the HDMI interface block at 0xD000.";
        field { sw = rw; hw = r; reset = 0x0; } value[31:0];
    } INTF_VGA_CSC_P2 @ 0xD134;
    reg {
        name = "INTF_CVBS_CSC_P2";
        desc = "CVBS interface (HAL interface id 1, adds 0x300; the Hi3536D has no CVBS output, GUESS the copy is unused): copy of INTF_CSC_P2 at +0x300 (offset 0xD334). Provenance: PROVEN offsets (hi3536dv100_vou.ko Vou_GetIntfAbsAddr adds the per-interface base and the HAL_DISP_SetIntf* functions pass the same in-block offsets for every interface); INFERRED that the layout is identical; the data sheet documents only the HDMI interface block at 0xD000.";
        field { sw = rw; hw = r; reset = 0x0; } value[31:0];
    } INTF_CVBS_CSC_P2 @ 0xD334;
    reg {
        name = "INTF_VGA_CSC_P3";
        desc = "VGA interface (HAL interface id 4, Vou_GetIntfAbsAddr adds 0x100): copy of INTF_CSC_P3 at +0x100 (offset 0xD138). Provenance: PROVEN offsets (hi3536dv100_vou.ko Vou_GetIntfAbsAddr adds the per-interface base and the HAL_DISP_SetIntf* functions pass the same in-block offsets for every interface); INFERRED that the layout is identical; the data sheet documents only the HDMI interface block at 0xD000.";
        field { sw = rw; hw = r; reset = 0x0; } value[31:0];
    } INTF_VGA_CSC_P3 @ 0xD138;
    reg {
        name = "INTF_CVBS_CSC_P3";
        desc = "CVBS interface (HAL interface id 1, adds 0x300; the Hi3536D has no CVBS output, GUESS the copy is unused): copy of INTF_CSC_P3 at +0x300 (offset 0xD338). Provenance: PROVEN offsets (hi3536dv100_vou.ko Vou_GetIntfAbsAddr adds the per-interface base and the HAL_DISP_SetIntf* functions pass the same in-block offsets for every interface); INFERRED that the layout is identical; the data sheet documents only the HDMI interface block at 0xD000.";
        field { sw = rw; hw = r; reset = 0x0; } value[31:0];
    } INTF_CVBS_CSC_P3 @ 0xD338;
    reg {
        name = "INTF_VGA_CSC_P4";
        desc = "VGA interface (HAL interface id 4, Vou_GetIntfAbsAddr adds 0x100): copy of INTF_CSC_P4 at +0x100 (offset 0xD13C). Provenance: PROVEN offsets (hi3536dv100_vou.ko Vou_GetIntfAbsAddr adds the per-interface base and the HAL_DISP_SetIntf* functions pass the same in-block offsets for every interface); INFERRED that the layout is identical; the data sheet documents only the HDMI interface block at 0xD000.";
        field { sw = rw; hw = r; reset = 0x0; } value[31:0];
    } INTF_VGA_CSC_P4 @ 0xD13C;
    reg {
        name = "INTF_CVBS_CSC_P4";
        desc = "CVBS interface (HAL interface id 1, adds 0x300; the Hi3536D has no CVBS output, GUESS the copy is unused): copy of INTF_CSC_P4 at +0x300 (offset 0xD33C). Provenance: PROVEN offsets (hi3536dv100_vou.ko Vou_GetIntfAbsAddr adds the per-interface base and the HAL_DISP_SetIntf* functions pass the same in-block offsets for every interface); INFERRED that the layout is identical; the data sheet documents only the HDMI interface block at 0xD000.";
        field { sw = rw; hw = r; reset = 0x0; } value[31:0];
    } INTF_CVBS_CSC_P4 @ 0xD33C;
    reg {
        name = "INTF_VGA_HSPCFG0";
        desc = "VGA interface (HAL interface id 4, Vou_GetIntfAbsAddr adds 0x100): copy of INTF_HSPCFG0 at +0x100 (offset 0xD140). Provenance: PROVEN offsets (hi3536dv100_vou.ko Vou_GetIntfAbsAddr adds the per-interface base and the HAL_DISP_SetIntf* functions pass the same in-block offsets for every interface); INFERRED that the layout is identical; the data sheet documents only the HDMI interface block at 0xD000.";
        field { sw = rw; hw = r; reset = 0x0; } value[31:0];
    } INTF_VGA_HSPCFG0 @ 0xD140;
    reg {
        name = "INTF_CVBS_HSPCFG0";
        desc = "CVBS interface (HAL interface id 1, adds 0x300; the Hi3536D has no CVBS output, GUESS the copy is unused): copy of INTF_HSPCFG0 at +0x300 (offset 0xD340). Provenance: PROVEN offsets (hi3536dv100_vou.ko Vou_GetIntfAbsAddr adds the per-interface base and the HAL_DISP_SetIntf* functions pass the same in-block offsets for every interface); INFERRED that the layout is identical; the data sheet documents only the HDMI interface block at 0xD000.";
        field { sw = rw; hw = r; reset = 0x0; } value[31:0];
    } INTF_CVBS_HSPCFG0 @ 0xD340;
    reg {
        name = "INTF_VGA_HSPCFG1";
        desc = "VGA interface (HAL interface id 4, Vou_GetIntfAbsAddr adds 0x100): copy of INTF_HSPCFG1 at +0x100 (offset 0xD144). Provenance: PROVEN offsets (hi3536dv100_vou.ko Vou_GetIntfAbsAddr adds the per-interface base and the HAL_DISP_SetIntf* functions pass the same in-block offsets for every interface); INFERRED that the layout is identical; the data sheet documents only the HDMI interface block at 0xD000.";
        field { sw = rw; hw = r; reset = 0x0; } value[31:0];
    } INTF_VGA_HSPCFG1 @ 0xD144;
    reg {
        name = "INTF_CVBS_HSPCFG1";
        desc = "CVBS interface (HAL interface id 1, adds 0x300; the Hi3536D has no CVBS output, GUESS the copy is unused): copy of INTF_HSPCFG1 at +0x300 (offset 0xD344). Provenance: PROVEN offsets (hi3536dv100_vou.ko Vou_GetIntfAbsAddr adds the per-interface base and the HAL_DISP_SetIntf* functions pass the same in-block offsets for every interface); INFERRED that the layout is identical; the data sheet documents only the HDMI interface block at 0xD000.";
        field { sw = rw; hw = r; reset = 0x0; } value[31:0];
    } INTF_CVBS_HSPCFG1 @ 0xD344;
    reg {
        name = "INTF_VGA_HSPCFG5";
        desc = "VGA interface (HAL interface id 4, Vou_GetIntfAbsAddr adds 0x100): copy of INTF_HSPCFG5 at +0x100 (offset 0xD154). Provenance: PROVEN offsets (hi3536dv100_vou.ko Vou_GetIntfAbsAddr adds the per-interface base and the HAL_DISP_SetIntf* functions pass the same in-block offsets for every interface); INFERRED that the layout is identical; the data sheet documents only the HDMI interface block at 0xD000.";
        field { sw = rw; hw = r; reset = 0x0; } value[31:0];
    } INTF_VGA_HSPCFG5 @ 0xD154;
    reg {
        name = "INTF_CVBS_HSPCFG5";
        desc = "CVBS interface (HAL interface id 1, adds 0x300; the Hi3536D has no CVBS output, GUESS the copy is unused): copy of INTF_HSPCFG5 at +0x300 (offset 0xD354). Provenance: PROVEN offsets (hi3536dv100_vou.ko Vou_GetIntfAbsAddr adds the per-interface base and the HAL_DISP_SetIntf* functions pass the same in-block offsets for every interface); INFERRED that the layout is identical; the data sheet documents only the HDMI interface block at 0xD000.";
        field { sw = rw; hw = r; reset = 0x0; } value[31:0];
    } INTF_CVBS_HSPCFG5 @ 0xD354;
    reg {
        name = "INTF_VGA_HSPCFG6";
        desc = "VGA interface (HAL interface id 4, Vou_GetIntfAbsAddr adds 0x100): copy of INTF_HSPCFG6 at +0x100 (offset 0xD158). Provenance: PROVEN offsets (hi3536dv100_vou.ko Vou_GetIntfAbsAddr adds the per-interface base and the HAL_DISP_SetIntf* functions pass the same in-block offsets for every interface); INFERRED that the layout is identical; the data sheet documents only the HDMI interface block at 0xD000.";
        field { sw = rw; hw = r; reset = 0x0; } value[31:0];
    } INTF_VGA_HSPCFG6 @ 0xD158;
    reg {
        name = "INTF_CVBS_HSPCFG6";
        desc = "CVBS interface (HAL interface id 1, adds 0x300; the Hi3536D has no CVBS output, GUESS the copy is unused): copy of INTF_HSPCFG6 at +0x300 (offset 0xD358). Provenance: PROVEN offsets (hi3536dv100_vou.ko Vou_GetIntfAbsAddr adds the per-interface base and the HAL_DISP_SetIntf* functions pass the same in-block offsets for every interface); INFERRED that the layout is identical; the data sheet documents only the HDMI interface block at 0xD000.";
        field { sw = rw; hw = r; reset = 0x0; } value[31:0];
    } INTF_CVBS_HSPCFG6 @ 0xD358;
    reg {
        name = "INTF_VGA_HSPCFG7";
        desc = "VGA interface (HAL interface id 4, Vou_GetIntfAbsAddr adds 0x100): copy of INTF_HSPCFG7 at +0x100 (offset 0xD15C). Provenance: PROVEN offsets (hi3536dv100_vou.ko Vou_GetIntfAbsAddr adds the per-interface base and the HAL_DISP_SetIntf* functions pass the same in-block offsets for every interface); INFERRED that the layout is identical; the data sheet documents only the HDMI interface block at 0xD000.";
        field { sw = rw; hw = r; reset = 0x0; } value[31:0];
    } INTF_VGA_HSPCFG7 @ 0xD15C;
    reg {
        name = "INTF_CVBS_HSPCFG7";
        desc = "CVBS interface (HAL interface id 1, adds 0x300; the Hi3536D has no CVBS output, GUESS the copy is unused): copy of INTF_HSPCFG7 at +0x300 (offset 0xD35C). Provenance: PROVEN offsets (hi3536dv100_vou.ko Vou_GetIntfAbsAddr adds the per-interface base and the HAL_DISP_SetIntf* functions pass the same in-block offsets for every interface); INFERRED that the layout is identical; the data sheet documents only the HDMI interface block at 0xD000.";
        field { sw = rw; hw = r; reset = 0x0; } value[31:0];
    } INTF_CVBS_HSPCFG7 @ 0xD35C;
    reg {
        name = "INTF_VGA_HSPCFG8";
        desc = "VGA interface (HAL interface id 4, Vou_GetIntfAbsAddr adds 0x100): copy of INTF_HSPCFG8 at +0x100 (offset 0xD160). Provenance: PROVEN offsets (hi3536dv100_vou.ko Vou_GetIntfAbsAddr adds the per-interface base and the HAL_DISP_SetIntf* functions pass the same in-block offsets for every interface); INFERRED that the layout is identical; the data sheet documents only the HDMI interface block at 0xD000.";
        field { sw = rw; hw = r; reset = 0x0; } value[31:0];
    } INTF_VGA_HSPCFG8 @ 0xD160;
    reg {
        name = "INTF_CVBS_HSPCFG8";
        desc = "CVBS interface (HAL interface id 1, adds 0x300; the Hi3536D has no CVBS output, GUESS the copy is unused): copy of INTF_HSPCFG8 at +0x300 (offset 0xD360). Provenance: PROVEN offsets (hi3536dv100_vou.ko Vou_GetIntfAbsAddr adds the per-interface base and the HAL_DISP_SetIntf* functions pass the same in-block offsets for every interface); INFERRED that the layout is identical; the data sheet documents only the HDMI interface block at 0xD000.";
        field { sw = rw; hw = r; reset = 0x0; } value[31:0];
    } INTF_CVBS_HSPCFG8 @ 0xD360;
    reg {
        name = "INTF_VGA_HSPCFG12";
        desc = "VGA interface (HAL interface id 4, Vou_GetIntfAbsAddr adds 0x100): copy of INTF_HSPCFG12 at +0x100 (offset 0xD170). Provenance: PROVEN offsets (hi3536dv100_vou.ko Vou_GetIntfAbsAddr adds the per-interface base and the HAL_DISP_SetIntf* functions pass the same in-block offsets for every interface); INFERRED that the layout is identical; the data sheet documents only the HDMI interface block at 0xD000.";
        field { sw = rw; hw = r; reset = 0x0; } value[31:0];
    } INTF_VGA_HSPCFG12 @ 0xD170;
    reg {
        name = "INTF_CVBS_HSPCFG12";
        desc = "CVBS interface (HAL interface id 1, adds 0x300; the Hi3536D has no CVBS output, GUESS the copy is unused): copy of INTF_HSPCFG12 at +0x300 (offset 0xD370). Provenance: PROVEN offsets (hi3536dv100_vou.ko Vou_GetIntfAbsAddr adds the per-interface base and the HAL_DISP_SetIntf* functions pass the same in-block offsets for every interface); INFERRED that the layout is identical; the data sheet documents only the HDMI interface block at 0xD000.";
        field { sw = rw; hw = r; reset = 0x0; } value[31:0];
    } INTF_CVBS_HSPCFG12 @ 0xD370;
    reg {
        name = "INTF_VGA_HSPCFG13";
        desc = "VGA interface (HAL interface id 4, Vou_GetIntfAbsAddr adds 0x100): copy of INTF_HSPCFG13 at +0x100 (offset 0xD174). Provenance: PROVEN offsets (hi3536dv100_vou.ko Vou_GetIntfAbsAddr adds the per-interface base and the HAL_DISP_SetIntf* functions pass the same in-block offsets for every interface); INFERRED that the layout is identical; the data sheet documents only the HDMI interface block at 0xD000.";
        field { sw = rw; hw = r; reset = 0x0; } value[31:0];
    } INTF_VGA_HSPCFG13 @ 0xD174;
    reg {
        name = "INTF_CVBS_HSPCFG13";
        desc = "CVBS interface (HAL interface id 1, adds 0x300; the Hi3536D has no CVBS output, GUESS the copy is unused): copy of INTF_HSPCFG13 at +0x300 (offset 0xD374). Provenance: PROVEN offsets (hi3536dv100_vou.ko Vou_GetIntfAbsAddr adds the per-interface base and the HAL_DISP_SetIntf* functions pass the same in-block offsets for every interface); INFERRED that the layout is identical; the data sheet documents only the HDMI interface block at 0xD000.";
        field { sw = rw; hw = r; reset = 0x0; } value[31:0];
    } INTF_CVBS_HSPCFG13 @ 0xD374;
    reg {
        name = "INTF_VGA_HSPCFG14";
        desc = "VGA interface (HAL interface id 4, Vou_GetIntfAbsAddr adds 0x100): copy of INTF_HSPCFG14 at +0x100 (offset 0xD178). Provenance: PROVEN offsets (hi3536dv100_vou.ko Vou_GetIntfAbsAddr adds the per-interface base and the HAL_DISP_SetIntf* functions pass the same in-block offsets for every interface); INFERRED that the layout is identical; the data sheet documents only the HDMI interface block at 0xD000.";
        field { sw = rw; hw = r; reset = 0x0; } value[31:0];
    } INTF_VGA_HSPCFG14 @ 0xD178;
    reg {
        name = "INTF_CVBS_HSPCFG14";
        desc = "CVBS interface (HAL interface id 1, adds 0x300; the Hi3536D has no CVBS output, GUESS the copy is unused): copy of INTF_HSPCFG14 at +0x300 (offset 0xD378). Provenance: PROVEN offsets (hi3536dv100_vou.ko Vou_GetIntfAbsAddr adds the per-interface base and the HAL_DISP_SetIntf* functions pass the same in-block offsets for every interface); INFERRED that the layout is identical; the data sheet documents only the HDMI interface block at 0xD000.";
        field { sw = rw; hw = r; reset = 0x0; } value[31:0];
    } INTF_CVBS_HSPCFG14 @ 0xD378;
    reg {
        name = "INTF_VGA_HSPCFG15";
        desc = "VGA interface (HAL interface id 4, Vou_GetIntfAbsAddr adds 0x100): copy of INTF_HSPCFG15 at +0x100 (offset 0xD17C). Provenance: PROVEN offsets (hi3536dv100_vou.ko Vou_GetIntfAbsAddr adds the per-interface base and the HAL_DISP_SetIntf* functions pass the same in-block offsets for every interface); INFERRED that the layout is identical; the data sheet documents only the HDMI interface block at 0xD000.";
        field { sw = rw; hw = r; reset = 0x0; } value[31:0];
    } INTF_VGA_HSPCFG15 @ 0xD17C;
    reg {
        name = "INTF_CVBS_HSPCFG15";
        desc = "CVBS interface (HAL interface id 1, adds 0x300; the Hi3536D has no CVBS output, GUESS the copy is unused): copy of INTF_HSPCFG15 at +0x300 (offset 0xD37C). Provenance: PROVEN offsets (hi3536dv100_vou.ko Vou_GetIntfAbsAddr adds the per-interface base and the HAL_DISP_SetIntf* functions pass the same in-block offsets for every interface); INFERRED that the layout is identical; the data sheet documents only the HDMI interface block at 0xD000.";
        field { sw = rw; hw = r; reset = 0x0; } value[31:0];
    } INTF_CVBS_HSPCFG15 @ 0xD37C;
    reg {
        name = "V3_HSP";
        desc = "V3_HSP: vendor-only (hi3536dv100_vou.ko HAL_LAYER_SetHorRatio/SetZmeEnable use in-layer offset 0x8C0 on layer 0 = 0x3000+0x8C0); name INFERRED from the neighbouring V3_VSP 0x38D8 and the function name (horizontal scaler parameter); bit layout unknown (offset 0x38C0). Provenance: PROVEN offset and written value (vendor Linux 4.9 demo device tree node sysctrl-ddr,pins, device-trees-hisilicon openipc-branches hi3536dv100-demb); bit layout NOT in the data sheet; name is the vendor DT comment / a GUESS.";
        field { sw = rw; hw = r; } value[31:0];
    } V3_HSP @ 0x38C0;
    reg {
        name = "V3_VDCMP_CLR";
        desc = "V3_VDCMP_CLR: vendor-only (HAL_VIDEO_ClrVDcmpLumaState/ChromaState, in-layer 0x1330 on layer 0); name INFERRED from the function names; bit layout unknown (offset 0x4330). Provenance: PROVEN offset and written value (vendor Linux 4.9 demo device tree node sysctrl-ddr,pins, device-trees-hisilicon openipc-branches hi3536dv100-demb); bit layout NOT in the data sheet; name is the vendor DT comment / a GUESS.";
        field { sw = rw; hw = r; } value[31:0];
    } V3_VDCMP_CLR @ 0x4330;
    reg {
        name = "V3_VDCMP_STATE";
        desc = "V3_VDCMP_STATE: vendor-only (HAL_VIDEO_GetVDcmpLumaState/ChromaState, in-layer 0x1334 on layer 0, next to V3_MRGERRCLR 0x4350); name INFERRED; bit layout unknown (offset 0x4334). Provenance: PROVEN offset and written value (vendor Linux 4.9 demo device tree node sysctrl-ddr,pins, device-trees-hisilicon openipc-branches hi3536dv100-demb); bit layout NOT in the data sheet; name is the vendor DT comment / a GUESS.";
        field { sw = rw; hw = r; } value[31:0];
    } V3_VDCMP_STATE @ 0x4334;
    reg {
        name = "G4_VFPOS";
        desc = "G4_VFPOS: vendor-only (HAL_VIDEO_SetLayerVideoRect, in-layer 0x6088 on layer 5 = 0x2000+0x6088, after G4_DLPOS 0x8084); name INFERRED from the function name and the V3_VFPOS/V3_VLPOS pair; bit layout unknown (offset 0x8088). Provenance: PROVEN offset and written value (vendor Linux 4.9 demo device tree node sysctrl-ddr,pins, device-trees-hisilicon openipc-branches hi3536dv100-demb); bit layout NOT in the data sheet; name is the vendor DT comment / a GUESS.";
        field { sw = rw; hw = r; } value[31:0];
    } G4_VFPOS @ 0x8088;
    reg {
        name = "G4_VLPOS";
        desc = "G4_VLPOS: vendor-only (HAL_VIDEO_SetLayerVideoRect, in-layer 0x608C on layer 5); name INFERRED as above; bit layout unknown (offset 0x808C). Provenance: PROVEN offset and written value (vendor Linux 4.9 demo device tree node sysctrl-ddr,pins, device-trees-hisilicon openipc-branches hi3536dv100-demb); bit layout NOT in the data sheet; name is the vendor DT comment / a GUESS.";
        field { sw = rw; hw = r; } value[31:0];
    } G4_VLPOS @ 0x808C;
    reg {
        name = "VENDOR_0030";
        desc = "Vendor-seen VOU register at 0x30 (hi3536dv100_vou.ko, arm-re path-sensitive scan 2026-11-12, base IO_13020000). Not in the data sheet table. Access RW by HAL_SYS_SetAxiMaster. Cleared bit extents: 0x890581a; field LSBs seen: none. Provenance: PROVEN offset and access direction; layer/channel replicas of documented registers are INFERRED from the identical function family; field meaning UNKNOWN. Unverified on hardware.";
        field {
            name = "word";
            desc = "32-bit word (layout UNKNOWN)";
            sw = rw; hw = r;
        } word[31:0];
    } VENDOR_0030 @ 0x30;
    reg {
        name = "VENDOR_0130";
        desc = "Vendor-seen VOU register at 0x130 (hi3536dv100_vou.ko, arm-re path-sensitive scan 2026-11-12, base IO_13020000). Not in the data sheet table. Access RW by HAL_DISP_SetIntfDacChnEnable. Cleared bit extents: 0x80000000; field LSBs seen: 31. Provenance: PROVEN offset and access direction; layer/channel replicas of documented registers are INFERRED from the identical function family; field meaning UNKNOWN. Unverified on hardware.";
        field {
            name = "word";
            desc = "32-bit word (layout UNKNOWN)";
            sw = rw; hw = r;
        } word[31:0];
    } VENDOR_0130 @ 0x130;
    reg {
        name = "VENDOR_0308";
        desc = "Vendor-seen VOU register at 0x308 (hi3536dv100_vou.ko, arm-re path-sensitive scan 2026-11-12, base IO_13020000). Not in the data sheet table. Access RW by HAL_CBM_ReleaseCbmAttr, HAL_CBM_SetCbmAttr. Cleared bit extents: 0xf0; field LSBs seen: none. Provenance: PROVEN offset and access direction; layer/channel replicas of documented registers are INFERRED from the identical function family; field meaning UNKNOWN. Unverified on hardware.";
        field {
            name = "word";
            desc = "32-bit word (layout UNKNOWN)";
            sw = rw; hw = r;
        } word[31:0];
    } VENDOR_0308 @ 0x308;
    reg {
        name = "VENDOR_0800";
        desc = "Vendor-seen VOU register at 0x800 (hi3536dv100_vou.ko, arm-re path-sensitive scan 2026-11-12, base IO_13020000). Not in the data sheet table. Access RW by HAL_LAYER_EnableLayer, HAL_LAYER_GetLayerDataFmt, HAL_LAYER_GetLayerEnable, HAL_LAYER_SetLayerDataFmt. Cleared bit extents: 0x20000, 0x80000000, 0xc0000; field LSBs seen: 0, 17, 18, 31. Provenance: PROVEN offset and access direction; layer/channel replicas of documented registers are INFERRED from the identical function family; field meaning UNKNOWN. Unverified on hardware.";
        field {
            name = "word";
            desc = "32-bit word (layout UNKNOWN)";
            sw = rw; hw = r;
        } word[31:0];
    } VENDOR_0800 @ 0x800;
    reg {
        name = "VENDOR_0804";
        desc = "Vendor-seen VOU register at 0x804 (hi3536dv100_vou.ko, arm-re path-sensitive scan 2026-11-12, base IO_13020000). Not in the data sheet table. Access RW by HAL_LAYER_SetRegUp. Cleared bit extents: none; field LSBs seen: none. Provenance: PROVEN offset and access direction; layer/channel replicas of documented registers are INFERRED from the identical function family; field meaning UNKNOWN. Unverified on hardware.";
        field {
            name = "word";
            desc = "32-bit word (layout UNKNOWN)";
            sw = rw; hw = r;
        } word[31:0];
    } VENDOR_0804 @ 0x804;
    reg {
        name = "VENDOR_0828";
        desc = "Vendor-seen VOU register at 0x828 (hi3536dv100_vou.ko, arm-re path-sensitive scan 2026-11-12, base IO_13020000). Not in the data sheet table. Access RW by HAL_LAYER_SetLayerInRect. Cleared bit extents: 0xffffff; field LSBs seen: 0, 12. Provenance: PROVEN offset and access direction; layer/channel replicas of documented registers are INFERRED from the identical function family; field meaning UNKNOWN. Unverified on hardware.";
        field {
            name = "word";
            desc = "32-bit word (layout UNKNOWN)";
            sw = rw; hw = r;
        } word[31:0];
    } VENDOR_0828 @ 0x828;
    reg {
        name = "VENDOR_082C";
        desc = "Vendor-seen VOU register at 0x82C (hi3536dv100_vou.ko, arm-re path-sensitive scan 2026-11-12, base IO_13020000). Not in the data sheet table. Access RW by HAL_LAYER_SetLayerOutRect. Cleared bit extents: 0xffffff; field LSBs seen: 0, 12. Provenance: PROVEN offset and access direction; layer/channel replicas of documented registers are INFERRED from the identical function family; field meaning UNKNOWN. Unverified on hardware.";
        field {
            name = "word";
            desc = "32-bit word (layout UNKNOWN)";
            sw = rw; hw = r;
        } word[31:0];
    } VENDOR_082C @ 0x82C;
    reg {
        name = "VENDOR_0838";
        desc = "Vendor-seen VOU register at 0x838 (hi3536dv100_vou.ko, arm-re path-sensitive scan 2026-11-12, base IO_13020000). Not in the data sheet table. Access RW by HAL_LAYER_GetLayerGalpha, HAL_LAYER_SetLayerGalpha. Cleared bit extents: 0xff; field LSBs seen: 0. Provenance: PROVEN offset and access direction; layer/channel replicas of documented registers are INFERRED from the identical function family; field meaning UNKNOWN. Unverified on hardware.";
        field {
            name = "word";
            desc = "32-bit word (layout UNKNOWN)";
            sw = rw; hw = r;
        } word[31:0];
    } VENDOR_0838 @ 0x838;
    reg {
        name = "VENDOR_0880";
        desc = "Vendor-seen VOU register at 0x880 (hi3536dv100_vou.ko, arm-re path-sensitive scan 2026-11-12, base IO_13020000). Not in the data sheet table. Access RW by HAL_LAYER_SetCscEn, HAL_VIDEOLAYER_SetCscMode. Cleared bit extents: 0x400000, 0x7800000; field LSBs seen: 22. Provenance: PROVEN offset and access direction; layer/channel replicas of documented registers are INFERRED from the identical function family; field meaning UNKNOWN. Unverified on hardware.";
        field {
            name = "word";
            desc = "32-bit word (layout UNKNOWN)";
            sw = rw; hw = r;
        } word[31:0];
    } VENDOR_0880 @ 0x880;
    reg {
        name = "VENDOR_08C0";
        desc = "Vendor-seen VOU register at 0x8C0 (hi3536dv100_vou.ko, arm-re path-sensitive scan 2026-11-12, base IO_13020000). Not in the data sheet table. Access RW by HAL_LAYER_SetHorRatio, HAL_LAYER_SetZmeEnable, HAL_LAYER_SetZmeFirEnable, HAL_LAYER_SetZmeMscEnable. Cleared bit extents: 0x2000000, 0x4000000, 0x40000000; field LSBs seen: 0, 25, 26, 30, 31. Provenance: PROVEN offset and access direction; layer/channel replicas of documented registers are INFERRED from the identical function family; field meaning UNKNOWN. Unverified on hardware.";
        field {
            name = "word";
            desc = "32-bit word (layout UNKNOWN)";
            sw = rw; hw = r;
        } word[31:0];
    } VENDOR_08C0 @ 0x8C0;
    reg {
        name = "VENDOR_08D8";
        desc = "Vendor-seen VOU register at 0x8D8 (hi3536dv100_vou.ko, arm-re path-sensitive scan 2026-11-12, base IO_13020000). Not in the data sheet table. Access RW by HAL_LAYER_SetZmeEnable, HAL_LAYER_SetZmeFirEnable, HAL_LAYER_SetZmeMscEnable, HAL_LAYER_SetZmeVerType. Cleared bit extents: 0x1000000, 0x180000, 0x40000000; field LSBs seen: 19, 23, 24, 30, 31. Provenance: PROVEN offset and access direction; layer/channel replicas of documented registers are INFERRED from the identical function family; field meaning UNKNOWN. Unverified on hardware.";
        field {
            name = "word";
            desc = "32-bit word (layout UNKNOWN)";
            sw = rw; hw = r;
        } word[31:0];
    } VENDOR_08D8 @ 0x8D8;
    reg {
        name = "VENDOR_08DC";
        desc = "Vendor-seen VOU register at 0x8DC (hi3536dv100_vou.ko, arm-re path-sensitive scan 2026-11-12, base IO_13020000). Not in the data sheet table. Access RW by HAL_LAYER_SetVerRatio. Cleared bit extents: 0xffff; field LSBs seen: 0. Provenance: PROVEN offset and access direction; layer/channel replicas of documented registers are INFERRED from the identical function family; field meaning UNKNOWN. Unverified on hardware.";
        field {
            name = "word";
            desc = "32-bit word (layout UNKNOWN)";
            sw = rw; hw = r;
        } word[31:0];
    } VENDOR_08DC @ 0x8DC;
    reg {
        name = "VENDOR_08F0";
        desc = "Vendor-seen VOU register at 0x8F0 (hi3536dv100_vou.ko, arm-re path-sensitive scan 2026-11-12, base IO_13020000). Not in the data sheet table. Access RW by HAL_VIDEO_SetCVfirCoef. Cleared bit extents: 0x3fffffff; field LSBs seen: none. Provenance: PROVEN offset and access direction; layer/channel replicas of documented registers are INFERRED from the identical function family; field meaning UNKNOWN. Unverified on hardware.";
        field {
            name = "word";
            desc = "32-bit word (layout UNKNOWN)";
            sw = rw; hw = r;
        } word[31:0];
    } VENDOR_08F0 @ 0x8F0;
    reg {
        name = "VENDOR_08F4";
        desc = "Vendor-seen VOU register at 0x8F4 (hi3536dv100_vou.ko, arm-re path-sensitive scan 2026-11-12, base IO_13020000). Not in the data sheet table. Access RW by HAL_VIDEO_SetCVfirCoef. Cleared bit extents: 0x3fffffff; field LSBs seen: none. Provenance: PROVEN offset and access direction; layer/channel replicas of documented registers are INFERRED from the identical function family; field meaning UNKNOWN. Unverified on hardware.";
        field {
            name = "word";
            desc = "32-bit word (layout UNKNOWN)";
            sw = rw; hw = r;
        } word[31:0];
    } VENDOR_08F4 @ 0x8F4;
    reg {
        name = "VENDOR_08F8";
        desc = "Vendor-seen VOU register at 0x8F8 (hi3536dv100_vou.ko, arm-re path-sensitive scan 2026-11-12, base IO_13020000). Not in the data sheet table. Access RW by HAL_VIDEO_SetCVfirCoef. Cleared bit extents: 0xfffff; field LSBs seen: none. Provenance: PROVEN offset and access direction; layer/channel replicas of documented registers are INFERRED from the identical function family; field meaning UNKNOWN. Unverified on hardware.";
        field {
            name = "word";
            desc = "32-bit word (layout UNKNOWN)";
            sw = rw; hw = r;
        } word[31:0];
    } VENDOR_08F8 @ 0x8F8;
    reg {
        name = "VENDOR_0900";
        desc = "Vendor-seen VOU register at 0x900 (hi3536dv100_vou.ko, arm-re path-sensitive scan 2026-11-12, base IO_13020000). Not in the data sheet table. Access RW by HAL_VIDEO_SetLayerDispRect. Cleared bit extents: 0xffffff; field LSBs seen: 0, 12. Provenance: PROVEN offset and access direction; layer/channel replicas of documented registers are INFERRED from the identical function family; field meaning UNKNOWN. Unverified on hardware.";
        field {
            name = "word";
            desc = "32-bit word (layout UNKNOWN)";
            sw = rw; hw = r;
        } word[31:0];
    } VENDOR_0900 @ 0x900;
    reg {
        name = "VENDOR_0904";
        desc = "Vendor-seen VOU register at 0x904 (hi3536dv100_vou.ko, arm-re path-sensitive scan 2026-11-12, base IO_13020000). Not in the data sheet table. Access RW by HAL_VIDEO_SetLayerDispRect. Cleared bit extents: 0xffffff; field LSBs seen: 0, 12. Provenance: PROVEN offset and access direction; layer/channel replicas of documented registers are INFERRED from the identical function family; field meaning UNKNOWN. Unverified on hardware.";
        field {
            name = "word";
            desc = "32-bit word (layout UNKNOWN)";
            sw = rw; hw = r;
        } word[31:0];
    } VENDOR_0904 @ 0x904;
    reg {
        name = "VENDOR_0908";
        desc = "Vendor-seen VOU register at 0x908 (hi3536dv100_vou.ko, arm-re path-sensitive scan 2026-11-12, base IO_13020000). Not in the data sheet table. Access RW by HAL_VIDEO_SetLayerVideoRect. Cleared bit extents: 0xffffff; field LSBs seen: 0, 12. Provenance: PROVEN offset and access direction; layer/channel replicas of documented registers are INFERRED from the identical function family; field meaning UNKNOWN. Unverified on hardware.";
        field {
            name = "word";
            desc = "32-bit word (layout UNKNOWN)";
            sw = rw; hw = r;
        } word[31:0];
    } VENDOR_0908 @ 0x908;
    reg {
        name = "VENDOR_090C";
        desc = "Vendor-seen VOU register at 0x90C (hi3536dv100_vou.ko, arm-re path-sensitive scan 2026-11-12, base IO_13020000). Not in the data sheet table. Access RW by HAL_VIDEO_SetLayerVideoRect. Cleared bit extents: 0xffffff; field LSBs seen: 0, 12. Provenance: PROVEN offset and access direction; layer/channel replicas of documented registers are INFERRED from the identical function family; field meaning UNKNOWN. Unverified on hardware.";
        field {
            name = "word";
            desc = "32-bit word (layout UNKNOWN)";
            sw = rw; hw = r;
        } word[31:0];
    } VENDOR_090C @ 0x90C;
    reg {
        name = "VENDOR_0980";
        desc = "Vendor-seen VOU register at 0x980 (hi3536dv100_vou.ko, arm-re path-sensitive scan 2026-11-12, base IO_13020000). Not in the data sheet table. Access RW by HAL_VIDEO_SetIfirCoef. Cleared bit extents: 0x3ff03ff; field LSBs seen: 0, 16. Provenance: PROVEN offset and access direction; layer/channel replicas of documented registers are INFERRED from the identical function family; field meaning UNKNOWN. Unverified on hardware.";
        field {
            name = "word";
            desc = "32-bit word (layout UNKNOWN)";
            sw = rw; hw = r;
        } word[31:0];
    } VENDOR_0980 @ 0x980;
    reg {
        name = "VENDOR_0984";
        desc = "Vendor-seen VOU register at 0x984 (hi3536dv100_vou.ko, arm-re path-sensitive scan 2026-11-12, base IO_13020000). Not in the data sheet table. Access RW by HAL_VIDEO_SetIfirCoef. Cleared bit extents: 0x3ff03ff; field LSBs seen: 0, 16. Provenance: PROVEN offset and access direction; layer/channel replicas of documented registers are INFERRED from the identical function family; field meaning UNKNOWN. Unverified on hardware.";
        field {
            name = "word";
            desc = "32-bit word (layout UNKNOWN)";
            sw = rw; hw = r;
        } word[31:0];
    } VENDOR_0984 @ 0x984;
    reg {
        name = "VENDOR_0988";
        desc = "Vendor-seen VOU register at 0x988 (hi3536dv100_vou.ko, arm-re path-sensitive scan 2026-11-12, base IO_13020000). Not in the data sheet table. Access RW by HAL_VIDEO_SetIfirCoef. Cleared bit extents: 0x3ff03ff; field LSBs seen: 0, 16. Provenance: PROVEN offset and access direction; layer/channel replicas of documented registers are INFERRED from the identical function family; field meaning UNKNOWN. Unverified on hardware.";
        field {
            name = "word";
            desc = "32-bit word (layout UNKNOWN)";
            sw = rw; hw = r;
        } word[31:0];
    } VENDOR_0988 @ 0x988;
    reg {
        name = "VENDOR_098C";
        desc = "Vendor-seen VOU register at 0x98C (hi3536dv100_vou.ko, arm-re path-sensitive scan 2026-11-12, base IO_13020000). Not in the data sheet table. Access RW by HAL_VIDEO_SetIfirCoef. Cleared bit extents: 0x3ff03ff; field LSBs seen: 0, 16. Provenance: PROVEN offset and access direction; layer/channel replicas of documented registers are INFERRED from the identical function family; field meaning UNKNOWN. Unverified on hardware.";
        field {
            name = "word";
            desc = "32-bit word (layout UNKNOWN)";
            sw = rw; hw = r;
        } word[31:0];
    } VENDOR_098C @ 0x98C;
    reg {
        name = "VENDOR_0A00";
        desc = "Vendor-seen VOU register at 0xA00 (hi3536dv100_vou.ko, arm-re path-sensitive scan 2026-11-12, base IO_13020000). Not in the data sheet table. Access RW by HAL_VIDEO_SetMultiAreaReso. Cleared bit extents: 0xfff; field LSBs seen: 0. Provenance: PROVEN offset and access direction; layer/channel replicas of documented registers are INFERRED from the identical function family; field meaning UNKNOWN. Unverified on hardware.";
        field {
            name = "word";
            desc = "32-bit word (layout UNKNOWN)";
            sw = rw; hw = r;
        } word[31:0];
    } VENDOR_0A00 @ 0xA00;
    reg {
        name = "VENDOR_0A04";
        desc = "Vendor-seen VOU register at 0xA04 (hi3536dv100_vou.ko, arm-re path-sensitive scan 2026-11-12, base IO_13020000). Not in the data sheet table. Access W by HAL_VIDEO_SetMultiAreaLAddr. Cleared bit extents: none; field LSBs seen: 0. Provenance: PROVEN offset and access direction; layer/channel replicas of documented registers are INFERRED from the identical function family; field meaning UNKNOWN. Unverified on hardware.";
        field {
            name = "word";
            desc = "32-bit word (layout UNKNOWN)";
            sw = rw; hw = r;
        } word[31:0];
    } VENDOR_0A04 @ 0xA04;
    reg {
        name = "VENDOR_0A08";
        desc = "Vendor-seen VOU register at 0xA08 (hi3536dv100_vou.ko, arm-re path-sensitive scan 2026-11-12, base IO_13020000). Not in the data sheet table. Access W by HAL_VIDEO_SetMultiAreaCAddr. Cleared bit extents: none; field LSBs seen: 0. Provenance: PROVEN offset and access direction; layer/channel replicas of documented registers are INFERRED from the identical function family; field meaning UNKNOWN. Unverified on hardware.";
        field {
            name = "word";
            desc = "32-bit word (layout UNKNOWN)";
            sw = rw; hw = r;
        } word[31:0];
    } VENDOR_0A08 @ 0xA08;
    reg {
        name = "VENDOR_0A0C";
        desc = "Vendor-seen VOU register at 0xA0C (hi3536dv100_vou.ko, arm-re path-sensitive scan 2026-11-12, base IO_13020000). Not in the data sheet table. Access RW by HAL_VIDEO_SetMultiAreaCAddr, HAL_VIDEO_SetMultiAreaLAddr. Cleared bit extents: 0xffff, 0xffff0000; field LSBs seen: 0, 16. Provenance: PROVEN offset and access direction; layer/channel replicas of documented registers are INFERRED from the identical function family; field meaning UNKNOWN. Unverified on hardware.";
        field {
            name = "word";
            desc = "32-bit word (layout UNKNOWN)";
            sw = rw; hw = r;
        } word[31:0];
    } VENDOR_0A0C @ 0xA0C;
    reg {
        name = "VENDOR_0A10";
        desc = "Vendor-seen VOU register at 0xA10 (hi3536dv100_vou.ko, arm-re path-sensitive scan 2026-11-12, base IO_13020000). Not in the data sheet table. Access RW by HAL_VIDEO_SetMultiAreaRect. Cleared bit extents: 0xffffff; field LSBs seen: none. Provenance: PROVEN offset and access direction; layer/channel replicas of documented registers are INFERRED from the identical function family; field meaning UNKNOWN. Unverified on hardware.";
        field {
            name = "word";
            desc = "32-bit word (layout UNKNOWN)";
            sw = rw; hw = r;
        } word[31:0];
    } VENDOR_0A10 @ 0xA10;
    reg {
        name = "VENDOR_0A14";
        desc = "Vendor-seen VOU register at 0xA14 (hi3536dv100_vou.ko, arm-re path-sensitive scan 2026-11-12, base IO_13020000). Not in the data sheet table. Access RW by HAL_VIDEO_SetMultiAreaRect. Cleared bit extents: 0xffffff; field LSBs seen: 0, 12. Provenance: PROVEN offset and access direction; layer/channel replicas of documented registers are INFERRED from the identical function family; field meaning UNKNOWN. Unverified on hardware.";
        field {
            name = "word";
            desc = "32-bit word (layout UNKNOWN)";
            sw = rw; hw = r;
        } word[31:0];
    } VENDOR_0A14 @ 0xA14;
    reg {
        name = "VENDOR_0A18";
        desc = "Vendor-seen VOU register at 0xA18 (hi3536dv100_vou.ko, arm-re path-sensitive scan 2026-11-12, base IO_13020000). Not in the data sheet table. Access RW by HAL_VIDEO_EnableAreaDcmp, HAL_VIDEO_GetMultiAreaEnable, HAL_VIDEO_SetAllAreaDisable, HAL_VIDEO_SetMultiAreaEnable. Cleared bit extents: 0x20, 0x3c; field LSBs seen: 0. Provenance: PROVEN offset and access direction; layer/channel replicas of documented registers are INFERRED from the identical function family; field meaning UNKNOWN. Unverified on hardware.";
        field {
            name = "word";
            desc = "32-bit word (layout UNKNOWN)";
            sw = rw; hw = r;
        } word[31:0];
    } VENDOR_0A18 @ 0xA18;
    reg {
        name = "VENDOR_1330";
        desc = "Vendor-seen VOU register at 0x1330 (hi3536dv100_vou.ko, arm-re path-sensitive scan 2026-11-12, base IO_13020000). Not in the data sheet table. Access RW by HAL_VIDEO_ClrVDcmpChromaState, HAL_VIDEO_ClrVDcmpLumaState. Cleared bit extents: none; field LSBs seen: none. Provenance: PROVEN offset and access direction; layer/channel replicas of documented registers are INFERRED from the identical function family; field meaning UNKNOWN. Unverified on hardware.";
        field {
            name = "word";
            desc = "32-bit word (layout UNKNOWN)";
            sw = rw; hw = r;
        } word[31:0];
    } VENDOR_1330 @ 0x1330;
    reg {
        name = "VENDOR_1334";
        desc = "Vendor-seen VOU register at 0x1334 (hi3536dv100_vou.ko, arm-re path-sensitive scan 2026-11-12, base IO_13020000). Not in the data sheet table. Access R by HAL_VIDEO_GetVDcmpChromaState, HAL_VIDEO_GetVDcmpLumaState. Cleared bit extents: none; field LSBs seen: none. Provenance: PROVEN offset and access direction; layer/channel replicas of documented registers are INFERRED from the identical function family; field meaning UNKNOWN. Unverified on hardware.";
        field {
            name = "word";
            desc = "32-bit word (layout UNKNOWN)";
            sw = r; hw = w;
        } word[31:0];
    } VENDOR_1334 @ 0x1334;
    reg {
        name = "VENDOR_1350";
        desc = "Vendor-seen VOU register at 0x1350 (hi3536dv100_vou.ko, arm-re path-sensitive scan 2026-11-12, base IO_13020000). Not in the data sheet table. Access RW by HAL_VIDEO_CLrMRGState. Cleared bit extents: none; field LSBs seen: none. Provenance: PROVEN offset and access direction; layer/channel replicas of documented registers are INFERRED from the identical function family; field meaning UNKNOWN. Unverified on hardware.";
        field {
            name = "word";
            desc = "32-bit word (layout UNKNOWN)";
            sw = rw; hw = r;
        } word[31:0];
    } VENDOR_1350 @ 0x1350;
    reg {
        name = "VENDOR_1354";
        desc = "Vendor-seen VOU register at 0x1354 (hi3536dv100_vou.ko, arm-re path-sensitive scan 2026-11-12, base IO_13020000). Not in the data sheet table. Access R by HAL_VIDEO_GetMRGState. Cleared bit extents: none; field LSBs seen: none. Provenance: PROVEN offset and access direction; layer/channel replicas of documented registers are INFERRED from the identical function family; field meaning UNKNOWN. Unverified on hardware.";
        field {
            name = "word";
            desc = "32-bit word (layout UNKNOWN)";
            sw = r; hw = w;
        } word[31:0];
    } VENDOR_1354 @ 0x1354;
    reg {
        name = "VENDOR_1800";
        desc = "Vendor-seen VOU register at 0x1800 (hi3536dv100_vou.ko, arm-re path-sensitive scan 2026-11-12, base IO_13020000). Not in the data sheet table. Access RW by HAL_LAYER_EnableLayer, HAL_LAYER_GetLayerDataFmt, HAL_LAYER_GetLayerEnable, HAL_LAYER_SetLayerDataFmt. Cleared bit extents: 0x20000, 0x80000000, 0xc0000; field LSBs seen: 0, 17, 18, 31. Provenance: PROVEN offset and access direction; layer/channel replicas of documented registers are INFERRED from the identical function family; field meaning UNKNOWN. Unverified on hardware.";
        field {
            name = "word";
            desc = "32-bit word (layout UNKNOWN)";
            sw = rw; hw = r;
        } word[31:0];
    } VENDOR_1800 @ 0x1800;
    reg {
        name = "VENDOR_1804";
        desc = "Vendor-seen VOU register at 0x1804 (hi3536dv100_vou.ko, arm-re path-sensitive scan 2026-11-12, base IO_13020000). Not in the data sheet table. Access RW by HAL_LAYER_SetRegUp. Cleared bit extents: none; field LSBs seen: none. Provenance: PROVEN offset and access direction; layer/channel replicas of documented registers are INFERRED from the identical function family; field meaning UNKNOWN. Unverified on hardware.";
        field {
            name = "word";
            desc = "32-bit word (layout UNKNOWN)";
            sw = rw; hw = r;
        } word[31:0];
    } VENDOR_1804 @ 0x1804;
    reg {
        name = "VENDOR_1828";
        desc = "Vendor-seen VOU register at 0x1828 (hi3536dv100_vou.ko, arm-re path-sensitive scan 2026-11-12, base IO_13020000). Not in the data sheet table. Access RW by HAL_LAYER_SetLayerInRect. Cleared bit extents: 0xffffff; field LSBs seen: 0, 12. Provenance: PROVEN offset and access direction; layer/channel replicas of documented registers are INFERRED from the identical function family; field meaning UNKNOWN. Unverified on hardware.";
        field {
            name = "word";
            desc = "32-bit word (layout UNKNOWN)";
            sw = rw; hw = r;
        } word[31:0];
    } VENDOR_1828 @ 0x1828;
    reg {
        name = "VENDOR_182C";
        desc = "Vendor-seen VOU register at 0x182C (hi3536dv100_vou.ko, arm-re path-sensitive scan 2026-11-12, base IO_13020000). Not in the data sheet table. Access RW by HAL_LAYER_SetLayerOutRect. Cleared bit extents: 0xffffff; field LSBs seen: 0, 12. Provenance: PROVEN offset and access direction; layer/channel replicas of documented registers are INFERRED from the identical function family; field meaning UNKNOWN. Unverified on hardware.";
        field {
            name = "word";
            desc = "32-bit word (layout UNKNOWN)";
            sw = rw; hw = r;
        } word[31:0];
    } VENDOR_182C @ 0x182C;
    reg {
        name = "VENDOR_1838";
        desc = "Vendor-seen VOU register at 0x1838 (hi3536dv100_vou.ko, arm-re path-sensitive scan 2026-11-12, base IO_13020000). Not in the data sheet table. Access RW by HAL_LAYER_GetLayerGalpha, HAL_LAYER_SetLayerGalpha. Cleared bit extents: 0xff; field LSBs seen: 0. Provenance: PROVEN offset and access direction; layer/channel replicas of documented registers are INFERRED from the identical function family; field meaning UNKNOWN. Unverified on hardware.";
        field {
            name = "word";
            desc = "32-bit word (layout UNKNOWN)";
            sw = rw; hw = r;
        } word[31:0];
    } VENDOR_1838 @ 0x1838;
    reg {
        name = "VENDOR_1880";
        desc = "Vendor-seen VOU register at 0x1880 (hi3536dv100_vou.ko, arm-re path-sensitive scan 2026-11-12, base IO_13020000). Not in the data sheet table. Access RW by HAL_LAYER_SetCscEn, HAL_VIDEOLAYER_SetCscMode. Cleared bit extents: 0x400000, 0x7800000; field LSBs seen: 22. Provenance: PROVEN offset and access direction; layer/channel replicas of documented registers are INFERRED from the identical function family; field meaning UNKNOWN. Unverified on hardware.";
        field {
            name = "word";
            desc = "32-bit word (layout UNKNOWN)";
            sw = rw; hw = r;
        } word[31:0];
    } VENDOR_1880 @ 0x1880;
    reg {
        name = "VENDOR_18C0";
        desc = "Vendor-seen VOU register at 0x18C0 (hi3536dv100_vou.ko, arm-re path-sensitive scan 2026-11-12, base IO_13020000). Not in the data sheet table. Access RW by HAL_LAYER_SetHorRatio, HAL_LAYER_SetZmeEnable, HAL_LAYER_SetZmeFirEnable, HAL_LAYER_SetZmeMscEnable. Cleared bit extents: 0x2000000, 0x4000000, 0x40000000; field LSBs seen: 0, 25, 26, 30, 31. Provenance: PROVEN offset and access direction; layer/channel replicas of documented registers are INFERRED from the identical function family; field meaning UNKNOWN. Unverified on hardware.";
        field {
            name = "word";
            desc = "32-bit word (layout UNKNOWN)";
            sw = rw; hw = r;
        } word[31:0];
    } VENDOR_18C0 @ 0x18C0;
    reg {
        name = "VENDOR_18D8";
        desc = "Vendor-seen VOU register at 0x18D8 (hi3536dv100_vou.ko, arm-re path-sensitive scan 2026-11-12, base IO_13020000). Not in the data sheet table. Access RW by HAL_LAYER_SetZmeEnable, HAL_LAYER_SetZmeFirEnable, HAL_LAYER_SetZmeMscEnable, HAL_LAYER_SetZmeVerType. Cleared bit extents: 0x1000000, 0x180000, 0x40000000; field LSBs seen: 19, 23, 24, 30, 31. Provenance: PROVEN offset and access direction; layer/channel replicas of documented registers are INFERRED from the identical function family; field meaning UNKNOWN. Unverified on hardware.";
        field {
            name = "word";
            desc = "32-bit word (layout UNKNOWN)";
            sw = rw; hw = r;
        } word[31:0];
    } VENDOR_18D8 @ 0x18D8;
    reg {
        name = "VENDOR_18DC";
        desc = "Vendor-seen VOU register at 0x18DC (hi3536dv100_vou.ko, arm-re path-sensitive scan 2026-11-12, base IO_13020000). Not in the data sheet table. Access RW by HAL_LAYER_SetVerRatio. Cleared bit extents: 0xffff; field LSBs seen: 0. Provenance: PROVEN offset and access direction; layer/channel replicas of documented registers are INFERRED from the identical function family; field meaning UNKNOWN. Unverified on hardware.";
        field {
            name = "word";
            desc = "32-bit word (layout UNKNOWN)";
            sw = rw; hw = r;
        } word[31:0];
    } VENDOR_18DC @ 0x18DC;
    reg {
        name = "VENDOR_18F0";
        desc = "Vendor-seen VOU register at 0x18F0 (hi3536dv100_vou.ko, arm-re path-sensitive scan 2026-11-12, base IO_13020000). Not in the data sheet table. Access RW by HAL_VIDEO_SetCVfirCoef. Cleared bit extents: 0x3fffffff; field LSBs seen: none. Provenance: PROVEN offset and access direction; layer/channel replicas of documented registers are INFERRED from the identical function family; field meaning UNKNOWN. Unverified on hardware.";
        field {
            name = "word";
            desc = "32-bit word (layout UNKNOWN)";
            sw = rw; hw = r;
        } word[31:0];
    } VENDOR_18F0 @ 0x18F0;
    reg {
        name = "VENDOR_18F4";
        desc = "Vendor-seen VOU register at 0x18F4 (hi3536dv100_vou.ko, arm-re path-sensitive scan 2026-11-12, base IO_13020000). Not in the data sheet table. Access RW by HAL_VIDEO_SetCVfirCoef. Cleared bit extents: 0x3fffffff; field LSBs seen: none. Provenance: PROVEN offset and access direction; layer/channel replicas of documented registers are INFERRED from the identical function family; field meaning UNKNOWN. Unverified on hardware.";
        field {
            name = "word";
            desc = "32-bit word (layout UNKNOWN)";
            sw = rw; hw = r;
        } word[31:0];
    } VENDOR_18F4 @ 0x18F4;
    reg {
        name = "VENDOR_18F8";
        desc = "Vendor-seen VOU register at 0x18F8 (hi3536dv100_vou.ko, arm-re path-sensitive scan 2026-11-12, base IO_13020000). Not in the data sheet table. Access RW by HAL_VIDEO_SetCVfirCoef. Cleared bit extents: 0xfffff; field LSBs seen: none. Provenance: PROVEN offset and access direction; layer/channel replicas of documented registers are INFERRED from the identical function family; field meaning UNKNOWN. Unverified on hardware.";
        field {
            name = "word";
            desc = "32-bit word (layout UNKNOWN)";
            sw = rw; hw = r;
        } word[31:0];
    } VENDOR_18F8 @ 0x18F8;
    reg {
        name = "VENDOR_1900";
        desc = "Vendor-seen VOU register at 0x1900 (hi3536dv100_vou.ko, arm-re path-sensitive scan 2026-11-12, base IO_13020000). Not in the data sheet table. Access RW by HAL_VIDEO_SetLayerDispRect. Cleared bit extents: 0xffffff; field LSBs seen: 0, 12. Provenance: PROVEN offset and access direction; layer/channel replicas of documented registers are INFERRED from the identical function family; field meaning UNKNOWN. Unverified on hardware.";
        field {
            name = "word";
            desc = "32-bit word (layout UNKNOWN)";
            sw = rw; hw = r;
        } word[31:0];
    } VENDOR_1900 @ 0x1900;
    reg {
        name = "VENDOR_1904";
        desc = "Vendor-seen VOU register at 0x1904 (hi3536dv100_vou.ko, arm-re path-sensitive scan 2026-11-12, base IO_13020000). Not in the data sheet table. Access RW by HAL_VIDEO_SetLayerDispRect. Cleared bit extents: 0xffffff; field LSBs seen: 0, 12. Provenance: PROVEN offset and access direction; layer/channel replicas of documented registers are INFERRED from the identical function family; field meaning UNKNOWN. Unverified on hardware.";
        field {
            name = "word";
            desc = "32-bit word (layout UNKNOWN)";
            sw = rw; hw = r;
        } word[31:0];
    } VENDOR_1904 @ 0x1904;
    reg {
        name = "VENDOR_1908";
        desc = "Vendor-seen VOU register at 0x1908 (hi3536dv100_vou.ko, arm-re path-sensitive scan 2026-11-12, base IO_13020000). Not in the data sheet table. Access RW by HAL_VIDEO_SetLayerVideoRect. Cleared bit extents: 0xffffff; field LSBs seen: 0, 12. Provenance: PROVEN offset and access direction; layer/channel replicas of documented registers are INFERRED from the identical function family; field meaning UNKNOWN. Unverified on hardware.";
        field {
            name = "word";
            desc = "32-bit word (layout UNKNOWN)";
            sw = rw; hw = r;
        } word[31:0];
    } VENDOR_1908 @ 0x1908;
    reg {
        name = "VENDOR_190C";
        desc = "Vendor-seen VOU register at 0x190C (hi3536dv100_vou.ko, arm-re path-sensitive scan 2026-11-12, base IO_13020000). Not in the data sheet table. Access RW by HAL_VIDEO_SetLayerVideoRect. Cleared bit extents: 0xffffff; field LSBs seen: 0, 12. Provenance: PROVEN offset and access direction; layer/channel replicas of documented registers are INFERRED from the identical function family; field meaning UNKNOWN. Unverified on hardware.";
        field {
            name = "word";
            desc = "32-bit word (layout UNKNOWN)";
            sw = rw; hw = r;
        } word[31:0];
    } VENDOR_190C @ 0x190C;
    reg {
        name = "VENDOR_1980";
        desc = "Vendor-seen VOU register at 0x1980 (hi3536dv100_vou.ko, arm-re path-sensitive scan 2026-11-12, base IO_13020000). Not in the data sheet table. Access RW by HAL_VIDEO_SetIfirCoef. Cleared bit extents: 0x3ff03ff; field LSBs seen: 0, 16. Provenance: PROVEN offset and access direction; layer/channel replicas of documented registers are INFERRED from the identical function family; field meaning UNKNOWN. Unverified on hardware.";
        field {
            name = "word";
            desc = "32-bit word (layout UNKNOWN)";
            sw = rw; hw = r;
        } word[31:0];
    } VENDOR_1980 @ 0x1980;
    reg {
        name = "VENDOR_1984";
        desc = "Vendor-seen VOU register at 0x1984 (hi3536dv100_vou.ko, arm-re path-sensitive scan 2026-11-12, base IO_13020000). Not in the data sheet table. Access RW by HAL_VIDEO_SetIfirCoef. Cleared bit extents: 0x3ff03ff; field LSBs seen: 0, 16. Provenance: PROVEN offset and access direction; layer/channel replicas of documented registers are INFERRED from the identical function family; field meaning UNKNOWN. Unverified on hardware.";
        field {
            name = "word";
            desc = "32-bit word (layout UNKNOWN)";
            sw = rw; hw = r;
        } word[31:0];
    } VENDOR_1984 @ 0x1984;
    reg {
        name = "VENDOR_1988";
        desc = "Vendor-seen VOU register at 0x1988 (hi3536dv100_vou.ko, arm-re path-sensitive scan 2026-11-12, base IO_13020000). Not in the data sheet table. Access RW by HAL_VIDEO_SetIfirCoef. Cleared bit extents: 0x3ff03ff; field LSBs seen: 0, 16. Provenance: PROVEN offset and access direction; layer/channel replicas of documented registers are INFERRED from the identical function family; field meaning UNKNOWN. Unverified on hardware.";
        field {
            name = "word";
            desc = "32-bit word (layout UNKNOWN)";
            sw = rw; hw = r;
        } word[31:0];
    } VENDOR_1988 @ 0x1988;
    reg {
        name = "VENDOR_198C";
        desc = "Vendor-seen VOU register at 0x198C (hi3536dv100_vou.ko, arm-re path-sensitive scan 2026-11-12, base IO_13020000). Not in the data sheet table. Access RW by HAL_VIDEO_SetIfirCoef. Cleared bit extents: 0x3ff03ff; field LSBs seen: 0, 16. Provenance: PROVEN offset and access direction; layer/channel replicas of documented registers are INFERRED from the identical function family; field meaning UNKNOWN. Unverified on hardware.";
        field {
            name = "word";
            desc = "32-bit word (layout UNKNOWN)";
            sw = rw; hw = r;
        } word[31:0];
    } VENDOR_198C @ 0x198C;
    reg {
        name = "VENDOR_1A00";
        desc = "Vendor-seen VOU register at 0x1A00 (hi3536dv100_vou.ko, arm-re path-sensitive scan 2026-11-12, base IO_13020000). Not in the data sheet table. Access RW by HAL_VIDEO_SetMultiAreaReso. Cleared bit extents: 0xfff; field LSBs seen: 0. Provenance: PROVEN offset and access direction; layer/channel replicas of documented registers are INFERRED from the identical function family; field meaning UNKNOWN. Unverified on hardware.";
        field {
            name = "word";
            desc = "32-bit word (layout UNKNOWN)";
            sw = rw; hw = r;
        } word[31:0];
    } VENDOR_1A00 @ 0x1A00;
    reg {
        name = "VENDOR_1A04";
        desc = "Vendor-seen VOU register at 0x1A04 (hi3536dv100_vou.ko, arm-re path-sensitive scan 2026-11-12, base IO_13020000). Not in the data sheet table. Access W by HAL_VIDEO_SetMultiAreaLAddr. Cleared bit extents: none; field LSBs seen: 0. Provenance: PROVEN offset and access direction; layer/channel replicas of documented registers are INFERRED from the identical function family; field meaning UNKNOWN. Unverified on hardware.";
        field {
            name = "word";
            desc = "32-bit word (layout UNKNOWN)";
            sw = rw; hw = r;
        } word[31:0];
    } VENDOR_1A04 @ 0x1A04;
    reg {
        name = "VENDOR_1A08";
        desc = "Vendor-seen VOU register at 0x1A08 (hi3536dv100_vou.ko, arm-re path-sensitive scan 2026-11-12, base IO_13020000). Not in the data sheet table. Access W by HAL_VIDEO_SetMultiAreaCAddr. Cleared bit extents: none; field LSBs seen: 0. Provenance: PROVEN offset and access direction; layer/channel replicas of documented registers are INFERRED from the identical function family; field meaning UNKNOWN. Unverified on hardware.";
        field {
            name = "word";
            desc = "32-bit word (layout UNKNOWN)";
            sw = rw; hw = r;
        } word[31:0];
    } VENDOR_1A08 @ 0x1A08;
    reg {
        name = "VENDOR_1A0C";
        desc = "Vendor-seen VOU register at 0x1A0C (hi3536dv100_vou.ko, arm-re path-sensitive scan 2026-11-12, base IO_13020000). Not in the data sheet table. Access RW by HAL_VIDEO_SetMultiAreaCAddr, HAL_VIDEO_SetMultiAreaLAddr. Cleared bit extents: 0xffff, 0xffff0000; field LSBs seen: 0, 16. Provenance: PROVEN offset and access direction; layer/channel replicas of documented registers are INFERRED from the identical function family; field meaning UNKNOWN. Unverified on hardware.";
        field {
            name = "word";
            desc = "32-bit word (layout UNKNOWN)";
            sw = rw; hw = r;
        } word[31:0];
    } VENDOR_1A0C @ 0x1A0C;
    reg {
        name = "VENDOR_1A10";
        desc = "Vendor-seen VOU register at 0x1A10 (hi3536dv100_vou.ko, arm-re path-sensitive scan 2026-11-12, base IO_13020000). Not in the data sheet table. Access RW by HAL_VIDEO_SetMultiAreaRect. Cleared bit extents: 0xffffff; field LSBs seen: none. Provenance: PROVEN offset and access direction; layer/channel replicas of documented registers are INFERRED from the identical function family; field meaning UNKNOWN. Unverified on hardware.";
        field {
            name = "word";
            desc = "32-bit word (layout UNKNOWN)";
            sw = rw; hw = r;
        } word[31:0];
    } VENDOR_1A10 @ 0x1A10;
    reg {
        name = "VENDOR_1A14";
        desc = "Vendor-seen VOU register at 0x1A14 (hi3536dv100_vou.ko, arm-re path-sensitive scan 2026-11-12, base IO_13020000). Not in the data sheet table. Access RW by HAL_VIDEO_SetMultiAreaRect. Cleared bit extents: 0xffffff; field LSBs seen: 0, 12. Provenance: PROVEN offset and access direction; layer/channel replicas of documented registers are INFERRED from the identical function family; field meaning UNKNOWN. Unverified on hardware.";
        field {
            name = "word";
            desc = "32-bit word (layout UNKNOWN)";
            sw = rw; hw = r;
        } word[31:0];
    } VENDOR_1A14 @ 0x1A14;
    reg {
        name = "VENDOR_1A18";
        desc = "Vendor-seen VOU register at 0x1A18 (hi3536dv100_vou.ko, arm-re path-sensitive scan 2026-11-12, base IO_13020000). Not in the data sheet table. Access RW by HAL_VIDEO_EnableAreaDcmp, HAL_VIDEO_GetMultiAreaEnable, HAL_VIDEO_SetAllAreaDisable, HAL_VIDEO_SetMultiAreaEnable. Cleared bit extents: 0x20, 0x3c; field LSBs seen: 0. Provenance: PROVEN offset and access direction; layer/channel replicas of documented registers are INFERRED from the identical function family; field meaning UNKNOWN. Unverified on hardware.";
        field {
            name = "word";
            desc = "32-bit word (layout UNKNOWN)";
            sw = rw; hw = r;
        } word[31:0];
    } VENDOR_1A18 @ 0x1A18;
    reg {
        name = "VENDOR_2330";
        desc = "Vendor-seen VOU register at 0x2330 (hi3536dv100_vou.ko, arm-re path-sensitive scan 2026-11-12, base IO_13020000). Not in the data sheet table. Access RW by HAL_VIDEO_ClrVDcmpChromaState, HAL_VIDEO_ClrVDcmpLumaState. Cleared bit extents: none; field LSBs seen: none. Provenance: PROVEN offset and access direction; layer/channel replicas of documented registers are INFERRED from the identical function family; field meaning UNKNOWN. Unverified on hardware.";
        field {
            name = "word";
            desc = "32-bit word (layout UNKNOWN)";
            sw = rw; hw = r;
        } word[31:0];
    } VENDOR_2330 @ 0x2330;
    reg {
        name = "VENDOR_2334";
        desc = "Vendor-seen VOU register at 0x2334 (hi3536dv100_vou.ko, arm-re path-sensitive scan 2026-11-12, base IO_13020000). Not in the data sheet table. Access R by HAL_VIDEO_GetVDcmpChromaState, HAL_VIDEO_GetVDcmpLumaState. Cleared bit extents: none; field LSBs seen: none. Provenance: PROVEN offset and access direction; layer/channel replicas of documented registers are INFERRED from the identical function family; field meaning UNKNOWN. Unverified on hardware.";
        field {
            name = "word";
            desc = "32-bit word (layout UNKNOWN)";
            sw = r; hw = w;
        } word[31:0];
    } VENDOR_2334 @ 0x2334;
    reg {
        name = "VENDOR_2350";
        desc = "Vendor-seen VOU register at 0x2350 (hi3536dv100_vou.ko, arm-re path-sensitive scan 2026-11-12, base IO_13020000). Not in the data sheet table. Access RW by HAL_VIDEO_CLrMRGState. Cleared bit extents: none; field LSBs seen: none. Provenance: PROVEN offset and access direction; layer/channel replicas of documented registers are INFERRED from the identical function family; field meaning UNKNOWN. Unverified on hardware.";
        field {
            name = "word";
            desc = "32-bit word (layout UNKNOWN)";
            sw = rw; hw = r;
        } word[31:0];
    } VENDOR_2350 @ 0x2350;
    reg {
        name = "VENDOR_2354";
        desc = "Vendor-seen VOU register at 0x2354 (hi3536dv100_vou.ko, arm-re path-sensitive scan 2026-11-12, base IO_13020000). Not in the data sheet table. Access R by HAL_VIDEO_GetMRGState. Cleared bit extents: none; field LSBs seen: none. Provenance: PROVEN offset and access direction; layer/channel replicas of documented registers are INFERRED from the identical function family; field meaning UNKNOWN. Unverified on hardware.";
        field {
            name = "word";
            desc = "32-bit word (layout UNKNOWN)";
            sw = r; hw = w;
        } word[31:0];
    } VENDOR_2354 @ 0x2354;
    reg {
        name = "VENDOR_2800";
        desc = "Vendor-seen VOU register at 0x2800 (hi3536dv100_vou.ko, arm-re path-sensitive scan 2026-11-12, base IO_13020000). Not in the data sheet table. Access RW by HAL_LAYER_EnableLayer, HAL_LAYER_GetLayerDataFmt, HAL_LAYER_GetLayerEnable, HAL_LAYER_SetLayerDataFmt. Cleared bit extents: 0x20000, 0x80000000, 0xc0000; field LSBs seen: 0, 17, 18, 31. Provenance: PROVEN offset and access direction; layer/channel replicas of documented registers are INFERRED from the identical function family; field meaning UNKNOWN. Unverified on hardware.";
        field {
            name = "word";
            desc = "32-bit word (layout UNKNOWN)";
            sw = rw; hw = r;
        } word[31:0];
    } VENDOR_2800 @ 0x2800;
    reg {
        name = "VENDOR_2804";
        desc = "Vendor-seen VOU register at 0x2804 (hi3536dv100_vou.ko, arm-re path-sensitive scan 2026-11-12, base IO_13020000). Not in the data sheet table. Access RW by HAL_LAYER_SetRegUp. Cleared bit extents: none; field LSBs seen: none. Provenance: PROVEN offset and access direction; layer/channel replicas of documented registers are INFERRED from the identical function family; field meaning UNKNOWN. Unverified on hardware.";
        field {
            name = "word";
            desc = "32-bit word (layout UNKNOWN)";
            sw = rw; hw = r;
        } word[31:0];
    } VENDOR_2804 @ 0x2804;
    reg {
        name = "VENDOR_2828";
        desc = "Vendor-seen VOU register at 0x2828 (hi3536dv100_vou.ko, arm-re path-sensitive scan 2026-11-12, base IO_13020000). Not in the data sheet table. Access RW by HAL_LAYER_SetLayerInRect. Cleared bit extents: 0xffffff; field LSBs seen: 0, 12. Provenance: PROVEN offset and access direction; layer/channel replicas of documented registers are INFERRED from the identical function family; field meaning UNKNOWN. Unverified on hardware.";
        field {
            name = "word";
            desc = "32-bit word (layout UNKNOWN)";
            sw = rw; hw = r;
        } word[31:0];
    } VENDOR_2828 @ 0x2828;
    reg {
        name = "VENDOR_282C";
        desc = "Vendor-seen VOU register at 0x282C (hi3536dv100_vou.ko, arm-re path-sensitive scan 2026-11-12, base IO_13020000). Not in the data sheet table. Access RW by HAL_LAYER_SetLayerOutRect. Cleared bit extents: 0xffffff; field LSBs seen: 0, 12. Provenance: PROVEN offset and access direction; layer/channel replicas of documented registers are INFERRED from the identical function family; field meaning UNKNOWN. Unverified on hardware.";
        field {
            name = "word";
            desc = "32-bit word (layout UNKNOWN)";
            sw = rw; hw = r;
        } word[31:0];
    } VENDOR_282C @ 0x282C;
    reg {
        name = "VENDOR_2838";
        desc = "Vendor-seen VOU register at 0x2838 (hi3536dv100_vou.ko, arm-re path-sensitive scan 2026-11-12, base IO_13020000). Not in the data sheet table. Access RW by HAL_LAYER_GetLayerGalpha, HAL_LAYER_SetLayerGalpha. Cleared bit extents: 0xff; field LSBs seen: 0. Provenance: PROVEN offset and access direction; layer/channel replicas of documented registers are INFERRED from the identical function family; field meaning UNKNOWN. Unverified on hardware.";
        field {
            name = "word";
            desc = "32-bit word (layout UNKNOWN)";
            sw = rw; hw = r;
        } word[31:0];
    } VENDOR_2838 @ 0x2838;
    reg {
        name = "VENDOR_2880";
        desc = "Vendor-seen VOU register at 0x2880 (hi3536dv100_vou.ko, arm-re path-sensitive scan 2026-11-12, base IO_13020000). Not in the data sheet table. Access RW by HAL_LAYER_SetCscEn, HAL_VIDEOLAYER_SetCscMode. Cleared bit extents: 0x400000, 0x7800000; field LSBs seen: 22. Provenance: PROVEN offset and access direction; layer/channel replicas of documented registers are INFERRED from the identical function family; field meaning UNKNOWN. Unverified on hardware.";
        field {
            name = "word";
            desc = "32-bit word (layout UNKNOWN)";
            sw = rw; hw = r;
        } word[31:0];
    } VENDOR_2880 @ 0x2880;
    reg {
        name = "VENDOR_28C0";
        desc = "Vendor-seen VOU register at 0x28C0 (hi3536dv100_vou.ko, arm-re path-sensitive scan 2026-11-12, base IO_13020000). Not in the data sheet table. Access RW by HAL_LAYER_SetHorRatio, HAL_LAYER_SetZmeEnable, HAL_LAYER_SetZmeFirEnable, HAL_LAYER_SetZmeMscEnable. Cleared bit extents: 0x2000000, 0x4000000, 0x40000000; field LSBs seen: 0, 25, 26, 30, 31. Provenance: PROVEN offset and access direction; layer/channel replicas of documented registers are INFERRED from the identical function family; field meaning UNKNOWN. Unverified on hardware.";
        field {
            name = "word";
            desc = "32-bit word (layout UNKNOWN)";
            sw = rw; hw = r;
        } word[31:0];
    } VENDOR_28C0 @ 0x28C0;
    reg {
        name = "VENDOR_28D8";
        desc = "Vendor-seen VOU register at 0x28D8 (hi3536dv100_vou.ko, arm-re path-sensitive scan 2026-11-12, base IO_13020000). Not in the data sheet table. Access RW by HAL_LAYER_SetZmeEnable, HAL_LAYER_SetZmeFirEnable, HAL_LAYER_SetZmeMscEnable, HAL_LAYER_SetZmeVerType. Cleared bit extents: 0x1000000, 0x180000, 0x40000000; field LSBs seen: 19, 23, 24, 30, 31. Provenance: PROVEN offset and access direction; layer/channel replicas of documented registers are INFERRED from the identical function family; field meaning UNKNOWN. Unverified on hardware.";
        field {
            name = "word";
            desc = "32-bit word (layout UNKNOWN)";
            sw = rw; hw = r;
        } word[31:0];
    } VENDOR_28D8 @ 0x28D8;
    reg {
        name = "VENDOR_28DC";
        desc = "Vendor-seen VOU register at 0x28DC (hi3536dv100_vou.ko, arm-re path-sensitive scan 2026-11-12, base IO_13020000). Not in the data sheet table. Access RW by HAL_LAYER_SetVerRatio. Cleared bit extents: 0xffff; field LSBs seen: 0. Provenance: PROVEN offset and access direction; layer/channel replicas of documented registers are INFERRED from the identical function family; field meaning UNKNOWN. Unverified on hardware.";
        field {
            name = "word";
            desc = "32-bit word (layout UNKNOWN)";
            sw = rw; hw = r;
        } word[31:0];
    } VENDOR_28DC @ 0x28DC;
    reg {
        name = "VENDOR_28F0";
        desc = "Vendor-seen VOU register at 0x28F0 (hi3536dv100_vou.ko, arm-re path-sensitive scan 2026-11-12, base IO_13020000). Not in the data sheet table. Access RW by HAL_VIDEO_SetCVfirCoef. Cleared bit extents: 0x3fffffff; field LSBs seen: none. Provenance: PROVEN offset and access direction; layer/channel replicas of documented registers are INFERRED from the identical function family; field meaning UNKNOWN. Unverified on hardware.";
        field {
            name = "word";
            desc = "32-bit word (layout UNKNOWN)";
            sw = rw; hw = r;
        } word[31:0];
    } VENDOR_28F0 @ 0x28F0;
    reg {
        name = "VENDOR_28F4";
        desc = "Vendor-seen VOU register at 0x28F4 (hi3536dv100_vou.ko, arm-re path-sensitive scan 2026-11-12, base IO_13020000). Not in the data sheet table. Access RW by HAL_VIDEO_SetCVfirCoef. Cleared bit extents: 0x3fffffff; field LSBs seen: none. Provenance: PROVEN offset and access direction; layer/channel replicas of documented registers are INFERRED from the identical function family; field meaning UNKNOWN. Unverified on hardware.";
        field {
            name = "word";
            desc = "32-bit word (layout UNKNOWN)";
            sw = rw; hw = r;
        } word[31:0];
    } VENDOR_28F4 @ 0x28F4;
    reg {
        name = "VENDOR_28F8";
        desc = "Vendor-seen VOU register at 0x28F8 (hi3536dv100_vou.ko, arm-re path-sensitive scan 2026-11-12, base IO_13020000). Not in the data sheet table. Access RW by HAL_VIDEO_SetCVfirCoef. Cleared bit extents: 0xfffff; field LSBs seen: none. Provenance: PROVEN offset and access direction; layer/channel replicas of documented registers are INFERRED from the identical function family; field meaning UNKNOWN. Unverified on hardware.";
        field {
            name = "word";
            desc = "32-bit word (layout UNKNOWN)";
            sw = rw; hw = r;
        } word[31:0];
    } VENDOR_28F8 @ 0x28F8;
    reg {
        name = "VENDOR_2900";
        desc = "Vendor-seen VOU register at 0x2900 (hi3536dv100_vou.ko, arm-re path-sensitive scan 2026-11-12, base IO_13020000). Not in the data sheet table. Access RW by HAL_VIDEO_SetLayerDispRect. Cleared bit extents: 0xffffff; field LSBs seen: 0, 12. Provenance: PROVEN offset and access direction; layer/channel replicas of documented registers are INFERRED from the identical function family; field meaning UNKNOWN. Unverified on hardware.";
        field {
            name = "word";
            desc = "32-bit word (layout UNKNOWN)";
            sw = rw; hw = r;
        } word[31:0];
    } VENDOR_2900 @ 0x2900;
    reg {
        name = "VENDOR_2904";
        desc = "Vendor-seen VOU register at 0x2904 (hi3536dv100_vou.ko, arm-re path-sensitive scan 2026-11-12, base IO_13020000). Not in the data sheet table. Access RW by HAL_VIDEO_SetLayerDispRect. Cleared bit extents: 0xffffff; field LSBs seen: 0, 12. Provenance: PROVEN offset and access direction; layer/channel replicas of documented registers are INFERRED from the identical function family; field meaning UNKNOWN. Unverified on hardware.";
        field {
            name = "word";
            desc = "32-bit word (layout UNKNOWN)";
            sw = rw; hw = r;
        } word[31:0];
    } VENDOR_2904 @ 0x2904;
    reg {
        name = "VENDOR_2908";
        desc = "Vendor-seen VOU register at 0x2908 (hi3536dv100_vou.ko, arm-re path-sensitive scan 2026-11-12, base IO_13020000). Not in the data sheet table. Access RW by HAL_VIDEO_SetLayerVideoRect. Cleared bit extents: 0xffffff; field LSBs seen: 0, 12. Provenance: PROVEN offset and access direction; layer/channel replicas of documented registers are INFERRED from the identical function family; field meaning UNKNOWN. Unverified on hardware.";
        field {
            name = "word";
            desc = "32-bit word (layout UNKNOWN)";
            sw = rw; hw = r;
        } word[31:0];
    } VENDOR_2908 @ 0x2908;
    reg {
        name = "VENDOR_290C";
        desc = "Vendor-seen VOU register at 0x290C (hi3536dv100_vou.ko, arm-re path-sensitive scan 2026-11-12, base IO_13020000). Not in the data sheet table. Access RW by HAL_VIDEO_SetLayerVideoRect. Cleared bit extents: 0xffffff; field LSBs seen: 0, 12. Provenance: PROVEN offset and access direction; layer/channel replicas of documented registers are INFERRED from the identical function family; field meaning UNKNOWN. Unverified on hardware.";
        field {
            name = "word";
            desc = "32-bit word (layout UNKNOWN)";
            sw = rw; hw = r;
        } word[31:0];
    } VENDOR_290C @ 0x290C;
    reg {
        name = "VENDOR_2980";
        desc = "Vendor-seen VOU register at 0x2980 (hi3536dv100_vou.ko, arm-re path-sensitive scan 2026-11-12, base IO_13020000). Not in the data sheet table. Access RW by HAL_VIDEO_SetIfirCoef. Cleared bit extents: 0x3ff03ff; field LSBs seen: 0, 16. Provenance: PROVEN offset and access direction; layer/channel replicas of documented registers are INFERRED from the identical function family; field meaning UNKNOWN. Unverified on hardware.";
        field {
            name = "word";
            desc = "32-bit word (layout UNKNOWN)";
            sw = rw; hw = r;
        } word[31:0];
    } VENDOR_2980 @ 0x2980;
    reg {
        name = "VENDOR_2984";
        desc = "Vendor-seen VOU register at 0x2984 (hi3536dv100_vou.ko, arm-re path-sensitive scan 2026-11-12, base IO_13020000). Not in the data sheet table. Access RW by HAL_VIDEO_SetIfirCoef. Cleared bit extents: 0x3ff03ff; field LSBs seen: 0, 16. Provenance: PROVEN offset and access direction; layer/channel replicas of documented registers are INFERRED from the identical function family; field meaning UNKNOWN. Unverified on hardware.";
        field {
            name = "word";
            desc = "32-bit word (layout UNKNOWN)";
            sw = rw; hw = r;
        } word[31:0];
    } VENDOR_2984 @ 0x2984;
    reg {
        name = "VENDOR_2988";
        desc = "Vendor-seen VOU register at 0x2988 (hi3536dv100_vou.ko, arm-re path-sensitive scan 2026-11-12, base IO_13020000). Not in the data sheet table. Access RW by HAL_VIDEO_SetIfirCoef. Cleared bit extents: 0x3ff03ff; field LSBs seen: 0, 16. Provenance: PROVEN offset and access direction; layer/channel replicas of documented registers are INFERRED from the identical function family; field meaning UNKNOWN. Unverified on hardware.";
        field {
            name = "word";
            desc = "32-bit word (layout UNKNOWN)";
            sw = rw; hw = r;
        } word[31:0];
    } VENDOR_2988 @ 0x2988;
    reg {
        name = "VENDOR_298C";
        desc = "Vendor-seen VOU register at 0x298C (hi3536dv100_vou.ko, arm-re path-sensitive scan 2026-11-12, base IO_13020000). Not in the data sheet table. Access RW by HAL_VIDEO_SetIfirCoef. Cleared bit extents: 0x3ff03ff; field LSBs seen: 0, 16. Provenance: PROVEN offset and access direction; layer/channel replicas of documented registers are INFERRED from the identical function family; field meaning UNKNOWN. Unverified on hardware.";
        field {
            name = "word";
            desc = "32-bit word (layout UNKNOWN)";
            sw = rw; hw = r;
        } word[31:0];
    } VENDOR_298C @ 0x298C;
    reg {
        name = "VENDOR_2A00";
        desc = "Vendor-seen VOU register at 0x2A00 (hi3536dv100_vou.ko, arm-re path-sensitive scan 2026-11-12, base IO_13020000). Not in the data sheet table. Access RW by HAL_VIDEO_SetMultiAreaReso. Cleared bit extents: 0xfff; field LSBs seen: 0. Provenance: PROVEN offset and access direction; layer/channel replicas of documented registers are INFERRED from the identical function family; field meaning UNKNOWN. Unverified on hardware.";
        field {
            name = "word";
            desc = "32-bit word (layout UNKNOWN)";
            sw = rw; hw = r;
        } word[31:0];
    } VENDOR_2A00 @ 0x2A00;
    reg {
        name = "VENDOR_2A04";
        desc = "Vendor-seen VOU register at 0x2A04 (hi3536dv100_vou.ko, arm-re path-sensitive scan 2026-11-12, base IO_13020000). Not in the data sheet table. Access W by HAL_VIDEO_SetMultiAreaLAddr. Cleared bit extents: none; field LSBs seen: 0. Provenance: PROVEN offset and access direction; layer/channel replicas of documented registers are INFERRED from the identical function family; field meaning UNKNOWN. Unverified on hardware.";
        field {
            name = "word";
            desc = "32-bit word (layout UNKNOWN)";
            sw = rw; hw = r;
        } word[31:0];
    } VENDOR_2A04 @ 0x2A04;
    reg {
        name = "VENDOR_2A08";
        desc = "Vendor-seen VOU register at 0x2A08 (hi3536dv100_vou.ko, arm-re path-sensitive scan 2026-11-12, base IO_13020000). Not in the data sheet table. Access W by HAL_VIDEO_SetMultiAreaCAddr. Cleared bit extents: none; field LSBs seen: 0. Provenance: PROVEN offset and access direction; layer/channel replicas of documented registers are INFERRED from the identical function family; field meaning UNKNOWN. Unverified on hardware.";
        field {
            name = "word";
            desc = "32-bit word (layout UNKNOWN)";
            sw = rw; hw = r;
        } word[31:0];
    } VENDOR_2A08 @ 0x2A08;
    reg {
        name = "VENDOR_2A0C";
        desc = "Vendor-seen VOU register at 0x2A0C (hi3536dv100_vou.ko, arm-re path-sensitive scan 2026-11-12, base IO_13020000). Not in the data sheet table. Access RW by HAL_VIDEO_SetMultiAreaCAddr, HAL_VIDEO_SetMultiAreaLAddr. Cleared bit extents: 0xffff, 0xffff0000; field LSBs seen: 0, 16. Provenance: PROVEN offset and access direction; layer/channel replicas of documented registers are INFERRED from the identical function family; field meaning UNKNOWN. Unverified on hardware.";
        field {
            name = "word";
            desc = "32-bit word (layout UNKNOWN)";
            sw = rw; hw = r;
        } word[31:0];
    } VENDOR_2A0C @ 0x2A0C;
    reg {
        name = "VENDOR_2A10";
        desc = "Vendor-seen VOU register at 0x2A10 (hi3536dv100_vou.ko, arm-re path-sensitive scan 2026-11-12, base IO_13020000). Not in the data sheet table. Access RW by HAL_VIDEO_SetMultiAreaRect. Cleared bit extents: 0xffffff; field LSBs seen: none. Provenance: PROVEN offset and access direction; layer/channel replicas of documented registers are INFERRED from the identical function family; field meaning UNKNOWN. Unverified on hardware.";
        field {
            name = "word";
            desc = "32-bit word (layout UNKNOWN)";
            sw = rw; hw = r;
        } word[31:0];
    } VENDOR_2A10 @ 0x2A10;
    reg {
        name = "VENDOR_2A14";
        desc = "Vendor-seen VOU register at 0x2A14 (hi3536dv100_vou.ko, arm-re path-sensitive scan 2026-11-12, base IO_13020000). Not in the data sheet table. Access RW by HAL_VIDEO_SetMultiAreaRect. Cleared bit extents: 0xffffff; field LSBs seen: 0, 12. Provenance: PROVEN offset and access direction; layer/channel replicas of documented registers are INFERRED from the identical function family; field meaning UNKNOWN. Unverified on hardware.";
        field {
            name = "word";
            desc = "32-bit word (layout UNKNOWN)";
            sw = rw; hw = r;
        } word[31:0];
    } VENDOR_2A14 @ 0x2A14;
    reg {
        name = "VENDOR_2A18";
        desc = "Vendor-seen VOU register at 0x2A18 (hi3536dv100_vou.ko, arm-re path-sensitive scan 2026-11-12, base IO_13020000). Not in the data sheet table. Access RW by HAL_VIDEO_EnableAreaDcmp, HAL_VIDEO_GetMultiAreaEnable, HAL_VIDEO_SetAllAreaDisable, HAL_VIDEO_SetMultiAreaEnable. Cleared bit extents: 0x20, 0x3c; field LSBs seen: 0. Provenance: PROVEN offset and access direction; layer/channel replicas of documented registers are INFERRED from the identical function family; field meaning UNKNOWN. Unverified on hardware.";
        field {
            name = "word";
            desc = "32-bit word (layout UNKNOWN)";
            sw = rw; hw = r;
        } word[31:0];
    } VENDOR_2A18 @ 0x2A18;
    reg {
        name = "VENDOR_3330";
        desc = "Vendor-seen VOU register at 0x3330 (hi3536dv100_vou.ko, arm-re path-sensitive scan 2026-11-12, base IO_13020000). Not in the data sheet table. Access RW by HAL_VIDEO_ClrVDcmpChromaState, HAL_VIDEO_ClrVDcmpLumaState. Cleared bit extents: none; field LSBs seen: none. Provenance: PROVEN offset and access direction; layer/channel replicas of documented registers are INFERRED from the identical function family; field meaning UNKNOWN. Unverified on hardware.";
        field {
            name = "word";
            desc = "32-bit word (layout UNKNOWN)";
            sw = rw; hw = r;
        } word[31:0];
    } VENDOR_3330 @ 0x3330;
    reg {
        name = "VENDOR_3334";
        desc = "Vendor-seen VOU register at 0x3334 (hi3536dv100_vou.ko, arm-re path-sensitive scan 2026-11-12, base IO_13020000). Not in the data sheet table. Access R by HAL_VIDEO_GetVDcmpChromaState, HAL_VIDEO_GetVDcmpLumaState. Cleared bit extents: none; field LSBs seen: none. Provenance: PROVEN offset and access direction; layer/channel replicas of documented registers are INFERRED from the identical function family; field meaning UNKNOWN. Unverified on hardware.";
        field {
            name = "word";
            desc = "32-bit word (layout UNKNOWN)";
            sw = r; hw = w;
        } word[31:0];
    } VENDOR_3334 @ 0x3334;
    reg {
        name = "VENDOR_3350";
        desc = "Vendor-seen VOU register at 0x3350 (hi3536dv100_vou.ko, arm-re path-sensitive scan 2026-11-12, base IO_13020000). Not in the data sheet table. Access RW by HAL_VIDEO_CLrMRGState. Cleared bit extents: none; field LSBs seen: none. Provenance: PROVEN offset and access direction; layer/channel replicas of documented registers are INFERRED from the identical function family; field meaning UNKNOWN. Unverified on hardware.";
        field {
            name = "word";
            desc = "32-bit word (layout UNKNOWN)";
            sw = rw; hw = r;
        } word[31:0];
    } VENDOR_3350 @ 0x3350;
    reg {
        name = "VENDOR_3354";
        desc = "Vendor-seen VOU register at 0x3354 (hi3536dv100_vou.ko, arm-re path-sensitive scan 2026-11-12, base IO_13020000). Not in the data sheet table. Access R by HAL_VIDEO_GetMRGState. Cleared bit extents: none; field LSBs seen: none. Provenance: PROVEN offset and access direction; layer/channel replicas of documented registers are INFERRED from the identical function family; field meaning UNKNOWN. Unverified on hardware.";
        field {
            name = "word";
            desc = "32-bit word (layout UNKNOWN)";
            sw = r; hw = w;
        } word[31:0];
    } VENDOR_3354 @ 0x3354;
    reg {
        name = "VENDOR_4800";
        desc = "Vendor-seen VOU register at 0x4800 (hi3536dv100_vou.ko, arm-re path-sensitive scan 2026-11-12, base IO_13020000). Not in the data sheet table. Access RW by HAL_LAYER_EnableLayer, HAL_LAYER_GetLayerDataFmt, HAL_LAYER_GetLayerEnable, HAL_LAYER_SetLayerDataFmt. Cleared bit extents: 0x20000, 0x80000000, 0xc0000; field LSBs seen: 0, 17, 18, 31. Provenance: PROVEN offset and access direction; layer/channel replicas of documented registers are INFERRED from the identical function family; field meaning UNKNOWN. Unverified on hardware.";
        field {
            name = "word";
            desc = "32-bit word (layout UNKNOWN)";
            sw = rw; hw = r;
        } word[31:0];
    } VENDOR_4800 @ 0x4800;
    reg {
        name = "VENDOR_4804";
        desc = "Vendor-seen VOU register at 0x4804 (hi3536dv100_vou.ko, arm-re path-sensitive scan 2026-11-12, base IO_13020000). Not in the data sheet table. Access RW by HAL_LAYER_SetRegUp. Cleared bit extents: none; field LSBs seen: none. Provenance: PROVEN offset and access direction; layer/channel replicas of documented registers are INFERRED from the identical function family; field meaning UNKNOWN. Unverified on hardware.";
        field {
            name = "word";
            desc = "32-bit word (layout UNKNOWN)";
            sw = rw; hw = r;
        } word[31:0];
    } VENDOR_4804 @ 0x4804;
    reg {
        name = "VENDOR_4828";
        desc = "Vendor-seen VOU register at 0x4828 (hi3536dv100_vou.ko, arm-re path-sensitive scan 2026-11-12, base IO_13020000). Not in the data sheet table. Access RW by HAL_LAYER_SetLayerInRect. Cleared bit extents: 0xffffff; field LSBs seen: 0, 12. Provenance: PROVEN offset and access direction; layer/channel replicas of documented registers are INFERRED from the identical function family; field meaning UNKNOWN. Unverified on hardware.";
        field {
            name = "word";
            desc = "32-bit word (layout UNKNOWN)";
            sw = rw; hw = r;
        } word[31:0];
    } VENDOR_4828 @ 0x4828;
    reg {
        name = "VENDOR_482C";
        desc = "Vendor-seen VOU register at 0x482C (hi3536dv100_vou.ko, arm-re path-sensitive scan 2026-11-12, base IO_13020000). Not in the data sheet table. Access RW by HAL_LAYER_SetLayerOutRect. Cleared bit extents: 0xffffff; field LSBs seen: 0, 12. Provenance: PROVEN offset and access direction; layer/channel replicas of documented registers are INFERRED from the identical function family; field meaning UNKNOWN. Unverified on hardware.";
        field {
            name = "word";
            desc = "32-bit word (layout UNKNOWN)";
            sw = rw; hw = r;
        } word[31:0];
    } VENDOR_482C @ 0x482C;
    reg {
        name = "VENDOR_4838";
        desc = "Vendor-seen VOU register at 0x4838 (hi3536dv100_vou.ko, arm-re path-sensitive scan 2026-11-12, base IO_13020000). Not in the data sheet table. Access RW by HAL_LAYER_GetLayerGalpha, HAL_LAYER_SetLayerGalpha. Cleared bit extents: 0xff; field LSBs seen: 0. Provenance: PROVEN offset and access direction; layer/channel replicas of documented registers are INFERRED from the identical function family; field meaning UNKNOWN. Unverified on hardware.";
        field {
            name = "word";
            desc = "32-bit word (layout UNKNOWN)";
            sw = rw; hw = r;
        } word[31:0];
    } VENDOR_4838 @ 0x4838;
    reg {
        name = "VENDOR_4880";
        desc = "Vendor-seen VOU register at 0x4880 (hi3536dv100_vou.ko, arm-re path-sensitive scan 2026-11-12, base IO_13020000). Not in the data sheet table. Access RW by HAL_LAYER_SetCscEn, HAL_VIDEOLAYER_SetCscMode. Cleared bit extents: 0x400000, 0x7800000; field LSBs seen: 22. Provenance: PROVEN offset and access direction; layer/channel replicas of documented registers are INFERRED from the identical function family; field meaning UNKNOWN. Unverified on hardware.";
        field {
            name = "word";
            desc = "32-bit word (layout UNKNOWN)";
            sw = rw; hw = r;
        } word[31:0];
    } VENDOR_4880 @ 0x4880;
    reg {
        name = "VENDOR_48C0";
        desc = "Vendor-seen VOU register at 0x48C0 (hi3536dv100_vou.ko, arm-re path-sensitive scan 2026-11-12, base IO_13020000). Not in the data sheet table. Access RW by HAL_LAYER_SetHorRatio, HAL_LAYER_SetZmeEnable, HAL_LAYER_SetZmeFirEnable, HAL_LAYER_SetZmeMscEnable. Cleared bit extents: 0x2000000, 0x4000000, 0x40000000; field LSBs seen: 0, 25, 26, 30, 31. Provenance: PROVEN offset and access direction; layer/channel replicas of documented registers are INFERRED from the identical function family; field meaning UNKNOWN. Unverified on hardware.";
        field {
            name = "word";
            desc = "32-bit word (layout UNKNOWN)";
            sw = rw; hw = r;
        } word[31:0];
    } VENDOR_48C0 @ 0x48C0;
    reg {
        name = "VENDOR_48D8";
        desc = "Vendor-seen VOU register at 0x48D8 (hi3536dv100_vou.ko, arm-re path-sensitive scan 2026-11-12, base IO_13020000). Not in the data sheet table. Access RW by HAL_LAYER_SetZmeEnable, HAL_LAYER_SetZmeFirEnable, HAL_LAYER_SetZmeMscEnable, HAL_LAYER_SetZmeVerType. Cleared bit extents: 0x1000000, 0x180000, 0x40000000; field LSBs seen: 19, 23, 24, 30, 31. Provenance: PROVEN offset and access direction; layer/channel replicas of documented registers are INFERRED from the identical function family; field meaning UNKNOWN. Unverified on hardware.";
        field {
            name = "word";
            desc = "32-bit word (layout UNKNOWN)";
            sw = rw; hw = r;
        } word[31:0];
    } VENDOR_48D8 @ 0x48D8;
    reg {
        name = "VENDOR_48DC";
        desc = "Vendor-seen VOU register at 0x48DC (hi3536dv100_vou.ko, arm-re path-sensitive scan 2026-11-12, base IO_13020000). Not in the data sheet table. Access RW by HAL_LAYER_SetVerRatio. Cleared bit extents: 0xffff; field LSBs seen: 0. Provenance: PROVEN offset and access direction; layer/channel replicas of documented registers are INFERRED from the identical function family; field meaning UNKNOWN. Unverified on hardware.";
        field {
            name = "word";
            desc = "32-bit word (layout UNKNOWN)";
            sw = rw; hw = r;
        } word[31:0];
    } VENDOR_48DC @ 0x48DC;
    reg {
        name = "VENDOR_48F0";
        desc = "Vendor-seen VOU register at 0x48F0 (hi3536dv100_vou.ko, arm-re path-sensitive scan 2026-11-12, base IO_13020000). Not in the data sheet table. Access RW by HAL_VIDEO_SetCVfirCoef. Cleared bit extents: 0x3fffffff; field LSBs seen: none. Provenance: PROVEN offset and access direction; layer/channel replicas of documented registers are INFERRED from the identical function family; field meaning UNKNOWN. Unverified on hardware.";
        field {
            name = "word";
            desc = "32-bit word (layout UNKNOWN)";
            sw = rw; hw = r;
        } word[31:0];
    } VENDOR_48F0 @ 0x48F0;
    reg {
        name = "VENDOR_48F4";
        desc = "Vendor-seen VOU register at 0x48F4 (hi3536dv100_vou.ko, arm-re path-sensitive scan 2026-11-12, base IO_13020000). Not in the data sheet table. Access RW by HAL_VIDEO_SetCVfirCoef. Cleared bit extents: 0x3fffffff; field LSBs seen: none. Provenance: PROVEN offset and access direction; layer/channel replicas of documented registers are INFERRED from the identical function family; field meaning UNKNOWN. Unverified on hardware.";
        field {
            name = "word";
            desc = "32-bit word (layout UNKNOWN)";
            sw = rw; hw = r;
        } word[31:0];
    } VENDOR_48F4 @ 0x48F4;
    reg {
        name = "VENDOR_48F8";
        desc = "Vendor-seen VOU register at 0x48F8 (hi3536dv100_vou.ko, arm-re path-sensitive scan 2026-11-12, base IO_13020000). Not in the data sheet table. Access RW by HAL_VIDEO_SetCVfirCoef. Cleared bit extents: 0xfffff; field LSBs seen: none. Provenance: PROVEN offset and access direction; layer/channel replicas of documented registers are INFERRED from the identical function family; field meaning UNKNOWN. Unverified on hardware.";
        field {
            name = "word";
            desc = "32-bit word (layout UNKNOWN)";
            sw = rw; hw = r;
        } word[31:0];
    } VENDOR_48F8 @ 0x48F8;
    reg {
        name = "VENDOR_4900";
        desc = "Vendor-seen VOU register at 0x4900 (hi3536dv100_vou.ko, arm-re path-sensitive scan 2026-11-12, base IO_13020000). Not in the data sheet table. Access RW by HAL_VIDEO_SetLayerDispRect. Cleared bit extents: 0xffffff; field LSBs seen: 0, 12. Provenance: PROVEN offset and access direction; layer/channel replicas of documented registers are INFERRED from the identical function family; field meaning UNKNOWN. Unverified on hardware.";
        field {
            name = "word";
            desc = "32-bit word (layout UNKNOWN)";
            sw = rw; hw = r;
        } word[31:0];
    } VENDOR_4900 @ 0x4900;
    reg {
        name = "VENDOR_4904";
        desc = "Vendor-seen VOU register at 0x4904 (hi3536dv100_vou.ko, arm-re path-sensitive scan 2026-11-12, base IO_13020000). Not in the data sheet table. Access RW by HAL_VIDEO_SetLayerDispRect. Cleared bit extents: 0xffffff; field LSBs seen: 0, 12. Provenance: PROVEN offset and access direction; layer/channel replicas of documented registers are INFERRED from the identical function family; field meaning UNKNOWN. Unverified on hardware.";
        field {
            name = "word";
            desc = "32-bit word (layout UNKNOWN)";
            sw = rw; hw = r;
        } word[31:0];
    } VENDOR_4904 @ 0x4904;
    reg {
        name = "VENDOR_4908";
        desc = "Vendor-seen VOU register at 0x4908 (hi3536dv100_vou.ko, arm-re path-sensitive scan 2026-11-12, base IO_13020000). Not in the data sheet table. Access RW by HAL_VIDEO_SetLayerVideoRect. Cleared bit extents: 0xffffff; field LSBs seen: 0, 12. Provenance: PROVEN offset and access direction; layer/channel replicas of documented registers are INFERRED from the identical function family; field meaning UNKNOWN. Unverified on hardware.";
        field {
            name = "word";
            desc = "32-bit word (layout UNKNOWN)";
            sw = rw; hw = r;
        } word[31:0];
    } VENDOR_4908 @ 0x4908;
    reg {
        name = "VENDOR_490C";
        desc = "Vendor-seen VOU register at 0x490C (hi3536dv100_vou.ko, arm-re path-sensitive scan 2026-11-12, base IO_13020000). Not in the data sheet table. Access RW by HAL_VIDEO_SetLayerVideoRect. Cleared bit extents: 0xffffff; field LSBs seen: 0, 12. Provenance: PROVEN offset and access direction; layer/channel replicas of documented registers are INFERRED from the identical function family; field meaning UNKNOWN. Unverified on hardware.";
        field {
            name = "word";
            desc = "32-bit word (layout UNKNOWN)";
            sw = rw; hw = r;
        } word[31:0];
    } VENDOR_490C @ 0x490C;
    reg {
        name = "VENDOR_4980";
        desc = "Vendor-seen VOU register at 0x4980 (hi3536dv100_vou.ko, arm-re path-sensitive scan 2026-11-12, base IO_13020000). Not in the data sheet table. Access RW by HAL_VIDEO_SetIfirCoef. Cleared bit extents: 0x3ff03ff; field LSBs seen: 0, 16. Provenance: PROVEN offset and access direction; layer/channel replicas of documented registers are INFERRED from the identical function family; field meaning UNKNOWN. Unverified on hardware.";
        field {
            name = "word";
            desc = "32-bit word (layout UNKNOWN)";
            sw = rw; hw = r;
        } word[31:0];
    } VENDOR_4980 @ 0x4980;
    reg {
        name = "VENDOR_4984";
        desc = "Vendor-seen VOU register at 0x4984 (hi3536dv100_vou.ko, arm-re path-sensitive scan 2026-11-12, base IO_13020000). Not in the data sheet table. Access RW by HAL_VIDEO_SetIfirCoef. Cleared bit extents: 0x3ff03ff; field LSBs seen: 0, 16. Provenance: PROVEN offset and access direction; layer/channel replicas of documented registers are INFERRED from the identical function family; field meaning UNKNOWN. Unverified on hardware.";
        field {
            name = "word";
            desc = "32-bit word (layout UNKNOWN)";
            sw = rw; hw = r;
        } word[31:0];
    } VENDOR_4984 @ 0x4984;
    reg {
        name = "VENDOR_4988";
        desc = "Vendor-seen VOU register at 0x4988 (hi3536dv100_vou.ko, arm-re path-sensitive scan 2026-11-12, base IO_13020000). Not in the data sheet table. Access RW by HAL_VIDEO_SetIfirCoef. Cleared bit extents: 0x3ff03ff; field LSBs seen: 0, 16. Provenance: PROVEN offset and access direction; layer/channel replicas of documented registers are INFERRED from the identical function family; field meaning UNKNOWN. Unverified on hardware.";
        field {
            name = "word";
            desc = "32-bit word (layout UNKNOWN)";
            sw = rw; hw = r;
        } word[31:0];
    } VENDOR_4988 @ 0x4988;
    reg {
        name = "VENDOR_498C";
        desc = "Vendor-seen VOU register at 0x498C (hi3536dv100_vou.ko, arm-re path-sensitive scan 2026-11-12, base IO_13020000). Not in the data sheet table. Access RW by HAL_VIDEO_SetIfirCoef. Cleared bit extents: 0x3ff03ff; field LSBs seen: 0, 16. Provenance: PROVEN offset and access direction; layer/channel replicas of documented registers are INFERRED from the identical function family; field meaning UNKNOWN. Unverified on hardware.";
        field {
            name = "word";
            desc = "32-bit word (layout UNKNOWN)";
            sw = rw; hw = r;
        } word[31:0];
    } VENDOR_498C @ 0x498C;
    reg {
        name = "VENDOR_4A00";
        desc = "Vendor-seen VOU register at 0x4A00 (hi3536dv100_vou.ko, arm-re path-sensitive scan 2026-11-12, base IO_13020000). Not in the data sheet table. Access RW by HAL_VIDEO_SetMultiAreaReso. Cleared bit extents: 0xfff; field LSBs seen: 0. Provenance: PROVEN offset and access direction; layer/channel replicas of documented registers are INFERRED from the identical function family; field meaning UNKNOWN. Unverified on hardware.";
        field {
            name = "word";
            desc = "32-bit word (layout UNKNOWN)";
            sw = rw; hw = r;
        } word[31:0];
    } VENDOR_4A00 @ 0x4A00;
    reg {
        name = "VENDOR_4A04";
        desc = "Vendor-seen VOU register at 0x4A04 (hi3536dv100_vou.ko, arm-re path-sensitive scan 2026-11-12, base IO_13020000). Not in the data sheet table. Access W by HAL_VIDEO_SetMultiAreaLAddr. Cleared bit extents: none; field LSBs seen: 0. Provenance: PROVEN offset and access direction; layer/channel replicas of documented registers are INFERRED from the identical function family; field meaning UNKNOWN. Unverified on hardware.";
        field {
            name = "word";
            desc = "32-bit word (layout UNKNOWN)";
            sw = rw; hw = r;
        } word[31:0];
    } VENDOR_4A04 @ 0x4A04;
    reg {
        name = "VENDOR_4A08";
        desc = "Vendor-seen VOU register at 0x4A08 (hi3536dv100_vou.ko, arm-re path-sensitive scan 2026-11-12, base IO_13020000). Not in the data sheet table. Access W by HAL_VIDEO_SetMultiAreaCAddr. Cleared bit extents: none; field LSBs seen: 0. Provenance: PROVEN offset and access direction; layer/channel replicas of documented registers are INFERRED from the identical function family; field meaning UNKNOWN. Unverified on hardware.";
        field {
            name = "word";
            desc = "32-bit word (layout UNKNOWN)";
            sw = rw; hw = r;
        } word[31:0];
    } VENDOR_4A08 @ 0x4A08;
    reg {
        name = "VENDOR_4A0C";
        desc = "Vendor-seen VOU register at 0x4A0C (hi3536dv100_vou.ko, arm-re path-sensitive scan 2026-11-12, base IO_13020000). Not in the data sheet table. Access RW by HAL_VIDEO_SetMultiAreaCAddr, HAL_VIDEO_SetMultiAreaLAddr. Cleared bit extents: 0xffff, 0xffff0000; field LSBs seen: 0, 16. Provenance: PROVEN offset and access direction; layer/channel replicas of documented registers are INFERRED from the identical function family; field meaning UNKNOWN. Unverified on hardware.";
        field {
            name = "word";
            desc = "32-bit word (layout UNKNOWN)";
            sw = rw; hw = r;
        } word[31:0];
    } VENDOR_4A0C @ 0x4A0C;
    reg {
        name = "VENDOR_4A10";
        desc = "Vendor-seen VOU register at 0x4A10 (hi3536dv100_vou.ko, arm-re path-sensitive scan 2026-11-12, base IO_13020000). Not in the data sheet table. Access RW by HAL_VIDEO_SetMultiAreaRect. Cleared bit extents: 0xffffff; field LSBs seen: none. Provenance: PROVEN offset and access direction; layer/channel replicas of documented registers are INFERRED from the identical function family; field meaning UNKNOWN. Unverified on hardware.";
        field {
            name = "word";
            desc = "32-bit word (layout UNKNOWN)";
            sw = rw; hw = r;
        } word[31:0];
    } VENDOR_4A10 @ 0x4A10;
    reg {
        name = "VENDOR_4A14";
        desc = "Vendor-seen VOU register at 0x4A14 (hi3536dv100_vou.ko, arm-re path-sensitive scan 2026-11-12, base IO_13020000). Not in the data sheet table. Access RW by HAL_VIDEO_SetMultiAreaRect. Cleared bit extents: 0xffffff; field LSBs seen: 0, 12. Provenance: PROVEN offset and access direction; layer/channel replicas of documented registers are INFERRED from the identical function family; field meaning UNKNOWN. Unverified on hardware.";
        field {
            name = "word";
            desc = "32-bit word (layout UNKNOWN)";
            sw = rw; hw = r;
        } word[31:0];
    } VENDOR_4A14 @ 0x4A14;
    reg {
        name = "VENDOR_4A18";
        desc = "Vendor-seen VOU register at 0x4A18 (hi3536dv100_vou.ko, arm-re path-sensitive scan 2026-11-12, base IO_13020000). Not in the data sheet table. Access RW by HAL_VIDEO_EnableAreaDcmp, HAL_VIDEO_GetMultiAreaEnable, HAL_VIDEO_SetAllAreaDisable, HAL_VIDEO_SetMultiAreaEnable. Cleared bit extents: 0x20, 0x3c; field LSBs seen: 0. Provenance: PROVEN offset and access direction; layer/channel replicas of documented registers are INFERRED from the identical function family; field meaning UNKNOWN. Unverified on hardware.";
        field {
            name = "word";
            desc = "32-bit word (layout UNKNOWN)";
            sw = rw; hw = r;
        } word[31:0];
    } VENDOR_4A18 @ 0x4A18;
    reg {
        name = "VENDOR_5330";
        desc = "Vendor-seen VOU register at 0x5330 (hi3536dv100_vou.ko, arm-re path-sensitive scan 2026-11-12, base IO_13020000). Not in the data sheet table. Access RW by HAL_VIDEO_ClrVDcmpChromaState, HAL_VIDEO_ClrVDcmpLumaState. Cleared bit extents: none; field LSBs seen: none. Provenance: PROVEN offset and access direction; layer/channel replicas of documented registers are INFERRED from the identical function family; field meaning UNKNOWN. Unverified on hardware.";
        field {
            name = "word";
            desc = "32-bit word (layout UNKNOWN)";
            sw = rw; hw = r;
        } word[31:0];
    } VENDOR_5330 @ 0x5330;
    reg {
        name = "VENDOR_5334";
        desc = "Vendor-seen VOU register at 0x5334 (hi3536dv100_vou.ko, arm-re path-sensitive scan 2026-11-12, base IO_13020000). Not in the data sheet table. Access R by HAL_VIDEO_GetVDcmpChromaState, HAL_VIDEO_GetVDcmpLumaState. Cleared bit extents: none; field LSBs seen: none. Provenance: PROVEN offset and access direction; layer/channel replicas of documented registers are INFERRED from the identical function family; field meaning UNKNOWN. Unverified on hardware.";
        field {
            name = "word";
            desc = "32-bit word (layout UNKNOWN)";
            sw = r; hw = w;
        } word[31:0];
    } VENDOR_5334 @ 0x5334;
    reg {
        name = "VENDOR_5350";
        desc = "Vendor-seen VOU register at 0x5350 (hi3536dv100_vou.ko, arm-re path-sensitive scan 2026-11-12, base IO_13020000). Not in the data sheet table. Access RW by HAL_VIDEO_CLrMRGState. Cleared bit extents: none; field LSBs seen: none. Provenance: PROVEN offset and access direction; layer/channel replicas of documented registers are INFERRED from the identical function family; field meaning UNKNOWN. Unverified on hardware.";
        field {
            name = "word";
            desc = "32-bit word (layout UNKNOWN)";
            sw = rw; hw = r;
        } word[31:0];
    } VENDOR_5350 @ 0x5350;
    reg {
        name = "VENDOR_5354";
        desc = "Vendor-seen VOU register at 0x5354 (hi3536dv100_vou.ko, arm-re path-sensitive scan 2026-11-12, base IO_13020000). Not in the data sheet table. Access R by HAL_VIDEO_GetMRGState. Cleared bit extents: none; field LSBs seen: none. Provenance: PROVEN offset and access direction; layer/channel replicas of documented registers are INFERRED from the identical function family; field meaning UNKNOWN. Unverified on hardware.";
        field {
            name = "word";
            desc = "32-bit word (layout UNKNOWN)";
            sw = r; hw = w;
        } word[31:0];
    } VENDOR_5354 @ 0x5354;
    reg {
        name = "VENDOR_6000";
        desc = "Vendor-seen VOU register at 0x6000 (hi3536dv100_vou.ko, arm-re path-sensitive scan 2026-11-12, base IO_13020000). Not in the data sheet table. Access RW by HAL_GRAPHIC_GetGfxDcmpEnableState, HAL_GRAPHIC_SetDcmpLossLess, HAL_GRAPHIC_SetGfxDcmpEnable, HAL_GRAPHIC_SetGfxExt. Cleared bit extents: 0x2000000, 0x300, 0x80000000; field LSBs seen: 0, 25, 31, 8. Provenance: PROVEN offset and access direction; layer/channel replicas of documented registers are INFERRED from the identical function family; field meaning UNKNOWN. Unverified on hardware.";
        field {
            name = "word";
            desc = "32-bit word (layout UNKNOWN)";
            sw = rw; hw = r;
        } word[31:0];
    } VENDOR_6000 @ 0x6000;
    reg {
        name = "VENDOR_6004";
        desc = "Vendor-seen VOU register at 0x6004 (hi3536dv100_vou.ko, arm-re path-sensitive scan 2026-11-12, base IO_13020000). Not in the data sheet table. Access RW by HAL_LAYER_SetRegUp. Cleared bit extents: none; field LSBs seen: none. Provenance: PROVEN offset and access direction; layer/channel replicas of documented registers are INFERRED from the identical function family; field meaning UNKNOWN. Unverified on hardware.";
        field {
            name = "word";
            desc = "32-bit word (layout UNKNOWN)";
            sw = rw; hw = r;
        } word[31:0];
    } VENDOR_6004 @ 0x6004;
    reg {
        name = "VENDOR_6010";
        desc = "Vendor-seen VOU register at 0x6010 (hi3536dv100_vou.ko, arm-re path-sensitive scan 2026-11-12, base IO_13020000). Not in the data sheet table. Access RW by HAL_GRAPHIC_GetGfxAddr, HAL_GRAPHIC_SetGfxAddr. Cleared bit extents: none; field LSBs seen: 0. Provenance: PROVEN offset and access direction; layer/channel replicas of documented registers are INFERRED from the identical function family; field meaning UNKNOWN. Unverified on hardware.";
        field {
            name = "word";
            desc = "32-bit word (layout UNKNOWN)";
            sw = rw; hw = r;
        } word[31:0];
    } VENDOR_6010 @ 0x6010;
    reg {
        name = "VENDOR_601C";
        desc = "Vendor-seen VOU register at 0x601C (hi3536dv100_vou.ko, arm-re path-sensitive scan 2026-11-12, base IO_13020000). Not in the data sheet table. Access RW by HAL_GRAPHIC_GetGfxStride, HAL_GRAPHIC_SetGfxStride. Cleared bit extents: 0xffff; field LSBs seen: 0. Provenance: PROVEN offset and access direction; layer/channel replicas of documented registers are INFERRED from the identical function family; field meaning UNKNOWN. Unverified on hardware.";
        field {
            name = "word";
            desc = "32-bit word (layout UNKNOWN)";
            sw = rw; hw = r;
        } word[31:0];
    } VENDOR_601C @ 0x601C;
    reg {
        name = "VENDOR_6020";
        desc = "Vendor-seen VOU register at 0x6020 (hi3536dv100_vou.ko, arm-re path-sensitive scan 2026-11-12, base IO_13020000). Not in the data sheet table. Access RW by HAL_LAYER_SetLayerInRect. Cleared bit extents: 0xffffff; field LSBs seen: 0, 12. Provenance: PROVEN offset and access direction; layer/channel replicas of documented registers are INFERRED from the identical function family; field meaning UNKNOWN. Unverified on hardware.";
        field {
            name = "word";
            desc = "32-bit word (layout UNKNOWN)";
            sw = rw; hw = r;
        } word[31:0];
    } VENDOR_6020 @ 0x6020;
    reg {
        name = "VENDOR_6030";
        desc = "Vendor-seen VOU register at 0x6030 (hi3536dv100_vou.ko, arm-re path-sensitive scan 2026-11-12, base IO_13020000). Not in the data sheet table. Access RW by HAL_GRAPHIC_GetGfxPreMult, HAL_GRAPHIC_SetGfxKeyEn, HAL_GRAPHIC_SetGfxKeyMode, HAL_GRAPHIC_SetGfxPalpha. Cleared bit extents: 0x100, 0x1000, 0x2000; field LSBs seen: 0, 12, 13, 14, 15, 8. Provenance: PROVEN offset and access direction; layer/channel replicas of documented registers are INFERRED from the identical function family; field meaning UNKNOWN. Unverified on hardware.";
        field {
            name = "word";
            desc = "32-bit word (layout UNKNOWN)";
            sw = rw; hw = r;
        } word[31:0];
    } VENDOR_6030 @ 0x6030;
    reg {
        name = "VENDOR_6034";
        desc = "Vendor-seen VOU register at 0x6034 (hi3536dv100_vou.ko, arm-re path-sensitive scan 2026-11-12, base IO_13020000). Not in the data sheet table. Access RW by HAL_GRAPHIC_SetColorKeyValue, HAL_GRAPHIC_SetGfxPalpha. Cleared bit extents: 0xff000000, 0xffffff; field LSBs seen: 0, 16, 24, 8. Provenance: PROVEN offset and access direction; layer/channel replicas of documented registers are INFERRED from the identical function family; field meaning UNKNOWN. Unverified on hardware.";
        field {
            name = "word";
            desc = "32-bit word (layout UNKNOWN)";
            sw = rw; hw = r;
        } word[31:0];
    } VENDOR_6034 @ 0x6034;
    reg {
        name = "VENDOR_6038";
        desc = "Vendor-seen VOU register at 0x6038 (hi3536dv100_vou.ko, arm-re path-sensitive scan 2026-11-12, base IO_13020000). Not in the data sheet table. Access RW by HAL_GRAPHIC_SetColorKeyValue, HAL_GRAPHIC_SetGfxPalpha. Cleared bit extents: 0xff000000, 0xffffff; field LSBs seen: 0, 16, 24, 8. Provenance: PROVEN offset and access direction; layer/channel replicas of documented registers are INFERRED from the identical function family; field meaning UNKNOWN. Unverified on hardware.";
        field {
            name = "word";
            desc = "32-bit word (layout UNKNOWN)";
            sw = rw; hw = r;
        } word[31:0];
    } VENDOR_6038 @ 0x6038;
    reg {
        name = "VENDOR_603C";
        desc = "Vendor-seen VOU register at 0x603C (hi3536dv100_vou.ko, arm-re path-sensitive scan 2026-11-12, base IO_13020000). Not in the data sheet table. Access RW by HAL_GRAPHIC_SetColorKeyMask. Cleared bit extents: 0xffffff; field LSBs seen: 0, 16, 8. Provenance: PROVEN offset and access direction; layer/channel replicas of documented registers are INFERRED from the identical function family; field meaning UNKNOWN. Unverified on hardware.";
        field {
            name = "word";
            desc = "32-bit word (layout UNKNOWN)";
            sw = rw; hw = r;
        } word[31:0];
    } VENDOR_603C @ 0x603C;
    reg {
        name = "VENDOR_6070";
        desc = "Vendor-seen VOU register at 0x6070 (hi3536dv100_vou.ko, arm-re path-sensitive scan 2026-11-12, base IO_13020000). Not in the data sheet table. Access R by HAL_GFX_WBC_GetDcmpState. Cleared bit extents: none; field LSBs seen: none. Provenance: PROVEN offset and access direction; layer/channel replicas of documented registers are INFERRED from the identical function family; field meaning UNKNOWN. Unverified on hardware.";
        field {
            name = "word";
            desc = "32-bit word (layout UNKNOWN)";
            sw = r; hw = w;
        } word[31:0];
    } VENDOR_6070 @ 0x6070;
    reg {
        name = "VENDOR_6080";
        desc = "Vendor-seen VOU register at 0x6080 (hi3536dv100_vou.ko, arm-re path-sensitive scan 2026-11-12, base IO_13020000). Not in the data sheet table. Access RW by HAL_VIDEO_SetLayerDispRect. Cleared bit extents: 0xffffff; field LSBs seen: 0, 12. Provenance: PROVEN offset and access direction; layer/channel replicas of documented registers are INFERRED from the identical function family; field meaning UNKNOWN. Unverified on hardware.";
        field {
            name = "word";
            desc = "32-bit word (layout UNKNOWN)";
            sw = rw; hw = r;
        } word[31:0];
    } VENDOR_6080 @ 0x6080;
    reg {
        name = "VENDOR_6084";
        desc = "Vendor-seen VOU register at 0x6084 (hi3536dv100_vou.ko, arm-re path-sensitive scan 2026-11-12, base IO_13020000). Not in the data sheet table. Access RW by HAL_VIDEO_SetLayerDispRect. Cleared bit extents: 0xffffff; field LSBs seen: 0, 12. Provenance: PROVEN offset and access direction; layer/channel replicas of documented registers are INFERRED from the identical function family; field meaning UNKNOWN. Unverified on hardware.";
        field {
            name = "word";
            desc = "32-bit word (layout UNKNOWN)";
            sw = rw; hw = r;
        } word[31:0];
    } VENDOR_6084 @ 0x6084;
    reg {
        name = "VENDOR_6088";
        desc = "Vendor-seen VOU register at 0x6088 (hi3536dv100_vou.ko, arm-re path-sensitive scan 2026-11-12, base IO_13020000). Not in the data sheet table. Access RW by HAL_VIDEO_SetLayerVideoRect. Cleared bit extents: 0xffffff; field LSBs seen: 0, 12. Provenance: PROVEN offset and access direction; layer/channel replicas of documented registers are INFERRED from the identical function family; field meaning UNKNOWN. Unverified on hardware.";
        field {
            name = "word";
            desc = "32-bit word (layout UNKNOWN)";
            sw = rw; hw = r;
        } word[31:0];
    } VENDOR_6088 @ 0x6088;
    reg {
        name = "VENDOR_608C";
        desc = "Vendor-seen VOU register at 0x608C (hi3536dv100_vou.ko, arm-re path-sensitive scan 2026-11-12, base IO_13020000). Not in the data sheet table. Access RW by HAL_VIDEO_SetLayerVideoRect. Cleared bit extents: 0xffffff; field LSBs seen: 0, 12. Provenance: PROVEN offset and access direction; layer/channel replicas of documented registers are INFERRED from the identical function family; field meaning UNKNOWN. Unverified on hardware.";
        field {
            name = "word";
            desc = "32-bit word (layout UNKNOWN)";
            sw = rw; hw = r;
        } word[31:0];
    } VENDOR_608C @ 0x608C;
    reg {
        name = "VENDOR_60C0";
        desc = "Vendor-seen VOU register at 0x60C0 (hi3536dv100_vou.ko, arm-re path-sensitive scan 2026-11-12, base IO_13020000). Not in the data sheet table. Access RW by HAL_LAYER_SetCscEn, HAL_LAYER_SetCscMode. Cleared bit extents: 0x400000, 0x7800000; field LSBs seen: 22. Provenance: PROVEN offset and access direction; layer/channel replicas of documented registers are INFERRED from the identical function family; field meaning UNKNOWN. Unverified on hardware.";
        field {
            name = "word";
            desc = "32-bit word (layout UNKNOWN)";
            sw = rw; hw = r;
        } word[31:0];
    } VENDOR_60C0 @ 0x60C0;
    reg {
        name = "VENDOR_6470";
        desc = "Vendor-seen VOU register at 0x6470 (hi3536dv100_vou.ko, arm-re path-sensitive scan 2026-11-12, base IO_13020000). Not in the data sheet table. Access R by HAL_GFX_WBC_GetDcmpState. Cleared bit extents: none; field LSBs seen: none. Provenance: PROVEN offset and access direction; layer/channel replicas of documented registers are INFERRED from the identical function family; field meaning UNKNOWN. Unverified on hardware.";
        field {
            name = "word";
            desc = "32-bit word (layout UNKNOWN)";
            sw = r; hw = w;
        } word[31:0];
    } VENDOR_6470 @ 0x6470;
    reg {
        name = "VENDOR_6830";
        desc = "Vendor-seen VOU register at 0x6830 (hi3536dv100_vou.ko, arm-re path-sensitive scan 2026-11-12, base IO_13020000). Not in the data sheet table. Access RW by HAL_GRAPHIC_SetGfxPalphaRange. Cleared bit extents: 0x100; field LSBs seen: none. Provenance: PROVEN offset and access direction; layer/channel replicas of documented registers are INFERRED from the identical function family; field meaning UNKNOWN. Unverified on hardware.";
        field {
            name = "word";
            desc = "32-bit word (layout UNKNOWN)";
            sw = rw; hw = r;
        } word[31:0];
    } VENDOR_6830 @ 0x6830;
    reg {
        name = "VENDOR_7000";
        desc = "Vendor-seen VOU register at 0x7000 (hi3536dv100_vou.ko, arm-re path-sensitive scan 2026-11-12, base IO_13020000). Not in the data sheet table. Access RW by HAL_GRAPHIC_GetGfxDcmpEnableState, HAL_GRAPHIC_SetDcmpLossLess, HAL_GRAPHIC_SetGfxDcmpEnable, HAL_GRAPHIC_SetGfxExt. Cleared bit extents: 0x2000000, 0x300, 0x80000000; field LSBs seen: 0, 25, 31, 8. Provenance: PROVEN offset and access direction; layer/channel replicas of documented registers are INFERRED from the identical function family; field meaning UNKNOWN. Unverified on hardware.";
        field {
            name = "word";
            desc = "32-bit word (layout UNKNOWN)";
            sw = rw; hw = r;
        } word[31:0];
    } VENDOR_7000 @ 0x7000;
    reg {
        name = "VENDOR_7004";
        desc = "Vendor-seen VOU register at 0x7004 (hi3536dv100_vou.ko, arm-re path-sensitive scan 2026-11-12, base IO_13020000). Not in the data sheet table. Access RW by HAL_LAYER_SetRegUp. Cleared bit extents: none; field LSBs seen: none. Provenance: PROVEN offset and access direction; layer/channel replicas of documented registers are INFERRED from the identical function family; field meaning UNKNOWN. Unverified on hardware.";
        field {
            name = "word";
            desc = "32-bit word (layout UNKNOWN)";
            sw = rw; hw = r;
        } word[31:0];
    } VENDOR_7004 @ 0x7004;
    reg {
        name = "VENDOR_7010";
        desc = "Vendor-seen VOU register at 0x7010 (hi3536dv100_vou.ko, arm-re path-sensitive scan 2026-11-12, base IO_13020000). Not in the data sheet table. Access RW by HAL_GRAPHIC_GetGfxAddr, HAL_GRAPHIC_SetGfxAddr. Cleared bit extents: none; field LSBs seen: 0. Provenance: PROVEN offset and access direction; layer/channel replicas of documented registers are INFERRED from the identical function family; field meaning UNKNOWN. Unverified on hardware.";
        field {
            name = "word";
            desc = "32-bit word (layout UNKNOWN)";
            sw = rw; hw = r;
        } word[31:0];
    } VENDOR_7010 @ 0x7010;
    reg {
        name = "VENDOR_701C";
        desc = "Vendor-seen VOU register at 0x701C (hi3536dv100_vou.ko, arm-re path-sensitive scan 2026-11-12, base IO_13020000). Not in the data sheet table. Access RW by HAL_GRAPHIC_GetGfxStride, HAL_GRAPHIC_SetGfxStride. Cleared bit extents: 0xffff; field LSBs seen: 0. Provenance: PROVEN offset and access direction; layer/channel replicas of documented registers are INFERRED from the identical function family; field meaning UNKNOWN. Unverified on hardware.";
        field {
            name = "word";
            desc = "32-bit word (layout UNKNOWN)";
            sw = rw; hw = r;
        } word[31:0];
    } VENDOR_701C @ 0x701C;
    reg {
        name = "VENDOR_7020";
        desc = "Vendor-seen VOU register at 0x7020 (hi3536dv100_vou.ko, arm-re path-sensitive scan 2026-11-12, base IO_13020000). Not in the data sheet table. Access RW by HAL_LAYER_SetLayerInRect. Cleared bit extents: 0xffffff; field LSBs seen: 0, 12. Provenance: PROVEN offset and access direction; layer/channel replicas of documented registers are INFERRED from the identical function family; field meaning UNKNOWN. Unverified on hardware.";
        field {
            name = "word";
            desc = "32-bit word (layout UNKNOWN)";
            sw = rw; hw = r;
        } word[31:0];
    } VENDOR_7020 @ 0x7020;
    reg {
        name = "VENDOR_7030";
        desc = "Vendor-seen VOU register at 0x7030 (hi3536dv100_vou.ko, arm-re path-sensitive scan 2026-11-12, base IO_13020000). Not in the data sheet table. Access RW by HAL_GRAPHIC_GetGfxPreMult, HAL_GRAPHIC_SetGfxKeyEn, HAL_GRAPHIC_SetGfxKeyMode, HAL_GRAPHIC_SetGfxPalpha. Cleared bit extents: 0x100, 0x1000, 0x2000; field LSBs seen: 0, 12, 13, 14, 15, 8. Provenance: PROVEN offset and access direction; layer/channel replicas of documented registers are INFERRED from the identical function family; field meaning UNKNOWN. Unverified on hardware.";
        field {
            name = "word";
            desc = "32-bit word (layout UNKNOWN)";
            sw = rw; hw = r;
        } word[31:0];
    } VENDOR_7030 @ 0x7030;
    reg {
        name = "VENDOR_7034";
        desc = "Vendor-seen VOU register at 0x7034 (hi3536dv100_vou.ko, arm-re path-sensitive scan 2026-11-12, base IO_13020000). Not in the data sheet table. Access RW by HAL_GRAPHIC_SetColorKeyValue, HAL_GRAPHIC_SetGfxPalpha. Cleared bit extents: 0xff000000, 0xffffff; field LSBs seen: 0, 16, 24, 8. Provenance: PROVEN offset and access direction; layer/channel replicas of documented registers are INFERRED from the identical function family; field meaning UNKNOWN. Unverified on hardware.";
        field {
            name = "word";
            desc = "32-bit word (layout UNKNOWN)";
            sw = rw; hw = r;
        } word[31:0];
    } VENDOR_7034 @ 0x7034;
    reg {
        name = "VENDOR_7038";
        desc = "Vendor-seen VOU register at 0x7038 (hi3536dv100_vou.ko, arm-re path-sensitive scan 2026-11-12, base IO_13020000). Not in the data sheet table. Access RW by HAL_GRAPHIC_SetColorKeyValue, HAL_GRAPHIC_SetGfxPalpha. Cleared bit extents: 0xff000000, 0xffffff; field LSBs seen: 0, 16, 24, 8. Provenance: PROVEN offset and access direction; layer/channel replicas of documented registers are INFERRED from the identical function family; field meaning UNKNOWN. Unverified on hardware.";
        field {
            name = "word";
            desc = "32-bit word (layout UNKNOWN)";
            sw = rw; hw = r;
        } word[31:0];
    } VENDOR_7038 @ 0x7038;
    reg {
        name = "VENDOR_703C";
        desc = "Vendor-seen VOU register at 0x703C (hi3536dv100_vou.ko, arm-re path-sensitive scan 2026-11-12, base IO_13020000). Not in the data sheet table. Access RW by HAL_GRAPHIC_SetColorKeyMask. Cleared bit extents: 0xffffff; field LSBs seen: 0, 16, 8. Provenance: PROVEN offset and access direction; layer/channel replicas of documented registers are INFERRED from the identical function family; field meaning UNKNOWN. Unverified on hardware.";
        field {
            name = "word";
            desc = "32-bit word (layout UNKNOWN)";
            sw = rw; hw = r;
        } word[31:0];
    } VENDOR_703C @ 0x703C;
    reg {
        name = "VENDOR_7070";
        desc = "Vendor-seen VOU register at 0x7070 (hi3536dv100_vou.ko, arm-re path-sensitive scan 2026-11-12, base IO_13020000). Not in the data sheet table. Access R by HAL_GFX_WBC_GetDcmpState. Cleared bit extents: none; field LSBs seen: none. Provenance: PROVEN offset and access direction; layer/channel replicas of documented registers are INFERRED from the identical function family; field meaning UNKNOWN. Unverified on hardware.";
        field {
            name = "word";
            desc = "32-bit word (layout UNKNOWN)";
            sw = r; hw = w;
        } word[31:0];
    } VENDOR_7070 @ 0x7070;
    reg {
        name = "VENDOR_7080";
        desc = "Vendor-seen VOU register at 0x7080 (hi3536dv100_vou.ko, arm-re path-sensitive scan 2026-11-12, base IO_13020000). Not in the data sheet table. Access RW by HAL_VIDEO_SetLayerDispRect. Cleared bit extents: 0xffffff; field LSBs seen: 0, 12. Provenance: PROVEN offset and access direction; layer/channel replicas of documented registers are INFERRED from the identical function family; field meaning UNKNOWN. Unverified on hardware.";
        field {
            name = "word";
            desc = "32-bit word (layout UNKNOWN)";
            sw = rw; hw = r;
        } word[31:0];
    } VENDOR_7080 @ 0x7080;
    reg {
        name = "VENDOR_7084";
        desc = "Vendor-seen VOU register at 0x7084 (hi3536dv100_vou.ko, arm-re path-sensitive scan 2026-11-12, base IO_13020000). Not in the data sheet table. Access RW by HAL_VIDEO_SetLayerDispRect. Cleared bit extents: 0xffffff; field LSBs seen: 0, 12. Provenance: PROVEN offset and access direction; layer/channel replicas of documented registers are INFERRED from the identical function family; field meaning UNKNOWN. Unverified on hardware.";
        field {
            name = "word";
            desc = "32-bit word (layout UNKNOWN)";
            sw = rw; hw = r;
        } word[31:0];
    } VENDOR_7084 @ 0x7084;
    reg {
        name = "VENDOR_7088";
        desc = "Vendor-seen VOU register at 0x7088 (hi3536dv100_vou.ko, arm-re path-sensitive scan 2026-11-12, base IO_13020000). Not in the data sheet table. Access RW by HAL_VIDEO_SetLayerVideoRect. Cleared bit extents: 0xffffff; field LSBs seen: 0, 12. Provenance: PROVEN offset and access direction; layer/channel replicas of documented registers are INFERRED from the identical function family; field meaning UNKNOWN. Unverified on hardware.";
        field {
            name = "word";
            desc = "32-bit word (layout UNKNOWN)";
            sw = rw; hw = r;
        } word[31:0];
    } VENDOR_7088 @ 0x7088;
    reg {
        name = "VENDOR_708C";
        desc = "Vendor-seen VOU register at 0x708C (hi3536dv100_vou.ko, arm-re path-sensitive scan 2026-11-12, base IO_13020000). Not in the data sheet table. Access RW by HAL_VIDEO_SetLayerVideoRect. Cleared bit extents: 0xffffff; field LSBs seen: 0, 12. Provenance: PROVEN offset and access direction; layer/channel replicas of documented registers are INFERRED from the identical function family; field meaning UNKNOWN. Unverified on hardware.";
        field {
            name = "word";
            desc = "32-bit word (layout UNKNOWN)";
            sw = rw; hw = r;
        } word[31:0];
    } VENDOR_708C @ 0x708C;
    reg {
        name = "VENDOR_70C0";
        desc = "Vendor-seen VOU register at 0x70C0 (hi3536dv100_vou.ko, arm-re path-sensitive scan 2026-11-12, base IO_13020000). Not in the data sheet table. Access RW by HAL_LAYER_SetCscEn, HAL_LAYER_SetCscMode. Cleared bit extents: 0x400000, 0x7800000; field LSBs seen: 22. Provenance: PROVEN offset and access direction; layer/channel replicas of documented registers are INFERRED from the identical function family; field meaning UNKNOWN. Unverified on hardware.";
        field {
            name = "word";
            desc = "32-bit word (layout UNKNOWN)";
            sw = rw; hw = r;
        } word[31:0];
    } VENDOR_70C0 @ 0x70C0;
    reg {
        name = "VENDOR_9000";
        desc = "Vendor-seen VOU register at 0x9000 (hi3536dv100_vou.ko, arm-re path-sensitive scan 2026-11-12, base IO_13020000). Not in the data sheet table. Access RW by HAL_GRAPHIC_GetGfxDcmpEnableState, HAL_GRAPHIC_SetDcmpLossLess, HAL_GRAPHIC_SetGfxDcmpEnable, HAL_GRAPHIC_SetGfxExt. Cleared bit extents: 0x2000000, 0x300, 0x80000000; field LSBs seen: 0, 25, 31, 8. Provenance: PROVEN offset and access direction; layer/channel replicas of documented registers are INFERRED from the identical function family; field meaning UNKNOWN. Unverified on hardware.";
        field {
            name = "word";
            desc = "32-bit word (layout UNKNOWN)";
            sw = rw; hw = r;
        } word[31:0];
    } VENDOR_9000 @ 0x9000;
    reg {
        name = "VENDOR_9004";
        desc = "Vendor-seen VOU register at 0x9004 (hi3536dv100_vou.ko, arm-re path-sensitive scan 2026-11-12, base IO_13020000). Not in the data sheet table. Access RW by HAL_LAYER_SetRegUp. Cleared bit extents: none; field LSBs seen: none. Provenance: PROVEN offset and access direction; layer/channel replicas of documented registers are INFERRED from the identical function family; field meaning UNKNOWN. Unverified on hardware.";
        field {
            name = "word";
            desc = "32-bit word (layout UNKNOWN)";
            sw = rw; hw = r;
        } word[31:0];
    } VENDOR_9004 @ 0x9004;
    reg {
        name = "VENDOR_9010";
        desc = "Vendor-seen VOU register at 0x9010 (hi3536dv100_vou.ko, arm-re path-sensitive scan 2026-11-12, base IO_13020000). Not in the data sheet table. Access RW by HAL_GRAPHIC_GetGfxAddr, HAL_GRAPHIC_SetGfxAddr. Cleared bit extents: none; field LSBs seen: 0. Provenance: PROVEN offset and access direction; layer/channel replicas of documented registers are INFERRED from the identical function family; field meaning UNKNOWN. Unverified on hardware.";
        field {
            name = "word";
            desc = "32-bit word (layout UNKNOWN)";
            sw = rw; hw = r;
        } word[31:0];
    } VENDOR_9010 @ 0x9010;
    reg {
        name = "VENDOR_901C";
        desc = "Vendor-seen VOU register at 0x901C (hi3536dv100_vou.ko, arm-re path-sensitive scan 2026-11-12, base IO_13020000). Not in the data sheet table. Access RW by HAL_GRAPHIC_GetGfxStride, HAL_GRAPHIC_SetGfxStride. Cleared bit extents: 0xffff; field LSBs seen: 0. Provenance: PROVEN offset and access direction; layer/channel replicas of documented registers are INFERRED from the identical function family; field meaning UNKNOWN. Unverified on hardware.";
        field {
            name = "word";
            desc = "32-bit word (layout UNKNOWN)";
            sw = rw; hw = r;
        } word[31:0];
    } VENDOR_901C @ 0x901C;
    reg {
        name = "VENDOR_9020";
        desc = "Vendor-seen VOU register at 0x9020 (hi3536dv100_vou.ko, arm-re path-sensitive scan 2026-11-12, base IO_13020000). Not in the data sheet table. Access RW by HAL_LAYER_SetLayerInRect. Cleared bit extents: 0xffffff; field LSBs seen: 0, 12. Provenance: PROVEN offset and access direction; layer/channel replicas of documented registers are INFERRED from the identical function family; field meaning UNKNOWN. Unverified on hardware.";
        field {
            name = "word";
            desc = "32-bit word (layout UNKNOWN)";
            sw = rw; hw = r;
        } word[31:0];
    } VENDOR_9020 @ 0x9020;
    reg {
        name = "VENDOR_9030";
        desc = "Vendor-seen VOU register at 0x9030 (hi3536dv100_vou.ko, arm-re path-sensitive scan 2026-11-12, base IO_13020000). Not in the data sheet table. Access RW by HAL_GRAPHIC_GetGfxPreMult, HAL_GRAPHIC_SetGfxKeyEn, HAL_GRAPHIC_SetGfxKeyMode, HAL_GRAPHIC_SetGfxPalpha. Cleared bit extents: 0x100, 0x1000, 0x2000; field LSBs seen: 0, 12, 13, 14, 15, 8. Provenance: PROVEN offset and access direction; layer/channel replicas of documented registers are INFERRED from the identical function family; field meaning UNKNOWN. Unverified on hardware.";
        field {
            name = "word";
            desc = "32-bit word (layout UNKNOWN)";
            sw = rw; hw = r;
        } word[31:0];
    } VENDOR_9030 @ 0x9030;
    reg {
        name = "VENDOR_9034";
        desc = "Vendor-seen VOU register at 0x9034 (hi3536dv100_vou.ko, arm-re path-sensitive scan 2026-11-12, base IO_13020000). Not in the data sheet table. Access RW by HAL_GRAPHIC_SetColorKeyValue, HAL_GRAPHIC_SetGfxPalpha. Cleared bit extents: 0xff000000, 0xffffff; field LSBs seen: 0, 16, 24, 8. Provenance: PROVEN offset and access direction; layer/channel replicas of documented registers are INFERRED from the identical function family; field meaning UNKNOWN. Unverified on hardware.";
        field {
            name = "word";
            desc = "32-bit word (layout UNKNOWN)";
            sw = rw; hw = r;
        } word[31:0];
    } VENDOR_9034 @ 0x9034;
    reg {
        name = "VENDOR_9038";
        desc = "Vendor-seen VOU register at 0x9038 (hi3536dv100_vou.ko, arm-re path-sensitive scan 2026-11-12, base IO_13020000). Not in the data sheet table. Access RW by HAL_GRAPHIC_SetColorKeyValue, HAL_GRAPHIC_SetGfxPalpha. Cleared bit extents: 0xff000000, 0xffffff; field LSBs seen: 0, 16, 24, 8. Provenance: PROVEN offset and access direction; layer/channel replicas of documented registers are INFERRED from the identical function family; field meaning UNKNOWN. Unverified on hardware.";
        field {
            name = "word";
            desc = "32-bit word (layout UNKNOWN)";
            sw = rw; hw = r;
        } word[31:0];
    } VENDOR_9038 @ 0x9038;
    reg {
        name = "VENDOR_903C";
        desc = "Vendor-seen VOU register at 0x903C (hi3536dv100_vou.ko, arm-re path-sensitive scan 2026-11-12, base IO_13020000). Not in the data sheet table. Access RW by HAL_GRAPHIC_SetColorKeyMask. Cleared bit extents: 0xffffff; field LSBs seen: 0, 16, 8. Provenance: PROVEN offset and access direction; layer/channel replicas of documented registers are INFERRED from the identical function family; field meaning UNKNOWN. Unverified on hardware.";
        field {
            name = "word";
            desc = "32-bit word (layout UNKNOWN)";
            sw = rw; hw = r;
        } word[31:0];
    } VENDOR_903C @ 0x903C;
    reg {
        name = "VENDOR_9070";
        desc = "Vendor-seen VOU register at 0x9070 (hi3536dv100_vou.ko, arm-re path-sensitive scan 2026-11-12, base IO_13020000). Not in the data sheet table. Access R by HAL_GFX_WBC_GetDcmpState. Cleared bit extents: none; field LSBs seen: none. Provenance: PROVEN offset and access direction; layer/channel replicas of documented registers are INFERRED from the identical function family; field meaning UNKNOWN. Unverified on hardware.";
        field {
            name = "word";
            desc = "32-bit word (layout UNKNOWN)";
            sw = r; hw = w;
        } word[31:0];
    } VENDOR_9070 @ 0x9070;
    reg {
        name = "VENDOR_9080";
        desc = "Vendor-seen VOU register at 0x9080 (hi3536dv100_vou.ko, arm-re path-sensitive scan 2026-11-12, base IO_13020000). Not in the data sheet table. Access RW by HAL_VIDEO_SetLayerDispRect. Cleared bit extents: 0xffffff; field LSBs seen: 0, 12. Provenance: PROVEN offset and access direction; layer/channel replicas of documented registers are INFERRED from the identical function family; field meaning UNKNOWN. Unverified on hardware.";
        field {
            name = "word";
            desc = "32-bit word (layout UNKNOWN)";
            sw = rw; hw = r;
        } word[31:0];
    } VENDOR_9080 @ 0x9080;
    reg {
        name = "VENDOR_9084";
        desc = "Vendor-seen VOU register at 0x9084 (hi3536dv100_vou.ko, arm-re path-sensitive scan 2026-11-12, base IO_13020000). Not in the data sheet table. Access RW by HAL_VIDEO_SetLayerDispRect. Cleared bit extents: 0xffffff; field LSBs seen: 0, 12. Provenance: PROVEN offset and access direction; layer/channel replicas of documented registers are INFERRED from the identical function family; field meaning UNKNOWN. Unverified on hardware.";
        field {
            name = "word";
            desc = "32-bit word (layout UNKNOWN)";
            sw = rw; hw = r;
        } word[31:0];
    } VENDOR_9084 @ 0x9084;
    reg {
        name = "VENDOR_9088";
        desc = "Vendor-seen VOU register at 0x9088 (hi3536dv100_vou.ko, arm-re path-sensitive scan 2026-11-12, base IO_13020000). Not in the data sheet table. Access RW by HAL_VIDEO_SetLayerVideoRect. Cleared bit extents: 0xffffff; field LSBs seen: 0, 12. Provenance: PROVEN offset and access direction; layer/channel replicas of documented registers are INFERRED from the identical function family; field meaning UNKNOWN. Unverified on hardware.";
        field {
            name = "word";
            desc = "32-bit word (layout UNKNOWN)";
            sw = rw; hw = r;
        } word[31:0];
    } VENDOR_9088 @ 0x9088;
    reg {
        name = "VENDOR_908C";
        desc = "Vendor-seen VOU register at 0x908C (hi3536dv100_vou.ko, arm-re path-sensitive scan 2026-11-12, base IO_13020000). Not in the data sheet table. Access RW by HAL_VIDEO_SetLayerVideoRect. Cleared bit extents: 0xffffff; field LSBs seen: 0, 12. Provenance: PROVEN offset and access direction; layer/channel replicas of documented registers are INFERRED from the identical function family; field meaning UNKNOWN. Unverified on hardware.";
        field {
            name = "word";
            desc = "32-bit word (layout UNKNOWN)";
            sw = rw; hw = r;
        } word[31:0];
    } VENDOR_908C @ 0x908C;
    reg {
        name = "VENDOR_90C0";
        desc = "Vendor-seen VOU register at 0x90C0 (hi3536dv100_vou.ko, arm-re path-sensitive scan 2026-11-12, base IO_13020000). Not in the data sheet table. Access RW by HAL_LAYER_SetCscEn, HAL_LAYER_SetCscMode. Cleared bit extents: 0x400000, 0x7800000; field LSBs seen: 22. Provenance: PROVEN offset and access direction; layer/channel replicas of documented registers are INFERRED from the identical function family; field meaning UNKNOWN. Unverified on hardware.";
        field {
            name = "word";
            desc = "32-bit word (layout UNKNOWN)";
            sw = rw; hw = r;
        } word[31:0];
    } VENDOR_90C0 @ 0x90C0;
    reg {
        name = "VENDOR_A000";
        desc = "Vendor-seen VOU register at 0xA000 (hi3536dv100_vou.ko, arm-re path-sensitive scan 2026-11-12, base IO_13020000). Not in the data sheet table. Access RW by HAL_GFX_WBC_GetWbcEnState, HAL_GFX_WBC_SetWbcAutoStopEn, HAL_GFX_WBC_SetWbcDataFmt, HAL_GFX_WBC_SetWbcEnable. Cleared bit extents: 0x2000000, 0x300, 0x400; field LSBs seen: 0, 10, 25, 31, 8. Provenance: PROVEN offset and access direction; layer/channel replicas of documented registers are INFERRED from the identical function family; field meaning UNKNOWN. Unverified on hardware.";
        field {
            name = "word";
            desc = "32-bit word (layout UNKNOWN)";
            sw = rw; hw = r;
        } word[31:0];
    } VENDOR_A000 @ 0xA000;
    reg {
        name = "VENDOR_A004";
        desc = "Vendor-seen VOU register at 0xA004 (hi3536dv100_vou.ko, arm-re path-sensitive scan 2026-11-12, base IO_13020000). Not in the data sheet table. Access RW by HAL_GFX_WBC_SetWbcRegUp, HAL_LAYER_SetRegUp. Cleared bit extents: none; field LSBs seen: none. Provenance: PROVEN offset and access direction; layer/channel replicas of documented registers are INFERRED from the identical function family; field meaning UNKNOWN. Unverified on hardware.";
        field {
            name = "word";
            desc = "32-bit word (layout UNKNOWN)";
            sw = rw; hw = r;
        } word[31:0];
    } VENDOR_A004 @ 0xA004;
    reg {
        name = "VENDOR_A008";
        desc = "Vendor-seen VOU register at 0xA008 (hi3536dv100_vou.ko, arm-re path-sensitive scan 2026-11-12, base IO_13020000). Not in the data sheet table. Access RW by HAL_GFX_WBC_SetWbcEnable. Cleared bit extents: 0x80000000; field LSBs seen: 31. Provenance: PROVEN offset and access direction; layer/channel replicas of documented registers are INFERRED from the identical function family; field meaning UNKNOWN. Unverified on hardware.";
        field {
            name = "word";
            desc = "32-bit word (layout UNKNOWN)";
            sw = rw; hw = r;
        } word[31:0];
    } VENDOR_A008 @ 0xA008;
    reg {
        name = "VENDOR_A010";
        desc = "Vendor-seen VOU register at 0xA010 (hi3536dv100_vou.ko, arm-re path-sensitive scan 2026-11-12, base IO_13020000). Not in the data sheet table. Access RW by HAL_GFX_WBC_SetWbcAddr, HAL_GRAPHIC_GetGfxAddr, HAL_GRAPHIC_SetGfxAddr. Cleared bit extents: none; field LSBs seen: 0. Provenance: PROVEN offset and access direction; layer/channel replicas of documented registers are INFERRED from the identical function family; field meaning UNKNOWN. Unverified on hardware.";
        field {
            name = "word";
            desc = "32-bit word (layout UNKNOWN)";
            sw = rw; hw = r;
        } word[31:0];
    } VENDOR_A010 @ 0xA010;
    reg {
        name = "VENDOR_A018";
        desc = "Vendor-seen VOU register at 0xA018 (hi3536dv100_vou.ko, arm-re path-sensitive scan 2026-11-12, base IO_13020000). Not in the data sheet table. Access RW by HAL_GFX_WBC_SetWbcStride. Cleared bit extents: 0xffff; field LSBs seen: 0. Provenance: PROVEN offset and access direction; layer/channel replicas of documented registers are INFERRED from the identical function family; field meaning UNKNOWN. Unverified on hardware.";
        field {
            name = "word";
            desc = "32-bit word (layout UNKNOWN)";
            sw = rw; hw = r;
        } word[31:0];
    } VENDOR_A018 @ 0xA018;
    reg {
        name = "VENDOR_A01C";
        desc = "Vendor-seen VOU register at 0xA01C (hi3536dv100_vou.ko, arm-re path-sensitive scan 2026-11-12, base IO_13020000). Not in the data sheet table. Access RW by HAL_GRAPHIC_GetGfxStride, HAL_GRAPHIC_SetGfxStride. Cleared bit extents: 0xffff; field LSBs seen: 0. Provenance: PROVEN offset and access direction; layer/channel replicas of documented registers are INFERRED from the identical function family; field meaning UNKNOWN. Unverified on hardware.";
        field {
            name = "word";
            desc = "32-bit word (layout UNKNOWN)";
            sw = rw; hw = r;
        } word[31:0];
    } VENDOR_A01C @ 0xA01C;
    reg {
        name = "VENDOR_A020";
        desc = "Vendor-seen VOU register at 0xA020 (hi3536dv100_vou.ko, arm-re path-sensitive scan 2026-11-12, base IO_13020000). Not in the data sheet table. Access RW by HAL_GFX_WBC_SetWbcOReso, HAL_LAYER_SetLayerInRect. Cleared bit extents: 0xffffff; field LSBs seen: 0, 12. Provenance: PROVEN offset and access direction; layer/channel replicas of documented registers are INFERRED from the identical function family; field meaning UNKNOWN. Unverified on hardware.";
        field {
            name = "word";
            desc = "32-bit word (layout UNKNOWN)";
            sw = rw; hw = r;
        } word[31:0];
    } VENDOR_A020 @ 0xA020;
    reg {
        name = "VENDOR_A024";
        desc = "Vendor-seen VOU register at 0xA024 (hi3536dv100_vou.ko, arm-re path-sensitive scan 2026-11-12, base IO_13020000). Not in the data sheet table. Access RW by HAL_GFX_WBC_SetWbcCrop. Cleared bit extents: 0xffffff; field LSBs seen: 0, 12. Provenance: PROVEN offset and access direction; layer/channel replicas of documented registers are INFERRED from the identical function family; field meaning UNKNOWN. Unverified on hardware.";
        field {
            name = "word";
            desc = "32-bit word (layout UNKNOWN)";
            sw = rw; hw = r;
        } word[31:0];
    } VENDOR_A024 @ 0xA024;
    reg {
        name = "VENDOR_A030";
        desc = "Vendor-seen VOU register at 0xA030 (hi3536dv100_vou.ko, arm-re path-sensitive scan 2026-11-12, base IO_13020000). Not in the data sheet table. Access RW by HAL_GRAPHIC_GetGfxPreMult, HAL_GRAPHIC_SetGfxKeyEn, HAL_GRAPHIC_SetGfxKeyMode, HAL_GRAPHIC_SetGfxPalpha. Cleared bit extents: 0x100, 0x1000, 0x2000; field LSBs seen: 0, 12, 13, 14, 15, 8. Provenance: PROVEN offset and access direction; layer/channel replicas of documented registers are INFERRED from the identical function family; field meaning UNKNOWN. Unverified on hardware.";
        field {
            name = "word";
            desc = "32-bit word (layout UNKNOWN)";
            sw = rw; hw = r;
        } word[31:0];
    } VENDOR_A030 @ 0xA030;
    reg {
        name = "VENDOR_A034";
        desc = "Vendor-seen VOU register at 0xA034 (hi3536dv100_vou.ko, arm-re path-sensitive scan 2026-11-12, base IO_13020000). Not in the data sheet table. Access RW by HAL_GFX_WBC_GetWbcStrideState, HAL_GRAPHIC_SetColorKeyValue, HAL_GRAPHIC_SetGfxPalpha. Cleared bit extents: 0xff000000, 0xffffff; field LSBs seen: 0, 16, 24, 8. Provenance: PROVEN offset and access direction; layer/channel replicas of documented registers are INFERRED from the identical function family; field meaning UNKNOWN. Unverified on hardware.";
        field {
            name = "word";
            desc = "32-bit word (layout UNKNOWN)";
            sw = rw; hw = r;
        } word[31:0];
    } VENDOR_A034 @ 0xA034;
    reg {
        name = "VENDOR_A038";
        desc = "Vendor-seen VOU register at 0xA038 (hi3536dv100_vou.ko, arm-re path-sensitive scan 2026-11-12, base IO_13020000). Not in the data sheet table. Access RW by HAL_GFX_WBC_GetWbcStrideState, HAL_GRAPHIC_SetColorKeyValue, HAL_GRAPHIC_SetGfxPalpha. Cleared bit extents: 0xff000000, 0xffffff; field LSBs seen: 0, 16, 24, 8. Provenance: PROVEN offset and access direction; layer/channel replicas of documented registers are INFERRED from the identical function family; field meaning UNKNOWN. Unverified on hardware.";
        field {
            name = "word";
            desc = "32-bit word (layout UNKNOWN)";
            sw = rw; hw = r;
        } word[31:0];
    } VENDOR_A038 @ 0xA038;
    reg {
        name = "VENDOR_A03C";
        desc = "Vendor-seen VOU register at 0xA03C (hi3536dv100_vou.ko, arm-re path-sensitive scan 2026-11-12, base IO_13020000). Not in the data sheet table. Access RW by HAL_GRAPHIC_SetColorKeyMask. Cleared bit extents: 0xffffff; field LSBs seen: 0, 16, 8. Provenance: PROVEN offset and access direction; layer/channel replicas of documented registers are INFERRED from the identical function family; field meaning UNKNOWN. Unverified on hardware.";
        field {
            name = "word";
            desc = "32-bit word (layout UNKNOWN)";
            sw = rw; hw = r;
        } word[31:0];
    } VENDOR_A03C @ 0xA03C;
    reg {
        name = "VENDOR_A070";
        desc = "Vendor-seen VOU register at 0xA070 (hi3536dv100_vou.ko, arm-re path-sensitive scan 2026-11-12, base IO_13020000). Not in the data sheet table. Access R by HAL_GFX_WBC_GetDcmpState. Cleared bit extents: none; field LSBs seen: none. Provenance: PROVEN offset and access direction; layer/channel replicas of documented registers are INFERRED from the identical function family; field meaning UNKNOWN. Unverified on hardware.";
        field {
            name = "word";
            desc = "32-bit word (layout UNKNOWN)";
            sw = r; hw = w;
        } word[31:0];
    } VENDOR_A070 @ 0xA070;
    reg {
        name = "VENDOR_A080";
        desc = "Vendor-seen VOU register at 0xA080 (hi3536dv100_vou.ko, arm-re path-sensitive scan 2026-11-12, base IO_13020000). Not in the data sheet table. Access RW by HAL_GFX_WBC_SetWbcGlbInfo, HAL_VIDEO_SetLayerDispRect. Cleared bit extents: 0xffffff; field LSBs seen: 0, 12. Provenance: PROVEN offset and access direction; layer/channel replicas of documented registers are INFERRED from the identical function family; field meaning UNKNOWN. Unverified on hardware.";
        field {
            name = "word";
            desc = "32-bit word (layout UNKNOWN)";
            sw = rw; hw = r;
        } word[31:0];
    } VENDOR_A080 @ 0xA080;
    reg {
        name = "VENDOR_A084";
        desc = "Vendor-seen VOU register at 0xA084 (hi3536dv100_vou.ko, arm-re path-sensitive scan 2026-11-12, base IO_13020000). Not in the data sheet table. Access RW by HAL_GFX_WBC_SetWbcFrameSize, HAL_VIDEO_SetLayerDispRect. Cleared bit extents: 0x1fff1fff, 0xffffff; field LSBs seen: 0, 12, 16. Provenance: PROVEN offset and access direction; layer/channel replicas of documented registers are INFERRED from the identical function family; field meaning UNKNOWN. Unverified on hardware.";
        field {
            name = "word";
            desc = "32-bit word (layout UNKNOWN)";
            sw = rw; hw = r;
        } word[31:0];
    } VENDOR_A084 @ 0xA084;
    reg {
        name = "VENDOR_A088";
        desc = "Vendor-seen VOU register at 0xA088 (hi3536dv100_vou.ko, arm-re path-sensitive scan 2026-11-12, base IO_13020000). Not in the data sheet table. Access RW by HAL_GFX_WBC_SetWbcRcCfg0, HAL_VIDEO_SetLayerVideoRect. Cleared bit extents: 0x3ff03ff, 0xffffff; field LSBs seen: 0, 12, 16. Provenance: PROVEN offset and access direction; layer/channel replicas of documented registers are INFERRED from the identical function family; field meaning UNKNOWN. Unverified on hardware.";
        field {
            name = "word";
            desc = "32-bit word (layout UNKNOWN)";
            sw = rw; hw = r;
        } word[31:0];
    } VENDOR_A088 @ 0xA088;
    reg {
        name = "VENDOR_A08C";
        desc = "Vendor-seen VOU register at 0xA08C (hi3536dv100_vou.ko, arm-re path-sensitive scan 2026-11-12, base IO_13020000). Not in the data sheet table. Access RW by HAL_GFX_WBC_SetWbcRcCfg1, HAL_VIDEO_SetLayerVideoRect. Cleared bit extents: 0x3ff, 0xffffff; field LSBs seen: 0, 12. Provenance: PROVEN offset and access direction; layer/channel replicas of documented registers are INFERRED from the identical function family; field meaning UNKNOWN. Unverified on hardware.";
        field {
            name = "word";
            desc = "32-bit word (layout UNKNOWN)";
            sw = rw; hw = r;
        } word[31:0];
    } VENDOR_A08C @ 0xA08C;
    reg {
        name = "VENDOR_A090";
        desc = "Vendor-seen VOU register at 0xA090 (hi3536dv100_vou.ko, arm-re path-sensitive scan 2026-11-12, base IO_13020000). Not in the data sheet table. Access RW by HAL_GFX_WBC_SetWbcRcCfg2. Cleared bit extents: 0xf070fff; field LSBs seen: 0, 16, 24, 4, 8. Provenance: PROVEN offset and access direction; layer/channel replicas of documented registers are INFERRED from the identical function family; field meaning UNKNOWN. Unverified on hardware.";
        field {
            name = "word";
            desc = "32-bit word (layout UNKNOWN)";
            sw = rw; hw = r;
        } word[31:0];
    } VENDOR_A090 @ 0xA090;
    reg {
        name = "VENDOR_A094";
        desc = "Vendor-seen VOU register at 0xA094 (hi3536dv100_vou.ko, arm-re path-sensitive scan 2026-11-12, base IO_13020000). Not in the data sheet table. Access RW by HAL_GFX_WBC_SetWbcRcCfg3. Cleared bit extents: 0x7f007f; field LSBs seen: 0, 16. Provenance: PROVEN offset and access direction; layer/channel replicas of documented registers are INFERRED from the identical function family; field meaning UNKNOWN. Unverified on hardware.";
        field {
            name = "word";
            desc = "32-bit word (layout UNKNOWN)";
            sw = rw; hw = r;
        } word[31:0];
    } VENDOR_A094 @ 0xA094;
    reg {
        name = "VENDOR_A098";
        desc = "Vendor-seen VOU register at 0xA098 (hi3536dv100_vou.ko, arm-re path-sensitive scan 2026-11-12, base IO_13020000). Not in the data sheet table. Access RW by HAL_GFX_WBC_SetWbcRcCfg4. Cleared bit extents: 0x3ff7f7f; field LSBs seen: 0, 16, 8. Provenance: PROVEN offset and access direction; layer/channel replicas of documented registers are INFERRED from the identical function family; field meaning UNKNOWN. Unverified on hardware.";
        field {
            name = "word";
            desc = "32-bit word (layout UNKNOWN)";
            sw = rw; hw = r;
        } word[31:0];
    } VENDOR_A098 @ 0xA098;
    reg {
        name = "VENDOR_A09C";
        desc = "Vendor-seen VOU register at 0xA09C (hi3536dv100_vou.ko, arm-re path-sensitive scan 2026-11-12, base IO_13020000). Not in the data sheet table. Access RW by HAL_GFX_WBC_SetWbcRcCfg5. Cleared bit extents: 0x3f3f3f3f; field LSBs seen: 0, 16, 24, 8. Provenance: PROVEN offset and access direction; layer/channel replicas of documented registers are INFERRED from the identical function family; field meaning UNKNOWN. Unverified on hardware.";
        field {
            name = "word";
            desc = "32-bit word (layout UNKNOWN)";
            sw = rw; hw = r;
        } word[31:0];
    } VENDOR_A09C @ 0xA09C;
    reg {
        name = "VENDOR_A0A0";
        desc = "Vendor-seen VOU register at 0xA0A0 (hi3536dv100_vou.ko, arm-re path-sensitive scan 2026-11-12, base IO_13020000). Not in the data sheet table. Access RW by HAL_GFX_WBC_SetWbcRcCfg6. Cleared bit extents: 0x1ff007f; field LSBs seen: 0, 16. Provenance: PROVEN offset and access direction; layer/channel replicas of documented registers are INFERRED from the identical function family; field meaning UNKNOWN. Unverified on hardware.";
        field {
            name = "word";
            desc = "32-bit word (layout UNKNOWN)";
            sw = rw; hw = r;
        } word[31:0];
    } VENDOR_A0A0 @ 0xA0A0;
    reg {
        name = "VENDOR_A0A4";
        desc = "Vendor-seen VOU register at 0xA0A4 (hi3536dv100_vou.ko, arm-re path-sensitive scan 2026-11-12, base IO_13020000). Not in the data sheet table. Access RW by HAL_GFX_WBC_SetWbcRcCfg7. Cleared bit extents: 0xff7f; field LSBs seen: 0, 8. Provenance: PROVEN offset and access direction; layer/channel replicas of documented registers are INFERRED from the identical function family; field meaning UNKNOWN. Unverified on hardware.";
        field {
            name = "word";
            desc = "32-bit word (layout UNKNOWN)";
            sw = rw; hw = r;
        } word[31:0];
    } VENDOR_A0A4 @ 0xA0A4;
    reg {
        name = "VENDOR_A0A8";
        desc = "Vendor-seen VOU register at 0xA0A8 (hi3536dv100_vou.ko, arm-re path-sensitive scan 2026-11-12, base IO_13020000). Not in the data sheet table. Access RW by HAL_GFX_WBC_SetWbcRcCfg8. Cleared bit extents: 0xffffffff; field LSBs seen: 0, 16, 24, 8. Provenance: PROVEN offset and access direction; layer/channel replicas of documented registers are INFERRED from the identical function family; field meaning UNKNOWN. Unverified on hardware.";
        field {
            name = "word";
            desc = "32-bit word (layout UNKNOWN)";
            sw = rw; hw = r;
        } word[31:0];
    } VENDOR_A0A8 @ 0xA0A8;
    reg {
        name = "VENDOR_A0AC";
        desc = "Vendor-seen VOU register at 0xA0AC (hi3536dv100_vou.ko, arm-re path-sensitive scan 2026-11-12, base IO_13020000). Not in the data sheet table. Access RW by HAL_GFX_WBC_SetWbcRcCfg9. Cleared bit extents: 0x3ff03ff; field LSBs seen: 0, 16. Provenance: PROVEN offset and access direction; layer/channel replicas of documented registers are INFERRED from the identical function family; field meaning UNKNOWN. Unverified on hardware.";
        field {
            name = "word";
            desc = "32-bit word (layout UNKNOWN)";
            sw = rw; hw = r;
        } word[31:0];
    } VENDOR_A0AC @ 0xA0AC;
    reg {
        name = "VENDOR_A0C0";
        desc = "Vendor-seen VOU register at 0xA0C0 (hi3536dv100_vou.ko, arm-re path-sensitive scan 2026-11-12, base IO_13020000). Not in the data sheet table. Access RW by HAL_LAYER_SetCscEn, HAL_LAYER_SetCscMode. Cleared bit extents: 0x400000, 0x7800000; field LSBs seen: 22. Provenance: PROVEN offset and access direction; layer/channel replicas of documented registers are INFERRED from the identical function family; field meaning UNKNOWN. Unverified on hardware.";
        field {
            name = "word";
            desc = "32-bit word (layout UNKNOWN)";
            sw = rw; hw = r;
        } word[31:0];
    } VENDOR_A0C0 @ 0xA0C0;
    reg {
        name = "VENDOR_A408";
        desc = "Vendor-seen VOU register at 0xA408 (hi3536dv100_vou.ko, arm-re path-sensitive scan 2026-11-12, base IO_13020000). Not in the data sheet table. Access RW by HAL_GFX_WBC_SetWbcEnable. Cleared bit extents: 0x80000000; field LSBs seen: 31. Provenance: PROVEN offset and access direction; layer/channel replicas of documented registers are INFERRED from the identical function family; field meaning UNKNOWN. Unverified on hardware.";
        field {
            name = "word";
            desc = "32-bit word (layout UNKNOWN)";
            sw = rw; hw = r;
        } word[31:0];
    } VENDOR_A408 @ 0xA408;
    reg {
        name = "VENDOR_AC04";
        desc = "Vendor-seen VOU register at 0xAC04 (hi3536dv100_vou.ko, arm-re path-sensitive scan 2026-11-12, base IO_13020000). Not in the data sheet table. Access RW by HAL_LAYER_SetRegUp. Cleared bit extents: none; field LSBs seen: none. Provenance: PROVEN offset and access direction; layer/channel replicas of documented registers are INFERRED from the identical function family; field meaning UNKNOWN. Unverified on hardware.";
        field {
            name = "word";
            desc = "32-bit word (layout UNKNOWN)";
            sw = rw; hw = r;
        } word[31:0];
    } VENDOR_AC04 @ 0xAC04;
    reg {
        name = "VENDOR_AEC0";
        desc = "Vendor-seen VOU register at 0xAEC0 (hi3536dv100_vou.ko, arm-re path-sensitive scan 2026-11-12, base IO_13020000). Not in the data sheet table. Access RW by HAL_LAYER_SetHorRatio, HAL_LAYER_SetZmeEnable, HAL_LAYER_SetZmeFirEnable, HAL_LAYER_SetZmeMscEnable. Cleared bit extents: 0x2000000, 0x4000000, 0x40000000; field LSBs seen: 0, 25, 26, 30, 31. Provenance: PROVEN offset and access direction; layer/channel replicas of documented registers are INFERRED from the identical function family; field meaning UNKNOWN. Unverified on hardware.";
        field {
            name = "word";
            desc = "32-bit word (layout UNKNOWN)";
            sw = rw; hw = r;
        } word[31:0];
    } VENDOR_AEC0 @ 0xAEC0;
    reg {
        name = "VENDOR_AED8";
        desc = "Vendor-seen VOU register at 0xAED8 (hi3536dv100_vou.ko, arm-re path-sensitive scan 2026-11-12, base IO_13020000). Not in the data sheet table. Access RW by HAL_LAYER_SetZmeEnable, HAL_LAYER_SetZmeFirEnable, HAL_LAYER_SetZmeMscEnable, HAL_LAYER_SetZmeVerType. Cleared bit extents: 0x1000000, 0x180000, 0x40000000; field LSBs seen: 19, 23, 24, 30, 31. Provenance: PROVEN offset and access direction; layer/channel replicas of documented registers are INFERRED from the identical function family; field meaning UNKNOWN. Unverified on hardware.";
        field {
            name = "word";
            desc = "32-bit word (layout UNKNOWN)";
            sw = rw; hw = r;
        } word[31:0];
    } VENDOR_AED8 @ 0xAED8;
    reg {
        name = "VENDOR_AEDC";
        desc = "Vendor-seen VOU register at 0xAEDC (hi3536dv100_vou.ko, arm-re path-sensitive scan 2026-11-12, base IO_13020000). Not in the data sheet table. Access RW by HAL_LAYER_SetVerRatio. Cleared bit extents: 0xffff; field LSBs seen: 0. Provenance: PROVEN offset and access direction; layer/channel replicas of documented registers are INFERRED from the identical function family; field meaning UNKNOWN. Unverified on hardware.";
        field {
            name = "word";
            desc = "32-bit word (layout UNKNOWN)";
            sw = rw; hw = r;
        } word[31:0];
    } VENDOR_AEDC @ 0xAEDC;
    reg {
        name = "VENDOR_B000";
        desc = "Vendor-seen VOU register at 0xB000 (hi3536dv100_vou.ko, arm-re path-sensitive scan 2026-11-12, base IO_13020000). Not in the data sheet table. Access RW by HAL_GFX_WBC_GetWbcEnState, HAL_GFX_WBC_SetWbcAutoStopEn, HAL_GFX_WBC_SetWbcDataFmt, HAL_GFX_WBC_SetWbcEnable. Cleared bit extents: 0x400, 0x80000000, 0xc000000; field LSBs seen: 10, 31. Provenance: PROVEN offset and access direction; layer/channel replicas of documented registers are INFERRED from the identical function family; field meaning UNKNOWN. Unverified on hardware.";
        field {
            name = "word";
            desc = "32-bit word (layout UNKNOWN)";
            sw = rw; hw = r;
        } word[31:0];
    } VENDOR_B000 @ 0xB000;
    reg {
        name = "VENDOR_B004";
        desc = "Vendor-seen VOU register at 0xB004 (hi3536dv100_vou.ko, arm-re path-sensitive scan 2026-11-12, base IO_13020000). Not in the data sheet table. Access RW by HAL_GFX_WBC_SetWbcRegUp. Cleared bit extents: none; field LSBs seen: none. Provenance: PROVEN offset and access direction; layer/channel replicas of documented registers are INFERRED from the identical function family; field meaning UNKNOWN. Unverified on hardware.";
        field {
            name = "word";
            desc = "32-bit word (layout UNKNOWN)";
            sw = rw; hw = r;
        } word[31:0];
    } VENDOR_B004 @ 0xB004;
    reg {
        name = "VENDOR_B008";
        desc = "Vendor-seen VOU register at 0xB008 (hi3536dv100_vou.ko, arm-re path-sensitive scan 2026-11-12, base IO_13020000). Not in the data sheet table. Access RW by HAL_GFX_WBC_SetWbcEnable. Cleared bit extents: 0x80000000; field LSBs seen: 31. Provenance: PROVEN offset and access direction; layer/channel replicas of documented registers are INFERRED from the identical function family; field meaning UNKNOWN. Unverified on hardware.";
        field {
            name = "word";
            desc = "32-bit word (layout UNKNOWN)";
            sw = rw; hw = r;
        } word[31:0];
    } VENDOR_B008 @ 0xB008;
    reg {
        name = "VENDOR_B010";
        desc = "Vendor-seen VOU register at 0xB010 (hi3536dv100_vou.ko, arm-re path-sensitive scan 2026-11-12, base IO_13020000). Not in the data sheet table. Access RW by HAL_GFX_WBC_SetWbcAddr. Cleared bit extents: none; field LSBs seen: 0. Provenance: PROVEN offset and access direction; layer/channel replicas of documented registers are INFERRED from the identical function family; field meaning UNKNOWN. Unverified on hardware.";
        field {
            name = "word";
            desc = "32-bit word (layout UNKNOWN)";
            sw = rw; hw = r;
        } word[31:0];
    } VENDOR_B010 @ 0xB010;
    reg {
        name = "VENDOR_B018";
        desc = "Vendor-seen VOU register at 0xB018 (hi3536dv100_vou.ko, arm-re path-sensitive scan 2026-11-12, base IO_13020000). Not in the data sheet table. Access RW by HAL_GFX_WBC_SetWbcStride. Cleared bit extents: 0xffff; field LSBs seen: 0. Provenance: PROVEN offset and access direction; layer/channel replicas of documented registers are INFERRED from the identical function family; field meaning UNKNOWN. Unverified on hardware.";
        field {
            name = "word";
            desc = "32-bit word (layout UNKNOWN)";
            sw = rw; hw = r;
        } word[31:0];
    } VENDOR_B018 @ 0xB018;
    reg {
        name = "VENDOR_B020";
        desc = "Vendor-seen VOU register at 0xB020 (hi3536dv100_vou.ko, arm-re path-sensitive scan 2026-11-12, base IO_13020000). Not in the data sheet table. Access RW by HAL_GFX_WBC_SetWbcOReso. Cleared bit extents: 0xffffff; field LSBs seen: 0, 12. Provenance: PROVEN offset and access direction; layer/channel replicas of documented registers are INFERRED from the identical function family; field meaning UNKNOWN. Unverified on hardware.";
        field {
            name = "word";
            desc = "32-bit word (layout UNKNOWN)";
            sw = rw; hw = r;
        } word[31:0];
    } VENDOR_B020 @ 0xB020;
    reg {
        name = "VENDOR_B024";
        desc = "Vendor-seen VOU register at 0xB024 (hi3536dv100_vou.ko, arm-re path-sensitive scan 2026-11-12, base IO_13020000). Not in the data sheet table. Access RW by HAL_GFX_WBC_SetWbcCrop. Cleared bit extents: 0xffffff; field LSBs seen: 0, 12. Provenance: PROVEN offset and access direction; layer/channel replicas of documented registers are INFERRED from the identical function family; field meaning UNKNOWN. Unverified on hardware.";
        field {
            name = "word";
            desc = "32-bit word (layout UNKNOWN)";
            sw = rw; hw = r;
        } word[31:0];
    } VENDOR_B024 @ 0xB024;
    reg {
        name = "VENDOR_B034";
        desc = "Vendor-seen VOU register at 0xB034 (hi3536dv100_vou.ko, arm-re path-sensitive scan 2026-11-12, base IO_13020000). Not in the data sheet table. Access R by HAL_GFX_WBC_GetWbcStrideState. Cleared bit extents: none; field LSBs seen: none. Provenance: PROVEN offset and access direction; layer/channel replicas of documented registers are INFERRED from the identical function family; field meaning UNKNOWN. Unverified on hardware.";
        field {
            name = "word";
            desc = "32-bit word (layout UNKNOWN)";
            sw = r; hw = w;
        } word[31:0];
    } VENDOR_B034 @ 0xB034;
    reg {
        name = "VENDOR_B038";
        desc = "Vendor-seen VOU register at 0xB038 (hi3536dv100_vou.ko, arm-re path-sensitive scan 2026-11-12, base IO_13020000). Not in the data sheet table. Access RW by HAL_GFX_WBC_GetWbcStrideState. Cleared bit extents: none; field LSBs seen: none. Provenance: PROVEN offset and access direction; layer/channel replicas of documented registers are INFERRED from the identical function family; field meaning UNKNOWN. Unverified on hardware.";
        field {
            name = "word";
            desc = "32-bit word (layout UNKNOWN)";
            sw = rw; hw = r;
        } word[31:0];
    } VENDOR_B038 @ 0xB038;
    reg {
        name = "VENDOR_B080";
        desc = "Vendor-seen VOU register at 0xB080 (hi3536dv100_vou.ko, arm-re path-sensitive scan 2026-11-12, base IO_13020000). Not in the data sheet table. Access RW by HAL_GFX_WBC_SetWbcGlbInfo. Cleared bit extents: none; field LSBs seen: 0. Provenance: PROVEN offset and access direction; layer/channel replicas of documented registers are INFERRED from the identical function family; field meaning UNKNOWN. Unverified on hardware.";
        field {
            name = "word";
            desc = "32-bit word (layout UNKNOWN)";
            sw = rw; hw = r;
        } word[31:0];
    } VENDOR_B080 @ 0xB080;
    reg {
        name = "VENDOR_B084";
        desc = "Vendor-seen VOU register at 0xB084 (hi3536dv100_vou.ko, arm-re path-sensitive scan 2026-11-12, base IO_13020000). Not in the data sheet table. Access RW by HAL_GFX_WBC_SetWbcFrameSize. Cleared bit extents: 0x1fff1fff; field LSBs seen: 0, 16. Provenance: PROVEN offset and access direction; layer/channel replicas of documented registers are INFERRED from the identical function family; field meaning UNKNOWN. Unverified on hardware.";
        field {
            name = "word";
            desc = "32-bit word (layout UNKNOWN)";
            sw = rw; hw = r;
        } word[31:0];
    } VENDOR_B084 @ 0xB084;
    reg {
        name = "VENDOR_B088";
        desc = "Vendor-seen VOU register at 0xB088 (hi3536dv100_vou.ko, arm-re path-sensitive scan 2026-11-12, base IO_13020000). Not in the data sheet table. Access RW by HAL_GFX_WBC_SetWbcRcCfg0. Cleared bit extents: 0x3ff03ff; field LSBs seen: 0, 16. Provenance: PROVEN offset and access direction; layer/channel replicas of documented registers are INFERRED from the identical function family; field meaning UNKNOWN. Unverified on hardware.";
        field {
            name = "word";
            desc = "32-bit word (layout UNKNOWN)";
            sw = rw; hw = r;
        } word[31:0];
    } VENDOR_B088 @ 0xB088;
    reg {
        name = "VENDOR_B08C";
        desc = "Vendor-seen VOU register at 0xB08C (hi3536dv100_vou.ko, arm-re path-sensitive scan 2026-11-12, base IO_13020000). Not in the data sheet table. Access RW by HAL_GFX_WBC_SetWbcRcCfg1. Cleared bit extents: 0x3ff; field LSBs seen: 0. Provenance: PROVEN offset and access direction; layer/channel replicas of documented registers are INFERRED from the identical function family; field meaning UNKNOWN. Unverified on hardware.";
        field {
            name = "word";
            desc = "32-bit word (layout UNKNOWN)";
            sw = rw; hw = r;
        } word[31:0];
    } VENDOR_B08C @ 0xB08C;
    reg {
        name = "VENDOR_B090";
        desc = "Vendor-seen VOU register at 0xB090 (hi3536dv100_vou.ko, arm-re path-sensitive scan 2026-11-12, base IO_13020000). Not in the data sheet table. Access RW by HAL_GFX_WBC_SetWbcRcCfg2. Cleared bit extents: 0xf070fff; field LSBs seen: 0, 16, 24, 4, 8. Provenance: PROVEN offset and access direction; layer/channel replicas of documented registers are INFERRED from the identical function family; field meaning UNKNOWN. Unverified on hardware.";
        field {
            name = "word";
            desc = "32-bit word (layout UNKNOWN)";
            sw = rw; hw = r;
        } word[31:0];
    } VENDOR_B090 @ 0xB090;
    reg {
        name = "VENDOR_B094";
        desc = "Vendor-seen VOU register at 0xB094 (hi3536dv100_vou.ko, arm-re path-sensitive scan 2026-11-12, base IO_13020000). Not in the data sheet table. Access RW by HAL_GFX_WBC_SetWbcRcCfg3. Cleared bit extents: 0x7f007f; field LSBs seen: 0, 16. Provenance: PROVEN offset and access direction; layer/channel replicas of documented registers are INFERRED from the identical function family; field meaning UNKNOWN. Unverified on hardware.";
        field {
            name = "word";
            desc = "32-bit word (layout UNKNOWN)";
            sw = rw; hw = r;
        } word[31:0];
    } VENDOR_B094 @ 0xB094;
    reg {
        name = "VENDOR_B098";
        desc = "Vendor-seen VOU register at 0xB098 (hi3536dv100_vou.ko, arm-re path-sensitive scan 2026-11-12, base IO_13020000). Not in the data sheet table. Access RW by HAL_GFX_WBC_SetWbcRcCfg4. Cleared bit extents: 0x3ff7f7f; field LSBs seen: 0, 16, 8. Provenance: PROVEN offset and access direction; layer/channel replicas of documented registers are INFERRED from the identical function family; field meaning UNKNOWN. Unverified on hardware.";
        field {
            name = "word";
            desc = "32-bit word (layout UNKNOWN)";
            sw = rw; hw = r;
        } word[31:0];
    } VENDOR_B098 @ 0xB098;
    reg {
        name = "VENDOR_B09C";
        desc = "Vendor-seen VOU register at 0xB09C (hi3536dv100_vou.ko, arm-re path-sensitive scan 2026-11-12, base IO_13020000). Not in the data sheet table. Access RW by HAL_GFX_WBC_SetWbcRcCfg5. Cleared bit extents: 0x3f3f3f3f; field LSBs seen: 0, 16, 24, 8. Provenance: PROVEN offset and access direction; layer/channel replicas of documented registers are INFERRED from the identical function family; field meaning UNKNOWN. Unverified on hardware.";
        field {
            name = "word";
            desc = "32-bit word (layout UNKNOWN)";
            sw = rw; hw = r;
        } word[31:0];
    } VENDOR_B09C @ 0xB09C;
    reg {
        name = "VENDOR_B0A0";
        desc = "Vendor-seen VOU register at 0xB0A0 (hi3536dv100_vou.ko, arm-re path-sensitive scan 2026-11-12, base IO_13020000). Not in the data sheet table. Access RW by HAL_GFX_WBC_SetWbcRcCfg6. Cleared bit extents: 0x1ff007f; field LSBs seen: 0, 16. Provenance: PROVEN offset and access direction; layer/channel replicas of documented registers are INFERRED from the identical function family; field meaning UNKNOWN. Unverified on hardware.";
        field {
            name = "word";
            desc = "32-bit word (layout UNKNOWN)";
            sw = rw; hw = r;
        } word[31:0];
    } VENDOR_B0A0 @ 0xB0A0;
    reg {
        name = "VENDOR_B0A4";
        desc = "Vendor-seen VOU register at 0xB0A4 (hi3536dv100_vou.ko, arm-re path-sensitive scan 2026-11-12, base IO_13020000). Not in the data sheet table. Access RW by HAL_GFX_WBC_SetWbcRcCfg7. Cleared bit extents: 0xff7f; field LSBs seen: 0, 8. Provenance: PROVEN offset and access direction; layer/channel replicas of documented registers are INFERRED from the identical function family; field meaning UNKNOWN. Unverified on hardware.";
        field {
            name = "word";
            desc = "32-bit word (layout UNKNOWN)";
            sw = rw; hw = r;
        } word[31:0];
    } VENDOR_B0A4 @ 0xB0A4;
    reg {
        name = "VENDOR_B0A8";
        desc = "Vendor-seen VOU register at 0xB0A8 (hi3536dv100_vou.ko, arm-re path-sensitive scan 2026-11-12, base IO_13020000). Not in the data sheet table. Access RW by HAL_GFX_WBC_SetWbcRcCfg8. Cleared bit extents: 0xffffffff; field LSBs seen: 0, 16, 24, 8. Provenance: PROVEN offset and access direction; layer/channel replicas of documented registers are INFERRED from the identical function family; field meaning UNKNOWN. Unverified on hardware.";
        field {
            name = "word";
            desc = "32-bit word (layout UNKNOWN)";
            sw = rw; hw = r;
        } word[31:0];
    } VENDOR_B0A8 @ 0xB0A8;
    reg {
        name = "VENDOR_B0AC";
        desc = "Vendor-seen VOU register at 0xB0AC (hi3536dv100_vou.ko, arm-re path-sensitive scan 2026-11-12, base IO_13020000). Not in the data sheet table. Access RW by HAL_GFX_WBC_SetWbcRcCfg9. Cleared bit extents: 0x3ff03ff; field LSBs seen: 0, 16. Provenance: PROVEN offset and access direction; layer/channel replicas of documented registers are INFERRED from the identical function family; field meaning UNKNOWN. Unverified on hardware.";
        field {
            name = "word";
            desc = "32-bit word (layout UNKNOWN)";
            sw = rw; hw = r;
        } word[31:0];
    } VENDOR_B0AC @ 0xB0AC;
    reg {
        name = "VENDOR_B600";
        desc = "Vendor-seen VOU register at 0xB600 (hi3536dv100_vou.ko, arm-re path-sensitive scan 2026-11-12, base IO_13020000). Not in the data sheet table. Access RW by HAL_CBM_SetCbmBkg. Cleared bit extents: 0x3fffffff; field LSBs seen: 0, 12, 2, 22. Provenance: PROVEN offset and access direction; layer/channel replicas of documented registers are INFERRED from the identical function family; field meaning UNKNOWN. Unverified on hardware.";
        field {
            name = "word";
            desc = "32-bit word (layout UNKNOWN)";
            sw = rw; hw = r;
        } word[31:0];
    } VENDOR_B600 @ 0xB600;
    reg {
        name = "VENDOR_B608";
        desc = "Vendor-seen VOU register at 0xB608 (hi3536dv100_vou.ko, arm-re path-sensitive scan 2026-11-12, base IO_13020000). Not in the data sheet table. Access RW by HAL_CBM_SetCbmMixerPrio. Cleared bit extents: 0xf, 0xf0, 0xf00; field LSBs seen: 0, 12, 4, 8. Provenance: PROVEN offset and access direction; layer/channel replicas of documented registers are INFERRED from the identical function family; field meaning UNKNOWN. Unverified on hardware.";
        field {
            name = "word";
            desc = "32-bit word (layout UNKNOWN)";
            sw = rw; hw = r;
        } word[31:0];
    } VENDOR_B608 @ 0xB608;
    reg {
        name = "VENDOR_BC04";
        desc = "Vendor-seen VOU register at 0xBC04 (hi3536dv100_vou.ko, arm-re path-sensitive scan 2026-11-12, base IO_13020000). Not in the data sheet table. Access RW by HAL_LAYER_SetRegUp. Cleared bit extents: none; field LSBs seen: none. Provenance: PROVEN offset and access direction; layer/channel replicas of documented registers are INFERRED from the identical function family; field meaning UNKNOWN. Unverified on hardware.";
        field {
            name = "word";
            desc = "32-bit word (layout UNKNOWN)";
            sw = rw; hw = r;
        } word[31:0];
    } VENDOR_BC04 @ 0xBC04;
    reg {
        name = "VENDOR_BEC0";
        desc = "Vendor-seen VOU register at 0xBEC0 (hi3536dv100_vou.ko, arm-re path-sensitive scan 2026-11-12, base IO_13020000). Not in the data sheet table. Access RW by HAL_LAYER_SetHorRatio, HAL_LAYER_SetZmeEnable, HAL_LAYER_SetZmeFirEnable, HAL_LAYER_SetZmeMscEnable. Cleared bit extents: 0x4000000, 0x80000000, 0xffffff; field LSBs seen: 0, 26, 31. Provenance: PROVEN offset and access direction; layer/channel replicas of documented registers are INFERRED from the identical function family; field meaning UNKNOWN. Unverified on hardware.";
        field {
            name = "word";
            desc = "32-bit word (layout UNKNOWN)";
            sw = rw; hw = r;
        } word[31:0];
    } VENDOR_BEC0 @ 0xBEC0;
    reg {
        name = "VENDOR_BED8";
        desc = "Vendor-seen VOU register at 0xBED8 (hi3536dv100_vou.ko, arm-re path-sensitive scan 2026-11-12, base IO_13020000). Not in the data sheet table. Access RW by HAL_LAYER_SetZmeVerType. Cleared bit extents: 0x180000; field LSBs seen: 19. Provenance: PROVEN offset and access direction; layer/channel replicas of documented registers are INFERRED from the identical function family; field meaning UNKNOWN. Unverified on hardware.";
        field {
            name = "word";
            desc = "32-bit word (layout UNKNOWN)";
            sw = rw; hw = r;
        } word[31:0];
    } VENDOR_BED8 @ 0xBED8;
    reg {
        name = "VENDOR_BEDC";
        desc = "Vendor-seen VOU register at 0xBEDC (hi3536dv100_vou.ko, arm-re path-sensitive scan 2026-11-12, base IO_13020000). Not in the data sheet table. Access RW by HAL_LAYER_SetVerRatio. Cleared bit extents: 0xffff; field LSBs seen: 0. Provenance: PROVEN offset and access direction; layer/channel replicas of documented registers are INFERRED from the identical function family; field meaning UNKNOWN. Unverified on hardware.";
        field {
            name = "word";
            desc = "32-bit word (layout UNKNOWN)";
            sw = rw; hw = r;
        } word[31:0];
    } VENDOR_BEDC @ 0xBEDC;
    reg {
        name = "VENDOR_C000";
        desc = "Vendor-seen VOU register at 0xC000 (hi3536dv100_vou.ko, arm-re path-sensitive scan 2026-11-12, base IO_13020000). Not in the data sheet table. Access RW by HAL_GFX_WBC_GetWbcEnState, HAL_GFX_WBC_SetWbcAutoStopEn, HAL_GFX_WBC_SetWbcDataFmt, HAL_GFX_WBC_SetWbcEnable. Cleared bit extents: 0x400, 0x80000000, 0xc000000; field LSBs seen: 10, 31. Provenance: PROVEN offset and access direction; layer/channel replicas of documented registers are INFERRED from the identical function family; field meaning UNKNOWN. Unverified on hardware.";
        field {
            name = "word";
            desc = "32-bit word (layout UNKNOWN)";
            sw = rw; hw = r;
        } word[31:0];
    } VENDOR_C000 @ 0xC000;
    reg {
        name = "VENDOR_C004";
        desc = "Vendor-seen VOU register at 0xC004 (hi3536dv100_vou.ko, arm-re path-sensitive scan 2026-11-12, base IO_13020000). Not in the data sheet table. Access RW by HAL_GFX_WBC_SetWbcRegUp. Cleared bit extents: none; field LSBs seen: none. Provenance: PROVEN offset and access direction; layer/channel replicas of documented registers are INFERRED from the identical function family; field meaning UNKNOWN. Unverified on hardware.";
        field {
            name = "word";
            desc = "32-bit word (layout UNKNOWN)";
            sw = rw; hw = r;
        } word[31:0];
    } VENDOR_C004 @ 0xC004;
    reg {
        name = "VENDOR_C008";
        desc = "Vendor-seen VOU register at 0xC008 (hi3536dv100_vou.ko, arm-re path-sensitive scan 2026-11-12, base IO_13020000). Not in the data sheet table. Access RW by HAL_GFX_WBC_SetWbcEnable. Cleared bit extents: 0x80000000; field LSBs seen: 31. Provenance: PROVEN offset and access direction; layer/channel replicas of documented registers are INFERRED from the identical function family; field meaning UNKNOWN. Unverified on hardware.";
        field {
            name = "word";
            desc = "32-bit word (layout UNKNOWN)";
            sw = rw; hw = r;
        } word[31:0];
    } VENDOR_C008 @ 0xC008;
    reg {
        name = "VENDOR_C010";
        desc = "Vendor-seen VOU register at 0xC010 (hi3536dv100_vou.ko, arm-re path-sensitive scan 2026-11-12, base IO_13020000). Not in the data sheet table. Access RW by HAL_GFX_WBC_SetWbcAddr. Cleared bit extents: none; field LSBs seen: 0. Provenance: PROVEN offset and access direction; layer/channel replicas of documented registers are INFERRED from the identical function family; field meaning UNKNOWN. Unverified on hardware.";
        field {
            name = "word";
            desc = "32-bit word (layout UNKNOWN)";
            sw = rw; hw = r;
        } word[31:0];
    } VENDOR_C010 @ 0xC010;
    reg {
        name = "VENDOR_C018";
        desc = "Vendor-seen VOU register at 0xC018 (hi3536dv100_vou.ko, arm-re path-sensitive scan 2026-11-12, base IO_13020000). Not in the data sheet table. Access RW by HAL_GFX_WBC_SetWbcStride. Cleared bit extents: 0xffff; field LSBs seen: 0. Provenance: PROVEN offset and access direction; layer/channel replicas of documented registers are INFERRED from the identical function family; field meaning UNKNOWN. Unverified on hardware.";
        field {
            name = "word";
            desc = "32-bit word (layout UNKNOWN)";
            sw = rw; hw = r;
        } word[31:0];
    } VENDOR_C018 @ 0xC018;
    reg {
        name = "VENDOR_C020";
        desc = "Vendor-seen VOU register at 0xC020 (hi3536dv100_vou.ko, arm-re path-sensitive scan 2026-11-12, base IO_13020000). Not in the data sheet table. Access RW by HAL_GFX_WBC_SetWbcOReso. Cleared bit extents: 0xffffff; field LSBs seen: 0, 12. Provenance: PROVEN offset and access direction; layer/channel replicas of documented registers are INFERRED from the identical function family; field meaning UNKNOWN. Unverified on hardware.";
        field {
            name = "word";
            desc = "32-bit word (layout UNKNOWN)";
            sw = rw; hw = r;
        } word[31:0];
    } VENDOR_C020 @ 0xC020;
    reg {
        name = "VENDOR_C024";
        desc = "Vendor-seen VOU register at 0xC024 (hi3536dv100_vou.ko, arm-re path-sensitive scan 2026-11-12, base IO_13020000). Not in the data sheet table. Access RW by HAL_GFX_WBC_SetWbcCrop. Cleared bit extents: 0xffffff; field LSBs seen: 0, 12. Provenance: PROVEN offset and access direction; layer/channel replicas of documented registers are INFERRED from the identical function family; field meaning UNKNOWN. Unverified on hardware.";
        field {
            name = "word";
            desc = "32-bit word (layout UNKNOWN)";
            sw = rw; hw = r;
        } word[31:0];
    } VENDOR_C024 @ 0xC024;
    reg {
        name = "VENDOR_C034";
        desc = "Vendor-seen VOU register at 0xC034 (hi3536dv100_vou.ko, arm-re path-sensitive scan 2026-11-12, base IO_13020000). Not in the data sheet table. Access R by HAL_GFX_WBC_GetWbcStrideState. Cleared bit extents: none; field LSBs seen: none. Provenance: PROVEN offset and access direction; layer/channel replicas of documented registers are INFERRED from the identical function family; field meaning UNKNOWN. Unverified on hardware.";
        field {
            name = "word";
            desc = "32-bit word (layout UNKNOWN)";
            sw = r; hw = w;
        } word[31:0];
    } VENDOR_C034 @ 0xC034;
    reg {
        name = "VENDOR_C038";
        desc = "Vendor-seen VOU register at 0xC038 (hi3536dv100_vou.ko, arm-re path-sensitive scan 2026-11-12, base IO_13020000). Not in the data sheet table. Access RW by HAL_GFX_WBC_GetWbcStrideState. Cleared bit extents: none; field LSBs seen: none. Provenance: PROVEN offset and access direction; layer/channel replicas of documented registers are INFERRED from the identical function family; field meaning UNKNOWN. Unverified on hardware.";
        field {
            name = "word";
            desc = "32-bit word (layout UNKNOWN)";
            sw = rw; hw = r;
        } word[31:0];
    } VENDOR_C038 @ 0xC038;
    reg {
        name = "VENDOR_C080";
        desc = "Vendor-seen VOU register at 0xC080 (hi3536dv100_vou.ko, arm-re path-sensitive scan 2026-11-12, base IO_13020000). Not in the data sheet table. Access RW by HAL_GFX_WBC_SetWbcGlbInfo. Cleared bit extents: none; field LSBs seen: 0. Provenance: PROVEN offset and access direction; layer/channel replicas of documented registers are INFERRED from the identical function family; field meaning UNKNOWN. Unverified on hardware.";
        field {
            name = "word";
            desc = "32-bit word (layout UNKNOWN)";
            sw = rw; hw = r;
        } word[31:0];
    } VENDOR_C080 @ 0xC080;
    reg {
        name = "VENDOR_C084";
        desc = "Vendor-seen VOU register at 0xC084 (hi3536dv100_vou.ko, arm-re path-sensitive scan 2026-11-12, base IO_13020000). Not in the data sheet table. Access RW by HAL_GFX_WBC_SetWbcFrameSize. Cleared bit extents: 0x1fff1fff; field LSBs seen: 0, 16. Provenance: PROVEN offset and access direction; layer/channel replicas of documented registers are INFERRED from the identical function family; field meaning UNKNOWN. Unverified on hardware.";
        field {
            name = "word";
            desc = "32-bit word (layout UNKNOWN)";
            sw = rw; hw = r;
        } word[31:0];
    } VENDOR_C084 @ 0xC084;
    reg {
        name = "VENDOR_C088";
        desc = "Vendor-seen VOU register at 0xC088 (hi3536dv100_vou.ko, arm-re path-sensitive scan 2026-11-12, base IO_13020000). Not in the data sheet table. Access RW by HAL_GFX_WBC_SetWbcRcCfg0. Cleared bit extents: 0x3ff03ff; field LSBs seen: 0, 16. Provenance: PROVEN offset and access direction; layer/channel replicas of documented registers are INFERRED from the identical function family; field meaning UNKNOWN. Unverified on hardware.";
        field {
            name = "word";
            desc = "32-bit word (layout UNKNOWN)";
            sw = rw; hw = r;
        } word[31:0];
    } VENDOR_C088 @ 0xC088;
    reg {
        name = "VENDOR_C08C";
        desc = "Vendor-seen VOU register at 0xC08C (hi3536dv100_vou.ko, arm-re path-sensitive scan 2026-11-12, base IO_13020000). Not in the data sheet table. Access RW by HAL_GFX_WBC_SetWbcRcCfg1. Cleared bit extents: 0x3ff; field LSBs seen: 0. Provenance: PROVEN offset and access direction; layer/channel replicas of documented registers are INFERRED from the identical function family; field meaning UNKNOWN. Unverified on hardware.";
        field {
            name = "word";
            desc = "32-bit word (layout UNKNOWN)";
            sw = rw; hw = r;
        } word[31:0];
    } VENDOR_C08C @ 0xC08C;
    reg {
        name = "VENDOR_C090";
        desc = "Vendor-seen VOU register at 0xC090 (hi3536dv100_vou.ko, arm-re path-sensitive scan 2026-11-12, base IO_13020000). Not in the data sheet table. Access RW by HAL_GFX_WBC_SetWbcRcCfg2. Cleared bit extents: 0xf070fff; field LSBs seen: 0, 16, 24, 4, 8. Provenance: PROVEN offset and access direction; layer/channel replicas of documented registers are INFERRED from the identical function family; field meaning UNKNOWN. Unverified on hardware.";
        field {
            name = "word";
            desc = "32-bit word (layout UNKNOWN)";
            sw = rw; hw = r;
        } word[31:0];
    } VENDOR_C090 @ 0xC090;
    reg {
        name = "VENDOR_C094";
        desc = "Vendor-seen VOU register at 0xC094 (hi3536dv100_vou.ko, arm-re path-sensitive scan 2026-11-12, base IO_13020000). Not in the data sheet table. Access RW by HAL_GFX_WBC_SetWbcRcCfg3. Cleared bit extents: 0x7f007f; field LSBs seen: 0, 16. Provenance: PROVEN offset and access direction; layer/channel replicas of documented registers are INFERRED from the identical function family; field meaning UNKNOWN. Unverified on hardware.";
        field {
            name = "word";
            desc = "32-bit word (layout UNKNOWN)";
            sw = rw; hw = r;
        } word[31:0];
    } VENDOR_C094 @ 0xC094;
    reg {
        name = "VENDOR_C098";
        desc = "Vendor-seen VOU register at 0xC098 (hi3536dv100_vou.ko, arm-re path-sensitive scan 2026-11-12, base IO_13020000). Not in the data sheet table. Access RW by HAL_GFX_WBC_SetWbcRcCfg4. Cleared bit extents: 0x3ff7f7f; field LSBs seen: 0, 16, 8. Provenance: PROVEN offset and access direction; layer/channel replicas of documented registers are INFERRED from the identical function family; field meaning UNKNOWN. Unverified on hardware.";
        field {
            name = "word";
            desc = "32-bit word (layout UNKNOWN)";
            sw = rw; hw = r;
        } word[31:0];
    } VENDOR_C098 @ 0xC098;
    reg {
        name = "VENDOR_C09C";
        desc = "Vendor-seen VOU register at 0xC09C (hi3536dv100_vou.ko, arm-re path-sensitive scan 2026-11-12, base IO_13020000). Not in the data sheet table. Access RW by HAL_GFX_WBC_SetWbcRcCfg5. Cleared bit extents: 0x3f3f3f3f; field LSBs seen: 0, 16, 24, 8. Provenance: PROVEN offset and access direction; layer/channel replicas of documented registers are INFERRED from the identical function family; field meaning UNKNOWN. Unverified on hardware.";
        field {
            name = "word";
            desc = "32-bit word (layout UNKNOWN)";
            sw = rw; hw = r;
        } word[31:0];
    } VENDOR_C09C @ 0xC09C;
    reg {
        name = "VENDOR_C0A0";
        desc = "Vendor-seen VOU register at 0xC0A0 (hi3536dv100_vou.ko, arm-re path-sensitive scan 2026-11-12, base IO_13020000). Not in the data sheet table. Access RW by HAL_GFX_WBC_SetWbcRcCfg6. Cleared bit extents: 0x1ff007f; field LSBs seen: 0, 16. Provenance: PROVEN offset and access direction; layer/channel replicas of documented registers are INFERRED from the identical function family; field meaning UNKNOWN. Unverified on hardware.";
        field {
            name = "word";
            desc = "32-bit word (layout UNKNOWN)";
            sw = rw; hw = r;
        } word[31:0];
    } VENDOR_C0A0 @ 0xC0A0;
    reg {
        name = "VENDOR_C0A4";
        desc = "Vendor-seen VOU register at 0xC0A4 (hi3536dv100_vou.ko, arm-re path-sensitive scan 2026-11-12, base IO_13020000). Not in the data sheet table. Access RW by HAL_GFX_WBC_SetWbcRcCfg7. Cleared bit extents: 0xff7f; field LSBs seen: 0, 8. Provenance: PROVEN offset and access direction; layer/channel replicas of documented registers are INFERRED from the identical function family; field meaning UNKNOWN. Unverified on hardware.";
        field {
            name = "word";
            desc = "32-bit word (layout UNKNOWN)";
            sw = rw; hw = r;
        } word[31:0];
    } VENDOR_C0A4 @ 0xC0A4;
    reg {
        name = "VENDOR_C0A8";
        desc = "Vendor-seen VOU register at 0xC0A8 (hi3536dv100_vou.ko, arm-re path-sensitive scan 2026-11-12, base IO_13020000). Not in the data sheet table. Access RW by HAL_GFX_WBC_SetWbcRcCfg8. Cleared bit extents: 0xffffffff; field LSBs seen: 0, 16, 24, 8. Provenance: PROVEN offset and access direction; layer/channel replicas of documented registers are INFERRED from the identical function family; field meaning UNKNOWN. Unverified on hardware.";
        field {
            name = "word";
            desc = "32-bit word (layout UNKNOWN)";
            sw = rw; hw = r;
        } word[31:0];
    } VENDOR_C0A8 @ 0xC0A8;
    reg {
        name = "VENDOR_C0AC";
        desc = "Vendor-seen VOU register at 0xC0AC (hi3536dv100_vou.ko, arm-re path-sensitive scan 2026-11-12, base IO_13020000). Not in the data sheet table. Access RW by HAL_GFX_WBC_SetWbcRcCfg9. Cleared bit extents: 0x3ff03ff; field LSBs seen: 0, 16. Provenance: PROVEN offset and access direction; layer/channel replicas of documented registers are INFERRED from the identical function family; field meaning UNKNOWN. Unverified on hardware.";
        field {
            name = "word";
            desc = "32-bit word (layout UNKNOWN)";
            sw = rw; hw = r;
        } word[31:0];
    } VENDOR_C0AC @ 0xC0AC;
    reg {
        name = "VENDOR_CC04";
        desc = "Vendor-seen VOU register at 0xCC04 (hi3536dv100_vou.ko, arm-re path-sensitive scan 2026-11-12, base IO_13020000). Not in the data sheet table. Access RW by HAL_LAYER_SetRegUp. Cleared bit extents: none; field LSBs seen: none. Provenance: PROVEN offset and access direction; layer/channel replicas of documented registers are INFERRED from the identical function family; field meaning UNKNOWN. Unverified on hardware.";
        field {
            name = "word";
            desc = "32-bit word (layout UNKNOWN)";
            sw = rw; hw = r;
        } word[31:0];
    } VENDOR_CC04 @ 0xCC04;
    reg {
        name = "VENDOR_CEC0";
        desc = "Vendor-seen VOU register at 0xCEC0 (hi3536dv100_vou.ko, arm-re path-sensitive scan 2026-11-12, base IO_13020000). Not in the data sheet table. Access RW by HAL_LAYER_SetHorRatio, HAL_LAYER_SetZmeEnable, HAL_LAYER_SetZmeFirEnable, HAL_LAYER_SetZmeMscEnable. Cleared bit extents: 0x4000000, 0x80000000, 0xffffff; field LSBs seen: 0, 26, 31. Provenance: PROVEN offset and access direction; layer/channel replicas of documented registers are INFERRED from the identical function family; field meaning UNKNOWN. Unverified on hardware.";
        field {
            name = "word";
            desc = "32-bit word (layout UNKNOWN)";
            sw = rw; hw = r;
        } word[31:0];
    } VENDOR_CEC0 @ 0xCEC0;
    reg {
        name = "VENDOR_CED8";
        desc = "Vendor-seen VOU register at 0xCED8 (hi3536dv100_vou.ko, arm-re path-sensitive scan 2026-11-12, base IO_13020000). Not in the data sheet table. Access RW by HAL_LAYER_SetZmeVerType. Cleared bit extents: 0x180000; field LSBs seen: 19. Provenance: PROVEN offset and access direction; layer/channel replicas of documented registers are INFERRED from the identical function family; field meaning UNKNOWN. Unverified on hardware.";
        field {
            name = "word";
            desc = "32-bit word (layout UNKNOWN)";
            sw = rw; hw = r;
        } word[31:0];
    } VENDOR_CED8 @ 0xCED8;
    reg {
        name = "VENDOR_CEDC";
        desc = "Vendor-seen VOU register at 0xCEDC (hi3536dv100_vou.ko, arm-re path-sensitive scan 2026-11-12, base IO_13020000). Not in the data sheet table. Access RW by HAL_LAYER_SetVerRatio. Cleared bit extents: 0xffff; field LSBs seen: 0. Provenance: PROVEN offset and access direction; layer/channel replicas of documented registers are INFERRED from the identical function family; field meaning UNKNOWN. Unverified on hardware.";
        field {
            name = "word";
            desc = "32-bit word (layout UNKNOWN)";
            sw = rw; hw = r;
        } word[31:0];
    } VENDOR_CEDC @ 0xCEDC;
    reg {
        name = "VENDOR_D004";
        desc = "Vendor-seen VOU register at 0xD004 (hi3536dv100_vou.ko, arm-re path-sensitive scan 2026-11-12, base IO_13020000). Not in the data sheet table. Access RW by HAL_GFX_WBC_SetWbcRegUp. Cleared bit extents: none; field LSBs seen: none. Provenance: PROVEN offset and access direction; layer/channel replicas of documented registers are INFERRED from the identical function family; field meaning UNKNOWN. Unverified on hardware.";
        field {
            name = "word";
            desc = "32-bit word (layout UNKNOWN)";
            sw = rw; hw = r;
        } word[31:0];
    } VENDOR_D004 @ 0xD004;
    reg {
        name = "VENDOR_D018";
        desc = "Vendor-seen VOU register at 0xD018 (hi3536dv100_vou.ko, arm-re path-sensitive scan 2026-11-12, base IO_13020000). Not in the data sheet table. Access RW by HAL_GFX_WBC_SetWbcStride. Cleared bit extents: 0xffff; field LSBs seen: 0. Provenance: PROVEN offset and access direction; layer/channel replicas of documented registers are INFERRED from the identical function family; field meaning UNKNOWN. Unverified on hardware.";
        field {
            name = "word";
            desc = "32-bit word (layout UNKNOWN)";
            sw = rw; hw = r;
        } word[31:0];
    } VENDOR_D018 @ 0xD018;
    reg {
        name = "VENDOR_D080";
        desc = "Vendor-seen VOU register at 0xD080 (hi3536dv100_vou.ko, arm-re path-sensitive scan 2026-11-12, base IO_13020000). Not in the data sheet table. Access RW by HAL_GFX_WBC_SetWbcGlbInfo. Cleared bit extents: none; field LSBs seen: 0. Provenance: PROVEN offset and access direction; layer/channel replicas of documented registers are INFERRED from the identical function family; field meaning UNKNOWN. Unverified on hardware.";
        field {
            name = "word";
            desc = "32-bit word (layout UNKNOWN)";
            sw = rw; hw = r;
        } word[31:0];
    } VENDOR_D080 @ 0xD080;
    reg {
        name = "VENDOR_D084";
        desc = "Vendor-seen VOU register at 0xD084 (hi3536dv100_vou.ko, arm-re path-sensitive scan 2026-11-12, base IO_13020000). Not in the data sheet table. Access RW by HAL_GFX_WBC_SetWbcFrameSize. Cleared bit extents: 0x1fff1fff; field LSBs seen: 0, 16. Provenance: PROVEN offset and access direction; layer/channel replicas of documented registers are INFERRED from the identical function family; field meaning UNKNOWN. Unverified on hardware.";
        field {
            name = "word";
            desc = "32-bit word (layout UNKNOWN)";
            sw = rw; hw = r;
        } word[31:0];
    } VENDOR_D084 @ 0xD084;
    reg {
        name = "VENDOR_D088";
        desc = "Vendor-seen VOU register at 0xD088 (hi3536dv100_vou.ko, arm-re path-sensitive scan 2026-11-12, base IO_13020000). Not in the data sheet table. Access RW by HAL_GFX_WBC_SetWbcRcCfg0. Cleared bit extents: 0x3ff03ff; field LSBs seen: 0, 16. Provenance: PROVEN offset and access direction; layer/channel replicas of documented registers are INFERRED from the identical function family; field meaning UNKNOWN. Unverified on hardware.";
        field {
            name = "word";
            desc = "32-bit word (layout UNKNOWN)";
            sw = rw; hw = r;
        } word[31:0];
    } VENDOR_D088 @ 0xD088;
    reg {
        name = "VENDOR_D08C";
        desc = "Vendor-seen VOU register at 0xD08C (hi3536dv100_vou.ko, arm-re path-sensitive scan 2026-11-12, base IO_13020000). Not in the data sheet table. Access RW by HAL_GFX_WBC_SetWbcRcCfg1. Cleared bit extents: 0x3ff; field LSBs seen: 0. Provenance: PROVEN offset and access direction; layer/channel replicas of documented registers are INFERRED from the identical function family; field meaning UNKNOWN. Unverified on hardware.";
        field {
            name = "word";
            desc = "32-bit word (layout UNKNOWN)";
            sw = rw; hw = r;
        } word[31:0];
    } VENDOR_D08C @ 0xD08C;
    reg {
        name = "VENDOR_D090";
        desc = "Vendor-seen VOU register at 0xD090 (hi3536dv100_vou.ko, arm-re path-sensitive scan 2026-11-12, base IO_13020000). Not in the data sheet table. Access RW by HAL_GFX_WBC_SetWbcRcCfg2. Cleared bit extents: 0xf070fff; field LSBs seen: 0, 16, 24, 4, 8. Provenance: PROVEN offset and access direction; layer/channel replicas of documented registers are INFERRED from the identical function family; field meaning UNKNOWN. Unverified on hardware.";
        field {
            name = "word";
            desc = "32-bit word (layout UNKNOWN)";
            sw = rw; hw = r;
        } word[31:0];
    } VENDOR_D090 @ 0xD090;
    reg {
        name = "VENDOR_D094";
        desc = "Vendor-seen VOU register at 0xD094 (hi3536dv100_vou.ko, arm-re path-sensitive scan 2026-11-12, base IO_13020000). Not in the data sheet table. Access RW by HAL_GFX_WBC_SetWbcRcCfg3. Cleared bit extents: 0x7f007f; field LSBs seen: 0, 16. Provenance: PROVEN offset and access direction; layer/channel replicas of documented registers are INFERRED from the identical function family; field meaning UNKNOWN. Unverified on hardware.";
        field {
            name = "word";
            desc = "32-bit word (layout UNKNOWN)";
            sw = rw; hw = r;
        } word[31:0];
    } VENDOR_D094 @ 0xD094;
    reg {
        name = "VENDOR_D098";
        desc = "Vendor-seen VOU register at 0xD098 (hi3536dv100_vou.ko, arm-re path-sensitive scan 2026-11-12, base IO_13020000). Not in the data sheet table. Access RW by HAL_GFX_WBC_SetWbcRcCfg4. Cleared bit extents: 0x3ff7f7f; field LSBs seen: 0, 16, 8. Provenance: PROVEN offset and access direction; layer/channel replicas of documented registers are INFERRED from the identical function family; field meaning UNKNOWN. Unverified on hardware.";
        field {
            name = "word";
            desc = "32-bit word (layout UNKNOWN)";
            sw = rw; hw = r;
        } word[31:0];
    } VENDOR_D098 @ 0xD098;
    reg {
        name = "VENDOR_D09C";
        desc = "Vendor-seen VOU register at 0xD09C (hi3536dv100_vou.ko, arm-re path-sensitive scan 2026-11-12, base IO_13020000). Not in the data sheet table. Access RW by HAL_GFX_WBC_SetWbcRcCfg5. Cleared bit extents: 0x3f3f3f3f; field LSBs seen: 0, 16, 24, 8. Provenance: PROVEN offset and access direction; layer/channel replicas of documented registers are INFERRED from the identical function family; field meaning UNKNOWN. Unverified on hardware.";
        field {
            name = "word";
            desc = "32-bit word (layout UNKNOWN)";
            sw = rw; hw = r;
        } word[31:0];
    } VENDOR_D09C @ 0xD09C;
    reg {
        name = "VENDOR_D0A0";
        desc = "Vendor-seen VOU register at 0xD0A0 (hi3536dv100_vou.ko, arm-re path-sensitive scan 2026-11-12, base IO_13020000). Not in the data sheet table. Access RW by HAL_GFX_WBC_SetWbcRcCfg6. Cleared bit extents: 0x1ff007f; field LSBs seen: 0, 16. Provenance: PROVEN offset and access direction; layer/channel replicas of documented registers are INFERRED from the identical function family; field meaning UNKNOWN. Unverified on hardware.";
        field {
            name = "word";
            desc = "32-bit word (layout UNKNOWN)";
            sw = rw; hw = r;
        } word[31:0];
    } VENDOR_D0A0 @ 0xD0A0;
    reg {
        name = "VENDOR_D0A4";
        desc = "Vendor-seen VOU register at 0xD0A4 (hi3536dv100_vou.ko, arm-re path-sensitive scan 2026-11-12, base IO_13020000). Not in the data sheet table. Access RW by HAL_GFX_WBC_SetWbcRcCfg7. Cleared bit extents: 0xff7f; field LSBs seen: 0, 8. Provenance: PROVEN offset and access direction; layer/channel replicas of documented registers are INFERRED from the identical function family; field meaning UNKNOWN. Unverified on hardware.";
        field {
            name = "word";
            desc = "32-bit word (layout UNKNOWN)";
            sw = rw; hw = r;
        } word[31:0];
    } VENDOR_D0A4 @ 0xD0A4;
    reg {
        name = "VENDOR_D0A8";
        desc = "Vendor-seen VOU register at 0xD0A8 (hi3536dv100_vou.ko, arm-re path-sensitive scan 2026-11-12, base IO_13020000). Not in the data sheet table. Access RW by HAL_GFX_WBC_SetWbcRcCfg8. Cleared bit extents: 0xffffffff; field LSBs seen: 0, 16, 24, 8. Provenance: PROVEN offset and access direction; layer/channel replicas of documented registers are INFERRED from the identical function family; field meaning UNKNOWN. Unverified on hardware.";
        field {
            name = "word";
            desc = "32-bit word (layout UNKNOWN)";
            sw = rw; hw = r;
        } word[31:0];
    } VENDOR_D0A8 @ 0xD0A8;
    reg {
        name = "VENDOR_D0AC";
        desc = "Vendor-seen VOU register at 0xD0AC (hi3536dv100_vou.ko, arm-re path-sensitive scan 2026-11-12, base IO_13020000). Not in the data sheet table. Access RW by HAL_GFX_WBC_SetWbcRcCfg9. Cleared bit extents: 0x3ff03ff; field LSBs seen: 0, 16. Provenance: PROVEN offset and access direction; layer/channel replicas of documented registers are INFERRED from the identical function family; field meaning UNKNOWN. Unverified on hardware.";
        field {
            name = "word";
            desc = "32-bit word (layout UNKNOWN)";
            sw = rw; hw = r;
        } word[31:0];
    } VENDOR_D0AC @ 0xD0AC;
    reg {
        name = "VENDOR_DC04";
        desc = "Vendor-seen VOU register at 0xDC04 (hi3536dv100_vou.ko, arm-re path-sensitive scan 2026-11-12, base IO_13020000). Not in the data sheet table. Access RW by HAL_LAYER_SetRegUp. Cleared bit extents: none; field LSBs seen: none. Provenance: PROVEN offset and access direction; layer/channel replicas of documented registers are INFERRED from the identical function family; field meaning UNKNOWN. Unverified on hardware.";
        field {
            name = "word";
            desc = "32-bit word (layout UNKNOWN)";
            sw = rw; hw = r;
        } word[31:0];
    } VENDOR_DC04 @ 0xDC04;
    reg {
        name = "VENDOR_DEC0";
        desc = "Vendor-seen VOU register at 0xDEC0 (hi3536dv100_vou.ko, arm-re path-sensitive scan 2026-11-12, base IO_13020000). Not in the data sheet table. Access RW by HAL_LAYER_SetHorRatio, HAL_LAYER_SetZmeEnable, HAL_LAYER_SetZmeFirEnable, HAL_LAYER_SetZmeMscEnable. Cleared bit extents: 0x4000000, 0x80000000, 0xffffff; field LSBs seen: 0, 26, 31. Provenance: PROVEN offset and access direction; layer/channel replicas of documented registers are INFERRED from the identical function family; field meaning UNKNOWN. Unverified on hardware.";
        field {
            name = "word";
            desc = "32-bit word (layout UNKNOWN)";
            sw = rw; hw = r;
        } word[31:0];
    } VENDOR_DEC0 @ 0xDEC0;
    reg {
        name = "VENDOR_DED8";
        desc = "Vendor-seen VOU register at 0xDED8 (hi3536dv100_vou.ko, arm-re path-sensitive scan 2026-11-12, base IO_13020000). Not in the data sheet table. Access RW by HAL_LAYER_SetZmeVerType. Cleared bit extents: 0x180000; field LSBs seen: 19. Provenance: PROVEN offset and access direction; layer/channel replicas of documented registers are INFERRED from the identical function family; field meaning UNKNOWN. Unverified on hardware.";
        field {
            name = "word";
            desc = "32-bit word (layout UNKNOWN)";
            sw = rw; hw = r;
        } word[31:0];
    } VENDOR_DED8 @ 0xDED8;
    reg {
        name = "VENDOR_DEDC";
        desc = "Vendor-seen VOU register at 0xDEDC (hi3536dv100_vou.ko, arm-re path-sensitive scan 2026-11-12, base IO_13020000). Not in the data sheet table. Access RW by HAL_LAYER_SetVerRatio. Cleared bit extents: 0xffff; field LSBs seen: 0. Provenance: PROVEN offset and access direction; layer/channel replicas of documented registers are INFERRED from the identical function family; field meaning UNKNOWN. Unverified on hardware.";
        field {
            name = "word";
            desc = "32-bit word (layout UNKNOWN)";
            sw = rw; hw = r;
        } word[31:0];
    } VENDOR_DEDC @ 0xDEDC;
    reg {
        name = "VENDOR_E000";
        desc = "Vendor-seen VOU register at 0xE000 (hi3536dv100_vou.ko, arm-re path-sensitive scan 2026-11-12, base IO_13020000). Not in the data sheet table. Access RW by HAL_GFX_WBC_GetWbcEnState, HAL_GFX_WBC_SetWbcAutoStopEn, HAL_GFX_WBC_SetWbcDataFmt, HAL_GFX_WBC_SetWbcEnable. Cleared bit extents: 0x400, 0x80000000, 0xc000000; field LSBs seen: 10, 31. Provenance: PROVEN offset and access direction; layer/channel replicas of documented registers are INFERRED from the identical function family; field meaning UNKNOWN. Unverified on hardware.";
        field {
            name = "word";
            desc = "32-bit word (layout UNKNOWN)";
            sw = rw; hw = r;
        } word[31:0];
    } VENDOR_E000 @ 0xE000;
    reg {
        name = "VENDOR_E004";
        desc = "Vendor-seen VOU register at 0xE004 (hi3536dv100_vou.ko, arm-re path-sensitive scan 2026-11-12, base IO_13020000). Not in the data sheet table. Access RW by HAL_GFX_WBC_SetWbcRegUp. Cleared bit extents: none; field LSBs seen: none. Provenance: PROVEN offset and access direction; layer/channel replicas of documented registers are INFERRED from the identical function family; field meaning UNKNOWN. Unverified on hardware.";
        field {
            name = "word";
            desc = "32-bit word (layout UNKNOWN)";
            sw = rw; hw = r;
        } word[31:0];
    } VENDOR_E004 @ 0xE004;
    reg {
        name = "VENDOR_E008";
        desc = "Vendor-seen VOU register at 0xE008 (hi3536dv100_vou.ko, arm-re path-sensitive scan 2026-11-12, base IO_13020000). Not in the data sheet table. Access RW by HAL_GFX_WBC_SetWbcEnable. Cleared bit extents: 0x80000000; field LSBs seen: 31. Provenance: PROVEN offset and access direction; layer/channel replicas of documented registers are INFERRED from the identical function family; field meaning UNKNOWN. Unverified on hardware.";
        field {
            name = "word";
            desc = "32-bit word (layout UNKNOWN)";
            sw = rw; hw = r;
        } word[31:0];
    } VENDOR_E008 @ 0xE008;
    reg {
        name = "VENDOR_E010";
        desc = "Vendor-seen VOU register at 0xE010 (hi3536dv100_vou.ko, arm-re path-sensitive scan 2026-11-12, base IO_13020000). Not in the data sheet table. Access RW by HAL_GFX_WBC_SetWbcAddr. Cleared bit extents: none; field LSBs seen: 0. Provenance: PROVEN offset and access direction; layer/channel replicas of documented registers are INFERRED from the identical function family; field meaning UNKNOWN. Unverified on hardware.";
        field {
            name = "word";
            desc = "32-bit word (layout UNKNOWN)";
            sw = rw; hw = r;
        } word[31:0];
    } VENDOR_E010 @ 0xE010;
    reg {
        name = "VENDOR_E018";
        desc = "Vendor-seen VOU register at 0xE018 (hi3536dv100_vou.ko, arm-re path-sensitive scan 2026-11-12, base IO_13020000). Not in the data sheet table. Access RW by HAL_GFX_WBC_SetWbcStride. Cleared bit extents: 0xffff; field LSBs seen: 0. Provenance: PROVEN offset and access direction; layer/channel replicas of documented registers are INFERRED from the identical function family; field meaning UNKNOWN. Unverified on hardware.";
        field {
            name = "word";
            desc = "32-bit word (layout UNKNOWN)";
            sw = rw; hw = r;
        } word[31:0];
    } VENDOR_E018 @ 0xE018;
    reg {
        name = "VENDOR_E020";
        desc = "Vendor-seen VOU register at 0xE020 (hi3536dv100_vou.ko, arm-re path-sensitive scan 2026-11-12, base IO_13020000). Not in the data sheet table. Access RW by HAL_GFX_WBC_SetWbcOReso. Cleared bit extents: 0xffffff; field LSBs seen: 0, 12. Provenance: PROVEN offset and access direction; layer/channel replicas of documented registers are INFERRED from the identical function family; field meaning UNKNOWN. Unverified on hardware.";
        field {
            name = "word";
            desc = "32-bit word (layout UNKNOWN)";
            sw = rw; hw = r;
        } word[31:0];
    } VENDOR_E020 @ 0xE020;
    reg {
        name = "VENDOR_E024";
        desc = "Vendor-seen VOU register at 0xE024 (hi3536dv100_vou.ko, arm-re path-sensitive scan 2026-11-12, base IO_13020000). Not in the data sheet table. Access RW by HAL_GFX_WBC_SetWbcCrop. Cleared bit extents: 0xffffff; field LSBs seen: 0, 12. Provenance: PROVEN offset and access direction; layer/channel replicas of documented registers are INFERRED from the identical function family; field meaning UNKNOWN. Unverified on hardware.";
        field {
            name = "word";
            desc = "32-bit word (layout UNKNOWN)";
            sw = rw; hw = r;
        } word[31:0];
    } VENDOR_E024 @ 0xE024;
    reg {
        name = "VENDOR_E034";
        desc = "Vendor-seen VOU register at 0xE034 (hi3536dv100_vou.ko, arm-re path-sensitive scan 2026-11-12, base IO_13020000). Not in the data sheet table. Access R by HAL_GFX_WBC_GetWbcStrideState. Cleared bit extents: none; field LSBs seen: none. Provenance: PROVEN offset and access direction; layer/channel replicas of documented registers are INFERRED from the identical function family; field meaning UNKNOWN. Unverified on hardware.";
        field {
            name = "word";
            desc = "32-bit word (layout UNKNOWN)";
            sw = r; hw = w;
        } word[31:0];
    } VENDOR_E034 @ 0xE034;
    reg {
        name = "VENDOR_E038";
        desc = "Vendor-seen VOU register at 0xE038 (hi3536dv100_vou.ko, arm-re path-sensitive scan 2026-11-12, base IO_13020000). Not in the data sheet table. Access RW by HAL_GFX_WBC_GetWbcStrideState. Cleared bit extents: none; field LSBs seen: none. Provenance: PROVEN offset and access direction; layer/channel replicas of documented registers are INFERRED from the identical function family; field meaning UNKNOWN. Unverified on hardware.";
        field {
            name = "word";
            desc = "32-bit word (layout UNKNOWN)";
            sw = rw; hw = r;
        } word[31:0];
    } VENDOR_E038 @ 0xE038;
    reg {
        name = "VENDOR_E080";
        desc = "Vendor-seen VOU register at 0xE080 (hi3536dv100_vou.ko, arm-re path-sensitive scan 2026-11-12, base IO_13020000). Not in the data sheet table. Access RW by HAL_GFX_WBC_SetWbcGlbInfo. Cleared bit extents: none; field LSBs seen: 0. Provenance: PROVEN offset and access direction; layer/channel replicas of documented registers are INFERRED from the identical function family; field meaning UNKNOWN. Unverified on hardware.";
        field {
            name = "word";
            desc = "32-bit word (layout UNKNOWN)";
            sw = rw; hw = r;
        } word[31:0];
    } VENDOR_E080 @ 0xE080;
    reg {
        name = "VENDOR_E084";
        desc = "Vendor-seen VOU register at 0xE084 (hi3536dv100_vou.ko, arm-re path-sensitive scan 2026-11-12, base IO_13020000). Not in the data sheet table. Access RW by HAL_GFX_WBC_SetWbcFrameSize. Cleared bit extents: 0x1fff1fff; field LSBs seen: 0, 16. Provenance: PROVEN offset and access direction; layer/channel replicas of documented registers are INFERRED from the identical function family; field meaning UNKNOWN. Unverified on hardware.";
        field {
            name = "word";
            desc = "32-bit word (layout UNKNOWN)";
            sw = rw; hw = r;
        } word[31:0];
    } VENDOR_E084 @ 0xE084;
    reg {
        name = "VENDOR_E088";
        desc = "Vendor-seen VOU register at 0xE088 (hi3536dv100_vou.ko, arm-re path-sensitive scan 2026-11-12, base IO_13020000). Not in the data sheet table. Access RW by HAL_GFX_WBC_SetWbcRcCfg0. Cleared bit extents: 0x3ff03ff; field LSBs seen: 0, 16. Provenance: PROVEN offset and access direction; layer/channel replicas of documented registers are INFERRED from the identical function family; field meaning UNKNOWN. Unverified on hardware.";
        field {
            name = "word";
            desc = "32-bit word (layout UNKNOWN)";
            sw = rw; hw = r;
        } word[31:0];
    } VENDOR_E088 @ 0xE088;
    reg {
        name = "VENDOR_E08C";
        desc = "Vendor-seen VOU register at 0xE08C (hi3536dv100_vou.ko, arm-re path-sensitive scan 2026-11-12, base IO_13020000). Not in the data sheet table. Access RW by HAL_GFX_WBC_SetWbcRcCfg1. Cleared bit extents: 0x3ff; field LSBs seen: 0. Provenance: PROVEN offset and access direction; layer/channel replicas of documented registers are INFERRED from the identical function family; field meaning UNKNOWN. Unverified on hardware.";
        field {
            name = "word";
            desc = "32-bit word (layout UNKNOWN)";
            sw = rw; hw = r;
        } word[31:0];
    } VENDOR_E08C @ 0xE08C;
    reg {
        name = "VENDOR_E090";
        desc = "Vendor-seen VOU register at 0xE090 (hi3536dv100_vou.ko, arm-re path-sensitive scan 2026-11-12, base IO_13020000). Not in the data sheet table. Access RW by HAL_GFX_WBC_SetWbcRcCfg2. Cleared bit extents: 0xf070fff; field LSBs seen: 0, 16, 24, 4, 8. Provenance: PROVEN offset and access direction; layer/channel replicas of documented registers are INFERRED from the identical function family; field meaning UNKNOWN. Unverified on hardware.";
        field {
            name = "word";
            desc = "32-bit word (layout UNKNOWN)";
            sw = rw; hw = r;
        } word[31:0];
    } VENDOR_E090 @ 0xE090;
    reg {
        name = "VENDOR_E094";
        desc = "Vendor-seen VOU register at 0xE094 (hi3536dv100_vou.ko, arm-re path-sensitive scan 2026-11-12, base IO_13020000). Not in the data sheet table. Access RW by HAL_GFX_WBC_SetWbcRcCfg3. Cleared bit extents: 0x7f007f; field LSBs seen: 0, 16. Provenance: PROVEN offset and access direction; layer/channel replicas of documented registers are INFERRED from the identical function family; field meaning UNKNOWN. Unverified on hardware.";
        field {
            name = "word";
            desc = "32-bit word (layout UNKNOWN)";
            sw = rw; hw = r;
        } word[31:0];
    } VENDOR_E094 @ 0xE094;
    reg {
        name = "VENDOR_E098";
        desc = "Vendor-seen VOU register at 0xE098 (hi3536dv100_vou.ko, arm-re path-sensitive scan 2026-11-12, base IO_13020000). Not in the data sheet table. Access RW by HAL_GFX_WBC_SetWbcRcCfg4. Cleared bit extents: 0x3ff7f7f; field LSBs seen: 0, 16, 8. Provenance: PROVEN offset and access direction; layer/channel replicas of documented registers are INFERRED from the identical function family; field meaning UNKNOWN. Unverified on hardware.";
        field {
            name = "word";
            desc = "32-bit word (layout UNKNOWN)";
            sw = rw; hw = r;
        } word[31:0];
    } VENDOR_E098 @ 0xE098;
    reg {
        name = "VENDOR_E09C";
        desc = "Vendor-seen VOU register at 0xE09C (hi3536dv100_vou.ko, arm-re path-sensitive scan 2026-11-12, base IO_13020000). Not in the data sheet table. Access RW by HAL_GFX_WBC_SetWbcRcCfg5. Cleared bit extents: 0x3f3f3f3f; field LSBs seen: 0, 16, 24, 8. Provenance: PROVEN offset and access direction; layer/channel replicas of documented registers are INFERRED from the identical function family; field meaning UNKNOWN. Unverified on hardware.";
        field {
            name = "word";
            desc = "32-bit word (layout UNKNOWN)";
            sw = rw; hw = r;
        } word[31:0];
    } VENDOR_E09C @ 0xE09C;
    reg {
        name = "VENDOR_E0A0";
        desc = "Vendor-seen VOU register at 0xE0A0 (hi3536dv100_vou.ko, arm-re path-sensitive scan 2026-11-12, base IO_13020000). Not in the data sheet table. Access RW by HAL_GFX_WBC_SetWbcRcCfg6. Cleared bit extents: 0x1ff007f; field LSBs seen: 0, 16. Provenance: PROVEN offset and access direction; layer/channel replicas of documented registers are INFERRED from the identical function family; field meaning UNKNOWN. Unverified on hardware.";
        field {
            name = "word";
            desc = "32-bit word (layout UNKNOWN)";
            sw = rw; hw = r;
        } word[31:0];
    } VENDOR_E0A0 @ 0xE0A0;
    reg {
        name = "VENDOR_E0A4";
        desc = "Vendor-seen VOU register at 0xE0A4 (hi3536dv100_vou.ko, arm-re path-sensitive scan 2026-11-12, base IO_13020000). Not in the data sheet table. Access RW by HAL_GFX_WBC_SetWbcRcCfg7. Cleared bit extents: 0xff7f; field LSBs seen: 0, 8. Provenance: PROVEN offset and access direction; layer/channel replicas of documented registers are INFERRED from the identical function family; field meaning UNKNOWN. Unverified on hardware.";
        field {
            name = "word";
            desc = "32-bit word (layout UNKNOWN)";
            sw = rw; hw = r;
        } word[31:0];
    } VENDOR_E0A4 @ 0xE0A4;
    reg {
        name = "VENDOR_E0A8";
        desc = "Vendor-seen VOU register at 0xE0A8 (hi3536dv100_vou.ko, arm-re path-sensitive scan 2026-11-12, base IO_13020000). Not in the data sheet table. Access RW by HAL_GFX_WBC_SetWbcRcCfg8. Cleared bit extents: 0xffffffff; field LSBs seen: 0, 16, 24, 8. Provenance: PROVEN offset and access direction; layer/channel replicas of documented registers are INFERRED from the identical function family; field meaning UNKNOWN. Unverified on hardware.";
        field {
            name = "word";
            desc = "32-bit word (layout UNKNOWN)";
            sw = rw; hw = r;
        } word[31:0];
    } VENDOR_E0A8 @ 0xE0A8;
    reg {
        name = "VENDOR_E0AC";
        desc = "Vendor-seen VOU register at 0xE0AC (hi3536dv100_vou.ko, arm-re path-sensitive scan 2026-11-12, base IO_13020000). Not in the data sheet table. Access RW by HAL_GFX_WBC_SetWbcRcCfg9. Cleared bit extents: 0x3ff03ff; field LSBs seen: 0, 16. Provenance: PROVEN offset and access direction; layer/channel replicas of documented registers are INFERRED from the identical function family; field meaning UNKNOWN. Unverified on hardware.";
        field {
            name = "word";
            desc = "32-bit word (layout UNKNOWN)";
            sw = rw; hw = r;
        } word[31:0];
    } VENDOR_E0AC @ 0xE0AC;
    reg {
        name = "VENDOR_EC04";
        desc = "Vendor-seen VOU register at 0xEC04 (hi3536dv100_vou.ko, arm-re path-sensitive scan 2026-11-12, base IO_13020000). Not in the data sheet table. Access RW by HAL_LAYER_SetRegUp. Cleared bit extents: none; field LSBs seen: none. Provenance: PROVEN offset and access direction; layer/channel replicas of documented registers are INFERRED from the identical function family; field meaning UNKNOWN. Unverified on hardware.";
        field {
            name = "word";
            desc = "32-bit word (layout UNKNOWN)";
            sw = rw; hw = r;
        } word[31:0];
    } VENDOR_EC04 @ 0xEC04;
    reg {
        name = "VENDOR_EEC0";
        desc = "Vendor-seen VOU register at 0xEEC0 (hi3536dv100_vou.ko, arm-re path-sensitive scan 2026-11-12, base IO_13020000). Not in the data sheet table. Access RW by HAL_LAYER_SetHorRatio, HAL_LAYER_SetZmeEnable, HAL_LAYER_SetZmeFirEnable, HAL_LAYER_SetZmeMscEnable. Cleared bit extents: 0x4000000, 0x80000000, 0xffffff; field LSBs seen: 0, 26, 31. Provenance: PROVEN offset and access direction; layer/channel replicas of documented registers are INFERRED from the identical function family; field meaning UNKNOWN. Unverified on hardware.";
        field {
            name = "word";
            desc = "32-bit word (layout UNKNOWN)";
            sw = rw; hw = r;
        } word[31:0];
    } VENDOR_EEC0 @ 0xEEC0;
    reg {
        name = "VENDOR_EED8";
        desc = "Vendor-seen VOU register at 0xEED8 (hi3536dv100_vou.ko, arm-re path-sensitive scan 2026-11-12, base IO_13020000). Not in the data sheet table. Access RW by HAL_LAYER_SetZmeVerType. Cleared bit extents: 0x180000; field LSBs seen: 19. Provenance: PROVEN offset and access direction; layer/channel replicas of documented registers are INFERRED from the identical function family; field meaning UNKNOWN. Unverified on hardware.";
        field {
            name = "word";
            desc = "32-bit word (layout UNKNOWN)";
            sw = rw; hw = r;
        } word[31:0];
    } VENDOR_EED8 @ 0xEED8;
    reg {
        name = "VENDOR_EEDC";
        desc = "Vendor-seen VOU register at 0xEEDC (hi3536dv100_vou.ko, arm-re path-sensitive scan 2026-11-12, base IO_13020000). Not in the data sheet table. Access RW by HAL_LAYER_SetVerRatio. Cleared bit extents: 0xffff; field LSBs seen: 0. Provenance: PROVEN offset and access direction; layer/channel replicas of documented registers are INFERRED from the identical function family; field meaning UNKNOWN. Unverified on hardware.";
        field {
            name = "word";
            desc = "32-bit word (layout UNKNOWN)";
            sw = rw; hw = r;
        } word[31:0];
    } VENDOR_EEDC @ 0xEEDC;
    reg {
        name = "VENDOR_F2C0";
        desc = "Vendor-seen VOU register at 0xF2C0 (hi3536dv100_vou.ko, arm-re path-sensitive scan 2026-11-12, base IO_13020000). Not in the data sheet table. Access RW by HAL_DISP_DATE_Enable_VDACDetect. Cleared bit extents: 0x3ff03ff; field LSBs seen: 16. Provenance: PROVEN offset and access direction; layer/channel replicas of documented registers are INFERRED from the identical function family; field meaning UNKNOWN. Unverified on hardware.";
        field {
            name = "word";
            desc = "32-bit word (layout UNKNOWN)";
            sw = rw; hw = r;
        } word[31:0];
    } VENDOR_F2C0 @ 0xF2C0;
    reg {
        name = "VENDOR_F2C4";
        desc = "Vendor-seen VOU register at 0xF2C4 (hi3536dv100_vou.ko, arm-re path-sensitive scan 2026-11-12, base IO_13020000). Not in the data sheet table. Access RW by HAL_DISP_DATE_Enable_VDACDetect. Cleared bit extents: 0x7ff, 0x800007ff; field LSBs seen: 0, 31. Provenance: PROVEN offset and access direction; layer/channel replicas of documented registers are INFERRED from the identical function family; field meaning UNKNOWN. Unverified on hardware.";
        field {
            name = "word";
            desc = "32-bit word (layout UNKNOWN)";
            sw = rw; hw = r;
        } word[31:0];
    } VENDOR_F2C4 @ 0xF2C4;
};
`endif
