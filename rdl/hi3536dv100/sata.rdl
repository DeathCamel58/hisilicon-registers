`ifndef HI3536D_SATA_RDL
`define HI3536D_SATA_RDL

regfile eHI3536D_SATA {
    name = "SATA AHCI 1.3 controller (one port), Hi3536D V100";
    desc = "AHCI 1.3 SATA host controller of the Hi3536D V100 at 0x10030000 (GIC SPI 17 = interrupt bit 49), one port (port 0, +0x100). 31 registers extracted programmatically from the Hi3536D V100 data sheet (Issue 00B04, 2017-12-13, Tables 11-16 and 11-17 and chapter 11.5.7); field names, bit ranges, access types and reset values are from the register tables (PROVEN: data sheet); free-text descriptions can be shifted by one field where a sentence wraps. This is a separate DV100 variant: relative to the shared eHISI_AHCI_SATA (Hi3520D) it has AHCI version 1.3 (VS reset 0x10300), different CAP1 reset (0x6F377FA0), PI reset 0xF (data sheet value, one port), PHY_CTL0/PHY_CTL1/OOB_CTL at 0xA0/0xA4/0xB8 (the Hi3520D has them at 0x54/0x58/0x6C), and port registers FBS 0x140, FIFOTH 0x144, PHYCTL1 0x148 (tx margin/deemphasis for Gen1-3), PHYCTL 0x174, PHYSTS 0x178 and OUTSTANDING 0x17C. Clock/reset: PERI_CRG44/45 (0xB0/0xB4), PHY clock select in MISC. Unofficial copy of the SDK documentation: facts only. Hardware not verified.";
    reg {
        name = "SATA_GHC_CAP1";
        desc = "SATA_GHC_CAP1 is feature support register 1. (offset 0x0, total reset 0x6F377FA0; PROVEN: Hi3536D V100 data sheet).";
        field {
            name = "s64a";
            desc = "Fixed at 0, indicating that the 64-bit data structure cannot be accessed.";
            sw = r; hw = w;
            reset = 0x0;
        } s64a[31:31];
        field {
            name = "sncq";
            desc = "Fixed at 1, indicating that NCQ is supported.";
            sw = r; hw = w;
            reset = 0x1;
        } sncq[30:30];
        field {
            name = "ssntf";
            desc = "Fixed at 1, indicating that the port SNTF register is supported.";
            sw = r; hw = w;
            reset = 0x1;
        } ssntf[29:29];
        field {
            name = "smps";
            desc = "Fixed at 0, indicating that mechanical hot-plugging is not supported.";
            sw = r; hw = w;
            reset = 0x0;
        } smps[28:28];
        field {
            name = "sss";
            desc = "Fixed at 1, indicating that staggered spin-up is supported.";
            sw = r; hw = w;
            reset = 0x1;
        } sss[27:27];
        field {
            name = "salp";
            desc = "Fixed at 1, indicating that power supply management is supported.";
            sw = r; hw = w;
            reset = 0x1;
        } salp[26:26];
        field {
            name = "sal";
            desc = "Fixed at 1, indicating that the LED pin is supported.";
            sw = r; hw = w;
            reset = 0x1;
        } sal[25:25];
        field {
            name = "sclo";
            desc = "Fixed at 1, indicating that command linked list override is supported.";
            sw = r; hw = w;
            reset = 0x1;
        } sclo[24:24];
        field {
            name = "reserved_23_19";
            desc = "Reserved";
            sw = r; hw = na;
            reset = 0x6;
        } reserved_23_19[23:19];
        field {
            name = "sam";
            desc = "Fixed at 1, indicating that only the AHCI mode is supported.";
            sw = r; hw = w;
            reset = 0x1;
        } sam[18:18];
        field {
            name = "spm";
            desc = "Fixed at 1, indicating that the port multiplier is supported.";
            sw = r; hw = w;
            reset = 0x1;
        } spm[17:17];
        field {
            name = "fbss";
            desc = "Fixed at 1, indicating that FIS-based switching is supported.";
            sw = r; hw = w;
            reset = 0x1;
        } fbss[16:16];
        field {
            name = "pmd";
            desc = "Fixed at 0, indicating that multiple DRQ blocks cannot be transferred in PIO mode.";
            sw = r; hw = w;
            reset = 0x0;
        } pmd[15:15];
        field {
            name = "ssc";
            desc = "Fixed at 1, indicating that the transition to the slumber status is supported.";
            sw = r; hw = w;
            reset = 0x1;
        } ssc[14:14];
        field {
            name = "psc";
            desc = "Fixed at 1, indicating that the transition to the partial status is supported.";
            sw = r; hw = w;
            reset = 0x1;
        } psc[13:13];
        field {
            name = "ncs";
            desc = "Fixed at 0x1F, indicating that 32 command slots are supported.";
            sw = r; hw = w;
            reset = 0x1f;
        } ncs[12:8];
        field {
            name = "cccs";
            desc = "Fixed at 1, indicating that the CCC function is supported.";
            sw = r; hw = w;
            reset = 0x1;
        } cccs[7:7];
        field {
            name = "ems";
            desc = "Fixed at 0, indicating that enclose management is not supported.";
            sw = r; hw = w;
            reset = 0x0;
        } ems[6:6];
        field {
            name = "sxs";
            desc = "Fixed at 1, indicating that the external SATA port is supported.";
            sw = r; hw = w;
            reset = 0x1;
        } sxs[5:5];
        field {
            name = "np";
            desc = "Fixed at 0x0, indicating that one SATA port is supported.";
            sw = r; hw = w;
            reset = 0x0;
        } np[4:0];
    } SATA_GHC_CAP1 @ 0x0;
    reg {
        name = "SATA_GHC_GHC";
        desc = "SATA_GHC_GHC is a global control register. (offset 0x4, total reset 0x80000000; PROVEN: Hi3536D V100 data sheet).";
        field {
            name = "ahci_en";
            desc = "Fixed at 1, indicating that the software can interact with the controller only through the AHCI mechanism.";
            sw = r; hw = w;
            reset = 0x1;
        } ahci_en[31:31];
        field {
            name = "reserved_30_2";
            desc = "Reserved";
            sw = r; hw = w;
            reset = 0x0;
        } reserved_30_2[30:2];
        field {
            name = "int_enable";
            desc = "Controller interrupt enable 0: disabled 1: enabled 0: not reset 1: reset";
            sw = rw; hw = r;
            reset = 0x0;
        } int_enable[1:1];
        field {
            name = "hba_rst";
            desc = "Soft reset control for the controller after reset; writing 0 has no effect. In addition, reset has no effect on the registers SATA_GHC_BOHC, SATA_PORT_FB, and Writing 1 resets the controller and this bit is automatically cleared SATA_PORT_CLB.";
            sw = rw; hw = r;
            reset = 0x0;
        } hba_rst[0:0];
    } SATA_GHC_GHC @ 0x4;
    reg {
        name = "SATA_GHC_IS";
        desc = "SATA_GHC_IS is an interrupt status register. (offset 0x8, total reset 0x00000000; PROVEN: Hi3536D V100 data sheet).";
        field {
            name = "ips_ccc";
            desc = "CCC interrupt status 0: No CCC interrupt is generated. 1: A CCC interrupt is generated.";
            sw = rw; hw = w; woclr;
            reset = 0x0;
        } ips_ccc[31:31];
        field {
            name = "reserved_30_3";
            desc = "Reserved";
            sw = r; hw = w;
            reset = 0x0;
        } reserved_30_3[30:3];
        field {
            name = "ips_port0";
            desc = "Interrupt status of port 0 0: No interrupt is reported. 1: An interrupt is reported.";
            sw = rw; hw = w; woclr;
            reset = 0x0;
        } ips_port0[0:0];
    } SATA_GHC_IS @ 0x8;
    reg {
        name = "SATA_GHC_PI";
        desc = "SATA_GHC_PI is a port implementation register. (offset 0xC, total reset 0x0000000F; PROVEN: Hi3536D V100 data sheet).";
        field {
            name = "reserved_31_1";
            desc = "Reserved";
            sw = r; hw = na;
            reset = 0x7;
        } reserved_31_1[31:1];
        field {
            name = "port_imp";
            desc = "Port validity indicator. 0: invalid 1: valid";
            sw = r; hw = w;
            reset = 0x1;
        } port_imp[0:0];
    } SATA_GHC_PI @ 0xC;
    reg {
        name = "SATA_GHC_VS";
        desc = "SATA_GHC_VS is an AHCI version identifier register. (offset 0x10, total reset 0x00010300; PROVEN: Hi3536D V100 data sheet).";
        field {
            name = "achi_vs";
            desc = "The supported AHCI version is V1.3.";
            sw = r; hw = w;
            reset = 0x10300;
        } achi_vs[31:0];
    } SATA_GHC_VS @ 0x10;
    reg {
        name = "SATA_GHC_CCC_CTL";
        desc = "SATA_GHC_CCC_CTL is a CCC control register. (offset 0x14, total reset 0x000101F8; PROVEN: Hi3536D V100 data sheet).";
        field {
            name = "ccc_tv";
            desc = "CCC timeout parameter, in the unit of ms When the CCC function is enabled, the timeout counter loads this parameter value. If a command is executed on a port involved in CCC counting, the counter decreases by 1 every 1 ms until a CCC interrupt is generated when the counter reaches 0. Then the counter reloads the parameter value for the next counting.";
            sw = rw; hw = r;
            reset = 0x1;
        } ccc_tv[31:16];
        field {
            name = "ccc_cc";
            desc = "Note that these bits cannot be set to 0s. CCC command completion upper limit When the CCC function is enabled, the counter is cleared after commands are executed. Then the counter starts to count the number of completed commands on the ports involved in CCC counting. If the count value is greater than or equal to the parameter value, a CCC interrupt is generated. In this case, the counter is clear";
            sw = rw; hw = r;
            reset = 0x1;
        } ccc_cc[15:8];
        field {
            name = "ccc_int";
            desc = "If the value 0 is written, the command completion interrupt is disabled and the CCC interrupt is generated only after timeout. CCC interrupt vector ID. If the value is 0x1F (31),";
            sw = r; hw = w;
            reset = 0x1f;
        } ccc_int[7:3];
        field {
            name = "reserved_2_1";
            desc = "SATA_GHC_IS[31] indicates the CCC interrupt status. Reserved 0: disabled";
            sw = r; hw = w;
            reset = 0x0;
        } reserved_2_1[2:1];
        field {
            name = "ccc_en";
            desc = "CCC function enable 1: enabled ccc_cc cannot be changed. When the CCC function is enabled, the values of ccc_tv and";
            sw = rw; hw = r;
            reset = 0x0;
        } ccc_en[0:0];
    } SATA_GHC_CCC_CTL @ 0x14;
    reg {
        name = "SATA_GHC_CCC_PORTS";
        desc = "SATA_GHC_CCC_PORTS is a CCC port enable register. (offset 0x18, total reset 0x00000000; PROVEN: Hi3536D V100 data sheet).";
        field {
            name = "reserved_31_1";
            desc = "Reserved the port participates in the CCC counting. If this bit is 0, the port";
            sw = r; hw = w;
            reset = 0x0;
        } reserved_31_1[31:1];
        field {
            name = "ccc_prt";
            desc = "Specifies the port that is involved in CCC counting. If this bit is 1, does not participate in the CCC counting. The value of this register can be changed at any time and the changed value takes effect immediately.";
            sw = rw; hw = r;
            reset = 0x0;
        } ccc_prt[0:0];
    } SATA_GHC_CCC_PORTS @ 0x18;
    reg {
        name = "SATA_GHC_CAP2";
        desc = "SATA_GHC_CAP2 (offset 0x24, total reset 0x00000001; PROVEN: Hi3536D V100 data sheet).";
        field {
            name = "reserved_31_1";
            desc = "Reserved";
            sw = r; hw = w;
            reset = 0x0;
        } reserved_31_1[31:1];
        field {
            name = "cap_boh";
            desc = "Fixed at 1, indicating that BIOS/OS handoff control is supported.";
            sw = r; hw = w;
            reset = 0x1;
        } cap_boh[0:0];
    } SATA_GHC_CAP2 @ 0x24;
    reg {
        name = "SATA_GHC_BOHC";
        desc = "SATA_GHC_BOHC is a BIOS/OS handoff control register. (offset 0x28, total reset 0x00000000; PROVEN: Hi3536D V100 data sheet).";
        field {
            name = "reserved_31_5";
            desc = "Reserved 0: The BIOS is not busy.";
            sw = r; hw = w;
            reset = 0x0;
        } reserved_31_5[31:5];
        field {
            name = "bohc_bb";
            desc = "BIOS status indicator 1: The BIOS is busy in performing certain operations and is ready to hand the control permission off to the OS.";
            sw = rw; hw = r;
            reset = 0x0;
        } bohc_bb[4:4];
        field {
            name = "bohc_ooc";
            desc = "When the value of bohc_oos is changed from 0 to 1, this bit is fixed at 1. Writing 1 clears this bit and writing 0 has no effect.";
            sw = rw; hw = w; woclr;
            reset = 0x0;
        } bohc_ooc[3:3];
        field {
            name = "bohc_sooe";
            desc = "Message interrupt enable 0: No message interrupt is generated. 1: When bohc_ooc is set to 1, a message interrupt is generated. 0: The OS does not apply for the control permission on the controller.";
            sw = rw; hw = r;
            reset = 0x0;
        } bohc_sooe[2:2];
        field {
            name = "bohc_oos";
            desc = "Request applied by the OS for controlling the controller 1: The OS applies for the control permission on the controller. If bohc_oos is 1 and bios_bos is 0, it indicates that the OS has obtained the control permission on the SATA controller. Resetting the SATA controller through SATA_GHC_GHC[hab_rst] has no effect on this bit. 0: The BIOS does not have the control permission on the controller.";
            sw = rw; hw = r;
            reset = 0x0;
        } bohc_oos[1:1];
        field {
            name = "bohc_bos";
            desc = "Flag that indicates that the BIOS has the control permission on the controller 1: The BIOS has the control permission on the controller. If the clears this bit. Resetting the SATA controller through OS applies for the control permission on the controller, the BIOS SATA_GHC_GHC[hab_rst] has no effect on this bit.";
            sw = rw; hw = r;
            reset = 0x0;
        } bohc_bos[0:0];
    } SATA_GHC_BOHC @ 0x28;
    reg {
        name = "SATA_PHY_CTL0";
        desc = "SATA_PHY_CTL0 is PHY global control register 0. (offset 0xA0, total reset 0xC9802780; PROVEN: Hi3536D V100 data sheet). Vendor kernel reads-modifies-writes the PHY control block through the mmio window (PHY_CTL1/PHY_CTL2 names in the vendor code; offsets not confirmed against 0xA0/0xA4).";
        field {
            name = "reserved_31_31";
            desc = "Reserved 0: disabled 1: enabled";
            sw = r; hw = na;
            reset = 0x1;
        } reserved_31_31[31:31];
        field {
            name = "data_sp_by_phy";
            desc = "Data bit extension enable Note: When speed_sel_mux is 1'b1 and the OOB is generated by the controller, the 20-bit parallel data transmitted by the controller needs to be extended according to the negotiation rate to ensure that the maximum bit rate of a single UI is 1.5 Gbit/s in the OOB phase.";
            sw = rw; hw = r;
            reset = 0x1;
        } data_sp_by_phy[30:30];
        field {
            name = "oob_send_by_phy";
            desc = "Whether the OOB is generated by the PHY or the controller 0: controller 1: PHY keeps in the 1 status timeout occurs and the status of the state machine at the PHY layer";
            sw = rw; hw = r;
            reset = 0x0;
        } oob_send_by_phy[29:29];
        field {
            name = "curr_st_cnt";
            desc = "Count value when the state machine current_state at the PHY layer Note: If there is no align signal during the rate negotiation, a jumps from 8 to 1, and then the state machine immediately generates the comreset OOB because the NANO PHY has special requirements on clock frequency switching. If the bit rate is also being switched, the time for a burst in the comreset sequence may be not 320 ns defi";
            sw = rw; hw = r;
            reset = 0x9;
        } curr_st_cnt[28:24];
        field {
            name = "speed_sel_mux";
            desc = "and the rate varies in the data phase. 1: dedicated mode for the NANO PLL. The rate indicator is the same in the OOB phase and the data phase.";
            sw = rw; hw = r;
            reset = 0x1;
        } speed_sel_mux[23:23];
        field {
            name = "pcs_timeout_cnt";
            desc = "Timeout count control when the bit rate of SATA is being switched. This field is used to ensure that the phy_status signal provided by the NANO can be detected after the bit rate switching is complete.";
            sw = rw; hw = r;
            reset = 0x13c0;
        } pcs_timeout_cnt[22:1];
        field {
            name = "reserved_0_0";
            desc = "Note: When speed_sel_mux is 0, this field needs to be set to 0x16 (about 220 ns) because the bit rate of NANO may be switched in different modes. Reserved";
            sw = r; hw = w;
            reset = 0x0;
        } reserved_0_0[0:0];
    } SATA_PHY_CTL0 @ 0xA0;
    reg {
        name = "SATA_PHY_CTL1";
        desc = "SATA_PHY_CTL1 is PHY global control register 1. (offset 0xA4, total reset 0x0000000D; PROVEN: Hi3536D V100 data sheet).";
        field {
            name = "reserved_31_4";
            desc = "Reserved 0: The endian modes of the p0 PHY and the parallel data interface connected to the SATA controller are the same.";
            sw = r; hw = w;
            reset = 0x0;
        } reserved_31_4[31:4];
        field {
            name = "data_invert";
            desc = " 1: The endian modes of the p0 PHY and the parallel data interface connected to the SATA controller are opposite.";
            sw = rw; hw = r;
            reset = 0x1;
        } data_invert[3:3];
        field {
            name = "reserved_2_0";
            desc = "Reserved";
            sw = r; hw = na;
            reset = 0x5;
        } reserved_2_0[2:0];
    } SATA_PHY_CTL1 @ 0xA4;
    reg {
        name = "SATA_OOB_CTL";
        desc = "SATA_OOB_CTL is a PHY OOB control register. (offset 0xB8, total reset 0x84060C15; PROVEN: Hi3536D V100 data sheet).";
        field {
            name = "oob_ctrl_valid";
            desc = "Configuration bit of the OOB detection parameter. For high level, this bit is used to select the parameter configurations of this register.";
            sw = rw; hw = r;
            reset = 0x1;
        } oob_ctrl_valid[31:31];
        field {
            name = "min_comiwake";
            desc = "Minimum space required for the COMWAKE space detection";
            sw = rw; hw = r;
            reset = 0x4;
        } min_comiwake[30:24];
        field {
            name = "max_comwake";
            desc = "Maximum space required for the COMWAKE space detection";
            sw = rw; hw = r;
            reset = 0x6;
        } max_comwake[23:16];
        field {
            name = "min_cominit";
            desc = "Minimum space required for the COMINIT space detection";
            sw = rw; hw = r;
            reset = 0xc;
        } min_cominit[15:8];
        field {
            name = "max_cominit";
            desc = "Maximum space required for the COMINIT space detection 11.5.7.2 SATA Port Configuration Registers";
            sw = rw; hw = r;
            reset = 0x15;
        } max_cominit[7:0];
    } SATA_OOB_CTL @ 0xB8;
    reg {
        name = "SATA_PORT_CLB";
        desc = "SATA_PORT_CLB is a command list base address register. (offset 0x100, total reset 0x00000000; PROVEN: Hi3536D V100 data sheet).";
        field {
            name = "port_clb";
            desc = "Base address for storing the port command list in the memory. Resetting the SATA controller through";
            sw = rw; hw = r;
            reset = 0x0;
        } port_clb[31:10];
        field {
            name = "reserved_9_0";
            desc = "SATA_GHC_GHC[hab_rst] has no effect on this field. Reserved";
            sw = r; hw = w;
            reset = 0x0;
        } reserved_9_0[9:0];
    } SATA_PORT_CLB @ 0x100;
    reg {
        name = "SATA_PORT_FB";
        desc = "SATA_PORT_FB is an RX FIS base address register. (offset 0x108, total reset 0x00000000; PROVEN: Hi3536D V100 data sheet).";
        field {
            name = "port_fb";
            desc = "Base address in the memory for storing the frames received through the port.";
            sw = rw; hw = r;
            reset = 0x0;
        } port_fb[31:8];
        field {
            name = "reserved_7_0";
            desc = "Resetting the SATA controller through SATA_GHC_GHC[hab_rst] has no effect on this field. Reserved";
            sw = r; hw = w;
            reset = 0x0;
        } reserved_7_0[7:0];
    } SATA_PORT_FB @ 0x108;
    reg {
        name = "SATA_PORT_IS";
        desc = "SATA_PORT_IS is a port interrupt status register. (offset 0x110, total reset 0x00000000; PROVEN: Hi3536D V100 data sheet).";
        field {
            name = "reserved_31_31";
            desc = "Reserved";
            sw = r; hw = w;
            reset = 0x0;
        } reserved_31_31[31:31];
        field {
            name = "pxis_tfes";
            desc = "Task file data (TFD) error interrupt status 0: The value of SATA_PORT_TFD[0] is not 1. 1: The value of SATA_PORT_TFD[0] is 1.";
            sw = rw; hw = w; woclr;
            reset = 0x0;
        } pxis_tfes[30:30];
        field {
            name = "reserved_29_29";
            desc = "Reserved";
            sw = r; hw = w;
            reset = 0x0;
        } reserved_29_29[29:29];
        field {
            name = "pxis_hbds";
            desc = "Internal bus error interrupt 0: The DMAC accesses the memory properly. 1: An error occurs when the DMAC accesses the memory.";
            sw = rw; hw = w; woclr;
            reset = 0x0;
        } pxis_hbds[28:28];
        field {
            name = "pxis_ifs";
            desc = "Fatal error interrupt status 0: No error occurs during the data frame transfer. 1: An error occurs during the data frame transfer.";
            sw = rw; hw = w; woclr;
            reset = 0x0;
        } pxis_ifs[27:27];
        field {
            name = "pxis_infs";
            desc = "Non-fatal error interrupt status 0: No error occurs during the non-data frame transfer. 1: An error occurs during the non-data frame transfer.";
            sw = rw; hw = w; woclr;
            reset = 0x0;
        } pxis_infs[26:26];
        field {
            name = "reserved_25_25";
            desc = "Reserved 0: No overflow is detected.";
            sw = r; hw = w;
            reset = 0x0;
        } reserved_25_25[25:25];
        field {
            name = "pxis_ofs";
            desc = "Data transfer overflow interrupt status 1: During the data frame transfer, if the size of the data memory occupied by commands is smaller than the actual data amount, an interrupt is reported at the end of the data transfer.";
            sw = rw; hw = w; woclr;
            reset = 0x0;
        } pxis_ofs[24:24];
        field {
            name = "pxis_ipms";
            desc = "PM port number error interrupt status 0: No PM port number error is detected during data reception. 1: A PM port number error is detected during data reception. 0: No changes of the phyrdy signal are detected.";
            sw = rw; hw = w; woclr;
            reset = 0x0;
        } pxis_ipms[23:23];
        field {
            name = "pxis_prcs";
            desc = "PHY status change interrupt status 1: Changes of the phyrdy signal are detected.";
            sw = r; hw = w;
            reset = 0x0;
        } pxis_prcs[22:22];
        field {
            name = "reserved_21_7";
            desc = "This bit directly reflects the value of SATA_PORT_SERR[diag_n]. Reserved 0: No COMINIT signal transmitted from the device is detected.";
            sw = r; hw = w;
            reset = 0x0;
        } reserved_21_7[21:7];
        field {
            name = "pxis_pcs";
            desc = "Port connection change interrupt status 1: A COMINIT signal transmitted from the device is detected. 0: The transfer of the linked list data is complete when no I bit in";
            sw = r; hw = w;
            reset = 0x0;
        } pxis_pcs[6:6];
        field {
            name = "pxis_dps";
            desc = "This bit directly reflects the value of SATA_PORT_SERR[diag.x]. Linked list transfer completion interrupt status the PRD is 1. 1: The transfer of the linked list data is complete when an I bit in the PRD is 1.";
            sw = rw; hw = w; woclr;
            reset = 0x0;
        } pxis_dps[5:5];
        field {
            name = "pxis_ufs";
            desc = "Unknown FIS interrupt status 0: No unknown FIS is received. 1: An unknown FIS is received.";
            sw = r; hw = w;
            reset = 0x0;
        } pxis_ufs[4:4];
        field {
            name = "pxis_sdbs";
            desc = "Set device bits FIS interrupt status 0: no effect 1: A set device bits FIS is received and the I bit is 1.";
            sw = rw; hw = w; woclr;
            reset = 0x0;
        } pxis_sdbs[3:3];
        field {
            name = "pxis_dss";
            desc = "DMA setup FIS interrupt status 0: no effect 1: A DMA setup FIS is received and the I bit is 1.";
            sw = rw; hw = w; woclr;
            reset = 0x0;
        } pxis_dss[2:2];
        field {
            name = "pxis_pss";
            desc = "PIO setup FIS interrupt status 0: no effect 1: A PIO setup FIS is received and the I bit is 1.";
            sw = rw; hw = w; woclr;
            reset = 0x0;
        } pxis_pss[1:1];
        field {
            name = "pxis_dhrs";
            desc = "D2H register FIS interrupt status 0: no effect 1: A D2H register FIS is received and the I bit is 1.";
            sw = rw; hw = w; woclr;
            reset = 0x0;
        } pxis_dhrs[0:0];
    } SATA_PORT_IS @ 0x110;
    reg {
        name = "SATA_PORT_IE";
        desc = "SATA_PORT_IE is a port interrupt mask register. (offset 0x114, total reset 0x00000000; PROVEN: Hi3536D V100 data sheet).";
        field {
            name = "reserved_31_31";
            desc = "Reserved";
            sw = r; hw = w;
            reset = 0x0;
        } reserved_31_31[31:31];
        field {
            name = "pxie_tfee";
            desc = "TFD error interrupt mask 0: masked 1: not masked";
            sw = rw; hw = r;
            reset = 0x0;
        } pxie_tfee[30:30];
        field {
            name = "reserved_29_29";
            desc = "Reserved";
            sw = r; hw = w;
            reset = 0x0;
        } reserved_29_29[29:29];
        field {
            name = "pxie_hbde";
            desc = "Internal bus error interrupt mask 0: masked 1: not masked";
            sw = rw; hw = r;
            reset = 0x0;
        } pxie_hbde[28:28];
        field {
            name = "pxie_ife";
            desc = "Fatal error interrupt mask 0: masked 1: not masked";
            sw = rw; hw = r;
            reset = 0x0;
        } pxie_ife[27:27];
        field {
            name = "pxie_infe";
            desc = "Non-fatal error interrupt mask 0: masked 1: not masked";
            sw = rw; hw = r;
            reset = 0x0;
        } pxie_infe[26:26];
        field {
            name = "reserved_25_25";
            desc = "Reserved";
            sw = r; hw = w;
            reset = 0x0;
        } reserved_25_25[25:25];
        field {
            name = "pxie_ofe";
            desc = "Data transfer overflow interrupt mask 0: masked 1: not masked.";
            sw = rw; hw = r;
            reset = 0x0;
        } pxie_ofe[24:24];
        field {
            name = "pxie_ipme";
            desc = "PM port error interrupt mask 0: masked 1: not masked";
            sw = rw; hw = r;
            reset = 0x0;
        } pxie_ipme[23:23];
        field {
            name = "pxie_prce";
            desc = "PHY status change interrupt mask 0: masked 1: not masked";
            sw = rw; hw = r;
            reset = 0x0;
        } pxie_prce[22:22];
        field {
            name = "reserved_21_7";
            desc = "Reserved";
            sw = r; hw = w;
            reset = 0x0;
        } reserved_21_7[21:7];
        field {
            name = "pxie_pce";
            desc = "Port connection change interrupt mask 0: masked 1: not masked";
            sw = rw; hw = r;
            reset = 0x0;
        } pxie_pce[6:6];
        field {
            name = "pxie_dpe";
            desc = "Linked list transfer completion interrupt mask 0: masked 1: not masked";
            sw = rw; hw = r;
            reset = 0x0;
        } pxie_dpe[5:5];
        field {
            name = "pxie_ufe";
            desc = "Unknown FIS interrupt mask 0: masked 1: not masked";
            sw = rw; hw = r;
            reset = 0x0;
        } pxie_ufe[4:4];
        field {
            name = "pxie_sdbe";
            desc = "Set device bits FIS interrupt mask 0: masked 1: not masked";
            sw = rw; hw = r;
            reset = 0x0;
        } pxie_sdbe[3:3];
        field {
            name = "pxie_dse";
            desc = "DMA setup FIS interrupt mask 0: masked 1: not masked";
            sw = rw; hw = r;
            reset = 0x0;
        } pxie_dse[2:2];
        field {
            name = "pxie_pse";
            desc = "PIO setup FIS interrupt mask 0: masked 1: not masked";
            sw = rw; hw = r;
            reset = 0x0;
        } pxie_pse[1:1];
        field {
            name = "pxie_dhre";
            desc = "D2H register FIS interrupt mask 0: masked 1: not masked";
            sw = rw; hw = r;
            reset = 0x0;
        } pxie_dhre[0:0];
    } SATA_PORT_IE @ 0x114;
    reg {
        name = "SATA_PORT_CMD";
        desc = "SATA_PORT_CMD is a port command and status register. (offset 0x118, total reset 0x00600000; PROVEN: Hi3536D V100 data sheet).";
        field {
            name = "cmd_icc";
            desc = "Port communication control signal 0x0: No operation. It indicates that the next port status request is allowed. 0x1: Request to enable the port to be in the active status. 0x2: Request to enable the port to be in the partial status. 0x6: Request to enable the port to be in the slumber status. Other values: reserved the reserved value, the controller clears the cmd_icc bit after performing related ";
            sw = rw; hw = r;
            reset = 0x0;
        } cmd_icc[31:28];
        field {
            name = "cmd_asp";
            desc = "When the software writes any of the preceding values rather than Slumber or partial status select for power management 0: proactively enter the partial status. 1: proactively enter the slumber status. 0: disabled 1: enabled If SATA_PORT_CI and SATA_PORT_SACT are";
            sw = rw; hw = r;
            reset = 0x0;
        } cmd_asp[27:27];
        field {
            name = "cmd_alpe";
            desc = "Automatic power management enable cleared, the controller enters the power-management status automatically. To be specific, if cmd_asp is 1, the controller enters the partial status; if cmd_asp is 0, the controller enters the slumber status. 0: The LED pin can be driven when cmd_atapi is 0 and commands";
            sw = rw; hw = r;
            reset = 0x0;
        } cmd_alpe[26:26];
        field {
            name = "cmd_dlae";
            desc = "LED drive enable in ATAPI mode are being executed. 1: The LED pin can be driven when commands are being executed.";
            sw = rw; hw = r;
            reset = 0x0;
        } cmd_dlae[25:25];
        field {
            name = "cmd_atapi";
            desc = "ATAPI device indicator 0: The current device is not an ATAPI device. 1: The current device is an ATAPI device.";
            sw = rw; hw = r;
            reset = 0x0;
        } cmd_atapi[24:24];
        field {
            name = "reserved_23_23";
            desc = "Reserved";
            sw = r; hw = w;
            reset = 0x0;
        } reserved_23_23[23:23];
        field {
            name = "fbscp";
            desc = "Whether the port supports FIS-based switching. When SATA_GHC_CAP1[spm] and SATA_GHC_CAP1[FBSS] are set to 1, this bit must be set to 1. 0: not supported 1: supported";
            sw = r; hw = w;
            reset = 0x1;
        } fbscp[22:22];
        field {
            name = "cmd_esp";
            desc = "Fixed at 1, indicating that the external SATA device is supported.";
            sw = r; hw = w;
            reset = 0x1;
        } cmd_esp[21:21];
        field {
            name = "reserved_20_18";
            desc = "Reserved";
            sw = r; hw = w;
            reset = 0x0;
        } reserved_20_18[20:18];
        field {
            name = "cmd_pma";
            desc = "Port multiplier detection indicator 0: No port multiplier is connected to the port. 1: A port multiplier is connected to the port.";
            sw = rw; hw = r;
            reset = 0x0;
        } cmd_pma[17:17];
        field {
            name = "reserved_16_16";
            desc = "Reserved";
            sw = r; hw = w;
            reset = 0x0;
        } reserved_16_16[16:16];
        field {
            name = "cmd_cr";
            desc = "Command list processing indicator 0: No command is being executed. 1: A command is being executed.";
            sw = r; hw = w;
            reset = 0x0;
        } cmd_cr[15:15];
        field {
            name = "cmd_fr";
            desc = "FIS receive processing indicator 0: No FIS is being received. 1: An FIS is being received.";
            sw = r; hw = w;
            reset = 0x0;
        } cmd_fr[14:14];
        field {
            name = "reserved_13_13";
            desc = "Reserved";
            sw = r; hw = w;
            reset = 0x0;
        } reserved_13_13[13:13];
        field {
            name = "cmd_ccs";
            desc = "Slot number of the current command This field is valid when cmd_st is 1 and is cleared when cmd_st is 0.";
            sw = r; hw = w;
            reset = 0x0;
        } cmd_ccs[12:8];
        field {
            name = "reserved_7_5";
            desc = "Reserved 0: forbid to write the received FISs to the system memory";
            sw = r; hw = w;
            reset = 0x0;
        } reserved_7_5[7:5];
        field {
            name = "cmd_fre";
            desc = "FIS receive enable control 1: enable the received FISs and write them to the system memory cmd_st is 1, this bit must be set to 1. 0: no effect";
            sw = rw; hw = r;
            reset = 0x0;
        } cmd_fre[4:4];
        field {
            name = "cmd_clo";
            desc = "The software needs to set the receive FIS base address register SATA_PORT_FB before enabling this bit to receive FISs. When BSY/DQR clear control. The software can forcibly clear the BSY and DRQ bits through this bit and transmit commands to the device. 1: Clear the BSY and DRQ bits of SATA_PORT_TFD[tfd_sts].";
            sw = rw; hw = r;
            reset = 0x0;
        } cmd_clo[3:3];
        field {
            name = "reserved_2_2";
            desc = "After the BSY and DRQ bits are 0, the cmd_clo bit is automatically cleared. The cmd_clo bit can be written as 1 only before the value of cmd_st is changed from 0 to 1. In addition, the software must write 1 to cmd_st after the cmd_clo bit is cleared. Reserved 0: When SATA_PORT_SCTL[det] is 0, the controller enters the listen mode.";
            sw = r; hw = w;
            reset = 0x0;
        } reserved_2_2[2:2];
        field {
            name = "cmd_sud";
            desc = "Spin-up device control 1: After the system is powered on or the HBA is reset, the controller is enabled to transmit a COMRESET sequence to initialize the hardware device. 0: The controller enters the idle status. 1: The controller processes the commands from slot 0 that are";
            sw = rw; hw = r;
            reset = 0x0;
        } cmd_sud[1:1];
        field {
            name = "cmd_st";
            desc = "Command list processing enable identified as valid slots by SATA_PORT_CI. The cmd_st bit can be set to 1 only after cmd_fre is 1.";
            sw = rw; hw = r;
            reset = 0x0;
        } cmd_st[0:0];
    } SATA_PORT_CMD @ 0x118;
    reg {
        name = "SATA_PORT_TFD";
        desc = "SATA_PORT_TFD is a port task file register. (offset 0x120, total reset 0x0000007F; PROVEN: Hi3536D V100 data sheet).";
        field {
            name = "reserved_31_16";
            desc = "Reserved";
            sw = r; hw = w;
            reset = 0x0;
        } reserved_31_16[31:16];
        field {
            name = "tfd_err";
            desc = "Task file error The controller updates this field after receiving a D2H register bit[7]: BSY bit. It indicates that the device is busy.";
            sw = r; hw = w;
            reset = 0x0;
        } tfd_err[15:8];
        field {
            name = "tfd_sts";
            desc = "FIS, a PIO setup FIS, or an SDB FIS. Task file status bit[6:4]: The meaning of this field varies according to commands. bit[3]: DRQ bit. It indicates that there is the data to be transferred in the device. bit[2:1]: The meaning of this field varies according to commands. bit[0]: ERR bit. It indicates that an error occurs during the data transfer. The controller updates this field after receiving a";
            sw = r; hw = w;
            reset = 0x7f;
        } tfd_sts[7:0];
    } SATA_PORT_TFD @ 0x120;
    reg {
        name = "SATA_PORT_SIG";
        desc = "SATA_PORT_SIG is a port signature register. (offset 0x124, total reset 0xFFFFFFFF; PROVEN: Hi3536D V100 data sheet).";
        field {
            name = "signature";
            desc = "LBA address and sector addressing. The allocated addresses are as follows: bit[31:24]: LBA upper-bit address bit[23:16]: LBA middle-bit address bit[15:8]: LBA lower-bit address bit[7:0]: number of sectors register FIS after the hardware device is reset. The controller updates this register when receiving the first D2H";
            sw = r; hw = w;
            reset = 0xffffffff;
        } signature[31:0];
    } SATA_PORT_SIG @ 0x124;
    reg {
        name = "SATA_PORT_SSTS";
        desc = "SATA_PORT_SSTS is a port status register. (offset 0x128, total reset 0x00000000; PROVEN: Hi3536D V100 data sheet).";
        field {
            name = "reserved_31_12";
            desc = "Reserved 0x0: No devices exist or no communication is set up. 0x1: active";
            sw = r; hw = w;
            reset = 0x0;
        } reserved_31_12[31:12];
        field {
            name = "pxssts_ipm";
            desc = "Current port status 0x2: partial 0x6: slumber Other values: reserved 0x0: No devices exist or no communication is set up. 0x1: Rate 1 is negotiated for communication.";
            sw = r; hw = w;
            reset = 0x0;
        } pxssts_ipm[11:8];
        field {
            name = "pxssts_spd";
            desc = "Port negotiation speed 0x2: Rate 2 is negotiated for communication. 0x3: Rate 3 is negotiated for communication. Other values: reserved 0x0: No device is detected and no PHY communication is set up. 0x1: A device is detected but no PHY communication is set up.";
            sw = r; hw = w;
            reset = 0x0;
        } pxssts_spd[7:4];
        field {
            name = "pxssts_det";
            desc = "Device detection and PHY status 0x3: A device is detected but the PHY communication is set up. 0x4: The PHY is offline or in the built-in self test (BIST) status. Other values: reserved";
            sw = r; hw = w;
            reset = 0x0;
        } pxssts_det[3:0];
    } SATA_PORT_SSTS @ 0x128;
    reg {
        name = "SATA_PORT_SCTL";
        desc = "SATA_PORT_SCTL is a port control register. (offset 0x12C, total reset 0x00000000; PROVEN: Hi3536D V100 data sheet).";
        field {
            name = "reserved_31_12";
            desc = "Reserved 0x0: no requirements 0x1: forbid to enter the partial status";
            sw = r; hw = w;
            reset = 0x0;
        } reserved_31_12[31:12];
        field {
            name = "pxsctl_ipm";
            desc = "Port power management status control 0x2: forbid to enter the slumber status 0x3: forbid to enter the partial or slumber state Other values: reserved 0x0: no requirements 0x1: limit the communication speed to rate 1";
            sw = rw; hw = r;
            reset = 0x0;
        } pxsctl_ipm[11:8];
        field {
            name = "pxsctl_spd";
            desc = "Port communication speed control 0x2: limit the communication speed to rate 2 0x3: limit the communication speed to rate 3 Other values: reserved 0x0: no device detection or initialization request 0x1: request the port to reset the initialization sequence Device detection and port initialization control";
            sw = rw; hw = r;
            reset = 0x0;
        } pxsctl_spd[7:4];
    } SATA_PORT_SCTL @ 0x12C;
    reg {
        name = "SATA_PORT_SERR";
        desc = "SATA_PORT_SERR is an error diagnosis status register. (offset 0x130, total reset 0x00000000; PROVEN: Hi3536D V100 data sheet).";
        field {
            name = "reserved_31_27";
            desc = "Reserved";
            sw = r; hw = w;
            reset = 0x0;
        } reserved_31_27[31:27];
        field {
            name = "diag_x";
            desc = "Device detection status 0: No COMINIT signal transmitted from the device is detected. 1: A COMINIT signal transmitted from the device is detected. 0: No unknown FIS is received.";
            sw = rw; hw = w; woclr;
            reset = 0x0;
        } diag_x[26:26];
        field {
            name = "diag_f";
            desc = "Detection status of the unknown FIS 1: An unknown FIS is received and this bit is set to 1 when the cyclic redundancy check (CRC) is correct.";
            sw = rw; hw = w; woclr;
            reset = 0x0;
        } diag_f[25:25];
        field {
            name = "reserved_24_24";
            desc = "Reserved";
            sw = r; hw = w;
            reset = 0x0;
        } reserved_24_24[24:24];
        field {
            name = "diag_s";
            desc = "Link layer error status 0: No status transition error occurs at the link layer. 1: A status transition error occurs at the link layer. 0: No R_ERR primitive transmitted from the device is received.";
            sw = rw; hw = w; woclr;
            reset = 0x0;
        } diag_s[23:23];
        field {
            name = "diag_h";
            desc = "Handshake error status 1: One or more R_ERR primitives transmitted from the device are received.";
            sw = rw; hw = w; woclr;
            reset = 0x0;
        } diag_h[22:22];
        field {
            name = "diag_c";
            desc = "CRC error status 0: No CRC error occurs during FIS receiving. 1: A CRC error occurs during FIS receiving.";
            sw = rw; hw = w; woclr;
            reset = 0x0;
        } diag_c[21:21];
        field {
            name = "reserved_20_20";
            desc = "Reserved";
            sw = r; hw = w;
            reset = 0x0;
        } reserved_20_20[20:20];
        field {
            name = "diag_b";
            desc = "Decoding error status 0: No 8B/10B decoding error is detected. 1: An 8B/10B decoding error is detected.";
            sw = rw; hw = w; woclr;
            reset = 0x0;
        } diag_b[19:19];
        field {
            name = "diag_w";
            desc = "COMWAKE status 0: No COMWAKE signal transmitted from the device is detected. 1: A COMWAKE signal transmitted from the device is detected.";
            sw = rw; hw = w; woclr;
            reset = 0x0;
        } diag_w[18:18];
        field {
            name = "diag_i";
            desc = "PHY internal error status 0: No PHY internal error is detected. 1: A PHY internal error is detected. 0: The PhyRdy signal is not changed.";
            sw = rw; hw = w; woclr;
            reset = 0x0;
        } diag_i[17:17];
        field {
            name = "diag_n";
            desc = "PhyRdy signal change status 1: The PhyRdy signal is changed.";
            sw = rw; hw = w; woclr;
            reset = 0x0;
        } diag_n[16:16];
        field {
            name = "reserved_15_11";
            desc = "This bit is set to 1 when the value of the PhyRdy signal is changed from 1 to 0 or from 0 to 1. Reserved 0: No device behavior does not comply with the SATA protocol.";
            sw = r; hw = w;
            reset = 0x0;
        } reserved_15_11[15:11];
        field {
            name = "err_p";
            desc = "SATA protocol incompliance error status 1: Some device behavior does not comply with the SATA protocol.";
            sw = rw; hw = w; woclr;
            reset = 0x0;
        } err_p[10:10];
        field {
            name = "reserved_9_9";
            desc = "Reserved";
            sw = r; hw = w;
            reset = 0x0;
        } reserved_9_9[9:9];
        field {
            name = "err_t";
            desc = "Data integrity error status 0: No data integrity error is detected. 1: A data integrity error is detected.";
            sw = rw; hw = w; woclr;
            reset = 0x0;
        } err_t[8:8];
        field {
            name = "reserved_7_0";
            desc = "Reserved";
            sw = r; hw = w;
            reset = 0x0;
        } reserved_7_0[7:0];
    } SATA_PORT_SERR @ 0x130;
    reg {
        name = "SATA_PORT_SACT";
        desc = "SATA_PORT_SACT is an NCQ command identifier control register. (offset 0x134, total reset 0x00000000; PROVEN: Hi3536D V100 data sheet).";
        field {
            name = "port_sact";
            desc = "NCQ command identifier control Each bit of this register maps to a tag ID and an NCQ command in the memory. To be specific, bit[31:0] map to the commands of slot 31–0 and tag 31–0 respectively. The following describes the meaning of each bit by taking bit[3] as an example: 0: The slot 3 command is a non-NCQ command. 1: The slot 3 command is an NCQ command. Before setting transmits an SDB FIS. Then";
            sw = rw; hw = r;
            reset = 0x0;
        } port_sact[31:0];
    } SATA_PORT_SACT @ 0x134;
    reg {
        name = "SATA_PORT_CI";
        desc = "SATA_PORT_CI is a command TX control register. (offset 0x138, total reset 0x00000000; PROVEN: Hi3536D V100 data sheet).";
        field {
            name = "port_ci";
            desc = "Control for the commands to be transmitted Each bit of this register maps to a command in the memory. To be specific, bit[31:0] map to the commands of slot 31–0 respectively. The following describes the meaning of each bit by taking bit[3] as an example: 0: There is no slot 3 command to be transmitted and executed. 1: A slot 3 command is created in the memory. Then the controller can transmit this";
            sw = rw; hw = r;
            reset = 0x0;
        } port_ci[31:0];
    } SATA_PORT_CI @ 0x138;
    reg {
        name = "SATA_PORT_SNTF";
        desc = "SATA_PORT_SNTF is an async notification event indicator register. (offset 0x13C, total reset 0x00000000; PROVEN: Hi3536D V100 data sheet).";
        field {
            name = "reserved_31_16";
            desc = "Reserved port and the N bit of this FIS is 1, the controller sets the bit of this register corresponding to this port number to 1.";
            sw = r; hw = w;
            reset = 0x0;
        } reserved_31_16[31:16];
        field {
            name = "pxsntf_pmn";
            desc = "Async notification event status If the controller receives an SDB FIS from the device on the PM The following describes the meaning of each bit by taking bit[3] as an example: 0: No async notification event occurs on the device whose PM port number is 3. 1: An async notification event occurs on the device whose PM port number is 3.";
            sw = rw; hw = w; woclr;
            reset = 0x0;
        } pxsntf_pmn[15:0];
    } SATA_PORT_SNTF @ 0x13C;
    reg {
        name = "SATA_PORT_FBS";
        desc = "SATA_PORT_FBS (offset 0x140, total reset 0x0000F000; PROVEN: Hi3536D V100 data sheet).";
        field {
            name = "reserved_31_20";
            desc = "Reserved";
            sw = r; hw = w;
            reset = 0x0;
        } reserved_31_20[31:20];
        field {
            name = "fbs_dwe";
            desc = "A fatal error occurs on the device corresponding to the current PM port. This field is configured by hardware and is valid only when during the current FIS-based switching. This field is configured by";
            sw = r; hw = w;
            reset = 0x0;
        } fbs_dwe[19:16];
        field {
            name = "fbs_ado";
            desc = "PxFBS.SDE is 1. Maximum number of external devices mounted over the PM hardware. The number of PM domains corresponding to the created command should be less than the value when a command is created for optimal performance.";
            sw = r; hw = w;
            reset = 0xf;
        } fbs_ado[15:12];
        field {
            name = "fbs_dev";
            desc = "ID of the PM port to which the next command is transmitted. This field is configured by software. Software cannot transmit commands to multiple PM ports. Therefore, when a CI is created, commands cannot be transmitted to multiple PM ports. The same";
            sw = rw; hw = r;
            reset = 0x0;
        } fbs_dev[11:8];
        field {
            name = "reserved_7_3";
            desc = "PM port must be used for a CI. Reserved considers that software processes this error first. This field is";
            sw = r; hw = w;
            reset = 0x0;
        } reserved_7_3[7:3];
        field {
            name = "fbs_sde";
            desc = "When this field is set to 1, a fatal error occurs, and hardware cleared by setting PxCMD.ST to 0. When PxFBS.DEC is set to 1 or PxCMD.ST is set to 0, the fbs_sde bit needs to be cleared.";
            sw = r; hw = w;
            reset = 0x0;
        } fbs_sde[2:2];
        field {
            name = "fbs_dec";
            desc = "When software sets this bit to 1, the HBA needs to clear the error trigger conditions and clear the commands of the outstanding corresponding to the device including PxCI and PxSACT of the device. After hardware rectifies the error, the hardware must set this bit to 0. Writing 0 to this bit by using software has no effect.";
            sw = rw; hw = r;
            reset = 0x0;
        } fbs_dec[1:1];
        field {
            name = "fbs_en";
            desc = "Software can set this bit to 1 only when PxFBS.EN and PxFBS.SDE are 1. When this bit is set to 1, a PM is connected, and the HBA needs to enable FIB-based switching to communicate with the PM. When this bit is cleared, FIS-based switching is unavailable. Software can modify this bit only when PxCMD.ST is 0.";
            sw = rw; hw = r;
            reset = 0x0;
        } fbs_en[0:0];
    } SATA_PORT_FBS @ 0x140;
    reg {
        name = "SATA_PORT_FIFOTH";
        desc = "SATA_PORT_FIFOTH (offset 0x144, total reset 0xFFEC3F24; PROVEN: Hi3536D V100 data sheet). Vendor kernel phy-hi3536dv100-sata.c writes 0xFEED9F24 here (PORT_FIFOTH at +0x100+0x44; PROVEN offset and value).";
        field {
            name = "reserved_31_9";
            desc = "Reserved";
            sw = r; hw = na;
            reset = 0x7ff61f;
        } reserved_31_9[31:9];
        field {
            name = "dmac_rxfifo_th";
            desc = "Flow control threshold of the DMAC RX FIFO. During data reception, if the data amount in the DMAC FIFO is above the threshold, the controller starts to control the data flow.";
            sw = rw; hw = r;
            reset = 0x12;
        } dmac_rxfifo_th[8:4];
        field {
            name = "rxfifo_th_sel";
            desc = "Flow control FIFO select 0: The flow control for the link RX FIFO is valid. 1: The flow control for the DMAC RX FIFO is valid.";
            sw = rw; hw = r;
            reset = 0x0;
        } rxfifo_th_sel[3:3];
        field {
            name = "link_rxfifo_th";
            desc = "Flow control threshold of the link RX FIFO. During data reception, if the data amount in the DMAC FIFO is above the threshold, the controller starts to control the data flow.";
            sw = rw; hw = r;
            reset = 0x4;
        } link_rxfifo_th[2:0];
    } SATA_PORT_FIFOTH @ 0x144;
    reg {
        name = "SATA_PORT_PHYCTL1";
        desc = "SATA_PORT_PHYCTL1 (offset 0x148, total reset 0x002E5CB8; PROVEN: Hi3536D V100 data sheet). Vendor kernel writes 0x00050438 here for both 1.5 and 3 Gbit/s (PORT_PHYCTL1 at +0x100+0x48; PROVEN).";
        field {
            name = "reserved_31_21";
            desc = "Reserved (The voltage value corresponding to each level indicates only the approximate value instead of the accurate value.) 000: 1000 mV 001: 1100 mV";
            sw = r; hw = na;
            reset = 0x1;
        } reserved_31_21[31:21];
        field {
            name = "tx_margin2";
            desc = "Gen3 TX signal amplitude control 010: 900 mV 011: 700 mV 100: 600 mV 101: 500 mV 110: 400 mV 111: 300 mV (The value corresponding to each level indicates only the approximate value instead of the accurate value.)";
            sw = rw; hw = r;
            reset = 0x3;
        } tx_margin2[20:18];
        field {
            name = "tx_deemph2";
            desc = "Gen3 TX signal preemphasis control 00: -6 dB 01: -3.5 dB 10: 0 dB 11: reserved";
            sw = rw; hw = r;
            reset = 0x2;
        } tx_deemph2[17:16];
        field {
            name = "tx_swing2";
            desc = "Gen3 TX signal amplitude type control 0: full swing 1: low swing";
            sw = rw; hw = r;
            reset = 0x0;
        } tx_swing2[15:15];
        field {
            name = "reserved_14_14";
            desc = "Reserved (The voltage value corresponding to each level indicates only the approximate value instead of the accurate value.) 000: 1000 mV 001: 1100 mV";
            sw = r; hw = na;
            reset = 0x1;
        } reserved_14_14[14:14];
        field {
            name = "tx_margin1";
            desc = "Gen2 TX signal amplitude control 010: 900 mV 011: 700 mV 100: 600 mV 101: 500 mV 110: 400 mV 111: 300 mV (The value corresponding to each level indicates only the approximate value instead of the accurate value.)";
            sw = rw; hw = r;
            reset = 0x3;
        } tx_margin1[13:11];
        field {
            name = "tx_deemph1";
            desc = "Gen2 TX signal preemphasis control 00: -6dB 01: -3.5dB 10: 0dB 11: reserved";
            sw = rw; hw = r;
            reset = 0x2;
        } tx_deemph1[10:9];
        field {
            name = "tx_swing1";
            desc = "Gen2 TX signal amplitude type control 0: full swing 1: low swing";
            sw = rw; hw = r;
            reset = 0x0;
        } tx_swing1[8:8];
        field {
            name = "reserved_7_7";
            desc = "Reserved (The voltage value corresponding to each level indicates only the approximate value instead of the accurate value.) 000: 1000 mV 001: 1100 mV";
            sw = r; hw = na;
            reset = 0x1;
        } reserved_7_7[7:7];
        field {
            name = "tx_margin0";
            desc = "Gen1 TX signal amplitude control 010: 900 mV 011: 700 mV 100: 600 mV 101: 500 mV 110: 400 mV 111: 300 mV (The value corresponding to each level indicates only the approximate value instead of the accurate value.)";
            sw = rw; hw = r;
            reset = 0x3;
        } tx_margin0[6:4];
        field {
            name = "tx_deemph0";
            desc = "Gen1 TX signal preemphasis control 00: -6 dB 01: -3.5 dB 10: 0 dB 11: reserved";
            sw = rw; hw = r;
            reset = 0x2;
        } tx_deemph0[3:2];
        field {
            name = "tx_swing0";
            desc = "Gen1 TX signal amplitude type control 0: full swing 1: low swing";
            sw = rw; hw = r;
            reset = 0x0;
        } tx_swing0[1:1];
        field {
            name = "reserved_0_0";
            desc = "Reserved";
            sw = r; hw = w;
            reset = 0x0;
        } reserved_0_0[0:0];
    } SATA_PORT_PHYCTL1 @ 0x148;
    reg {
        name = "SATA_PORT_PHYCTL";
        desc = "SATA_PORT_PHYCTL is a PHY control register. (offset 0x174, total reset 0x0E240000; PROVEN: Hi3536D V100 data sheet). Vendor kernel writes 0x0E180000 (1.5 Gbit/s) or 0x0E390000 (3 Gbit/s) here (PORT_PHYCTL at +0x100+0x74; PROVEN); the data sheet operating-mode step also sets 0x0E390000 for 3 Gbit/s.";
        field {
            name = "test_seq_sel";
            desc = "Test mode. Parameters are configured to transmit various test sequences to test eye patterns. 001: The HFTP sequence is transmitted. 010: The MFTP sequence is transmitted. 100: The LFTP sequence is transmitted. 011: The LBP sequence is transmitted.";
            sw = rw; hw = r;
            reset = 0x0;
        } test_seq_sel[31:29];
        field {
            name = "phy_disable";
            desc = "PHY enable 0: enabled 1: disabled";
            sw = rw; hw = r;
            reset = 0x0;
        } phy_disable[28:28];
        field {
            name = "phy_calibrated";
            desc = "Whether to calibrate the PHY 0: not calibrated 1: calibrated";
            sw = rw; hw = r;
            reset = 0x1;
        } phy_calibrated[27:27];
        field {
            name = "spd_change_ack";
            desc = "Whether the rate can be switched 0: no 1: yes";
            sw = rw; hw = r;
            reset = 0x1;
        } spd_change_ack[26:26];
        field {
            name = "dp_rdy";
            desc = "Whether the PHY is ready to transmit data 0: no 1: yes";
            sw = rw; hw = r;
            reset = 0x1;
        } dp_rdy[25:25];
        field {
            name = "bist_tx_fspd";
            desc = "Whether the clock frequency is forcibly transmitted in BIST mode 0: no 1: yes";
            sw = rw; hw = r;
            reset = 0x0;
        } bist_tx_fspd[24:24];
        field {
            name = "neg_mode_b";
            desc = "Negotiation mode B select 0: not supported 1: supported 00: 1.5 Gbit/s mode";
            sw = rw; hw = r;
            reset = 0x0;
        } neg_mode_b[23:23];
        field {
            name = "gen2_en";
            desc = "Maximum interface rate control signal 01: 3 Gbit/s mode 11: reserved";
            sw = rw; hw = r;
            reset = 0x1;
        } gen2_en[22:21];
        field {
            name = "reserved_20_0";
            desc = "Reserved";
            sw = r; hw = na;
            reset = 0x40000;
        } reserved_20_0[20:0];
    } SATA_PORT_PHYCTL @ 0x174;
    reg {
        name = "SATA_PORT_PHYSTS";
        desc = "SATA_PORT_PHYSTS (offset 0x178, total reset 0x00000002; PROVEN: Hi3536D V100 data sheet).";
        field {
            name = "reserved_31_21";
            desc = "Reserved";
            sw = r; hw = w;
            reset = 0x0;
        } reserved_31_21[31:21];
        field {
            name = "current_state";
            desc = "Current status of the state machine at the PHY layer";
            sw = r; hw = w;
            reset = 0x0;
        } current_state[20:17];
        field {
            name = "spd_change";
            desc = "Rate change request";
            sw = r; hw = w;
            reset = 0x0;
        } spd_change[16:16];
        field {
            name = "link_rdy";
            desc = "Sufficient D10.2 is transmitted when this bit is 1.";
            sw = r; hw = w;
            reset = 0x0;
        } link_rdy[15:15];
        field {
            name = "init_compl";
            desc = "Non-align primitive is received and the initialization is complete when this bit is 1.";
            sw = r; hw = w;
            reset = 0x0;
        } init_compl[14:14];
        field {
            name = "pwr_state";
            desc = "Whether the controller is in low-power (slumber or partial) status 1: yes 0: no";
            sw = r; hw = w;
            reset = 0x0;
        } pwr_state[13:13];
        field {
            name = "rx_pll_pwron";
            desc = "PHY RX PLL power-on indicator, valid only for the Synopsys";
            sw = r; hw = w;
            reset = 0x0;
        } rx_pll_pwron[12:12];
        field {
            name = "reserved_11_11";
            desc = "PHY Reserved 3'b000: idle status";
            sw = r; hw = w;
            reset = 0x0;
        } reserved_11_11[11:11];
        field {
            name = "tx_en";
            desc = "Required status of the PHY TX 3'b001: low-power slumber status 3'b010: low-power partial status 3'b011: normal operating status";
            sw = r; hw = w;
            reset = 0x0;
        } tx_en[10:8];
        field {
            name = "reserved_7_7";
            desc = "Reserved";
            sw = r; hw = w;
            reset = 0x0;
        } reserved_7_7[7:7];
        field {
            name = "phy_comwake";
            desc = "The PHY detects COMWAKE when this bit is 1.";
            sw = r; hw = w;
            reset = 0x0;
        } phy_comwake[6:6];
        field {
            name = "phy_cominit";
            desc = "The PHY detects COMINIT when this bit is 1.";
            sw = r; hw = w;
            reset = 0x0;
        } phy_cominit[5:5];
        field {
            name = "half_rate";
            desc = "Rate mode of the PHY 0: full-speed mode 1: half-speed mode";
            sw = r; hw = w;
            reset = 0x0;
        } half_rate[4:3];
        field {
            name = "phyrdy";
            desc = "The OOB phase and the rate negotiation are complete at the link layer, and the data can be transmitted normally when this bit is 1. 0: Data is received on the RX differential line that is in normal";
            sw = r; hw = w;
            reset = 0x0;
        } phyrdy[2:2];
        field {
            name = "los";
            desc = "Status of the RX differential line operating status. 1: The RX differential line is in static idle status.";
            sw = r; hw = w;
            reset = 0x1;
        } los[1:1];
        field {
            name = "reserved_0_0";
            desc = "Reserved";
            sw = r; hw = w;
            reset = 0x0;
        } reserved_0_0[0:0];
    } SATA_PORT_PHYSTS @ 0x178;
    reg {
        name = "SATA_PORT_OUTSTANDING";
        desc = "SATA_PORT_OUTSTANDING is an AXI outstanding control register. (offset 0x17C, total reset 0x00000000; PROVEN: Hi3536D V100 data sheet).";
        field {
            name = "reserved_31_10";
            desc = "Reserved performed by the AXI master of each port 0xF: outstanding of 16 0x7: outstanding of 8";
            sw = r; hw = w;
            reset = 0x0;
        } reserved_31_10[31:10];
        field {
            name = "px_wr_otd_ctrl";
            desc = "Maximum outstanding capability during the write operation 0x3: outstanding of 4 0x1: outstanding of 2 0x0: outstanding of 1 Other values: reserved performed by the AXI master of each port 0xF: outstanding of 16 0x7: outstanding of 8";
            sw = rw; hw = r;
            reset = 0x0;
        } px_wr_otd_ctrl[9:6];
        field {
            name = "px_rd_otd_ctrl";
            desc = "Maximum outstanding capability during the read operation 0x3: outstanding of 4 0x1: outstanding of 2 0x0: outstanding of 1 Other values: reserved write operation performed by the AXI master of each port";
            sw = rw; hw = r;
            reset = 0x0;
        } px_rd_otd_ctrl[5:2];
        field {
            name = "px_wr_otd_en";
            desc = "Whether to control the maximum outstanding capability during the 0: no 1: yes read operation performed by the AXI master of each port";
            sw = rw; hw = r;
            reset = 0x0;
        } px_wr_otd_en[1:1];
        field {
            name = "px_rd_otd_en";
            desc = "Whether to control the maximum outstanding capability during the 0: no 1: yes 11.5.8 Appendix A Format of the SATA Command Linked List created in the system memory by software. The base address for the linked list is stored in the its destination address and transfers the received frames to different memory spaces. Figure 11-31 shows the structure of the FIS linked list. The linked list refers to ";
            sw = rw; hw = r;
            reset = 0x0;
        } px_rd_otd_en[0:0];
    } SATA_PORT_OUTSTANDING @ 0x17C;
};

`endif
