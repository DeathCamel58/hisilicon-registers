`ifndef HI3516AV100_IO_CONFIG_RDL
`define HI3516AV100_IO_CONFIG_RDL

regfile eIO_CONFIG {
    name = "IO configuration (pin multiplexing and pad control), Hi3516A/Hi3516D V100";
    desc = "
    0x200F0000..0x200F07FF: `muxctrl_regN` pin multiplexing control registers (123 registers, one per pin; the field value selects the pin function, 0 is the reset default; bits [31:n] are reserved, read 0 - the data sheet bit tables spell them `reseved`).
    0x200F0800..: `PADCTRL_REGn` pin drive capability (pad control) registers (136 registers: slew rate `_sr` and drive strength `_ds` per pin; PADCTRL_REG100/101 for the SAR ADC pins also carry Schmitt/pull-up/pull-down bits). The pad registers reset to non-zero values (slow edge, mid drive) as given per register.
    Source: Hi3516A/Hi3516D data sheet issue 08 (2016-10-28), English edition (no Chinese original is available in the tree, so a few ambiguous descriptions are flagged low confidence): 2.3 Pin Multiplexing Control Registers (Table 2-37, `hi3516av100--Hi3516A-Hi3516D-Datasheet.txt` lines 4671-8858) and 2.6 Pin Drive Capability Registers (Table 2-80, lines 10138-16170). Memory map Table 1-1: 'IO MUX register' 0x200F0000, 2 KB.
    Vendor cross-check: the vendor U-Boot `arch/arm/cpu/hi3516a/lowlevel_init_svb.c` writes 2 to MUX_CTRL_REG83/84 (0x200F014C/0x150: PWM0/PWM1 pins -> PMC_I2C_SCL/SDA) and the OpenIPC `load3516a` script writes 1 (SPI0) or 2 (I2C0) to 0x200F0050..0x5C (muxctrl_reg20-23, SPI0_SCLK/SDO/SDI/CSN pins); both agree with the encodings below.
    Hi3516D: same register set (one data sheet covers both parts; the Hi3516D has fewer bonded pins, see 2.1).
    ";

    reg {
        name = "Multiplexing control register for the SENSOR_CLK pin";
        desc = "muxctrl_reg0 is a multiplexing control register for the SENSOR_CLK pin.

Data sheet 2.3.2 muxctrl_reg0 (offset 0x0, printed page 2-70, `hi3516av100--Hi3516A-Hi3516D-Datasheet.txt` line 5007).";

        enum muxctrl_reg0_muxctrl_reg0_enum {
            GPIO0_5 = 0 { name = "Gpio0 5"; desc = "GPIO0_5"; };
            SENSOR_CLK = 1 { name = "Sensor Clk"; desc = "SENSOR_CLK"; };
        };

        field {
            name = "muxctrl_reg0";
            desc = "Multiplexing control for the SENSOR_CLK pin";
            sw = rw;
            hw = r;
            encode = muxctrl_reg0_muxctrl_reg0_enum;
            reset = 0x0;
        } muxctrl_reg0[0:0];
    } muxctrl_reg0 @ 0x0;

    reg {
        name = "Multiplexing control register for the FLASH_TRIG pin";
        desc = "muxctrl_reg1 is a multiplexing control register for the FLASH_TRIG pin.

Data sheet 2.3.2 muxctrl_reg1 (offset 0x4, printed page 2-70, `hi3516av100--Hi3516A-Hi3516D-Datasheet.txt` line 5034).";

        enum muxctrl_reg1_muxctrl_reg1_enum {
            GPIO0_6 = 0 { name = "Gpio0 6"; desc = "GPIO0_6"; };
            FLASH_TRIG = 1 { name = "Flash Trig"; desc = "FLASH_TRIG"; };
            SPI1_CSN1 = 2 { name = "Spi1 Csn1"; desc = "SPI1_CSN1"; };
            RESERVED = 3 { name = "Reserved"; desc = "reserved"; };
        };

        field {
            name = "muxctrl_reg1";
            desc = "Multiplexing control for the FLASH_TRIG pin";
            sw = rw;
            hw = r;
            encode = muxctrl_reg1_muxctrl_reg1_enum;
            reset = 0x0;
        } muxctrl_reg1[1:0];
    } muxctrl_reg1 @ 0x4;

    reg {
        name = "Multiplexing control register for the SHUTTER_TRIG pin";
        desc = "muxctrl_reg2 is a multiplexing control register for the SHUTTER_TRIG pin.

Data sheet 2.3.2 muxctrl_reg2 (offset 0x8, printed page 2-71, `hi3516av100--Hi3516A-Hi3516D-Datasheet.txt` line 5073).";

        enum muxctrl_reg2_muxctrl_reg2_enum {
            GPIO0_7 = 0 { name = "Gpio0 7"; desc = "GPIO0_7"; };
            SHUTTER_TRIG = 1 { name = "Shutter Trig"; desc = "SHUTTER_TRIG"; };
            SPI1_CSN2 = 2 { name = "Spi1 Csn2"; desc = "SPI1_CSN2"; };
            RESERVED = 3 { name = "Reserved"; desc = "reserved"; };
        };

        field {
            name = "muxctrl_reg2";
            desc = "Multiplexing control for the SHUTTER_TRIG pin";
            sw = rw;
            hw = r;
            encode = muxctrl_reg2_muxctrl_reg2_enum;
            reset = 0x0;
        } muxctrl_reg2[1:0];
    } muxctrl_reg2 @ 0x8;

    reg {
        name = "Multiplexing control register for the VO_CLK pin";
        desc = "muxctrl_reg3 is a multiplexing control register for the VO_CLK pin.

Data sheet 2.3.2 muxctrl_reg3 (offset 0xC, printed page 2-71, `hi3516av100--Hi3516A-Hi3516D-Datasheet.txt` line 5102).";

        enum muxctrl_reg3_muxctrl_reg3_enum {
            GPIO1_0 = 0 { name = "Gpio1 0"; desc = "GPIO1_0"; };
            VO_CLK = 1 { name = "Vo Clk"; desc = "VO_CLK"; };
        };

        field {
            name = "muxctrl_reg3";
            desc = "VO_CLK pin";
            sw = rw;
            hw = r;
            encode = muxctrl_reg3_muxctrl_reg3_enum;
            reset = 0x0;
        } muxctrl_reg3[0:0];
    } muxctrl_reg3 @ 0xC;

    reg {
        name = "Multiplexing control register for the VO_DAT15 pin";
        desc = "muxctrl_reg4 is a multiplexing control register for the VO_DAT15 pin.

Data sheet 2.3.2 muxctrl_reg4 (offset 0x10, printed page 2-72, `hi3516av100--Hi3516A-Hi3516D-Datasheet.txt` line 5139).";

        enum muxctrl_reg4_muxctrl_reg4_enum {
            GPIO6_0 = 0 { name = "Gpio6 0"; desc = "GPIO6_0"; };
            VO_DAT15 = 1 { name = "Vo Dat15"; desc = "VO_DAT15"; };
        };

        field {
            name = "muxctrl_reg4";
            desc = "Multiplexing control for the VO_DAT15 pin";
            sw = rw;
            hw = r;
            encode = muxctrl_reg4_muxctrl_reg4_enum;
            reset = 0x0;
        } muxctrl_reg4[0:0];
    } muxctrl_reg4 @ 0x10;

    reg {
        name = "Multiplexing control register for the VO_DAT14 pin";
        desc = "muxctrl_reg5 is a multiplexing control register for the VO_DAT14 pin.

Data sheet 2.3.2 muxctrl_reg5 (offset 0x14, printed page 2-72, `hi3516av100--Hi3516A-Hi3516D-Datasheet.txt` line 5166).";

        enum muxctrl_reg5_muxctrl_reg5_enum {
            GPIO6_1 = 0 { name = "Gpio6 1"; desc = "GPIO6_1"; };
            VO_DAT14 = 1 { name = "Vo Dat14"; desc = "VO_DAT14"; };
        };

        field {
            name = "muxctrl_reg5";
            desc = "Multiplexing control for the VO_DAT14 pin";
            sw = rw;
            hw = r;
            encode = muxctrl_reg5_muxctrl_reg5_enum;
            reset = 0x0;
        } muxctrl_reg5[0:0];
    } muxctrl_reg5 @ 0x14;

    reg {
        name = "Multiplexing control register for the VO_DAT13 pin";
        desc = "muxctrl_reg6 is a multiplexing control register for the VO_DAT13 pin.

Data sheet 2.3.2 muxctrl_reg6 (offset 0x18, printed page 2-73, `hi3516av100--Hi3516A-Hi3516D-Datasheet.txt` line 5203).";

        enum muxctrl_reg6_muxctrl_reg6_enum {
            GPIO6_2 = 0 { name = "Gpio6 2"; desc = "GPIO6_2"; };
            VO_DAT13 = 1 { name = "Vo Dat13"; desc = "VO_DAT13"; };
        };

        field {
            name = "muxctrl_reg6";
            desc = "Multiplexing control for the VO_DAT13 pin";
            sw = rw;
            hw = r;
            encode = muxctrl_reg6_muxctrl_reg6_enum;
            reset = 0x0;
        } muxctrl_reg6[0:0];
    } muxctrl_reg6 @ 0x18;

    reg {
        name = "Multiplexing control register for the VO_DAT12 pin";
        desc = "muxctrl_reg7 is a multiplexing control register for the VO_DAT12 pin.

Data sheet 2.3.2 muxctrl_reg7 (offset 0x1C, printed page 2-73, `hi3516av100--Hi3516A-Hi3516D-Datasheet.txt` line 5230).";

        enum muxctrl_reg7_muxctrl_reg7_enum {
            GPIO6_3 = 0 { name = "Gpio6 3"; desc = "GPIO6_3"; };
            VO_DAT12 = 1 { name = "Vo Dat12"; desc = "VO_DAT12"; };
        };

        field {
            name = "muxctrl_reg7";
            desc = "Multiplexing control for the VO_DAT12 pin";
            sw = rw;
            hw = r;
            encode = muxctrl_reg7_muxctrl_reg7_enum;
            reset = 0x0;
        } muxctrl_reg7[0:0];
    } muxctrl_reg7 @ 0x1C;

    reg {
        name = "Multiplexing control register for the VO_DAT11 pin";
        desc = "muxctrl_reg8 is a multiplexing control register for the VO_DAT11 pin.

Data sheet 2.3.2 muxctrl_reg8 (offset 0x20, printed page 2-74, `hi3516av100--Hi3516A-Hi3516D-Datasheet.txt` line 5267).";

        enum muxctrl_reg8_muxctrl_reg8_enum {
            GPIO6_4 = 0 { name = "Gpio6 4"; desc = "GPIO6_4"; };
            VO_DAT11 = 1 { name = "Vo Dat11"; desc = "VO_DAT11"; };
            SFC_NAND_BOOT = 2 { name = "Sfc Nand Boot"; desc = "SFC_NAND_BOOT_PIN2"; };
        };

        field {
            name = "muxctrl_reg8";
            desc = "Multiplexing control for the VO_DAT11 pin. Other values: reserved.";
            sw = rw;
            hw = r;
            encode = muxctrl_reg8_muxctrl_reg8_enum;
            reset = 0x0;
        } muxctrl_reg8[1:0];
    } muxctrl_reg8 @ 0x20;

    reg {
        name = "Multiplexing control register for the VO_DAT10 pin";
        desc = "muxctrl_reg9 is a multiplexing control register for the VO_DAT10 pin.

Data sheet 2.3.2 muxctrl_reg9 (offset 0x24, printed page 2-74, `hi3516av100--Hi3516A-Hi3516D-Datasheet.txt` line 5296).";

        enum muxctrl_reg9_muxctrl_reg9_enum {
            GPIO6_5 = 0 { name = "Gpio6 5"; desc = "GPIO6_5"; };
            VO_DAT10 = 1 { name = "Vo Dat10"; desc = "VO_DAT10"; };
            SFC_NAND_BOOT = 2 { name = "Sfc Nand Boot"; desc = "SFC_NAND_BOOT_PIN1"; };
        };

        field {
            name = "muxctrl_reg9";
            desc = "Multiplexing control for the VO_DAT10 pin. Other values: reserved.";
            sw = rw;
            hw = r;
            encode = muxctrl_reg9_muxctrl_reg9_enum;
            reset = 0x0;
        } muxctrl_reg9[1:0];
    } muxctrl_reg9 @ 0x24;

    reg {
        name = "Multiplexing control register for the";
        desc = "muxctrl_reg10 is a multiplexing control register for the VO_DAT9 pin.

Data sheet 2.3.2 muxctrl_reg10 (offset 0x28, printed page 2-75, `hi3516av100--Hi3516A-Hi3516D-Datasheet.txt` line 5331).";

        enum muxctrl_reg10_muxctrl_reg10_enum {
            GPIO6_6 = 0 { name = "Gpio6 6"; desc = "GPIO6_6"; };
            VO_DAT9 = 1 { name = "Vo Dat9"; desc = "VO_DAT9"; };
            SFC_NAND_BOOT = 2 { name = "Sfc Nand Boot"; desc = "SFC_NAND_BOOT_PIN0"; };
        };

        field {
            name = "muxctrl_reg10";
            desc = "Multiplexing control for the VO_DAT9 pin. Other values: reserved.";
            sw = rw;
            hw = r;
            encode = muxctrl_reg10_muxctrl_reg10_enum;
            reset = 0x0;
        } muxctrl_reg10[1:0];
    } muxctrl_reg10 @ 0x28;

    reg {
        name = "Multiplexing control register for the VO_DAT8 pin";
        desc = "muxctrl_reg11 is a multiplexing control register for the VO_DAT8 pin.

Data sheet 2.3.2 muxctrl_reg11 (offset 0x2C, printed page 2-75, `hi3516av100--Hi3516A-Hi3516D-Datasheet.txt` line 5360).";

        enum muxctrl_reg11_muxctrl_reg11_enum {
            GPIO6_7 = 0 { name = "Gpio6 7"; desc = "GPIO6_7"; };
            VO_DAT8 = 1 { name = "Vo Dat8"; desc = "VO_DAT8"; };
        };

        field {
            name = "muxctrl_reg11";
            desc = "Multiplexing control for the VO_DAT8 pin";
            sw = rw;
            hw = r;
            encode = muxctrl_reg11_muxctrl_reg11_enum;
            reset = 0x0;
        } muxctrl_reg11[0:0];
    } muxctrl_reg11 @ 0x2C;

    reg {
        name = "Multiplexing control register for the VO_DAT7 pin";
        desc = "muxctrl_reg12 is a multiplexing control register for the VO_DAT7 pin.

Data sheet 2.3.2 muxctrl_reg12 (offset 0x30, printed page 2-76, `hi3516av100--Hi3516A-Hi3516D-Datasheet.txt` line 5393).";

        enum muxctrl_reg12_muxctrl_reg12_enum {
            GPIO7_0 = 0 { name = "Gpio7 0"; desc = "GPIO7_0"; };
            VO_DAT7 = 1 { name = "Vo Dat7"; desc = "VO_DAT7"; };
        };

        field {
            name = "muxctrl_reg12";
            desc = "Multiplexing control for the VO_DAT7 pin";
            sw = rw;
            hw = r;
            encode = muxctrl_reg12_muxctrl_reg12_enum;
            reset = 0x0;
        } muxctrl_reg12[0:0];
    } muxctrl_reg12 @ 0x30;

    reg {
        name = "Multiplexing control register for the VO_DAT6 pin";
        desc = "muxctrl_reg13 is a multiplexing control register for the VO_DAT6 pin.

Data sheet 2.3.2 muxctrl_reg13 (offset 0x34, printed page 2-76, `hi3516av100--Hi3516A-Hi3516D-Datasheet.txt` line 5420).";

        enum muxctrl_reg13_muxctrl_reg13_enum {
            GPIO7_1 = 0 { name = "Gpio7 1"; desc = "GPIO7_1"; };
            VO_DAT6 = 1 { name = "Vo Dat6"; desc = "VO_DAT6"; };
        };

        field {
            name = "muxctrl_reg13";
            desc = "Multiplexing control for the VO_DAT6 pin";
            sw = rw;
            hw = r;
            encode = muxctrl_reg13_muxctrl_reg13_enum;
            reset = 0x0;
        } muxctrl_reg13[0:0];
    } muxctrl_reg13 @ 0x34;

    reg {
        name = "Multiplexing control register for the VO_DAT5 pin";
        desc = "muxctrl_reg14 is a multiplexing control register for the VO_DAT5 pin.

Data sheet 2.3.2 muxctrl_reg14 (offset 0x38, printed page 2-77, `hi3516av100--Hi3516A-Hi3516D-Datasheet.txt` line 5455).";

        enum muxctrl_reg14_muxctrl_reg14_enum {
            GPIO7_2 = 0 { name = "Gpio7 2"; desc = "GPIO7_2"; };
            VO_DAT5 = 1 { name = "Vo Dat5"; desc = "VO_DAT5"; };
        };

        field {
            name = "muxctrl_reg14";
            desc = "Multiplexing control for the VO_DAT5 pin";
            sw = rw;
            hw = r;
            encode = muxctrl_reg14_muxctrl_reg14_enum;
            reset = 0x0;
        } muxctrl_reg14[0:0];
    } muxctrl_reg14 @ 0x38;

    reg {
        name = "Multiplexing control register for the VO_DAT4 pin";
        desc = "muxctrl_reg15 is a multiplexing control register for the VO_DAT4 pin.

Data sheet 2.3.2 muxctrl_reg15 (offset 0x3C, printed page 2-77, `hi3516av100--Hi3516A-Hi3516D-Datasheet.txt` line 5482).";

        enum muxctrl_reg15_muxctrl_reg15_enum {
            GPIO7_3 = 0 { name = "Gpio7 3"; desc = "GPIO7_3"; };
            VO_DAT4 = 1 { name = "Vo Dat4"; desc = "VO_DAT4"; };
        };

        field {
            name = "muxctrl_reg15";
            desc = "Multiplexing control for the VO_DAT4 pin";
            sw = rw;
            hw = r;
            encode = muxctrl_reg15_muxctrl_reg15_enum;
            reset = 0x0;
        } muxctrl_reg15[0:0];
    } muxctrl_reg15 @ 0x3C;

    reg {
        name = "Multiplexing control register for the VO_DAT3 pin";
        desc = "muxctrl_reg16 is a multiplexing control register for the VO_DAT3 pin.

Data sheet 2.3.2 muxctrl_reg16 (offset 0x40, printed page 2-78, `hi3516av100--Hi3516A-Hi3516D-Datasheet.txt` line 5519).";

        enum muxctrl_reg16_muxctrl_reg16_enum {
            GPIO7_4 = 0 { name = "Gpio7 4"; desc = "GPIO7_4"; };
            VO_DAT3 = 1 { name = "Vo Dat3"; desc = "VO_DAT3"; };
            SFC_DEVICE_MODE = 2 { name = "Sfc Device Mode"; desc = "SFC_DEVICE_MODE"; };
        };

        field {
            name = "muxctrl_reg16";
            desc = "Multiplexing control for the VO_DAT3 pin. Other values: reserved.";
            sw = rw;
            hw = r;
            encode = muxctrl_reg16_muxctrl_reg16_enum;
            reset = 0x0;
        } muxctrl_reg16[1:0];
    } muxctrl_reg16 @ 0x40;

    reg {
        name = "Multiplexing control register for the VO_DAT2 pin";
        desc = "muxctrl_reg17 is a multiplexing control register for the VO_DAT2 pin.

Data sheet 2.3.2 muxctrl_reg17 (offset 0x44, printed page 2-78, `hi3516av100--Hi3516A-Hi3516D-Datasheet.txt` line 5548).";

        enum muxctrl_reg17_muxctrl_reg17_enum {
            GPIO7_5 = 0 { name = "Gpio7 5"; desc = "GPIO7_5"; };
            VO_DAT2 = 1 { name = "Vo Dat2"; desc = "VO_DAT2"; };
        };

        field {
            name = "muxctrl_reg17";
            desc = "Multiplexing control for the VO_DAT2 pin";
            sw = rw;
            hw = r;
            encode = muxctrl_reg17_muxctrl_reg17_enum;
            reset = 0x0;
        } muxctrl_reg17[0:0];
    } muxctrl_reg17 @ 0x44;

    reg {
        name = "Multiplexing control register for the VO_DAT1 pin";
        desc = "muxctrl_reg18 is a multiplexing control register for the VO_DAT1 pin.

Data sheet 2.3.2 muxctrl_reg18 (offset 0x48, printed page 2-79, `hi3516av100--Hi3516A-Hi3516D-Datasheet.txt` line 5585).";

        enum muxctrl_reg18_muxctrl_reg18_enum {
            GPIO7_6 = 0 { name = "Gpio7 6"; desc = "GPIO7_6"; };
            VO_DAT1 = 1 { name = "Vo Dat1"; desc = "VO_DAT1"; };
            BOOTROM_SEL = 2 { name = "Bootrom Sel"; desc = "BOOTROM_SEL"; };
        };

        field {
            name = "muxctrl_reg18";
            desc = "Multiplexing control for the VO_DAT1 pin. Other values: reserved.";
            sw = rw;
            hw = r;
            encode = muxctrl_reg18_muxctrl_reg18_enum;
            reset = 0x0;
        } muxctrl_reg18[1:0];
    } muxctrl_reg18 @ 0x48;

    reg {
        name = "Multiplexing control register for the VO_DAT0 pin";
        desc = "muxctrl_reg19 is a multiplexing control register for the VO_DAT0 pin.

Data sheet 2.3.2 muxctrl_reg19 (offset 0x4C, printed page 2-79, `hi3516av100--Hi3516A-Hi3516D-Datasheet.txt` line 5614).";

        enum muxctrl_reg19_muxctrl_reg19_enum {
            GPIO7_7 = 0 { name = "Gpio7 7"; desc = "GPIO7_7"; };
            VO_DAT0 = 1 { name = "Vo Dat0"; desc = "VO_DAT0"; };
            BOOT_SEL = 2 { name = "Boot Sel"; desc = "BOOT_SEL"; };
        };

        field {
            name = "muxctrl_reg19";
            desc = "Multiplexing control for the VO_DAT0 pin. Other values: reserved.";
            sw = rw;
            hw = r;
            encode = muxctrl_reg19_muxctrl_reg19_enum;
            reset = 0x0;
        } muxctrl_reg19[1:0];
    } muxctrl_reg19 @ 0x4C;

    reg {
        name = "Multiplexing control register for the SPI0_SCLK pin";
        desc = "muxctrl_reg20 is a multiplexing control register for the SPI0_SCLK pin.

Data sheet 2.3.2 muxctrl_reg20 (offset 0x50, printed page 2-80, `hi3516av100--Hi3516A-Hi3516D-Datasheet.txt` line 5649).";

        enum muxctrl_reg20_muxctrl_reg20_enum {
            GPIO8_0 = 0 { name = "Gpio8 0"; desc = "GPIO8_0"; };
            SPI0_SCLK = 1 { name = "Spi0 Sclk"; desc = "SPI0_SCLK"; };
            I2C0_SCL = 2 { name = "I2C0 Scl"; desc = "I2C0_SCL"; };
        };

        field {
            name = "muxctrl_reg20";
            desc = "Multiplexing control for the SPI0_SCLK pin. Other values: reserved.";
            sw = rw;
            hw = r;
            encode = muxctrl_reg20_muxctrl_reg20_enum;
            reset = 0x0;
        } muxctrl_reg20[1:0];
    } muxctrl_reg20 @ 0x50;

    reg {
        name = "Multiplexing control register for the SPI0_SDO pin";
        desc = "muxctrl_reg21 is a multiplexing control register for the SPI0_SDO pin.

Data sheet 2.3.2 muxctrl_reg21 (offset 0x54, printed page 2-80, `hi3516av100--Hi3516A-Hi3516D-Datasheet.txt` line 5678).";

        enum muxctrl_reg21_muxctrl_reg21_enum {
            GPIO8_1 = 0 { name = "Gpio8 1"; desc = "GPIO8_1"; };
            SPI0_SDO = 1 { name = "Spi0 Sdo"; desc = "SPI0_SDO"; };
            I2C0_SDA = 2 { name = "I2C0 Sda"; desc = "I2C0_SDA"; };
        };

        field {
            name = "muxctrl_reg21";
            desc = "Multiplexing control for the SPI0_SDO pin. Other values: reserved.";
            sw = rw;
            hw = r;
            encode = muxctrl_reg21_muxctrl_reg21_enum;
            reset = 0x0;
        } muxctrl_reg21[1:0];
    } muxctrl_reg21 @ 0x54;

    reg {
        name = "Multiplexing control register for the SPI0_SDI pin";
        desc = "muxctrl_reg22 is a multiplexing control register for the SPI0_SDI pin.

Data sheet 2.3.2 muxctrl_reg22 (offset 0x58, printed page 2-81, `hi3516av100--Hi3516A-Hi3516D-Datasheet.txt` line 5713).";

        enum muxctrl_reg22_muxctrl_reg22_enum {
            GPIO8_2 = 0 { name = "Gpio8 2"; desc = "GPIO8_2"; };
            SPI0_SDI = 1 { name = "Spi0 Sdi"; desc = "SPI0_SDI"; };
        };

        field {
            name = "muxctrl_reg22";
            desc = "Multiplexing control for the SPI0_SDI pin";
            sw = rw;
            hw = r;
            encode = muxctrl_reg22_muxctrl_reg22_enum;
            reset = 0x0;
        } muxctrl_reg22[0:0];
    } muxctrl_reg22 @ 0x58;

    reg {
        name = "Multiplexing control register for the SPI0_CSN pin";
        desc = "muxctrl_reg23 is a multiplexing control register for the SPI0_CSN pin.

Data sheet 2.3.2 muxctrl_reg23 (offset 0x5C, printed page 2-81, `hi3516av100--Hi3516A-Hi3516D-Datasheet.txt` line 5741).";

        enum muxctrl_reg23_muxctrl_reg23_enum {
            GPIO8_3 = 0 { name = "Gpio8 3"; desc = "GPIO8_3"; };
            SPI0_CSN = 1 { name = "Spi0 Csn"; desc = "SPI0_CSN"; };
        };

        field {
            name = "muxctrl_reg23";
            desc = "Multiplexing control for the SPI0_CSN pin";
            sw = rw;
            hw = r;
            encode = muxctrl_reg23_muxctrl_reg23_enum;
            reset = 0x0;
        } muxctrl_reg23[0:0];
    } muxctrl_reg23 @ 0x5C;

    reg {
        name = "Multiplexing control register for the SPI1_SCLK pin";
        desc = "muxctrl_reg24 is a multiplexing control register for the SPI1_SCLK pin.

Data sheet 2.3.2 muxctrl_reg24 (offset 0x60, printed page 2-82, `hi3516av100--Hi3516A-Hi3516D-Datasheet.txt` line 5774).";

        enum muxctrl_reg24_muxctrl_reg24_enum {
            GPIO8_4 = 0 { name = "Gpio8 4"; desc = "GPIO8_4"; };
            SPI1_SCLK = 1 { name = "Spi1 Sclk"; desc = "SPI1_SCLK"; };
            I2C1_SCL = 2 { name = "I2C1 Scl"; desc = "I2C1_SCL"; };
        };

        field {
            name = "muxctrl_reg24";
            desc = "Multiplexing control for the SPI1_SCLK pin. Other values: reserved.";
            sw = rw;
            hw = r;
            encode = muxctrl_reg24_muxctrl_reg24_enum;
            reset = 0x0;
        } muxctrl_reg24[1:0];
    } muxctrl_reg24 @ 0x60;

    reg {
        name = "Multiplexing control register for the SPI1_SDO pin";
        desc = "muxctrl_reg25 is a multiplexing control register for the SPI1_SDO pin.

Data sheet 2.3.2 muxctrl_reg25 (offset 0x64, printed page 2-82, `hi3516av100--Hi3516A-Hi3516D-Datasheet.txt` line 5803).";

        enum muxctrl_reg25_muxctrl_reg25_enum {
            GPIO8_5 = 0 { name = "Gpio8 5"; desc = "GPIO8_5"; };
            SPI1_SDO = 1 { name = "Spi1 Sdo"; desc = "SPI1_SDO"; };
            I2C1_SDA = 2 { name = "I2C1 Sda"; desc = "I2C1_SDA"; };
        };

        field {
            name = "muxctrl_reg25";
            desc = "Multiplexing control for the SPI1_SDO pin. Other values: reserved.";
            sw = rw;
            hw = r;
            encode = muxctrl_reg25_muxctrl_reg25_enum;
            reset = 0x0;
        } muxctrl_reg25[1:0];
    } muxctrl_reg25 @ 0x64;

    reg {
        name = "Multiplexing control register for the SPI1_SDI pin";
        desc = "muxctrl_reg26 is a multiplexing control register for the SPI1_SDI pin.

Data sheet 2.3.2 muxctrl_reg26 (offset 0x68, printed page 2-83, `hi3516av100--Hi3516A-Hi3516D-Datasheet.txt` line 5838).";

        enum muxctrl_reg26_muxctrl_reg26_enum {
            GPIO8_6 = 0 { name = "Gpio8 6"; desc = "GPIO8_6"; };
            SPI1_SDI = 1 { name = "Spi1 Sdi"; desc = "SPI1_SDI"; };
        };

        field {
            name = "muxctrl_reg26";
            desc = "Multiplexing control for the SPI1_SDI pin";
            sw = rw;
            hw = r;
            encode = muxctrl_reg26_muxctrl_reg26_enum;
            reset = 0x0;
        } muxctrl_reg26[0:0];
    } muxctrl_reg26 @ 0x68;

    reg {
        name = "Multiplexing control register for the SPI1_CSN0 pin";
        desc = "SPI1_CSN0 is a multiplexing control register for the SPI1_CSN pin.

Data sheet 2.3.2 muxctrl_reg27 (offset 0x6C, printed page 2-83, `hi3516av100--Hi3516A-Hi3516D-Datasheet.txt` line 5865).";

        enum muxctrl_reg27_muxctrl_reg27_enum {
            GPIO8_7 = 0 { name = "Gpio8 7"; desc = "GPIO8_7"; };
            SPI1_CSN0 = 1 { name = "Spi1 Csn0"; desc = "SPI1_CSN0"; };
        };

        field {
            name = "muxctrl_reg27";
            desc = "Multiplexing control for the SPI1_CSN0 pin";
            sw = rw;
            hw = r;
            encode = muxctrl_reg27_muxctrl_reg27_enum;
            reset = 0x0;
        } muxctrl_reg27[0:0];
    } muxctrl_reg27 @ 0x6C;

    reg {
        name = "Multiplexing control register for the I2C2_SDA pin";
        desc = "muxctrl_reg28 is a multiplexing control register for the I2C2_SDA pin.

Data sheet 2.3.2 muxctrl_reg28 (offset 0x70, printed page 2-84, `hi3516av100--Hi3516A-Hi3516D-Datasheet.txt` line 5900).";

        enum muxctrl_reg28_muxctrl_reg28_enum {
            GPIO9_0 = 0 { name = "Gpio9 0"; desc = "GPIO9_0"; };
            I2C2_SDA = 1 { name = "I2C2 Sda"; desc = "I2C2_SDA"; };
        };

        field {
            name = "muxctrl_reg28";
            desc = "Multiplexing control for the I2C2_SDA pin";
            sw = rw;
            hw = r;
            encode = muxctrl_reg28_muxctrl_reg28_enum;
            reset = 0x0;
        } muxctrl_reg28[0:0];
    } muxctrl_reg28 @ 0x70;

    reg {
        name = "Multiplexing control register for the I2C2_SCL pin";
        desc = "muxctrl_reg29 is a multiplexing control register for the I2C2_SCL pin.

Data sheet 2.3.2 muxctrl_reg29 (offset 0x74, printed page 2-84, `hi3516av100--Hi3516A-Hi3516D-Datasheet.txt` line 5928).";

        enum muxctrl_reg29_muxctrl_reg29_enum {
            GPIO9_1 = 0 { name = "Gpio9 1"; desc = "GPIO9_1"; };
            I2C2_SCL = 1 { name = "I2C2 Scl"; desc = "I2C2_SCL"; };
        };

        field {
            name = "muxctrl_reg29";
            desc = "Multiplexing control for the I2C2_SCL pin";
            sw = rw;
            hw = r;
            encode = muxctrl_reg29_muxctrl_reg29_enum;
            reset = 0x0;
        } muxctrl_reg29[0:0];
    } muxctrl_reg29 @ 0x74;

    reg {
        name = "Multiplexing control register for the UART1_RTSN pin";
        desc = "muxctrl_reg30 is a multiplexing control register for the UART1_RTSN pin.

Data sheet 2.3.2 muxctrl_reg30 (offset 0x78, printed page 2-85, `hi3516av100--Hi3516A-Hi3516D-Datasheet.txt` line 5965).";

        enum muxctrl_reg30_muxctrl_reg30_enum {
            GPIO9_2 = 0 { name = "Gpio9 2"; desc = "GPIO9_2"; };
            UART1_RTSN = 1 { name = "Uart1 Rtsn"; desc = "UART1_RTSN"; };
            UART3_RXD = 2 { name = "Uart3 Rxd"; desc = "UART3_RXD"; };
        };

        field {
            name = "muxctrl_reg30";
            desc = "Multiplexing control for the UART1_RTSN pin. Other values: reserved.";
            sw = rw;
            hw = r;
            encode = muxctrl_reg30_muxctrl_reg30_enum;
            reset = 0x0;
        } muxctrl_reg30[1:0];
    } muxctrl_reg30 @ 0x78;

    reg {
        name = "Multiplexing control register for the UART1_RXD pin";
        desc = "muxctrl_reg31 is a multiplexing control register for the UART1_RXD pin.

Data sheet 2.3.2 muxctrl_reg31 (offset 0x7C, printed page 2-85, `hi3516av100--Hi3516A-Hi3516D-Datasheet.txt` line 5994).";

        enum muxctrl_reg31_muxctrl_reg31_enum {
            GPIO9_3 = 0 { name = "Gpio9 3"; desc = "GPIO9_3"; };
            UART1_RXD = 1 { name = "Uart1 Rxd"; desc = "UART1_RXD"; };
        };

        field {
            name = "muxctrl_reg31";
            desc = "Multiplexing control for the UART1_RXD pin";
            sw = rw;
            hw = r;
            encode = muxctrl_reg31_muxctrl_reg31_enum;
            reset = 0x0;
        } muxctrl_reg31[0:0];
    } muxctrl_reg31 @ 0x7C;

    reg {
        name = "Multiplexing control register for the UART1_CTSN pin";
        desc = "muxctrl_reg32 is a multiplexing control register for the UART1_CTSN pin.

Data sheet 2.3.2 muxctrl_reg32 (offset 0x80, printed page 2-86, `hi3516av100--Hi3516A-Hi3516D-Datasheet.txt` line 6031).";

        enum muxctrl_reg32_muxctrl_reg32_enum {
            GPIO9_4 = 0 { name = "Gpio9 4"; desc = "GPIO9_4"; };
            UART1_CTSN = 1 { name = "Uart1 Ctsn"; desc = "UART1_CTSN"; };
            UART3_TXD = 2 { name = "Uart3 Txd"; desc = "UART3_TXD"; };
        };

        field {
            name = "muxctrl_reg32";
            desc = "Multiplexing control for the UART1_CTSN pin. Other values: reserved.";
            sw = rw;
            hw = r;
            encode = muxctrl_reg32_muxctrl_reg32_enum;
            reset = 0x0;
        } muxctrl_reg32[1:0];
    } muxctrl_reg32 @ 0x80;

    reg {
        name = "Multiplexing control register for the UART1_TXD pin";
        desc = "muxctrl_reg33 is a multiplexing control register for the UART1_TXD pin.

Data sheet 2.3.2 muxctrl_reg33 (offset 0x84, printed page 2-86, `hi3516av100--Hi3516A-Hi3516D-Datasheet.txt` line 6060).";

        enum muxctrl_reg33_muxctrl_reg33_enum {
            GPIO9_5 = 0 { name = "Gpio9 5"; desc = "GPIO9_5"; };
            UART1_TXD = 1 { name = "Uart1 Txd"; desc = "UART1_TXD"; };
        };

        field {
            name = "muxctrl_reg33";
            desc = "Multiplexing control for the UART1_TXD pin";
            sw = rw;
            hw = r;
            encode = muxctrl_reg33_muxctrl_reg33_enum;
            reset = 0x0;
        } muxctrl_reg33[0:0];
    } muxctrl_reg33 @ 0x84;

    reg {
        name = "Multiplexing control register for the UART2_RXD pin";
        desc = "muxctrl_reg34 is a multiplexing control register for the UART2_RXD pin.

Data sheet 2.3.2 muxctrl_reg34 (offset 0x88, printed page 2-87, `hi3516av100--Hi3516A-Hi3516D-Datasheet.txt` line 6097).";

        enum muxctrl_reg34_muxctrl_reg34_enum {
            GPIO9_6 = 0 { name = "Gpio9 6"; desc = "GPIO9_6"; };
            UART2_RXD = 1 { name = "Uart2 Rxd"; desc = "UART2_RXD"; };
            I2S_BCLK_RX = 2 { name = "I2S Bclk Rx"; desc = "I2S_BCLK_RX"; };
        };

        field {
            name = "muxctrl_reg34";
            desc = "Multiplexing control for the UART2_RXD pin. Other values: reserved.";
            sw = rw;
            hw = r;
            encode = muxctrl_reg34_muxctrl_reg34_enum;
            reset = 0x0;
        } muxctrl_reg34[1:0];
    } muxctrl_reg34 @ 0x88;

    reg {
        name = "Multiplexing control register for the UART2_TXD pin";
        desc = "muxctrl_reg35 is a multiplexing control register for the UART2_TXD pin.

Data sheet 2.3.2 muxctrl_reg35 (offset 0x8C, printed page 2-87, `hi3516av100--Hi3516A-Hi3516D-Datasheet.txt` line 6126).";

        enum muxctrl_reg35_muxctrl_reg35_enum {
            GPIO9_7 = 0 { name = "Gpio9 7"; desc = "GPIO9_7"; };
            UART2_TXD = 1 { name = "Uart2 Txd"; desc = "UART2_TXD"; };
            I2S_WS_RX = 2 { name = "I2S Ws Rx"; desc = "I2S_WS_RX"; };
        };

        field {
            name = "muxctrl_reg35";
            desc = "Multiplexing control for the UART2_TXD pin. Other values: reserved.";
            sw = rw;
            hw = r;
            encode = muxctrl_reg35_muxctrl_reg35_enum;
            reset = 0x0;
        } muxctrl_reg35[1:0];
    } muxctrl_reg35 @ 0x8C;

    reg {
        name = "Multiplexing control register for the JTAG_TRSTN pin";
        desc = "muxctrl_reg36 is a multiplexing control register for the JTAG_TRSTN pin.

Data sheet 2.3.2 muxctrl_reg36 (offset 0x90, printed page 2-88, `hi3516av100--Hi3516A-Hi3516D-Datasheet.txt` line 6161).";

        enum muxctrl_reg36_muxctrl_reg36_enum {
            GPIO10_0 = 0 { name = "Gpio10 0"; desc = "GPIO10_0"; };
            JTAG_TRSTN = 1 { name = "Jtag Trstn"; desc = "JTAG_TRSTN"; };
            I2S_MCLK = 2 { name = "I2S Mclk"; desc = "I2S_MCLK"; };
        };

        field {
            name = "muxctrl_reg36";
            desc = "Multiplexing control for the JTAG_TRSTN pin. Other values: reserved.";
            sw = rw;
            hw = r;
            encode = muxctrl_reg36_muxctrl_reg36_enum;
            reset = 0x0;
        } muxctrl_reg36[1:0];
    } muxctrl_reg36 @ 0x90;

    reg {
        name = "Multiplexing control register for the JTAG_TCK pin";
        desc = "muxctrl_reg37 is a multiplexing control register for the JTAG_TCK pin.

Data sheet 2.3.2 muxctrl_reg37 (offset 0x94, printed page 2-88, `hi3516av100--Hi3516A-Hi3516D-Datasheet.txt` line 6190).";

        enum muxctrl_reg37_muxctrl_reg37_enum {
            GPIO10_1 = 0 { name = "Gpio10 1"; desc = "GPIO10_1"; };
            JTAG_TCK = 1 { name = "Jtag Tck"; desc = "JTAG_TCK"; };
            I2S_BCLK_TX = 2 { name = "I2S Bclk Tx"; desc = "I2S_BCLK_TX"; };
        };

        field {
            name = "muxctrl_reg37";
            desc = "Multiplexing control for the JTAG_TCK pin. Other values: reserved.";
            sw = rw;
            hw = r;
            encode = muxctrl_reg37_muxctrl_reg37_enum;
            reset = 0x0;
        } muxctrl_reg37[1:0];
    } muxctrl_reg37 @ 0x94;

    reg {
        name = "Multiplexing control register for the JTAG_TMS pin";
        desc = "muxctrl_reg38 is a multiplexing control register for the JTAG_TMS pin.

Data sheet 2.3.2 muxctrl_reg38 (offset 0x98, printed page 2-89, `hi3516av100--Hi3516A-Hi3516D-Datasheet.txt` line 6225).";

        enum muxctrl_reg38_muxctrl_reg38_enum {
            GPIO10_2 = 0 { name = "Gpio10 2"; desc = "GPIO10_2"; };
            JTAG_TMS = 1 { name = "Jtag Tms"; desc = "JTAG_TMS"; };
            I2S_WS_TX = 2 { name = "I2S Ws Tx"; desc = "I2S_WS_TX"; };
        };

        field {
            name = "muxctrl_reg38";
            desc = "Multiplexing control for the JTAG_TMS pin. Other values: reserved.";
            sw = rw;
            hw = r;
            encode = muxctrl_reg38_muxctrl_reg38_enum;
            reset = 0x0;
        } muxctrl_reg38[1:0];
    } muxctrl_reg38 @ 0x98;

    reg {
        name = "Multiplexing control register for the JTAG_TDO pin";
        desc = "muxctrl_reg39 is a multiplexing control register for the JTAG_TDO pin.

Data sheet 2.3.2 muxctrl_reg39 (offset 0x9C, printed page 2-89, `hi3516av100--Hi3516A-Hi3516D-Datasheet.txt` line 6254).";

        enum muxctrl_reg39_muxctrl_reg39_enum {
            GPIO10_3 = 0 { name = "Gpio10 3"; desc = "GPIO10_3"; };
            JTAG_TDO = 1 { name = "Jtag Tdo"; desc = "JTAG_TDO"; };
            I2S_SD_RX = 2 { name = "I2S Sd Rx"; desc = "I2S_SD_RX"; };
        };

        field {
            name = "muxctrl_reg39";
            desc = "Multiplexing control for the JTAG_TDO pin. Other values: reserved.";
            sw = rw;
            hw = r;
            encode = muxctrl_reg39_muxctrl_reg39_enum;
            reset = 0x0;
        } muxctrl_reg39[1:0];
    } muxctrl_reg39 @ 0x9C;

    reg {
        name = "Multiplexing control register for the JTAG_TDI pin";
        desc = "muxctrl_reg40 is a multiplexing control register for the JTAG_TDI pin.

Data sheet 2.3.2 muxctrl_reg40 (offset 0xA0, printed page 2-90, `hi3516av100--Hi3516A-Hi3516D-Datasheet.txt` line 6289).";

        enum muxctrl_reg40_muxctrl_reg40_enum {
            GPIO10_4 = 0 { name = "Gpio10 4"; desc = "GPIO10_4"; };
            JTAG_TDI = 1 { name = "Jtag Tdi"; desc = "JTAG_TDI"; };
            I2S_SD_TX = 2 { name = "I2S Sd Tx"; desc = "I2S_SD_TX"; };
        };

        field {
            name = "muxctrl_reg40";
            desc = "Multiplexing control for the JTAG_TDI pin. Other values: reserved.";
            sw = rw;
            hw = r;
            encode = muxctrl_reg40_muxctrl_reg40_enum;
            reset = 0x0;
        } muxctrl_reg40[1:0];
    } muxctrl_reg40 @ 0xA0;

    reg {
        name = "Multiplexing control register for the IR_IN pin";
        desc = "muxctrl_reg41 is a multiplexing control register for the IR_IN pin.

Data sheet 2.3.2 muxctrl_reg41 (offset 0xA4, printed page 2-90, `hi3516av100--Hi3516A-Hi3516D-Datasheet.txt` line 6318).";

        enum muxctrl_reg41_muxctrl_reg41_enum {
            GPIO10_5 = 0 { name = "Gpio10 5"; desc = "GPIO10_5"; };
            IR = 1 { name = "Ir"; desc = "IR_IN"; };
            PWM4 = 2 { name = "Pwm4"; desc = "PWM4"; };
        };

        field {
            name = "muxctrl_reg41";
            desc = "Multiplexing control for the IR_IN pin. Other values: reserved.";
            sw = rw;
            hw = r;
            encode = muxctrl_reg41_muxctrl_reg41_enum;
            reset = 0x0;
        } muxctrl_reg41[1:0];
    } muxctrl_reg41 @ 0xA4;

    reg {
        name = "Multiplexing control register for the USB_OVRCUR pin";
        desc = "muxctrl_reg42 is a multiplexing control register for the USB_OVRCUR pin.

Data sheet 2.3.2 muxctrl_reg42 (offset 0xA8, printed page 2-91, `hi3516av100--Hi3516A-Hi3516D-Datasheet.txt` line 6353).";

        enum muxctrl_reg42_muxctrl_reg42_enum {
            GPIO10_6 = 0 { name = "Gpio10 6"; desc = "GPIO10_6"; };
            USB_OVRCUR = 1 { name = "Usb Ovrcur"; desc = "USB_OVRCUR"; };
        };

        field {
            name = "muxctrl_reg42";
            desc = "Multiplexing control for the USB_OVRCUR pin";
            sw = rw;
            hw = r;
            encode = muxctrl_reg42_muxctrl_reg42_enum;
            reset = 0x0;
        } muxctrl_reg42[0:0];
    } muxctrl_reg42 @ 0xA8;

    reg {
        name = "Multiplexing control register for the USB_PWREN pin";
        desc = "muxctrl_reg43 is a multiplexing control register for the USB_PWREN pin.

Data sheet 2.3.2 muxctrl_reg43 (offset 0xAC, printed page 2-91, `hi3516av100--Hi3516A-Hi3516D-Datasheet.txt` line 6381).";

        enum muxctrl_reg43_muxctrl_reg43_enum {
            GPIO10_7 = 0 { name = "Gpio10 7"; desc = "GPIO10_7"; };
            USB_PWREN = 1 { name = "Usb Pwren"; desc = "USB_PWREN"; };
        };

        field {
            name = "muxctrl_reg43";
            desc = "Multiplexing control for the USB_PWREN pin";
            sw = rw;
            hw = r;
            encode = muxctrl_reg43_muxctrl_reg43_enum;
            reset = 0x0;
        } muxctrl_reg43[0:0];
    } muxctrl_reg43 @ 0xAC;

    reg {
        name = "Multiplexing control register for the SDIO0_CCLK_OUT pin";
        desc = "muxctrl_reg44 is a multiplexing control register for the SDIO0_CCLK_OUT pin.

Data sheet 2.3.2 muxctrl_reg44 (offset 0xB0, printed page 2-92, `hi3516av100--Hi3516A-Hi3516D-Datasheet.txt` line 6414).";

        enum muxctrl_reg44_muxctrl_reg44_enum {
            GPIO2_0 = 0 { name = "Gpio2 0"; desc = "GPIO2_0"; };
            SDIO0_CCLK_OUT = 1 { name = "Sdio0 Cclk Out"; desc = "SDIO0_CCLK_OUT"; };
            I2S_MCLK = 2 { name = "I2S Mclk"; desc = "I2S_MCLK"; };
        };

        field {
            name = "muxctrl_reg44";
            desc = "Multiplexing control for the SDIO0_CCLK_OUT pin. Other values: reserved.";
            sw = rw;
            hw = r;
            encode = muxctrl_reg44_muxctrl_reg44_enum;
            reset = 0x0;
        } muxctrl_reg44[1:0];
    } muxctrl_reg44 @ 0xB0;

    reg {
        name = "Multiplexing control register for the SDIO0_CARD_POWER_EN pin";
        desc = "muxctrl_reg45 is a multiplexing control register for the SDIO0_CARD_POWER_EN pin.

Data sheet 2.3.2 muxctrl_reg45 (offset 0xB4, printed page 2-92, `hi3516av100--Hi3516A-Hi3516D-Datasheet.txt` line 6443).";

        enum muxctrl_reg45_muxctrl_reg45_enum {
            GPIO2_1 = 0 { name = "Gpio2 1"; desc = "GPIO2_1"; };
            SDIO0_CARD_POWER = 1 { name = "Sdio0 Card Power"; desc = "SDIO0_CARD_POWER_EN"; };
            I2S_BCLK_TX = 2 { name = "I2S Bclk Tx"; desc = "I2S_BCLK_TX"; };
        };

        field {
            name = "muxctrl_reg45";
            desc = "Multiplexing control for the SDIO0_CARD_POWER_EN pin. Other values: reserved.";
            sw = rw;
            hw = r;
            encode = muxctrl_reg45_muxctrl_reg45_enum;
            reset = 0x0;
        } muxctrl_reg45[1:0];
    } muxctrl_reg45 @ 0xB4;

    reg {
        name = "Multiplexing control register for the SDIO0_CARD_DETECT pin";
        desc = "muxctrl_reg46 is a multiplexing control register for the SDIO0_CARD_DETECT pin.

Data sheet 2.3.2 muxctrl_reg46 (offset 0xB8, printed page 2-93, `hi3516av100--Hi3516A-Hi3516D-Datasheet.txt` line 6478).";

        enum muxctrl_reg46_muxctrl_reg46_enum {
            GPIO2_2 = 0 { name = "Gpio2 2"; desc = "GPIO2_2"; };
            SDIO0_CARD_DETECT = 1 { name = "Sdio0 Card Detect"; desc = "SDIO0_CARD_DETECT"; };
            I2S_WS_TX = 2 { name = "I2S Ws Tx"; desc = "I2S_WS_TX"; };
        };

        field {
            name = "muxctrl_reg46";
            desc = "Multiplexing control for the SDIO0_CARD_DETECT pin. Other values: reserved.";
            sw = rw;
            hw = r;
            encode = muxctrl_reg46_muxctrl_reg46_enum;
            reset = 0x0;
        } muxctrl_reg46[1:0];
    } muxctrl_reg46 @ 0xB8;

    reg {
        name = "Multiplexing control register for the SDIO0_CWPR pin";
        desc = "muxctrl_reg47 is a multiplexing control register for the SDIO0_CWPR pin.

Data sheet 2.3.2 muxctrl_reg47 (offset 0xBC, printed page 2-93, `hi3516av100--Hi3516A-Hi3516D-Datasheet.txt` line 6507).";

        enum muxctrl_reg47_muxctrl_reg47_enum {
            GPIO2_3 = 0 { name = "Gpio2 3"; desc = "GPIO2_3"; };
            SDIO0_CWPR = 1 { name = "Sdio0 Cwpr"; desc = "SDIO0_CWPR"; };
            I2S_SD_TX = 2 { name = "I2S Sd Tx"; desc = "I2S_SD_TX"; };
        };

        field {
            name = "muxctrl_reg47";
            desc = "Multiplexing control for the SDIO0_CWPR pin. Other values: reserved.";
            sw = rw;
            hw = r;
            encode = muxctrl_reg47_muxctrl_reg47_enum;
            reset = 0x0;
        } muxctrl_reg47[1:0];
    } muxctrl_reg47 @ 0xBC;

    reg {
        name = "Multiplexing control register for the SDIO0_CCMD pin";
        desc = "muxctrl_reg48 is a multiplexing control register for the SDIO0_CCMD pin.

Data sheet 2.3.2 muxctrl_reg48 (offset 0xC0, printed page 2-94, `hi3516av100--Hi3516A-Hi3516D-Datasheet.txt` line 6542).";

        enum muxctrl_reg48_muxctrl_reg48_enum {
            GPIO2_4 = 0 { name = "Gpio2 4"; desc = "GPIO2_4"; };
            SDIO0_CCMD = 1 { name = "Sdio0 Ccmd"; desc = "SDIO0_CCMD"; };
            I2S_BCLK_RX = 2 { name = "I2S Bclk Rx"; desc = "I2S_BCLK_RX"; };
        };

        field {
            name = "muxctrl_reg48";
            desc = "Multiplexing control for the SDIO0_CCMD pin. Other values: reserved.";
            sw = rw;
            hw = r;
            encode = muxctrl_reg48_muxctrl_reg48_enum;
            reset = 0x0;
        } muxctrl_reg48[1:0];
    } muxctrl_reg48 @ 0xC0;

    reg {
        name = "Multiplexing control register for the";
        desc = "muxctrl_reg49 is a multiplexing control register for the SDIO0_CDATA0 pin.

Data sheet 2.3.2 muxctrl_reg49 (offset 0xC4, printed page 2-94, `hi3516av100--Hi3516A-Hi3516D-Datasheet.txt` line 6571).";

        enum muxctrl_reg49_muxctrl_reg49_enum {
            GPIO2_5 = 0 { name = "Gpio2 5"; desc = "GPIO2_5"; };
            SDIO0_CDATA0 = 1 { name = "Sdio0 Cdata0"; desc = "SDIO0_CDATA0"; };
            I2S_WS_RX = 2 { name = "I2S Ws Rx"; desc = "I2S_WS_RX"; };
        };

        field {
            name = "muxctrl_reg49";
            desc = "Multiplexing control for the SDIO0_CDATA0 pin. Other values: reserved.";
            sw = rw;
            hw = r;
            encode = muxctrl_reg49_muxctrl_reg49_enum;
            reset = 0x0;
        } muxctrl_reg49[1:0];
    } muxctrl_reg49 @ 0xC4;

    reg {
        name = "Multiplexing control register for the SDIO0_CDATA1 pin";
        desc = "muxctrl_reg50 is a multiplexing control register for the SDIO0_CDATA1 pin.

Data sheet 2.3.2 muxctrl_reg50 (offset 0xC8, printed page 2-95, `hi3516av100--Hi3516A-Hi3516D-Datasheet.txt` line 6606).";

        enum muxctrl_reg50_muxctrl_reg50_enum {
            GPIO2_6 = 0 { name = "Gpio2 6"; desc = "GPIO2_6"; };
            SDIO0_CDATA1 = 1 { name = "Sdio0 Cdata1"; desc = "SDIO0_CDATA1"; };
            I2S_SD_RX = 2 { name = "I2S Sd Rx"; desc = "I2S_SD_RX"; };
        };

        field {
            name = "muxctrl_reg50";
            desc = "Multiplexing control for the SDIO0_CDATA1 pin. Other values: reserved.";
            sw = rw;
            hw = r;
            encode = muxctrl_reg50_muxctrl_reg50_enum;
            reset = 0x0;
        } muxctrl_reg50[1:0];
    } muxctrl_reg50 @ 0xC8;

    reg {
        name = "Multiplexing control register for the SDIO0_CDATA2 pin";
        desc = "muxctrl_reg51 is a multiplexing control register for the SDIO0_CDATA2 pin.

Data sheet 2.3.2 muxctrl_reg51 (offset 0xCC, printed page 2-95, `hi3516av100--Hi3516A-Hi3516D-Datasheet.txt` line 6635).";

        enum muxctrl_reg51_muxctrl_reg51_enum {
            GPIO2_7 = 0 { name = "Gpio2 7"; desc = "GPIO2_7"; };
            SDIO0_CDATA2 = 1 { name = "Sdio0 Cdata2"; desc = "SDIO0_CDATA2"; };
        };

        field {
            name = "muxctrl_reg51";
            desc = "Multiplexing control for the SDIO0_CDATA2 pin";
            sw = rw;
            hw = r;
            encode = muxctrl_reg51_muxctrl_reg51_enum;
            reset = 0x0;
        } muxctrl_reg51[0:0];
    } muxctrl_reg51 @ 0xCC;

    reg {
        name = "Multiplexing control register for the SDIO0_CDATA3 pin";
        desc = "muxctrl_reg52 is a multiplexing control register for the SDIO0_CDATA3 pin.

Data sheet 2.3.2 muxctrl_reg52 (offset 0xD0, printed page 2-96, `hi3516av100--Hi3516A-Hi3516D-Datasheet.txt` line 6668).";

        enum muxctrl_reg52_muxctrl_reg52_enum {
            GPIO1_1 = 0 { name = "Gpio1 1"; desc = "GPIO1_1"; };
            SDIO0_CDATA3 = 1 { name = "Sdio0 Cdata3"; desc = "SDIO0_CDATA3"; };
        };

        field {
            name = "muxctrl_reg52";
            desc = "Multiplexing control for the SDIO0_CDATA3 pin";
            sw = rw;
            hw = r;
            encode = muxctrl_reg52_muxctrl_reg52_enum;
            reset = 0x0;
        } muxctrl_reg52[0:0];
    } muxctrl_reg52 @ 0xD0;

    reg {
        name = "Multiplexing control register for the GPIO0_0 pin";
        desc = "muxctrl_reg53 is a multiplexing control register for the GPIO0_0 pin.

Data sheet 2.3.2 muxctrl_reg53 (offset 0xD4, printed page 2-96, `hi3516av100--Hi3516A-Hi3516D-Datasheet.txt` line 6695).";

        enum muxctrl_reg53_muxctrl_reg53_enum {
            SENSOR_RSTN = 0 { name = "Sensor Rstn"; desc = "SENSOR_RSTN"; };
            GPIO0_0 = 1 { name = "Gpio0 0"; desc = "GPIO0_0"; };
            TEMPER_DQ = 2 { name = "Temper Dq"; desc = "TEMPER_DQ"; };
        };

        field {
            name = "muxctrl_reg53";
            desc = "Multiplexing control for the GPIO0_0 pin. Other values: reserved.";
            sw = rw;
            hw = r;
            encode = muxctrl_reg53_muxctrl_reg53_enum;
            reset = 0x0;
        } muxctrl_reg53[1:0];
    } muxctrl_reg53 @ 0xD4;

    reg {
        name = "Multiplexing control register for the GPIO0_1 pin";
        desc = "muxctrl_reg54 is a multiplexing control register for the GPIO0_1 pin.

Data sheet 2.3.2 muxctrl_reg54 (offset 0xD8, printed page 2-97, `hi3516av100--Hi3516A-Hi3516D-Datasheet.txt` line 6730).";

        enum muxctrl_reg54_muxctrl_reg54_enum {
            GPIO0_1 = 0 { name = "Gpio0 1"; desc = "GPIO0_1"; };
            TEMPER_DQ = 2 { name = "Temper Dq"; desc = "TEMPER_DQ"; };
        };

        field {
            name = "muxctrl_reg54";
            desc = "Multiplexing control for the GPIO0_1 pin. Other values: reserved.";
            sw = rw;
            hw = r;
            encode = muxctrl_reg54_muxctrl_reg54_enum;
            reset = 0x0;
        } muxctrl_reg54[1:0];
    } muxctrl_reg54 @ 0xD8;

    reg {
        name = "Multiplexing control register for the GPIO0_2 pin";
        desc = "muxctrl_reg55 is a multiplexing control register for the GPIO0_2 pin.

Data sheet 2.3.2 muxctrl_reg55 (offset 0xDC, printed page 2-97, `hi3516av100--Hi3516A-Hi3516D-Datasheet.txt` line 6759).";

        enum muxctrl_reg55_muxctrl_reg55_enum {
            GPIO0_2 = 0 { name = "Gpio0 2"; desc = "GPIO0_2"; };
            PWM5 = 1 { name = "Pwm5"; desc = "PWM5"; };
            TEMPER_DQ = 2 { name = "Temper Dq"; desc = "TEMPER_DQ"; };
        };

        field {
            name = "muxctrl_reg55";
            desc = "Multiplexing control for the GPIO0_2 pin. Other values: reserved.";
            sw = rw;
            hw = r;
            encode = muxctrl_reg55_muxctrl_reg55_enum;
            reset = 0x0;
        } muxctrl_reg55[1:0];
    } muxctrl_reg55 @ 0xDC;

    reg {
        name = "Multiplexing control register for the GPIO0_3 pin";
        desc = "muxctrl_reg56 is a multiplexing control register for the GPIO0_3 pin.

Data sheet 2.3.2 muxctrl_reg56 (offset 0xE0, printed page 2-98, `hi3516av100--Hi3516A-Hi3516D-Datasheet.txt` line 6794).";

        enum muxctrl_reg56_muxctrl_reg56_enum {
            GPIO0_3 = 0 { name = "Gpio0 3"; desc = "GPIO0_3"; };
            PWM6 = 1 { name = "Pwm6"; desc = "PWM6"; };
            TEMPER_DQ = 2 { name = "Temper Dq"; desc = "TEMPER_DQ"; };
        };

        field {
            name = "muxctrl_reg56";
            desc = "Multiplexing control for the GPIO0_3 pin. Other values: reserved.";
            sw = rw;
            hw = r;
            encode = muxctrl_reg56_muxctrl_reg56_enum;
            reset = 0x0;
        } muxctrl_reg56[1:0];
    } muxctrl_reg56 @ 0xE0;

    reg {
        name = "Multiplexing control register for the GPIO0_4 pin";
        desc = "muxctrl_reg57 is a multiplexing control register for the GPIO0_4 pin.

Data sheet 2.3.2 muxctrl_reg57 (offset 0xE4, printed page 2-98, `hi3516av100--Hi3516A-Hi3516D-Datasheet.txt` line 6823).";

        enum muxctrl_reg57_muxctrl_reg57_enum {
            GPIO0_4 = 0 { name = "Gpio0 4"; desc = "GPIO0_4"; };
            PWM7 = 1 { name = "Pwm7"; desc = "PWM7"; };
            TEMPER_DQ = 2 { name = "Temper Dq"; desc = "TEMPER_DQ"; };
        };

        field {
            name = "muxctrl_reg57";
            desc = "Multiplexing control for the GPIO0_4 pin. Other values: reserved.";
            sw = rw;
            hw = r;
            encode = muxctrl_reg57_muxctrl_reg57_enum;
            reset = 0x0;
        } muxctrl_reg57[1:0];
    } muxctrl_reg57 @ 0xE4;

    reg {
        name = "Multiplexing control register for the SDIO1_CCLK_OUT pin";
        desc = "muxctrl_reg58 is a multiplexing control register for the SDIO1_CCLK_OUT pin.

Data sheet 2.3.2 muxctrl_reg58 (offset 0xE8, printed page 2-99, `hi3516av100--Hi3516A-Hi3516D-Datasheet.txt` line 6858).";

        enum muxctrl_reg58_muxctrl_reg58_enum {
            GPIO11_0 = 0 { name = "Gpio11 0"; desc = "GPIO11_0"; };
            SDIO1_CCLK_OUT = 1 { name = "Sdio1 Cclk Out"; desc = "SDIO1_CCLK_OUT"; };
        };

        field {
            name = "muxctrl_reg58";
            desc = "Multiplexing control for the SDIO1_CCLK_OUT pin";
            sw = rw;
            hw = r;
            encode = muxctrl_reg58_muxctrl_reg58_enum;
            reset = 0x0;
        } muxctrl_reg58[0:0];
    } muxctrl_reg58 @ 0xE8;

    reg {
        name = "Multiplexing control register for the SDIO1_CARD_POWER_EN pin";
        desc = "muxctrl_reg59 is a multiplexing control register for the SDIO1_CARD_POWER_EN pin.

Data sheet 2.3.2 muxctrl_reg59 (offset 0xEC, printed page 2-99, `hi3516av100--Hi3516A-Hi3516D-Datasheet.txt` line 6885).";

        enum muxctrl_reg59_muxctrl_reg59_enum {
            GPIO11_1 = 0 { name = "Gpio11 1"; desc = "GPIO11_1"; };
            SDIO1_CARD_POWER = 1 { name = "Sdio1 Card Power"; desc = "SDIO1_CARD_POWER_EN"; };
        };

        field {
            name = "muxctrl_reg59";
            desc = "Multiplexing control for the SDIO1_CARD_POWER_EN pin";
            sw = rw;
            hw = r;
            encode = muxctrl_reg59_muxctrl_reg59_enum;
            reset = 0x0;
        } muxctrl_reg59[0:0];
    } muxctrl_reg59 @ 0xEC;

    reg {
        name = "Multiplexing control register for the SDIO1_CARD_DETECT pin";
        desc = "muxctrl_reg60 is a multiplexing control register for the SDIO1_CARD_DETECT pin.

Data sheet 2.3.2 muxctrl_reg60 (offset 0xF0, printed page 2-100, `hi3516av100--Hi3516A-Hi3516D-Datasheet.txt` line 6921).";

        enum muxctrl_reg60_muxctrl_reg60_enum {
            GPIO11_2 = 0 { name = "Gpio11 2"; desc = "GPIO11_2"; };
            SDIO1_CARD_DETECT = 1 { name = "Sdio1 Card Detect"; desc = "SDIO1_CARD_DETECT"; };
        };

        field {
            name = "muxctrl_reg60";
            desc = "Multiplexing control for the SDIO1_CARD_DETECT pin";
            sw = rw;
            hw = r;
            encode = muxctrl_reg60_muxctrl_reg60_enum;
            reset = 0x0;
        } muxctrl_reg60[0:0];
    } muxctrl_reg60 @ 0xF0;

    reg {
        name = "Multiplexing control register for the SDIO1_CWPR pin";
        desc = "muxctrl_reg61 is a multiplexing control register for the SDIO1_CWPR pin.

Data sheet 2.3.2 muxctrl_reg61 (offset 0xF4, printed page 2-100, `hi3516av100--Hi3516A-Hi3516D-Datasheet.txt` line 6948).";

        enum muxctrl_reg61_muxctrl_reg61_enum {
            GPIO11_3 = 0 { name = "Gpio11 3"; desc = "GPIO11_3"; };
            SDIO1_CWPR = 1 { name = "Sdio1 Cwpr"; desc = "SDIO1_CWPR"; };
        };

        field {
            name = "muxctrl_reg61";
            desc = "Multiplexing control for the SDIO1_CWPR pin";
            sw = rw;
            hw = r;
            encode = muxctrl_reg61_muxctrl_reg61_enum;
            reset = 0x0;
        } muxctrl_reg61[0:0];
    } muxctrl_reg61 @ 0xF4;

    reg {
        name = "Multiplexing control register for the SDIO1_CCMD pin";
        desc = "muxctrl_reg62 is a multiplexing control register for the SDIO1_CCMD pin.

Data sheet 2.3.2 muxctrl_reg62 (offset 0xF8, printed page 2-101, `hi3516av100--Hi3516A-Hi3516D-Datasheet.txt` line 6985).";

        enum muxctrl_reg62_muxctrl_reg62_enum {
            GPIO11_4 = 0 { name = "Gpio11 4"; desc = "GPIO11_4"; };
            SDIO1_CCMD = 1 { name = "Sdio1 Ccmd"; desc = "SDIO1_CCMD"; };
        };

        field {
            name = "muxctrl_reg62";
            desc = "Multiplexing control for the SDIO1_CCMD pin";
            sw = rw;
            hw = r;
            encode = muxctrl_reg62_muxctrl_reg62_enum;
            reset = 0x0;
        } muxctrl_reg62[0:0];
    } muxctrl_reg62 @ 0xF8;

    reg {
        name = "Multiplexing control register for the SDIO1_CDATA0 pin";
        desc = "muxctrl_reg63 is a multiplexing control register for the SDIO1_CDATA0 pin.

Data sheet 2.3.2 muxctrl_reg63 (offset 0xFC, printed page 2-101, `hi3516av100--Hi3516A-Hi3516D-Datasheet.txt` line 7012).";

        enum muxctrl_reg63_muxctrl_reg63_enum {
            GPIO11_5 = 0 { name = "Gpio11 5"; desc = "GPIO11_5"; };
            SDIO1_CDATA0 = 1 { name = "Sdio1 Cdata0"; desc = "SDIO1_CDATA0"; };
            CLK_TEST_OUT0 = 2 { name = "Clk Test Out0"; desc = "CLK_TEST_OUT0"; };
            CLK_TEST_OUT1 = 3 { name = "Clk Test Out1"; desc = "CLK_TEST_OUT1"; };
            CLK_TEST_OUT2 = 4 { name = "Clk Test Out2"; desc = "CLK_TEST_OUT2"; };
            CLK_TEST_OUT3 = 5 { name = "Clk Test Out3"; desc = "CLK_TEST_OUT3"; };
            RTC_TEST_CLK = 6 { name = "Rtc Test Clk"; desc = "RTC_TEST_CLK"; };
            OSC_TEST_CLK = 7 { name = "Osc Test Clk"; desc = "OSC_TEST_CLK"; };
        };

        field {
            name = "muxctrl_reg63";
            desc = "Multiplexing control for the SDIO1_CDATA0 pin";
            sw = rw;
            hw = r;
            encode = muxctrl_reg63_muxctrl_reg63_enum;
            reset = 0x0;
        } muxctrl_reg63[2:0];
    } muxctrl_reg63 @ 0xFC;

    reg {
        name = "Multiplexing control register for the SDIO1_CDATA1 pin";
        desc = "muxctrl_reg64 is a multiplexing control register for the SDIO1_CDATA1 pin.

Data sheet 2.3.2 muxctrl_reg64 (offset 0x100, printed page 2-102, `hi3516av100--Hi3516A-Hi3516D-Datasheet.txt` line 7051).";

        enum muxctrl_reg64_muxctrl_reg64_enum {
            PLL_TEST_OUT0 = 0 { name = "Pll Test Out0"; desc = "PLL_TEST_OUT0"; };
            SDIO1_CDATA1 = 1 { name = "Sdio1 Cdata1"; desc = "SDIO1_CDATA1"; };
            PLL_TEST_OUT1 = 2 { name = "Pll Test Out1"; desc = "PLL_TEST_OUT1"; };
            PLL_TEST_OUT2 = 3 { name = "Pll Test Out2"; desc = "PLL_TEST_OUT2"; };
            PLL_TEST_OUT3 = 4 { name = "Pll Test Out3"; desc = "PLL_TEST_OUT3"; };
            GPIO11_6 = 5 { name = "Gpio11 6"; desc = "GPIO11_6"; };
        };

        field {
            name = "muxctrl_reg64";
            desc = "Multiplexing control for the SDIO1_CDATA1 pin. Other values: reserved.";
            sw = rw;
            hw = r;
            encode = muxctrl_reg64_muxctrl_reg64_enum;
            reset = 0x0;
        } muxctrl_reg64[2:0];
    } muxctrl_reg64 @ 0x100;

    reg {
        name = "Multiplexing control register for the SDIO1_CDATA2 pin";
        desc = "muxctrl_reg65 is a multiplexing control register for the SDIO1_CDATA2 pin.

Data sheet 2.3.2 muxctrl_reg65 (offset 0x104, printed page 2-102, `hi3516av100--Hi3516A-Hi3516D-Datasheet.txt` line 7084).";

        enum muxctrl_reg65_muxctrl_reg65_enum {
            GPIO11_7 = 0 { name = "Gpio11 7"; desc = "GPIO11_7"; };
            SDIO1_CDATA2 = 1 { name = "Sdio1 Cdata2"; desc = "SDIO1_CDATA2"; };
        };

        field {
            name = "muxctrl_reg65";
            desc = "Multiplexing control for the SDIO1_CDATA2 pin";
            sw = rw;
            hw = r;
            encode = muxctrl_reg65_muxctrl_reg65_enum;
            reset = 0x0;
        } muxctrl_reg65[0:0];
    } muxctrl_reg65 @ 0x104;

    reg {
        name = "Multiplexing control register for the SDIO1_CDATA3 pin";
        desc = "muxctrl_reg66 is a multiplexing control register for the SDIO1_CDATA3 pin.

Data sheet 2.3.2 muxctrl_reg66 (offset 0x108, printed page 2-103, `hi3516av100--Hi3516A-Hi3516D-Datasheet.txt` line 7119).";

        enum muxctrl_reg66_muxctrl_reg66_enum {
            GPIO1_2 = 0 { name = "Gpio1 2"; desc = "GPIO1_2"; };
            SDIO1_CDATA3 = 1 { name = "Sdio1 Cdata3"; desc = "SDIO1_CDATA3"; };
        };

        field {
            name = "muxctrl_reg66";
            desc = "Multiplexing control for the SDIO1_CDATA3 pin";
            sw = rw;
            hw = r;
            encode = muxctrl_reg66_muxctrl_reg66_enum;
            reset = 0x0;
        } muxctrl_reg66[0:0];
    } muxctrl_reg66 @ 0x108;

    reg {
        name = "Multiplexing control register for the NF_DQ0 pin";
        desc = "muxctrl_reg67 is a multiplexing control register for the NF_DQ0 pin.

Data sheet 2.3.2 muxctrl_reg67 (offset 0x10C, printed page 2-103, `hi3516av100--Hi3516A-Hi3516D-Datasheet.txt` line 7146).";

        enum muxctrl_reg67_muxctrl_reg67_enum {
            NF_DQ0 = 0 { name = "Nf Dq0"; desc = "NF_DQ0"; };
            GPIO5_0 = 1 { name = "Gpio5 0"; desc = "GPIO5_0"; };
        };

        field {
            name = "muxctrl_reg67";
            desc = "Multiplexing control for the NF_DQ0 pin";
            sw = rw;
            hw = r;
            encode = muxctrl_reg67_muxctrl_reg67_enum;
            reset = 0x0;
        } muxctrl_reg67[0:0];
    } muxctrl_reg67 @ 0x10C;

    reg {
        name = "Multiplexing control register for the NF_DQ1 pin";
        desc = "muxctrl_reg68 is a multiplexing control register for the NF_DQ1 pin.

Data sheet 2.3.2 muxctrl_reg68 (offset 0x110, printed page 2-104, `hi3516av100--Hi3516A-Hi3516D-Datasheet.txt` line 7179).";

        enum muxctrl_reg68_muxctrl_reg68_enum {
            NF_DQ1 = 0 { name = "Nf Dq1"; desc = "NF_DQ1"; };
            GPIO5_1 = 1 { name = "Gpio5 1"; desc = "GPIO5_1"; };
        };

        field {
            name = "muxctrl_reg68";
            desc = "Multiplexing control for the NF_DQ1 pin";
            sw = rw;
            hw = r;
            encode = muxctrl_reg68_muxctrl_reg68_enum;
            reset = 0x0;
        } muxctrl_reg68[0:0];
    } muxctrl_reg68 @ 0x110;

    reg {
        name = "Multiplexing control register for the NF_DQ2 pin";
        desc = "muxctrl_reg69 is a multiplexing control register for the NF_DQ2 pin.

Data sheet 2.3.2 muxctrl_reg69 (offset 0x114, printed page 2-104, `hi3516av100--Hi3516A-Hi3516D-Datasheet.txt` line 7206).";

        enum muxctrl_reg69_muxctrl_reg69_enum {
            NF_DQ2 = 0 { name = "Nf Dq2"; desc = "NF_DQ2"; };
            GPIO5_2 = 1 { name = "Gpio5 2"; desc = "GPIO5_2"; };
        };

        field {
            name = "muxctrl_reg69";
            desc = "Multiplexing control for the NF_DQ2 pin";
            sw = rw;
            hw = r;
            encode = muxctrl_reg69_muxctrl_reg69_enum;
            reset = 0x0;
        } muxctrl_reg69[0:0];
    } muxctrl_reg69 @ 0x114;

    reg {
        name = "Multiplexing control register for the NF_DQ3 pin";
        desc = "muxctrl_reg70 is a multiplexing control register for the NF_DQ3 pin.

Data sheet 2.3.2 muxctrl_reg70 (offset 0x118, printed page 2-105, `hi3516av100--Hi3516A-Hi3516D-Datasheet.txt` line 7243).";

        enum muxctrl_reg70_muxctrl_reg70_enum {
            NF_DQ3 = 0 { name = "Nf Dq3"; desc = "NF_DQ3"; };
            GPIO5_3 = 1 { name = "Gpio5 3"; desc = "GPIO5_3"; };
        };

        field {
            name = "muxctrl_reg70";
            desc = "Multiplexing control for the NF_DQ3 pin";
            sw = rw;
            hw = r;
            encode = muxctrl_reg70_muxctrl_reg70_enum;
            reset = 0x0;
        } muxctrl_reg70[0:0];
    } muxctrl_reg70 @ 0x118;

    reg {
        name = "Multiplexing control register for the NF_DQ4 pin";
        desc = "muxctrl_reg71 is a multiplexing control register for the NF_DQ4 pin.

Data sheet 2.3.2 muxctrl_reg71 (offset 0x11C, printed page 2-105, `hi3516av100--Hi3516A-Hi3516D-Datasheet.txt` line 7270).";

        enum muxctrl_reg71_muxctrl_reg71_enum {
            NF_DQ4 = 0 { name = "Nf Dq4"; desc = "NF_DQ4"; };
            GPIO5_4 = 1 { name = "Gpio5 4"; desc = "GPIO5_4"; };
        };

        field {
            name = "muxctrl_reg71";
            desc = "Multiplexing control for the NF_DQ4 pin";
            sw = rw;
            hw = r;
            encode = muxctrl_reg71_muxctrl_reg71_enum;
            reset = 0x0;
        } muxctrl_reg71[0:0];
    } muxctrl_reg71 @ 0x11C;

    reg {
        name = "Multiplexing control register for the NF_DQ5 pin";
        desc = "muxctrl_reg72 is a multiplexing control register for the NF_DQ5 pin.

Data sheet 2.3.2 muxctrl_reg72 (offset 0x120, printed page 2-106, `hi3516av100--Hi3516A-Hi3516D-Datasheet.txt` line 7307).";

        enum muxctrl_reg72_muxctrl_reg72_enum {
            NF_DQ5 = 0 { name = "Nf Dq5"; desc = "NF_DQ5"; };
            GPIO5_5 = 1 { name = "Gpio5 5"; desc = "GPIO5_5"; };
        };

        field {
            name = "muxctrl_reg72";
            desc = "Multiplexing control for the NF_DQ5 pin";
            sw = rw;
            hw = r;
            encode = muxctrl_reg72_muxctrl_reg72_enum;
            reset = 0x0;
        } muxctrl_reg72[0:0];
    } muxctrl_reg72 @ 0x120;

    reg {
        name = "Multiplexing control register for the NF_DQ6 pin";
        desc = "muxctrl_reg73 is a multiplexing control register for the NF_DQ6 pin.

Data sheet 2.3.2 muxctrl_reg73 (offset 0x124, printed page 2-106, `hi3516av100--Hi3516A-Hi3516D-Datasheet.txt` line 7334).";

        enum muxctrl_reg73_muxctrl_reg73_enum {
            NF_DQ6 = 0 { name = "Nf Dq6"; desc = "NF_DQ6"; };
            GPIO5_6 = 1 { name = "Gpio5 6"; desc = "GPIO5_6"; };
        };

        field {
            name = "muxctrl_reg73";
            desc = "Multiplexing control for the NF_DQ6 pin";
            sw = rw;
            hw = r;
            encode = muxctrl_reg73_muxctrl_reg73_enum;
            reset = 0x0;
        } muxctrl_reg73[0:0];
    } muxctrl_reg73 @ 0x124;

    reg {
        name = "Multiplexing control register for the NF_DQ7 pin";
        desc = "muxctrl_reg74 is a multiplexing control register for the NF_DQ7 pin.

Data sheet 2.3.2 muxctrl_reg74 (offset 0x128, printed page 2-107, `hi3516av100--Hi3516A-Hi3516D-Datasheet.txt` line 7371).";

        enum muxctrl_reg74_muxctrl_reg74_enum {
            NF_DQ7 = 0 { name = "Nf Dq7"; desc = "NF_DQ7"; };
            GPIO5_7 = 1 { name = "Gpio5 7"; desc = "GPIO5_7"; };
        };

        field {
            name = "muxctrl_reg74";
            desc = "Multiplexing control for the NF_DQ7 pin";
            sw = rw;
            hw = r;
            encode = muxctrl_reg74_muxctrl_reg74_enum;
            reset = 0x0;
        } muxctrl_reg74[0:0];
    } muxctrl_reg74 @ 0x128;

    reg {
        name = "Multiplexing control register for the NF_RDY0 pin";
        desc = "muxctrl_reg75 is a multiplexing control register for the NF_RDY0 pin.

Data sheet 2.3.2 muxctrl_reg75 (offset 0x12C, printed page 2-107, `hi3516av100--Hi3516A-Hi3516D-Datasheet.txt` line 7398).";

        enum muxctrl_reg75_muxctrl_reg75_enum {
            NF_RDY0 = 0 { name = "Nf Rdy0"; desc = "NF_RDY0"; };
            GPIO3_0 = 1 { name = "Gpio3 0"; desc = "GPIO3_0"; };
        };

        field {
            name = "muxctrl_reg75";
            desc = "Multiplexing control for the NF_RDY0 pin";
            sw = rw;
            hw = r;
            encode = muxctrl_reg75_muxctrl_reg75_enum;
            reset = 0x0;
        } muxctrl_reg75[0:0];
    } muxctrl_reg75 @ 0x12C;

    reg {
        name = "Multiplexing control register for the NF_RDY1 pin";
        desc = "muxctrl_reg76 is a multiplexing control register for the NF_RDY1 pin.

Data sheet 2.3.2 muxctrl_reg76 (offset 0x130, printed page 2-108, `hi3516av100--Hi3516A-Hi3516D-Datasheet.txt` line 7435).";

        enum muxctrl_reg76_muxctrl_reg76_enum {
            NF_RDY1 = 0 { name = "Nf Rdy1"; desc = "NF_RDY1"; };
            GPIO3_1 = 1 { name = "Gpio3 1"; desc = "GPIO3_1"; };
        };

        field {
            name = "muxctrl_reg76";
            desc = "Multiplexing control for the NF_RDY1 pin";
            sw = rw;
            hw = r;
            encode = muxctrl_reg76_muxctrl_reg76_enum;
            reset = 0x0;
        } muxctrl_reg76[0:0];
    } muxctrl_reg76 @ 0x130;

    reg {
        name = "Multiplexing control register for the NF_REN pin";
        desc = "muxctrl_reg77 is a multiplexing control register for the NF_REN pin.

Data sheet 2.3.2 muxctrl_reg77 (offset 0x134, printed page 2-108, `hi3516av100--Hi3516A-Hi3516D-Datasheet.txt` line 7462).";

        enum muxctrl_reg77_muxctrl_reg77_enum {
            NF_REN = 0 { name = "Nf Ren"; desc = "NF_REN"; };
            GPIO3_2 = 1 { name = "Gpio3 2"; desc = "GPIO3_2"; };
        };

        field {
            name = "muxctrl_reg77";
            desc = "Multiplexing control for the NF_REN pin";
            sw = rw;
            hw = r;
            encode = muxctrl_reg77_muxctrl_reg77_enum;
            reset = 0x0;
        } muxctrl_reg77[0:0];
    } muxctrl_reg77 @ 0x134;

    reg {
        name = "Multiplexing control register for the NF_CSN0 pin";
        desc = "muxctrl_reg78 is a multiplexing control register for the NF_CSN0 pin.

Data sheet 2.3.2 muxctrl_reg78 (offset 0x138, printed page 2-109, `hi3516av100--Hi3516A-Hi3516D-Datasheet.txt` line 7499).";

        enum muxctrl_reg78_muxctrl_reg78_enum {
            NF_CSN0 = 0 { name = "Nf Csn0"; desc = "NF_CSN0"; };
            GPIO3_3 = 1 { name = "Gpio3 3"; desc = "GPIO3_3"; };
        };

        field {
            name = "muxctrl_reg78";
            desc = "Multiplexing control for the NF_CSN0 pin";
            sw = rw;
            hw = r;
            encode = muxctrl_reg78_muxctrl_reg78_enum;
            reset = 0x0;
        } muxctrl_reg78[0:0];
    } muxctrl_reg78 @ 0x138;

    reg {
        name = "Multiplexing control register for the NF_CSN1 pin";
        desc = "muxctrl_reg79 is a multiplexing control register for the NF_CSN1 pin.

Data sheet 2.3.2 muxctrl_reg79 (offset 0x13C, printed page 2-109, `hi3516av100--Hi3516A-Hi3516D-Datasheet.txt` line 7526).";

        enum muxctrl_reg79_muxctrl_reg79_enum {
            NF_CSN1 = 0 { name = "Nf Csn1"; desc = "NF_CSN1"; };
            GPIO3_4 = 1 { name = "Gpio3 4"; desc = "GPIO3_4"; };
            SFC_CSN0 = 2 { name = "Sfc Csn0"; desc = "SFC_CSN0"; };
        };

        field {
            name = "muxctrl_reg79";
            desc = "Multiplexing control for the NF_CSN1 pin. Other values: reserved.";
            sw = rw;
            hw = r;
            encode = muxctrl_reg79_muxctrl_reg79_enum;
            reset = 0x0;
        } muxctrl_reg79[1:0];
    } muxctrl_reg79 @ 0x13C;

    reg {
        name = "Multiplexing control register for the NF_CLE pin";
        desc = "muxctrl_reg80 is a multiplexing control register for the NF_CLE pin.

Data sheet 2.3.2 muxctrl_reg80 (offset 0x140, printed page 2-110, `hi3516av100--Hi3516A-Hi3516D-Datasheet.txt` line 7565).";

        enum muxctrl_reg80_muxctrl_reg80_enum {
            NF_CLE = 0 { name = "Nf Cle"; desc = "NF_CLE"; };
            GPIO3_5 = 1 { name = "Gpio3 5"; desc = "GPIO3_5"; };
        };

        field {
            name = "muxctrl_reg80";
            desc = "Multiplexing control for the NF_CLE pin";
            sw = rw;
            hw = r;
            encode = muxctrl_reg80_muxctrl_reg80_enum;
            reset = 0x0;
        } muxctrl_reg80[0:0];
    } muxctrl_reg80 @ 0x140;

    reg {
        name = "Multiplexing control register for the NF_ALE pin";
        desc = "muxctrl_reg81 is a multiplexing control register for the NF_ALE pin.

Data sheet 2.3.2 muxctrl_reg81 (offset 0x144, printed page 2-110, `hi3516av100--Hi3516A-Hi3516D-Datasheet.txt` line 7592).";

        enum muxctrl_reg81_muxctrl_reg81_enum {
            NF_ALE = 0 { name = "Nf Ale"; desc = "NF_ALE"; };
            GPIO3_6 = 1 { name = "Gpio3 6"; desc = "GPIO3_6"; };
        };

        field {
            name = "muxctrl_reg81";
            desc = "Multiplexing control for the NF_ALE pin";
            sw = rw;
            hw = r;
            encode = muxctrl_reg81_muxctrl_reg81_enum;
            reset = 0x0;
        } muxctrl_reg81[0:0];
    } muxctrl_reg81 @ 0x144;

    reg {
        name = "Multiplexing control register for the NF_WEN pin";
        desc = "muxctrl_reg82 is a multiplexing control register for the NF_WEN pin.

Data sheet 2.3.2 muxctrl_reg82 (offset 0x148, printed page 2-111, `hi3516av100--Hi3516A-Hi3516D-Datasheet.txt` line 7629).";

        enum muxctrl_reg82_muxctrl_reg82_enum {
            NF_WEN = 0 { name = "Nf Wen"; desc = "NF_WEN"; };
            GPIO3_7 = 1 { name = "Gpio3 7"; desc = "GPIO3_7"; };
        };

        field {
            name = "muxctrl_reg82";
            desc = "Multiplexing control for the NF_WEN pin";
            sw = rw;
            hw = r;
            encode = muxctrl_reg82_muxctrl_reg82_enum;
            reset = 0x0;
        } muxctrl_reg82[0:0];
    } muxctrl_reg82 @ 0x148;

    reg {
        name = "Multiplexing control register for the PWM0 pin";
        desc = "muxctrl_reg83 is a multiplexing control register for the PWM0 pin.

Data sheet 2.3.2 muxctrl_reg83 (offset 0x14C, printed page 2-111, `hi3516av100--Hi3516A-Hi3516D-Datasheet.txt` line 7656).";

        enum muxctrl_reg83_muxctrl_reg83_enum {
            PWM0 = 0 { name = "Pwm0"; desc = "PWM0"; };
            GPIO14_0 = 1 { name = "Gpio14 0"; desc = "GPIO14_0"; };
            PMC_I2C_SCL = 2 { name = "Pmc I2C Scl"; desc = "PMC_I2C_SCL"; };
        };

        field {
            name = "muxctrl_reg83";
            desc = "Multiplexing control for the PWM0 pin. Other values: reserved.";
            sw = rw;
            hw = r;
            encode = muxctrl_reg83_muxctrl_reg83_enum;
            reset = 0x0;
        } muxctrl_reg83[1:0];
    } muxctrl_reg83 @ 0x14C;

    reg {
        name = "Multiplexing control register for the PWM1 pin";
        desc = "muxctrl_reg84 is a multiplexing control register for the PWM1 pin.

Data sheet 2.3.2 muxctrl_reg84 (offset 0x150, printed page 2-112, `hi3516av100--Hi3516A-Hi3516D-Datasheet.txt` line 7695).";

        enum muxctrl_reg84_muxctrl_reg84_enum {
            PWM1 = 0 { name = "Pwm1"; desc = "PWM1"; };
            GPIO14_1 = 1 { name = "Gpio14 1"; desc = "GPIO14_1"; };
            PMC_I2C_SDA = 2 { name = "Pmc I2C Sda"; desc = "PMC_I2C_SDA"; };
        };

        field {
            name = "muxctrl_reg84";
            desc = "Multiplexing control for the PWM1 pin. Other values: reserved.";
            sw = rw;
            hw = r;
            encode = muxctrl_reg84_muxctrl_reg84_enum;
            reset = 0x0;
        } muxctrl_reg84[1:0];
    } muxctrl_reg84 @ 0x150;

    reg {
        name = "Multiplexing control register for the PWM2 pin";
        desc = "muxctrl_reg85 is a multiplexing control register for the PWM2 pin.

Data sheet 2.3.2 muxctrl_reg85 (offset 0x154, printed page 2-112, `hi3516av100--Hi3516A-Hi3516D-Datasheet.txt` line 7724).";

        enum muxctrl_reg85_muxctrl_reg85_enum {
            PWM2 = 0 { name = "Pwm2"; desc = "PWM2"; };
            GPIO14_2 = 1 { name = "Gpio14 2"; desc = "GPIO14_2"; };
        };

        field {
            name = "muxctrl_reg85";
            desc = "Multiplexing control for the PWM2 pin";
            sw = rw;
            hw = r;
            encode = muxctrl_reg85_muxctrl_reg85_enum;
            reset = 0x0;
        } muxctrl_reg85[0:0];
    } muxctrl_reg85 @ 0x154;

    reg {
        name = "Multiplexing control register for the PWM3 pin";
        desc = "muxctrl_reg86 is a multiplexing control register for the PWM3 pin.

Data sheet 2.3.2 muxctrl_reg86 (offset 0x158, printed page 2-113, `hi3516av100--Hi3516A-Hi3516D-Datasheet.txt` line 7761).";

        enum muxctrl_reg86_muxctrl_reg86_enum {
            PWM3 = 0 { name = "Pwm3"; desc = "PWM3"; };
            GPIO14_3 = 1 { name = "Gpio14 3"; desc = "GPIO14_3"; };
        };

        field {
            name = "muxctrl_reg86";
            desc = "Multiplexing control for the PWM3 pin";
            sw = rw;
            hw = r;
            encode = muxctrl_reg86_muxctrl_reg86_enum;
            reset = 0x0;
        } muxctrl_reg86[0:0];
    } muxctrl_reg86 @ 0x158;

    reg {
        name = "Multiplexing control register for the SAR_ADC_CH0 pin";
        desc = "muxctrl_reg87 is a multiplexing control register for the SAR_ADC_CH0 pin.

Data sheet 2.3.2 muxctrl_reg87 (offset 0x15C, printed page 2-113, `hi3516av100--Hi3516A-Hi3516D-Datasheet.txt` line 7788).";

        enum muxctrl_reg87_muxctrl_reg87_enum {
            SAR_ADC_CH0 = 0 { name = "Sar Adc Ch0"; desc = "SAR_ADC_CH0"; };
            GPIO1_6 = 1 { name = "Gpio1 6"; desc = "GPIO1_6"; };
        };

        field {
            name = "muxctrl_reg87";
            desc = "Multiplexing control for the SAR_ADC_CH0 pin";
            sw = rw;
            hw = r;
            encode = muxctrl_reg87_muxctrl_reg87_enum;
            reset = 0x0;
        } muxctrl_reg87[0:0];
    } muxctrl_reg87 @ 0x15C;

    reg {
        name = "Multiplexing control register for the";
        desc = "muxctrl_reg88 is a multiplexing control register for the SAR_ADC_CH1 pin.

Data sheet 2.3.2 muxctrl_reg88 (offset 0x160, printed page 2-114, `hi3516av100--Hi3516A-Hi3516D-Datasheet.txt` line 7825).";

        enum muxctrl_reg88_muxctrl_reg88_enum {
            SAR_ADC_CH1 = 0 { name = "Sar Adc Ch1"; desc = "SAR_ADC_CH1"; };
            GPIO1_7 = 1 { name = "Gpio1 7"; desc = "GPIO1_7"; };
        };

        field {
            name = "muxctrl_reg88";
            desc = "Multiplexing control for the SAR_ADC_CH1 pin";
            sw = rw;
            hw = r;
            encode = muxctrl_reg88_muxctrl_reg88_enum;
            reset = 0x0;
        } muxctrl_reg88[0:0];
    } muxctrl_reg88 @ 0x160;

    reg {
        name = "Multiplexing control register for the EPHY_CLK pin";
        desc = "muxctrl_reg89 is a multiplexing control register for the EPHY_CLK pin.

Data sheet 2.3.2 muxctrl_reg89 (offset 0x164, printed page 2-114, `hi3516av100--Hi3516A-Hi3516D-Datasheet.txt` line 7852).";

        enum muxctrl_reg89_muxctrl_reg89_enum {
            GPIO14_4 = 0 { name = "Gpio14 4"; desc = "GPIO14_4"; };
            EPHY_CLK = 1 { name = "Ephy Clk"; desc = "EPHY_CLK"; };
        };

        field {
            name = "muxctrl_reg89";
            desc = "Multiplexing control for the EPHY_CLK pin";
            sw = rw;
            hw = r;
            encode = muxctrl_reg89_muxctrl_reg89_enum;
            reset = 0x0;
        } muxctrl_reg89[0:0];
    } muxctrl_reg89 @ 0x164;

    reg {
        name = "Multiplexing control register for the MDCK pin";
        desc = "muxctrl_reg90 is a multiplexing control register for the MDCK pin.

Data sheet 2.3.2 muxctrl_reg90 (offset 0x168, printed page 2-115, `hi3516av100--Hi3516A-Hi3516D-Datasheet.txt` line 7889).";

        enum muxctrl_reg90_muxctrl_reg90_enum {
            GPIO14_5 = 0 { name = "Gpio14 5"; desc = "GPIO14_5"; };
            MDCK = 1 { name = "Mdck"; desc = "MDCK"; };
        };

        field {
            name = "muxctrl_reg90";
            desc = "Multiplexing control for the MDCK pin";
            sw = rw;
            hw = r;
            encode = muxctrl_reg90_muxctrl_reg90_enum;
            reset = 0x0;
        } muxctrl_reg90[0:0];
    } muxctrl_reg90 @ 0x168;

    reg {
        name = "Multiplexing control register for the MDIO pin";
        desc = "muxctrl_reg91 is a multiplexing control register for the MDIO pin.

Data sheet 2.3.2 muxctrl_reg91 (offset 0x16C, printed page 2-115, `hi3516av100--Hi3516A-Hi3516D-Datasheet.txt` line 7916).";

        enum muxctrl_reg91_muxctrl_reg91_enum {
            GPIO14_6 = 0 { name = "Gpio14 6"; desc = "GPIO14_6"; };
            MDIO = 1 { name = "Mdio"; desc = "MDIO"; };
        };

        field {
            name = "muxctrl_reg91";
            desc = "Multiplexing control for the MDIO pin";
            sw = rw;
            hw = r;
            encode = muxctrl_reg91_muxctrl_reg91_enum;
            reset = 0x0;
        } muxctrl_reg91[0:0];
    } muxctrl_reg91 @ 0x16C;

    reg {
        name = "Multiplexing control register for the RGMII_TX_EN pin";
        desc = "muxctrl_reg92 is a multiplexing control register for the RGMII_TX_EN pin.

Data sheet 2.3.2 muxctrl_reg92 (offset 0x170, printed page 2-116, `hi3516av100--Hi3516A-Hi3516D-Datasheet.txt` line 7953).";

        enum muxctrl_reg92_muxctrl_reg92_enum {
            GPIO14_7 = 0 { name = "Gpio14 7"; desc = "GPIO14_7"; };
            RGMII_TX_EN = 1 { name = "Rgmii Tx En"; desc = "RGMII_TX_EN"; };
        };

        field {
            name = "muxctrl_reg92";
            desc = "Multiplexing control for the RGMII_TX_EN pin";
            sw = rw;
            hw = r;
            encode = muxctrl_reg92_muxctrl_reg92_enum;
            reset = 0x0;
        } muxctrl_reg92[0:0];
    } muxctrl_reg92 @ 0x170;

    reg {
        name = "Multiplexing control register for the RGMII_TX_CLK pin";
        desc = "muxctrl_reg93 is a multiplexing control register for the RGMII_TX_CLK pin.

Data sheet 2.3.2 muxctrl_reg93 (offset 0x174, printed page 2-116, `hi3516av100--Hi3516A-Hi3516D-Datasheet.txt` line 7980).";

        enum muxctrl_reg93_muxctrl_reg93_enum {
            GPIO4_0 = 0 { name = "Gpio4 0"; desc = "GPIO4_0"; };
            RGMII_TX_CLK = 1 { name = "Rgmii Tx Clk"; desc = "RGMII_TX_CLK"; };
            RMII_CLK_OUT = 2 { name = "Rmii Clk Out"; desc = "RMII_CLK_OUT/MII_TX_CLK"; };
        };

        field {
            name = "muxctrl_reg93";
            desc = "Multiplexing control for the RGMII_TX_CLK pin. Other values: reserved.";
            sw = rw;
            hw = r;
            encode = muxctrl_reg93_muxctrl_reg93_enum;
            reset = 0x0;
        } muxctrl_reg93[1:0];
    } muxctrl_reg93 @ 0x174;

    reg {
        name = "Multiplexing control register for the RGMII_TXD0 pin";
        desc = "muxctrl_reg94 is a multiplexing control register for the RGMII_TXD0 pin.

Data sheet 2.3.2 muxctrl_reg94 (offset 0x178, printed page 2-117, `hi3516av100--Hi3516A-Hi3516D-Datasheet.txt` line 8019).";

        enum muxctrl_reg94_muxctrl_reg94_enum {
            GPIO4_1 = 0 { name = "Gpio4 1"; desc = "GPIO4_1"; };
            RGMII_TXD0 = 1 { name = "Rgmii Txd0"; desc = "RGMII_TXD0"; };
        };

        field {
            name = "muxctrl_reg94";
            desc = "Multiplexing control for the RGMII_TXD0 pin";
            sw = rw;
            hw = r;
            encode = muxctrl_reg94_muxctrl_reg94_enum;
            reset = 0x0;
        } muxctrl_reg94[0:0];
    } muxctrl_reg94 @ 0x178;

    reg {
        name = "Multiplexing control register for the RGMII_TXD1 pin";
        desc = "muxctrl_reg95 is a multiplexing control register for the RGMII_TXD1 pin.

Data sheet 2.3.2 muxctrl_reg95 (offset 0x17C, printed page 2-117, `hi3516av100--Hi3516A-Hi3516D-Datasheet.txt` line 8047).";

        enum muxctrl_reg95_muxctrl_reg95_enum {
            GPIO4_2 = 0 { name = "Gpio4 2"; desc = "GPIO4_2"; };
            RGMII_TXD1 = 1 { name = "Rgmii Txd1"; desc = "RGMII_TXD1"; };
        };

        field {
            name = "muxctrl_reg95";
            desc = "Multiplexing control for the RGMII_TXD1 pin";
            sw = rw;
            hw = r;
            encode = muxctrl_reg95_muxctrl_reg95_enum;
            reset = 0x0;
        } muxctrl_reg95[0:0];
    } muxctrl_reg95 @ 0x17C;

    reg {
        name = "Multiplexing control register for the RGMII_TXD2 pin";
        desc = "muxctrl_reg96 is a multiplexing control register for the RGMII_TXD2 pin.

Data sheet 2.3.2 muxctrl_reg96 (offset 0x180, printed page 2-118, `hi3516av100--Hi3516A-Hi3516D-Datasheet.txt` line 8085).";

        enum muxctrl_reg96_muxctrl_reg96_enum {
            GPIO4_3 = 0 { name = "Gpio4 3"; desc = "GPIO4_3"; };
            RGMII_TXD2 = 1 { name = "Rgmii Txd2"; desc = "RGMII_TXD2"; };
        };

        field {
            name = "muxctrl_reg96";
            desc = "Multiplexing control for the RGMII_TXD2 pin";
            sw = rw;
            hw = r;
            encode = muxctrl_reg96_muxctrl_reg96_enum;
            reset = 0x0;
        } muxctrl_reg96[0:0];
    } muxctrl_reg96 @ 0x180;

    reg {
        name = "Multiplexing control register for the RGMII_TXD3 pin";
        desc = "muxctrl_reg97 is a multiplexing control register for the RGMII_TXD3 pin.

Data sheet 2.3.2 muxctrl_reg97 (offset 0x184, printed page 2-118, `hi3516av100--Hi3516A-Hi3516D-Datasheet.txt` line 8112).";

        enum muxctrl_reg97_muxctrl_reg97_enum {
            GPIO4_4 = 0 { name = "Gpio4 4"; desc = "GPIO4_4"; };
            RGMII_TXD3 = 1 { name = "Rgmii Txd3"; desc = "RGMII_TXD3"; };
        };

        field {
            name = "muxctrl_reg97";
            desc = "Multiplexing control for the RGMII_TXD3 pin";
            sw = rw;
            hw = r;
            encode = muxctrl_reg97_muxctrl_reg97_enum;
            reset = 0x0;
        } muxctrl_reg97[0:0];
    } muxctrl_reg97 @ 0x184;

    reg {
        name = "Multiplexing control register for the RGMII_RX_CLK pin";
        desc = "muxctrl_reg98 is a multiplexing control register for the RGMII_RX_CLK pin.

Data sheet 2.3.2 muxctrl_reg98 (offset 0x188, printed page 2-119, `hi3516av100--Hi3516A-Hi3516D-Datasheet.txt` line 8149).";

        enum muxctrl_reg98_muxctrl_reg98_enum {
            GPIO4_5 = 0 { name = "Gpio4 5"; desc = "GPIO4_5"; };
            RGMII_RX_CLK = 1 { name = "Rgmii Rx Clk"; desc = "RGMII_RX_CLK"; };
        };

        field {
            name = "muxctrl_reg98";
            desc = "Multiplexing control for the RGMII_RX_CLK pin";
            sw = rw;
            hw = r;
            encode = muxctrl_reg98_muxctrl_reg98_enum;
            reset = 0x0;
        } muxctrl_reg98[0:0];
    } muxctrl_reg98 @ 0x188;

    reg {
        name = "Multiplexing control register for the RGMII_RX_DV pin";
        desc = "muxctrl_reg99 is a multiplexing control register for the RGMII_RX_DV pin.

Data sheet 2.3.2 muxctrl_reg99 (offset 0x18C, printed page 2-119, `hi3516av100--Hi3516A-Hi3516D-Datasheet.txt` line 8177).";

        enum muxctrl_reg99_muxctrl_reg99_enum {
            GPIO4_6 = 0 { name = "Gpio4 6"; desc = "GPIO4_6"; };
            RGMII_RX_DV = 1 { name = "Rgmii Rx Dv"; desc = "RGMII_RX_DV"; };
        };

        field {
            name = "muxctrl_reg99";
            desc = "Multiplexing control for the RGMII_RX_DV pin";
            sw = rw;
            hw = r;
            encode = muxctrl_reg99_muxctrl_reg99_enum;
            reset = 0x0;
        } muxctrl_reg99[0:0];
    } muxctrl_reg99 @ 0x18C;

    reg {
        name = "Multiplexing control register for the RGMII_RXD0 pin";
        desc = "muxctrl_reg100 is a multiplexing control register for the RGMII_RXD0 pin.

Data sheet 2.3.2 muxctrl_reg100 (offset 0x190, printed page 2-120, `hi3516av100--Hi3516A-Hi3516D-Datasheet.txt` line 8214).";

        enum muxctrl_reg100_muxctrl_reg100_enum {
            GPIO4_7 = 0 { name = "Gpio4 7"; desc = "GPIO4_7"; };
            RGMII_RXD0 = 1 { name = "Rgmii Rxd0"; desc = "RGMII_RXD0"; };
        };

        field {
            name = "muxctrl_reg100";
            desc = "Multiplexing control for the RGMII_RXD0 pin";
            sw = rw;
            hw = r;
            encode = muxctrl_reg100_muxctrl_reg100_enum;
            reset = 0x0;
        } muxctrl_reg100[0:0];
    } muxctrl_reg100 @ 0x190;

    reg {
        name = "Multiplexing control register for the RGMII_RXD1 pin";
        desc = "muxctrl_reg101 is a multiplexing control register for the RGMII_RXD1 pin.

Data sheet 2.3.2 muxctrl_reg101 (offset 0x194, printed page 2-120, `hi3516av100--Hi3516A-Hi3516D-Datasheet.txt` line 8237).";

        enum muxctrl_reg101_muxctrl_reg101_enum {
            GPIO1_3 = 0 { name = "Gpio1 3"; desc = "GPIO1_3"; };
            RGMII_RXD1 = 1 { name = "Rgmii Rxd1"; desc = "RGMII_RXD1"; };
        };

        field {
            name = "muxctrl_reg101";
            desc = "Multiplexing control for the RGMII_RXD1 pin";
            sw = rw;
            hw = r;
            encode = muxctrl_reg101_muxctrl_reg101_enum;
            reset = 0x0;
        } muxctrl_reg101[0:0];
    } muxctrl_reg101 @ 0x194;

    reg {
        name = "Multiplexing control register for the RGMII_RXD2 pin";
        desc = "muxctrl_reg102 is a multiplexing control register for the RGMII_RXD2 pin.

Data sheet 2.3.2 muxctrl_reg102 (offset 0x198, printed page 2-121, `hi3516av100--Hi3516A-Hi3516D-Datasheet.txt` line 8271).";

        enum muxctrl_reg102_muxctrl_reg102_enum {
            GPIO1_4 = 0 { name = "Gpio1 4"; desc = "GPIO1_4"; };
            RGMII_RXD2 = 1 { name = "Rgmii Rxd2"; desc = "RGMII_RXD2"; };
        };

        field {
            name = "muxctrl_reg102";
            desc = "Multiplexing control for the RGMII_RXD2 pin";
            sw = rw;
            hw = r;
            encode = muxctrl_reg102_muxctrl_reg102_enum;
            reset = 0x0;
        } muxctrl_reg102[0:0];
    } muxctrl_reg102 @ 0x198;

    reg {
        name = "Multiplexing control register for the RGMII_RXD3 pin";
        desc = "muxctrl_reg103 is a multiplexing control register for the RGMII_RXD3 pin.

Data sheet 2.3.2 muxctrl_reg103 (offset 0x19C, printed page 2-121, `hi3516av100--Hi3516A-Hi3516D-Datasheet.txt` line 8295).";

        enum muxctrl_reg103_muxctrl_reg103_enum {
            GPIO1_5 = 0 { name = "Gpio1 5"; desc = "GPIO1_5"; };
            RGMII_RXD3 = 1 { name = "Rgmii Rxd3"; desc = "RGMII_RXD3"; };
        };

        field {
            name = "muxctrl_reg103";
            desc = "Multiplexing control for the RGMII_RXD3 pin";
            sw = rw;
            hw = r;
            encode = muxctrl_reg103_muxctrl_reg103_enum;
            reset = 0x0;
        } muxctrl_reg103[0:0];
    } muxctrl_reg103 @ 0x19C;

    reg {
        name = "Multiplexing control register for the VI_CLK pin";
        desc = "muxctrl_reg104 is a multiplexing control register for the VI_CLK pin.

Data sheet 2.3.2 muxctrl_reg104 (offset 0x1A0, printed page 2-122, `hi3516av100--Hi3516A-Hi3516D-Datasheet.txt` line 8329).";

        enum muxctrl_reg104_muxctrl_reg104_enum {
            GPIO15_0 = 0 { name = "Gpio15 0"; desc = "GPIO15_0"; };
            VI_CLK = 1 { name = "Vi Clk"; desc = "VI_CLK"; };
        };

        field {
            name = "muxctrl_reg104";
            desc = "Multiplexing control for the VI_CLK pin";
            sw = rw;
            hw = r;
            encode = muxctrl_reg104_muxctrl_reg104_enum;
            reset = 0x0;
        } muxctrl_reg104[0:0];
    } muxctrl_reg104 @ 0x1A0;

    reg {
        name = "Multiplexing control register for the VI_HS pin";
        desc = "muxctrl_reg105 is a multiplexing control register for the VI_HS pin.

Data sheet 2.3.2 muxctrl_reg105 (offset 0x1A4, printed page 2-122, `hi3516av100--Hi3516A-Hi3516D-Datasheet.txt` line 8352).";

        enum muxctrl_reg105_muxctrl_reg105_enum {
            GPIO15_1 = 0 { name = "Gpio15 1"; desc = "GPIO15_1"; };
            VI_HS = 1 { name = "Vi Hs"; desc = "VI_HS"; };
        };

        field {
            name = "muxctrl_reg105";
            desc = "Multiplexing control for the VI_HS pin. Other values: reserved.";
            sw = rw;
            hw = r;
            encode = muxctrl_reg105_muxctrl_reg105_enum;
            reset = 0x0;
        } muxctrl_reg105[1:0];
    } muxctrl_reg105 @ 0x1A4;

    reg {
        name = "Multiplexing control register for the VI_VS pin";
        desc = "muxctrl_reg106 is a multiplexing control register for the VI_VS pin.

Data sheet 2.3.2 muxctrl_reg106 (offset 0x1A8, printed page 2-123, `hi3516av100--Hi3516A-Hi3516D-Datasheet.txt` line 8387).";

        enum muxctrl_reg106_muxctrl_reg106_enum {
            GPIO15_2 = 0 { name = "Gpio15 2"; desc = "GPIO15_2"; };
            VI_VS = 1 { name = "Vi Vs"; desc = "VI_VS"; };
        };

        field {
            name = "muxctrl_reg106";
            desc = "Multiplexing control for the VI_VS pin. Other values: reserved.";
            sw = rw;
            hw = r;
            encode = muxctrl_reg106_muxctrl_reg106_enum;
            reset = 0x0;
        } muxctrl_reg106[1:0];
    } muxctrl_reg106 @ 0x1A8;

    reg {
        name = "Multiplexing control register for the VI_DAT15 pin";
        desc = "muxctrl_reg107 is a multiplexing control register for the VI_DAT15 pin.

Data sheet 2.3.2 muxctrl_reg107 (offset 0x1AC, printed page 2-123, `hi3516av100--Hi3516A-Hi3516D-Datasheet.txt` line 8412).";

        enum muxctrl_reg107_muxctrl_reg107_enum {
            GPIO12_0 = 0 { name = "Gpio12 0"; desc = "GPIO12_0"; };
            VI_DAT15 = 1 { name = "Vi Dat15"; desc = "VI_DAT15"; };
            I2S_MCLK = 2 { name = "I2S Mclk"; desc = "I2S_MCLK"; };
        };

        field {
            name = "muxctrl_reg107";
            desc = "Multiplexing control for the VI_DAT15 pin. Other values: reserved.";
            sw = rw;
            hw = r;
            encode = muxctrl_reg107_muxctrl_reg107_enum;
            reset = 0x0;
        } muxctrl_reg107[1:0];
    } muxctrl_reg107 @ 0x1AC;

    reg {
        name = "Multiplexing control register for the VI_DAT14 pin";
        desc = "muxctrl_reg108 is a multiplexing control register for the VI_DAT14 pin.

Data sheet 2.3.2 muxctrl_reg108 (offset 0x1B0, printed page 2-124, `hi3516av100--Hi3516A-Hi3516D-Datasheet.txt` line 8446).";

        enum muxctrl_reg108_muxctrl_reg108_enum {
            GPIO12_1 = 0 { name = "Gpio12 1"; desc = "GPIO12_1"; };
            VI_DAT14 = 1 { name = "Vi Dat14"; desc = "VI_DAT14"; };
            I2S_BCLK_TX = 2 { name = "I2S Bclk Tx"; desc = "I2S_BCLK_TX"; };
        };

        field {
            name = "muxctrl_reg108";
            desc = "Multiplexing control for the VI_DAT14 pin. Other values: reserved.";
            sw = rw;
            hw = r;
            encode = muxctrl_reg108_muxctrl_reg108_enum;
            reset = 0x0;
        } muxctrl_reg108[1:0];
    } muxctrl_reg108 @ 0x1B0;

    reg {
        name = "Multiplexing control register for the VI_DAT13 pin";
        desc = "muxctrl_reg109 is a multiplexing control register for the VI_DAT13 pin.

Data sheet 2.3.2 muxctrl_reg109 (offset 0x1B4, printed page 2-124, `hi3516av100--Hi3516A-Hi3516D-Datasheet.txt` line 8471).";

        enum muxctrl_reg109_muxctrl_reg109_enum {
            GPIO12_2 = 0 { name = "Gpio12 2"; desc = "GPIO12_2"; };
            VI_DAT13 = 1 { name = "Vi Dat13"; desc = "VI_DAT13"; };
            I2S_WS_TX = 2 { name = "I2S Ws Tx"; desc = "I2S_WS_TX"; };
        };

        field {
            name = "muxctrl_reg109";
            desc = "Multiplexing control for the VI_DAT13 pin. Other values: reserved.";
            sw = rw;
            hw = r;
            encode = muxctrl_reg109_muxctrl_reg109_enum;
            reset = 0x0;
        } muxctrl_reg109[1:0];
    } muxctrl_reg109 @ 0x1B4;

    reg {
        name = "Multiplexing control register for the VI_DAT12 pin";
        desc = "muxctrl_reg110 is a multiplexing control register for the VI_DAT12 pin.

Data sheet 2.3.2 muxctrl_reg110 (offset 0x1B8, printed page 2-125, `hi3516av100--Hi3516A-Hi3516D-Datasheet.txt` line 8502).";

        enum muxctrl_reg110_muxctrl_reg110_enum {
            GPIO12_3 = 0 { name = "Gpio12 3"; desc = "GPIO12_3"; };
            VI_DAT12 = 1 { name = "Vi Dat12"; desc = "VI_DAT12"; };
            I2S_SD_TX = 2 { name = "I2S Sd Tx"; desc = "I2S_SD_TX"; };
        };

        field {
            name = "muxctrl_reg110";
            desc = "Multiplexing control for the VI_DAT12 pin. Other values: reserved.";
            sw = rw;
            hw = r;
            encode = muxctrl_reg110_muxctrl_reg110_enum;
            reset = 0x0;
        } muxctrl_reg110[1:0];
    } muxctrl_reg110 @ 0x1B8;

    reg {
        name = "Multiplexing control register for the VI_DAT11 pin";
        desc = "muxctrl_reg111 is a multiplexing control register for the VI_DAT11 pin.

Data sheet 2.3.2 muxctrl_reg111 (offset 0x1BC, printed page 2-125, `hi3516av100--Hi3516A-Hi3516D-Datasheet.txt` line 8527).";

        enum muxctrl_reg111_muxctrl_reg111_enum {
            GPIO12_4 = 0 { name = "Gpio12 4"; desc = "GPIO12_4"; };
            VI_DAT11 = 1 { name = "Vi Dat11"; desc = "VI_DAT11"; };
            I2S_BCLK_RX = 2 { name = "I2S Bclk Rx"; desc = "I2S_BCLK_RX"; };
        };

        field {
            name = "muxctrl_reg111";
            desc = "Multiplexing control for the VI_DAT11 pin. Other values: reserved.";
            sw = rw;
            hw = r;
            encode = muxctrl_reg111_muxctrl_reg111_enum;
            reset = 0x0;
        } muxctrl_reg111[1:0];
    } muxctrl_reg111 @ 0x1BC;

    reg {
        name = "Multiplexing control register for the VI_DAT10 pin";
        desc = "muxctrl_reg112 is a multiplexing control register for the VI_DAT10 pin.

Data sheet 2.3.2 muxctrl_reg112 (offset 0x1C0, printed page 2-126, `hi3516av100--Hi3516A-Hi3516D-Datasheet.txt` line 8558).";

        enum muxctrl_reg112_muxctrl_reg112_enum {
            GPIO12_5 = 0 { name = "Gpio12 5"; desc = "GPIO12_5"; };
            VI_DAT10 = 1 { name = "Vi Dat10"; desc = "VI_DAT10"; };
            I2S_WS_RX = 2 { name = "I2S Ws Rx"; desc = "I2S_WS_RX"; };
        };

        field {
            name = "muxctrl_reg112";
            desc = "Multiplexing control for the VI_DAT10 pin. Other values: reserved.";
            sw = rw;
            hw = r;
            encode = muxctrl_reg112_muxctrl_reg112_enum;
            reset = 0x0;
        } muxctrl_reg112[1:0];
    } muxctrl_reg112 @ 0x1C0;

    reg {
        name = "Multiplexing control register for the VI_DAT9 pin";
        desc = "muxctrl_reg113 is a multiplexing control register for the VI_DAT9 pin.

Data sheet 2.3.2 muxctrl_reg113 (offset 0x1C4, printed page 2-126, `hi3516av100--Hi3516A-Hi3516D-Datasheet.txt` line 8583).";

        enum muxctrl_reg113_muxctrl_reg113_enum {
            GPIO12_6 = 0 { name = "Gpio12 6"; desc = "GPIO12_6"; };
            VI_DAT9 = 1 { name = "Vi Dat9"; desc = "VI_DAT9"; };
            I2S_SD_RX = 2 { name = "I2S Sd Rx"; desc = "I2S_SD_RX"; };
        };

        field {
            name = "muxctrl_reg113";
            desc = "Multiplexing control for the VI_DAT9 pin. Other values: reserved.";
            sw = rw;
            hw = r;
            encode = muxctrl_reg113_muxctrl_reg113_enum;
            reset = 0x0;
        } muxctrl_reg113[1:0];
    } muxctrl_reg113 @ 0x1C4;

    reg {
        name = "Multiplexing control register for the VI_DAT8 pin";
        desc = "muxctrl_reg114 is a multiplexing control register for the VI_DAT8 pin.

Data sheet 2.3.2 muxctrl_reg114 (offset 0x1C8, printed page 2-127, `hi3516av100--Hi3516A-Hi3516D-Datasheet.txt` line 8614).";

        enum muxctrl_reg114_muxctrl_reg114_enum {
            GPIO12_7 = 0 { name = "Gpio12 7"; desc = "GPIO12_7"; };
            VI_DAT8 = 1 { name = "Vi Dat8"; desc = "VI_DAT8"; };
        };

        field {
            name = "muxctrl_reg114";
            desc = "Multiplexing control for the VI_DAT8 pin. Other values: reserved.";
            sw = rw;
            hw = r;
            encode = muxctrl_reg114_muxctrl_reg114_enum;
            reset = 0x0;
        } muxctrl_reg114[1:0];
    } muxctrl_reg114 @ 0x1C8;

    reg {
        name = "Multiplexing control register for the VI_DAT7 pin";
        desc = "muxctrl_reg115 is a multiplexing control register for the VI_DAT7 pin.

Data sheet 2.3.2 muxctrl_reg115 (offset 0x1CC, printed page 2-127, `hi3516av100--Hi3516A-Hi3516D-Datasheet.txt` line 8639).";

        enum muxctrl_reg115_muxctrl_reg115_enum {
            GPIO13_0 = 0 { name = "Gpio13 0"; desc = "GPIO13_0"; };
            VI_DAT7 = 1 { name = "Vi Dat7"; desc = "VI_DAT7"; };
        };

        field {
            name = "muxctrl_reg115";
            desc = "Multiplexing control for the VI_DAT7 pin. Other values: reserved.";
            sw = rw;
            hw = r;
            encode = muxctrl_reg115_muxctrl_reg115_enum;
            reset = 0x0;
        } muxctrl_reg115[1:0];
    } muxctrl_reg115 @ 0x1CC;

    reg {
        name = "Multiplexing control register for the VI_DAT6 pin";
        desc = "muxctrl_reg116 is a multiplexing control register for the VI_DAT6 pin.

Data sheet 2.3.2 muxctrl_reg116 (offset 0x1D0, printed page 2-128, `hi3516av100--Hi3516A-Hi3516D-Datasheet.txt` line 8670).";

        enum muxctrl_reg116_muxctrl_reg116_enum {
            GPIO13_1 = 0 { name = "Gpio13 1"; desc = "GPIO13_1"; };
            VI_DAT6 = 1 { name = "Vi Dat6"; desc = "VI_DAT6"; };
        };

        field {
            name = "muxctrl_reg116";
            desc = "Multiplexing control for the VI_DAT6 pin. Other values: reserved.";
            sw = rw;
            hw = r;
            encode = muxctrl_reg116_muxctrl_reg116_enum;
            reset = 0x0;
        } muxctrl_reg116[1:0];
    } muxctrl_reg116 @ 0x1D0;

    reg {
        name = "Multiplexing control register for the VI_DAT5 pin";
        desc = "muxctrl_reg117 is a multiplexing control register for the VI_DAT5 pin.

Data sheet 2.3.2 muxctrl_reg117 (offset 0x1D4, printed page 2-128, `hi3516av100--Hi3516A-Hi3516D-Datasheet.txt` line 8695).";

        enum muxctrl_reg117_muxctrl_reg117_enum {
            GPIO13_2 = 0 { name = "Gpio13 2"; desc = "GPIO13_2"; };
            VI_DAT5 = 1 { name = "Vi Dat5"; desc = "VI_DAT5"; };
        };

        field {
            name = "muxctrl_reg117";
            desc = "Multiplexing control for the VI_DAT5 pin. Other values: reserved.";
            sw = rw;
            hw = r;
            encode = muxctrl_reg117_muxctrl_reg117_enum;
            reset = 0x0;
        } muxctrl_reg117[1:0];
    } muxctrl_reg117 @ 0x1D4;

    reg {
        name = "Multiplexing control register for the VI_DAT4 pin";
        desc = "muxctrl_reg118 is a multiplexing control register for the VI_DAT4 pin.

Data sheet 2.3.2 muxctrl_reg118 (offset 0x1D8, printed page 2-129, `hi3516av100--Hi3516A-Hi3516D-Datasheet.txt` line 8726).";

        enum muxctrl_reg118_muxctrl_reg118_enum {
            GPIO13_3 = 0 { name = "Gpio13 3"; desc = "GPIO13_3"; };
            VI_DAT4 = 1 { name = "Vi Dat4"; desc = "VI_DAT4"; };
        };

        field {
            name = "muxctrl_reg118";
            desc = "Multiplexing control for the VI_DAT4 pin. Other values: reserved.";
            sw = rw;
            hw = r;
            encode = muxctrl_reg118_muxctrl_reg118_enum;
            reset = 0x0;
        } muxctrl_reg118[1:0];
    } muxctrl_reg118 @ 0x1D8;

    reg {
        name = "Multiplexing control register for the VI_DAT3 pin";
        desc = "muxctrl_reg119 is a multiplexing control register for the VI_DAT3 pin.

Data sheet 2.3.2 muxctrl_reg119 (offset 0x1DC, printed page 2-129, `hi3516av100--Hi3516A-Hi3516D-Datasheet.txt` line 8751).";

        enum muxctrl_reg119_muxctrl_reg119_enum {
            GPIO13_4 = 0 { name = "Gpio13 4"; desc = "GPIO13_4"; };
            VI_DAT3 = 1 { name = "Vi Dat3"; desc = "VI_DAT3"; };
        };

        field {
            name = "muxctrl_reg119";
            desc = "Multiplexing control for the VI_DAT3 pin. Other values: reserved.";
            sw = rw;
            hw = r;
            encode = muxctrl_reg119_muxctrl_reg119_enum;
            reset = 0x0;
        } muxctrl_reg119[1:0];
    } muxctrl_reg119 @ 0x1DC;

    reg {
        name = "Multiplexing control register for the VI_DAT2 pin";
        desc = "muxctrl_reg120 is a multiplexing control register for the VI_DAT2 pin.

Data sheet 2.3.2 muxctrl_reg120 (offset 0x1E0, printed page 2-130, `hi3516av100--Hi3516A-Hi3516D-Datasheet.txt` line 8782).";

        enum muxctrl_reg120_muxctrl_reg120_enum {
            GPIO13_5 = 0 { name = "Gpio13 5"; desc = "GPIO13_5"; };
            VI_DAT2 = 1 { name = "Vi Dat2"; desc = "VI_DAT2"; };
        };

        field {
            name = "muxctrl_reg120";
            desc = "Multiplexing control for the VI_DAT2 pin. Other values: reserved.";
            sw = rw;
            hw = r;
            encode = muxctrl_reg120_muxctrl_reg120_enum;
            reset = 0x0;
        } muxctrl_reg120[1:0];
    } muxctrl_reg120 @ 0x1E0;

    reg {
        name = "Multiplexing control register for the VI_DAT1 pin";
        desc = "muxctrl_reg121 is a multiplexing control register for the VI_DAT1 pin.

Data sheet 2.3.2 muxctrl_reg121 (offset 0x1E4, printed page 2-130, `hi3516av100--Hi3516A-Hi3516D-Datasheet.txt` line 8807).";

        enum muxctrl_reg121_muxctrl_reg121_enum {
            GPIO13_6 = 0 { name = "Gpio13 6"; desc = "GPIO13_6"; };
            VI_DAT1 = 1 { name = "Vi Dat1"; desc = "VI_DAT1"; };
        };

        field {
            name = "muxctrl_reg121";
            desc = "Multiplexing control for the VI_DAT1 pin. Other values: reserved.";
            sw = rw;
            hw = r;
            encode = muxctrl_reg121_muxctrl_reg121_enum;
            reset = 0x0;
        } muxctrl_reg121[1:0];
    } muxctrl_reg121 @ 0x1E4;

    reg {
        name = "Multiplexing control register for the VI_DAT0 pin";
        desc = "muxctrl_reg122 is a multiplexing control register for the VI_DAT0 pin.

Data sheet 2.3.2 muxctrl_reg122 (offset 0x1E8, printed page 2-131, `hi3516av100--Hi3516A-Hi3516D-Datasheet.txt` line 8838).";

        enum muxctrl_reg122_muxctrl_reg122_enum {
            GPIO13_7 = 0 { name = "Gpio13 7"; desc = "GPIO13_7"; };
            VI_DAT0 = 1 { name = "Vi Dat0"; desc = "VI_DAT0"; };
            PWM4 = 3 { name = "Pwm4"; desc = "PWM4"; };
        };

        field {
            name = "muxctrl_reg122";
            desc = "Multiplexing control for the VI_DAT0 pin. Other values: reserved.";
            sw = rw;
            hw = r;
            encode = muxctrl_reg122_muxctrl_reg122_enum;
            reset = 0x0;
        } muxctrl_reg122[1:0];
    } muxctrl_reg122 @ 0x1E8;

    reg {
        name = "Drive capability register for the SENSOR_CLK pin";
        desc = "PADCTRL_REG0 is a drive capability register for the SENSOR_CLK pin.

Pad control register at 0x200F0800 + 0x0. Fields named `_sr` read 0 = fast edge / 1 = slow edge; the two SAR_ADC registers (PADCTRL_REG100/101) instead have `_sl` (0 = slow / 1 = fast) plus Schmitt, pull-up and pull-down bits. Drive strength tables differ per pin group (see the field).

Data sheet 2.6.2 PADCTRL_REG0 (offset 0x0, printed page 2-164, `hi3516av100--Hi3516A-Hi3516D-Datasheet.txt` line 10506).";

        enum PADCTRL_REG0_sensor_clk_sr_enum {
            FAST_EDGE = 0 { name = "Fast Edge"; desc = "fast edge"; };
            SLOW_EDGE = 1 { name = "Slow Edge"; desc = "slow edge"; };
        };

        field {
            name = "sensor_clk_sr";
            desc = "Level conversion rate of the SENSOR_CLK pin";
            sw = rw;
            hw = r;
            encode = PADCTRL_REG0_sensor_clk_sr_enum;
            reset = 0x0;
        } sensor_clk_sr[7:7];

        enum PADCTRL_REG0_sensor_clk_ds_enum {
            V_12_MA = 0 { name = "V 12 Ma"; desc = "12 mA"; };
            V_11_MA = 1 { name = "V 11 Ma"; desc = "11 mA"; };
            V_9_MA = 2 { name = "V 9 Ma"; desc = "9 mA"; };
            V_8_MA = 3 { name = "V 8 Ma"; desc = "8 mA"; };
            V_5_MA = 4 { name = "V 5 Ma"; desc = "5 mA"; };
            V_4_MA = 5 { name = "V 4 Ma"; desc = "4 mA"; };
            V_2_MA = 6 { name = "V 2 Ma"; desc = "2 mA"; };
            V_1_MA = 7 { name = "V 1 Ma"; desc = "1 mA"; };
        };

        field {
            name = "sensor_clk_ds";
            desc = "Drive current of the SENSOR_CLK pin";
            sw = rw;
            hw = r;
            encode = PADCTRL_REG0_sensor_clk_ds_enum;
            reset = 0x4;
        } sensor_clk_ds[6:4];
    } PADCTRL_REG0 @ 0x800;

    reg {
        name = "Drive capability register for the FLASH_TRIG pin";
        desc = "PADCTRL_REG1 is a drive capability register for the FLASH_TRIG pin.

Data sheet 2.6.2 PADCTRL_REG1 (offset 0x4, printed page 2-165, `hi3516av100--Hi3516A-Hi3516D-Datasheet.txt` line 10550).";

        enum PADCTRL_REG1_flash_trig_sr_enum {
            FAST_EDGE = 0 { name = "Fast Edge"; desc = "fast edge"; };
            SLOW_EDGE = 1 { name = "Slow Edge"; desc = "slow edge"; };
        };

        field {
            name = "flash_trig_sr";
            desc = "Level conversion rate of the FLASH_TRIG pin";
            sw = rw;
            hw = r;
            encode = PADCTRL_REG1_flash_trig_sr_enum;
            reset = 0x1;
        } flash_trig_sr[7:7];

        enum PADCTRL_REG1_flash_trig_ds_enum {
            V_4_MA = 0 { name = "V 4 Ma"; desc = "4 mA"; };
            V_3_MA = 1 { name = "V 3 Ma"; desc = "3 mA"; };
            V_2_MA = 2 { name = "V 2 Ma"; desc = "2 mA"; };
            V_1_MA = 3 { name = "V 1 Ma"; desc = "1 mA"; };
        };

        field {
            name = "flash_trig_ds";
            desc = "Drive current of the FLASH_TRIG pin";
            sw = rw;
            hw = r;
            encode = PADCTRL_REG1_flash_trig_ds_enum;
            reset = 0x2;
        } flash_trig_ds[5:4];
    } PADCTRL_REG1 @ 0x804;

    reg {
        name = "Drive capability register for the SHUTTER_TRIG pin";
        desc = "PADCTRL_REG2 is a drive capability register for the SHUTTER_TRIG pin.

Data sheet 2.6.2 PADCTRL_REG2 (offset 0x8, printed page 2-165, `hi3516av100--Hi3516A-Hi3516D-Datasheet.txt` line 10585).";

        enum PADCTRL_REG2_shutter_trig_sr_enum {
            FAST_EDGE = 0 { name = "Fast Edge"; desc = "fast edge"; };
            SLOW_EDGE = 1 { name = "Slow Edge"; desc = "slow edge"; };
        };

        field {
            name = "shutter_trig_sr";
            desc = "Level conversion rate of the SHUTTER_TRIG pin";
            sw = rw;
            hw = r;
            encode = PADCTRL_REG2_shutter_trig_sr_enum;
            reset = 0x1;
        } shutter_trig_sr[7:7];

        enum PADCTRL_REG2_shutter_trig_ds_enum {
            V_4_MA = 0 { name = "V 4 Ma"; desc = "4 mA"; };
            V_3_MA = 1 { name = "V 3 Ma"; desc = "3 mA"; };
            V_2_MA = 2 { name = "V 2 Ma"; desc = "2 mA"; };
            V_1_MA = 3 { name = "V 1 Ma"; desc = "1 mA"; };
        };

        field {
            name = "shutter_trig_ds";
            desc = "Drive current of the SHUTTER_TRIG pin";
            sw = rw;
            hw = r;
            encode = PADCTRL_REG2_shutter_trig_ds_enum;
            reset = 0x2;
        } shutter_trig_ds[5:4];
    } PADCTRL_REG2 @ 0x808;

    reg {
        name = "Drive capability register for the VO_CLK pin";
        desc = "PADCTRL_REG3 is a drive capability register for the VO_CLK pin.

Data sheet 2.6.2 PADCTRL_REG3 (offset 0xC, printed page 2-166, `hi3516av100--Hi3516A-Hi3516D-Datasheet.txt` line 10627).";

        enum PADCTRL_REG3_vo_clk_sr_enum {
            FAST_EDGE = 0 { name = "Fast Edge"; desc = "fast edge"; };
            SLOW_EDGE = 1 { name = "Slow Edge"; desc = "slow edge"; };
        };

        field {
            name = "vo_clk_sr";
            desc = "Level conversion rate of the VO_CLK pin";
            sw = rw;
            hw = r;
            encode = PADCTRL_REG3_vo_clk_sr_enum;
            reset = 0x0;
        } vo_clk_sr[7:7];

        enum PADCTRL_REG3_vo_clk_ds_enum {
            V_12_MA = 0 { name = "V 12 Ma"; desc = "12 mA"; };
            V_11_MA = 1 { name = "V 11 Ma"; desc = "11 mA"; };
            V_9_MA = 2 { name = "V 9 Ma"; desc = "9 mA"; };
            V_8_MA = 3 { name = "V 8 Ma"; desc = "8 mA"; };
            V_5_MA = 4 { name = "V 5 Ma"; desc = "5 mA"; };
            V_4_MA = 5 { name = "V 4 Ma"; desc = "4 mA"; };
            V_2_MA = 6 { name = "V 2 Ma"; desc = "2 mA"; };
            V_1_MA = 7 { name = "V 1 Ma"; desc = "1 mA"; };
        };

        field {
            name = "vo_clk_ds";
            desc = "Drive current of the VO_CLK pin";
            sw = rw;
            hw = r;
            encode = PADCTRL_REG3_vo_clk_ds_enum;
            reset = 0x4;
        } vo_clk_ds[6:4];
    } PADCTRL_REG3 @ 0x80C;

    reg {
        name = "Drive capability register for the VO_DAT15 pin";
        desc = "PADCTRL_REG4 is a drive capability register for the VO_DAT15 pin.

Data sheet 2.6.2 PADCTRL_REG4 (offset 0x10, printed page 2-167, `hi3516av100--Hi3516A-Hi3516D-Datasheet.txt` line 10675).";

        enum PADCTRL_REG4_vo_dat15_sr_enum {
            FAST_EDGE = 0 { name = "Fast Edge"; desc = "fast edge"; };
            SLOW_EDGE = 1 { name = "Slow Edge"; desc = "slow edge"; };
        };

        field {
            name = "vo_dat15_sr";
            desc = "Level conversion rate of the VO_DAT15 pin";
            sw = rw;
            hw = r;
            encode = PADCTRL_REG4_vo_dat15_sr_enum;
            reset = 0x1;
        } vo_dat15_sr[7:7];

        enum PADCTRL_REG4_vo_dat15_ds_enum {
            V_4_MA = 0 { name = "V 4 Ma"; desc = "4 mA"; };
            V_3_MA = 1 { name = "V 3 Ma"; desc = "3 mA"; };
            V_2_MA = 2 { name = "V 2 Ma"; desc = "2 mA"; };
            V_1_MA = 3 { name = "V 1 Ma"; desc = "1 mA"; };
        };

        field {
            name = "vo_dat15_ds";
            desc = "Drive current of the VO_DAT15 pin";
            sw = rw;
            hw = r;
            encode = PADCTRL_REG4_vo_dat15_ds_enum;
            reset = 0x2;
        } vo_dat15_ds[5:4];
    } PADCTRL_REG4 @ 0x810;

    reg {
        name = "Drive capability register for the VO_DAT14 pin";
        desc = "PADCTRL_REG5 is a drive capability register for the VO_DAT14 pin.

Data sheet 2.6.2 PADCTRL_REG5 (offset 0x14, printed page 2-168, `hi3516av100--Hi3516A-Hi3516D-Datasheet.txt` line 10716).";

        enum PADCTRL_REG5_vo_dat14_sr_enum {
            FAST_EDGE = 0 { name = "Fast Edge"; desc = "fast edge"; };
            SLOW_EDGE = 1 { name = "Slow Edge"; desc = "slow edge"; };
        };

        field {
            name = "vo_dat14_sr";
            desc = "Level conversion rate of the VO_DAT14 pin";
            sw = rw;
            hw = r;
            encode = PADCTRL_REG5_vo_dat14_sr_enum;
            reset = 0x1;
        } vo_dat14_sr[7:7];

        enum PADCTRL_REG5_vo_dat14_ds_enum {
            V_4_MA = 0 { name = "V 4 Ma"; desc = "4 mA"; };
            V_3_MA = 1 { name = "V 3 Ma"; desc = "3 mA"; };
            V_2_MA = 2 { name = "V 2 Ma"; desc = "2 mA"; };
            V_1_MA = 3 { name = "V 1 Ma"; desc = "1 mA"; };
        };

        field {
            name = "vo_dat14_ds";
            desc = "Drive current of the VO_DAT14 pin";
            sw = rw;
            hw = r;
            encode = PADCTRL_REG5_vo_dat14_ds_enum;
            reset = 0x2;
        } vo_dat14_ds[5:4];
    } PADCTRL_REG5 @ 0x814;

    reg {
        name = "Drive capability register for the VO_DAT13 pin";
        desc = "PADCTRL_REG6 is a drive capability register for the VO_DAT13 pin.

Data sheet 2.6.2 PADCTRL_REG6 (offset 0x18, printed page 2-168, `hi3516av100--Hi3516A-Hi3516D-Datasheet.txt` line 10751).";

        enum PADCTRL_REG6_vo_dat13_sr_enum {
            FAST_EDGE = 0 { name = "Fast Edge"; desc = "fast edge"; };
            SLOW_EDGE = 1 { name = "Slow Edge"; desc = "slow edge"; };
        };

        field {
            name = "vo_dat13_sr";
            desc = "Level conversion rate of the VO_DAT13 pin";
            sw = rw;
            hw = r;
            encode = PADCTRL_REG6_vo_dat13_sr_enum;
            reset = 0x1;
        } vo_dat13_sr[7:7];

        enum PADCTRL_REG6_vo_dat13_ds_enum {
            V_4_MA = 0 { name = "V 4 Ma"; desc = "4 mA"; };
            V_3_MA = 1 { name = "V 3 Ma"; desc = "3 mA"; };
            V_2_MA = 2 { name = "V 2 Ma"; desc = "2 mA"; };
            V_1_MA = 3 { name = "V 1 Ma"; desc = "1 mA"; };
        };

        field {
            name = "vo_dat13_ds";
            desc = "Drive current of the VO_DAT13 pin";
            sw = rw;
            hw = r;
            encode = PADCTRL_REG6_vo_dat13_ds_enum;
            reset = 0x2;
        } vo_dat13_ds[5:4];
    } PADCTRL_REG6 @ 0x818;

    reg {
        name = "Drive capability register for the VO_DAT12 pin";
        desc = "PADCTRL_REG7 is a drive capability register for the VO_DAT12 pin.

Data sheet 2.6.2 PADCTRL_REG7 (offset 0x1C, printed page 2-169, `hi3516av100--Hi3516A-Hi3516D-Datasheet.txt` line 10793).";

        enum PADCTRL_REG7_vo_dat12_sr_enum {
            FAST_EDGE = 0 { name = "Fast Edge"; desc = "fast edge"; };
            SLOW_EDGE = 1 { name = "Slow Edge"; desc = "slow edge"; };
        };

        field {
            name = "vo_dat12_sr";
            desc = "Level conversion rate of the VO_DAT12 pin";
            sw = rw;
            hw = r;
            encode = PADCTRL_REG7_vo_dat12_sr_enum;
            reset = 0x1;
        } vo_dat12_sr[7:7];

        enum PADCTRL_REG7_vo_dat12_ds_enum {
            V_4_MA = 0 { name = "V 4 Ma"; desc = "4 mA"; };
            V_3_MA = 1 { name = "V 3 Ma"; desc = "3 mA"; };
            V_2_MA = 2 { name = "V 2 Ma"; desc = "2 mA"; };
            V_1_MA = 3 { name = "V 1 Ma"; desc = "1 mA"; };
        };

        field {
            name = "vo_dat12_ds";
            desc = "Drive current of the VO_DAT12 pin";
            sw = rw;
            hw = r;
            encode = PADCTRL_REG7_vo_dat12_ds_enum;
            reset = 0x2;
        } vo_dat12_ds[5:4];
    } PADCTRL_REG7 @ 0x81C;

    reg {
        name = "Drive capability register for the VO_DAT11 pin";
        desc = "PADCTRL_REG8 is a drive capability register for the VO_DAT11 pin.

Data sheet 2.6.2 PADCTRL_REG8 (offset 0x20, printed page 2-170, `hi3516av100--Hi3516A-Hi3516D-Datasheet.txt` line 10839).";

        enum PADCTRL_REG8_vo_dat11_sr_enum {
            FAST_EDGE = 0 { name = "Fast Edge"; desc = "fast edge"; };
            SLOW_EDGE = 1 { name = "Slow Edge"; desc = "slow edge"; };
        };

        field {
            name = "vo_dat11_sr";
            desc = "Level conversion rate of the VO_DAT11 pin";
            sw = rw;
            hw = r;
            encode = PADCTRL_REG8_vo_dat11_sr_enum;
            reset = 0x1;
        } vo_dat11_sr[7:7];

        enum PADCTRL_REG8_vo_dat11_ds_enum {
            V_4_MA = 0 { name = "V 4 Ma"; desc = "4 mA"; };
            V_3_MA = 1 { name = "V 3 Ma"; desc = "3 mA"; };
            V_2_MA = 2 { name = "V 2 Ma"; desc = "2 mA"; };
            V_1_MA = 3 { name = "V 1 Ma"; desc = "1 mA"; };
        };

        field {
            name = "vo_dat11_ds";
            desc = "Drive current of the VO_DAT11 pin";
            sw = rw;
            hw = r;
            encode = PADCTRL_REG8_vo_dat11_ds_enum;
            reset = 0x2;
        } vo_dat11_ds[5:4];
    } PADCTRL_REG8 @ 0x820;

    reg {
        name = "Drive capability register for the VO_DAT10 pin";
        desc = "PADCTRL_REG9 is a drive capability register for the VO_DAT10 pin.

Data sheet 2.6.2 PADCTRL_REG9 (offset 0x24, printed page 2-171, `hi3516av100--Hi3516A-Hi3516D-Datasheet.txt` line 10880).";

        enum PADCTRL_REG9_vo_dat10_sr_enum {
            FAST_EDGE = 0 { name = "Fast Edge"; desc = "fast edge"; };
            SLOW_EDGE = 1 { name = "Slow Edge"; desc = "slow edge"; };
        };

        field {
            name = "vo_dat10_sr";
            desc = "Level conversion rate of the VO_DAT10 pin";
            sw = rw;
            hw = r;
            encode = PADCTRL_REG9_vo_dat10_sr_enum;
            reset = 0x1;
        } vo_dat10_sr[7:7];

        enum PADCTRL_REG9_vo_dat10_ds_enum {
            V_4_MA = 0 { name = "V 4 Ma"; desc = "4 mA"; };
            V_3_MA = 1 { name = "V 3 Ma"; desc = "3 mA"; };
            V_2_MA = 2 { name = "V 2 Ma"; desc = "2 mA"; };
            V_1_MA = 3 { name = "V 1 Ma"; desc = "1 mA"; };
        };

        field {
            name = "vo_dat10_ds";
            desc = "Drive current of the VO_DAT10 pin";
            sw = rw;
            hw = r;
            encode = PADCTRL_REG9_vo_dat10_ds_enum;
            reset = 0x2;
        } vo_dat10_ds[5:4];
    } PADCTRL_REG9 @ 0x824;

    reg {
        name = "Drive capability register for the VO_DAT9 pin";
        desc = "PADCTRL_REG10 is a drive capability register for the VO_DAT9 pin.

Data sheet 2.6.2 PADCTRL_REG10 (offset 0x28, printed page 2-171, `hi3516av100--Hi3516A-Hi3516D-Datasheet.txt` line 10915).";

        enum PADCTRL_REG10_vo_dat9_sr_enum {
            FAST_EDGE = 0 { name = "Fast Edge"; desc = "fast edge"; };
            SLOW_EDGE = 1 { name = "Slow Edge"; desc = "slow edge"; };
        };

        field {
            name = "vo_dat9_sr";
            desc = "Level conversion rate of the VO_DAT9 pin";
            sw = rw;
            hw = r;
            encode = PADCTRL_REG10_vo_dat9_sr_enum;
            reset = 0x1;
        } vo_dat9_sr[7:7];

        enum PADCTRL_REG10_vo_dat9_ds_enum {
            V_4_MA = 0 { name = "V 4 Ma"; desc = "4 mA"; };
            V_3_MA = 1 { name = "V 3 Ma"; desc = "3 mA"; };
            V_2_MA = 2 { name = "V 2 Ma"; desc = "2 mA"; };
            V_1_MA = 3 { name = "V 1 Ma"; desc = "1 mA"; };
        };

        field {
            name = "vo_dat9_ds";
            desc = "Drive current of the VO_DAT9 pin";
            sw = rw;
            hw = r;
            encode = PADCTRL_REG10_vo_dat9_ds_enum;
            reset = 0x2;
        } vo_dat9_ds[5:4];
    } PADCTRL_REG10 @ 0x828;

    reg {
        name = "Drive capability register for the VO_DAT8 pin";
        desc = "PADCTRL_REG11 is a drive capability register for the VO_DAT8 pin.

Data sheet 2.6.2 PADCTRL_REG11 (offset 0x2C, printed page 2-172, `hi3516av100--Hi3516A-Hi3516D-Datasheet.txt` line 10957).";

        enum PADCTRL_REG11_vo_dat8_sr_enum {
            FAST_EDGE = 0 { name = "Fast Edge"; desc = "fast edge"; };
            SLOW_EDGE = 1 { name = "Slow Edge"; desc = "slow edge"; };
        };

        field {
            name = "vo_dat8_sr";
            desc = "Level conversion rate of the VO_DAT8 pin";
            sw = rw;
            hw = r;
            encode = PADCTRL_REG11_vo_dat8_sr_enum;
            reset = 0x1;
        } vo_dat8_sr[7:7];

        enum PADCTRL_REG11_vo_dat8_ds_enum {
            V_4_MA = 0 { name = "V 4 Ma"; desc = "4 mA"; };
            V_3_MA = 1 { name = "V 3 Ma"; desc = "3 mA"; };
            V_2_MA = 2 { name = "V 2 Ma"; desc = "2 mA"; };
            V_1_MA = 3 { name = "V 1 Ma"; desc = "1 mA"; };
        };

        field {
            name = "vo_dat8_ds";
            desc = "Drive current of the VO_DAT8 pin";
            sw = rw;
            hw = r;
            encode = PADCTRL_REG11_vo_dat8_ds_enum;
            reset = 0x2;
        } vo_dat8_ds[5:4];
    } PADCTRL_REG11 @ 0x82C;

    reg {
        name = "Drive capability register for the VO_DAT7 pin";
        desc = "PADCTRL_REG12 is a drive capability register for the VO_DAT7 pin.

Data sheet 2.6.2 PADCTRL_REG12 (offset 0x30, printed page 2-173, `hi3516av100--Hi3516A-Hi3516D-Datasheet.txt` line 11003).";

        enum PADCTRL_REG12_vo_dat7_sr_enum {
            FAST_EDGE = 0 { name = "Fast Edge"; desc = "fast edge"; };
            SLOW_EDGE = 1 { name = "Slow Edge"; desc = "slow edge"; };
        };

        field {
            name = "vo_dat7_sr";
            desc = "Level conversion rate of the VO_DAT7 pin";
            sw = rw;
            hw = r;
            encode = PADCTRL_REG12_vo_dat7_sr_enum;
            reset = 0x1;
        } vo_dat7_sr[7:7];

        enum PADCTRL_REG12_vo_dat7_ds_enum {
            V_4_MA = 0 { name = "V 4 Ma"; desc = "4 mA"; };
            V_3_MA = 1 { name = "V 3 Ma"; desc = "3 mA"; };
            V_2_MA = 2 { name = "V 2 Ma"; desc = "2 mA"; };
            V_1_MA = 3 { name = "V 1 Ma"; desc = "1 mA"; };
        };

        field {
            name = "vo_dat7_ds";
            desc = "Drive current of the VO_DAT7 pin";
            sw = rw;
            hw = r;
            encode = PADCTRL_REG12_vo_dat7_ds_enum;
            reset = 0x2;
        } vo_dat7_ds[5:4];
    } PADCTRL_REG12 @ 0x830;

    reg {
        name = "Drive capability register for the VO_DAT6 pin";
        desc = "PADCTRL_REG13 is a drive capability register for the VO_DAT6 pin.

Data sheet 2.6.2 PADCTRL_REG13 (offset 0x34, printed page 2-174, `hi3516av100--Hi3516A-Hi3516D-Datasheet.txt` line 11044).";

        enum PADCTRL_REG13_vo_dat6_sr_enum {
            FAST_EDGE = 0 { name = "Fast Edge"; desc = "fast edge"; };
            SLOW_EDGE = 1 { name = "Slow Edge"; desc = "slow edge"; };
        };

        field {
            name = "vo_dat6_sr";
            desc = "Level conversion rate of the VO_DAT6 pin";
            sw = rw;
            hw = r;
            encode = PADCTRL_REG13_vo_dat6_sr_enum;
            reset = 0x1;
        } vo_dat6_sr[7:7];

        enum PADCTRL_REG13_vo_dat6_ds_enum {
            V_4_MA = 0 { name = "V 4 Ma"; desc = "4 mA"; };
            V_3_MA = 1 { name = "V 3 Ma"; desc = "3 mA"; };
            V_2_MA = 2 { name = "V 2 Ma"; desc = "2 mA"; };
            V_1_MA = 3 { name = "V 1 Ma"; desc = "1 mA"; };
        };

        field {
            name = "vo_dat6_ds";
            desc = "Drive current of the VO_DAT6 pin";
            sw = rw;
            hw = r;
            encode = PADCTRL_REG13_vo_dat6_ds_enum;
            reset = 0x2;
        } vo_dat6_ds[5:4];
    } PADCTRL_REG13 @ 0x834;

    reg {
        name = "Drive capability register for the VO_DAT5 pin";
        desc = "PADCTRL_REG14 is a drive capability register for the VO_DAT5 pin.

Data sheet 2.6.2 PADCTRL_REG14 (offset 0x38, printed page 2-174, `hi3516av100--Hi3516A-Hi3516D-Datasheet.txt` line 11079).";

        enum PADCTRL_REG14_vo_dat5_sr_enum {
            FAST_EDGE = 0 { name = "Fast Edge"; desc = "fast edge"; };
            SLOW_EDGE = 1 { name = "Slow Edge"; desc = "slow edge"; };
        };

        field {
            name = "vo_dat5_sr";
            desc = "Level conversion rate of the VO_DAT5 pin";
            sw = rw;
            hw = r;
            encode = PADCTRL_REG14_vo_dat5_sr_enum;
            reset = 0x1;
        } vo_dat5_sr[7:7];

        enum PADCTRL_REG14_vo_dat5_ds_enum {
            V_4_MA = 0 { name = "V 4 Ma"; desc = "4 mA"; };
            V_3_MA = 1 { name = "V 3 Ma"; desc = "3 mA"; };
            V_2_MA = 2 { name = "V 2 Ma"; desc = "2 mA"; };
            V_1_MA = 3 { name = "V 1 Ma"; desc = "1 mA"; };
        };

        field {
            name = "vo_dat5_ds";
            desc = "Drive current of the VO_DAT5 pin";
            sw = rw;
            hw = r;
            encode = PADCTRL_REG14_vo_dat5_ds_enum;
            reset = 0x2;
        } vo_dat5_ds[5:4];
    } PADCTRL_REG14 @ 0x838;

    reg {
        name = "Drive capability register for the VO_DAT4 pin";
        desc = "PADCTRL_REG15 is a drive capability register for the VO_DAT4 pin.

Data sheet 2.6.2 PADCTRL_REG15 (offset 0x3C, printed page 2-175, `hi3516av100--Hi3516A-Hi3516D-Datasheet.txt` line 11121).";

        enum PADCTRL_REG15_vo_dat4_sr_enum {
            FAST_EDGE = 0 { name = "Fast Edge"; desc = "fast edge"; };
            SLOW_EDGE = 1 { name = "Slow Edge"; desc = "slow edge"; };
        };

        field {
            name = "vo_dat4_sr";
            desc = "Level conversion rate of the VO_DAT4 pin";
            sw = rw;
            hw = r;
            encode = PADCTRL_REG15_vo_dat4_sr_enum;
            reset = 0x1;
        } vo_dat4_sr[7:7];

        enum PADCTRL_REG15_vo_dat4_ds_enum {
            V_4_MA = 0 { name = "V 4 Ma"; desc = "4 mA"; };
            V_3_MA = 1 { name = "V 3 Ma"; desc = "3 mA"; };
            V_2_MA = 2 { name = "V 2 Ma"; desc = "2 mA"; };
            V_1_MA = 3 { name = "V 1 Ma"; desc = "1 mA"; };
        };

        field {
            name = "vo_dat4_ds";
            desc = "Drive current of the VO_DAT4 pin";
            sw = rw;
            hw = r;
            encode = PADCTRL_REG15_vo_dat4_ds_enum;
            reset = 0x2;
        } vo_dat4_ds[5:4];
    } PADCTRL_REG15 @ 0x83C;

    reg {
        name = "Drive capability register for the VO_DAT3 pin";
        desc = "PADCTRL_REG16 is a drive capability register for the VO_DAT3 pin.

Data sheet 2.6.2 PADCTRL_REG16 (offset 0x40, printed page 2-176, `hi3516av100--Hi3516A-Hi3516D-Datasheet.txt` line 11167).";

        enum PADCTRL_REG16_vo_dat3_sr_enum {
            FAST_EDGE = 0 { name = "Fast Edge"; desc = "fast edge"; };
            SLOW_EDGE = 1 { name = "Slow Edge"; desc = "slow edge"; };
        };

        field {
            name = "vo_dat3_sr";
            desc = "Level conversion rate of the VO_DAT3 pin";
            sw = rw;
            hw = r;
            encode = PADCTRL_REG16_vo_dat3_sr_enum;
            reset = 0x1;
        } vo_dat3_sr[7:7];

        enum PADCTRL_REG16_vo_dat3_ds_enum {
            V_4_MA = 0 { name = "V 4 Ma"; desc = "4 mA"; };
            V_3_MA = 1 { name = "V 3 Ma"; desc = "3 mA"; };
            V_2_MA = 2 { name = "V 2 Ma"; desc = "2 mA"; };
            V_1_MA = 3 { name = "V 1 Ma"; desc = "1 mA"; };
        };

        field {
            name = "vo_dat3_ds";
            desc = "Drive current of the VO_DAT3 pin";
            sw = rw;
            hw = r;
            encode = PADCTRL_REG16_vo_dat3_ds_enum;
            reset = 0x2;
        } vo_dat3_ds[5:4];
    } PADCTRL_REG16 @ 0x840;

    reg {
        name = "Drive capability register for the VO_DAT2 pin";
        desc = "PADCTRL_REG17 is a drive capability register for the VO_DAT2 pin.

Data sheet 2.6.2 PADCTRL_REG17 (offset 0x44, printed page 2-177, `hi3516av100--Hi3516A-Hi3516D-Datasheet.txt` line 11208).";

        enum PADCTRL_REG17_vo_dat2_sr_enum {
            FAST_EDGE = 0 { name = "Fast Edge"; desc = "fast edge"; };
            SLOW_EDGE = 1 { name = "Slow Edge"; desc = "slow edge"; };
        };

        field {
            name = "vo_dat2_sr";
            desc = "Level conversion rate of the VO_DAT2 pin";
            sw = rw;
            hw = r;
            encode = PADCTRL_REG17_vo_dat2_sr_enum;
            reset = 0x1;
        } vo_dat2_sr[7:7];

        enum PADCTRL_REG17_vo_dat2_ds_enum {
            V_4_MA = 0 { name = "V 4 Ma"; desc = "4 mA"; };
            V_3_MA = 1 { name = "V 3 Ma"; desc = "3 mA"; };
            V_2_MA = 2 { name = "V 2 Ma"; desc = "2 mA"; };
            V_1_MA = 3 { name = "V 1 Ma"; desc = "1 mA"; };
        };

        field {
            name = "vo_dat2_ds";
            desc = "Drive current of the VO_DAT2 pin";
            sw = rw;
            hw = r;
            encode = PADCTRL_REG17_vo_dat2_ds_enum;
            reset = 0x2;
        } vo_dat2_ds[5:4];
    } PADCTRL_REG17 @ 0x844;

    reg {
        name = "Drive capability register for the VO_DAT1 pin";
        desc = "PADCTRL_REG18 is a drive capability register for the VO_DAT1 pin.

Data sheet 2.6.2 PADCTRL_REG18 (offset 0x48, printed page 2-177, `hi3516av100--Hi3516A-Hi3516D-Datasheet.txt` line 11243).";

        enum PADCTRL_REG18_vo_dat1_sr_enum {
            FAST_EDGE = 0 { name = "Fast Edge"; desc = "fast edge"; };
            SLOW_EDGE = 1 { name = "Slow Edge"; desc = "slow edge"; };
        };

        field {
            name = "vo_dat1_sr";
            desc = "Level conversion rate of the VO_DAT1 pin";
            sw = rw;
            hw = r;
            encode = PADCTRL_REG18_vo_dat1_sr_enum;
            reset = 0x1;
        } vo_dat1_sr[7:7];

        enum PADCTRL_REG18_vo_dat1_ds_enum {
            V_4_MA = 0 { name = "V 4 Ma"; desc = "4 mA"; };
            V_3_MA = 1 { name = "V 3 Ma"; desc = "3 mA"; };
            V_2_MA = 2 { name = "V 2 Ma"; desc = "2 mA"; };
            V_1_MA = 3 { name = "V 1 Ma"; desc = "1 mA"; };
        };

        field {
            name = "vo_dat1_ds";
            desc = "Drive current of the VO_DAT1 pin";
            sw = rw;
            hw = r;
            encode = PADCTRL_REG18_vo_dat1_ds_enum;
            reset = 0x2;
        } vo_dat1_ds[5:4];
    } PADCTRL_REG18 @ 0x848;

    reg {
        name = "Drive capability register for the VO_DAT0 pin";
        desc = "PADCTRL_REG19 is a drive capability register for the VO_DAT0 pin.

Data sheet 2.6.2 PADCTRL_REG19 (offset 0x4C, printed page 2-178, `hi3516av100--Hi3516A-Hi3516D-Datasheet.txt` line 11285).";

        enum PADCTRL_REG19_vo_dat0_sr_enum {
            FAST_EDGE = 0 { name = "Fast Edge"; desc = "fast edge"; };
            SLOW_EDGE = 1 { name = "Slow Edge"; desc = "slow edge"; };
        };

        field {
            name = "vo_dat0_sr";
            desc = "Level conversion rate of the VO_DAT0 pin";
            sw = rw;
            hw = r;
            encode = PADCTRL_REG19_vo_dat0_sr_enum;
            reset = 0x1;
        } vo_dat0_sr[7:7];

        enum PADCTRL_REG19_vo_dat0_ds_enum {
            V_4_MA = 0 { name = "V 4 Ma"; desc = "4 mA"; };
            V_3_MA = 1 { name = "V 3 Ma"; desc = "3 mA"; };
            V_2_MA = 2 { name = "V 2 Ma"; desc = "2 mA"; };
            V_1_MA = 3 { name = "V 1 Ma"; desc = "1 mA"; };
        };

        field {
            name = "vo_dat0_ds";
            desc = "Drive current of the VO_DAT0 pin";
            sw = rw;
            hw = r;
            encode = PADCTRL_REG19_vo_dat0_ds_enum;
            reset = 0x2;
        } vo_dat0_ds[5:4];
    } PADCTRL_REG19 @ 0x84C;

    reg {
        name = "Drive capability register for the SPI0_SCLK pin";
        desc = "PADCTRL_REG20 is a drive capability register for the SPI0_SCLK pin.

Data sheet 2.6.2 PADCTRL_REG20 (offset 0x50, printed page 2-179, `hi3516av100--Hi3516A-Hi3516D-Datasheet.txt` line 11331).";

        enum PADCTRL_REG20_spi0_sclk_sr_enum {
            FAST_EDGE = 0 { name = "Fast Edge"; desc = "fast edge"; };
            SLOW_EDGE = 1 { name = "Slow Edge"; desc = "slow edge"; };
        };

        field {
            name = "spi0_sclk_sr";
            desc = "Level conversion rate of the SPI0_SCLK pin";
            sw = rw;
            hw = r;
            encode = PADCTRL_REG20_spi0_sclk_sr_enum;
            reset = 0x0;
        } spi0_sclk_sr[7:7];

        enum PADCTRL_REG20_spi0_sclk_ds_enum {
            V_12_MA = 0 { name = "V 12 Ma"; desc = "12 mA"; };
            V_11_MA = 1 { name = "V 11 Ma"; desc = "11 mA"; };
            V_9_MA = 2 { name = "V 9 Ma"; desc = "9 mA"; };
            V_8_MA = 3 { name = "V 8 Ma"; desc = "8 mA"; };
            V_5_MA = 4 { name = "V 5 Ma"; desc = "5 mA"; };
            V_4_MA = 5 { name = "V 4 Ma"; desc = "4 mA"; };
            V_2_MA = 6 { name = "V 2 Ma"; desc = "2 mA"; };
            V_1_MA = 7 { name = "V 1 Ma"; desc = "1 mA"; };
        };

        field {
            name = "spi0_sclk_ds";
            desc = "Drive current of the SPI0_SCLK pin";
            sw = rw;
            hw = r;
            encode = PADCTRL_REG20_spi0_sclk_ds_enum;
            reset = 0x4;
        } spi0_sclk_ds[6:4];
    } PADCTRL_REG20 @ 0x850;

    reg {
        name = "Drive capability register for the SPI0_SDO pin";
        desc = "PADCTRL_REG21 is a drive capability register for the SPI0_SDO pin.

Data sheet 2.6.2 PADCTRL_REG21 (offset 0x54, printed page 2-180, `hi3516av100--Hi3516A-Hi3516D-Datasheet.txt` line 11375).";

        enum PADCTRL_REG21_spi0_sdo_sr_enum {
            FAST_EDGE = 0 { name = "Fast Edge"; desc = "fast edge"; };
            SLOW_EDGE = 1 { name = "Slow Edge"; desc = "slow edge"; };
        };

        field {
            name = "spi0_sdo_sr";
            desc = "Level conversion rate of the SPI0_SDO pin";
            sw = rw;
            hw = r;
            encode = PADCTRL_REG21_spi0_sdo_sr_enum;
            reset = 0x1;
        } spi0_sdo_sr[7:7];

        enum PADCTRL_REG21_spi0_sdo_ds_enum {
            V_4_MA = 0 { name = "V 4 Ma"; desc = "4 mA"; };
            V_3_MA = 1 { name = "V 3 Ma"; desc = "3 mA"; };
            V_2_MA = 2 { name = "V 2 Ma"; desc = "2 mA"; };
            V_1_MA = 3 { name = "V 1 Ma"; desc = "1 mA"; };
        };

        field {
            name = "spi0_sdo_ds";
            desc = "Drive current of the SPI0_SDO pin (the data sheet names this field `sip0_sdo_ds`, which does not match the pin of this register: corrected here, low confidence that the typo is only in the name).";
            sw = rw;
            hw = r;
            encode = PADCTRL_REG21_spi0_sdo_ds_enum;
            reset = 0x1;
        } spi0_sdo_ds[5:4];
    } PADCTRL_REG21 @ 0x854;

    reg {
        name = "Drive capability register for the SPI0_SDI pin";
        desc = "PADCTRL_REG22 is a drive capability register for the SPI0_SDI pin.

Data sheet 2.6.2 PADCTRL_REG22 (offset 0x58, printed page 2-180, `hi3516av100--Hi3516A-Hi3516D-Datasheet.txt` line 11410).";

        enum PADCTRL_REG22_spi0_sdi_sr_enum {
            FAST_EDGE = 0 { name = "Fast Edge"; desc = "fast edge"; };
            SLOW_EDGE = 1 { name = "Slow Edge"; desc = "slow edge"; };
        };

        field {
            name = "spi0_sdi_sr";
            desc = "Level conversion rate of the SPI0_SDI pin";
            sw = rw;
            hw = r;
            encode = PADCTRL_REG22_spi0_sdi_sr_enum;
            reset = 0x1;
        } spi0_sdi_sr[7:7];

        enum PADCTRL_REG22_spi0_sdi_ds_enum {
            V_4_MA = 0 { name = "V 4 Ma"; desc = "4 mA"; };
            V_3_MA = 1 { name = "V 3 Ma"; desc = "3 mA"; };
            V_2_MA = 2 { name = "V 2 Ma"; desc = "2 mA"; };
            V_1_MA = 3 { name = "V 1 Ma"; desc = "1 mA"; };
        };

        field {
            name = "spi0_sdi_ds";
            desc = "Drive current of the SPI0_SDI pin";
            sw = rw;
            hw = r;
            encode = PADCTRL_REG22_spi0_sdi_ds_enum;
            reset = 0x1;
        } spi0_sdi_ds[5:4];
    } PADCTRL_REG22 @ 0x858;

    reg {
        name = "Drive capability register for the SPI0_CSN pin";
        desc = "PADCTRL_REG23 is a drive capability register for the SPI0_CSN pin.

Data sheet 2.6.2 PADCTRL_REG23 (offset 0x5C, printed page 2-181, `hi3516av100--Hi3516A-Hi3516D-Datasheet.txt` line 11452).";

        enum PADCTRL_REG23_spi0_csn_sr_enum {
            FAST_EDGE = 0 { name = "Fast Edge"; desc = "fast edge"; };
            SLOW_EDGE = 1 { name = "Slow Edge"; desc = "slow edge"; };
        };

        field {
            name = "spi0_csn_sr";
            desc = "Level conversion rate of the SPI0_CSN pin";
            sw = rw;
            hw = r;
            encode = PADCTRL_REG23_spi0_csn_sr_enum;
            reset = 0x1;
        } spi0_csn_sr[7:7];

        enum PADCTRL_REG23_spi0_csn_ds_enum {
            V_4_MA = 0 { name = "V 4 Ma"; desc = "4 mA"; };
            V_3_MA = 1 { name = "V 3 Ma"; desc = "3 mA"; };
            V_2_MA = 2 { name = "V 2 Ma"; desc = "2 mA"; };
            V_1_MA = 3 { name = "V 1 Ma"; desc = "1 mA"; };
        };

        field {
            name = "spi0_csn_ds";
            desc = "Drive current of the SPI0_CSN pin (the data sheet names this field `sip0_csn_ds`, which does not match the pin of this register: corrected here, low confidence that the typo is only in the name).";
            sw = rw;
            hw = r;
            encode = PADCTRL_REG23_spi0_csn_ds_enum;
            reset = 0x1;
        } spi0_csn_ds[5:4];
    } PADCTRL_REG23 @ 0x85C;

    reg {
        name = "Drive capability register for the SPI1_SCLK pin";
        desc = "PADCTRL_REG24 is a drive capability register for the SPI1_SCLK pin.

Data sheet 2.6.2 PADCTRL_REG24 (offset 0x60, printed page 2-182, `hi3516av100--Hi3516A-Hi3516D-Datasheet.txt` line 11498).";

        enum PADCTRL_REG24_spi1_sclk_sr_enum {
            FAST_EDGE = 0 { name = "Fast Edge"; desc = "fast edge"; };
            SLOW_EDGE = 1 { name = "Slow Edge"; desc = "slow edge"; };
        };

        field {
            name = "spi1_sclk_sr";
            desc = "Level conversion rate of the SPI1_SCLK pin";
            sw = rw;
            hw = r;
            encode = PADCTRL_REG24_spi1_sclk_sr_enum;
            reset = 0x1;
        } spi1_sclk_sr[7:7];

        field {
            name = "reserved_nz_6";
            desc = "Reserved in the bit table, but the data sheet Reset row and total reset value (0x0000_00D0) have this bit set (reads 1).";
            sw = r;
            hw = w;
            reset = 0x1;
        } reserved_nz_6[6:6];

        enum PADCTRL_REG24_spi1_sclk_ds_enum {
            V_4_MA = 0 { name = "V 4 Ma"; desc = "4 mA"; };
            V_3_MA = 1 { name = "V 3 Ma"; desc = "3 mA"; };
            V_2_MA = 2 { name = "V 2 Ma"; desc = "2 mA"; };
            V_1_MA = 3 { name = "V 1 Ma"; desc = "1 mA"; };
        };

        field {
            name = "spi1_sclk_ds";
            desc = "Drive current of the SPI1_SCLK pin";
            sw = rw;
            hw = r;
            encode = PADCTRL_REG24_spi1_sclk_ds_enum;
            reset = 0x1;
        } spi1_sclk_ds[5:4];
    } PADCTRL_REG24 @ 0x860;

    reg {
        name = "Drive capability register for the SPI1_SDO pin";
        desc = "PADCTRL_REG25 is a drive capability register for the SPI1_SDO pin.

Data sheet 2.6.2 PADCTRL_REG25 (offset 0x64, printed page 2-183, `hi3516av100--Hi3516A-Hi3516D-Datasheet.txt` line 11539).";

        enum PADCTRL_REG25_spi1_sdo_sr_enum {
            FAST_EDGE = 0 { name = "Fast Edge"; desc = "fast edge"; };
            SLOW_EDGE = 1 { name = "Slow Edge"; desc = "slow edge"; };
        };

        field {
            name = "spi1_sdo_sr";
            desc = "Level conversion rate of the SPI1_SDO pin";
            sw = rw;
            hw = r;
            encode = PADCTRL_REG25_spi1_sdo_sr_enum;
            reset = 0x1;
        } spi1_sdo_sr[7:7];

        enum PADCTRL_REG25_spi1_sdo_ds_enum {
            V_4_MA = 0 { name = "V 4 Ma"; desc = "4 mA"; };
            V_3_MA = 1 { name = "V 3 Ma"; desc = "3 mA"; };
            V_2_MA = 2 { name = "V 2 Ma"; desc = "2 mA"; };
            V_1_MA = 3 { name = "V 1 Ma"; desc = "1 mA"; };
        };

        field {
            name = "spi1_sdo_ds";
            desc = "Drive current of the SPI1_SDO pin";
            sw = rw;
            hw = r;
            encode = PADCTRL_REG25_spi1_sdo_ds_enum;
            reset = 0x2;
        } spi1_sdo_ds[5:4];
    } PADCTRL_REG25 @ 0x864;

    reg {
        name = "Drive capability register for the SPI1_SDI pin";
        desc = "PADCTRL_REG26 is a drive capability register for the SPI1_SDI pin.

Data sheet 2.6.2 PADCTRL_REG26 (offset 0x68, printed page 2-183, `hi3516av100--Hi3516A-Hi3516D-Datasheet.txt` line 11574).";

        enum PADCTRL_REG26_spi1_sdi_sr_enum {
            FAST_EDGE = 0 { name = "Fast Edge"; desc = "fast edge"; };
            SLOW_EDGE = 1 { name = "Slow Edge"; desc = "slow edge"; };
        };

        field {
            name = "spi1_sdi_sr";
            desc = "Level conversion rate of the SPI1_SDI pin";
            sw = rw;
            hw = r;
            encode = PADCTRL_REG26_spi1_sdi_sr_enum;
            reset = 0x1;
        } spi1_sdi_sr[7:7];

        enum PADCTRL_REG26_spi1_sdi_ds_enum {
            V_4_MA = 0 { name = "V 4 Ma"; desc = "4 mA"; };
            V_3_MA = 1 { name = "V 3 Ma"; desc = "3 mA"; };
            V_2_MA = 2 { name = "V 2 Ma"; desc = "2 mA"; };
            V_1_MA = 3 { name = "V 1 Ma"; desc = "1 mA"; };
        };

        field {
            name = "spi1_sdi_ds";
            desc = "Drive current of the SPI1_SDI pin";
            sw = rw;
            hw = r;
            encode = PADCTRL_REG26_spi1_sdi_ds_enum;
            reset = 0x2;
        } spi1_sdi_ds[5:4];
    } PADCTRL_REG26 @ 0x868;

    reg {
        name = "Drive capability register for the SPI1_CSN0 pin";
        desc = "PADCTRL_REG27 is a drive capability register for the SPI1_CSN0 pin.

Data sheet 2.6.2 PADCTRL_REG27 (offset 0x6C, printed page 2-184, `hi3516av100--Hi3516A-Hi3516D-Datasheet.txt` line 11616).";

        enum PADCTRL_REG27_spi1_csn0_sr_enum {
            FAST_EDGE = 0 { name = "Fast Edge"; desc = "fast edge"; };
            SLOW_EDGE = 1 { name = "Slow Edge"; desc = "slow edge"; };
        };

        field {
            name = "spi1_csn0_sr";
            desc = "Level conversion rate of the SPI1_CSN0 pin (the data sheet names this field `spi1_csn_sr`, which does not match the pin of this register: corrected here, low confidence that the typo is only in the name).";
            sw = rw;
            hw = r;
            encode = PADCTRL_REG27_spi1_csn0_sr_enum;
            reset = 0x1;
        } spi1_csn0_sr[7:7];

        enum PADCTRL_REG27_spi1_csn0_ds_enum {
            V_4_MA = 0 { name = "V 4 Ma"; desc = "4 mA"; };
            V_3_MA = 1 { name = "V 3 Ma"; desc = "3 mA"; };
            V_2_MA = 2 { name = "V 2 Ma"; desc = "2 mA"; };
            V_1_MA = 3 { name = "V 1 Ma"; desc = "1 mA"; };
        };

        field {
            name = "spi1_csn0_ds";
            desc = "Drive current of the SPI1_CSN0 pin (the data sheet names this field `spi1_csn_ds`, which does not match the pin of this register: corrected here, low confidence that the typo is only in the name).";
            sw = rw;
            hw = r;
            encode = PADCTRL_REG27_spi1_csn0_ds_enum;
            reset = 0x2;
        } spi1_csn0_ds[5:4];
    } PADCTRL_REG27 @ 0x86C;

    reg {
        name = "Drive capability register for the I2C2_SDA pin";
        desc = "PADCTRL_REG28 is a drive capability register for the I2C2_SDA pin.

Data sheet 2.6.2 PADCTRL_REG28 (offset 0x70, printed page 2-185, `hi3516av100--Hi3516A-Hi3516D-Datasheet.txt` line 11662).";

        enum PADCTRL_REG28_i2c2_sda_sr_enum {
            FAST_EDGE = 0 { name = "Fast Edge"; desc = "fast edge"; };
            SLOW_EDGE = 1 { name = "Slow Edge"; desc = "slow edge"; };
        };

        field {
            name = "i2c2_sda_sr";
            desc = "Level conversion rate of the I2C2_SDA pin";
            sw = rw;
            hw = r;
            encode = PADCTRL_REG28_i2c2_sda_sr_enum;
            reset = 0x1;
        } i2c2_sda_sr[7:7];

        enum PADCTRL_REG28_i2c2_sda_ds_enum {
            V_4_MA = 0 { name = "V 4 Ma"; desc = "4 mA"; };
            V_3_MA = 1 { name = "V 3 Ma"; desc = "3 mA"; };
            V_2_MA = 2 { name = "V 2 Ma"; desc = "2 mA"; };
            V_1_MA = 3 { name = "V 1 Ma"; desc = "1 mA"; };
        };

        field {
            name = "i2c2_sda_ds";
            desc = "Drive current of the I2C2_SDA pin";
            sw = rw;
            hw = r;
            encode = PADCTRL_REG28_i2c2_sda_ds_enum;
            reset = 0x2;
        } i2c2_sda_ds[5:4];
    } PADCTRL_REG28 @ 0x870;

    reg {
        name = "Drive capability register for the I2C2_SCL pin";
        desc = "PADCTRL_REG29 is a drive capability register for the I2C2_SCL pin.

Data sheet 2.6.2 PADCTRL_REG29 (offset 0x74, printed page 2-186, `hi3516av100--Hi3516A-Hi3516D-Datasheet.txt` line 11703).";

        enum PADCTRL_REG29_i2c2_scl_sr_enum {
            FAST_EDGE = 0 { name = "Fast Edge"; desc = "fast edge"; };
            SLOW_EDGE = 1 { name = "Slow Edge"; desc = "slow edge"; };
        };

        field {
            name = "i2c2_scl_sr";
            desc = "Level conversion rate of the I2C2_SCL pin";
            sw = rw;
            hw = r;
            encode = PADCTRL_REG29_i2c2_scl_sr_enum;
            reset = 0x1;
        } i2c2_scl_sr[7:7];

        enum PADCTRL_REG29_i2c2_scl_ds_enum {
            V_4_MA = 0 { name = "V 4 Ma"; desc = "4 mA"; };
            V_3_MA = 1 { name = "V 3 Ma"; desc = "3 mA"; };
            V_2_MA = 2 { name = "V 2 Ma"; desc = "2 mA"; };
            V_1_MA = 3 { name = "V 1 Ma"; desc = "1 mA"; };
        };

        field {
            name = "i2c2_scl_ds";
            desc = "Drive current of the I2C2_SCL pin";
            sw = rw;
            hw = r;
            encode = PADCTRL_REG29_i2c2_scl_ds_enum;
            reset = 0x2;
        } i2c2_scl_ds[5:4];
    } PADCTRL_REG29 @ 0x874;

    reg {
        name = "Drive capability register for the UART0_RXD pin";
        desc = "PADCTRL_REG30 is a drive capability register for the UART0_RXD pin.

Data sheet 2.6.2 PADCTRL_REG30 (offset 0x78, printed page 2-186, `hi3516av100--Hi3516A-Hi3516D-Datasheet.txt` line 11738).";

        enum PADCTRL_REG30_uart0_rxd_sr_enum {
            FAST_EDGE = 0 { name = "Fast Edge"; desc = "fast edge"; };
            SLOW_EDGE = 1 { name = "Slow Edge"; desc = "slow edge"; };
        };

        field {
            name = "uart0_rxd_sr";
            desc = "Level conversion rate of the UART0_RXD pin";
            sw = rw;
            hw = r;
            encode = PADCTRL_REG30_uart0_rxd_sr_enum;
            reset = 0x1;
        } uart0_rxd_sr[7:7];

        enum PADCTRL_REG30_uart0_rxd_ds_enum {
            V_4_MA = 0 { name = "V 4 Ma"; desc = "4 mA"; };
            V_3_MA = 1 { name = "V 3 Ma"; desc = "3 mA"; };
            V_2_MA = 2 { name = "V 2 Ma"; desc = "2 mA"; };
            V_1_MA = 3 { name = "V 1 Ma"; desc = "1 mA"; };
        };

        field {
            name = "uart0_rxd_ds";
            desc = "Drive current of the UART0_RXD pin";
            sw = rw;
            hw = r;
            encode = PADCTRL_REG30_uart0_rxd_ds_enum;
            reset = 0x2;
        } uart0_rxd_ds[5:4];
    } PADCTRL_REG30 @ 0x878;

    reg {
        name = "Drive capability register for the UART0_TXD pin";
        desc = "PADCTRL_REG31 is a drive capability register for the UART0_TXD pin.

Data sheet 2.6.2 PADCTRL_REG31 (offset 0x7C, printed page 2-187, `hi3516av100--Hi3516A-Hi3516D-Datasheet.txt` line 11780).";

        enum PADCTRL_REG31_uart0_txd_sr_enum {
            FAST_EDGE = 0 { name = "Fast Edge"; desc = "fast edge"; };
            SLOW_EDGE = 1 { name = "Slow Edge"; desc = "slow edge"; };
        };

        field {
            name = "uart0_txd_sr";
            desc = "Level conversion rate of the UART0_TXD pin";
            sw = rw;
            hw = r;
            encode = PADCTRL_REG31_uart0_txd_sr_enum;
            reset = 0x1;
        } uart0_txd_sr[7:7];

        enum PADCTRL_REG31_uart0_txd_ds_enum {
            V_4_MA = 0 { name = "V 4 Ma"; desc = "4 mA"; };
            V_3_MA = 1 { name = "V 3 Ma"; desc = "3 mA"; };
            V_2_MA = 2 { name = "V 2 Ma"; desc = "2 mA"; };
            V_1_MA = 3 { name = "V 1 Ma"; desc = "1 mA"; };
        };

        field {
            name = "uart0_txd_ds";
            desc = "Drive current of the UART0_TXD pin";
            sw = rw;
            hw = r;
            encode = PADCTRL_REG31_uart0_txd_ds_enum;
            reset = 0x2;
        } uart0_txd_ds[5:4];
    } PADCTRL_REG31 @ 0x87C;

    reg {
        name = "Drive capability register for the UART1_RTSN pin";
        desc = "PADCTRL_REG32 is a drive capability register for the UART1_RTSN pin.

Data sheet 2.6.2 PADCTRL_REG32 (offset 0x80, printed page 2-188, `hi3516av100--Hi3516A-Hi3516D-Datasheet.txt` line 11826).";

        enum PADCTRL_REG32_uart1_rtsn_sr_enum {
            FAST_EDGE = 0 { name = "Fast Edge"; desc = "fast edge"; };
            SLOW_EDGE = 1 { name = "Slow Edge"; desc = "slow edge"; };
        };

        field {
            name = "uart1_rtsn_sr";
            desc = "Level conversion rate of the UART1_RTSN pin";
            sw = rw;
            hw = r;
            encode = PADCTRL_REG32_uart1_rtsn_sr_enum;
            reset = 0x1;
        } uart1_rtsn_sr[7:7];

        enum PADCTRL_REG32_uart1_rtsn_ds_enum {
            V_4_MA = 0 { name = "V 4 Ma"; desc = "4 mA"; };
            V_3_MA = 1 { name = "V 3 Ma"; desc = "3 mA"; };
            V_2_MA = 2 { name = "V 2 Ma"; desc = "2 mA"; };
            V_1_MA = 3 { name = "V 1 Ma"; desc = "1 mA"; };
        };

        field {
            name = "uart1_rtsn_ds";
            desc = "Drive current of the UART1_RTSN pin";
            sw = rw;
            hw = r;
            encode = PADCTRL_REG32_uart1_rtsn_ds_enum;
            reset = 0x2;
        } uart1_rtsn_ds[5:4];
    } PADCTRL_REG32 @ 0x880;

    reg {
        name = "Drive capability register for the UART1_RXD pin";
        desc = "PADCTRL_REG33 is a drive capability register for the UART1_RXD pin.

Data sheet 2.6.2 PADCTRL_REG33 (offset 0x84, printed page 2-189, `hi3516av100--Hi3516A-Hi3516D-Datasheet.txt` line 11867).";

        enum PADCTRL_REG33_uart1_rxd_sr_enum {
            FAST_EDGE = 0 { name = "Fast Edge"; desc = "fast edge"; };
            SLOW_EDGE = 1 { name = "Slow Edge"; desc = "slow edge"; };
        };

        field {
            name = "uart1_rxd_sr";
            desc = "Level conversion rate of the UART1_RXD pin";
            sw = rw;
            hw = r;
            encode = PADCTRL_REG33_uart1_rxd_sr_enum;
            reset = 0x1;
        } uart1_rxd_sr[7:7];

        enum PADCTRL_REG33_uart1_rxd_ds_enum {
            V_4_MA = 0 { name = "V 4 Ma"; desc = "4 mA"; };
            V_3_MA = 1 { name = "V 3 Ma"; desc = "3 mA"; };
            V_2_MA = 2 { name = "V 2 Ma"; desc = "2 mA"; };
            V_1_MA = 3 { name = "V 1 Ma"; desc = "1 mA"; };
        };

        field {
            name = "uart1_rxd_ds";
            desc = "Drive current of the UART1_RXD pin";
            sw = rw;
            hw = r;
            encode = PADCTRL_REG33_uart1_rxd_ds_enum;
            reset = 0x2;
        } uart1_rxd_ds[5:4];
    } PADCTRL_REG33 @ 0x884;

    reg {
        name = "Drive capability register for the UART1_CTSN pin";
        desc = "PADCTRL_REG34 is a drive capability register for the UART1_CTSN pin.

Data sheet 2.6.2 PADCTRL_REG34 (offset 0x88, printed page 2-189, `hi3516av100--Hi3516A-Hi3516D-Datasheet.txt` line 11902).";

        enum PADCTRL_REG34_uart1_ctsn_sr_enum {
            FAST_EDGE = 0 { name = "Fast Edge"; desc = "fast edge"; };
            SLOW_EDGE = 1 { name = "Slow Edge"; desc = "slow edge"; };
        };

        field {
            name = "uart1_ctsn_sr";
            desc = "Level conversion rate of the UART1_CTSN pin";
            sw = rw;
            hw = r;
            encode = PADCTRL_REG34_uart1_ctsn_sr_enum;
            reset = 0x1;
        } uart1_ctsn_sr[7:7];

        enum PADCTRL_REG34_uart1_ctsn_ds_enum {
            V_4_MA = 0 { name = "V 4 Ma"; desc = "4 mA"; };
            V_3_MA = 1 { name = "V 3 Ma"; desc = "3 mA"; };
            V_2_MA = 2 { name = "V 2 Ma"; desc = "2 mA"; };
            V_1_MA = 3 { name = "V 1 Ma"; desc = "1 mA"; };
        };

        field {
            name = "uart1_ctsn_ds";
            desc = "Drive current of the UART1_CTSN pin";
            sw = rw;
            hw = r;
            encode = PADCTRL_REG34_uart1_ctsn_ds_enum;
            reset = 0x2;
        } uart1_ctsn_ds[5:4];
    } PADCTRL_REG34 @ 0x888;

    reg {
        name = "Drive capability register for the UART1_TXD pin";
        desc = "PADCTRL_REG35 is a drive capability register for the UART1_TXD pin.

Data sheet 2.6.2 PADCTRL_REG35 (offset 0x8C, printed page 2-190, `hi3516av100--Hi3516A-Hi3516D-Datasheet.txt` line 11944).";

        enum PADCTRL_REG35_uart1_txd_sr_enum {
            FAST_EDGE = 0 { name = "Fast Edge"; desc = "fast edge"; };
            SLOW_EDGE = 1 { name = "Slow Edge"; desc = "slow edge"; };
        };

        field {
            name = "uart1_txd_sr";
            desc = "Level conversion rate of the UART1_TXD pin";
            sw = rw;
            hw = r;
            encode = PADCTRL_REG35_uart1_txd_sr_enum;
            reset = 0x1;
        } uart1_txd_sr[7:7];

        enum PADCTRL_REG35_uart1_txd_ds_enum {
            V_4_MA = 0 { name = "V 4 Ma"; desc = "4 mA"; };
            V_3_MA = 1 { name = "V 3 Ma"; desc = "3 mA"; };
            V_2_MA = 2 { name = "V 2 Ma"; desc = "2 mA"; };
            V_1_MA = 3 { name = "V 1 Ma"; desc = "1 mA"; };
        };

        field {
            name = "uart1_txd_ds";
            desc = "Drive current of the UART1_TXD pin";
            sw = rw;
            hw = r;
            encode = PADCTRL_REG35_uart1_txd_ds_enum;
            reset = 0x2;
        } uart1_txd_ds[5:4];
    } PADCTRL_REG35 @ 0x88C;

    reg {
        name = "Drive capability register for the UART2_RXD pin";
        desc = "PADCTRL_REG36 is a drive capability register for the UART2_RXD pin.

Data sheet 2.6.2 PADCTRL_REG36 (offset 0x90, printed page 2-191, `hi3516av100--Hi3516A-Hi3516D-Datasheet.txt` line 11990).";

        enum PADCTRL_REG36_uart2_rxd_sr_enum {
            FAST_EDGE = 0 { name = "Fast Edge"; desc = "fast edge"; };
            SLOW_EDGE = 1 { name = "Slow Edge"; desc = "slow edge"; };
        };

        field {
            name = "uart2_rxd_sr";
            desc = "Level conversion rate of the UART2_RXD pin";
            sw = rw;
            hw = r;
            encode = PADCTRL_REG36_uart2_rxd_sr_enum;
            reset = 0x1;
        } uart2_rxd_sr[7:7];

        enum PADCTRL_REG36_uart2_rxd_ds_enum {
            V_4_MA = 0 { name = "V 4 Ma"; desc = "4 mA"; };
            V_3_MA = 1 { name = "V 3 Ma"; desc = "3 mA"; };
            V_2_MA = 2 { name = "V 2 Ma"; desc = "2 mA"; };
            V_1_MA = 3 { name = "V 1 Ma"; desc = "1 mA"; };
        };

        field {
            name = "uart2_rxd_ds";
            desc = "Drive current of the UART2_RXD pin";
            sw = rw;
            hw = r;
            encode = PADCTRL_REG36_uart2_rxd_ds_enum;
            reset = 0x2;
        } uart2_rxd_ds[5:4];
    } PADCTRL_REG36 @ 0x890;

    reg {
        name = "Drive capability register for the UART2_TXD pin";
        desc = "PADCTRL_REG37 is a drive capability register for the UART2_TXD pin.

Data sheet 2.6.2 PADCTRL_REG37 (offset 0x94, printed page 2-192, `hi3516av100--Hi3516A-Hi3516D-Datasheet.txt` line 12031).";

        enum PADCTRL_REG37_uart2_txd_sr_enum {
            FAST_EDGE = 0 { name = "Fast Edge"; desc = "fast edge"; };
            SLOW_EDGE = 1 { name = "Slow Edge"; desc = "slow edge"; };
        };

        field {
            name = "uart2_txd_sr";
            desc = "Level conversion rate of the UART2_TXD pin";
            sw = rw;
            hw = r;
            encode = PADCTRL_REG37_uart2_txd_sr_enum;
            reset = 0x1;
        } uart2_txd_sr[7:7];

        enum PADCTRL_REG37_uart2_txd_ds_enum {
            V_4_MA = 0 { name = "V 4 Ma"; desc = "4 mA"; };
            V_3_MA = 1 { name = "V 3 Ma"; desc = "3 mA"; };
            V_2_MA = 2 { name = "V 2 Ma"; desc = "2 mA"; };
            V_1_MA = 3 { name = "V 1 Ma"; desc = "1 mA"; };
        };

        field {
            name = "uart2_txd_ds";
            desc = "Drive current of the UART2_TXD pin";
            sw = rw;
            hw = r;
            encode = PADCTRL_REG37_uart2_txd_ds_enum;
            reset = 0x2;
        } uart2_txd_ds[5:4];
    } PADCTRL_REG37 @ 0x894;

    reg {
        name = "Drive capability register for the JTAG_EN pin";
        desc = "PADCTRL_REG38 is a drive capability register for the JTAG_EN pin.

Data sheet 2.6.2 PADCTRL_REG38 (offset 0x98, printed page 2-192, `hi3516av100--Hi3516A-Hi3516D-Datasheet.txt` line 12066).";

        enum PADCTRL_REG38_jtag_en_sr_enum {
            FAST_EDGE = 0 { name = "Fast Edge"; desc = "fast edge"; };
            SLOW_EDGE = 1 { name = "Slow Edge"; desc = "slow edge"; };
        };

        field {
            name = "jtag_en_sr";
            desc = "Level conversion rate of the JTAG_EN pin";
            sw = rw;
            hw = r;
            encode = PADCTRL_REG38_jtag_en_sr_enum;
            reset = 0x1;
        } jtag_en_sr[7:7];

        enum PADCTRL_REG38_jtag_en_ds_enum {
            V_4_MA = 0 { name = "V 4 Ma"; desc = "4 mA"; };
            V_3_MA = 1 { name = "V 3 Ma"; desc = "3 mA"; };
            V_2_MA = 2 { name = "V 2 Ma"; desc = "2 mA"; };
            V_1_MA = 3 { name = "V 1 Ma"; desc = "1 mA"; };
        };

        field {
            name = "jtag_en_ds";
            desc = "Drive current of the JTAG_EN pin";
            sw = rw;
            hw = r;
            encode = PADCTRL_REG38_jtag_en_ds_enum;
            reset = 0x2;
        } jtag_en_ds[5:4];
    } PADCTRL_REG38 @ 0x898;

    reg {
        name = "Drive capability register for the JTAG_TRSTN pin";
        desc = "PADCTRL_REG39 is a drive capability register for the JTAG_TRSTN pin.

Data sheet 2.6.2 PADCTRL_REG39 (offset 0x9C, printed page 2-193, `hi3516av100--Hi3516A-Hi3516D-Datasheet.txt` line 12108).";

        enum PADCTRL_REG39_jtag_trstn_sr_enum {
            FAST_EDGE = 0 { name = "Fast Edge"; desc = "fast edge"; };
            SLOW_EDGE = 1 { name = "Slow Edge"; desc = "slow edge"; };
        };

        field {
            name = "jtag_trstn_sr";
            desc = "Level conversion rate of the JTAG_TRSTN pin";
            sw = rw;
            hw = r;
            encode = PADCTRL_REG39_jtag_trstn_sr_enum;
            reset = 0x1;
        } jtag_trstn_sr[7:7];

        enum PADCTRL_REG39_jtag_trstn_ds_enum {
            V_4_MA = 0 { name = "V 4 Ma"; desc = "4 mA"; };
            V_3_MA = 1 { name = "V 3 Ma"; desc = "3 mA"; };
            V_2_MA = 2 { name = "V 2 Ma"; desc = "2 mA"; };
            V_1_MA = 3 { name = "V 1 Ma"; desc = "1 mA"; };
        };

        field {
            name = "jtag_trstn_ds";
            desc = "Drive current of the JTAG_TRSTN pin";
            sw = rw;
            hw = r;
            encode = PADCTRL_REG39_jtag_trstn_ds_enum;
            reset = 0x2;
        } jtag_trstn_ds[5:4];
    } PADCTRL_REG39 @ 0x89C;

    reg {
        name = "Drive capability register for the JTAG_TCK pin";
        desc = "PADCTRL_REG40 is a drive capability register for the JTAG_TCK pin.

Data sheet 2.6.2 PADCTRL_REG40 (offset 0xA0, printed page 2-194, `hi3516av100--Hi3516A-Hi3516D-Datasheet.txt` line 12154).";

        enum PADCTRL_REG40_jtag_tck_sr_enum {
            FAST_EDGE = 0 { name = "Fast Edge"; desc = "fast edge"; };
            SLOW_EDGE = 1 { name = "Slow Edge"; desc = "slow edge"; };
        };

        field {
            name = "jtag_tck_sr";
            desc = "Level conversion rate of the JTAG_TCK pin";
            sw = rw;
            hw = r;
            encode = PADCTRL_REG40_jtag_tck_sr_enum;
            reset = 0x1;
        } jtag_tck_sr[7:7];

        enum PADCTRL_REG40_jtag_tck_ds_enum {
            V_4_MA = 0 { name = "V 4 Ma"; desc = "4 mA"; };
            V_3_MA = 1 { name = "V 3 Ma"; desc = "3 mA"; };
            V_2_MA = 2 { name = "V 2 Ma"; desc = "2 mA"; };
            V_1_MA = 3 { name = "V 1 Ma"; desc = "1 mA"; };
        };

        field {
            name = "jtag_tck_ds";
            desc = "Drive current of the JTAG_TCK pin";
            sw = rw;
            hw = r;
            encode = PADCTRL_REG40_jtag_tck_ds_enum;
            reset = 0x2;
        } jtag_tck_ds[5:4];
    } PADCTRL_REG40 @ 0x8A0;

    reg {
        name = "Drive capability register for the JTAG_TMS pin";
        desc = "PADCTRL_REG41 is a drive capability register for the JTAG_TMS pin.

Data sheet 2.6.2 PADCTRL_REG41 (offset 0xA4, printed page 2-195, `hi3516av100--Hi3516A-Hi3516D-Datasheet.txt` line 12195).";

        enum PADCTRL_REG41_jtag_tms_sr_enum {
            FAST_EDGE = 0 { name = "Fast Edge"; desc = "fast edge"; };
            SLOW_EDGE = 1 { name = "Slow Edge"; desc = "slow edge"; };
        };

        field {
            name = "jtag_tms_sr";
            desc = "Level conversion rate of the JTAG_TMS pin";
            sw = rw;
            hw = r;
            encode = PADCTRL_REG41_jtag_tms_sr_enum;
            reset = 0x1;
        } jtag_tms_sr[7:7];

        enum PADCTRL_REG41_jtag_tms_ds_enum {
            V_4_MA = 0 { name = "V 4 Ma"; desc = "4 mA"; };
            V_3_MA = 1 { name = "V 3 Ma"; desc = "3 mA"; };
            V_2_MA = 2 { name = "V 2 Ma"; desc = "2 mA"; };
            V_1_MA = 3 { name = "V 1 Ma"; desc = "1 mA"; };
        };

        field {
            name = "jtag_tms_ds";
            desc = "Drive current of the JTAG_TMS pin";
            sw = rw;
            hw = r;
            encode = PADCTRL_REG41_jtag_tms_ds_enum;
            reset = 0x2;
        } jtag_tms_ds[5:4];
    } PADCTRL_REG41 @ 0x8A4;

    reg {
        name = "Drive capability register for the JTAG_TDO pin";
        desc = "PADCTRL_REG42 is a drive capability register for the JTAG_TDO pin.

Data sheet 2.6.2 PADCTRL_REG42 (offset 0xA8, printed page 2-195, `hi3516av100--Hi3516A-Hi3516D-Datasheet.txt` line 12230).";

        enum PADCTRL_REG42_jtag_tdo_sr_enum {
            FAST_EDGE = 0 { name = "Fast Edge"; desc = "fast edge"; };
            SLOW_EDGE = 1 { name = "Slow Edge"; desc = "slow edge"; };
        };

        field {
            name = "jtag_tdo_sr";
            desc = "Level conversion rate of the JTAG_TDO pin";
            sw = rw;
            hw = r;
            encode = PADCTRL_REG42_jtag_tdo_sr_enum;
            reset = 0x1;
        } jtag_tdo_sr[7:7];

        enum PADCTRL_REG42_jtag_tdo_ds_enum {
            V_4_MA = 0 { name = "V 4 Ma"; desc = "4 mA"; };
            V_3_MA = 1 { name = "V 3 Ma"; desc = "3 mA"; };
            V_2_MA = 2 { name = "V 2 Ma"; desc = "2 mA"; };
            V_1_MA = 3 { name = "V 1 Ma"; desc = "1 mA"; };
        };

        field {
            name = "jtag_tdo_ds";
            desc = "Drive current of the JTAG_TDO pin";
            sw = rw;
            hw = r;
            encode = PADCTRL_REG42_jtag_tdo_ds_enum;
            reset = 0x2;
        } jtag_tdo_ds[5:4];
    } PADCTRL_REG42 @ 0x8A8;

    reg {
        name = "Drive capability register for the JTAG_TDI pin";
        desc = "PADCTRL_REG43 is a drive capability register for the JTAG_TDI pin.

Data sheet 2.6.2 PADCTRL_REG43 (offset 0xAC, printed page 2-196, `hi3516av100--Hi3516A-Hi3516D-Datasheet.txt` line 12272).";

        enum PADCTRL_REG43_jtag_tdi_sr_enum {
            FAST_EDGE = 0 { name = "Fast Edge"; desc = "fast edge"; };
            SLOW_EDGE = 1 { name = "Slow Edge"; desc = "slow edge"; };
        };

        field {
            name = "jtag_tdi_sr";
            desc = "Level conversion rate of the JTAG_TDI pin";
            sw = rw;
            hw = r;
            encode = PADCTRL_REG43_jtag_tdi_sr_enum;
            reset = 0x1;
        } jtag_tdi_sr[7:7];

        enum PADCTRL_REG43_jtag_tdi_ds_enum {
            V_4_MA = 0 { name = "V 4 Ma"; desc = "4 mA"; };
            V_3_MA = 1 { name = "V 3 Ma"; desc = "3 mA"; };
            V_2_MA = 2 { name = "V 2 Ma"; desc = "2 mA"; };
            V_1_MA = 3 { name = "V 1 Ma"; desc = "1 mA"; };
        };

        field {
            name = "jtag_tdi_ds";
            desc = "Drive current of the JTAG_TDI pin";
            sw = rw;
            hw = r;
            encode = PADCTRL_REG43_jtag_tdi_ds_enum;
            reset = 0x2;
        } jtag_tdi_ds[5:4];
    } PADCTRL_REG43 @ 0x8AC;

    reg {
        name = "Drive capability register for the IR_IN pin";
        desc = "PADCTRL_REG44 is a drive capability register for the IR_IN pin.

Data sheet 2.6.2 PADCTRL_REG44 (offset 0xB0, printed page 2-197, `hi3516av100--Hi3516A-Hi3516D-Datasheet.txt` line 12318).";

        enum PADCTRL_REG44_ir_in_sr_enum {
            FAST_EDGE = 0 { name = "Fast Edge"; desc = "fast edge"; };
            SLOW_EDGE = 1 { name = "Slow Edge"; desc = "slow edge"; };
        };

        field {
            name = "ir_in_sr";
            desc = "Level conversion rate of the IR_IN pin";
            sw = rw;
            hw = r;
            encode = PADCTRL_REG44_ir_in_sr_enum;
            reset = 0x1;
        } ir_in_sr[7:7];

        enum PADCTRL_REG44_ir_in_ds_enum {
            V_4_MA = 0 { name = "V 4 Ma"; desc = "4 mA"; };
            V_3_MA = 1 { name = "V 3 Ma"; desc = "3 mA"; };
            V_2_MA = 2 { name = "V 2 Ma"; desc = "2 mA"; };
            V_1_MA = 3 { name = "V 1 Ma"; desc = "1 mA"; };
        };

        field {
            name = "ir_in_ds";
            desc = "Drive current of the IR_IN pin";
            sw = rw;
            hw = r;
            encode = PADCTRL_REG44_ir_in_ds_enum;
            reset = 0x2;
        } ir_in_ds[5:4];
    } PADCTRL_REG44 @ 0x8B0;

    reg {
        name = "Drive capability register for the POR_SEL pin";
        desc = "PADCTRL_REG45 is a drive capability register for the POR_SEL pin.

Data sheet 2.6.2 PADCTRL_REG45 (offset 0xB4, printed page 2-198, `hi3516av100--Hi3516A-Hi3516D-Datasheet.txt` line 12356).";

        enum PADCTRL_REG45_por_sel_sr_enum {
            FAST_EDGE = 0 { name = "Fast Edge"; desc = "fast edge"; };
            SLOW_EDGE = 1 { name = "Slow Edge"; desc = "slow edge"; };
        };

        field {
            name = "por_sel_sr";
            desc = "Level conversion rate of the POR_SEL pin";
            sw = rw;
            hw = r;
            encode = PADCTRL_REG45_por_sel_sr_enum;
            reset = 0x1;
        } por_sel_sr[7:7];

        enum PADCTRL_REG45_por_sel_ds_enum {
            V_4_MA = 0 { name = "V 4 Ma"; desc = "4 mA"; };
            V_3_MA = 1 { name = "V 3 Ma"; desc = "3 mA"; };
            V_2_MA = 2 { name = "V 2 Ma"; desc = "2 mA"; };
            V_1_MA = 3 { name = "V 1 Ma"; desc = "1 mA"; };
        };

        field {
            name = "por_sel_ds";
            desc = "Drive current of the POR_SEL pin";
            sw = rw;
            hw = r;
            encode = PADCTRL_REG45_por_sel_ds_enum;
            reset = 0x2;
        } por_sel_ds[5:4];
    } PADCTRL_REG45 @ 0x8B4;

    reg {
        name = "Drive capability register for the RSTN pin";
        desc = "PADCTRL_REG46 is a drive capability register for the RSTN pin.

Data sheet 2.6.2 PADCTRL_REG46 (offset 0xB8, printed page 2-198, `hi3516av100--Hi3516A-Hi3516D-Datasheet.txt` line 12391).";

        enum PADCTRL_REG46_rstn_sr_enum {
            FAST_EDGE = 0 { name = "Fast Edge"; desc = "fast edge"; };
            SLOW_EDGE = 1 { name = "Slow Edge"; desc = "slow edge"; };
        };

        field {
            name = "rstn_sr";
            desc = "Level conversion rate of the RSTN pin";
            sw = rw;
            hw = r;
            encode = PADCTRL_REG46_rstn_sr_enum;
            reset = 0x1;
        } rstn_sr[7:7];

        enum PADCTRL_REG46_rstn_ds_enum {
            V_4_MA = 0 { name = "V 4 Ma"; desc = "4 mA"; };
            V_3_MA = 1 { name = "V 3 Ma"; desc = "3 mA"; };
            V_2_MA = 2 { name = "V 2 Ma"; desc = "2 mA"; };
            V_1_MA = 3 { name = "V 1 Ma"; desc = "1 mA"; };
        };

        field {
            name = "rstn_ds";
            desc = "Drive current of the RSTN pin";
            sw = rw;
            hw = r;
            encode = PADCTRL_REG46_rstn_ds_enum;
            reset = 0x2;
        } rstn_ds[5:4];
    } PADCTRL_REG46 @ 0x8B8;

    reg {
        name = "Drive capability register for the WDG_RSTN pin";
        desc = "PADCTRL_REG47 is a drive capability register for the WDG_RSTN pin.

Data sheet 2.6.2 PADCTRL_REG47 (offset 0xBC, printed page 2-199, `hi3516av100--Hi3516A-Hi3516D-Datasheet.txt` line 12431).";

        enum PADCTRL_REG47_wdg_rstn_sr_enum {
            FAST_EDGE = 0 { name = "Fast Edge"; desc = "fast edge"; };
            SLOW_EDGE = 1 { name = "Slow Edge"; desc = "slow edge"; };
        };

        field {
            name = "wdg_rstn_sr";
            desc = "Level conversion rate of the WDG_RSTN pin";
            sw = rw;
            hw = r;
            encode = PADCTRL_REG47_wdg_rstn_sr_enum;
            reset = 0x1;
        } wdg_rstn_sr[7:7];

        enum PADCTRL_REG47_wdg_rstn_ds_enum {
            V_4_MA = 0 { name = "V 4 Ma"; desc = "4 mA"; };
            V_3_MA = 1 { name = "V 3 Ma"; desc = "3 mA"; };
            V_2_MA = 2 { name = "V 2 Ma"; desc = "2 mA"; };
            V_1_MA = 3 { name = "V 1 Ma"; desc = "1 mA"; };
        };

        field {
            name = "wdg_rstn_ds";
            desc = "Drive current of the WDG_RSTN pin";
            sw = rw;
            hw = r;
            encode = PADCTRL_REG47_wdg_rstn_ds_enum;
            reset = 0x2;
        } wdg_rstn_ds[5:4];
    } PADCTRL_REG47 @ 0x8BC;

    reg {
        name = "Drive capability register for the TEST_MODE pin";
        desc = "PADCTRL_REG48 is a drive capability register for the TEST_MODE pin.

Data sheet 2.6.2 PADCTRL_REG48 (offset 0xC0, printed page 2-200, `hi3516av100--Hi3516A-Hi3516D-Datasheet.txt` line 12477).";

        enum PADCTRL_REG48_test_mode_sr_enum {
            FAST_EDGE = 0 { name = "Fast Edge"; desc = "fast edge"; };
            SLOW_EDGE = 1 { name = "Slow Edge"; desc = "slow edge"; };
        };

        field {
            name = "test_mode_sr";
            desc = "Level conversion rate of the TEST_MODE pin";
            sw = rw;
            hw = r;
            encode = PADCTRL_REG48_test_mode_sr_enum;
            reset = 0x1;
        } test_mode_sr[7:7];

        enum PADCTRL_REG48_test_mode_ds_enum {
            V_4_MA = 0 { name = "V 4 Ma"; desc = "4 mA"; };
            V_3_MA = 1 { name = "V 3 Ma"; desc = "3 mA"; };
            V_2_MA = 2 { name = "V 2 Ma"; desc = "2 mA"; };
            V_1_MA = 3 { name = "V 1 Ma"; desc = "1 mA"; };
        };

        field {
            name = "test_mode_ds";
            desc = "Drive current of the TEST_MODE pin";
            sw = rw;
            hw = r;
            encode = PADCTRL_REG48_test_mode_ds_enum;
            reset = 0x2;
        } test_mode_ds[5:4];
    } PADCTRL_REG48 @ 0x8C0;

    reg {
        name = "Drive capability register for the USB_OVRCUR pin";
        desc = "PADCTRL_REG49 is a drive capability register for the USB_OVRCUR pin.

Data sheet 2.6.2 PADCTRL_REG49 (offset 0xC4, printed page 2-201, `hi3516av100--Hi3516A-Hi3516D-Datasheet.txt` line 12518).";

        enum PADCTRL_REG49_usb_ovrcur_sr_enum {
            FAST_EDGE = 0 { name = "Fast Edge"; desc = "fast edge"; };
            SLOW_EDGE = 1 { name = "Slow Edge"; desc = "slow edge"; };
        };

        field {
            name = "usb_ovrcur_sr";
            desc = "Level conversion rate of the USB_OVRCUR pin";
            sw = rw;
            hw = r;
            encode = PADCTRL_REG49_usb_ovrcur_sr_enum;
            reset = 0x1;
        } usb_ovrcur_sr[7:7];

        enum PADCTRL_REG49_usb_ovrcur_ds_enum {
            V_4_MA = 0 { name = "V 4 Ma"; desc = "4 mA"; };
            V_3_MA = 1 { name = "V 3 Ma"; desc = "3 mA"; };
            V_2_MA = 2 { name = "V 2 Ma"; desc = "2 mA"; };
            V_1_MA = 3 { name = "V 1 Ma"; desc = "1 mA"; };
        };

        field {
            name = "usb_ovrcur_ds";
            desc = "Drive current of the USB_OVRCUR pin";
            sw = rw;
            hw = r;
            encode = PADCTRL_REG49_usb_ovrcur_ds_enum;
            reset = 0x2;
        } usb_ovrcur_ds[5:4];
    } PADCTRL_REG49 @ 0x8C4;

    reg {
        name = "Drive capability register for the USB_PWREN pin";
        desc = "PADCTRL_REG50 is a drive capability register for the USB_PWREN pin.

Data sheet 2.6.2 PADCTRL_REG50 (offset 0xC8, printed page 2-201, `hi3516av100--Hi3516A-Hi3516D-Datasheet.txt` line 12553).";

        enum PADCTRL_REG50_usb_pwren_sr_enum {
            FAST_EDGE = 0 { name = "Fast Edge"; desc = "fast edge"; };
            SLOW_EDGE = 1 { name = "Slow Edge"; desc = "slow edge"; };
        };

        field {
            name = "usb_pwren_sr";
            desc = "Level conversion rate of the USB_PWREN pin";
            sw = rw;
            hw = r;
            encode = PADCTRL_REG50_usb_pwren_sr_enum;
            reset = 0x1;
        } usb_pwren_sr[7:7];

        enum PADCTRL_REG50_usb_pwren_ds_enum {
            V_4_MA = 0 { name = "V 4 Ma"; desc = "4 mA"; };
            V_3_MA = 1 { name = "V 3 Ma"; desc = "3 mA"; };
            V_2_MA = 2 { name = "V 2 Ma"; desc = "2 mA"; };
            V_1_MA = 3 { name = "V 1 Ma"; desc = "1 mA"; };
        };

        field {
            name = "usb_pwren_ds";
            desc = "Drive current of the USB_PWREN pin";
            sw = rw;
            hw = r;
            encode = PADCTRL_REG50_usb_pwren_ds_enum;
            reset = 0x2;
        } usb_pwren_ds[5:4];
    } PADCTRL_REG50 @ 0x8C8;

    reg {
        name = "Drive capability register for the SDIO0_CCLK_OUT pin";
        desc = "PADCTRL_REG51 is a drive capability register for the SDIO0_CCLK_OUT pin.

Data sheet 2.6.2 PADCTRL_REG51 (offset 0xCC, printed page 2-202, `hi3516av100--Hi3516A-Hi3516D-Datasheet.txt` line 12595).";

        enum PADCTRL_REG51_sdio0_cclk_out_sr_enum {
            FAST_EDGE = 0 { name = "Fast Edge"; desc = "fast edge"; };
            SLOW_EDGE = 1 { name = "Slow Edge"; desc = "slow edge"; };
        };

        field {
            name = "sdio0_cclk_out_sr";
            desc = "Level conversion rate of the SDIO0_CCLK_OUT pin";
            sw = rw;
            hw = r;
            encode = PADCTRL_REG51_sdio0_cclk_out_sr_enum;
            reset = 0x1;
        } sdio0_cclk_out_sr[7:7];

        enum PADCTRL_REG51_sdio0_cclk_out_ds_enum {
            V_18_MA = 0 { name = "V 18 Ma"; desc = "18 mA"; };
            V_16_MA = 1 { name = "V 16 Ma"; desc = "16 mA"; };
            V_14_MA = 2 { name = "V 14 Ma"; desc = "14 mA"; };
            V_12_MA = 3 { name = "V 12 Ma"; desc = "12 mA"; };
            V_5_MA = 4 { name = "V 5 Ma"; desc = "5 mA"; };
            V_4_MA = 5 { name = "V 4 Ma"; desc = "4 mA"; };
            V_2_MA = 6 { name = "V 2 Ma"; desc = "2 mA"; };
            V_1_MA = 7 { name = "V 1 Ma"; desc = "1 mA"; };
        };

        field {
            name = "sdio0_cclk_out_ds";
            desc = "Drive current of the SDIO0_CCLK_OUT pin";
            sw = rw;
            hw = r;
            encode = PADCTRL_REG51_sdio0_cclk_out_ds_enum;
            reset = 0x5;
        } sdio0_cclk_out_ds[6:4];
    } PADCTRL_REG51 @ 0x8CC;

    reg {
        name = "Drive capability register for the SDIO0_CARD_POWER_EN pin";
        desc = "PADCTRL_REG52 is a drive capability register for the SDIO0_CARD_POWER_EN pin.

Data sheet 2.6.2 PADCTRL_REG52 (offset 0xD0, printed page 2-203, `hi3516av100--Hi3516A-Hi3516D-Datasheet.txt` line 12644).";

        enum PADCTRL_REG52_sdio0_card_power_en_sr_enum {
            FAST_EDGE = 0 { name = "Fast Edge"; desc = "fast edge"; };
            SLOW_EDGE = 1 { name = "Slow Edge"; desc = "slow edge"; };
        };

        field {
            name = "sdio0_card_power_en_sr";
            desc = "Level conversion rate of the SDIO0_CARD_POWER_EN pin";
            sw = rw;
            hw = r;
            encode = PADCTRL_REG52_sdio0_card_power_en_sr_enum;
            reset = 0x1;
        } sdio0_card_power_en_sr[7:7];

        enum PADCTRL_REG52_sdio0_card_power_en_ds_enum {
            V_4_MA = 0 { name = "V 4 Ma"; desc = "4 mA"; };
            V_3_MA = 1 { name = "V 3 Ma"; desc = "3 mA"; };
            V_2_MA = 2 { name = "V 2 Ma"; desc = "2 mA"; };
            V_1_MA = 3 { name = "V 1 Ma"; desc = "1 mA"; };
        };

        field {
            name = "sdio0_card_power_en_ds";
            desc = "Drive current of the SDIO0_CARD_POWER_EN pin";
            sw = rw;
            hw = r;
            encode = PADCTRL_REG52_sdio0_card_power_en_ds_enum;
            reset = 0x2;
        } sdio0_card_power_en_ds[5:4];
    } PADCTRL_REG52 @ 0x8D0;

    reg {
        name = "Drive capability register for the SDIO0_CARD_DETECT pin";
        desc = "PADCTRL_REG53 is a drive capability register for the SDIO0_CARD_DETECT pin.

Data sheet 2.6.2 PADCTRL_REG53 (offset 0xD4, printed page 2-204, `hi3516av100--Hi3516A-Hi3516D-Datasheet.txt` line 12692).";

        enum PADCTRL_REG53_sdio0_card_detect_en_sr_enum {
            FAST_EDGE = 0 { name = "Fast Edge"; desc = "fast edge"; };
            SLOW_EDGE = 1 { name = "Slow Edge"; desc = "slow edge"; };
        };

        field {
            name = "sdio0_card_detect_en_sr";
            desc = "Level conversion rate of the SDIO0_CARD_DETECT pin";
            sw = rw;
            hw = r;
            encode = PADCTRL_REG53_sdio0_card_detect_en_sr_enum;
            reset = 0x1;
        } sdio0_card_detect_en_sr[7:7];

        enum PADCTRL_REG53_sdio0_card_detect_en_ds_enum {
            V_4_MA = 0 { name = "V 4 Ma"; desc = "4 mA"; };
            V_3_MA = 1 { name = "V 3 Ma"; desc = "3 mA"; };
            V_2_MA = 2 { name = "V 2 Ma"; desc = "2 mA"; };
            V_1_MA = 3 { name = "V 1 Ma"; desc = "1 mA"; };
        };

        field {
            name = "sdio0_card_detect_en_ds";
            desc = "Drive current of the SDIO0_CARD_DETECT pin";
            sw = rw;
            hw = r;
            encode = PADCTRL_REG53_sdio0_card_detect_en_ds_enum;
            reset = 0x2;
        } sdio0_card_detect_en_ds[5:4];
    } PADCTRL_REG53 @ 0x8D4;

    reg {
        name = "Drive capability register for the SDIO0_CWPR pin";
        desc = "PADCTRL_REG54 is a drive capability register for the SDIO0_CWPR pin.

Data sheet 2.6.2 PADCTRL_REG54 (offset 0xD8, printed page 2-205, `hi3516av100--Hi3516A-Hi3516D-Datasheet.txt` line 12737).";

        enum PADCTRL_REG54_sdio0_cwpr_sr_enum {
            FAST_EDGE = 0 { name = "Fast Edge"; desc = "fast edge"; };
            SLOW_EDGE = 1 { name = "Slow Edge"; desc = "slow edge"; };
        };

        field {
            name = "sdio0_cwpr_sr";
            desc = "Level conversion rate of the SDIO0_CWPR pin";
            sw = rw;
            hw = r;
            encode = PADCTRL_REG54_sdio0_cwpr_sr_enum;
            reset = 0x1;
        } sdio0_cwpr_sr[7:7];

        enum PADCTRL_REG54_sdio0_cwpr_ds_enum {
            V_4_MA = 0 { name = "V 4 Ma"; desc = "4 mA"; };
            V_3_MA = 1 { name = "V 3 Ma"; desc = "3 mA"; };
            V_2_MA = 2 { name = "V 2 Ma"; desc = "2 mA"; };
            V_1_MA = 3 { name = "V 1 Ma"; desc = "1 mA"; };
        };

        field {
            name = "sdio0_cwpr_ds";
            desc = "Drive current of the SDIO0_CWPR pin";
            sw = rw;
            hw = r;
            encode = PADCTRL_REG54_sdio0_cwpr_ds_enum;
            reset = 0x2;
        } sdio0_cwpr_ds[5:4];
    } PADCTRL_REG54 @ 0x8D8;

    reg {
        name = "Drive capability register for the SDIO0_CCMD pin";
        desc = "PADCTRL_REG55 is a drive capability register for the SDIO0_CCMD pin.

Data sheet 2.6.2 PADCTRL_REG55 (offset 0xDC, printed page 2-206, `hi3516av100--Hi3516A-Hi3516D-Datasheet.txt` line 12778).";

        enum PADCTRL_REG55_sdio0_ccmd_sr_enum {
            FAST_EDGE = 0 { name = "Fast Edge"; desc = "fast edge"; };
            SLOW_EDGE = 1 { name = "Slow Edge"; desc = "slow edge"; };
        };

        field {
            name = "sdio0_ccmd_sr";
            desc = "Level conversion rate of the SDIO0_CCMD pin";
            sw = rw;
            hw = r;
            encode = PADCTRL_REG55_sdio0_ccmd_sr_enum;
            reset = 0x1;
        } sdio0_ccmd_sr[7:7];

        enum PADCTRL_REG55_sdio0_ccmd_ds_enum {
            V_12_MA = 0 { name = "V 12 Ma"; desc = "12 mA"; };
            V_11_MA = 1 { name = "V 11 Ma"; desc = "11 mA"; };
            V_9_MA = 2 { name = "V 9 Ma"; desc = "9 mA"; };
            V_8_MA = 3 { name = "V 8 Ma"; desc = "8 mA"; };
            V_5_MA = 4 { name = "V 5 Ma"; desc = "5 mA"; };
            V_4_MA = 5 { name = "V 4 Ma"; desc = "4 mA"; };
            V_2_MA = 6 { name = "V 2 Ma"; desc = "2 mA"; };
            V_1_MA = 7 { name = "V 1 Ma"; desc = "1 mA"; };
        };

        field {
            name = "sdio0_ccmd_ds";
            desc = "Drive current of the SDIO0_CCMD pin";
            sw = rw;
            hw = r;
            encode = PADCTRL_REG55_sdio0_ccmd_ds_enum;
            reset = 0x6;
        } sdio0_ccmd_ds[6:4];
    } PADCTRL_REG55 @ 0x8DC;

    reg {
        name = "Drive capability register for the SDIO0_CDATA0 pin";
        desc = "PADCTRL_REG56 is a drive capability register for the SDIO0_CDATA0 pin.

Data sheet 2.6.2 PADCTRL_REG56 (offset 0xE0, printed page 2-207, `hi3516av100--Hi3516A-Hi3516D-Datasheet.txt` line 12822).";

        enum PADCTRL_REG56_sdio0_cdata0_sr_enum {
            FAST_EDGE = 0 { name = "Fast Edge"; desc = "fast edge"; };
            SLOW_EDGE = 1 { name = "Slow Edge"; desc = "slow edge"; };
        };

        field {
            name = "sdio0_cdata0_sr";
            desc = "Level conversion rate of the SDIO0_CDATA0 pin";
            sw = rw;
            hw = r;
            encode = PADCTRL_REG56_sdio0_cdata0_sr_enum;
            reset = 0x1;
        } sdio0_cdata0_sr[7:7];

        enum PADCTRL_REG56_sdio0_cdata0_ds_enum {
            V_12_MA = 0 { name = "V 12 Ma"; desc = "12 mA"; };
            V_11_MA = 1 { name = "V 11 Ma"; desc = "11 mA"; };
            V_9_MA = 2 { name = "V 9 Ma"; desc = "9 mA"; };
            V_8_MA = 3 { name = "V 8 Ma"; desc = "8 mA"; };
            V_5_MA = 4 { name = "V 5 Ma"; desc = "5 mA"; };
            V_4_MA = 5 { name = "V 4 Ma"; desc = "4 mA"; };
            V_2_MA = 6 { name = "V 2 Ma"; desc = "2 mA"; };
            V_1_MA = 7 { name = "V 1 Ma"; desc = "1 mA"; };
        };

        field {
            name = "sdio0_cdata0_ds";
            desc = "Drive current of the SDIO0_CDATA0 pin";
            sw = rw;
            hw = r;
            encode = PADCTRL_REG56_sdio0_cdata0_ds_enum;
            reset = 0x6;
        } sdio0_cdata0_ds[6:4];
    } PADCTRL_REG56 @ 0x8E0;

    reg {
        name = "Drive capability register for the SDIO0_CDATA1 pin";
        desc = "PADCTRL_REG57 is a drive capability register for the SDIO0_CDATA1 pin.

Data sheet 2.6.2 PADCTRL_REG57 (offset 0xE4, printed page 2-208, `hi3516av100--Hi3516A-Hi3516D-Datasheet.txt` line 12866).";

        enum PADCTRL_REG57_sdio0_cdata1_sr_enum {
            FAST_EDGE = 0 { name = "Fast Edge"; desc = "fast edge"; };
            SLOW_EDGE = 1 { name = "Slow Edge"; desc = "slow edge"; };
        };

        field {
            name = "sdio0_cdata1_sr";
            desc = "Level conversion rate of the SDIO0_CDATA1 pin";
            sw = rw;
            hw = r;
            encode = PADCTRL_REG57_sdio0_cdata1_sr_enum;
            reset = 0x1;
        } sdio0_cdata1_sr[7:7];

        enum PADCTRL_REG57_sdio0_cdata1_ds_enum {
            V_12_MA = 0 { name = "V 12 Ma"; desc = "12 mA"; };
            V_11_MA = 1 { name = "V 11 Ma"; desc = "11 mA"; };
            V_9_MA = 2 { name = "V 9 Ma"; desc = "9 mA"; };
            V_8_MA = 3 { name = "V 8 Ma"; desc = "8 mA"; };
            V_5_MA = 4 { name = "V 5 Ma"; desc = "5 mA"; };
            V_4_MA = 5 { name = "V 4 Ma"; desc = "4 mA"; };
            V_2_MA = 6 { name = "V 2 Ma"; desc = "2 mA"; };
            V_1_MA = 7 { name = "V 1 Ma"; desc = "1 mA"; };
        };

        field {
            name = "sdio0_cdata1_ds";
            desc = "Drive current of the SDIO0_CDATA1 pin";
            sw = rw;
            hw = r;
            encode = PADCTRL_REG57_sdio0_cdata1_ds_enum;
            reset = 0x6;
        } sdio0_cdata1_ds[6:4];
    } PADCTRL_REG57 @ 0x8E4;

    reg {
        name = "Drive capability register for the SDIO0_CDATA2 pin";
        desc = "PADCTRL_REG58 is a drive capability register for the SDIO0_CDATA2 pin.

Data sheet 2.6.2 PADCTRL_REG58 (offset 0xE8, printed page 2-209, `hi3516av100--Hi3516A-Hi3516D-Datasheet.txt` line 12910).";

        enum PADCTRL_REG58_sdio0_cdata2_sr_enum {
            FAST_EDGE = 0 { name = "Fast Edge"; desc = "fast edge"; };
            SLOW_EDGE = 1 { name = "Slow Edge"; desc = "slow edge"; };
        };

        field {
            name = "sdio0_cdata2_sr";
            desc = "Level conversion rate of the SDIO0_CDATA2 pin";
            sw = rw;
            hw = r;
            encode = PADCTRL_REG58_sdio0_cdata2_sr_enum;
            reset = 0x1;
        } sdio0_cdata2_sr[7:7];

        enum PADCTRL_REG58_sdio0_cdata2_ds_enum {
            V_12_MA = 0 { name = "V 12 Ma"; desc = "12 mA"; };
            V_11_MA = 1 { name = "V 11 Ma"; desc = "11 mA"; };
            V_9_MA = 2 { name = "V 9 Ma"; desc = "9 mA"; };
            V_8_MA = 3 { name = "V 8 Ma"; desc = "8 mA"; };
            V_5_MA = 4 { name = "V 5 Ma"; desc = "5 mA"; };
            V_4_MA = 5 { name = "V 4 Ma"; desc = "4 mA"; };
            V_2_MA = 6 { name = "V 2 Ma"; desc = "2 mA"; };
            V_1_MA = 7 { name = "V 1 Ma"; desc = "1 mA"; };
        };

        field {
            name = "sdio0_cdata2_ds";
            desc = "Drive current of the SDIO0_CDATA2 pin";
            sw = rw;
            hw = r;
            encode = PADCTRL_REG58_sdio0_cdata2_ds_enum;
            reset = 0x6;
        } sdio0_cdata2_ds[6:4];
    } PADCTRL_REG58 @ 0x8E8;

    reg {
        name = "Drive capability register for the SDIO0_CDATA3 pin";
        desc = "PADCTRL_REG59 is a drive capability register for the SDIO0_CDATA3 pin.

Data sheet 2.6.2 PADCTRL_REG59 (offset 0xEC, printed page 2-210, `hi3516av100--Hi3516A-Hi3516D-Datasheet.txt` line 12954).";

        enum PADCTRL_REG59_sdio0_cdata3_sr_enum {
            FAST_EDGE = 0 { name = "Fast Edge"; desc = "fast edge"; };
            SLOW_EDGE = 1 { name = "Slow Edge"; desc = "slow edge"; };
        };

        field {
            name = "sdio0_cdata3_sr";
            desc = "Level conversion rate of the SDIO0_CDATA3 pin";
            sw = rw;
            hw = r;
            encode = PADCTRL_REG59_sdio0_cdata3_sr_enum;
            reset = 0x1;
        } sdio0_cdata3_sr[7:7];

        enum PADCTRL_REG59_sdio0_cdata3_ds_enum {
            V_12_MA = 0 { name = "V 12 Ma"; desc = "12 mA"; };
            V_11_MA = 1 { name = "V 11 Ma"; desc = "11 mA"; };
            V_9_MA = 2 { name = "V 9 Ma"; desc = "9 mA"; };
            V_8_MA = 3 { name = "V 8 Ma"; desc = "8 mA"; };
            V_5_MA = 4 { name = "V 5 Ma"; desc = "5 mA"; };
            V_4_MA = 5 { name = "V 4 Ma"; desc = "4 mA"; };
            V_2_MA = 6 { name = "V 2 Ma"; desc = "2 mA"; };
            V_1_MA = 7 { name = "V 1 Ma"; desc = "1 mA"; };
        };

        field {
            name = "sdio0_cdata3_ds";
            desc = "Drive current of the SDIO0_CDATA3 pin";
            sw = rw;
            hw = r;
            encode = PADCTRL_REG59_sdio0_cdata3_ds_enum;
            reset = 0x6;
        } sdio0_cdata3_ds[6:4];
    } PADCTRL_REG59 @ 0x8EC;

    reg {
        name = "Drive capability register for the GPIO0_0 pin";
        desc = "PADCTRL_REG60 is a drive capability register for the GPIO0_0 pin.

Data sheet 2.6.2 PADCTRL_REG60 (offset 0xF0, printed page 2-211, `hi3516av100--Hi3516A-Hi3516D-Datasheet.txt` line 12998).";

        enum PADCTRL_REG60_gpio0_0_sr_enum {
            FAST_EDGE = 0 { name = "Fast Edge"; desc = "fast edge"; };
            SLOW_EDGE = 1 { name = "Slow Edge"; desc = "slow edge"; };
        };

        field {
            name = "gpio0_0_sr";
            desc = "Level conversion rate of the GPIO0_0 pin";
            sw = rw;
            hw = r;
            encode = PADCTRL_REG60_gpio0_0_sr_enum;
            reset = 0x1;
        } gpio0_0_sr[7:7];

        enum PADCTRL_REG60_gpio0_0_ds_enum {
            V_4_MA = 0 { name = "V 4 Ma"; desc = "4 mA"; };
            V_3_MA = 1 { name = "V 3 Ma"; desc = "3 mA"; };
            V_2_MA = 2 { name = "V 2 Ma"; desc = "2 mA"; };
            V_1_MA = 3 { name = "V 1 Ma"; desc = "1 mA"; };
        };

        field {
            name = "gpio0_0_ds";
            desc = "Drive current of the GPIO0_0 pin";
            sw = rw;
            hw = r;
            encode = PADCTRL_REG60_gpio0_0_ds_enum;
            reset = 0x1;
        } gpio0_0_ds[5:4];
    } PADCTRL_REG60 @ 0x8F0;

    reg {
        name = "Drive capability register for the GPIO0_1 pin";
        desc = "PADCTRL_REG61 is a drive capability register for the GPIO0_1 pin.

Data sheet 2.6.2 PADCTRL_REG61 (offset 0xF4, printed page 2-211, `hi3516av100--Hi3516A-Hi3516D-Datasheet.txt` line 13033).";

        enum PADCTRL_REG61_gpio0_1_sr_enum {
            FAST_EDGE = 0 { name = "Fast Edge"; desc = "fast edge"; };
            SLOW_EDGE = 1 { name = "Slow Edge"; desc = "slow edge"; };
        };

        field {
            name = "gpio0_1_sr";
            desc = "Level conversion rate of the GPIO0_1 pin";
            sw = rw;
            hw = r;
            encode = PADCTRL_REG61_gpio0_1_sr_enum;
            reset = 0x1;
        } gpio0_1_sr[7:7];

        enum PADCTRL_REG61_gpio0_1_ds_enum {
            V_12_MA = 0 { name = "V 12 Ma"; desc = "12 mA"; };
            V_11_MA = 1 { name = "V 11 Ma"; desc = "11 mA"; };
            V_9_MA = 2 { name = "V 9 Ma"; desc = "9 mA"; };
            V_8_MA = 3 { name = "V 8 Ma"; desc = "8 mA"; };
            V_5_MA = 4 { name = "V 5 Ma"; desc = "5 mA"; };
            V_4_MA = 5 { name = "V 4 Ma"; desc = "4 mA"; };
            V_2_MA = 6 { name = "V 2 Ma"; desc = "2 mA"; };
            V_1_MA = 7 { name = "V 1 Ma"; desc = "1 mA"; };
        };

        field {
            name = "gpio0_1_ds";
            desc = "Drive current of the GPIO0_1 pin";
            sw = rw;
            hw = r;
            encode = PADCTRL_REG61_gpio0_1_ds_enum;
            reset = 0x6;
        } gpio0_1_ds[6:4];
    } PADCTRL_REG61 @ 0x8F4;

    reg {
        name = "Drive capability register for the GPIO0_2 pin";
        desc = "PADCTRL_REG62 is a drive capability register for the GPIO0_2 pin.

Data sheet 2.6.2 PADCTRL_REG62 (offset 0xF8, printed page 2-212, `hi3516av100--Hi3516A-Hi3516D-Datasheet.txt` line 13078).";

        enum PADCTRL_REG62_gpio0_2_sr_enum {
            FAST_EDGE = 0 { name = "Fast Edge"; desc = "fast edge"; };
            SLOW_EDGE = 1 { name = "Slow Edge"; desc = "slow edge"; };
        };

        field {
            name = "gpio0_2_sr";
            desc = "Level conversion rate of the GPIO0_2 pin";
            sw = rw;
            hw = r;
            encode = PADCTRL_REG62_gpio0_2_sr_enum;
            reset = 0x1;
        } gpio0_2_sr[7:7];

        enum PADCTRL_REG62_gpio0_2_ds_enum {
            V_4_MA = 0 { name = "V 4 Ma"; desc = "4 mA"; };
            V_3_MA = 1 { name = "V 3 Ma"; desc = "3 mA"; };
            V_2_MA = 2 { name = "V 2 Ma"; desc = "2 mA"; };
            V_1_MA = 3 { name = "V 1 Ma"; desc = "1 mA"; };
        };

        field {
            name = "gpio0_2_ds";
            desc = "Drive current of the GPIO0_2 pin";
            sw = rw;
            hw = r;
            encode = PADCTRL_REG62_gpio0_2_ds_enum;
            reset = 0x2;
        } gpio0_2_ds[5:4];
    } PADCTRL_REG62 @ 0x8F8;

    reg {
        name = "Drive capability register for the GPIO0_3 pin";
        desc = "PADCTRL_REG63 is a drive capability register for the GPIO0_3 pin.

Data sheet 2.6.2 PADCTRL_REG63 (offset 0xFC, printed page 2-213, `hi3516av100--Hi3516A-Hi3516D-Datasheet.txt` line 13124).";

        enum PADCTRL_REG63_gpio0_3_sr_enum {
            FAST_EDGE = 0 { name = "Fast Edge"; desc = "fast edge"; };
            SLOW_EDGE = 1 { name = "Slow Edge"; desc = "slow edge"; };
        };

        field {
            name = "gpio0_3_sr";
            desc = "Level conversion rate of the GPIO0_3 pin";
            sw = rw;
            hw = r;
            encode = PADCTRL_REG63_gpio0_3_sr_enum;
            reset = 0x1;
        } gpio0_3_sr[7:7];

        enum PADCTRL_REG63_gpio0_3_ds_enum {
            V_4_MA = 0 { name = "V 4 Ma"; desc = "4 mA"; };
            V_3_MA = 1 { name = "V 3 Ma"; desc = "3 mA"; };
            V_2_MA = 2 { name = "V 2 Ma"; desc = "2 mA"; };
            V_1_MA = 3 { name = "V 1 Ma"; desc = "1 mA"; };
        };

        field {
            name = "gpio0_3_ds";
            desc = "Drive current of the GPIO0_3 pin";
            sw = rw;
            hw = r;
            encode = PADCTRL_REG63_gpio0_3_ds_enum;
            reset = 0x2;
        } gpio0_3_ds[5:4];
    } PADCTRL_REG63 @ 0x8FC;

    reg {
        name = "Drive capability register for the GPIO0_4 pin";
        desc = "PADCTRL_REG64 is a drive capability register for the GPIO0_4 pin.

Data sheet 2.6.2 PADCTRL_REG64 (offset 0x100, printed page 2-214, `hi3516av100--Hi3516A-Hi3516D-Datasheet.txt` line 13165).";

        enum PADCTRL_REG64_gpio0_4_sr_enum {
            FAST_EDGE = 0 { name = "Fast Edge"; desc = "fast edge"; };
            SLOW_EDGE = 1 { name = "Slow Edge"; desc = "slow edge"; };
        };

        field {
            name = "gpio0_4_sr";
            desc = "Level conversion rate of the GPIO0_4 pin";
            sw = rw;
            hw = r;
            encode = PADCTRL_REG64_gpio0_4_sr_enum;
            reset = 0x1;
        } gpio0_4_sr[7:7];

        enum PADCTRL_REG64_gpio0_4_ds_enum {
            V_4_MA = 0 { name = "V 4 Ma"; desc = "4 mA"; };
            V_3_MA = 1 { name = "V 3 Ma"; desc = "3 mA"; };
            V_2_MA = 2 { name = "V 2 Ma"; desc = "2 mA"; };
            V_1_MA = 3 { name = "V 1 Ma"; desc = "1 mA"; };
        };

        field {
            name = "gpio0_4_ds";
            desc = "Drive current of the GPIO0_4 pin";
            sw = rw;
            hw = r;
            encode = PADCTRL_REG64_gpio0_4_ds_enum;
            reset = 0x2;
        } gpio0_4_ds[5:4];
    } PADCTRL_REG64 @ 0x900;

    reg {
        name = "Drive capability register for the SDIO1_CCLK_OUT pin";
        desc = "PADCTRL_REG65 is a drive capability register for the SDIO1_CCLK_OUT pin.

Data sheet 2.6.2 PADCTRL_REG65 (offset 0x104, printed page 2-214, `hi3516av100--Hi3516A-Hi3516D-Datasheet.txt` line 13200).";

        enum PADCTRL_REG65_sdio1_cclk_out_sr_enum {
            FAST_EDGE = 0 { name = "Fast Edge"; desc = "fast edge"; };
            SLOW_EDGE = 1 { name = "Slow Edge"; desc = "slow edge"; };
        };

        field {
            name = "sdio1_cclk_out_sr";
            desc = "Level conversion rate of the SDIO1_CCLK_OUT pin";
            sw = rw;
            hw = r;
            encode = PADCTRL_REG65_sdio1_cclk_out_sr_enum;
            reset = 0x1;
        } sdio1_cclk_out_sr[7:7];

        enum PADCTRL_REG65_sdio1_cclk_out_ds_enum {
            V_18_MA = 0 { name = "V 18 Ma"; desc = "18 mA"; };
            V_16_MA = 1 { name = "V 16 Ma"; desc = "16 mA"; };
            V_14_MA = 2 { name = "V 14 Ma"; desc = "14 mA"; };
            V_12_MA = 3 { name = "V 12 Ma"; desc = "12 mA"; };
            V_5_MA = 4 { name = "V 5 Ma"; desc = "5 mA"; };
            V_4_MA = 5 { name = "V 4 Ma"; desc = "4 mA"; };
            V_2_MA = 6 { name = "V 2 Ma"; desc = "2 mA"; };
            V_1_MA = 7 { name = "V 1 Ma"; desc = "1 mA"; };
        };

        field {
            name = "sdio1_cclk_out_ds";
            desc = "Drive current of the SDIO1_CCLK_OUT pin";
            sw = rw;
            hw = r;
            encode = PADCTRL_REG65_sdio1_cclk_out_ds_enum;
            reset = 0x5;
        } sdio1_cclk_out_ds[6:4];
    } PADCTRL_REG65 @ 0x904;

    reg {
        name = "Drive capability register for the SDIO1_CARD_POWER_EN pin";
        desc = "PADCTRL_REG66 is a drive capability register for the SDIO1_CARD_POWER_EN pin.

Data sheet 2.6.2 PADCTRL_REG66 (offset 0x108, printed page 2-215, `hi3516av100--Hi3516A-Hi3516D-Datasheet.txt` line 13245).";

        enum PADCTRL_REG66_sdio1_card_power_en_sr_enum {
            FAST_EDGE = 0 { name = "Fast Edge"; desc = "fast edge"; };
            SLOW_EDGE = 1 { name = "Slow Edge"; desc = "slow edge"; };
        };

        field {
            name = "sdio1_card_power_en_sr";
            desc = "Level conversion rate of the SDIO1_CARD_POWER_EN pin";
            sw = rw;
            hw = r;
            encode = PADCTRL_REG66_sdio1_card_power_en_sr_enum;
            reset = 0x1;
        } sdio1_card_power_en_sr[7:7];

        enum PADCTRL_REG66_sdio1_card_power_en_ds_enum {
            V_4_MA = 0 { name = "V 4 Ma"; desc = "4 mA"; };
            V_3_MA = 1 { name = "V 3 Ma"; desc = "3 mA"; };
            V_2_MA = 2 { name = "V 2 Ma"; desc = "2 mA"; };
            V_1_MA = 3 { name = "V 1 Ma"; desc = "1 mA"; };
        };

        field {
            name = "sdio1_card_power_en_ds";
            desc = "Drive current of the SDIO1_CARD_POWER_EN pin";
            sw = rw;
            hw = r;
            encode = PADCTRL_REG66_sdio1_card_power_en_ds_enum;
            reset = 0x2;
        } sdio1_card_power_en_ds[5:4];
    } PADCTRL_REG66 @ 0x908;

    reg {
        name = "Drive capability register for the SDIO1_CARD_DETECT pin";
        desc = "PADCTRL_REG67 is a drive capability register for the SDIO1_CARD_DETECT pin.

Data sheet 2.6.2 PADCTRL_REG67 (offset 0x10C, printed page 2-216, `hi3516av100--Hi3516A-Hi3516D-Datasheet.txt` line 13295).";

        enum PADCTRL_REG67_sdio1_card_detect_en_sr_enum {
            FAST_EDGE = 0 { name = "Fast Edge"; desc = "fast edge"; };
            SLOW_EDGE = 1 { name = "Slow Edge"; desc = "slow edge"; };
        };

        field {
            name = "sdio1_card_detect_en_sr";
            desc = "Level conversion rate of the SDIO1_CARD_DETECT pin";
            sw = rw;
            hw = r;
            encode = PADCTRL_REG67_sdio1_card_detect_en_sr_enum;
            reset = 0x1;
        } sdio1_card_detect_en_sr[7:7];

        enum PADCTRL_REG67_sdio1_card_detect_en_ds_enum {
            V_4_MA = 0 { name = "V 4 Ma"; desc = "4 mA"; };
            V_3_MA = 1 { name = "V 3 Ma"; desc = "3 mA"; };
            V_2_MA = 2 { name = "V 2 Ma"; desc = "2 mA"; };
            V_1_MA = 3 { name = "V 1 Ma"; desc = "1 mA"; };
        };

        field {
            name = "sdio1_card_detect_en_ds";
            desc = "Drive current of the SDIO1_CARD_DETECT pin";
            sw = rw;
            hw = r;
            encode = PADCTRL_REG67_sdio1_card_detect_en_ds_enum;
            reset = 0x2;
        } sdio1_card_detect_en_ds[5:4];
    } PADCTRL_REG67 @ 0x90C;

    reg {
        name = "Drive capability register for the SDIO1_CWPR pin";
        desc = "PADCTRL_REG68 is a drive capability register for the SDIO1_CWPR pin.

Data sheet 2.6.2 PADCTRL_REG68 (offset 0x110, printed page 2-217, `hi3516av100--Hi3516A-Hi3516D-Datasheet.txt` line 13345).";

        enum PADCTRL_REG68_sdio1_cwpr_sr_enum {
            FAST_EDGE = 0 { name = "Fast Edge"; desc = "fast edge"; };
            SLOW_EDGE = 1 { name = "Slow Edge"; desc = "slow edge"; };
        };

        field {
            name = "sdio1_cwpr_sr";
            desc = "Level conversion rate of the SDIO1_CWPR pin";
            sw = rw;
            hw = r;
            encode = PADCTRL_REG68_sdio1_cwpr_sr_enum;
            reset = 0x1;
        } sdio1_cwpr_sr[7:7];

        enum PADCTRL_REG68_sdio1_cwpr_ds_enum {
            V_4_MA = 0 { name = "V 4 Ma"; desc = "4 mA"; };
            V_3_MA = 1 { name = "V 3 Ma"; desc = "3 mA"; };
            V_2_MA = 2 { name = "V 2 Ma"; desc = "2 mA"; };
            V_1_MA = 3 { name = "V 1 Ma"; desc = "1 mA"; };
        };

        field {
            name = "sdio1_cwpr_ds";
            desc = "Drive current of the SDIO1_CWPR pin";
            sw = rw;
            hw = r;
            encode = PADCTRL_REG68_sdio1_cwpr_ds_enum;
            reset = 0x2;
        } sdio1_cwpr_ds[5:4];
    } PADCTRL_REG68 @ 0x910;

    reg {
        name = "Drive capability register for the SDIO1_CCMD pin";
        desc = "PADCTRL_REG69 is a drive capability register for the SDIO1_CCMD pin.

Data sheet 2.6.2 PADCTRL_REG69 (offset 0x114, printed page 2-218, `hi3516av100--Hi3516A-Hi3516D-Datasheet.txt` line 13386).";

        enum PADCTRL_REG69_sdio1_ccmd_sr_enum {
            FAST_EDGE = 0 { name = "Fast Edge"; desc = "fast edge"; };
            SLOW_EDGE = 1 { name = "Slow Edge"; desc = "slow edge"; };
        };

        field {
            name = "sdio1_ccmd_sr";
            desc = "Level conversion rate of the SDIO1_CCMD pin";
            sw = rw;
            hw = r;
            encode = PADCTRL_REG69_sdio1_ccmd_sr_enum;
            reset = 0x1;
        } sdio1_ccmd_sr[7:7];

        enum PADCTRL_REG69_sdio1_ccmd_ds_enum {
            V_12_MA = 0 { name = "V 12 Ma"; desc = "12 mA"; };
            V_11_MA = 1 { name = "V 11 Ma"; desc = "11 mA"; };
            V_9_MA = 2 { name = "V 9 Ma"; desc = "9 mA"; };
            V_8_MA = 3 { name = "V 8 Ma"; desc = "8 mA"; };
            V_5_MA = 4 { name = "V 5 Ma"; desc = "5 mA"; };
            V_4_MA = 5 { name = "V 4 Ma"; desc = "4 mA"; };
            V_2_MA = 6 { name = "V 2 Ma"; desc = "2 mA"; };
            V_1_MA = 7 { name = "V 1 Ma"; desc = "1 mA"; };
        };

        field {
            name = "sdio1_ccmd_ds";
            desc = "Drive current of the SDIO1_CCMD pin";
            sw = rw;
            hw = r;
            encode = PADCTRL_REG69_sdio1_ccmd_ds_enum;
            reset = 0x6;
        } sdio1_ccmd_ds[6:4];
    } PADCTRL_REG69 @ 0x914;

    reg {
        name = "Drive capability register for the SDIO1_CDATA0 pin";
        desc = "PADCTRL_REG70 is a drive capability register for the SDIO1_CDATA0 pin.

Data sheet 2.6.2 PADCTRL_REG70 (offset 0x118, printed page 2-219, `hi3516av100--Hi3516A-Hi3516D-Datasheet.txt` line 13430).";

        enum PADCTRL_REG70_sdio1_cdata0_sr_enum {
            FAST_EDGE = 0 { name = "Fast Edge"; desc = "fast edge"; };
            SLOW_EDGE = 1 { name = "Slow Edge"; desc = "slow edge"; };
        };

        field {
            name = "sdio1_cdata0_sr";
            desc = "Level conversion rate of the SDIO1_CDATA0 pin";
            sw = rw;
            hw = r;
            encode = PADCTRL_REG70_sdio1_cdata0_sr_enum;
            reset = 0x1;
        } sdio1_cdata0_sr[7:7];

        enum PADCTRL_REG70_sdio1_cdata0_ds_enum {
            V_12_MA = 0 { name = "V 12 Ma"; desc = "12 mA"; };
            V_11_MA = 1 { name = "V 11 Ma"; desc = "11 mA"; };
            V_9_MA = 2 { name = "V 9 Ma"; desc = "9 mA"; };
            V_8_MA = 3 { name = "V 8 Ma"; desc = "8 mA"; };
            V_5_MA = 4 { name = "V 5 Ma"; desc = "5 mA"; };
            V_4_MA = 5 { name = "V 4 Ma"; desc = "4 mA"; };
            V_2_MA = 6 { name = "V 2 Ma"; desc = "2 mA"; };
            V_1_MA = 7 { name = "V 1 Ma"; desc = "1 mA"; };
        };

        field {
            name = "sdio1_cdata0_ds";
            desc = "Drive current of the SDIO1_CDATA0 pin";
            sw = rw;
            hw = r;
            encode = PADCTRL_REG70_sdio1_cdata0_ds_enum;
            reset = 0x6;
        } sdio1_cdata0_ds[6:4];
    } PADCTRL_REG70 @ 0x918;

    reg {
        name = "Drive capability register for the SDIO1_CDATA1 pin";
        desc = "PADCTRL_REG71 is a drive capability register for the SDIO1_CDATA1 pin.

Data sheet 2.6.2 PADCTRL_REG71 (offset 0x11C, printed page 2-220, `hi3516av100--Hi3516A-Hi3516D-Datasheet.txt` line 13474).";

        enum PADCTRL_REG71_sdio1_cdata1_sr_enum {
            FAST_EDGE = 0 { name = "Fast Edge"; desc = "fast edge"; };
            SLOW_EDGE = 1 { name = "Slow Edge"; desc = "slow edge"; };
        };

        field {
            name = "sdio1_cdata1_sr";
            desc = "Level conversion rate of the SDIO1_CDATA1 pin";
            sw = rw;
            hw = r;
            encode = PADCTRL_REG71_sdio1_cdata1_sr_enum;
            reset = 0x1;
        } sdio1_cdata1_sr[7:7];

        enum PADCTRL_REG71_sdio1_cdata1_ds_enum {
            V_12_MA = 0 { name = "V 12 Ma"; desc = "12 mA"; };
            V_11_MA = 1 { name = "V 11 Ma"; desc = "11 mA"; };
            V_9_MA = 2 { name = "V 9 Ma"; desc = "9 mA"; };
            V_8_MA = 3 { name = "V 8 Ma"; desc = "8 mA"; };
            V_5_MA = 4 { name = "V 5 Ma"; desc = "5 mA"; };
            V_4_MA = 5 { name = "V 4 Ma"; desc = "4 mA"; };
            V_2_MA = 6 { name = "V 2 Ma"; desc = "2 mA"; };
            V_1_MA = 7 { name = "V 1 Ma"; desc = "1 mA"; };
        };

        field {
            name = "sdio1_cdata1_ds";
            desc = "Drive current of the SDIO1_CDATA1 pin";
            sw = rw;
            hw = r;
            encode = PADCTRL_REG71_sdio1_cdata1_ds_enum;
            reset = 0x6;
        } sdio1_cdata1_ds[6:4];
    } PADCTRL_REG71 @ 0x91C;

    reg {
        name = "Drive capability register for the SDIO1_CDATA2 pin";
        desc = "PADCTRL_REG72 is a drive capability register for the SDIO1_CDATA2 pin.

Data sheet 2.6.2 PADCTRL_REG72 (offset 0x120, printed page 2-221, `hi3516av100--Hi3516A-Hi3516D-Datasheet.txt` line 13518).";

        enum PADCTRL_REG72_sdio1_cdata2_sr_enum {
            FAST_EDGE = 0 { name = "Fast Edge"; desc = "fast edge"; };
            SLOW_EDGE = 1 { name = "Slow Edge"; desc = "slow edge"; };
        };

        field {
            name = "sdio1_cdata2_sr";
            desc = "Level conversion rate of the SDIO1_CDATA2 pin";
            sw = rw;
            hw = r;
            encode = PADCTRL_REG72_sdio1_cdata2_sr_enum;
            reset = 0x1;
        } sdio1_cdata2_sr[7:7];

        enum PADCTRL_REG72_sdio1_cdata2_ds_enum {
            V_12_MA = 0 { name = "V 12 Ma"; desc = "12 mA"; };
            V_11_MA = 1 { name = "V 11 Ma"; desc = "11 mA"; };
            V_9_MA = 2 { name = "V 9 Ma"; desc = "9 mA"; };
            V_8_MA = 3 { name = "V 8 Ma"; desc = "8 mA"; };
            V_5_MA = 4 { name = "V 5 Ma"; desc = "5 mA"; };
            V_4_MA = 5 { name = "V 4 Ma"; desc = "4 mA"; };
            V_2_MA = 6 { name = "V 2 Ma"; desc = "2 mA"; };
            V_1_MA = 7 { name = "V 1 Ma"; desc = "1 mA"; };
        };

        field {
            name = "sdio1_cdata2_ds";
            desc = "Drive current of the SDIO1_CDATA2 pin";
            sw = rw;
            hw = r;
            encode = PADCTRL_REG72_sdio1_cdata2_ds_enum;
            reset = 0x6;
        } sdio1_cdata2_ds[6:4];
    } PADCTRL_REG72 @ 0x920;

    reg {
        name = "Drive capability register for the SDIO1_CDATA3 pin";
        desc = "PADCTRL_REG73 is a drive capability register for the SDIO1_CDATA3 pin.

Data sheet 2.6.2 PADCTRL_REG73 (offset 0x124, printed page 2-222, `hi3516av100--Hi3516A-Hi3516D-Datasheet.txt` line 13562).";

        enum PADCTRL_REG73_sdio1_cdata3_sr_enum {
            FAST_EDGE = 0 { name = "Fast Edge"; desc = "fast edge"; };
            SLOW_EDGE = 1 { name = "Slow Edge"; desc = "slow edge"; };
        };

        field {
            name = "sdio1_cdata3_sr";
            desc = "Level conversion rate of the SDIO1_CDATA3 pin";
            sw = rw;
            hw = r;
            encode = PADCTRL_REG73_sdio1_cdata3_sr_enum;
            reset = 0x1;
        } sdio1_cdata3_sr[7:7];

        enum PADCTRL_REG73_sdio1_cdata3_ds_enum {
            V_12_MA = 0 { name = "V 12 Ma"; desc = "12 mA"; };
            V_11_MA = 1 { name = "V 11 Ma"; desc = "11 mA"; };
            V_9_MA = 2 { name = "V 9 Ma"; desc = "9 mA"; };
            V_8_MA = 3 { name = "V 8 Ma"; desc = "8 mA"; };
            V_5_MA = 4 { name = "V 5 Ma"; desc = "5 mA"; };
            V_4_MA = 5 { name = "V 4 Ma"; desc = "4 mA"; };
            V_2_MA = 6 { name = "V 2 Ma"; desc = "2 mA"; };
            V_1_MA = 7 { name = "V 1 Ma"; desc = "1 mA"; };
        };

        field {
            name = "sdio1_cdata3_ds";
            desc = "Drive current of the SDIO1_CDATA3 pin";
            sw = rw;
            hw = r;
            encode = PADCTRL_REG73_sdio1_cdata3_ds_enum;
            reset = 0x6;
        } sdio1_cdata3_ds[6:4];
    } PADCTRL_REG73 @ 0x924;

    reg {
        name = "Drive capability register for the SFC_SIO_IO0 pin";
        desc = "PADCTRL_REG74 is a drive capability register for the SFC_SIO_IO0 pin.

Data sheet 2.6.2 PADCTRL_REG74 (offset 0x128, printed page 2-223, `hi3516av100--Hi3516A-Hi3516D-Datasheet.txt` line 13606).";

        enum PADCTRL_REG74_sfc_sio_io0_sr_enum {
            FAST_EDGE = 0 { name = "Fast Edge"; desc = "fast edge"; };
            SLOW_EDGE = 1 { name = "Slow Edge"; desc = "slow edge"; };
        };

        field {
            name = "sfc_sio_io0_sr";
            desc = "Level conversion rate of the SFC_SIO_IO0 pin";
            sw = rw;
            hw = r;
            encode = PADCTRL_REG74_sfc_sio_io0_sr_enum;
            reset = 0x1;
        } sfc_sio_io0_sr[7:7];

        enum PADCTRL_REG74_sfc_sio_io0_ds_enum {
            V_4_MA = 0 { name = "V 4 Ma"; desc = "4 mA"; };
            V_3_MA = 1 { name = "V 3 Ma"; desc = "3 mA"; };
            V_2_MA = 2 { name = "V 2 Ma"; desc = "2 mA"; };
            V_1_MA = 3 { name = "V 1 Ma"; desc = "1 mA"; };
        };

        field {
            name = "sfc_sio_io0_ds";
            desc = "Drive current of the SFC_SIO_IO0 pin";
            sw = rw;
            hw = r;
            encode = PADCTRL_REG74_sfc_sio_io0_ds_enum;
            reset = 0x2;
        } sfc_sio_io0_ds[5:4];
    } PADCTRL_REG74 @ 0x928;

    reg {
        name = "Drive capability register for the SFC_WP_IO2 pin";
        desc = "PADCTRL_REG75 is a drive capability register for the SFC_WP_IO2 pin.

Data sheet 2.6.2 PADCTRL_REG75 (offset 0x12C, printed page 2-223, `hi3516av100--Hi3516A-Hi3516D-Datasheet.txt` line 13641).";

        enum PADCTRL_REG75_sfc_wp_io2_sr_enum {
            FAST_EDGE = 0 { name = "Fast Edge"; desc = "fast edge"; };
            SLOW_EDGE = 1 { name = "Slow Edge"; desc = "slow edge"; };
        };

        field {
            name = "sfc_wp_io2_sr";
            desc = "Level conversion rate of the SFC_WP_IO2 pin (the data sheet names this field `sfc_wp_io1_sr`, which does not match the pin of this register: corrected here, low confidence that the typo is only in the name).";
            sw = rw;
            hw = r;
            encode = PADCTRL_REG75_sfc_wp_io2_sr_enum;
            reset = 0x1;
        } sfc_wp_io2_sr[7:7];

        enum PADCTRL_REG75_sfc_wp_io2_ds_enum {
            V_4_MA = 0 { name = "V 4 Ma"; desc = "4 mA"; };
            V_3_MA = 1 { name = "V 3 Ma"; desc = "3 mA"; };
            V_2_MA = 2 { name = "V 2 Ma"; desc = "2 mA"; };
            V_1_MA = 3 { name = "V 1 Ma"; desc = "1 mA"; };
        };

        field {
            name = "sfc_wp_io2_ds";
            desc = "Drive current of the SFC_WP_IO2 pin (the data sheet names this field `sfc_wp_io1_ds`, which does not match the pin of this register: corrected here, low confidence that the typo is only in the name).";
            sw = rw;
            hw = r;
            encode = PADCTRL_REG75_sfc_wp_io2_ds_enum;
            reset = 0x2;
        } sfc_wp_io2_ds[5:4];
    } PADCTRL_REG75 @ 0x92C;

    reg {
        name = "Drive capability register for the SFC_CLK pin";
        desc = "PADCTRL_REG76 is a drive capability register for the SFC_CLK pin.

Data sheet 2.6.2 PADCTRL_REG76 (offset 0x130, printed page 2-224, `hi3516av100--Hi3516A-Hi3516D-Datasheet.txt` line 13683).";

        enum PADCTRL_REG76_sfc_clk_sr_enum {
            FAST_EDGE = 0 { name = "Fast Edge"; desc = "fast edge"; };
            SLOW_EDGE = 1 { name = "Slow Edge"; desc = "slow edge"; };
        };

        field {
            name = "sfc_clk_sr";
            desc = "Level conversion rate of the SFC_CLK pin";
            sw = rw;
            hw = r;
            encode = PADCTRL_REG76_sfc_clk_sr_enum;
            reset = 0x1;
        } sfc_clk_sr[7:7];

        enum PADCTRL_REG76_sfc_clk_ds_enum {
            V_4_MA = 0 { name = "V 4 Ma"; desc = "4 mA"; };
            V_3_MA = 1 { name = "V 3 Ma"; desc = "3 mA"; };
            V_2_MA = 2 { name = "V 2 Ma"; desc = "2 mA"; };
            V_1_MA = 3 { name = "V 1 Ma"; desc = "1 mA"; };
        };

        field {
            name = "sfc_clk_ds";
            desc = "Drive current of the SFC_CLK pin";
            sw = rw;
            hw = r;
            encode = PADCTRL_REG76_sfc_clk_ds_enum;
            reset = 0x1;
        } sfc_clk_ds[5:4];
    } PADCTRL_REG76 @ 0x930;

    reg {
        name = "Drive capability register for the SFC_SOI_IO1 pin";
        desc = "PADCTRL_REG77 is a drive capability register for the SFC_SOI_IO1 pin.

Data sheet 2.6.2 PADCTRL_REG77 (offset 0x134, printed page 2-225, `hi3516av100--Hi3516A-Hi3516D-Datasheet.txt` line 13727).";

        enum PADCTRL_REG77_sfc_soi_io1_sr_enum {
            FAST_EDGE = 0 { name = "Fast Edge"; desc = "fast edge"; };
            SLOW_EDGE = 1 { name = "Slow Edge"; desc = "slow edge"; };
        };

        field {
            name = "sfc_soi_io1_sr";
            desc = "Level conversion rate of the SFC_SOI_IO1 pin";
            sw = rw;
            hw = r;
            encode = PADCTRL_REG77_sfc_soi_io1_sr_enum;
            reset = 0x1;
        } sfc_soi_io1_sr[7:7];

        enum PADCTRL_REG77_sfc_soi_io1_ds_enum {
            V_4_MA = 0 { name = "V 4 Ma"; desc = "4 mA"; };
            V_3_MA = 1 { name = "V 3 Ma"; desc = "3 mA"; };
            V_2_MA = 2 { name = "V 2 Ma"; desc = "2 mA"; };
            V_1_MA = 3 { name = "V 1 Ma"; desc = "1 mA"; };
        };

        field {
            name = "sfc_soi_io1_ds";
            desc = "Drive current of the SFC_SOI_IO1 pin";
            sw = rw;
            hw = r;
            encode = PADCTRL_REG77_sfc_soi_io1_ds_enum;
            reset = 0x2;
        } sfc_soi_io1_ds[5:4];
    } PADCTRL_REG77 @ 0x934;

    reg {
        name = "Drive capability register for the SFC_HOLD_IO3 pin";
        desc = "PADCTRL_REG78 is a drive capability register for the SFC_HOLD_IO3 pin.

Data sheet 2.6.2 PADCTRL_REG78 (offset 0x138, printed page 2-226, `hi3516av100--Hi3516A-Hi3516D-Datasheet.txt` line 13768).";

        enum PADCTRL_REG78_sfc_hold_io3_sr_enum {
            FAST_EDGE = 0 { name = "Fast Edge"; desc = "fast edge"; };
            SLOW_EDGE = 1 { name = "Slow Edge"; desc = "slow edge"; };
        };

        field {
            name = "sfc_hold_io3_sr";
            desc = "Level conversion rate of the SFC_HOLD_IO3 pin";
            sw = rw;
            hw = r;
            encode = PADCTRL_REG78_sfc_hold_io3_sr_enum;
            reset = 0x1;
        } sfc_hold_io3_sr[7:7];

        enum PADCTRL_REG78_sfc_hold_io3_ds_enum {
            V_4_MA = 0 { name = "V 4 Ma"; desc = "4 mA"; };
            V_3_MA = 1 { name = "V 3 Ma"; desc = "3 mA"; };
            V_2_MA = 2 { name = "V 2 Ma"; desc = "2 mA"; };
            V_1_MA = 3 { name = "V 1 Ma"; desc = "1 mA"; };
        };

        field {
            name = "sfc_hold_io3_ds";
            desc = "Drive current of the SFC_HOLD_IO3 pin";
            sw = rw;
            hw = r;
            encode = PADCTRL_REG78_sfc_hold_io3_ds_enum;
            reset = 0x2;
        } sfc_hold_io3_ds[5:4];
    } PADCTRL_REG78 @ 0x938;

    reg {
        name = "Drive capability register for the SFC_CSN1 pin";
        desc = "PADCTRL_REG79 is a drive capability register for the SFC_CSN1 pin.

Data sheet 2.6.2 PADCTRL_REG79 (offset 0x13C, printed page 2-226, `hi3516av100--Hi3516A-Hi3516D-Datasheet.txt` line 13803).";

        enum PADCTRL_REG79_sfc_csn1_sr_enum {
            FAST_EDGE = 0 { name = "Fast Edge"; desc = "fast edge"; };
            SLOW_EDGE = 1 { name = "Slow Edge"; desc = "slow edge"; };
        };

        field {
            name = "sfc_csn1_sr";
            desc = "Level conversion rate of the SFC_CSN1 pin";
            sw = rw;
            hw = r;
            encode = PADCTRL_REG79_sfc_csn1_sr_enum;
            reset = 0x1;
        } sfc_csn1_sr[7:7];

        enum PADCTRL_REG79_sfc_csn1_ds_enum {
            V_4_MA = 0 { name = "V 4 Ma"; desc = "4 mA"; };
            V_3_MA = 1 { name = "V 3 Ma"; desc = "3 mA"; };
            V_2_MA = 2 { name = "V 2 Ma"; desc = "2 mA"; };
            V_1_MA = 3 { name = "V 1 Ma"; desc = "1 mA"; };
        };

        field {
            name = "sfc_csn1_ds";
            desc = "Drive current of the SFC_CSN1 pin";
            sw = rw;
            hw = r;
            encode = PADCTRL_REG79_sfc_csn1_ds_enum;
            reset = 0x2;
        } sfc_csn1_ds[5:4];
    } PADCTRL_REG79 @ 0x93C;

    reg {
        name = "Drive capability register for the NF_DQ0 pin";
        desc = "PADCTRL_REG80 is a drive capability register for the NF_DQ0 pin.

Data sheet 2.6.2 PADCTRL_REG80 (offset 0x140, printed page 2-227, `hi3516av100--Hi3516A-Hi3516D-Datasheet.txt` line 13845).";

        enum PADCTRL_REG80_nf_dq0_sr_enum {
            FAST_EDGE = 0 { name = "Fast Edge"; desc = "fast edge"; };
            SLOW_EDGE = 1 { name = "Slow Edge"; desc = "slow edge"; };
        };

        field {
            name = "nf_dq0_sr";
            desc = "Level conversion rate of the NF_DQ0 pin";
            sw = rw;
            hw = r;
            encode = PADCTRL_REG80_nf_dq0_sr_enum;
            reset = 0x1;
        } nf_dq0_sr[7:7];

        enum PADCTRL_REG80_nf_dq0_ds_enum {
            V_4_MA = 0 { name = "V 4 Ma"; desc = "4 mA"; };
            V_3_MA = 1 { name = "V 3 Ma"; desc = "3 mA"; };
            V_2_MA = 2 { name = "V 2 Ma"; desc = "2 mA"; };
            V_1_MA = 3 { name = "V 1 Ma"; desc = "1 mA"; };
        };

        field {
            name = "nf_dq0_ds";
            desc = "Drive current of the NF_DQ0 pin";
            sw = rw;
            hw = r;
            encode = PADCTRL_REG80_nf_dq0_ds_enum;
            reset = 0x2;
        } nf_dq0_ds[5:4];
    } PADCTRL_REG80 @ 0x940;

    reg {
        name = "Drive capability register for the NF_DQ1 pin";
        desc = "PADCTRL_REG81 is a drive capability register for the NF_DQ1 pin.

Data sheet 2.6.2 PADCTRL_REG81 (offset 0x144, printed page 2-228, `hi3516av100--Hi3516A-Hi3516D-Datasheet.txt` line 13889).";

        enum PADCTRL_REG81_nf_dq1_sr_enum {
            FAST_EDGE = 0 { name = "Fast Edge"; desc = "fast edge"; };
            SLOW_EDGE = 1 { name = "Slow Edge"; desc = "slow edge"; };
        };

        field {
            name = "nf_dq1_sr";
            desc = "Level conversion rate of the NF_DQ1 pin";
            sw = rw;
            hw = r;
            encode = PADCTRL_REG81_nf_dq1_sr_enum;
            reset = 0x1;
        } nf_dq1_sr[7:7];

        enum PADCTRL_REG81_nf_dq1_ds_enum {
            V_4_MA = 0 { name = "V 4 Ma"; desc = "4 mA"; };
            V_3_MA = 1 { name = "V 3 Ma"; desc = "3 mA"; };
            V_2_MA = 2 { name = "V 2 Ma"; desc = "2 mA"; };
            V_1_MA = 3 { name = "V 1 Ma"; desc = "1 mA"; };
        };

        field {
            name = "nf_dq1_ds";
            desc = "Drive current of the NF_DQ1 pin";
            sw = rw;
            hw = r;
            encode = PADCTRL_REG81_nf_dq1_ds_enum;
            reset = 0x2;
        } nf_dq1_ds[5:4];
    } PADCTRL_REG81 @ 0x944;

    reg {
        name = "Drive capability register for the NF_DQ2 pin";
        desc = "PADCTRL_REG82 is a drive capability register for the NF_DQ2 pin.

Data sheet 2.6.2 PADCTRL_REG82 (offset 0x148, printed page 2-228, `hi3516av100--Hi3516A-Hi3516D-Datasheet.txt` line 13923).";

        enum PADCTRL_REG82_nf_dq2_sr_enum {
            FAST_EDGE = 0 { name = "Fast Edge"; desc = "fast edge"; };
            SLOW_EDGE = 1 { name = "Slow Edge"; desc = "slow edge"; };
        };

        field {
            name = "nf_dq2_sr";
            desc = "Level conversion rate of the NF_DQ2 pin";
            sw = rw;
            hw = r;
            encode = PADCTRL_REG82_nf_dq2_sr_enum;
            reset = 0x1;
        } nf_dq2_sr[7:7];

        enum PADCTRL_REG82_nf_dq2_ds_enum {
            V_4_MA = 0 { name = "V 4 Ma"; desc = "4 mA"; };
            V_3_MA = 1 { name = "V 3 Ma"; desc = "3 mA"; };
            V_2_MA = 2 { name = "V 2 Ma"; desc = "2 mA"; };
            V_1_MA = 3 { name = "V 1 Ma"; desc = "1 mA"; };
        };

        field {
            name = "nf_dq2_ds";
            desc = "Drive current of the NF_DQ2 pin";
            sw = rw;
            hw = r;
            encode = PADCTRL_REG82_nf_dq2_ds_enum;
            reset = 0x2;
        } nf_dq2_ds[5:4];
    } PADCTRL_REG82 @ 0x948;

    reg {
        name = "Drive capability register for the NF_DQ3 pin";
        desc = "PADCTRL_REG83 is a drive capability register for the NF_DQ3 pin.

Data sheet 2.6.2 PADCTRL_REG83 (offset 0x14C, printed page 2-229, `hi3516av100--Hi3516A-Hi3516D-Datasheet.txt` line 13965).";

        enum PADCTRL_REG83_nf_dq3_sr_enum {
            FAST_EDGE = 0 { name = "Fast Edge"; desc = "fast edge"; };
            SLOW_EDGE = 1 { name = "Slow Edge"; desc = "slow edge"; };
        };

        field {
            name = "nf_dq3_sr";
            desc = "Level conversion rate of the NF_DQ3 pin";
            sw = rw;
            hw = r;
            encode = PADCTRL_REG83_nf_dq3_sr_enum;
            reset = 0x1;
        } nf_dq3_sr[7:7];

        enum PADCTRL_REG83_nf_dq3_ds_enum {
            V_4_MA = 0 { name = "V 4 Ma"; desc = "4 mA"; };
            V_3_MA = 1 { name = "V 3 Ma"; desc = "3 mA"; };
            V_2_MA = 2 { name = "V 2 Ma"; desc = "2 mA"; };
            V_1_MA = 3 { name = "V 1 Ma"; desc = "1 mA"; };
        };

        field {
            name = "nf_dq3_ds";
            desc = "Drive current of the NF_DQ3 pin";
            sw = rw;
            hw = r;
            encode = PADCTRL_REG83_nf_dq3_ds_enum;
            reset = 0x2;
        } nf_dq3_ds[5:4];
    } PADCTRL_REG83 @ 0x94C;

    reg {
        name = "Drive capability register for the NF_DQ4 pin";
        desc = "PADCTRL_REG84 is a drive capability register for the NF_DQ4 pin.

Data sheet 2.6.2 PADCTRL_REG84 (offset 0x150, printed page 2-230, `hi3516av100--Hi3516A-Hi3516D-Datasheet.txt` line 14009).";

        enum PADCTRL_REG84_nf_dq4_sr_enum {
            FAST_EDGE = 0 { name = "Fast Edge"; desc = "fast edge"; };
            SLOW_EDGE = 1 { name = "Slow Edge"; desc = "slow edge"; };
        };

        field {
            name = "nf_dq4_sr";
            desc = "Level conversion rate of the NF_DQ4 pin";
            sw = rw;
            hw = r;
            encode = PADCTRL_REG84_nf_dq4_sr_enum;
            reset = 0x1;
        } nf_dq4_sr[7:7];

        enum PADCTRL_REG84_nf_dq4_ds_enum {
            V_4_MA = 0 { name = "V 4 Ma"; desc = "4 mA"; };
            V_3_MA = 1 { name = "V 3 Ma"; desc = "3 mA"; };
            V_2_MA = 2 { name = "V 2 Ma"; desc = "2 mA"; };
            V_1_MA = 3 { name = "V 1 Ma"; desc = "1 mA"; };
        };

        field {
            name = "nf_dq4_ds";
            desc = "Drive current of the NF_DQ4 pin";
            sw = rw;
            hw = r;
            encode = PADCTRL_REG84_nf_dq4_ds_enum;
            reset = 0x2;
        } nf_dq4_ds[5:4];
    } PADCTRL_REG84 @ 0x950;

    reg {
        name = "Drive capability register for the NF_DQ5 pin";
        desc = "PADCTRL_REG85 is a drive capability register for the NF_DQ5 pin.

Data sheet 2.6.2 PADCTRL_REG85 (offset 0x154, printed page 2-230, `hi3516av100--Hi3516A-Hi3516D-Datasheet.txt` line 14043).";

        enum PADCTRL_REG85_nf_dq5_sr_enum {
            FAST_EDGE = 0 { name = "Fast Edge"; desc = "fast edge"; };
            SLOW_EDGE = 1 { name = "Slow Edge"; desc = "slow edge"; };
        };

        field {
            name = "nf_dq5_sr";
            desc = "Level conversion rate of the NF_DQ5 pin";
            sw = rw;
            hw = r;
            encode = PADCTRL_REG85_nf_dq5_sr_enum;
            reset = 0x1;
        } nf_dq5_sr[7:7];

        enum PADCTRL_REG85_nf_dq5_ds_enum {
            V_4_MA = 0 { name = "V 4 Ma"; desc = "4 mA"; };
            V_3_MA = 1 { name = "V 3 Ma"; desc = "3 mA"; };
            V_2_MA = 2 { name = "V 2 Ma"; desc = "2 mA"; };
            V_1_MA = 3 { name = "V 1 Ma"; desc = "1 mA"; };
        };

        field {
            name = "nf_dq5_ds";
            desc = "Drive current of the NF_DQ5 pin";
            sw = rw;
            hw = r;
            encode = PADCTRL_REG85_nf_dq5_ds_enum;
            reset = 0x2;
        } nf_dq5_ds[5:4];
    } PADCTRL_REG85 @ 0x954;

    reg {
        name = "Drive capability register for the NF_DQ6 pin";
        desc = "PADCTRL_REG86 is a drive capability register for the NF_DQ6 pin.

Data sheet 2.6.2 PADCTRL_REG86 (offset 0x158, printed page 2-231, `hi3516av100--Hi3516A-Hi3516D-Datasheet.txt` line 14085).";

        enum PADCTRL_REG86_nf_dq6_sr_enum {
            FAST_EDGE = 0 { name = "Fast Edge"; desc = "fast edge"; };
            SLOW_EDGE = 1 { name = "Slow Edge"; desc = "slow edge"; };
        };

        field {
            name = "nf_dq6_sr";
            desc = "Level conversion rate of the NF_DQ6 pin";
            sw = rw;
            hw = r;
            encode = PADCTRL_REG86_nf_dq6_sr_enum;
            reset = 0x1;
        } nf_dq6_sr[7:7];

        enum PADCTRL_REG86_nf_dq6_ds_enum {
            V_4_MA = 0 { name = "V 4 Ma"; desc = "4 mA"; };
            V_3_MA = 1 { name = "V 3 Ma"; desc = "3 mA"; };
            V_2_MA = 2 { name = "V 2 Ma"; desc = "2 mA"; };
            V_1_MA = 3 { name = "V 1 Ma"; desc = "1 mA"; };
        };

        field {
            name = "nf_dq6_ds";
            desc = "Drive current of the NF_DQ6 pin";
            sw = rw;
            hw = r;
            encode = PADCTRL_REG86_nf_dq6_ds_enum;
            reset = 0x2;
        } nf_dq6_ds[5:4];
    } PADCTRL_REG86 @ 0x958;

    reg {
        name = "Drive capability register for the NF_DQ7 pin";
        desc = "PADCTRL_REG87 is a drive capability register for the NF_DQ7 pin.

Data sheet 2.6.2 PADCTRL_REG87 (offset 0x15C, printed page 2-232, `hi3516av100--Hi3516A-Hi3516D-Datasheet.txt` line 14129).";

        enum PADCTRL_REG87_nf_dq7_sr_enum {
            FAST_EDGE = 0 { name = "Fast Edge"; desc = "fast edge"; };
            SLOW_EDGE = 1 { name = "Slow Edge"; desc = "slow edge"; };
        };

        field {
            name = "nf_dq7_sr";
            desc = "Level conversion rate of the NF_DQ7 pin";
            sw = rw;
            hw = r;
            encode = PADCTRL_REG87_nf_dq7_sr_enum;
            reset = 0x1;
        } nf_dq7_sr[7:7];

        enum PADCTRL_REG87_nf_dq7_ds_enum {
            V_4_MA = 0 { name = "V 4 Ma"; desc = "4 mA"; };
            V_3_MA = 1 { name = "V 3 Ma"; desc = "3 mA"; };
            V_2_MA = 2 { name = "V 2 Ma"; desc = "2 mA"; };
            V_1_MA = 3 { name = "V 1 Ma"; desc = "1 mA"; };
        };

        field {
            name = "nf_dq7_ds";
            desc = "Drive current of the NF_DQ7 pin";
            sw = rw;
            hw = r;
            encode = PADCTRL_REG87_nf_dq7_ds_enum;
            reset = 0x2;
        } nf_dq7_ds[5:4];
    } PADCTRL_REG87 @ 0x95C;

    reg {
        name = "Drive capability register for the NF_RDY0 pin";
        desc = "PADCTRL_REG88 is a drive capability register for the NF_RDY0 pin.

Data sheet 2.6.2 PADCTRL_REG88 (offset 0x160, printed page 2-233, `hi3516av100--Hi3516A-Hi3516D-Datasheet.txt` line 14169).";

        enum PADCTRL_REG88_nf_rdy0_sr_enum {
            FAST_EDGE = 0 { name = "Fast Edge"; desc = "fast edge"; };
            SLOW_EDGE = 1 { name = "Slow Edge"; desc = "slow edge"; };
        };

        field {
            name = "nf_rdy0_sr";
            desc = "Level conversion rate of the NF_RDY0 pin";
            sw = rw;
            hw = r;
            encode = PADCTRL_REG88_nf_rdy0_sr_enum;
            reset = 0x1;
        } nf_rdy0_sr[7:7];

        enum PADCTRL_REG88_nf_rdy0_ds_enum {
            V_4_MA = 0 { name = "V 4 Ma"; desc = "4 mA"; };
            V_3_MA = 1 { name = "V 3 Ma"; desc = "3 mA"; };
            V_2_MA = 2 { name = "V 2 Ma"; desc = "2 mA"; };
            V_1_MA = 3 { name = "V 1 Ma"; desc = "1 mA"; };
        };

        field {
            name = "nf_rdy0_ds";
            desc = "Drive current of the NF_RDY0 pin";
            sw = rw;
            hw = r;
            encode = PADCTRL_REG88_nf_rdy0_ds_enum;
            reset = 0x2;
        } nf_rdy0_ds[5:4];
    } PADCTRL_REG88 @ 0x960;

    reg {
        name = "Drive capability register for the NF_RDY1 pin";
        desc = "PADCTRL_REG89 is a drive capability register for the NF_RDY1 pin.

Data sheet 2.6.2 PADCTRL_REG89 (offset 0x164, printed page 2-233, `hi3516av100--Hi3516A-Hi3516D-Datasheet.txt` line 14204).";

        enum PADCTRL_REG89_nf_rdy1_sr_enum {
            FAST_EDGE = 0 { name = "Fast Edge"; desc = "fast edge"; };
            SLOW_EDGE = 1 { name = "Slow Edge"; desc = "slow edge"; };
        };

        field {
            name = "nf_rdy1_sr";
            desc = "Level conversion rate of the NF_RDY1 pin";
            sw = rw;
            hw = r;
            encode = PADCTRL_REG89_nf_rdy1_sr_enum;
            reset = 0x1;
        } nf_rdy1_sr[7:7];

        enum PADCTRL_REG89_nf_rdy1_ds_enum {
            V_4_MA = 0 { name = "V 4 Ma"; desc = "4 mA"; };
            V_3_MA = 1 { name = "V 3 Ma"; desc = "3 mA"; };
            V_2_MA = 2 { name = "V 2 Ma"; desc = "2 mA"; };
            V_1_MA = 3 { name = "V 1 Ma"; desc = "1 mA"; };
        };

        field {
            name = "nf_rdy1_ds";
            desc = "Drive current of the NF_RDY1 pin";
            sw = rw;
            hw = r;
            encode = PADCTRL_REG89_nf_rdy1_ds_enum;
            reset = 0x2;
        } nf_rdy1_ds[5:4];
    } PADCTRL_REG89 @ 0x964;

    reg {
        name = "Drive capability register for the NF_REN pin";
        desc = "PADCTRL_REG90 is a drive capability register for the NF_REN pin.

Data sheet 2.6.2 PADCTRL_REG90 (offset 0x168, printed page 2-234, `hi3516av100--Hi3516A-Hi3516D-Datasheet.txt` line 14246).";

        enum PADCTRL_REG90_nf_ren_sr_enum {
            FAST_EDGE = 0 { name = "Fast Edge"; desc = "fast edge"; };
            SLOW_EDGE = 1 { name = "Slow Edge"; desc = "slow edge"; };
        };

        field {
            name = "nf_ren_sr";
            desc = "Level conversion rate of the NF_REN pin";
            sw = rw;
            hw = r;
            encode = PADCTRL_REG90_nf_ren_sr_enum;
            reset = 0x1;
        } nf_ren_sr[7:7];

        enum PADCTRL_REG90_nf_ren_ds_enum {
            V_4_MA = 0 { name = "V 4 Ma"; desc = "4 mA"; };
            V_3_MA = 1 { name = "V 3 Ma"; desc = "3 mA"; };
            V_2_MA = 2 { name = "V 2 Ma"; desc = "2 mA"; };
            V_1_MA = 3 { name = "V 1 Ma"; desc = "1 mA"; };
        };

        field {
            name = "nf_ren_ds";
            desc = "Drive current of the NF_REN pin";
            sw = rw;
            hw = r;
            encode = PADCTRL_REG90_nf_ren_ds_enum;
            reset = 0x2;
        } nf_ren_ds[5:4];
    } PADCTRL_REG90 @ 0x968;

    reg {
        name = "Drive capability register for the NF_CSN0 pin";
        desc = "PADCTRL_REG91 is a drive capability register for the NF_CSN0 pin.

Data sheet 2.6.2 PADCTRL_REG91 (offset 0x16C, printed page 2-235, `hi3516av100--Hi3516A-Hi3516D-Datasheet.txt` line 14290).";

        enum PADCTRL_REG91_nf_csn0_sr_enum {
            FAST_EDGE = 0 { name = "Fast Edge"; desc = "fast edge"; };
            SLOW_EDGE = 1 { name = "Slow Edge"; desc = "slow edge"; };
        };

        field {
            name = "nf_csn0_sr";
            desc = "Level conversion rate of the NF_CSN0 pin";
            sw = rw;
            hw = r;
            encode = PADCTRL_REG91_nf_csn0_sr_enum;
            reset = 0x1;
        } nf_csn0_sr[7:7];

        enum PADCTRL_REG91_nf_csn0_ds_enum {
            V_4_MA = 0 { name = "V 4 Ma"; desc = "4 mA"; };
            V_3_MA = 1 { name = "V 3 Ma"; desc = "3 mA"; };
            V_2_MA = 2 { name = "V 2 Ma"; desc = "2 mA"; };
            V_1_MA = 3 { name = "V 1 Ma"; desc = "1 mA"; };
        };

        field {
            name = "nf_csn0_ds";
            desc = "Drive current of the NF_CSN0 pin";
            sw = rw;
            hw = r;
            encode = PADCTRL_REG91_nf_csn0_ds_enum;
            reset = 0x2;
        } nf_csn0_ds[5:4];
    } PADCTRL_REG91 @ 0x96C;

    reg {
        name = "Drive capability register for the NF_CSN1 pin";
        desc = "PADCTRL_REG92 is a drive capability register for the NF_CSN1 pin.

Data sheet 2.6.2 PADCTRL_REG92 (offset 0x170, printed page 2-236, `hi3516av100--Hi3516A-Hi3516D-Datasheet.txt` line 14331).";

        enum PADCTRL_REG92_nf_csn1_sr_enum {
            FAST_EDGE = 0 { name = "Fast Edge"; desc = "fast edge"; };
            SLOW_EDGE = 1 { name = "Slow Edge"; desc = "slow edge"; };
        };

        field {
            name = "nf_csn1_sr";
            desc = "Level conversion rate of the NF_CSN1 pin";
            sw = rw;
            hw = r;
            encode = PADCTRL_REG92_nf_csn1_sr_enum;
            reset = 0x1;
        } nf_csn1_sr[7:7];

        enum PADCTRL_REG92_nf_csn1_ds_enum {
            V_4_MA = 0 { name = "V 4 Ma"; desc = "4 mA"; };
            V_3_MA = 1 { name = "V 3 Ma"; desc = "3 mA"; };
            V_2_MA = 2 { name = "V 2 Ma"; desc = "2 mA"; };
            V_1_MA = 3 { name = "V 1 Ma"; desc = "1 mA"; };
        };

        field {
            name = "nf_csn1_ds";
            desc = "Drive current of the NF_CSN1 pin";
            sw = rw;
            hw = r;
            encode = PADCTRL_REG92_nf_csn1_ds_enum;
            reset = 0x2;
        } nf_csn1_ds[5:4];
    } PADCTRL_REG92 @ 0x970;

    reg {
        name = "Drive capability register for the NF_CLE pin";
        desc = "PADCTRL_REG93 is a drive capability register for the NF_CLE pin.

Data sheet 2.6.2 PADCTRL_REG93 (offset 0x174, printed page 2-236, `hi3516av100--Hi3516A-Hi3516D-Datasheet.txt` line 14366).";

        enum PADCTRL_REG93_nf_cle_sr_enum {
            FAST_EDGE = 0 { name = "Fast Edge"; desc = "fast edge"; };
            SLOW_EDGE = 1 { name = "Slow Edge"; desc = "slow edge"; };
        };

        field {
            name = "nf_cle_sr";
            desc = "Level conversion rate of the NF_CLE pin";
            sw = rw;
            hw = r;
            encode = PADCTRL_REG93_nf_cle_sr_enum;
            reset = 0x1;
        } nf_cle_sr[7:7];

        enum PADCTRL_REG93_nf_cle_ds_enum {
            V_4_MA = 0 { name = "V 4 Ma"; desc = "4 mA"; };
            V_3_MA = 1 { name = "V 3 Ma"; desc = "3 mA"; };
            V_2_MA = 2 { name = "V 2 Ma"; desc = "2 mA"; };
            V_1_MA = 3 { name = "V 1 Ma"; desc = "1 mA"; };
        };

        field {
            name = "nf_cle_ds";
            desc = "Drive current of the NF_CLE pin";
            sw = rw;
            hw = r;
            encode = PADCTRL_REG93_nf_cle_ds_enum;
            reset = 0x2;
        } nf_cle_ds[5:4];
    } PADCTRL_REG93 @ 0x974;

    reg {
        name = "Drive capability register for the NF_ALE pin";
        desc = "PADCTRL_REG94 is a drive capability register for the NF_ALE pin.

Data sheet 2.6.2 PADCTRL_REG94 (offset 0x178, printed page 2-237, `hi3516av100--Hi3516A-Hi3516D-Datasheet.txt` line 14408).";

        enum PADCTRL_REG94_nf_ale_sr_enum {
            FAST_EDGE = 0 { name = "Fast Edge"; desc = "fast edge"; };
            SLOW_EDGE = 1 { name = "Slow Edge"; desc = "slow edge"; };
        };

        field {
            name = "nf_ale_sr";
            desc = "Level conversion rate of the NF_ALE pin";
            sw = rw;
            hw = r;
            encode = PADCTRL_REG94_nf_ale_sr_enum;
            reset = 0x1;
        } nf_ale_sr[7:7];

        enum PADCTRL_REG94_nf_ale_ds_enum {
            V_4_MA = 0 { name = "V 4 Ma"; desc = "4 mA"; };
            V_3_MA = 1 { name = "V 3 Ma"; desc = "3 mA"; };
            V_2_MA = 2 { name = "V 2 Ma"; desc = "2 mA"; };
            V_1_MA = 3 { name = "V 1 Ma"; desc = "1 mA"; };
        };

        field {
            name = "nf_ale_ds";
            desc = "Drive current of the NF_ALE pin";
            sw = rw;
            hw = r;
            encode = PADCTRL_REG94_nf_ale_ds_enum;
            reset = 0x2;
        } nf_ale_ds[5:4];
    } PADCTRL_REG94 @ 0x978;

    reg {
        name = "Drive capability register for the NF_WEN pin";
        desc = "PADCTRL_REG95 is a drive capability register for the NF_WEN pin.

Data sheet 2.6.2 PADCTRL_REG95 (offset 0x17C, printed page 2-238, `hi3516av100--Hi3516A-Hi3516D-Datasheet.txt` line 14452).";

        enum PADCTRL_REG95_nf_wen_sr_enum {
            FAST_EDGE = 0 { name = "Fast Edge"; desc = "fast edge"; };
            SLOW_EDGE = 1 { name = "Slow Edge"; desc = "slow edge"; };
        };

        field {
            name = "nf_wen_sr";
            desc = "Level conversion rate of the NF_WEN pin";
            sw = rw;
            hw = r;
            encode = PADCTRL_REG95_nf_wen_sr_enum;
            reset = 0x1;
        } nf_wen_sr[7:7];

        enum PADCTRL_REG95_nf_wen_ds_enum {
            V_4_MA = 0 { name = "V 4 Ma"; desc = "4 mA"; };
            V_3_MA = 1 { name = "V 3 Ma"; desc = "3 mA"; };
            V_2_MA = 2 { name = "V 2 Ma"; desc = "2 mA"; };
            V_1_MA = 3 { name = "V 1 Ma"; desc = "1 mA"; };
        };

        field {
            name = "nf_wen_ds";
            desc = "Drive current of the NF_WEN pin";
            sw = rw;
            hw = r;
            encode = PADCTRL_REG95_nf_wen_ds_enum;
            reset = 0x2;
        } nf_wen_ds[5:4];
    } PADCTRL_REG95 @ 0x97C;

    reg {
        name = "Drive capability register for the PWM0 pin";
        desc = "PADCTRL_REG96 is a drive capability register for the PWM0 pin.

Data sheet 2.6.2 PADCTRL_REG96 (offset 0x180, printed page 2-238, `hi3516av100--Hi3516A-Hi3516D-Datasheet.txt` line 14486).";

        enum PADCTRL_REG96_pwm0_sr_enum {
            FAST_EDGE = 0 { name = "Fast Edge"; desc = "fast edge"; };
            SLOW_EDGE = 1 { name = "Slow Edge"; desc = "slow edge"; };
        };

        field {
            name = "pwm0_sr";
            desc = "Level conversion rate of the PWM0 pin";
            sw = rw;
            hw = r;
            encode = PADCTRL_REG96_pwm0_sr_enum;
            reset = 0x1;
        } pwm0_sr[7:7];

        enum PADCTRL_REG96_pwm0_ds_enum {
            V_4_MA = 0 { name = "V 4 Ma"; desc = "4 mA"; };
            V_3_MA = 1 { name = "V 3 Ma"; desc = "3 mA"; };
            V_2_MA = 2 { name = "V 2 Ma"; desc = "2 mA"; };
            V_1_MA = 3 { name = "V 1 Ma"; desc = "1 mA"; };
        };

        field {
            name = "pwm0_ds";
            desc = "Drive current of the PWM0 pin";
            sw = rw;
            hw = r;
            encode = PADCTRL_REG96_pwm0_ds_enum;
            reset = 0x2;
        } pwm0_ds[5:4];
    } PADCTRL_REG96 @ 0x980;

    reg {
        name = "Drive capability register for the PWM1 pin";
        desc = "PADCTRL_REG97 is a drive capability register for the PWM1 pin.

Data sheet 2.6.2 PADCTRL_REG97 (offset 0x184, printed page 2-239, `hi3516av100--Hi3516A-Hi3516D-Datasheet.txt` line 14528).";

        enum PADCTRL_REG97_pwm1_sr_enum {
            FAST_EDGE = 0 { name = "Fast Edge"; desc = "fast edge"; };
            SLOW_EDGE = 1 { name = "Slow Edge"; desc = "slow edge"; };
        };

        field {
            name = "pwm1_sr";
            desc = "Level conversion rate of the PWM1 pin";
            sw = rw;
            hw = r;
            encode = PADCTRL_REG97_pwm1_sr_enum;
            reset = 0x1;
        } pwm1_sr[7:7];

        enum PADCTRL_REG97_pwm1_ds_enum {
            V_4_MA = 0 { name = "V 4 Ma"; desc = "4 mA"; };
            V_3_MA = 1 { name = "V 3 Ma"; desc = "3 mA"; };
            V_2_MA = 2 { name = "V 2 Ma"; desc = "2 mA"; };
            V_1_MA = 3 { name = "V 1 Ma"; desc = "1 mA"; };
        };

        field {
            name = "pwm1_ds";
            desc = "Drive current of the PWM1 pin";
            sw = rw;
            hw = r;
            encode = PADCTRL_REG97_pwm1_ds_enum;
            reset = 0x2;
        } pwm1_ds[5:4];
    } PADCTRL_REG97 @ 0x984;

    reg {
        name = "Drive capability register for the PWM2 pin";
        desc = "PADCTRL_REG98 is a drive capability register for the PWM2 pin.

Data sheet 2.6.2 PADCTRL_REG98 (offset 0x188, printed page 2-240, `hi3516av100--Hi3516A-Hi3516D-Datasheet.txt` line 14572).";

        enum PADCTRL_REG98_pwm2_sr_enum {
            FAST_EDGE = 0 { name = "Fast Edge"; desc = "fast edge"; };
            SLOW_EDGE = 1 { name = "Slow Edge"; desc = "slow edge"; };
        };

        field {
            name = "pwm2_sr";
            desc = "Level conversion rate of the PWM2 pin";
            sw = rw;
            hw = r;
            encode = PADCTRL_REG98_pwm2_sr_enum;
            reset = 0x1;
        } pwm2_sr[7:7];

        enum PADCTRL_REG98_pwm2_ds_enum {
            V_4_MA = 0 { name = "V 4 Ma"; desc = "4 mA"; };
            V_3_MA = 1 { name = "V 3 Ma"; desc = "3 mA"; };
            V_2_MA = 2 { name = "V 2 Ma"; desc = "2 mA"; };
            V_1_MA = 3 { name = "V 1 Ma"; desc = "1 mA"; };
        };

        field {
            name = "pwm2_ds";
            desc = "Drive current of the PWM2 pin";
            sw = rw;
            hw = r;
            encode = PADCTRL_REG98_pwm2_ds_enum;
            reset = 0x2;
        } pwm2_ds[5:4];
    } PADCTRL_REG98 @ 0x988;

    reg {
        name = "Drive capability register for the PWM3 pin";
        desc = "PADCTRL_REG99 is a drive capability register for the PWM3 pin.

Data sheet 2.6.2 PADCTRL_REG99 (offset 0x18C, printed page 2-240, `hi3516av100--Hi3516A-Hi3516D-Datasheet.txt` line 14606).";

        enum PADCTRL_REG99_pwm3_sr_enum {
            FAST_EDGE = 0 { name = "Fast Edge"; desc = "fast edge"; };
            SLOW_EDGE = 1 { name = "Slow Edge"; desc = "slow edge"; };
        };

        field {
            name = "pwm3_sr";
            desc = "Level conversion rate of the PWM3 pin";
            sw = rw;
            hw = r;
            encode = PADCTRL_REG99_pwm3_sr_enum;
            reset = 0x1;
        } pwm3_sr[7:7];

        enum PADCTRL_REG99_pwm3_ds_enum {
            V_4_MA = 0 { name = "V 4 Ma"; desc = "4 mA"; };
            V_3_MA = 1 { name = "V 3 Ma"; desc = "3 mA"; };
            V_2_MA = 2 { name = "V 2 Ma"; desc = "2 mA"; };
            V_1_MA = 3 { name = "V 1 Ma"; desc = "1 mA"; };
        };

        field {
            name = "pwm3_ds";
            desc = "Drive current of the PWM3 pin";
            sw = rw;
            hw = r;
            encode = PADCTRL_REG99_pwm3_ds_enum;
            reset = 0x2;
        } pwm3_ds[5:4];
    } PADCTRL_REG99 @ 0x98C;

    reg {
        name = "Drive capability register for the SAR_ADC_CH0 pin";
        desc = "PADCTRL_REG100 is a drive capability register for the SAR_ADC_CH0 pin.

Data sheet 2.6.2 PADCTRL_REG100 (offset 0x190, printed page 2-241, `hi3516av100--Hi3516A-Hi3516D-Datasheet.txt` line 14648).";

        enum PADCTRL_REG100_sar_adc_ch0_st_enum {
            NO_SCHMITT_INPUT = 0 { name = "No Schmitt Input"; desc = "no Schmitt input"; };
            SCHMITT_INPUT = 1 { name = "Schmitt Input"; desc = "Schmitt input"; };
        };

        field {
            name = "sar_adc_ch0_st";
            desc = "Input Schmitt control for the SAR_ADC_CH0 pin";
            sw = rw;
            hw = r;
            encode = PADCTRL_REG100_sar_adc_ch0_st_enum;
            reset = 0x1;
        } sar_adc_ch0_st[10:10];

        enum PADCTRL_REG100_sar_adc_ch0_pd_enum {
            NO_PULL_DOWN = 0 { name = "No Pull Down"; desc = "no pull-down"; };
            PULL_DOWN = 1 { name = "Pull Down"; desc = "pull-down"; };
        };

        field {
            name = "sar_adc_ch0_pd";
            desc = "Input pull-down control for the SAR_ADC_CH0 pin";
            sw = rw;
            hw = r;
            encode = PADCTRL_REG100_sar_adc_ch0_pd_enum;
            reset = 0x0;
        } sar_adc_ch0_pd[9:9];

        enum PADCTRL_REG100_sar_adc_ch0_pu_enum {
            NO_PULL_UP = 0 { name = "No Pull Up"; desc = "no pull-up"; };
            PULL_UP = 1 { name = "Pull Up"; desc = "pull-up"; };
        };

        field {
            name = "sar_adc_ch0_pu";
            desc = "Input pull-up control for the SAR_ADC_CH0 pin";
            sw = rw;
            hw = r;
            encode = PADCTRL_REG100_sar_adc_ch0_pu_enum;
            reset = 0x0;
        } sar_adc_ch0_pu[8:8];

        enum PADCTRL_REG100_sar_adc_ch0_sl_enum {
            SLOW_EDGE = 0 { name = "Slow Edge"; desc = "slow edge"; };
            FAST_EDGE = 1 { name = "Fast Edge"; desc = "fast edge"; };
        };

        field {
            name = "sar_adc_ch0_sl";
            desc = "Level conversion rate of the SAR_ADC_CH0 pin";
            sw = rw;
            hw = r;
            encode = PADCTRL_REG100_sar_adc_ch0_sl_enum;
            reset = 0x0;
        } sar_adc_ch0_sl[7:7];

        enum PADCTRL_REG100_sar_adc_ch0_ds_enum {
            V_1_9_MA = 0 { name = "V 1 9 Ma"; desc = "1.9 mA"; };
            V_3_7_MA = 1 { name = "V 3 7 Ma"; desc = "3.7 mA"; };
            V_5_7_MA = 2 { name = "V 5 7 Ma"; desc = "5.7 mA"; };
            V_7_5_MA = 3 { name = "V 7 5 Ma"; desc = "7.5 mA"; };
        };

        field {
            name = "sar_adc_ch0_ds";
            desc = "Drive current of the SAR_ADC_CH0 pin";
            sw = rw;
            hw = r;
            encode = PADCTRL_REG100_sar_adc_ch0_ds_enum;
            reset = 0x0;
        } sar_adc_ch0_ds[5:4];
    } PADCTRL_REG100 @ 0x990;

    reg {
        name = "Drive capability register for the SAR_ADC_CH1 pin";
        desc = "PADCTRL_REG101 is a drive capability register for the SAR_ADC_CH1 pin.

Data sheet 2.6.2 PADCTRL_REG101 (offset 0x194, printed page 2-242, `hi3516av100--Hi3516A-Hi3516D-Datasheet.txt` line 14703).";

        enum PADCTRL_REG101_sar_adc_ch1_st_enum {
            NO_SCHMITT_INPUT = 0 { name = "No Schmitt Input"; desc = "no Schmitt input"; };
            SCHMITT_INPUT = 1 { name = "Schmitt Input"; desc = "Schmitt input"; };
        };

        field {
            name = "sar_adc_ch1_st";
            desc = "Input Schmitt control for the SAR_ADC_CH1 pin";
            sw = rw;
            hw = r;
            encode = PADCTRL_REG101_sar_adc_ch1_st_enum;
            reset = 0x1;
        } sar_adc_ch1_st[10:10];

        enum PADCTRL_REG101_sar_adc_ch1_pd_enum {
            NO_PULL_DOWN = 0 { name = "No Pull Down"; desc = "no pull-down"; };
            PULL_DOWN = 1 { name = "Pull Down"; desc = "pull-down"; };
        };

        field {
            name = "sar_adc_ch1_pd";
            desc = "Input pull-down control for the SAR_ADC_CH1 pin";
            sw = rw;
            hw = r;
            encode = PADCTRL_REG101_sar_adc_ch1_pd_enum;
            reset = 0x0;
        } sar_adc_ch1_pd[9:9];

        enum PADCTRL_REG101_sar_adc_ch1_pu_enum {
            NO_PULL_UP = 0 { name = "No Pull Up"; desc = "no pull-up"; };
            PULL_UP = 1 { name = "Pull Up"; desc = "pull-up"; };
        };

        field {
            name = "sar_adc_ch1_pu";
            desc = "Input pull-up control for the SAR_ADC_CH1 pin";
            sw = rw;
            hw = r;
            encode = PADCTRL_REG101_sar_adc_ch1_pu_enum;
            reset = 0x0;
        } sar_adc_ch1_pu[8:8];

        enum PADCTRL_REG101_sar_adc_ch1_sl_enum {
            SLOW_EDGE = 0 { name = "Slow Edge"; desc = "slow edge"; };
            FAST_EDGE = 1 { name = "Fast Edge"; desc = "fast edge"; };
        };

        field {
            name = "sar_adc_ch1_sl";
            desc = "Level conversion rate of the SAR_ADC_CH1 pin";
            sw = rw;
            hw = r;
            encode = PADCTRL_REG101_sar_adc_ch1_sl_enum;
            reset = 0x0;
        } sar_adc_ch1_sl[7:7];

        enum PADCTRL_REG101_sar_adc_ch1_ds_enum {
            V_1_9_MA = 0 { name = "V 1 9 Ma"; desc = "1.9 mA"; };
            V_3_7_MA = 1 { name = "V 3 7 Ma"; desc = "3.7 mA"; };
            V_5_7_MA = 2 { name = "V 5 7 Ma"; desc = "5.7 mA"; };
            V_7_5_MA = 3 { name = "V 7 5 Ma"; desc = "7.5 mA"; };
        };

        field {
            name = "sar_adc_ch1_ds";
            desc = "Drive current of the SAR_ADC_CH1 pin";
            sw = rw;
            hw = r;
            encode = PADCTRL_REG101_sar_adc_ch1_ds_enum;
            reset = 0x0;
        } sar_adc_ch1_ds[5:4];
    } PADCTRL_REG101 @ 0x994;

    reg {
        name = "Drive capability register for the EPHY_CLK pin";
        desc = "PADCTRL_REG102 is a drive capability register for the EPHY_CLK pin.

Data sheet 2.6.2 PADCTRL_REG102 (offset 0x198, printed page 2-243, `hi3516av100--Hi3516A-Hi3516D-Datasheet.txt` line 14758).";

        enum PADCTRL_REG102_ephy_clk_sr_enum {
            FAST_EDGE = 0 { name = "Fast Edge"; desc = "fast edge"; };
            SLOW_EDGE = 1 { name = "Slow Edge"; desc = "slow edge"; };
        };

        field {
            name = "ephy_clk_sr";
            desc = "Level conversion rate of the EPHY_CLK pin";
            sw = rw;
            hw = r;
            encode = PADCTRL_REG102_ephy_clk_sr_enum;
            reset = 0x1;
        } ephy_clk_sr[7:7];

        enum PADCTRL_REG102_ephy_clk_ds_enum {
            V_12_MA = 0 { name = "V 12 Ma"; desc = "12 mA"; };
            V_11_MA = 1 { name = "V 11 Ma"; desc = "11 mA"; };
            V_9_MA = 2 { name = "V 9 Ma"; desc = "9 mA"; };
            V_8_MA = 3 { name = "V 8 Ma"; desc = "8 mA"; };
            V_5_MA = 4 { name = "V 5 Ma"; desc = "5 mA"; };
            V_4_MA = 5 { name = "V 4 Ma"; desc = "4 mA"; };
            V_2_MA = 6 { name = "V 2 Ma"; desc = "2 mA"; };
            V_1_MA = 7 { name = "V 1 Ma"; desc = "1 mA"; };
        };

        field {
            name = "ephy_clk_ds";
            desc = "Drive current of the EPHY_CLK pin";
            sw = rw;
            hw = r;
            encode = PADCTRL_REG102_ephy_clk_ds_enum;
            reset = 0x5;
        } ephy_clk_ds[6:4];
    } PADCTRL_REG102 @ 0x998;

    reg {
        name = "Drive capability register for the MDCK pin";
        desc = "PADCTRL_REG103 is a drive capability register for the MDCK pin.

Data sheet 2.6.2 PADCTRL_REG103 (offset 0x19C, printed page 2-244, `hi3516av100--Hi3516A-Hi3516D-Datasheet.txt` line 14807).";

        enum PADCTRL_REG103_mdck_sr_enum {
            FAST_EDGE = 0 { name = "Fast Edge"; desc = "fast edge"; };
            SLOW_EDGE = 1 { name = "Slow Edge"; desc = "slow edge"; };
        };

        field {
            name = "mdck_sr";
            desc = "Level conversion rate of the MDCK pin";
            sw = rw;
            hw = r;
            encode = PADCTRL_REG103_mdck_sr_enum;
            reset = 0x1;
        } mdck_sr[7:7];

        enum PADCTRL_REG103_mdck_ds_enum {
            V_12_MA = 0 { name = "V 12 Ma"; desc = "12 mA"; };
            V_11_MA = 1 { name = "V 11 Ma"; desc = "11 mA"; };
            V_9_MA = 2 { name = "V 9 Ma"; desc = "9 mA"; };
            V_8_MA = 3 { name = "V 8 Ma"; desc = "8 mA"; };
            V_5_MA = 4 { name = "V 5 Ma"; desc = "5 mA"; };
            V_4_MA = 5 { name = "V 4 Ma"; desc = "4 mA"; };
            V_2_MA = 6 { name = "V 2 Ma"; desc = "2 mA"; };
            V_1_MA = 7 { name = "V 1 Ma"; desc = "1 mA"; };
        };

        field {
            name = "mdck_ds";
            desc = "Drive current of the MDCK pin";
            sw = rw;
            hw = r;
            encode = PADCTRL_REG103_mdck_ds_enum;
            reset = 0x6;
        } mdck_ds[6:4];
    } PADCTRL_REG103 @ 0x99C;

    reg {
        name = "Drive capability register for the MDIO pin";
        desc = "PADCTRL_REG104 is a drive capability register for the MDIO pin.

Data sheet 2.6.2 PADCTRL_REG104 (offset 0x1A0, printed page 2-245, `hi3516av100--Hi3516A-Hi3516D-Datasheet.txt` line 14849).";

        enum PADCTRL_REG104_mdio_sr_enum {
            FAST_EDGE = 0 { name = "Fast Edge"; desc = "fast edge"; };
            SLOW_EDGE = 1 { name = "Slow Edge"; desc = "slow edge"; };
        };

        field {
            name = "mdio_sr";
            desc = "Level conversion rate of the MDIO pin";
            sw = rw;
            hw = r;
            encode = PADCTRL_REG104_mdio_sr_enum;
            reset = 0x1;
        } mdio_sr[7:7];

        enum PADCTRL_REG104_mdio_ds_enum {
            V_12_MA = 0 { name = "V 12 Ma"; desc = "12 mA"; };
            V_11_MA = 1 { name = "V 11 Ma"; desc = "11 mA"; };
            V_9_MA = 2 { name = "V 9 Ma"; desc = "9 mA"; };
            V_8_MA = 3 { name = "V 8 Ma"; desc = "8 mA"; };
            V_5_MA = 4 { name = "V 5 Ma"; desc = "5 mA"; };
            V_4_MA = 5 { name = "V 4 Ma"; desc = "4 mA"; };
            V_2_MA = 6 { name = "V 2 Ma"; desc = "2 mA"; };
            V_1_MA = 7 { name = "V 1 Ma"; desc = "1 mA"; };
        };

        field {
            name = "mdio_ds";
            desc = "Drive current of the MDIO pin";
            sw = rw;
            hw = r;
            encode = PADCTRL_REG104_mdio_ds_enum;
            reset = 0x6;
        } mdio_ds[6:4];
    } PADCTRL_REG104 @ 0x9A0;

    reg {
        name = "Drive capability register for the RGMII_TX_EN pin";
        desc = "PADCTRL_REG105 is a drive capability register for the RGMII_TX_EN pin.

Data sheet 2.6.2 PADCTRL_REG105 (offset 0x1A4, printed page 2-246, `hi3516av100--Hi3516A-Hi3516D-Datasheet.txt` line 14890).";

        enum PADCTRL_REG105_rgmii_tx_en_sr_enum {
            FAST_EDGE = 0 { name = "Fast Edge"; desc = "fast edge"; };
            SLOW_EDGE = 1 { name = "Slow Edge"; desc = "slow edge"; };
        };

        field {
            name = "rgmii_tx_en_sr";
            desc = "Level conversion rate of the RGMII_TX_EN pin";
            sw = rw;
            hw = r;
            encode = PADCTRL_REG105_rgmii_tx_en_sr_enum;
            reset = 0x0;
        } rgmii_tx_en_sr[7:7];

        enum PADCTRL_REG105_rgmii_tx_en_ds_enum {
            V_18_MA = 0 { name = "V 18 Ma"; desc = "18 mA"; };
            V_16_MA = 1 { name = "V 16 Ma"; desc = "16 mA"; };
            V_14_MA = 2 { name = "V 14 Ma"; desc = "14 mA"; };
            V_12_MA = 3 { name = "V 12 Ma"; desc = "12 mA"; };
            V_5_MA = 4 { name = "V 5 Ma"; desc = "5 mA"; };
            V_4_MA = 5 { name = "V 4 Ma"; desc = "4 mA"; };
            V_2_MA = 6 { name = "V 2 Ma"; desc = "2 mA"; };
            V_1_MA = 7 { name = "V 1 Ma"; desc = "1 mA"; };
        };

        field {
            name = "rgmii_tx_en_ds";
            desc = "Drive current of the RGMII_TX_EN pin";
            sw = rw;
            hw = r;
            encode = PADCTRL_REG105_rgmii_tx_en_ds_enum;
            reset = 0x4;
        } rgmii_tx_en_ds[6:4];
    } PADCTRL_REG105 @ 0x9A4;

    reg {
        name = "Drive capability register for the RGMII_TX_CLK pin";
        desc = "PADCTRL_REG106 is a drive capability register for the RGMII_TX_CLK pin.

Data sheet 2.6.2 PADCTRL_REG106 (offset 0x1A8, printed page 2-247, `hi3516av100--Hi3516A-Hi3516D-Datasheet.txt` line 14934).";

        enum PADCTRL_REG106_rgmii_tx_clk_sr_enum {
            FAST_EDGE = 0 { name = "Fast Edge"; desc = "fast edge"; };
            SLOW_EDGE = 1 { name = "Slow Edge"; desc = "slow edge"; };
        };

        field {
            name = "rgmii_tx_clk_sr";
            desc = "Level conversion rate of the RGMII_TX_CLK pin";
            sw = rw;
            hw = r;
            encode = PADCTRL_REG106_rgmii_tx_clk_sr_enum;
            reset = 0x0;
        } rgmii_tx_clk_sr[7:7];

        enum PADCTRL_REG106_rgmii_tx_clk_ds_enum {
            V_18_MA = 0 { name = "V 18 Ma"; desc = "18 mA"; };
            V_16_MA = 1 { name = "V 16 Ma"; desc = "16 mA"; };
            V_14_MA = 2 { name = "V 14 Ma"; desc = "14 mA"; };
            V_12_MA = 3 { name = "V 12 Ma"; desc = "12 mA"; };
            V_5_MA = 4 { name = "V 5 Ma"; desc = "5 mA"; };
            V_4_MA = 5 { name = "V 4 Ma"; desc = "4 mA"; };
            V_2_MA = 6 { name = "V 2 Ma"; desc = "2 mA"; };
            V_1_MA = 7 { name = "V 1 Ma"; desc = "1 mA"; };
        };

        field {
            name = "rgmii_tx_clk_ds";
            desc = "Drive current of the RGMII_TX_CLK pin";
            sw = rw;
            hw = r;
            encode = PADCTRL_REG106_rgmii_tx_clk_ds_enum;
            reset = 0x4;
        } rgmii_tx_clk_ds[6:4];
    } PADCTRL_REG106 @ 0x9A8;

    reg {
        name = "Drive capability register for the RGMII_TXD0 pin";
        desc = "PADCTRL_REG107 is a drive capability register for the RGMII_TXD0 pin.

Data sheet 2.6.2 PADCTRL_REG107 (offset 0x1AC, printed page 2-248, `hi3516av100--Hi3516A-Hi3516D-Datasheet.txt` line 14978).";

        enum PADCTRL_REG107_rgmii_txd0_sr_enum {
            FAST_EDGE = 0 { name = "Fast Edge"; desc = "fast edge"; };
            SLOW_EDGE = 1 { name = "Slow Edge"; desc = "slow edge"; };
        };

        field {
            name = "rgmii_txd0_sr";
            desc = "Level conversion rate of the RGMII_TXD0 pin";
            sw = rw;
            hw = r;
            encode = PADCTRL_REG107_rgmii_txd0_sr_enum;
            reset = 0x0;
        } rgmii_txd0_sr[7:7];

        enum PADCTRL_REG107_rgmii_txd0_ds_enum {
            V_18_MA = 0 { name = "V 18 Ma"; desc = "18 mA"; };
            V_16_MA = 1 { name = "V 16 Ma"; desc = "16 mA"; };
            V_14_MA = 2 { name = "V 14 Ma"; desc = "14 mA"; };
            V_12_MA = 3 { name = "V 12 Ma"; desc = "12 mA"; };
            V_5_MA = 4 { name = "V 5 Ma"; desc = "5 mA"; };
            V_4_MA = 5 { name = "V 4 Ma"; desc = "4 mA"; };
            V_2_MA = 6 { name = "V 2 Ma"; desc = "2 mA"; };
            V_1_MA = 7 { name = "V 1 Ma"; desc = "1 mA"; };
        };

        field {
            name = "rgmii_txd0_ds";
            desc = "Drive current of the RGMII_TXD0 pin";
            sw = rw;
            hw = r;
            encode = PADCTRL_REG107_rgmii_txd0_ds_enum;
            reset = 0x4;
        } rgmii_txd0_ds[6:4];
    } PADCTRL_REG107 @ 0x9AC;

    reg {
        name = "Drive capability register for the RGMII_TXD1 pin";
        desc = "PADCTRL_REG108 is a drive capability register for the RGMII_TXD1 pin.

Data sheet 2.6.2 PADCTRL_REG108 (offset 0x1B0, printed page 2-249, `hi3516av100--Hi3516A-Hi3516D-Datasheet.txt` line 15022).";

        enum PADCTRL_REG108_rgmii_txd1_sr_enum {
            FAST_EDGE = 0 { name = "Fast Edge"; desc = "fast edge"; };
            SLOW_EDGE = 1 { name = "Slow Edge"; desc = "slow edge"; };
        };

        field {
            name = "rgmii_txd1_sr";
            desc = "Level conversion rate of the RGMII_TXD1 pin";
            sw = rw;
            hw = r;
            encode = PADCTRL_REG108_rgmii_txd1_sr_enum;
            reset = 0x0;
        } rgmii_txd1_sr[7:7];

        enum PADCTRL_REG108_rgmii_txd1_ds_enum {
            V_18_MA = 0 { name = "V 18 Ma"; desc = "18 mA"; };
            V_16_MA = 1 { name = "V 16 Ma"; desc = "16 mA"; };
            V_14_MA = 2 { name = "V 14 Ma"; desc = "14 mA"; };
            V_12_MA = 3 { name = "V 12 Ma"; desc = "12 mA"; };
            V_5_MA = 4 { name = "V 5 Ma"; desc = "5 mA"; };
            V_4_MA = 5 { name = "V 4 Ma"; desc = "4 mA"; };
            V_2_MA = 6 { name = "V 2 Ma"; desc = "2 mA"; };
            V_1_MA = 7 { name = "V 1 Ma"; desc = "1 mA"; };
        };

        field {
            name = "rgmii_txd1_ds";
            desc = "Drive current of the RGMII_TXD1 pin";
            sw = rw;
            hw = r;
            encode = PADCTRL_REG108_rgmii_txd1_ds_enum;
            reset = 0x4;
        } rgmii_txd1_ds[6:4];
    } PADCTRL_REG108 @ 0x9B0;

    reg {
        name = "Drive capability register for the RGMII_TXD2 pin";
        desc = "PADCTRL_REG109 is a drive capability register for the RGMII_TXD2 pin.

Data sheet 2.6.2 PADCTRL_REG109 (offset 0x1B4, printed page 2-250, `hi3516av100--Hi3516A-Hi3516D-Datasheet.txt` line 15066).";

        enum PADCTRL_REG109_rgmii_txd2_sr_enum {
            FAST_EDGE = 0 { name = "Fast Edge"; desc = "fast edge"; };
            SLOW_EDGE = 1 { name = "Slow Edge"; desc = "slow edge"; };
        };

        field {
            name = "rgmii_txd2_sr";
            desc = "Level conversion rate of the RGMII_TXD2 pin";
            sw = rw;
            hw = r;
            encode = PADCTRL_REG109_rgmii_txd2_sr_enum;
            reset = 0x0;
        } rgmii_txd2_sr[7:7];

        enum PADCTRL_REG109_rgmii_txd2_ds_enum {
            V_18_MA = 0 { name = "V 18 Ma"; desc = "18 mA"; };
            V_16_MA = 1 { name = "V 16 Ma"; desc = "16 mA"; };
            V_14_MA = 2 { name = "V 14 Ma"; desc = "14 mA"; };
            V_12_MA = 3 { name = "V 12 Ma"; desc = "12 mA"; };
            V_5_MA = 4 { name = "V 5 Ma"; desc = "5 mA"; };
            V_4_MA = 5 { name = "V 4 Ma"; desc = "4 mA"; };
            V_2_MA = 6 { name = "V 2 Ma"; desc = "2 mA"; };
            V_1_MA = 7 { name = "V 1 Ma"; desc = "1 mA"; };
        };

        field {
            name = "rgmii_txd2_ds";
            desc = "Drive current of the RGMII_TXD2 pin";
            sw = rw;
            hw = r;
            encode = PADCTRL_REG109_rgmii_txd2_ds_enum;
            reset = 0x4;
        } rgmii_txd2_ds[6:4];
    } PADCTRL_REG109 @ 0x9B4;

    reg {
        name = "Drive capability register for the RGMII_TXD3 pin";
        desc = "PADCTRL_REG110 is a drive capability register for the RGMII_TXD3 pin.

Data sheet 2.6.2 PADCTRL_REG110 (offset 0x1B8, printed page 2-251, `hi3516av100--Hi3516A-Hi3516D-Datasheet.txt` line 15110).";

        enum PADCTRL_REG110_rgmii_txd3_sr_enum {
            FAST_EDGE = 0 { name = "Fast Edge"; desc = "fast edge"; };
            SLOW_EDGE = 1 { name = "Slow Edge"; desc = "slow edge"; };
        };

        field {
            name = "rgmii_txd3_sr";
            desc = "Level conversion rate of the RGMII_TXD3 pin";
            sw = rw;
            hw = r;
            encode = PADCTRL_REG110_rgmii_txd3_sr_enum;
            reset = 0x0;
        } rgmii_txd3_sr[7:7];

        enum PADCTRL_REG110_rgmii_txd3_ds_enum {
            V_18_MA = 0 { name = "V 18 Ma"; desc = "18 mA"; };
            V_16_MA = 1 { name = "V 16 Ma"; desc = "16 mA"; };
            V_14_MA = 2 { name = "V 14 Ma"; desc = "14 mA"; };
            V_12_MA = 3 { name = "V 12 Ma"; desc = "12 mA"; };
            V_5_MA = 4 { name = "V 5 Ma"; desc = "5 mA"; };
            V_4_MA = 5 { name = "V 4 Ma"; desc = "4 mA"; };
            V_2_MA = 6 { name = "V 2 Ma"; desc = "2 mA"; };
            V_1_MA = 7 { name = "V 1 Ma"; desc = "1 mA"; };
        };

        field {
            name = "rgmii_txd3_ds";
            desc = "Drive current of the RGMII_TXD3 pin";
            sw = rw;
            hw = r;
            encode = PADCTRL_REG110_rgmii_txd3_ds_enum;
            reset = 0x4;
        } rgmii_txd3_ds[6:4];
    } PADCTRL_REG110 @ 0x9B8;

    reg {
        name = "Drive capability register for the RGMII_RX_CLK pin";
        desc = "PADCTRL_REG111 is a drive capability register for the RGMII_RX_CLK pin.

Data sheet 2.6.2 PADCTRL_REG111 (offset 0x1BC, printed page 2-252, `hi3516av100--Hi3516A-Hi3516D-Datasheet.txt` line 15154).";

        enum PADCTRL_REG111_rgmii_rx_clk_sr_enum {
            FAST_EDGE = 0 { name = "Fast Edge"; desc = "fast edge"; };
            SLOW_EDGE = 1 { name = "Slow Edge"; desc = "slow edge"; };
        };

        field {
            name = "rgmii_rx_clk_sr";
            desc = "Level conversion rate of the RGMII_RX_CLK pin";
            sw = rw;
            hw = r;
            encode = PADCTRL_REG111_rgmii_rx_clk_sr_enum;
            reset = 0x1;
        } rgmii_rx_clk_sr[7:7];

        enum PADCTRL_REG111_rgmii_rx_clk_ds_enum {
            V_4_MA = 0 { name = "V 4 Ma"; desc = "4 mA"; };
            V_3_MA = 1 { name = "V 3 Ma"; desc = "3 mA"; };
            V_2_MA = 2 { name = "V 2 Ma"; desc = "2 mA"; };
            V_1_MA = 3 { name = "V 1 Ma"; desc = "1 mA"; };
        };

        field {
            name = "rgmii_rx_clk_ds";
            desc = "Drive current of the RGMII_RX_CLK pin";
            sw = rw;
            hw = r;
            encode = PADCTRL_REG111_rgmii_rx_clk_ds_enum;
            reset = 0x2;
        } rgmii_rx_clk_ds[5:4];
    } PADCTRL_REG111 @ 0x9BC;

    reg {
        name = "Drive capability register for the RGMII_RX_DV pin";
        desc = "PADCTRL_REG112 is a drive capability register for the RGMII_RX_DV pin.

Data sheet 2.6.2 PADCTRL_REG112 (offset 0x1C0, printed page 2-253, `hi3516av100--Hi3516A-Hi3516D-Datasheet.txt` line 15195).";

        enum PADCTRL_REG112_rgmii_rx_dv_sr_enum {
            FAST_EDGE = 0 { name = "Fast Edge"; desc = "fast edge"; };
            SLOW_EDGE = 1 { name = "Slow Edge"; desc = "slow edge"; };
        };

        field {
            name = "rgmii_rx_dv_sr";
            desc = "Level conversion rate of the RGMII_RX_DV pin";
            sw = rw;
            hw = r;
            encode = PADCTRL_REG112_rgmii_rx_dv_sr_enum;
            reset = 0x1;
        } rgmii_rx_dv_sr[7:7];

        enum PADCTRL_REG112_rgmii_rx_dv_ds_enum {
            V_4_MA = 0 { name = "V 4 Ma"; desc = "4 mA"; };
            V_3_MA = 1 { name = "V 3 Ma"; desc = "3 mA"; };
            V_2_MA = 2 { name = "V 2 Ma"; desc = "2 mA"; };
            V_1_MA = 3 { name = "V 1 Ma"; desc = "1 mA"; };
        };

        field {
            name = "rgmii_rx_dv_ds";
            desc = "Drive current of the RGMII_RX_DV pin";
            sw = rw;
            hw = r;
            encode = PADCTRL_REG112_rgmii_rx_dv_ds_enum;
            reset = 0x2;
        } rgmii_rx_dv_ds[5:4];
    } PADCTRL_REG112 @ 0x9C0;

    reg {
        name = "Drive capability register for the RGMII_RXD0 pin";
        desc = "PADCTRL_REG113 is a drive capability register for the RGMII_RXD0 pin.

Data sheet 2.6.2 PADCTRL_REG113 (offset 0x1C4, printed page 2-254, `hi3516av100--Hi3516A-Hi3516D-Datasheet.txt` line 15236).";

        enum PADCTRL_REG113_rgmii_rxd0_sr_enum {
            FAST_EDGE = 0 { name = "Fast Edge"; desc = "fast edge"; };
            SLOW_EDGE = 1 { name = "Slow Edge"; desc = "slow edge"; };
        };

        field {
            name = "rgmii_rxd0_sr";
            desc = "Level conversion rate of the RGMII_RXD0 pin";
            sw = rw;
            hw = r;
            encode = PADCTRL_REG113_rgmii_rxd0_sr_enum;
            reset = 0x1;
        } rgmii_rxd0_sr[7:7];

        enum PADCTRL_REG113_rgmii_rxd0_ds_enum {
            V_4_MA = 0 { name = "V 4 Ma"; desc = "4 mA"; };
            V_3_MA = 1 { name = "V 3 Ma"; desc = "3 mA"; };
            V_2_MA = 2 { name = "V 2 Ma"; desc = "2 mA"; };
            V_1_MA = 3 { name = "V 1 Ma"; desc = "1 mA"; };
        };

        field {
            name = "rgmii_rxd0_ds";
            desc = "Drive current of the RGMII_RXD0 pin";
            sw = rw;
            hw = r;
            encode = PADCTRL_REG113_rgmii_rxd0_ds_enum;
            reset = 0x2;
        } rgmii_rxd0_ds[5:4];
    } PADCTRL_REG113 @ 0x9C4;

    reg {
        name = "Drive capability register for the RGMII_RXD1 pin";
        desc = "PADCTRL_REG114 is a drive capability register for the RGMII_RXD1 pin.

Data sheet 2.6.2 PADCTRL_REG114 (offset 0x1C8, printed page 2-255, `hi3516av100--Hi3516A-Hi3516D-Datasheet.txt` line 15277).";

        enum PADCTRL_REG114_rgmii_rxd1_sr_enum {
            FAST_EDGE = 0 { name = "Fast Edge"; desc = "fast edge"; };
            SLOW_EDGE = 1 { name = "Slow Edge"; desc = "slow edge"; };
        };

        field {
            name = "rgmii_rxd1_sr";
            desc = "Level conversion rate of the RGMII_RXD1 pin";
            sw = rw;
            hw = r;
            encode = PADCTRL_REG114_rgmii_rxd1_sr_enum;
            reset = 0x1;
        } rgmii_rxd1_sr[7:7];

        enum PADCTRL_REG114_rgmii_rxd1_ds_enum {
            V_4_MA = 0 { name = "V 4 Ma"; desc = "4 mA"; };
            V_3_MA = 1 { name = "V 3 Ma"; desc = "3 mA"; };
            V_2_MA = 2 { name = "V 2 Ma"; desc = "2 mA"; };
            V_1_MA = 3 { name = "V 1 Ma"; desc = "1 mA"; };
        };

        field {
            name = "rgmii_rxd1_ds";
            desc = "Drive current of the RGMII_RXD1 pin";
            sw = rw;
            hw = r;
            encode = PADCTRL_REG114_rgmii_rxd1_ds_enum;
            reset = 0x2;
        } rgmii_rxd1_ds[5:4];
    } PADCTRL_REG114 @ 0x9C8;

    reg {
        name = "Drive capability register for the RGMII_RXD2 pin";
        desc = "PADCTRL_REG115 is a drive capability register for the RGMII_RXD2 pin.

Data sheet 2.6.2 PADCTRL_REG115 (offset 0x1CC, printed page 2-256, `hi3516av100--Hi3516A-Hi3516D-Datasheet.txt` line 15318).";

        enum PADCTRL_REG115_rgmii_rxd2_sr_enum {
            FAST_EDGE = 0 { name = "Fast Edge"; desc = "fast edge"; };
            SLOW_EDGE = 1 { name = "Slow Edge"; desc = "slow edge"; };
        };

        field {
            name = "rgmii_rxd2_sr";
            desc = "Level conversion rate of the RGMII_RXD2 pin";
            sw = rw;
            hw = r;
            encode = PADCTRL_REG115_rgmii_rxd2_sr_enum;
            reset = 0x1;
        } rgmii_rxd2_sr[7:7];

        enum PADCTRL_REG115_rgmii_rxd2_ds_enum {
            V_4_MA = 0 { name = "V 4 Ma"; desc = "4 mA"; };
            V_3_MA = 1 { name = "V 3 Ma"; desc = "3 mA"; };
            V_2_MA = 2 { name = "V 2 Ma"; desc = "2 mA"; };
            V_1_MA = 3 { name = "V 1 Ma"; desc = "1 mA"; };
        };

        field {
            name = "rgmii_rxd2_ds";
            desc = "Drive current of the RGMII_RXD2 pin";
            sw = rw;
            hw = r;
            encode = PADCTRL_REG115_rgmii_rxd2_ds_enum;
            reset = 0x2;
        } rgmii_rxd2_ds[5:4];
    } PADCTRL_REG115 @ 0x9CC;

    reg {
        name = "Drive capability register for the RGMII_RXD3 pin";
        desc = "PADCTRL_REG116 is a drive capability register for the RGMII_RXD3 pin.

Data sheet 2.6.2 PADCTRL_REG116 (offset 0x1D0, printed page 2-257, `hi3516av100--Hi3516A-Hi3516D-Datasheet.txt` line 15359).";

        enum PADCTRL_REG116_rgmii_rxd3_sr_enum {
            FAST_EDGE = 0 { name = "Fast Edge"; desc = "fast edge"; };
            SLOW_EDGE = 1 { name = "Slow Edge"; desc = "slow edge"; };
        };

        field {
            name = "rgmii_rxd3_sr";
            desc = "Level conversion rate of the RGMII_RXD3 pin";
            sw = rw;
            hw = r;
            encode = PADCTRL_REG116_rgmii_rxd3_sr_enum;
            reset = 0x1;
        } rgmii_rxd3_sr[7:7];

        enum PADCTRL_REG116_rgmii_rxd3_ds_enum {
            V_4_MA = 0 { name = "V 4 Ma"; desc = "4 mA"; };
            V_3_MA = 1 { name = "V 3 Ma"; desc = "3 mA"; };
            V_2_MA = 2 { name = "V 2 Ma"; desc = "2 mA"; };
            V_1_MA = 3 { name = "V 1 Ma"; desc = "1 mA"; };
        };

        field {
            name = "rgmii_rxd3_ds";
            desc = "Drive current of the RGMII_RXD3 pin";
            sw = rw;
            hw = r;
            encode = PADCTRL_REG116_rgmii_rxd3_ds_enum;
            reset = 0x2;
        } rgmii_rxd3_ds[5:4];
    } PADCTRL_REG116 @ 0x9D0;

    reg {
        name = "Drive capability register for the VI_CLK pin";
        desc = "PADCTRL_REG117 is a drive capability register for the VI_CLK pin.

Data sheet 2.6.2 PADCTRL_REG117 (offset 0x1D4, printed page 2-257, `hi3516av100--Hi3516A-Hi3516D-Datasheet.txt` line 15394).";

        enum PADCTRL_REG117_vi_clk_sr_enum {
            FAST_EDGE = 0 { name = "Fast Edge"; desc = "fast edge"; };
            SLOW_EDGE = 1 { name = "Slow Edge"; desc = "slow edge"; };
        };

        field {
            name = "vi_clk_sr";
            desc = "Level conversion rate of the VI_CLK pin";
            sw = rw;
            hw = r;
            encode = PADCTRL_REG117_vi_clk_sr_enum;
            reset = 0x1;
        } vi_clk_sr[7:7];

        enum PADCTRL_REG117_vi_clk_ds_enum {
            V_4_MA = 0 { name = "V 4 Ma"; desc = "4 mA"; };
            V_3_MA = 1 { name = "V 3 Ma"; desc = "3 mA"; };
            V_2_MA = 2 { name = "V 2 Ma"; desc = "2 mA"; };
            V_1_MA = 3 { name = "V 1 Ma"; desc = "1 mA"; };
        };

        field {
            name = "vi_clk_ds";
            desc = "Drive current of the VI_CLK pin";
            sw = rw;
            hw = r;
            encode = PADCTRL_REG117_vi_clk_ds_enum;
            reset = 0x2;
        } vi_clk_ds[5:4];
    } PADCTRL_REG117 @ 0x9D4;

    reg {
        name = "Drive capability register for the VI_HS pin";
        desc = "PADCTRL_REG118 is a drive capability register for the VI_HS pin.

Data sheet 2.6.2 PADCTRL_REG118 (offset 0x1D8, printed page 2-258, `hi3516av100--Hi3516A-Hi3516D-Datasheet.txt` line 15436).";

        enum PADCTRL_REG118_vi_hs_sr_enum {
            FAST_EDGE = 0 { name = "Fast Edge"; desc = "fast edge"; };
            SLOW_EDGE = 1 { name = "Slow Edge"; desc = "slow edge"; };
        };

        field {
            name = "vi_hs_sr";
            desc = "Level conversion rate of the VI_HS pin";
            sw = rw;
            hw = r;
            encode = PADCTRL_REG118_vi_hs_sr_enum;
            reset = 0x1;
        } vi_hs_sr[7:7];

        enum PADCTRL_REG118_vi_hs_ds_enum {
            V_4_MA = 0 { name = "V 4 Ma"; desc = "4 mA"; };
            V_3_MA = 1 { name = "V 3 Ma"; desc = "3 mA"; };
            V_2_MA = 2 { name = "V 2 Ma"; desc = "2 mA"; };
            V_1_MA = 3 { name = "V 1 Ma"; desc = "1 mA"; };
        };

        field {
            name = "vi_hs_ds";
            desc = "Drive current of the VI_HS pin";
            sw = rw;
            hw = r;
            encode = PADCTRL_REG118_vi_hs_ds_enum;
            reset = 0x2;
        } vi_hs_ds[5:4];
    } PADCTRL_REG118 @ 0x9D8;

    reg {
        name = "Drive capability register for the VI_VS pin";
        desc = "PADCTRL_REG119 is a drive capability register for the VI_VS pin.

Data sheet 2.6.2 PADCTRL_REG119 (offset 0x1DC, printed page 2-259, `hi3516av100--Hi3516A-Hi3516D-Datasheet.txt` line 15479).";

        enum PADCTRL_REG119_vi_vs_sr_enum {
            FAST_EDGE = 0 { name = "Fast Edge"; desc = "fast edge"; };
            SLOW_EDGE = 1 { name = "Slow Edge"; desc = "slow edge"; };
        };

        field {
            name = "vi_vs_sr";
            desc = "Level conversion rate of the VI_VS pin";
            sw = rw;
            hw = r;
            encode = PADCTRL_REG119_vi_vs_sr_enum;
            reset = 0x1;
        } vi_vs_sr[7:7];

        enum PADCTRL_REG119_vi_vs_ds_enum {
            V_4_MA = 0 { name = "V 4 Ma"; desc = "4 mA"; };
            V_3_MA = 1 { name = "V 3 Ma"; desc = "3 mA"; };
            V_2_MA = 2 { name = "V 2 Ma"; desc = "2 mA"; };
            V_1_MA = 3 { name = "V 1 Ma"; desc = "1 mA"; };
        };

        field {
            name = "vi_vs_ds";
            desc = "Drive current of the VI_VS pin";
            sw = rw;
            hw = r;
            encode = PADCTRL_REG119_vi_vs_ds_enum;
            reset = 0x2;
        } vi_vs_ds[5:4];
    } PADCTRL_REG119 @ 0x9DC;

    reg {
        name = "Drive capability register for the VI_DAT15 pin";
        desc = "PADCTRL_REG120 is a drive capability register for the VI_DAT15 pin.

Data sheet 2.6.2 PADCTRL_REG120 (offset 0x1E0, printed page 2-260, `hi3516av100--Hi3516A-Hi3516D-Datasheet.txt` line 15518).";

        enum PADCTRL_REG120_vi_dat15_sr_enum {
            FAST_EDGE = 0 { name = "Fast Edge"; desc = "fast edge"; };
            SLOW_EDGE = 1 { name = "Slow Edge"; desc = "slow edge"; };
        };

        field {
            name = "vi_dat15_sr";
            desc = "Level conversion rate of the VI_DAT15 pin";
            sw = rw;
            hw = r;
            encode = PADCTRL_REG120_vi_dat15_sr_enum;
            reset = 0x1;
        } vi_dat15_sr[7:7];

        enum PADCTRL_REG120_vi_dat15_ds_enum {
            V_4_MA = 0 { name = "V 4 Ma"; desc = "4 mA"; };
            V_3_MA = 1 { name = "V 3 Ma"; desc = "3 mA"; };
            V_2_MA = 2 { name = "V 2 Ma"; desc = "2 mA"; };
            V_1_MA = 3 { name = "V 1 Ma"; desc = "1 mA"; };
        };

        field {
            name = "vi_dat15_ds";
            desc = "Drive current of the VI_DAT15 pin";
            sw = rw;
            hw = r;
            encode = PADCTRL_REG120_vi_dat15_ds_enum;
            reset = 0x2;
        } vi_dat15_ds[5:4];
    } PADCTRL_REG120 @ 0x9E0;

    reg {
        name = "Drive capability register for the VI_DAT14 pin";
        desc = "PADCTRL_REG121 is a drive capability register for the VI_DAT14 pin.

Data sheet 2.6.2 PADCTRL_REG121 (offset 0x1E4, printed page 2-260, `hi3516av100--Hi3516A-Hi3516D-Datasheet.txt` line 15553).";

        enum PADCTRL_REG121_vi_dat14_sr_enum {
            FAST_EDGE = 0 { name = "Fast Edge"; desc = "fast edge"; };
            SLOW_EDGE = 1 { name = "Slow Edge"; desc = "slow edge"; };
        };

        field {
            name = "vi_dat14_sr";
            desc = "Level conversion rate of the VI_DAT14 pin";
            sw = rw;
            hw = r;
            encode = PADCTRL_REG121_vi_dat14_sr_enum;
            reset = 0x1;
        } vi_dat14_sr[7:7];

        enum PADCTRL_REG121_vi_dat14_ds_enum {
            V_4_MA = 0 { name = "V 4 Ma"; desc = "4 mA"; };
            V_3_MA = 1 { name = "V 3 Ma"; desc = "3 mA"; };
            V_2_MA = 2 { name = "V 2 Ma"; desc = "2 mA"; };
            V_1_MA = 3 { name = "V 1 Ma"; desc = "1 mA"; };
        };

        field {
            name = "vi_dat14_ds";
            desc = "Drive current of the VI_DAT14 pin";
            sw = rw;
            hw = r;
            encode = PADCTRL_REG121_vi_dat14_ds_enum;
            reset = 0x2;
        } vi_dat14_ds[5:4];
    } PADCTRL_REG121 @ 0x9E4;

    reg {
        name = "Drive capability register for the VI_DAT13 pin";
        desc = "PADCTRL_REG122 is a drive capability register for the VI_DAT13 pin.

Data sheet 2.6.2 PADCTRL_REG122 (offset 0x1E8, printed page 2-261, `hi3516av100--Hi3516A-Hi3516D-Datasheet.txt` line 15595).";

        enum PADCTRL_REG122_vi_dat13_sr_enum {
            FAST_EDGE = 0 { name = "Fast Edge"; desc = "fast edge"; };
            SLOW_EDGE = 1 { name = "Slow Edge"; desc = "slow edge"; };
        };

        field {
            name = "vi_dat13_sr";
            desc = "Level conversion rate of the VI_DAT13 pin";
            sw = rw;
            hw = r;
            encode = PADCTRL_REG122_vi_dat13_sr_enum;
            reset = 0x1;
        } vi_dat13_sr[7:7];

        enum PADCTRL_REG122_vi_dat13_ds_enum {
            V_4_MA = 0 { name = "V 4 Ma"; desc = "4 mA"; };
            V_3_MA = 1 { name = "V 3 Ma"; desc = "3 mA"; };
            V_2_MA = 2 { name = "V 2 Ma"; desc = "2 mA"; };
            V_1_MA = 3 { name = "V 1 Ma"; desc = "1 mA"; };
        };

        field {
            name = "vi_dat13_ds";
            desc = "Drive current of the VI_DAT13 pin";
            sw = rw;
            hw = r;
            encode = PADCTRL_REG122_vi_dat13_ds_enum;
            reset = 0x2;
        } vi_dat13_ds[5:4];
    } PADCTRL_REG122 @ 0x9E8;

    reg {
        name = "Drive capability register for the VI_DAT12 pin";
        desc = "PADCTRL_REG123 is a drive capability register for the VI_DAT12 pin.

Data sheet 2.6.2 PADCTRL_REG123 (offset 0x1EC, printed page 2-262, `hi3516av100--Hi3516A-Hi3516D-Datasheet.txt` line 15641).";

        enum PADCTRL_REG123_vi_dat12_sr_enum {
            FAST_EDGE = 0 { name = "Fast Edge"; desc = "fast edge"; };
            SLOW_EDGE = 1 { name = "Slow Edge"; desc = "slow edge"; };
        };

        field {
            name = "vi_dat12_sr";
            desc = "Level conversion rate of the VI_DAT12 pin";
            sw = rw;
            hw = r;
            encode = PADCTRL_REG123_vi_dat12_sr_enum;
            reset = 0x1;
        } vi_dat12_sr[7:7];

        enum PADCTRL_REG123_vi_dat12_ds_enum {
            V_4_MA = 0 { name = "V 4 Ma"; desc = "4 mA"; };
            V_3_MA = 1 { name = "V 3 Ma"; desc = "3 mA"; };
            V_2_MA = 2 { name = "V 2 Ma"; desc = "2 mA"; };
            V_1_MA = 3 { name = "V 1 Ma"; desc = "1 mA"; };
        };

        field {
            name = "vi_dat12_ds";
            desc = "Drive current of the VI_DAT12 pin";
            sw = rw;
            hw = r;
            encode = PADCTRL_REG123_vi_dat12_ds_enum;
            reset = 0x2;
        } vi_dat12_ds[5:4];
    } PADCTRL_REG123 @ 0x9EC;

    reg {
        name = "Drive capability register for the VI_DAT11 pin";
        desc = "PADCTRL_REG124 is a drive capability register for the VI_DAT11 pin.

Data sheet 2.6.2 PADCTRL_REG124 (offset 0x1F0, printed page 2-263, `hi3516av100--Hi3516A-Hi3516D-Datasheet.txt` line 15682).";

        enum PADCTRL_REG124_vi_dat11_sr_enum {
            FAST_EDGE = 0 { name = "Fast Edge"; desc = "fast edge"; };
            SLOW_EDGE = 1 { name = "Slow Edge"; desc = "slow edge"; };
        };

        field {
            name = "vi_dat11_sr";
            desc = "Level conversion rate of the VI_DAT11 pin";
            sw = rw;
            hw = r;
            encode = PADCTRL_REG124_vi_dat11_sr_enum;
            reset = 0x1;
        } vi_dat11_sr[7:7];

        enum PADCTRL_REG124_vi_dat11_ds_enum {
            V_4_MA = 0 { name = "V 4 Ma"; desc = "4 mA"; };
            V_3_MA = 1 { name = "V 3 Ma"; desc = "3 mA"; };
            V_2_MA = 2 { name = "V 2 Ma"; desc = "2 mA"; };
            V_1_MA = 3 { name = "V 1 Ma"; desc = "1 mA"; };
        };

        field {
            name = "vi_dat11_ds";
            desc = "Drive current of the VI_DAT11 pin";
            sw = rw;
            hw = r;
            encode = PADCTRL_REG124_vi_dat11_ds_enum;
            reset = 0x2;
        } vi_dat11_ds[5:4];
    } PADCTRL_REG124 @ 0x9F0;

    reg {
        name = "Drive capability register for the VI_DAT10 pin";
        desc = "PADCTRL_REG125 is a drive capability register for the VI_DAT10 pin.

Data sheet 2.6.2 PADCTRL_REG125 (offset 0x1F4, printed page 2-263, `hi3516av100--Hi3516A-Hi3516D-Datasheet.txt` line 15717).";

        enum PADCTRL_REG125_vi_dat10_sr_enum {
            FAST_EDGE = 0 { name = "Fast Edge"; desc = "fast edge"; };
            SLOW_EDGE = 1 { name = "Slow Edge"; desc = "slow edge"; };
        };

        field {
            name = "vi_dat10_sr";
            desc = "Level conversion rate of the VI_DAT10 pin";
            sw = rw;
            hw = r;
            encode = PADCTRL_REG125_vi_dat10_sr_enum;
            reset = 0x1;
        } vi_dat10_sr[7:7];

        enum PADCTRL_REG125_vi_dat10_ds_enum {
            V_4_MA = 0 { name = "V 4 Ma"; desc = "4 mA"; };
            V_3_MA = 1 { name = "V 3 Ma"; desc = "3 mA"; };
            V_2_MA = 2 { name = "V 2 Ma"; desc = "2 mA"; };
            V_1_MA = 3 { name = "V 1 Ma"; desc = "1 mA"; };
        };

        field {
            name = "vi_dat10_ds";
            desc = "Drive current of the VI_DAT10 pin";
            sw = rw;
            hw = r;
            encode = PADCTRL_REG125_vi_dat10_ds_enum;
            reset = 0x2;
        } vi_dat10_ds[5:4];
    } PADCTRL_REG125 @ 0x9F4;

    reg {
        name = "Drive capability register for the VI_DAT9 pin";
        desc = "PADCTRL_REG126 is a drive capability register for the VI_DAT9 pin.

Data sheet 2.6.2 PADCTRL_REG126 (offset 0x1F8, printed page 2-264, `hi3516av100--Hi3516A-Hi3516D-Datasheet.txt` line 15759).";

        enum PADCTRL_REG126_vi_dat9_sr_enum {
            FAST_EDGE = 0 { name = "Fast Edge"; desc = "fast edge"; };
            SLOW_EDGE = 1 { name = "Slow Edge"; desc = "slow edge"; };
        };

        field {
            name = "vi_dat9_sr";
            desc = "Level conversion rate of the VI_DAT9 pin";
            sw = rw;
            hw = r;
            encode = PADCTRL_REG126_vi_dat9_sr_enum;
            reset = 0x1;
        } vi_dat9_sr[7:7];

        enum PADCTRL_REG126_vi_dat9_ds_enum {
            V_4_MA = 0 { name = "V 4 Ma"; desc = "4 mA"; };
            V_3_MA = 1 { name = "V 3 Ma"; desc = "3 mA"; };
            V_2_MA = 2 { name = "V 2 Ma"; desc = "2 mA"; };
            V_1_MA = 3 { name = "V 1 Ma"; desc = "1 mA"; };
        };

        field {
            name = "vi_dat9_ds";
            desc = "Drive current of the VI_DAT9 pin";
            sw = rw;
            hw = r;
            encode = PADCTRL_REG126_vi_dat9_ds_enum;
            reset = 0x2;
        } vi_dat9_ds[5:4];
    } PADCTRL_REG126 @ 0x9F8;

    reg {
        name = "Drive capability register for the VI_DAT8 pin";
        desc = "PADCTRL_REG127 is a drive capability register for the VI_DAT8 pin.

Data sheet 2.6.2 PADCTRL_REG127 (offset 0x1FC, printed page 2-265, `hi3516av100--Hi3516A-Hi3516D-Datasheet.txt` line 15805).";

        enum PADCTRL_REG127_vi_dat8_sr_enum {
            FAST_EDGE = 0 { name = "Fast Edge"; desc = "fast edge"; };
            SLOW_EDGE = 1 { name = "Slow Edge"; desc = "slow edge"; };
        };

        field {
            name = "vi_dat8_sr";
            desc = "Level conversion rate of the VI_DAT8 pin";
            sw = rw;
            hw = r;
            encode = PADCTRL_REG127_vi_dat8_sr_enum;
            reset = 0x1;
        } vi_dat8_sr[7:7];

        enum PADCTRL_REG127_vi_dat8_ds_enum {
            V_4_MA = 0 { name = "V 4 Ma"; desc = "4 mA"; };
            V_3_MA = 1 { name = "V 3 Ma"; desc = "3 mA"; };
            V_2_MA = 2 { name = "V 2 Ma"; desc = "2 mA"; };
            V_1_MA = 3 { name = "V 1 Ma"; desc = "1 mA"; };
        };

        field {
            name = "vi_dat8_ds";
            desc = "Drive current of the VI_DAT8 pin";
            sw = rw;
            hw = r;
            encode = PADCTRL_REG127_vi_dat8_ds_enum;
            reset = 0x2;
        } vi_dat8_ds[5:4];
    } PADCTRL_REG127 @ 0x9FC;

    reg {
        name = "Drive capability register for the VI_DAT7 pin";
        desc = "PADCTRL_REG128 is a drive capability register for the VI_DAT7 pin.

Data sheet 2.6.2 PADCTRL_REG128 (offset 0x200, printed page 2-266, `hi3516av100--Hi3516A-Hi3516D-Datasheet.txt` line 15846).";

        enum PADCTRL_REG128_vi_dat7_sr_enum {
            FAST_EDGE = 0 { name = "Fast Edge"; desc = "fast edge"; };
            SLOW_EDGE = 1 { name = "Slow Edge"; desc = "slow edge"; };
        };

        field {
            name = "vi_dat7_sr";
            desc = "Level conversion rate of the VI_DAT7 pin";
            sw = rw;
            hw = r;
            encode = PADCTRL_REG128_vi_dat7_sr_enum;
            reset = 0x1;
        } vi_dat7_sr[7:7];

        enum PADCTRL_REG128_vi_dat7_ds_enum {
            V_4_MA = 0 { name = "V 4 Ma"; desc = "4 mA"; };
            V_3_MA = 1 { name = "V 3 Ma"; desc = "3 mA"; };
            V_2_MA = 2 { name = "V 2 Ma"; desc = "2 mA"; };
            V_1_MA = 3 { name = "V 1 Ma"; desc = "1 mA"; };
        };

        field {
            name = "vi_dat7_ds";
            desc = "Drive current of the VI_DAT7 pin";
            sw = rw;
            hw = r;
            encode = PADCTRL_REG128_vi_dat7_ds_enum;
            reset = 0x2;
        } vi_dat7_ds[5:4];
    } PADCTRL_REG128 @ 0xA00;

    reg {
        name = "Drive capability register for the VI_DAT6 pin";
        desc = "PADCTRL_REG129 is a drive capability register for the VI_DAT6 pin.

Data sheet 2.6.2 PADCTRL_REG129 (offset 0x204, printed page 2-266, `hi3516av100--Hi3516A-Hi3516D-Datasheet.txt` line 15881).";

        enum PADCTRL_REG129_vi_dat6_sr_enum {
            FAST_EDGE = 0 { name = "Fast Edge"; desc = "fast edge"; };
            SLOW_EDGE = 1 { name = "Slow Edge"; desc = "slow edge"; };
        };

        field {
            name = "vi_dat6_sr";
            desc = "Level conversion rate of the VI_DAT6 pin";
            sw = rw;
            hw = r;
            encode = PADCTRL_REG129_vi_dat6_sr_enum;
            reset = 0x1;
        } vi_dat6_sr[7:7];

        enum PADCTRL_REG129_vi_dat6_ds_enum {
            V_4_MA = 0 { name = "V 4 Ma"; desc = "4 mA"; };
            V_3_MA = 1 { name = "V 3 Ma"; desc = "3 mA"; };
            V_2_MA = 2 { name = "V 2 Ma"; desc = "2 mA"; };
            V_1_MA = 3 { name = "V 1 Ma"; desc = "1 mA"; };
        };

        field {
            name = "vi_dat6_ds";
            desc = "Drive current of the VI_DAT6 pin";
            sw = rw;
            hw = r;
            encode = PADCTRL_REG129_vi_dat6_ds_enum;
            reset = 0x2;
        } vi_dat6_ds[5:4];
    } PADCTRL_REG129 @ 0xA04;

    reg {
        name = "Drive capability register for the VI_DAT5 pin";
        desc = "PADCTRL_REG130 is a drive capability register for the VI_DAT5 pin.

Data sheet 2.6.2 PADCTRL_REG130 (offset 0x208, printed page 2-267, `hi3516av100--Hi3516A-Hi3516D-Datasheet.txt` line 15923).";

        enum PADCTRL_REG130_vi_dat5_sr_enum {
            FAST_EDGE = 0 { name = "Fast Edge"; desc = "fast edge"; };
            SLOW_EDGE = 1 { name = "Slow Edge"; desc = "slow edge"; };
        };

        field {
            name = "vi_dat5_sr";
            desc = "Level conversion rate of the VI_DAT5 pin";
            sw = rw;
            hw = r;
            encode = PADCTRL_REG130_vi_dat5_sr_enum;
            reset = 0x1;
        } vi_dat5_sr[7:7];

        enum PADCTRL_REG130_vi_dat5_ds_enum {
            V_4_MA = 0 { name = "V 4 Ma"; desc = "4 mA"; };
            V_3_MA = 1 { name = "V 3 Ma"; desc = "3 mA"; };
            V_2_MA = 2 { name = "V 2 Ma"; desc = "2 mA"; };
            V_1_MA = 3 { name = "V 1 Ma"; desc = "1 mA"; };
        };

        field {
            name = "vi_dat5_ds";
            desc = "Drive current of the VI_DAT5 pin";
            sw = rw;
            hw = r;
            encode = PADCTRL_REG130_vi_dat5_ds_enum;
            reset = 0x2;
        } vi_dat5_ds[5:4];
    } PADCTRL_REG130 @ 0xA08;

    reg {
        name = "Drive capability register for the VI_DAT4 pin";
        desc = "PADCTRL_REG131 is a drive capability register for the VI_DAT4 pin.

Data sheet 2.6.2 PADCTRL_REG131 (offset 0x20C, printed page 2-268, `hi3516av100--Hi3516A-Hi3516D-Datasheet.txt` line 15969).";

        enum PADCTRL_REG131_vi_dat4_sr_enum {
            FAST_EDGE = 0 { name = "Fast Edge"; desc = "fast edge"; };
            SLOW_EDGE = 1 { name = "Slow Edge"; desc = "slow edge"; };
        };

        field {
            name = "vi_dat4_sr";
            desc = "Level conversion rate of the VI_DAT4 pin";
            sw = rw;
            hw = r;
            encode = PADCTRL_REG131_vi_dat4_sr_enum;
            reset = 0x1;
        } vi_dat4_sr[7:7];

        enum PADCTRL_REG131_vi_dat4_ds_enum {
            V_4_MA = 0 { name = "V 4 Ma"; desc = "4 mA"; };
            V_3_MA = 1 { name = "V 3 Ma"; desc = "3 mA"; };
            V_2_MA = 2 { name = "V 2 Ma"; desc = "2 mA"; };
            V_1_MA = 3 { name = "V 1 Ma"; desc = "1 mA"; };
        };

        field {
            name = "vi_dat4_ds";
            desc = "Drive current of the VI_DAT4 pin";
            sw = rw;
            hw = r;
            encode = PADCTRL_REG131_vi_dat4_ds_enum;
            reset = 0x2;
        } vi_dat4_ds[5:4];
    } PADCTRL_REG131 @ 0xA0C;

    reg {
        name = "Drive capability register for the VI_DAT3 pin";
        desc = "PADCTRL_REG132 is a drive capability register for the VI_DAT3 pin.

Data sheet 2.6.2 PADCTRL_REG132 (offset 0x210, printed page 2-269, `hi3516av100--Hi3516A-Hi3516D-Datasheet.txt` line 16010).";

        enum PADCTRL_REG132_vi_dat3_sr_enum {
            FAST_EDGE = 0 { name = "Fast Edge"; desc = "fast edge"; };
            SLOW_EDGE = 1 { name = "Slow Edge"; desc = "slow edge"; };
        };

        field {
            name = "vi_dat3_sr";
            desc = "Level conversion rate of the VI_DAT3 pin";
            sw = rw;
            hw = r;
            encode = PADCTRL_REG132_vi_dat3_sr_enum;
            reset = 0x1;
        } vi_dat3_sr[7:7];

        enum PADCTRL_REG132_vi_dat3_ds_enum {
            V_4_MA = 0 { name = "V 4 Ma"; desc = "4 mA"; };
            V_3_MA = 1 { name = "V 3 Ma"; desc = "3 mA"; };
            V_2_MA = 2 { name = "V 2 Ma"; desc = "2 mA"; };
            V_1_MA = 3 { name = "V 1 Ma"; desc = "1 mA"; };
        };

        field {
            name = "vi_dat3_ds";
            desc = "Drive current of the VI_DAT3 pin";
            sw = rw;
            hw = r;
            encode = PADCTRL_REG132_vi_dat3_ds_enum;
            reset = 0x2;
        } vi_dat3_ds[5:4];
    } PADCTRL_REG132 @ 0xA10;

    reg {
        name = "Drive capability register for the VI_DAT2 pin";
        desc = "PADCTRL_REG133 is a drive capability register for the VI_DAT2 pin.

Data sheet 2.6.2 PADCTRL_REG133 (offset 0x214, printed page 2-269, `hi3516av100--Hi3516A-Hi3516D-Datasheet.txt` line 16045).";

        enum PADCTRL_REG133_vi_dat2_sr_enum {
            FAST_EDGE = 0 { name = "Fast Edge"; desc = "fast edge"; };
            SLOW_EDGE = 1 { name = "Slow Edge"; desc = "slow edge"; };
        };

        field {
            name = "vi_dat2_sr";
            desc = "Level conversion rate of the VI_DAT2 pin";
            sw = rw;
            hw = r;
            encode = PADCTRL_REG133_vi_dat2_sr_enum;
            reset = 0x1;
        } vi_dat2_sr[7:7];

        enum PADCTRL_REG133_vi_dat2_ds_enum {
            V_4_MA = 0 { name = "V 4 Ma"; desc = "4 mA"; };
            V_3_MA = 1 { name = "V 3 Ma"; desc = "3 mA"; };
            V_2_MA = 2 { name = "V 2 Ma"; desc = "2 mA"; };
            V_1_MA = 3 { name = "V 1 Ma"; desc = "1 mA"; };
        };

        field {
            name = "vi_dat2_ds";
            desc = "Drive current of the VI_DAT2 pin";
            sw = rw;
            hw = r;
            encode = PADCTRL_REG133_vi_dat2_ds_enum;
            reset = 0x2;
        } vi_dat2_ds[5:4];
    } PADCTRL_REG133 @ 0xA14;

    reg {
        name = "Drive capability register for the VI_DAT1 pin";
        desc = "PADCTRL_REG134 is a drive capability register for the VI_DAT1 pin.

Data sheet 2.6.2 PADCTRL_REG134 (offset 0x218, printed page 2-270, `hi3516av100--Hi3516A-Hi3516D-Datasheet.txt` line 16087).";

        enum PADCTRL_REG134_vi_dat1_sr_enum {
            FAST_EDGE = 0 { name = "Fast Edge"; desc = "fast edge"; };
            SLOW_EDGE = 1 { name = "Slow Edge"; desc = "slow edge"; };
        };

        field {
            name = "vi_dat1_sr";
            desc = "Level conversion rate of the VI_DAT1 pin";
            sw = rw;
            hw = r;
            encode = PADCTRL_REG134_vi_dat1_sr_enum;
            reset = 0x1;
        } vi_dat1_sr[7:7];

        enum PADCTRL_REG134_vi_dat1_ds_enum {
            V_4_MA = 0 { name = "V 4 Ma"; desc = "4 mA"; };
            V_3_MA = 1 { name = "V 3 Ma"; desc = "3 mA"; };
            V_2_MA = 2 { name = "V 2 Ma"; desc = "2 mA"; };
            V_1_MA = 3 { name = "V 1 Ma"; desc = "1 mA"; };
        };

        field {
            name = "vi_dat1_ds";
            desc = "Drive current of the VI_DAT1 pin";
            sw = rw;
            hw = r;
            encode = PADCTRL_REG134_vi_dat1_ds_enum;
            reset = 0x2;
        } vi_dat1_ds[5:4];
    } PADCTRL_REG134 @ 0xA18;

    reg {
        name = "Drive capability register for the VI_DAT0 pin";
        desc = "PADCTRL_REG135 is a drive capability register for the VI_DAT0 pin.

Data sheet 2.6.2 PADCTRL_REG135 (offset 0x21C, printed page 2-271, `hi3516av100--Hi3516A-Hi3516D-Datasheet.txt` line 16133).";

        enum PADCTRL_REG135_vi_dat0_sr_enum {
            FAST_EDGE = 0 { name = "Fast Edge"; desc = "fast edge"; };
            SLOW_EDGE = 1 { name = "Slow Edge"; desc = "slow edge"; };
        };

        field {
            name = "vi_dat0_sr";
            desc = "Level conversion rate of the VI_DAT0 pin";
            sw = rw;
            hw = r;
            encode = PADCTRL_REG135_vi_dat0_sr_enum;
            reset = 0x1;
        } vi_dat0_sr[7:7];

        enum PADCTRL_REG135_vi_dat0_ds_enum {
            V_4_MA = 0 { name = "V 4 Ma"; desc = "4 mA"; };
            V_3_MA = 1 { name = "V 3 Ma"; desc = "3 mA"; };
            V_2_MA = 2 { name = "V 2 Ma"; desc = "2 mA"; };
            V_1_MA = 3 { name = "V 1 Ma"; desc = "1 mA"; };
        };

        field {
            name = "vi_dat0_ds";
            desc = "Drive current of the VI_DAT0 pin";
            sw = rw;
            hw = r;
            encode = PADCTRL_REG135_vi_dat0_ds_enum;
            reset = 0x2;
        } vi_dat0_ds[5:4];
    } PADCTRL_REG135 @ 0xA1C;

};

`endif
