`include "defines.rdl"

`include "CRG.rdl"
`include "IO_CONFIG.rdl"
`include "MISC_CTRL.rdl"
`include "../common/ARM_GIC400.rdl"
`include "../common/ARM_PL011.rdl"
`include "../common/ARM_PL061.rdl"
`include "../common/HISI_AIAO.rdl"
`include "../common/HISI_CIPHER_MC.rdl"
`include "../common/HISI_DDRC_V2.rdl"
`include "../common/HISI_DDRT.rdl"
`include "../common/HISI_DMAC.rdl"
`include "../common/HISI_DWMMC.rdl"
`include "../common/HISI_GMAC.rdl"
`include "../common/HISI_I2C_DW.rdl"
`include "../common/HISI_IR.rdl"
`include "../common/HISI_IVE.rdl"
`include "../common/HISI_JPGE.rdl"
`include "../common/HISI_LSADC.rdl"
`include "../common/HISI_MIPI_RX_AV100.rdl"
`include "../common/HISI_MOTION_DETECT.rdl"
`include "../common/HISI_NANDC.rdl"
`include "../common/HISI_PWM.rdl"
`include "../common/HISI_RTC_SPI.rdl"
`include "../common/HISI_SFC_350.rdl"
`include "../common/HISI_SNFC.rdl"
`include "../common/HISI_SPI.rdl"
`include "../common/HISI_SYS_CTRL.rdl"
`include "../common/HISI_TDE.rdl"
`include "../common/HISI_TIMER_SP804.rdl"
`include "../common/HISI_USB_DEVICE.rdl"
`include "../common/HISI_USB_HOST.rdl"
`include "../common/HISI_VDP_AV100.rdl"
`include "../common/HISI_VEDU.rdl"
`include "../common/HISI_VEDU_V2.rdl"
`include "../common/HISI_VGS.rdl"
`include "../common/HISI_VICAP_AV100.rdl"
`include "../common/HISI_VPSS.rdl"
`include "../common/HISI_WDG_SP805.rdl"

addrmap hi3516av100 {
    name = "hi3516av100 registers";
    desc = "
        ## Datasheets

        * [Full Datasheet](assets/Hi3516A-Hi3516D-Datasheet.pdf)

        ## Board Information
        * [Demo Board User Guide](assets/Hi3516A-Hi3516D-Demo-Board-User-Guide.pdf)
        * [Demo Board User Guide (CN)](assets/Hi3516A-Hi3516D-Demo-Board-User-Guide-CN.pdf)
        * [Hardware Design Checklist](assets/Hi3516A-Hi3516D-Hardware-Design-Checklist.doc)
        * [Hardware Design Checklist (CN)](assets/Hi3516A-Hi3516D-Hardware-Design-Checklist-CN.doc)
        * [Hardware Design User Guide](assets/Hi3516A-Hi3516D-Hardware-Design-User-Guide.pdf)
        * [Hardware Design User Guide (CN)](assets/Hi3516A-Hi3516D-Hardware-Design-User-Guide-CN.pdf)
        * [Demo Board Files](assets/Hi3516A-DMEB-PERB.zip)

        ## Diagrams

        ![Application Block Diagram](assets/Hi3516A-Application-Block-Diagram.png)
        ![Logic Block Diagram](assets/Hi3516A-Logic-Block-Diagram.png)

        ## Addresses

        | Start Address | End Address | Description                                                                                                                 | Documented Here |
        |---------------|-------------|-----------------------------------------------------------------------------------------------------------------------------|-----------------|
        | 0xC0000000    | 0xFFFFFFFF  | Reserved - -                                                                                                                | &#10060;        |
        | 0x80000000    | 0xBFFFFFFF  | Address space of the connected external DDR. The Hi3516D supports only the 512 MB DDR. 1 GB                                 | &#10060;        |
        | 0x5C000000    | 0x7FFFFFFF  | Reserved - -                                                                                                                | &#10060;        |
        | 0x58000000    | 0x5BFFFFFF  | Storage space of the SPI NOR flash 64 MB                                                                                    | &#10060;        |
        | 0x54000000    | 0x57FFFFFF  | Storage space of the SPI NAND flash 64 MB                                                                                   | &#10060;        |
        | 0x50000000    | 0x53FFFFFF  | Storage space of the NAND flash 64 MB                                                                                       | &#10060;        |
        | 0x20700000    | 0x4FFFFFFF  | Reserved - -                                                                                                                | &#10060;        |
        | 0x206F0000    | 0x206FFFFF  | SDIO1 register 64 KB                                                                                                        | &#9989;         |
        | 0x206E0000    | 0x206EFFFF  | SDIO0 register 64 KB                                                                                                        | &#9989;         |
        | 0x206D0000    | 0x206DFFFF  | DDR test module 64 KB                                                                                                       | &#9989;         |
        | 0x206C0000    | 0x206CFFFF  | MD register 64 KB                                                                                                           | &#9989;         |
        | 0x206B0000    | 0x206BFFFF  | Reserved - -                                                                                                                | &#10060;        |
        | 0x206A0000    | 0x206AFFFF  | IVE register 64 KB                                                                                                          | &#9989;         |
        | 0x20690000    | 0x2069FFFF  | Reserved 64 KB                                                                                                              | &#10060;        |
        | 0x20680000    | 0x2068FFFF  | MIPI register 64 KB                                                                                                         | &#9989;         |
        | 0x20670000    | 0x2067FFFF  | Reserved - -                                                                                                                | &#10060;        |
        | 0x20660000    | 0x2066FFFF  | JPGE register 64 KB                                                                                                         | &#9989;        |
        | 0x20650000    | 0x2065FFFF  | AIO register 64 KB                                                                                                          | &#9989;         |
        | 0x20640000    | 0x2064FFFF  | VEDU register 64 KB                                                                                                         | &#9989;         |
        | 0x20630000    | 0x2063FFFF  | VGS register 64 KB                                                                                                          | &#9989;        |
        | 0x20620000    | 0x2062FFFF  | AVC register 64 KB (Hi3520D-layout VEDU, control registers cross-checked in hi3516a_h264e.ko) | &#9888; partial        |
        | 0x20610000    | 0x2061FFFF  | TDE register 64 KB                                                                                                          | &#9989;         |
        | 0x20600000    | 0x2060FFFF  | VPSS register 64 KB                                                                                                         | &#9989;         |
        | 0x205D0000    | 0x205FFFFF  | Reserved - -                                                                                                                | &#10060;        |
        | 0x205C0000    | 0x205CFFFF  | VDP register 64 KB                                                                                                          | &#9989;         |
        | 0x20580000    | 0x205BFFFF  | VICAP register 256 KB                                                                                                       | &#9989;         |
        | 0x20300000    | 0x2030FFFF  | GIC internal register 64 KB                                                                                                 | &#9989;         |
        | 0x20280000    | 0x2057FFFF  | Reserved - -                                                                                                                | &#10060;        |
        | 0x20270000    | 0x2027FFFF  | PMC register 64 KB                                                                                                          | &#10060;        |
        | 0x20260000    | 0x2026FFFF  | GPIO15 register 64 KB                                                                                                       | &#9989;         |
        | 0x20250000    | 0x2025FFFF  | I2C2 register 64 KB                                                                                                         | &#9989;         |
        | 0x20240000    | 0x2024FFFF  | I2C1 register 64 KB                                                                                                         | &#9989;         |
        | 0x20230000    | 0x2023FFFF  | UART3 register 64 KB                                                                                                        | &#9989;         |
        | 0x20220000    | 0x2022FFFF  | GPIO14 register 64 KB                                                                                                       | &#9989;         |
        | 0x20210000    | 0x2021FFFF  | GPIO13 register 64 KB                                                                                                       | &#9989;         |
        | 0x20200000    | 0x2020FFFF  | GPIO12 register 64 KB                                                                                                       | &#9989;         |
        | 0x201F0000    | 0x201FFFFF  | GPIO11 register 64 KB                                                                                                       | &#9989;         |
        | 0x201E0000    | 0x201EFFFF  | GPIO10 register 64 KB                                                                                                       | &#9989;         |
        | 0x201D0000    | 0x201DFFFF  | GPIO9 register 64 KB                                                                                                        | &#9989;         |
        | 0x201C0000    | 0x201CFFFF  | GPIO8 register 64 KB                                                                                                        | &#9989;         |
        | 0x201B0000    | 0x201BFFFF  | GPIO7 register 64 KB                                                                                                        | &#9989;         |
        | 0x201A0000    | 0x201AFFFF  | GPIO6 register 64 KB                                                                                                        | &#9989;         |
        | 0x20190000    | 0x2019FFFF  | GPIO5 register 64 KB                                                                                                        | &#9989;         |
        | 0x20180000    | 0x2018FFFF  | GPIO4 register 64 KB                                                                                                        | &#9989;         |
        | 0x20170000    | 0x2017FFFF  | GPIO3 register 64 KB                                                                                                        | &#9989;         |
        | 0x20160000    | 0x2016FFFF  | GPIO2 register 64 KB                                                                                                        | &#9989;         |
        | 0x20150000    | 0x2015FFFF  | GPIO1 register 64 KB                                                                                                        | &#9989;         |
        | 0x20140000    | 0x2014FFFF  | GPIO0 register 64 KB                                                                                                        | &#9989;         |
        | 0x20132000    | 0x2013FFFF  | Reserved - -                                                                                                                | &#10060;        |
        | 0x20131000    | 0x20131FFF  | PWM4−7 register4 KB-                                                                                                        | &#9989;         |
        | 0x20130000    | 0x20130FFF  | PWM0−3 register4 KB-                                                                                                        | &#9989;         |
        | 0x20120000    | 0x2012FFFF  | MISC register 64 KB                                                                                                         | &#9989;         |
        | 0x20110000    | 0x2011FFFF  | DDRC/DDR PHY register 64 KB-                                                                                                | &#9989;         |
        | 0x20100000    | 0x2010FFFF  | Reserved 64 KB                                                                                                              | &#10060;        |
        | 0x200F0800    | 0x200FFFFF  | IO CTR register 62 KB                                                                                                       | &#10060;        |
        | 0x200F0000    | 0x200F07FF  | IO MUX register2  KB                                                                                                        | &#9989;         |
        | 0x200E0000    | 0x200EFFFF  | SPI1 register 64 KB                                                                                                         | &#9989;         |
        | 0x200D0000    | 0x200DFFFF  | I C0 register 64 KB                                                                                                         | &#9989;         |
        | 0x200C0000    | 0x200CFFFF  | SPI0 register 64 KB                                                                                                         | &#9989;         |
        | 0x200B0000    | 0x200BFFFF  | SAR_ADC register 64 KB-                                                                                                     | &#9989;         |
        | 0x200A0000    | 0x200AFFFF  | UART2 register 64 KB                                                                                                        | &#9989;         |
        | 0x20090000    | 0x2009FFFF  | UART1 register 64 KB                                                                                                        | &#9989;         |
        | 0x20080000    | 0x2008FFFF  | UART0 register 64 KB                                                                                                        | &#9989;         |
        | 0x20070000    | 0x2007FFFF  | IR register 64 KB                                                                                                           | &#9989;         |
        | 0x20060000    | 0x2006FFFF  | RTC register 64 KB                                                                                                          | &#9989;         |
        | 0x20050000    | 0x2005FFFF  | SYS_CTRL register 64 KB-                                                                                                    | &#9989;         |
        | 0x20040000    | 0x2004FFFF  | WDG register 64 KB                                                                                                          | &#9989;         |
        | 0x20030000    | 0x2003FFFF  | CRG register 64 KB                                                                                                          | &#9989;         |
        | 0x20020000    | 0x2002FFFF  | Reserved 64 KB                                                                                                              | &#10060;        |
        | 0x20010000    | 0x2001FFFF  | Timer 2/Timer 3 register 64 KB-                                                                                             | &#9989;         |
        | 0x20000000    | 0x2000FFFF  | Timer 0/Timer 1 register 64 KB-                                                                                             | &#9989;         |
        | 0x100D0000    | 0x1FFFFFFF  | Reserved - -                                                                                                                | &#10060;        |
        | 0x100C0000    | 0x100CFFFF  | Cipher register 64 KB                                                                                                       | &#9989;         |
        | 0x100B0000    | 0x100BFFFF  | USB EHCI register 64 KB                                                                                                     | &#9989;         |
        | 0x100A0000    | 0x100AFFFF  | USB OHCI register 64 KB                                                                                                     | &#9989;         |
        | 0x10090000    | 0x1009FFFF  | GSF register 64 KB                                                                                                          | &#9989;         |
        | 0x10080000    | 0x1008FFFF  | USB device register 64 KB                                                                                                   | &#9989;         |
        | 0x10070000    | 0x1007FFFF  | Reserved 64 KB                                                                                                              | &#10060;        |
        | 0x10060000    | 0x1006FFFF  | DMAC register 64 KB                                                                                                         | &#9989;         |
        | 0x10050000    | 0x1005FFFF  | Reserved 64 KB                                                                                                              | &#10060;        |
        | 0x10040000    | 0x1004FFFF  | SPI NAND flash control register 64 KB                                                                                       | &#9989;         |
        | 0x10020000    | 0x1003FFFF  | Reserved - -                                                                                                                | &#10060;        |
        | 0x10010000    | 0x1001FFFF  | SPI NOR flash control register 64 KB                                                                                        | &#9989;         |
        | 0x10000000    | 0x1000FFFF  | NAND flash control register 64 KB                                                                                           | &#9989;         |
        | 0x04020000    | 0x0FFFFFFF  | Reserved - -                                                                                                                | &#10060;        |
        | 0x04010000    | 0x0401FFFF  | On-chip RAM 64 KB                                                                                                           | &#10060;        |
        | 0x04000000    | 0x0400FFFF  | BOOTROM 64 KB                                                                                                               | &#10060;        |
        | 0x00000000    | 0x03FFFFFF  | Memory selected after address remapping is cleared. The address points to the on-chip RAM after remapping is cleared. 64 MB | &#10060;        |

        <!-- overview:begin -->

        ### Diagrams

        ![Register blocks by function](assets/diagrams/hi3516av100-blocks.svg)

        ### Interrupts (Cortex-A7 GIC interrupt IDs, data sheet Table 3-8)

        | # | Source | # | Source | # | Source |
        |---|---|---|---|---|---|
        | 0-31 | For A7 internal use | 53 | USB_EHCI | 75 | VEDU (265) |
        | 32 | COMMTX[0] | 54 | USB_OHCI | 76 | MD |
        | 33 | COMMRX[0] | 55 | USB_DEV | 77 | IVE |
        | 34 | Watchdog | 56 | SFC_NAND | 78 | Reserved |
        | 35 | Timer01 | 57 | GSF | 79 | GPIO0 |
        | 36 | Timer23 | 58 | Cipher | 80 | GPIO1 |
        | 37 | DMAC | 59 | Reserved | 81 | GPIO2/ GPIO15 |
        | 38 | Reserved | 60 | Software int | 82 | GPIO3/ GPIO14 |
        | 39 | RTC | 61 | Reserved | 83 | GPIO4/ GPIO13 |
        | 40 | UART0 | 62 | Reserved | 84 | GPIO5/ GPIO12 |
        | 41 | UART1 | 63 | Reserved | 85 | GPIO6/ GPIO11 |
        | 42 | UART2 | 64 | A7_PMU_INT0 | 86 | GPIO7/ GPIO10 |
        | 43 | UART3 | 65 | VDP | 87 | GPIO8/ GPIO9 |
        | 44 | SSP0 | 66 | MIPI | 88 | tem_cap_int |
        | 45 | SSP1 | 67 | VICAP | 89 | I2C1 |
        | 46 | I2C | 68 | VPSS | 90 | I2C2 |
        | 47 | IR | 69 | TDE | 91 | Reserved |
        | 48 | SAR_ADC | 70 | VGS | 92 | Reserved |
        | 49 | SFC_NOR | 71 | AIO | 93 | Reserved |
        | 50 | NFC | 72 | AVC (264) | 94 | Reserved |
        | 51 | SDIO0 | 73 | JPGE | 95 | Reserved |
        | 52 | SDIO1 | 74 | Reserved |  |  |

        ### Clock-gate and reset map (generated from the CRG registers)

        | Offset | Register | Description | Gate / reset fields |
        |---|---|---|---|
        | 0x02C | PERI_CRG11 | VICAP and MIPI CTRL clock and reset configuration register | vi_cken, vi_srst_req, vi_hrst_req, mipi_srst_req, isp_core_srst_req, isp_cfg_srst_req, sensor_cken, sensor_srst_req |
        | 0x034 | PERI_CRG13 | VOU clock and reset control register | vo_srst_req, vo_cfg_cken, vo_ppc_cken, vo_pcken, vo_out_cken, vou_acken, vou_hd_cken, vou_sd_cken, dac_cken |
        | 0x038 | PERI_CRG14 | PWM clock and reset control register | pwm_srst_req, pwm_cken |
        | 0x040 | PERI_CRG16 | VEDU clock and soft reset control register | vedu_srst_req, vedu_cken, avc_srst_req, avc_cken |
        | 0x048 | PERI_CRG18 | VPSS clock and reset control register | vps_srst_req, vps_cken |
        | 0x058 | PERI_CRG22 | TDE clock and soft reset control register | tde_srst_req, tde_cken |
        | 0x05C | PERI_CRG23 | VGS clock and soft reset control register | vgs_srst_req, vgs_cken |
        | 0x060 | PERI_CRG24 | JPGE clock and soft reset control register | jpge_srst_req, jpge_cken |
        | 0x068 | PERI_CRG26 | MDU clock and soft reset control register | mdu_srst_req, mdu_cken |
        | 0x06C | PERI_CRG27 | IVE clock and soft reset control register | ive_srst_req, ive_cken |
        | 0x07C | PERI_CRG31 | SAR_ADC and cipher clock and soft reset control register | cipher_srst_req, cipher_cken, sar_adc_srst_req |
        | 0x08C | PERI_CRG35 | AIO clock and soft reset control register | aio_srst_req, aiao_cken |
        | 0x0B8 | PERI_CRG46 | USB clock and soft reset control register | usb_ahb_srst_req, usb_cken, usb_device_ctrl_srst_req |
        | 0x0C0 | PERI_CRG48 | SFC clock and soft reset control register | sfc_srst_req, sfc_cken, sfc_nand_srst_req, sfc_nand_cken |
        | 0x0C4 | PERI_CRG49 | SDIO0/SDIO1 clock and soft reset control register | sdio0_srst_req, sdio0_cken, sdio1_srst_req, sdio1_cken |
        | 0x0CC | PERI_CRG51 | GSF/GMAC/FE PHY clock and soft reset control register | gsf_srst_req, gsf_cken, gmac_if_srst_req, gmac_if_cken |
        | 0x0D0 | PERI_CRG52 | NANDC clock and soft reset control register | nfc_srst_req, nfc_cken |
        | 0x0D8 | PERI_CRG54 | DMA/DDRTEST/eFUSE clock and soft reset control register | efuse_srst_req, efuse_cken, ddrtest_srst_req, ddrtest_cken, dma_srst_req, dma_cken |
        | 0x0E4 | PERI_CRG57 | Soft reset control register for other CRG interface modules | test_clk_en, i2c_srst_req, tcap_srst_req, ir_srst_req, ssp0_srst_req, ssp1_srst_req, uart0_srst_req, uart1_srst_req, uart2_srst_req, uart3_srst_req, ... |
        | 0x10C | PERI_CRG67 | BPLL spread spectrum configuration register | bpll_ssmod_cken, bpll_ssmod_rst_req |
        | 0x110 | PERI_CRG68 | VPLL spread spectrum configuration register | vpll_ssmod_cken, vpll_ssmod_rst_req |
        | 0x118 | PERI_CRG70 | EPLL spread spectrum configuration register | epll_ssmod_cken, epll_ssmod_rst_req |
        | 0x12C | PERI_CRG75 | Core high performance monitor | core_hpm_en, core_hpm_monitor_en, core_hpm_srst_req |

        Only fields whose names contain a clock-enable or reset keyword are listed; the field descriptions in the register pages give the polarity and the clocks they gate.

        ### Register blocks (generated from this description)

        | Base | Instance | Block | Register space |
        |---|---|---|---|
        | 0x10000000 | NANDC | HiSilicon parallel NAND flash controller (hinfc300/301/504 family) | 208 B |
        | 0x10010000 | SFC | System Flash Controller Registers | 1088 B |
        | 0x10040000 | SNFC | HiSilicon SPI NAND flash controller (hisnfc100) | 112 B |
        | 0x10060000 | DMAC | HiSilicon DMA controller (PL080-compatible, 4 or 8 channels) | 384 B |
        | 0x10080000 | USB_DEV | HiSilicon USB 2.0 device controller (DesignWare DWC_otg, device mode) | 3328 B |
        | 0x10090000 | ETH | HiSilicon GSF gigabit Ethernet MAC with descriptor queues and MDIO | 2596 B |
        | 0x100A0000 | OHCI | HiSilicon USB 2.0 host controller - OHCI | 92 B |
        | 0x100B0000 | EHCI | HiSilicon USB 2.0 host controller - EHCI | 176 B |
        | 0x100C0000 | CIPHER | CIPHER (8 channels) | 5184 B |
        | 0x20000000 | TIMER0 | Timer Registers | 28 B |
        | 0x20000020 | TIMER1 | Timer Registers | 28 B |
        | 0x20010000 | TIMER2 | Timer Registers | 28 B |
        | 0x20010020 | TIMER3 | Timer Registers | 28 B |
        | 0x20030000 | CRG | Clock and reset generator (CRG), Hi3516A V100 / Hi3516D V100 | 304 B |
        | 0x20040000 | WDG | Watchdog Registers | 3076 B |
        | 0x20050000 | SYS_CTRL | System Controller Registers | 3824 B |
        | 0x20060000 | RTC | HiSilicon SPI-bridged RTC (APB registers) | 164 B |
        | 0x20070000 | IR | HiSilicon IR receiver | 56 B |
        | 0x20080000 | UART0 | UART (ARM PrimeCell PL011) | 4 KB |
        | 0x20090000 | UART1 | UART (ARM PrimeCell PL011) | 4 KB |
        | 0x200A0000 | UART2 | UART (ARM PrimeCell PL011) | 4 KB |
        | 0x200B0000 | LSADC | HiSilicon LSADC controller (SAR ADC, 4 channels) | 36 B |
        | 0x200C0000 | SPI0 | SPI Registers | 48 B |
        | 0x200D0000 | I2C0 | HiSilicon I2C Master Controller (DesignWare-style register map) | 196 B |
        | 0x200E0000 | SPI1 | SPI Registers | 48 B |
        | 0x200F0000 | IO_CONFIG | IO configuration (pin multiplexing and pad control), Hi3516A/Hi3516D V100 | 2592 B |
        | 0x20110000 | DDRC | HiSilicon DDRC V2 (DDR2/DDR3 controller and DDR PHY, Hi3518E V20X / Hi3516C V200 / Hi3516A/D V100 / Hi3516C V300) | 34876 B |
        | 0x20120000 | MISC_CTRL | Miscellaneous control (MISC_CTRL), Hi3516A V100 / Hi3516D V100 | 228 B |
        | 0x20130000 | PWM0_3 | HiSilicon PWM group | 128 B |
        | 0x20131000 | PWM4_7 | HiSilicon PWM group | 128 B |
        | 0x20140000 | GPIO0 | ARM PL061 | 1053 B |
        | 0x20150000 | GPIO1 | ARM PL061 | 1053 B |
        | 0x20160000 | GPIO2 | ARM PL061 | 1053 B |
        | 0x20170000 | GPIO3 | ARM PL061 | 1053 B |
        | 0x20180000 | GPIO4 | ARM PL061 | 1053 B |
        | 0x20190000 | GPIO5 | ARM PL061 | 1053 B |
        | 0x201A0000 | GPIO6 | ARM PL061 | 1053 B |
        | 0x201B0000 | GPIO7 | ARM PL061 | 1053 B |
        | 0x201C0000 | GPIO8 | ARM PL061 | 1053 B |
        | 0x201D0000 | GPIO9 | ARM PL061 | 1053 B |
        | 0x201E0000 | GPIO10 | ARM PL061 | 1053 B |
        | 0x201F0000 | GPIO11 | ARM PL061 | 1053 B |
        | 0x20200000 | GPIO12 | ARM PL061 | 1053 B |
        | 0x20210000 | GPIO13 | ARM PL061 | 1053 B |
        | 0x20220000 | GPIO14 | ARM PL061 | 1053 B |
        | 0x20230000 | UART3 | UART (ARM PrimeCell PL011) | 4 KB |
        | 0x20240000 | I2C1 | HiSilicon I2C Master Controller (DesignWare-style register map) | 196 B |
        | 0x20250000 | I2C2 | HiSilicon I2C Master Controller (DesignWare-style register map) | 196 B |
        | 0x20260000 | GPIO15 | ARM PL061 | 1053 B |
        | 0x20300000 | GIC | Generic interrupt controller (ARM GIC-400, GICv2) | 12292 B |
        | 0x20580000 | VICAP | VICAP (video capture and ISP, Hi3516A V100 / Hi3516D V100) | 103 KB |
        | 0x205C0000 | VDP | HiSilicon video display processor (Hi3516A/D V100) | 62292 B |
        | 0x20600000 | VPSS | HiSilicon VPSS (registers not described) | 64 KB |
        | 0x20610000 | TDE | HiSilicon TDE, Hi3516A/D and Hi3518E V200 / Hi3516C V200 generation (vendor-derived) | 2160 B |
        | 0x20620000 | AVC | HiSilicon VEDU (Hi3520D V100 edition, vendor-derived registers) | 64 KB |
        | 0x20630000 | VGS | HiSilicon VGS (registers not described) | 64 KB |
        | 0x20640000 | VEDU | HiSilicon VEDU, H.265/H.264 generation V2 (control registers, vendor-derived) | 68 B |
        | 0x20650000 | AIAO | AIAO (audio input/output) | 8368 B |
        | 0x20660000 | JPGE | HiSilicon JPEG encoder (JPGE, r004 register layout) | 4288 B |
        | 0x20680000 | MIPI | MIPI RX (sensor serial interface receiver, Hi3516A/D V100) | 5672 B |
        | 0x206A0000 | IVE | HiSilicon intelligent video engine | 140 B |
        | 0x206C0000 | MOTION_DETECT | Motion Detect Unit Registers | 188 B |
        | 0x206D0000 | DDRT | HiSilicon DDR test module | 132 B |
        | 0x206E0000 | SDIO0 | HiSilicon MMC/SD/SDIO controller (DesignWare-MMC based, himciv200) | 516 B |
        | 0x206F0000 | SDIO1 | HiSilicon MMC/SD/SDIO controller (DesignWare-MMC based, himciv200) | 516 B |

        The table is generated from the elaborated root (instances at their absolute addresses; register space is the span of the block's registers, not the data sheet window).

        <!-- overview:end -->
    ";

    eHISI_NANDC         NANDC           @ 0x10000000;
    eHISI_SFC_350       SFC             @ 0x10010000;
    eHISI_SNFC          SNFC            @ 0x10040000;
    eHISI_DMAC          DMAC            @ 0x10060000;
    eHISI_USB_DEVICE    USB_DEV         @ 0x10080000;
    eHISI_GMAC          ETH             @ 0x10090000;
    eHISI_USB_OHCI      OHCI            @ 0x100A0000;
    eHISI_USB_EHCI      EHCI            @ 0x100B0000;
    eHISI_CIPHER_MC     CIPHER          @ 0x100C0000;
    eHISI_TIMER_SP804   TIMER0          @ 0x20000000;
    eHISI_TIMER_SP804   TIMER1          @ 0x20000020;
    eCRG                CRG             @ 0x20030000;
    eHISI_IR            IR              @ 0x20070000;
    eARM_PL011          UART0           @ 0x20080000;
    eARM_PL011          UART1           @ 0x20090000;
    eARM_PL011          UART2           @ 0x200A0000;
    eHISI_LSADC         LSADC           @ 0x200B0000;
    eHISI_SPI           SPI0            @ 0x200C0000;
    eHISI_I2C_DW        I2C0            @ 0x200D0000;
    eHISI_SPI           SPI1            @ 0x200E0000;
    eHISI_TIMER_SP804   TIMER2          @ 0x20010000;
    eHISI_TIMER_SP804   TIMER3          @ 0x20010020;
    eHISI_WDG_SP805     WDG             @ 0x20040000;
    eSYS_CTRL           SYS_CTRL        @ 0x20050000;
    eHISI_RTC_SPI       RTC             @ 0x20060000;
    eIO_CONFIG          IO_CONFIG       @ 0x200F0000;
    eHISI_DDRC_V2       DDRC            @ 0x20110000;
    eMISC_CTRL          MISC_CTRL       @ 0x20120000;
    eHISI_PWM_GRP       PWM0_3          @ 0x20130000;
    eHISI_PWM_GRP       PWM4_7          @ 0x20131000;
    eARM_PL061          GPIO0           @ 0x20140000;
    eARM_PL061          GPIO1           @ 0x20150000;
    eARM_PL061          GPIO2           @ 0x20160000;
    eARM_PL061          GPIO3           @ 0x20170000;
    eARM_PL061          GPIO4           @ 0x20180000;
    eARM_PL061          GPIO5           @ 0x20190000;
    eARM_PL061          GPIO6           @ 0x201A0000;
    eARM_PL061          GPIO7           @ 0x201B0000;
    eARM_PL061          GPIO8           @ 0x201C0000;
    eARM_PL061          GPIO9           @ 0x201D0000;
    eARM_PL061          GPIO10          @ 0x201E0000;
    eARM_PL061          GPIO11          @ 0x201F0000;
    eARM_PL061          GPIO12          @ 0x20200000;
    eARM_PL061          GPIO13          @ 0x20210000;
    eARM_PL061          GPIO14          @ 0x20220000;
    eARM_PL011          UART3           @ 0x20230000;
    eHISI_I2C_DW        I2C1            @ 0x20240000;
    eHISI_I2C_DW        I2C2            @ 0x20250000;
    eARM_PL061          GPIO15          @ 0x20260000;
    eARM_GIC400         GIC             @ 0x20300000;
    eHISI_VICAP_AV100   VICAP           @ 0x20580000;
    eHISI_VDP_AV100     VDP             @ 0x205C0000;
    aHISI_VPSS          VPSS            @ 0x20600000;
    eHISI_TDE_G2          TDE             @ 0x20610000;
    aHISI_VEDU_V2       VEDU            @ 0x20640000;
    aHISI_VEDU_V100     AVC             @ 0x20620000;
    aHISI_VGS           VGS             @ 0x20630000;
    eHISI_AIAO          AIAO            @ 0x20650000;
    eHISI_JPGE          JPGE            @ 0x20660000;
    eHISI_MIPI_RX_AV100 MIPI            @ 0x20680000;
    eHISI_IVE           IVE             @ 0x206A0000;
    eMOTION_DETECT      MOTION_DETECT   @ 0x206C0000;
    eHISI_DDRT          DDRT            @ 0x206D0000;
    eHISI_DWMMC         SDIO0           @ 0x206E0000;
    eHISI_DWMMC         SDIO1           @ 0x206F0000;
};
