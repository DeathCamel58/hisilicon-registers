`ifndef HI3516EV300_VEDU_RDL
`define HI3516EV300_VEDU_RDL

regfile eVEDU_V4_EV300 {
    name = "VEDU H.264/H.265 encoder, EV200/EV300 generation (subset)";
    desc = "VEDU at 0x11410000 (SPI 47). Only the MMIO registers the vendor driver writes per picture are listed; the bulk of the configuration is a register image in DDR (REG_IMAGE). Not a full register description.";

    reg {
        name = "Interrupt mask";
        desc = "Bit 0: end of picture. Source: OpenIPC qemu-bench docs/hisilicon-venc.md (reverse engineering of the SDK driver objects hi_vedu.o / hi_vpss.o / hi_vi.o plus a model that runs the unmodified vendor driver stack); not read from hardware. Evidence: INFERRED.";
        field {
            name = "end_of_pic";
            desc = "End-of-picture interrupt enable.";
            sw = rw;
            hw = r;
        } end_of_pic[0:0];
    } INTMASK @ 0x0;

    reg {
        name = "Interrupt clear";
        desc = "Write 1s to clear. Source: OpenIPC qemu-bench docs/hisilicon-venc.md (reverse engineering of the SDK driver objects hi_vedu.o / hi_vpss.o / hi_vi.o plus a model that runs the unmodified vendor driver stack); not read from hardware. Evidence: INFERRED.";
        field {
            name = "clr";
            desc = "Clear bits.";
            sw = w;
            hw = r;
        } clr[31:0];
    } INTCLR @ 0x4;

    reg {
        name = "Start";
        desc = "Write 1 to start a picture. Source: OpenIPC qemu-bench docs/hisilicon-venc.md (reverse engineering of the SDK driver objects hi_vedu.o / hi_vpss.o / hi_vi.o plus a model that runs the unmodified vendor driver stack); not read from hardware. Evidence: INFERRED.";
        field {
            name = "start";
            desc = "Start encoding.";
            sw = w;
            hw = r;
        } start[0:0];
    } START @ 0x8;

    reg {
        name = "Encoder mode";
        desc = "Values seen: 0x40071116 (H.264), 0x400103D2 (H.265). Source: OpenIPC qemu-bench docs/hisilicon-venc.md (reverse engineering of the SDK driver objects hi_vedu.o / hi_vpss.o / hi_vi.o plus a model that runs the unmodified vendor driver stack); not read from hardware. Evidence: INFERRED.";
        field {
            name = "mode";
            desc = "Raw value";
            sw = rw;
            hw = r;
        } mode[31:0];
    } MODE @ 0x10;

    reg {
        name = "Picture size";
        desc = "(width - 1) | (height - 1) << 16. Source: OpenIPC qemu-bench docs/hisilicon-venc.md (reverse engineering of the SDK driver objects hi_vedu.o / hi_vpss.o / hi_vi.o plus a model that runs the unmodified vendor driver stack); not read from hardware. Evidence: INFERRED.";
        field {
            name = "width_m1";
            desc = "Width - 1.";
            sw = rw;
            hw = r;
        } width_m1[15:0];
        field {
            name = "height_m1";
            desc = "Height - 1.";
            sw = rw;
            hw = r;
        } height_m1[31:16];
    } PIC_SIZE @ 0x14;

    reg {
        name = "Reset request";
        desc = "Reset request; BUS_IDLE is polled around a reset. Source: OpenIPC qemu-bench docs/hisilicon-venc.md (reverse engineering of the SDK driver objects hi_vedu.o / hi_vpss.o / hi_vi.o plus a model that runs the unmodified vendor driver stack); not read from hardware. Evidence: INFERRED.";
        field {
            name = "reset";
            desc = "Raw value";
            sw = rw;
            hw = r;
        } reset[31:0];
    } RESET @ 0x4C;

    reg {
        name = "Register image address";
        desc = "Physical address of the configuration image in DDR (laid out like the MMIO space; image offsets 0x104/0x108 source luma/chroma, 0x12C/0x130 ring pointer cells, 0x16C ring base, 0x1F4 source strides, 0x4A0 ring size, 0x61C slice QP). Source: OpenIPC qemu-bench docs/hisilicon-venc.md (reverse engineering of the SDK driver objects hi_vedu.o / hi_vpss.o / hi_vi.o plus a model that runs the unmodified vendor driver stack); not read from hardware. Evidence: INFERRED.";
        field {
            name = "addr";
            desc = "Raw value";
            sw = rw;
            hw = r;
        } addr[31:0];
    } REG_IMAGE @ 0x58;

    reg {
        name = "Masked interrupt status";
        desc = "Bit 0 end of picture, 2 buffer full, 3 bits over, 6 timeout. Source: OpenIPC qemu-bench docs/hisilicon-venc.md (reverse engineering of the SDK driver objects hi_vedu.o / hi_vpss.o / hi_vi.o plus a model that runs the unmodified vendor driver stack); not read from hardware. Evidence: INFERRED.";
        field {
            name = "status";
            desc = "Raw value";
            sw = rw;
            hw = r;
        } status[31:0];
    } INTSTAT @ 0x3000;

    reg {
        name = "Raw interrupt status";
        desc = "Bit 11 ring full, 12 ring back (plus the INTSTAT bits). Source: OpenIPC qemu-bench docs/hisilicon-venc.md (reverse engineering of the SDK driver objects hi_vedu.o / hi_vpss.o / hi_vi.o plus a model that runs the unmodified vendor driver stack); not read from hardware. Evidence: INFERRED.";
        field {
            name = "raw";
            desc = "Raw value";
            sw = rw;
            hw = r;
        } raw[31:0];
    } RAWINT @ 0x3004;

    reg {
        name = "Bus idle";
        desc = "Bit 0: idle. Source: OpenIPC qemu-bench docs/hisilicon-venc.md (reverse engineering of the SDK driver objects hi_vedu.o / hi_vpss.o / hi_vi.o plus a model that runs the unmodified vendor driver stack); not read from hardware. Evidence: INFERRED.";
        field {
            name = "idle";
            desc = "Bus idle.";
            sw = r;
            hw = w;
        } idle[0:0];
    } BUS_IDLE @ 0x3010;

};

`endif
`ifndef HI3516EV300_JPGE_RDL
`define HI3516EV300_JPGE_RDL

regfile eJPGE_V4_EV300 {
    name = "JPEG encoder, EV200/EV300 generation (subset)";
    desc = "JPGE at 0x11420000 (SPI 48), programmed directly over MMIO (no register image). Quantizer tables: 0x800 / 0x900 / 0xA00 = Y / Cb / Cr as 2^23 / q (not modelled in this subset). Not a full register description.";

    reg {
        name = "Status";
        desc = "0 done, 1 error, 5 ring full, 7 ring back. Source: OpenIPC qemu-bench docs/hisilicon-venc.md (reverse engineering of the SDK driver objects hi_vedu.o / hi_vpss.o / hi_vi.o plus a model that runs the unmodified vendor driver stack); not read from hardware. Evidence: INFERRED.";
        field {
            name = "status";
            desc = "Raw value";
            sw = rw;
            hw = r;
        } status[31:0];
    } STATUS @ 0x0;

    reg {
        name = "Interrupt enable";
        desc = "The driver writes 3. Source: OpenIPC qemu-bench docs/hisilicon-venc.md (reverse engineering of the SDK driver objects hi_vedu.o / hi_vpss.o / hi_vi.o plus a model that runs the unmodified vendor driver stack); not read from hardware. Evidence: INFERRED.";
        field {
            name = "en";
            desc = "Raw value";
            sw = rw;
            hw = r;
        } en[31:0];
    } INT_EN @ 0x4;

    reg {
        name = "Raw status";
        desc = " Source: OpenIPC qemu-bench docs/hisilicon-venc.md (reverse engineering of the SDK driver objects hi_vedu.o / hi_vpss.o / hi_vi.o plus a model that runs the unmodified vendor driver stack); not read from hardware. Evidence: INFERRED.";
        field {
            name = "raw";
            desc = "Raw value";
            sw = rw;
            hw = r;
        } raw[31:0];
    } RAW_STATUS @ 0x8;

    reg {
        name = "Interrupt clear";
        desc = "The driver writes 0xFFFFFFFF. Source: OpenIPC qemu-bench docs/hisilicon-venc.md (reverse engineering of the SDK driver objects hi_vedu.o / hi_vpss.o / hi_vi.o plus a model that runs the unmodified vendor driver stack); not read from hardware. Evidence: INFERRED.";
        field {
            name = "clr";
            desc = "Clear bits.";
            sw = w;
            hw = r;
        } clr[31:0];
    } CLEAR @ 0xC;

    reg {
        name = "Start";
        desc = "Write 0, then 1. Source: OpenIPC qemu-bench docs/hisilicon-venc.md (reverse engineering of the SDK driver objects hi_vedu.o / hi_vpss.o / hi_vi.o plus a model that runs the unmodified vendor driver stack); not read from hardware. Evidence: INFERRED.";
        field {
            name = "start";
            desc = "Start.";
            sw = w;
            hw = r;
        } start[0:0];
    } START @ 0x2C;

    reg {
        name = "Picture size";
        desc = "(width - 1) | (height - 1) << 16. Source: OpenIPC qemu-bench docs/hisilicon-venc.md (reverse engineering of the SDK driver objects hi_vedu.o / hi_vpss.o / hi_vi.o plus a model that runs the unmodified vendor driver stack); not read from hardware. Evidence: INFERRED.";
        field {
            name = "width_m1";
            desc = "Width - 1.";
            sw = rw;
            hw = r;
        } width_m1[15:0];
        field {
            name = "height_m1";
            desc = "Height - 1.";
            sw = rw;
            hw = r;
        } height_m1[31:16];
    } PIC_SIZE @ 0x34;

    reg {
        name = "Stream ring size";
        desc = " Source: OpenIPC qemu-bench docs/hisilicon-venc.md (reverse engineering of the SDK driver objects hi_vedu.o / hi_vpss.o / hi_vi.o plus a model that runs the unmodified vendor driver stack); not read from hardware. Evidence: INFERRED.";
        field {
            name = "size";
            desc = "Raw value";
            sw = rw;
            hw = r;
        } size[31:0];
    } RING_SIZE @ 0x60;

    reg {
        name = "Reset request";
        desc = "Bit 0. Source: OpenIPC qemu-bench docs/hisilicon-venc.md (reverse engineering of the SDK driver objects hi_vedu.o / hi_vpss.o / hi_vi.o plus a model that runs the unmodified vendor driver stack); not read from hardware. Evidence: INFERRED.";
        field {
            name = "reset";
            desc = "Reset request.";
            sw = rw;
            hw = r;
        } reset[0:0];
    } RESET @ 0x68;

    reg {
        name = "Strides";
        desc = "luma | chroma << 16. Source: OpenIPC qemu-bench docs/hisilicon-venc.md (reverse engineering of the SDK driver objects hi_vedu.o / hi_vpss.o / hi_vi.o plus a model that runs the unmodified vendor driver stack); not read from hardware. Evidence: INFERRED.";
        field {
            name = "luma";
            desc = "Luma stride.";
            sw = rw;
            hw = r;
        } luma[15:0];
        field {
            name = "chroma";
            desc = "Chroma stride.";
            sw = rw;
            hw = r;
        } chroma[31:16];
    } STRIDE @ 0x164;

    reg {
        name = "Source luma address";
        desc = "NV21 source. Source: OpenIPC qemu-bench docs/hisilicon-venc.md (reverse engineering of the SDK driver objects hi_vedu.o / hi_vpss.o / hi_vi.o plus a model that runs the unmodified vendor driver stack); not read from hardware. Evidence: INFERRED.";
        field {
            name = "addr";
            desc = "Raw value";
            sw = rw;
            hw = r;
        } addr[31:0];
    } SRC_Y @ 0x200;

    reg {
        name = "Source chroma address";
        desc = " Source: OpenIPC qemu-bench docs/hisilicon-venc.md (reverse engineering of the SDK driver objects hi_vedu.o / hi_vpss.o / hi_vi.o plus a model that runs the unmodified vendor driver stack); not read from hardware. Evidence: INFERRED.";
        field {
            name = "addr";
            desc = "Raw value";
            sw = rw;
            hw = r;
        } addr[31:0];
    } SRC_C @ 0x204;

    reg {
        name = "Stream ring base";
        desc = " Source: OpenIPC qemu-bench docs/hisilicon-venc.md (reverse engineering of the SDK driver objects hi_vedu.o / hi_vpss.o / hi_vi.o plus a model that runs the unmodified vendor driver stack); not read from hardware. Evidence: INFERRED.";
        field {
            name = "addr";
            desc = "Raw value";
            sw = rw;
            hw = r;
        } addr[31:0];
    } RING_BASE @ 0x210;

    reg {
        name = "Read pointer cell address";
        desc = " Source: OpenIPC qemu-bench docs/hisilicon-venc.md (reverse engineering of the SDK driver objects hi_vedu.o / hi_vpss.o / hi_vi.o plus a model that runs the unmodified vendor driver stack); not read from hardware. Evidence: INFERRED.";
        field {
            name = "addr";
            desc = "Raw value";
            sw = rw;
            hw = r;
        } addr[31:0];
    } RING_RD @ 0x214;

    reg {
        name = "Write pointer cell address";
        desc = " Source: OpenIPC qemu-bench docs/hisilicon-venc.md (reverse engineering of the SDK driver objects hi_vedu.o / hi_vpss.o / hi_vi.o plus a model that runs the unmodified vendor driver stack); not read from hardware. Evidence: INFERRED.";
        field {
            name = "addr";
            desc = "Raw value";
            sw = rw;
            hw = r;
        } addr[31:0];
    } RING_WR @ 0x218;

    reg {
        name = "Bus idle";
        desc = "Bit 0. Source: OpenIPC qemu-bench docs/hisilicon-venc.md (reverse engineering of the SDK driver objects hi_vedu.o / hi_vpss.o / hi_vi.o plus a model that runs the unmodified vendor driver stack); not read from hardware. Evidence: INFERRED.";
        field {
            name = "idle";
            desc = "Bus idle.";
            sw = r;
            hw = w;
        } idle[0:0];
    } BUS_IDLE @ 0xC0C;

};

`endif
`ifndef HI3516EV300_VPSS_RDL
`define HI3516EV300_VPSS_RDL

regfile eVPSS_V4_EV300 {
    name = "VPSS, EV200/EV300 generation (subset)";
    desc = "VPSS at 0x11400000 (SPI 46). Only registers the vendor driver uses for the online/offline frame flow are listed. Not a full register description.";

    reg {
        name = "Control";
        desc = "Bit 31: online video enable. Source: OpenIPC qemu-bench docs/hisilicon-venc.md (reverse engineering of the SDK driver objects hi_vedu.o / hi_vpss.o / hi_vi.o plus a model that runs the unmodified vendor driver stack); not read from hardware. Evidence: INFERRED.";
        field {
            name = "online_en";
            desc = "Online video enable.";
            sw = rw;
            hw = r;
        } online_en[31:31];
    } CTRL @ 0x0;

    reg {
        name = "Register update";
        desc = "Written after programming a frame. Source: OpenIPC qemu-bench docs/hisilicon-venc.md (reverse engineering of the SDK driver objects hi_vedu.o / hi_vpss.o / hi_vi.o plus a model that runs the unmodified vendor driver stack); not read from hardware. Evidence: INFERRED.";
        field {
            name = "regup";
            desc = "Raw value";
            sw = rw;
            hw = r;
        } regup[31:0];
    } REGUP @ 0x10;

    reg {
        name = "Interrupt mask";
        desc = "The driver writes 0x7401. Source: OpenIPC qemu-bench docs/hisilicon-venc.md (reverse engineering of the SDK driver objects hi_vedu.o / hi_vpss.o / hi_vi.o plus a model that runs the unmodified vendor driver stack); not read from hardware. Evidence: INFERRED.";
        field {
            name = "mask";
            desc = "Raw value";
            sw = rw;
            hw = r;
        } mask[31:0];
    } INT_MASK @ 0xF0;

    reg {
        name = "Offline node list address";
        desc = "First node of the register-image list (offline mode); read back after the write. Source: OpenIPC qemu-bench docs/hisilicon-venc.md (reverse engineering of the SDK driver objects hi_vedu.o / hi_vpss.o / hi_vi.o plus a model that runs the unmodified vendor driver stack); not read from hardware. Evidence: INFERRED.";
        field {
            name = "addr";
            desc = "Raw value";
            sw = rw;
            hw = r;
        } addr[31:0];
    } NODE_ADDR @ 0x2F8;

    reg {
        name = "Offline node list start";
        desc = "Bit 0 starts the node list; the driver writes 0x0900647F. Source: OpenIPC qemu-bench docs/hisilicon-venc.md (reverse engineering of the SDK driver objects hi_vedu.o / hi_vpss.o / hi_vi.o plus a model that runs the unmodified vendor driver stack); not read from hardware. Evidence: INFERRED.";
        field {
            name = "start";
            desc = "Raw value";
            sw = rw;
            hw = r;
        } start[31:0];
    } NODE_START @ 0x304;

    reg {
        name = "Raw status";
        desc = "Write 1s to clear: bit 10 frame start, bit 0 end of frame; 0xADC clears the errors. Source: OpenIPC qemu-bench docs/hisilicon-venc.md (reverse engineering of the SDK driver objects hi_vedu.o / hi_vpss.o / hi_vi.o plus a model that runs the unmodified vendor driver stack); not read from hardware. Evidence: INFERRED.";
        field {
            name = "raw";
            desc = "Raw value";
            sw = rw;
            hw = r;
        } raw[31:0];
    } RAW_STATUS @ 0x310;

    reg {
        name = "Masked status";
        desc = " Source: OpenIPC qemu-bench docs/hisilicon-venc.md (reverse engineering of the SDK driver objects hi_vedu.o / hi_vpss.o / hi_vi.o plus a model that runs the unmodified vendor driver stack); not read from hardware. Evidence: INFERRED.";
        field {
            name = "status";
            desc = "Raw value";
            sw = rw;
            hw = r;
        } status[31:0];
    } STATUS @ 0x314;

    reg {
        name = "Channel 0 size";
        desc = "Channel 1: 0x4A0, channel 2: 0x4E8. Source: OpenIPC qemu-bench docs/hisilicon-venc.md (reverse engineering of the SDK driver objects hi_vedu.o / hi_vpss.o / hi_vi.o plus a model that runs the unmodified vendor driver stack); not read from hardware. Evidence: INFERRED.";
        field {
            name = "size";
            desc = "Raw value";
            sw = rw;
            hw = r;
        } size[31:0];
    } CH0_SIZE @ 0x44C;

    reg {
        name = "Channel 0 control";
        desc = "Bit 31 enable (toggled per frame by frame-rate control); channel 1: 0x4A4, channel 2: 0x4EC. Source: OpenIPC qemu-bench docs/hisilicon-venc.md (reverse engineering of the SDK driver objects hi_vedu.o / hi_vpss.o / hi_vi.o plus a model that runs the unmodified vendor driver stack); not read from hardware. Evidence: INFERRED.";
        field {
            name = "enable";
            desc = "Channel enable.";
            sw = rw;
            hw = r;
        } enable[31:31];
    } CH0_CTRL @ 0x450;

    reg {
        name = "Channel 0 buffer addresses";
        desc = "Header Y, header C, Y, C, 8 bytes apart; channel 1: 0x4B0, channel 2: 0x4F4. Source: OpenIPC qemu-bench docs/hisilicon-venc.md (reverse engineering of the SDK driver objects hi_vedu.o / hi_vpss.o / hi_vi.o plus a model that runs the unmodified vendor driver stack); not read from hardware. Evidence: INFERRED.";
        field {
            name = "addr";
            desc = "Raw value";
            sw = rw;
            hw = r;
        } addr[31:0];
    } CH0_ADDR @ 0x468;

    reg {
        name = "Channel 0 stride";
        desc = "Channel 1: 0x4D0, channel 2: 0x514. Source: OpenIPC qemu-bench docs/hisilicon-venc.md (reverse engineering of the SDK driver objects hi_vedu.o / hi_vpss.o / hi_vi.o plus a model that runs the unmodified vendor driver stack); not read from hardware. Evidence: INFERRED.";
        field {
            name = "stride";
            desc = "Raw value";
            sw = rw;
            hw = r;
        } stride[31:0];
    } CH0_STRIDE @ 0x488;

    reg {
        name = "Compression";
        desc = "Bit 0: channel 0 compression. Source: OpenIPC qemu-bench docs/hisilicon-venc.md (reverse engineering of the SDK driver objects hi_vedu.o / hi_vpss.o / hi_vi.o plus a model that runs the unmodified vendor driver stack); not read from hardware. Evidence: INFERRED.";
        field {
            name = "ch0_compress";
            desc = "Channel 0 compression.";
            sw = rw;
            hw = r;
        } ch0_compress[0:0];
    } COMPRESS @ 0x700;

};

`endif
`ifndef HI3516EV300_VICAP_RDL
`define HI3516EV300_VICAP_RDL

regfile eVI_CAP_V4_EV300 {
    name = "VI capture, EV200/EV300 generation (subset)";
    desc = "VI_CAP at 0x11000000 (2 MB window, SPI 43; ISP front-end statistics share the window and the interrupt). Not a full register description.";

    reg {
        name = "VI_CAP status";
        desc = "Bit 8 (pipe 0) stands while the pipe's write channel has anything pending. Source: OpenIPC qemu-bench docs/hisilicon-venc.md (reverse engineering of the SDK driver objects hi_vedu.o / hi_vpss.o / hi_vi.o plus a model that runs the unmodified vendor driver stack); not read from hardware. Evidence: INFERRED.";
        field {
            name = "status";
            desc = "Raw value";
            sw = rw;
            hw = r;
        } status[31:0];
    } VI_CAP_STATUS @ 0xF0;

    reg {
        name = "VI_CAP mask";
        desc = "The driver sets all bits at module load. Source: OpenIPC qemu-bench docs/hisilicon-venc.md (reverse engineering of the SDK driver objects hi_vedu.o / hi_vpss.o / hi_vi.o plus a model that runs the unmodified vendor driver stack); not read from hardware. Evidence: INFERRED.";
        field {
            name = "mask";
            desc = "Raw value";
            sw = rw;
            hw = r;
        } mask[31:0];
    } VI_CAP_MASK @ 0xF8;

    reg {
        name = "Pipe 0 write channel status";
        desc = "Pipe n at 0x10000 + n x 0x1000 + 0xF0. Write 1s to clear: bit 0 frame start, bit 1 frame end, bit 15 'early' (VPSS programs the buffers). Source: OpenIPC qemu-bench docs/hisilicon-venc.md (reverse engineering of the SDK driver objects hi_vedu.o / hi_vpss.o / hi_vi.o plus a model that runs the unmodified vendor driver stack); not read from hardware. Evidence: INFERRED.";
        field {
            name = "status";
            desc = "Raw value";
            sw = rw;
            hw = r;
        } status[31:0];
    } PIPE0_WCH_STATUS @ 0x100F0;

    reg {
        name = "AE histogram STT address";
        desc = "256 u32 bins; swapped between two buffers every frame (ISP_DRV_FE_SwitchSttAddr). Source: OpenIPC qemu-bench docs/hisilicon-venc.md (reverse engineering of the SDK driver objects hi_vedu.o / hi_vpss.o / hi_vi.o plus a model that runs the unmodified vendor driver stack); not read from hardware. Evidence: INFERRED.";
        field {
            name = "addr";
            desc = "Raw value";
            sw = rw;
            hw = r;
        } addr[31:0];
    } STT_AE_HIST_ADDR @ 0x10208;

    reg {
        name = "AE zone mean STT address 0";
        desc = " Source: OpenIPC qemu-bench docs/hisilicon-venc.md (reverse engineering of the SDK driver objects hi_vedu.o / hi_vpss.o / hi_vi.o plus a model that runs the unmodified vendor driver stack); not read from hardware. Evidence: INFERRED.";
        field {
            name = "addr";
            desc = "Raw value";
            sw = rw;
            hw = r;
        } addr[31:0];
    } STT_AE_ZONE0_ADDR @ 0x10210;

    reg {
        name = "AE zone mean STT address 1";
        desc = " Source: OpenIPC qemu-bench docs/hisilicon-venc.md (reverse engineering of the SDK driver objects hi_vedu.o / hi_vpss.o / hi_vi.o plus a model that runs the unmodified vendor driver stack); not read from hardware. Evidence: INFERRED.";
        field {
            name = "addr";
            desc = "Raw value";
            sw = rw;
            hw = r;
        } addr[31:0];
    } STT_AE_ZONE1_ADDR @ 0x10218;

    reg {
        name = "ISP front-end status";
        desc = "Write 1s to clear: bit 0 frame start, bit 4 frame end. Source: OpenIPC qemu-bench docs/hisilicon-venc.md (reverse engineering of the SDK driver objects hi_vedu.o / hi_vpss.o / hi_vi.o plus a model that runs the unmodified vendor driver stack); not read from hardware. Evidence: INFERRED.";
        field {
            name = "status";
            desc = "Raw value";
            sw = rw;
            hw = r;
        } status[31:0];
    } FE_STATUS @ 0x200F0;

    reg {
        name = "ISP front-end mask";
        desc = " Source: OpenIPC qemu-bench docs/hisilicon-venc.md (reverse engineering of the SDK driver objects hi_vedu.o / hi_vpss.o / hi_vi.o plus a model that runs the unmodified vendor driver stack); not read from hardware. Evidence: INFERRED.";
        field {
            name = "mask";
            desc = "Raw value";
            sw = rw;
            hw = r;
        } mask[31:0];
    } FE_MASK @ 0x200F8;

    reg {
        name = "AE zones";
        desc = "hnum | vnum << 8. Source: OpenIPC qemu-bench docs/hisilicon-venc.md (reverse engineering of the SDK driver objects hi_vedu.o / hi_vpss.o / hi_vi.o plus a model that runs the unmodified vendor driver stack); not read from hardware. Evidence: INFERRED.";
        field {
            name = "zones";
            desc = "Raw value";
            sw = rw;
            hw = r;
        } zones[31:0];
    } AE_ZONES @ 0x22810;

};

`endif
`ifndef HI3516EV300_VIPROC_RDL
`define HI3516EV300_VIPROC_RDL

regfile eVI_PROC_V4_EV300 {
    name = "VI process (VIPROC), EV200/EV300 generation (subset)";
    desc = "VI_PROC at 0x11200000 (SPI 44). Not a full register description; the ISP at 0x11220000 is not described.";

    reg {
        name = "Pipe node address";
        desc = "Offline: the pipe's own node. Source: OpenIPC qemu-bench docs/hisilicon-venc.md (reverse engineering of the SDK driver objects hi_vedu.o / hi_vpss.o / hi_vi.o plus a model that runs the unmodified vendor driver stack); not read from hardware. Evidence: INFERRED.";
        field {
            name = "addr";
            desc = "Raw value";
            sw = rw;
            hw = r;
        } addr[31:0];
    } NODE @ 0x2F8;

    reg {
        name = "Offline start";
        desc = "VI_HAL_Start writes 1 (online mode never writes it). Source: OpenIPC qemu-bench docs/hisilicon-venc.md (reverse engineering of the SDK driver objects hi_vedu.o / hi_vpss.o / hi_vi.o plus a model that runs the unmodified vendor driver stack); not read from hardware. Evidence: INFERRED.";
        field {
            name = "start";
            desc = "Raw value";
            sw = rw;
            hw = r;
        } start[31:0];
    } START @ 0x300;

    reg {
        name = "Status";
        desc = "Write 1s to clear: bit 10 frame start, bit 1 frame end; the offline route treats status & 0x19C as an error. Source: OpenIPC qemu-bench docs/hisilicon-venc.md (reverse engineering of the SDK driver objects hi_vedu.o / hi_vpss.o / hi_vi.o plus a model that runs the unmodified vendor driver stack); not read from hardware. Evidence: INFERRED.";
        field {
            name = "status";
            desc = "Raw value";
            sw = rw;
            hw = r;
        } status[31:0];
    } STATUS @ 0x310;

    reg {
        name = "Status 2";
        desc = "Cleared together with 0x310. Source: OpenIPC qemu-bench docs/hisilicon-venc.md (reverse engineering of the SDK driver objects hi_vedu.o / hi_vpss.o / hi_vi.o plus a model that runs the unmodified vendor driver stack); not read from hardware. Evidence: INFERRED.";
        field {
            name = "status";
            desc = "Raw value";
            sw = rw;
            hw = r;
        } status[31:0];
    } STATUS2 @ 0x318;

    reg {
        name = "Control";
        desc = "The offline start writes 6 here. Source: OpenIPC qemu-bench docs/hisilicon-venc.md (reverse engineering of the SDK driver objects hi_vedu.o / hi_vpss.o / hi_vi.o plus a model that runs the unmodified vendor driver stack); not read from hardware. Evidence: INFERRED.";
        field {
            name = "ctrl";
            desc = "Raw value";
            sw = rw;
            hw = r;
        } ctrl[31:0];
    } CTRL @ 0xF0;

};

`endif
