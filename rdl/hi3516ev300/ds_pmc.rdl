`ifndef HI3516EV300_PMC_RDL
`define HI3516EV300_PMC_RDL
regfile eHI3516EV300_PMC {
    name = "Power management controller (PMC)";
    desc = "Power management controller (PMC) of the Hi3516E V300 at base 0x120F_0000. 12 registers extracted programmatically from the Hi3516E V300 data sheet (Issue 00B06, 2019-05-15) (Table 3-17 Summary of PMC registers (base address: 0x120F_0000)): register headings, offsets, total reset values, field bit ranges, access types, names, reset values and descriptions, with PDF page numbers in each register description. Field names, bit ranges, access types and offsets are exact; the free-text descriptions are taken from the cell text of the field table and were checked by sampling only. Hardware not verified.";
    reg {
        name = "PWR_CTRL0";
        desc = "PWR_CTRL0 is PWR control register 0. (offset 0x0; total reset 0x00100160; PROVEN: Hi3516E V300 data sheet (Issue 00B06, 2019-05-15), section 3.10.2.3, PDF page 199).";
        field {
            name = "reserved";
            desc = "Reserved";
            sw = r; hw = w;
            reset = 0x0;
        } reserved_31_28[31:28];
        field {
            name = "high_adj_startup_time";
            desc = "Effective time adjustment value of the startup pin (unit: 100 ms). The effective value is the configured value plus 1.";
            sw = rw; hw = r;
            reset = 0x1;
        } high_adj_startup_time[27:20];
        field {
            name = "reserved";
            desc = "Reserved";
            sw = r; hw = w;
            reset = 0x0;
        } reserved_19_16[19:16];
        field {
            name = "high_adj_button0_time";
            desc = "Effective time adjustment value of the button pin (unit: 100 ms). The effective value is the configured value plus 1.";
            sw = rw; hw = r;
            reset = 0x1;
        } high_adj_button0_time[15:8];
        field {
            name = "reserved";
            desc = "Reserved";
            sw = r; hw = w;
            reset = 0x0;
        } reserved_7_7[7:7];
        field {
            name = "wakeup_mask";
            desc = "Wakeup mask
- 0: not masked
- 1: masked";
            sw = rw; hw = r;
            reset = 0x1;
        } wakeup_mask[6:6];
        field {
            name = "rtc_int_mask";
            desc = "RTC interrupt wakeup mask
- 0: not masked
- 1: masked";
            sw = rw; hw = r;
            reset = 0x1;
        } rtc_int_mask[5:5];
        field {
            name = "wakeup_act_mode";
            desc = "Wakeup valid mode select
- 00: active on the rising edge
- 01: active on the falling edge
- 10: active high
- 11: active low";
            sw = rw; hw = r;
            reset = 0x0;
        } wakeup_act_mode[4:3];
        field {
            name = "pwr_pen";
            desc = "PWR_EN output control
- 0: Output 0.
- 1: Output 1.";
            sw = rw; hw = r;
            reset = 0x0;
        } pwr_pen[2:2];
        field {
            name = "start_powerdown";
            desc = "Power-down process start";
            sw = w; hw = r;
            reset = 0x0;
        } start_powerdown[1:1];
        field {
            name = "reserved";
            desc = "Reserved";
            sw = r; hw = w;
            reset = 0x0;
        } reserved_0_0[0:0];
    } PWR_CTRL0 @ 0x0;
    reg {
        name = "PWR_CTRL1";
        desc = "PWR_CTRL1 is PWR control register 1. (offset 0x4; total reset 0x10101010; PROVEN: Hi3516E V300 data sheet (Issue 00B06, 2019-05-15), section 3.10.2.3, PDF page 200).";
        field {
            name = "reserved";
            desc = "Reserved";
            sw = r; hw = w;
            reset = 0x10;
        } reserved_31_24[31:24];
        field {
            name = "reserved";
            desc = "Reserved";
            sw = r; hw = w;
            reset = 0x10;
        } reserved_23_16[23:16];
        field {
            name = "reserved";
            desc = "Reserved";
            sw = r; hw = w;
            reset = 0x10;
        } reserved_15_8[15:8];
        field {
            name = "pwr_td0";
            desc = "Power timing parameter 0. The unit is ms. The value 0 is invalid. The actual effective value is 1.";
            sw = rw; hw = r;
            reset = 0x10;
        } pwr_td0[7:0];
    } PWR_CTRL1 @ 0x4;
    reg {
        name = "PWR_STATUS";
        desc = "PWR_STATUS is a PWR status register. (offset 0x8; total reset 0x00000000; PROVEN: Hi3516E V300 data sheet (Issue 00B06, 2019-05-15), section 3.10.2.3, PDF page 200).";
        field {
            name = "reserved";
            desc = "Reserved";
            sw = r; hw = w;
            reset = 0x0;
        } reserved_31_10[31:10];
        field {
            name = "startup_in";
            desc = "Input of the STRATUP pin";
            sw = r; hw = w;
            reset = 0x0;
        } startup_in[9:9];
        field {
            name = "wakeup_in";
            desc = "Input of the PWR_WAKEUP pin";
            sw = r; hw = w;
            reset = 0x0;
        } wakeup_in[8:8];
        field {
            name = "button_in";
            desc = "Input of the PWR_BUTTON pin";
            sw = r; hw = w;
            reset = 0x0;
        } button_in[7:7];
        field {
            name = "wakeup_source";
            desc = "Wakeup source Bit 0: WAKEUP Bit 1: reserved Bit 2: STARTUP Bit 3: BUTTON Bit 4: RTC";
            sw = r; hw = w;
            reset = 0x0;
        } wakeup_source[6:2];
        field {
            name = "reserved";
            desc = "Reserved";
            sw = r; hw = w;
            reset = 0x0;
        } reserved_1_1[1:1];
        field {
            name = "reserved";
            desc = "Reserved";
            sw = r; hw = w;
            reset = 0x0;
        } reserved_0_0[0:0];
    } PWR_STATUS @ 0x8;
    reg {
        name = "PWR_WAKEUP_OUT_CRTL";
        desc = "PWR_WAKEUP_OUT_CRTL is the PWR_WAKEUP output control register. (offset 0x10; total reset 0x00000004; PROVEN: Hi3516E V300 data sheet (Issue 00B06, 2019-05-15), section 3.10.2.3, PDF page 201).";
        field {
            name = "reserved";
            desc = "Reserved";
            sw = r; hw = w;
            reset = 0x0;
        } reserved_31_3[31:3];
        field {
            name = "reserved";
            desc = "Reserved";
            sw = r; hw = w;
            reset = 0x1;
        } reserved_2_2[2:2];
        field {
            name = "pwr_wakeup_out";
            desc = "Output value of the PWR_WAKEUP pin";
            sw = rw; hw = r;
            reset = 0x0;
        } pwr_wakeup_out[1:1];
        field {
            name = "pwr_wakeup_out_en";
            desc = "Output enable of the PWR_WAKEUP pin
- 0: input enabled
- 1: output enabled. The output value is controlled by the pwr_wakeup_out register.";
            sw = rw; hw = r;
            reset = 0x0;
        } pwr_wakeup_out_en[0:0];
    } PWR_WAKEUP_OUT_CRTL @ 0x10;
    reg {
        name = "PWR_SEQ_CRTL";
        desc = "PWR_SEQ_CRTL is the PWR_SEQ pin control register. (offset 0x14; total reset 0x00000000; PROVEN: Hi3516E V300 data sheet (Issue 00B06, 2019-05-15), section 3.10.2.3, PDF page 201).";
        field {
            name = "reserved";
            desc = "Reserved";
            sw = r; hw = w;
            reset = 0x0;
        } reserved_31_5[31:5];
        field {
            name = "pad_pwr_seq_sr";
            desc = "Level conversion rate control for the PWR_SEQ pin
- 0: fast
- 1: slow";
            sw = rw; hw = r;
            reset = 0x0;
        } pad_pwr_seq_sr[4:4];
        field {
            name = "pad_pwr_req_pd";
            desc = "Pull-down enable for the PWR_SEQ pin
- 0: disabled
- 1: enabled";
            sw = rw; hw = r;
            reset = 0x0;
        } pad_pwr_req_pd[3:3];
        field {
            name = "pad_pwr_req_pu";
            desc = "Pull-up enable for the PWR_SEQ pin
- 0: disabled
- 1: enabled";
            sw = rw; hw = r;
            reset = 0x0;
        } pad_pwr_req_pu[2:2];
        field {
            name = "pad_pwr_req_ds";
            desc = "Drive capability control for the PWR_SEQ pin
- 00: IO2 level 4
- 01: IO2 level 3
- 10: IO2 level 2
- 11: IO2 level 1";
            sw = rw; hw = r;
            reset = 0x0;
        } pad_pwr_req_ds[1:0];
    } PWR_SEQ_CRTL @ 0x14;
    reg {
        name = "PWR_STARUP_CRTL";
        desc = "PWR_STARUP_CRTL is the PWR_STARUP pin control register. (offset 0x1C; total reset 0x00000000; PROVEN: Hi3516E V300 data sheet (Issue 00B06, 2019-05-15), section 3.10.2.3, PDF page 202).";
        field {
            name = "reserved";
            desc = "Reserved";
            sw = r; hw = w;
            reset = 0x0;
        } reserved_31_4[31:4];
        field {
            name = "pad_pwr_starup_pd";
            desc = "Pull-down enable for the PWR_STARUP pin
- 0:disabled
- 1: enabled";
            sw = rw; hw = r;
            reset = 0x0;
        } pad_pwr_starup_pd[3:3];
        field {
            name = "pad_pwr_starup_pu";
            desc = "Pull-up enable for the PWR_STARUP pin
- 0: disabled
- 1: enabled";
            sw = rw; hw = r;
            reset = 0x0;
        } pad_pwr_starup_pu[2:2];
        field {
            name = "reserved";
            desc = "Reserved";
            sw = r; hw = w;
            reset = 0x0;
        } reserved_1_0[1:0];
    } PWR_STARUP_CRTL @ 0x1C;
    reg {
        name = "PWR_WAKEUP_CRTL";
        desc = "PWR_WAKEUP_CRTL is the PWR_WAKEUP pin control register. (offset 0x20; total reset 0x00000000; PROVEN: Hi3516E V300 data sheet (Issue 00B06, 2019-05-15), section 3.10.2.3, PDF page 202).";
        field {
            name = "reserved";
            desc = "Reserved";
            sw = r; hw = w;
            reset = 0x0;
        } reserved_31_5[31:5];
        field {
            name = "pad_pwr_wakeup_sr";
            desc = "Level conversion rate of the PWR_WAKEUP pin
- 0: fast
- 1: slow";
            sw = rw; hw = r;
            reset = 0x0;
        } pad_pwr_wakeup_sr[4:4];
        field {
            name = "pad_pwr_wakeup_pd";
            desc = "Pull-down enable for the PWR_WAKEUP pin
- 0: disabled
- 1: enabled";
            sw = rw; hw = r;
            reset = 0x0;
        } pad_pwr_wakeup_pd[3:3];
        field {
            name = "pad_pwr_wakeup_pu";
            desc = "Pull-up enable for the PWR_WAKEUP pin
- 0: disabled
- 1: enabled";
            sw = rw; hw = r;
            reset = 0x0;
        } pad_pwr_wakeup_pu[2:2];
        field {
            name = "pad_pwr_wakeup_ds";
            desc = "Drive capability control for the PWR_WAKEUP pin
- 00: IO2 level 4
- 01: IO2 level 3
- 10: IO2 level 2
- 11: IO2 level 1";
            sw = rw; hw = r;
            reset = 0x0;
        } pad_pwr_wakeup_ds[1:0];
    } PWR_WAKEUP_CRTL @ 0x20;
    reg {
        name = "PWR_EN_CRTL";
        desc = "PWR_EN_CRTL is the PWR_EN pin control register. (offset 0x24; total reset 0x00000000; PROVEN: Hi3516E V300 data sheet (Issue 00B06, 2019-05-15), section 3.10.2.3, PDF page 203).";
        field {
            name = "reserved";
            desc = "Reserved";
            sw = r; hw = w;
            reset = 0x0;
        } reserved_31_5[31:5];
        field {
            name = "pad_pwr_en_sr";
            desc = "Level conversion rate of the PWR_EN pin
- 0: fast
- 1: slow";
            sw = rw; hw = r;
            reset = 0x0;
        } pad_pwr_en_sr[4:4];
        field {
            name = "pad_pwr_en_pd";
            desc = "Pull-down enable for the PWR_EN pin
- 0: disabled
- 1: enabled";
            sw = rw; hw = r;
            reset = 0x0;
        } pad_pwr_en_pd[3:3];
        field {
            name = "pad_pwr_en_pu";
            desc = "Pull-up enable for the PWR_EN pin
- 0: disabled
- 1: enabled";
            sw = rw; hw = r;
            reset = 0x0;
        } pad_pwr_en_pu[2:2];
        field {
            name = "pad_pwr_en_ds";
            desc = "Drive capability control for the PWR_EN pin
- 00: IO2 level 4
- 01: IO2 level 3
- 10: IO2 level 2
- 11: IO2 level 1";
            sw = rw; hw = r;
            reset = 0x0;
        } pad_pwr_en_ds[1:0];
    } PWR_EN_CRTL @ 0x24;
    reg {
        name = "PWR_USER_REG0";
        desc = "PWR_USER_REG0 is PWR user register 0. (offset 0x48; total reset 0x00000000; PROVEN: Hi3516E V300 data sheet (Issue 00B06, 2019-05-15), section 3.10.2.3, PDF page 203).";
        field {
            name = "pwr_user_reg0";
            desc = "PWR user register 0";
            sw = rw; hw = r;
            reset = 0x0;
        } pwr_user_reg0[31:0];
    } PWR_USER_REG0 @ 0x48;
    reg {
        name = "PWR_USER_REG1";
        desc = "PWR_USER_REG1 is PWR user register 1. (offset 0x4C; total reset 0x00000000; PROVEN: Hi3516E V300 data sheet (Issue 00B06, 2019-05-15), section 3.10.2.3, PDF page 203).";
        field {
            name = "pwr_user_reg1";
            desc = "PWR user register 1";
            sw = rw; hw = r;
            reset = 0x0;
        } pwr_user_reg1[31:0];
    } PWR_USER_REG1 @ 0x4C;
    reg {
        name = "PWR_USER_REG2";
        desc = "PWR_USER_REG2 is PWR user register 2. (offset 0x50; total reset 0x00000000; PROVEN: Hi3516E V300 data sheet (Issue 00B06, 2019-05-15), section 3.10.2.3, PDF page 204).";
        field {
            name = "pwr_user_reg2";
            desc = "PWR user register 2";
            sw = rw; hw = r;
            reset = 0x0;
        } pwr_user_reg2[31:0];
    } PWR_USER_REG2 @ 0x50;
    reg {
        name = "PWR_USER_REG3";
        desc = "PWR_USER_REG3 is PWR user register 3. (offset 0x54; total reset 0x00000000; PROVEN: Hi3516E V300 data sheet (Issue 00B06, 2019-05-15), section 3.10.2.3, PDF page 204).";
        field {
            name = "pwr_user_reg3";
            desc = "PWR user register 3";
            sw = rw; hw = r;
            reset = 0x0;
        } pwr_user_reg3[31:0];
    } PWR_USER_REG3 @ 0x54;
};
`endif
