`ifndef HI3516EV300_VO_RDL
`define HI3516EV300_VO_RDL

regfile eVO_V4_EV300 {
    name = "VO / VDP display output, Hi3516EV200/EV300 generation (heuristic map)";
    desc = "VO window 0x11280000 (0x40000, DT; SPI 40, hifb SPI 41). Register addresses recovered by static disassembly of the SDK module hi3516ev200_vo.ko (HAL_DISP_*, HAL_LAYER_*, HAL_VIDEO_* / VOU_HAL functions through HAL_ReadReg/HAL_WriteReg, which also bound the accessible ranges to 0x11280000..0x11291FFF and a second window up to 0x11292BFF). The structure is the classic HiSilicon VDP HAL (device registers at 0xD000.., layer registers at 0x1000.., 0x7000.., zoom engine 0x1400/0x15400, CSC 0x1200/0x7100). Only addresses >= 0x1000 are placed here; the following addresses are added to a layer/device base by the HAL and cannot be placed without the base map (offset: first function): 0x10000 (DCMP_SEG_GetBsErr, DCMP_SEG_GetConsume); 0x88 (DISP_GetIntState, DISP_GetIntStateVcnt); 0x90 (DISP_SetIntfMuxSel); 0xB0 (DISP_SetDitherDataInOut, DISP_SetDitherDomainMode); 0xB4 (DISP_SetDitherSed); 0xB8 (DISP_SetDitherSed); 0xBC (DISP_SetDitherSed); 0xC0 (DISP_SetDitherSed); 0xC4 (DISP_SetDitherSed); 0xC8 (DISP_SetDitherSed); 0xCC (DISP_SetDitherSed); 0xD0 (DISP_SetDitherSed); 0xD4 (DISP_SetDitherSed); 0xD8 (DISP_SetDitherSed); 0xDC (DISP_SetDitherSed); 0xE0 (DISP_SetDitherSed); 0xE4 (DISP_SetDitherSed); 0xE8 (DISP_SetDitherSed); 0xEC (DISP_SetDitherSed); 0xF0 (DISP_SetDitherSed); 0xF4 (DISP_SetDitherThrMinMax); 0x80 (VIDEO_SetLayerDispRect); 0x84 (LAYER_SetVerRatio, VIDEO_SetLayerDispRect); 0x8C (VIDEO_SetLayerVideoRect); 0x254 (VIDEO_GetMultiAreaLAddr, VIDEO_SetMultiAreaLAddr); 0x250 (VIDEO_GetMultiAreaLAddr, VIDEO_SetMultiAreaLAddr); 0x270 (VIDEO_SetMultiAreaCAddr, VIDEO_SetMultiAreaLAddr); 0x25C (VIDEO_GetMultiAreaCAddr, VIDEO_SetMultiAreaCAddr); 0x258 (VIDEO_GetMultiAreaCAddr, VIDEO_SetMultiAreaCAddr); 0x104 (LAYER_SetVerRatio, LAYER_SetZmeFirEnable); 0x240 (FDR_VID_SetDcmpEn, LAYER_GetLayerDataFmt); 0x244 (LAYER_SetSrcResolution); 0x44 (LAYER_CSC_SetParam); 0x4C (LAYER_CSC_SetParam); 0x24C (LAYER_SetLayerInRect); 0x300 (CBM_SetCbmBkg); 0x308 (CBM_SetCbmMixerPrio); 0x380 (DCMP_SEG_SetIceEn); 0x390 (DCMP_SEG_GetBsErr, DCMP_SEG_GetConsume); 0x210 (FDR_VID_SetVidOutUVOrder). The EV300 VO is NOT identical to any of the VDP blocks in rdl/common (HISI_VDP, _AV100, _AV200, _V2, _CV300; dither registers 0xB0..0xF4 match HISI_VDP, the layer registers match the AV100/AV200 family). Field names are derived from HAL function names: INFERRED.";

    reg {
        name = "VO register at 0xD000";
        desc = "Address formed by an add-immediate 0xD000 in HAL_DISP_GetDispIoP, HAL_DISP_GetIntState, HAL_DISP_GetIntStateVcnt, HAL_DISP_GetIntfEnable, HAL_DISP_GetVtThdMode, HAL_DISP_SetDitherDataInOut. Layer/device instances are probably replicated at a stride (layer n at +n x 0x?, device n at +n x 0x?): stride UNKNOWN. Evidence: PROVEN (offset in vendor binary), role INFERRED from function names.";
        field {
            name = "disp_setintfenable";
            desc = "Bits [31:31] are inserted/extracted by HAL_DISP_SetIntfEnable, HAL_DISP_SetVtThdMode. Field name derived from the function name: INFERRED; bit range PROVEN (bfi/ubfx in the SDK binary).";
            sw = rw;
            hw = r;
        } disp_setintfenable[31:31];
        field {
            name = "disp_getdispiop";
            desc = "Bits [4:4] are inserted/extracted by HAL_DISP_GetDispIoP, HAL_DISP_SetIntfSync. Field name derived from the function name: INFERRED; bit range PROVEN (bfi/ubfx in the SDK binary).";
            sw = rw;
            hw = r;
        } disp_getdispiop[4:4];
        field {
            name = "disp_setintfsync";
            desc = "Bits [6:6] are inserted/extracted by HAL_DISP_SetIntfSync. Field name derived from the function name: INFERRED; bit range PROVEN (bfi/ubfx in the SDK binary).";
            sw = rw;
            hw = r;
        } disp_setintfsync[6:6];
        field {
            name = "disp_setintfsync_5";
            desc = "Bits [5:5] are inserted/extracted by HAL_DISP_SetIntfSync. Field name derived from the function name: INFERRED; bit range PROVEN (bfi/ubfx in the SDK binary).";
            sw = rw;
            hw = r;
        } disp_setintfsync_5[5:5];
        field {
            name = "disp_setintfsync_7";
            desc = "Bits [7:7] are inserted/extracted by HAL_DISP_SetIntfSync. Field name derived from the function name: INFERRED; bit range PROVEN (bfi/ubfx in the SDK binary).";
            sw = rw;
            hw = r;
        } disp_setintfsync_7[7:7];
        field {
            name = "disp_setintfsync_16";
            desc = "Bits [23:16] are inserted/extracted by HAL_DISP_SetIntfSync. Field name derived from the function name: INFERRED; bit range PROVEN (bfi/ubfx in the SDK binary).";
            sw = rw;
            hw = r;
        } disp_setintfsync_16[23:16];
        field {
            name = "disp_getvtthdmode";
            desc = "Bits [15:15] are inserted/extracted by HAL_DISP_GetVtThdMode, HAL_DISP_SetVtThdMode. Field name derived from the function name: INFERRED; bit range PROVEN (bfi/ubfx in the SDK binary).";
            sw = rw;
            hw = r;
        } disp_getvtthdmode[15:15];
    } VO_0D000 @ 0xD000;

    reg {
        name = "VO register at 0xD300";
        desc = "Address formed by an add-immediate 0xD300 in HAL_DISP_SetLcdSerialPerd. Layer/device instances are probably replicated at a stride (layer n at +n x 0x?, device n at +n x 0x?): stride UNKNOWN. Evidence: PROVEN (offset in vendor binary), role INFERRED from function names.";
        field {
            name = "disp_setlcdserialperd";
            desc = "Bits [28:28] are inserted/extracted by HAL_DISP_SetLcdSerialPerd. Field name derived from the function name: INFERRED; bit range PROVEN (bfi/ubfx in the SDK binary).";
            sw = rw;
            hw = r;
        } disp_setlcdserialperd[28:28];
    } VO_0D300 @ 0xD300;

    reg {
        name = "VO register at 0xD100";
        desc = "Address formed by an add-immediate 0xD100 in HAL_DISP_SetIntfCtrl. Layer/device instances are probably replicated at a stride (layer n at +n x 0x?, device n at +n x 0x?): stride UNKNOWN. Evidence: PROVEN (offset in vendor binary), role INFERRED from function names.";
        field {
            name = "disp_setintfctrl";
            desc = "Bits [5:5] are inserted/extracted by HAL_DISP_SetIntfCtrl. Field name derived from the function name: INFERRED; bit range PROVEN (bfi/ubfx in the SDK binary).";
            sw = rw;
            hw = r;
        } disp_setintfctrl[5:5];
        field {
            name = "disp_setintfctrl_3";
            desc = "Bits [3:3] are inserted/extracted by HAL_DISP_SetIntfCtrl. Field name derived from the function name: INFERRED; bit range PROVEN (bfi/ubfx in the SDK binary).";
            sw = rw;
            hw = r;
        } disp_setintfctrl_3[3:3];
        field {
            name = "disp_setintfctrl_2";
            desc = "Bits [2:2] are inserted/extracted by HAL_DISP_SetIntfCtrl. Field name derived from the function name: INFERRED; bit range PROVEN (bfi/ubfx in the SDK binary).";
            sw = rw;
            hw = r;
        } disp_setintfctrl_2[2:2];
        field {
            name = "disp_setintfctrl_1";
            desc = "Bits [1:1] are inserted/extracted by HAL_DISP_SetIntfCtrl. Field name derived from the function name: INFERRED; bit range PROVEN (bfi/ubfx in the SDK binary).";
            sw = rw;
            hw = r;
        } disp_setintfctrl_1[1:1];
        field {
            name = "disp_setintfctrl_31";
            desc = "Bits [31:31] are inserted/extracted by HAL_DISP_SetIntfCtrl. Field name derived from the function name: INFERRED; bit range PROVEN (bfi/ubfx in the SDK binary).";
            sw = rw;
            hw = r;
        } disp_setintfctrl_31[31:31];
        field {
            name = "disp_setintfctrl_29";
            desc = "Bits [29:29] are inserted/extracted by HAL_DISP_SetIntfCtrl. Field name derived from the function name: INFERRED; bit range PROVEN (bfi/ubfx in the SDK binary).";
            sw = rw;
            hw = r;
        } disp_setintfctrl_29[29:29];
        field {
            name = "disp_setintfctrl_27";
            desc = "Bits [27:27] are inserted/extracted by HAL_DISP_SetIntfCtrl. Field name derived from the function name: INFERRED; bit range PROVEN (bfi/ubfx in the SDK binary).";
            sw = rw;
            hw = r;
        } disp_setintfctrl_27[27:27];
        field {
            name = "disp_setintfctrl_26";
            desc = "Bits [26:26] are inserted/extracted by HAL_DISP_SetIntfCtrl. Field name derived from the function name: INFERRED; bit range PROVEN (bfi/ubfx in the SDK binary).";
            sw = rw;
            hw = r;
        } disp_setintfctrl_26[26:26];
        field {
            name = "disp_setintfctrl_25";
            desc = "Bits [25:25] are inserted/extracted by HAL_DISP_SetIntfCtrl. Field name derived from the function name: INFERRED; bit range PROVEN (bfi/ubfx in the SDK binary).";
            sw = rw;
            hw = r;
        } disp_setintfctrl_25[25:25];
    } VO_0D100 @ 0xD100;

    reg {
        name = "VO register at 0xD200";
        desc = "Address formed by an add-immediate 0xD200 in HAL_DISP_SetIntfClip, HAL_INTF_BT_SetDfirEn. Layer/device instances are probably replicated at a stride (layer n at +n x 0x?, device n at +n x 0x?): stride UNKNOWN. Evidence: PROVEN (offset in vendor binary), role INFERRED from function names.";
        field {
            name = "disp_setintfclip";
            desc = "Bits [31:31] are inserted/extracted by HAL_DISP_SetIntfClip. Field name derived from the function name: INFERRED; bit range PROVEN (bfi/ubfx in the SDK binary).";
            sw = rw;
            hw = r;
        } disp_setintfclip[31:31];
        field {
            name = "disp_setintfclip_20";
            desc = "Bits [29:20] are inserted/extracted by HAL_DISP_SetIntfClip. Field name derived from the function name: INFERRED; bit range PROVEN (bfi/ubfx in the SDK binary).";
            sw = rw;
            hw = r;
        } disp_setintfclip_20[29:20];
        field {
            name = "disp_setintfclip_10";
            desc = "Bits [19:10] are inserted/extracted by HAL_DISP_SetIntfClip. Field name derived from the function name: INFERRED; bit range PROVEN (bfi/ubfx in the SDK binary).";
            sw = rw;
            hw = r;
        } disp_setintfclip_10[19:10];
        field {
            name = "disp_setintfclip_0";
            desc = "Bits [9:0] are inserted/extracted by HAL_DISP_SetIntfClip. Field name derived from the function name: INFERRED; bit range PROVEN (bfi/ubfx in the SDK binary).";
            sw = rw;
            hw = r;
        } disp_setintfclip_0[9:0];
        field {
            name = "intf_bt_setdfiren";
            desc = "Bits [30:30] are inserted/extracted by HAL_INTF_BT_SetDfirEn. Field name derived from the function name: INFERRED; bit range PROVEN (bfi/ubfx in the SDK binary).";
            sw = rw;
            hw = r;
        } intf_bt_setdfiren[30:30];
    } VO_0D200 @ 0xD200;

    reg {
        name = "VO register at 0x1000";
        desc = "Address formed by an add-immediate 0x1000 in HAL_LAYER_EnableLayer, HAL_LAYER_GetLayerEnable, HAL_LAYER_SetLayerGAlpha, HAL_LAYER_SetRegUp, HAL_VIDEO_SetLayerUpMode. Layer/device instances are probably replicated at a stride (layer n at +n x 0x?, device n at +n x 0x?): stride UNKNOWN. Evidence: PROVEN (offset in vendor binary), role INFERRED from function names.";
        field {
            name = "video_setlayerupmode";
            desc = "Bits [29:29] are inserted/extracted by HAL_VIDEO_SetLayerUpMode. Field name derived from the function name: INFERRED; bit range PROVEN (bfi/ubfx in the SDK binary).";
            sw = rw;
            hw = r;
        } video_setlayerupmode[29:29];
        field {
            name = "layer_enablelayer";
            desc = "Bits [31:31] are inserted/extracted by HAL_LAYER_EnableLayer. Field name derived from the function name: INFERRED; bit range PROVEN (bfi/ubfx in the SDK binary).";
            sw = rw;
            hw = r;
        } layer_enablelayer[31:31];
        field {
            name = "layer_setlayergalpha";
            desc = "Bits [7:0] are inserted/extracted by HAL_LAYER_SetLayerGAlpha. Field name derived from the function name: INFERRED; bit range PROVEN (bfi/ubfx in the SDK binary).";
            sw = rw;
            hw = r;
        } layer_setlayergalpha[7:0];
    } VO_01000 @ 0x1000;

    reg {
        name = "VO register at 0x1080";
        desc = "Address formed by an add-immediate 0x1080 in HAL_LAYER_SetLayerBgColor, HAL_VIDEO_SetLayerAlpha, HAL_VIDEO_SetLayerDispRect, HAL_VIDEO_SetLayerVideoRect. Layer/device instances are probably replicated at a stride (layer n at +n x 0x?, device n at +n x 0x?): stride UNKNOWN. Evidence: PROVEN (offset in vendor binary), role INFERRED from function names.";
        field {
            name = "video_setlayeralpha";
            desc = "Bits [7:0] are inserted/extracted by HAL_VIDEO_SetLayerAlpha. Field name derived from the function name: INFERRED; bit range PROVEN (bfi/ubfx in the SDK binary).";
            sw = rw;
            hw = r;
        } video_setlayeralpha[7:0];
        field {
            name = "video_setlayerdisprect";
            desc = "Bits [31:16] are inserted/extracted by HAL_VIDEO_SetLayerDispRect, HAL_VIDEO_SetLayerVideoRect. Field name derived from the function name: INFERRED; bit range PROVEN (bfi/ubfx in the SDK binary).";
            sw = rw;
            hw = r;
        } video_setlayerdisprect[31:16];
    } VO_01080 @ 0x1080;

    reg {
        name = "VO register at 0x7000";
        desc = "Address formed by an add-immediate 0x7000 in HAL_LAYER_EnableLayer, HAL_LAYER_GetLayerEnable, HAL_LAYER_SetRegUp, HAL_VIDEO_SetLayerDispRect, HAL_VIDEO_SetLayerVideoRect. Layer/device instances are probably replicated at a stride (layer n at +n x 0x?, device n at +n x 0x?): stride UNKNOWN. Evidence: PROVEN (offset in vendor binary), role INFERRED from function names.";
        field {
            name = "layer_enablelayer";
            desc = "Bits [31:31] are inserted/extracted by HAL_LAYER_EnableLayer. Field name derived from the function name: INFERRED; bit range PROVEN (bfi/ubfx in the SDK binary).";
            sw = rw;
            hw = r;
        } layer_enablelayer[31:31];
    } VO_07000 @ 0x7000;

    reg {
        name = "VO register at 0x1400";
        desc = "Address formed by an add-immediate 0x1400 in HAL_LAYER_SetZmeFirEnable, HAL_LAYER_SetZmeInfo, HAL_VIDEO_CVFIR_SetCoef, HAL_VIDEO_CVFIR_SetCvfirEn, HAL_VIDEO_CVFIR_SetCvfirMode, HAL_VIDEO_CVFIR_SetCvmidEn. Layer/device instances are probably replicated at a stride (layer n at +n x 0x?, device n at +n x 0x?): stride UNKNOWN. Evidence: PROVEN (offset in vendor binary), role INFERRED from function names.";
        field {
            name = "layer_setzmeinfo";
            desc = "Bits [15:0] are inserted/extracted by HAL_LAYER_SetZmeInfo, HAL_VIDEO_CVFIR_SetOutHeight, HAL_VIDEO_CVFIR_SetVChromaOffset. Field name derived from the function name: INFERRED; bit range PROVEN (bfi/ubfx in the SDK binary).";
            sw = rw;
            hw = r;
        } layer_setzmeinfo[15:0];
        field {
            name = "layer_setzmeinfo_16";
            desc = "Bits [17:16] are inserted/extracted by HAL_LAYER_SetZmeInfo, HAL_VIDEO_CVFIR_SetOutFmt. Field name derived from the function name: INFERRED; bit range PROVEN (bfi/ubfx in the SDK binary).";
            sw = rw;
            hw = r;
        } layer_setzmeinfo_16[17:16];
        field {
            name = "layer_setzmefirenable";
            desc = "Bits [30:30] are inserted/extracted by HAL_LAYER_SetZmeFirEnable, HAL_VIDEO_CVFIR_SetCvfirEn. Field name derived from the function name: INFERRED; bit range PROVEN (bfi/ubfx in the SDK binary).";
            sw = rw;
            hw = r;
        } layer_setzmefirenable[30:30];
        field {
            name = "layer_setzmefirenable_28";
            desc = "Bits [28:28] are inserted/extracted by HAL_LAYER_SetZmeFirEnable, HAL_VIDEO_CVFIR_SetCvmidEn. Field name derived from the function name: INFERRED; bit range PROVEN (bfi/ubfx in the SDK binary).";
            sw = rw;
            hw = r;
        } layer_setzmefirenable_28[28:28];
        field {
            name = "video_cvfir_setoutpro";
            desc = "Bits [18:18] are inserted/extracted by HAL_VIDEO_CVFIR_SetOutPro. Field name derived from the function name: INFERRED; bit range PROVEN (bfi/ubfx in the SDK binary).";
            sw = rw;
            hw = r;
        } video_cvfir_setoutpro[18:18];
        field {
            name = "video_cvfir_setvzmeckgten";
            desc = "Bits [19:19] are inserted/extracted by HAL_VIDEO_CVFIR_SetVzmeCkGtEn. Field name derived from the function name: INFERRED; bit range PROVEN (bfi/ubfx in the SDK binary).";
            sw = rw;
            hw = r;
        } video_cvfir_setvzmeckgten[19:19];
        field {
            name = "video_cvfir_setcvfirmode";
            desc = "Bits [25:25] are inserted/extracted by HAL_VIDEO_CVFIR_SetCvfirMode. Field name derived from the function name: INFERRED; bit range PROVEN (bfi/ubfx in the SDK binary).";
            sw = rw;
            hw = r;
        } video_cvfir_setcvfirmode[25:25];
    } VO_01400 @ 0x1400;

    reg {
        name = "VO register at 0x15400";
        desc = "Address formed by an add-immediate 0x15400 in HAL_LAYER_SetVerRatio, HAL_LAYER_SetZmeFirEnable. Layer/device instances are probably replicated at a stride (layer n at +n x 0x?, device n at +n x 0x?): stride UNKNOWN. Evidence: PROVEN (offset in vendor binary), role INFERRED from function names.";
        field {
            name = "layer_setzmefirenable";
            desc = "Bits [30:30] are inserted/extracted by HAL_LAYER_SetZmeFirEnable. Field name derived from the function name: INFERRED; bit range PROVEN (bfi/ubfx in the SDK binary).";
            sw = rw;
            hw = r;
        } layer_setzmefirenable[30:30];
        field {
            name = "layer_setzmefirenable_31";
            desc = "Bits [31:31] are inserted/extracted by HAL_LAYER_SetZmeFirEnable. Field name derived from the function name: INFERRED; bit range PROVEN (bfi/ubfx in the SDK binary).";
            sw = rw;
            hw = r;
        } layer_setzmefirenable_31[31:31];
    } VO_15400 @ 0x15400;

    reg {
        name = "VO register at 0x10C00";
        desc = "Address formed by an add-immediate 0x10C00 in HAL_LAYER_SetLayerDataFmt, HAL_LAYER_SetLayerInRect. Layer/device instances are probably replicated at a stride (layer n at +n x 0x?, device n at +n x 0x?): stride UNKNOWN. Evidence: PROVEN (offset in vendor binary), role INFERRED from function names.";
        field {
            name = "raw";
            desc = "Raw register; no bit-field access seen. UNKNOWN layout.";
            sw = rw;
            hw = r;
        } raw[31:0];
    } VO_10C00 @ 0x10C00;

    reg {
        name = "VO register at 0x1500";
        desc = "Address formed by an add-immediate 0x1500 in HAL_VIDEO_HFIR_SetCkGtEn, HAL_VIDEO_HFIR_SetCoef, HAL_VIDEO_HFIR_SetHfirMode, HAL_VIDEO_HFIR_SetMidEn. Layer/device instances are probably replicated at a stride (layer n at +n x 0x?, device n at +n x 0x?): stride UNKNOWN. Evidence: PROVEN (offset in vendor binary), role INFERRED from function names.";
        field {
            name = "video_hfir_setckgten";
            desc = "Bits [4:4] are inserted/extracted by HAL_VIDEO_HFIR_SetCkGtEn. Field name derived from the function name: INFERRED; bit range PROVEN (bfi/ubfx in the SDK binary).";
            sw = rw;
            hw = r;
        } video_hfir_setckgten[4:4];
        field {
            name = "video_hfir_setmiden";
            desc = "Bits [3:3] are inserted/extracted by HAL_VIDEO_HFIR_SetMidEn. Field name derived from the function name: INFERRED; bit range PROVEN (bfi/ubfx in the SDK binary).";
            sw = rw;
            hw = r;
        } video_hfir_setmiden[3:3];
        field {
            name = "video_hfir_sethfirmode";
            desc = "Bits [2:1] are inserted/extracted by HAL_VIDEO_HFIR_SetHfirMode. Field name derived from the function name: INFERRED; bit range PROVEN (bfi/ubfx in the SDK binary).";
            sw = rw;
            hw = r;
        } video_hfir_sethfirmode[2:1];
        field {
            name = "video_hfir_setcoef";
            desc = "Bits [25:16] are inserted/extracted by HAL_VIDEO_HFIR_SetCoef. Field name derived from the function name: INFERRED; bit range PROVEN (bfi/ubfx in the SDK binary).";
            sw = rw;
            hw = r;
        } video_hfir_setcoef[25:16];
    } VO_01500 @ 0x1500;

    reg {
        name = "VO register at 0x1200";
        desc = "Address formed by an add-immediate 0x1200 in HAL_LAYER_CSC_SetCkGtEn, HAL_LAYER_CSC_SetEnable, HAL_LAYER_CSC_SetParam. Layer/device instances are probably replicated at a stride (layer n at +n x 0x?, device n at +n x 0x?): stride UNKNOWN. Evidence: PROVEN (offset in vendor binary), role INFERRED from function names.";
        field {
            name = "layer_csc_setenable";
            desc = "Bits [0:0] are inserted/extracted by HAL_LAYER_CSC_SetEnable. Field name derived from the function name: INFERRED; bit range PROVEN (bfi/ubfx in the SDK binary).";
            sw = rw;
            hw = r;
        } layer_csc_setenable[0:0];
        field {
            name = "layer_csc_setckgten";
            desc = "Bits [2:2] are inserted/extracted by HAL_LAYER_CSC_SetCkGtEn. Field name derived from the function name: INFERRED; bit range PROVEN (bfi/ubfx in the SDK binary).";
            sw = rw;
            hw = r;
        } layer_csc_setckgten[2:2];
    } VO_01200 @ 0x1200;

    reg {
        name = "VO register at 0x7100";
        desc = "Address formed by an add-immediate 0x7100 in HAL_LAYER_CSC_SetCkGtEn, HAL_LAYER_CSC_SetCscMode, HAL_LAYER_CSC_SetEnable, HAL_LAYER_CSC_SetParam. Layer/device instances are probably replicated at a stride (layer n at +n x 0x?, device n at +n x 0x?): stride UNKNOWN. Evidence: PROVEN (offset in vendor binary), role INFERRED from function names.";
        field {
            name = "layer_csc_setenable";
            desc = "Bits [0:0] are inserted/extracted by HAL_LAYER_CSC_SetEnable. Field name derived from the function name: INFERRED; bit range PROVEN (bfi/ubfx in the SDK binary).";
            sw = rw;
            hw = r;
        } layer_csc_setenable[0:0];
        field {
            name = "layer_csc_setckgten";
            desc = "Bits [2:2] are inserted/extracted by HAL_LAYER_CSC_SetCkGtEn. Field name derived from the function name: INFERRED; bit range PROVEN (bfi/ubfx in the SDK binary).";
            sw = rw;
            hw = r;
        } layer_csc_setckgten[2:2];
    } VO_07100 @ 0x7100;

    reg {
        name = "VO register at 0x1240";
        desc = "Address formed by an add-immediate 0x1240 in HAL_LAYER_CSC_SetParam. Layer/device instances are probably replicated at a stride (layer n at +n x 0x?, device n at +n x 0x?): stride UNKNOWN. Evidence: PROVEN (offset in vendor binary), role INFERRED from function names.";
        field {
            name = "layer_csc_setparam";
            desc = "Bits [9:0] are inserted/extracted by HAL_LAYER_CSC_SetParam. Field name derived from the function name: INFERRED; bit range PROVEN (bfi/ubfx in the SDK binary).";
            sw = rw;
            hw = r;
        } layer_csc_setparam[9:0];
    } VO_01240 @ 0x1240;

    reg {
        name = "VO register at 0x7300";
        desc = "Address formed by an add-immediate 0x7300 in HAL_LAYER_SetVerRatio. Layer/device instances are probably replicated at a stride (layer n at +n x 0x?, device n at +n x 0x?): stride UNKNOWN. Evidence: PROVEN (offset in vendor binary), role INFERRED from function names.";
        field {
            name = "raw";
            desc = "Raw register; no bit-field access seen. UNKNOWN layout.";
            sw = rw;
            hw = r;
        } raw[31:0];
    } VO_07300 @ 0x7300;

};

`endif
