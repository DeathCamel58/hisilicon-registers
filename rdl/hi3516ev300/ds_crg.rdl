`ifndef HI3516EV300_CRG_RDL
`define HI3516EV300_CRG_RDL
regfile eHI3516EV300_CRG {
    name = "Clock and reset generator (CRG)";
    desc = "Clock and reset generator (CRG) of the Hi3516E V300 at base 0x1201_0000. 43 registers extracted programmatically (plus 8 registers kept from the vendor-derived map, marked INFERRED) from the Hi3516E V300 data sheet (Issue 00B06, 2019-05-15) (Table 3-5 Summary of CRG registers (base address: 0x1201_0000)): register headings, offsets, total reset values, field bit ranges, access types, names, reset values and descriptions, with PDF page numbers in each register description. Field names, bit ranges, access types and offsets are exact; the free-text descriptions are taken from the cell text of the field table and were checked by sampling only. Hardware not verified.";
    reg {
        name = "PERI_CRG_PLL0";
        desc = "PERI_CRG_PLL0 is APLL configuration register 0. (offset 0x0; total reset 0x12000000; PROVEN: Hi3516E V300 data sheet (Issue 00B06, 2019-05-15), section 3.2.6, PDF page 82).";
        field {
            name = "reserved";
            desc = "Reserved";
            sw = r; hw = w;
            reset = 0x0;
        } reserved_31_31[31:31];
        field {
            name = "apll_postdiv2";
            desc = "Level-2 output frequency division factor of the APLL";
            sw = rw; hw = r;
            reset = 0x1;
        } apll_postdiv2[30:28];
        field {
            name = "reserved";
            desc = "Reserved";
            sw = r; hw = w;
            reset = 0x0;
        } reserved_27_27[27:27];
        field {
            name = "apll_postdiv1";
            desc = "Level-1 output frequency division factor of the APLL";
            sw = rw; hw = r;
            reset = 0x2;
        } apll_postdiv1[26:24];
        field {
            name = "apll_frac";
            desc = "Decimal part of the APLL frequency multiplication coefficient";
            sw = rw; hw = r;
            reset = 0x0;
        } apll_frac[23:0];
    } PERI_CRG_PLL0 @ 0x0;
    reg {
        name = "PERI_CRG_PLL1";
        desc = "PERI_CRG_PLL1 is APLL configuration register 1. (offset 0x4; total reset 0x0100104B; PROVEN: Hi3516E V300 data sheet (Issue 00B06, 2019-05-15), section 3.2.6, PDF page 82).";
        field {
            name = "reserved";
            desc = "Reserved";
            sw = r; hw = w;
            reset = 0x0;
        } reserved_31_27[31:27];
        field {
            name = "apll_bypass";
            desc = "APLL clock frequency division bypass
- 0: not bypassed
- 1: bypassed";
            sw = rw; hw = r;
            reset = 0x0;
        } apll_bypass[26:26];
        field {
            name = "apll_dacpd";
            desc = "APLL test signal control
- 0: normal operating mode
- 1: power-down mode";
            sw = rw; hw = r;
            reset = 0x0;
        } apll_dacpd[25:25];
        field {
            name = "apll_dsmpd";
            desc = "APLL decimal division control
- 0: decimal frequency-division mode";
            sw = rw; hw = r;
            reset = 0x1;
        } apll_dsmpd[24:24];
        field {
            name = "apll_pd";
            desc = "APLL power-down control
- 0: normal operating mode
- 1: power-down mode";
            sw = rw; hw = r;
            reset = 0x0;
        } apll_pd[23:23];
        field {
            name = "apll_foutvcopd";
            desc = "APLL VCO output power-down control
- 0: normal clock output
- 1: no clock output";
            sw = rw; hw = r;
            reset = 0x0;
        } apll_foutvcopd[22:22];
        field {
            name = "apll_postdivpd";
            desc = "APLL POSTDIV output power-down control
- 0: normal clock output
- 1: no clock output";
            sw = rw; hw = r;
            reset = 0x0;
        } apll_postdivpd[21:21];
        field {
            name = "apll_fout4phasepd";
            desc = "APLL FOUT output power-down control
- 0: normal clock output
- 1: no clock output";
            sw = rw; hw = r;
            reset = 0x0;
        } apll_fout4phasepd[20:20];
        field {
            name = "reserved";
            desc = "Reserved";
            sw = r; hw = w;
            reset = 0x0;
        } reserved_19_18[19:18];
        field {
            name = "apll_refdiv";
            desc = "Frequency division factor of the APLL reference clock";
            sw = rw; hw = r;
            reset = 0x1;
        } apll_refdiv[17:12];
        field {
            name = "apll_fbdiv";
            desc = "Integral part of the frequency multiplication factor of the APLL";
            sw = rw; hw = r;
            reset = 0x4b;
        } apll_fbdiv[11:0];
    } PERI_CRG_PLL1 @ 0x4;
    reg {
        name = "PERI_CRG_PLL6";
        desc = "PERI_CRG_PLL6 is VPLL configuration register 0. (offset 0x18; total reset 0x14000000; PROVEN: Hi3516E V300 data sheet (Issue 00B06, 2019-05-15), section 3.2.6, PDF page 83).";
        field {
            name = "reserved";
            desc = "Reserved";
            sw = rw; hw = r;
            reset = 0x0;
        } reserved_31_31[31:31];
        field {
            name = "vpll_postdiv2";
            desc = "Level-2 output frequency division factor of the VPLL";
            sw = rw; hw = r;
            reset = 0x1;
        } vpll_postdiv2[30:28];
        field {
            name = "reserved";
            desc = "Reserved";
            sw = rw; hw = r;
            reset = 0x0;
        } reserved_27_27[27:27];
        field {
            name = "vpll_postdiv1";
            desc = "Level-1 output frequency division factor of the VPLL";
            sw = rw; hw = r;
            reset = 0x4;
        } vpll_postdiv1[26:24];
        field {
            name = "vpll_frac";
            desc = "Decimal part of the APLL frequency multiplication coefficient";
            sw = rw; hw = r;
            reset = 0x0;
        } vpll_frac[23:0];
    } PERI_CRG_PLL6 @ 0x18;
    reg {
        name = "PERI_CRG_PLL7";
        desc = "PERI_CRG_PLL7 is VPLL configuration register 1. (offset 0x1C; total reset 0x01001063; PROVEN: Hi3516E V300 data sheet (Issue 00B06, 2019-05-15), section 3.2.6, PDF page 84).";
        field {
            name = "reserved";
            desc = "Reserved";
            sw = r; hw = w;
            reset = 0x0;
        } reserved_31_27[31:27];
        field {
            name = "vpll_bypass";
            desc = "VPLL clock frequency division bypass
- 0: not bypassed
- 1: bypassed";
            sw = rw; hw = r;
            reset = 0x0;
        } vpll_bypass[26:26];
        field {
            name = "vpll_dacpd";
            desc = "VPLL test signal control
- 0: normal operating mode
- 1: power-down mode";
            sw = rw; hw = r;
            reset = 0x0;
        } vpll_dacpd[25:25];
        field {
            name = "vpll_dsmpd";
            desc = "VPLL decimal division control
- 0: decimal frequency-division mode
- 1: integral frequency-division mode";
            sw = rw; hw = r;
            reset = 0x1;
        } vpll_dsmpd[24:24];
        field {
            name = "vpll_pd";
            desc = "VPLL power-down control
- 0: normal operating mode
- 1: power-down mode";
            sw = rw; hw = r;
            reset = 0x0;
        } vpll_pd[23:23];
        field {
            name = "vpll_foutvcopd";
            desc = "VPLL VCO output power-down control
- 0: normal clock output
- 1: no clock output";
            sw = rw; hw = r;
            reset = 0x0;
        } vpll_foutvcopd[22:22];
        field {
            name = "vpll_postdivpd";
            desc = "VPLL POSTDIV output power-down control
- 0: normal clock output
- 1: no clock output";
            sw = rw; hw = r;
            reset = 0x0;
        } vpll_postdivpd[21:21];
        field {
            name = "vpll_fout4phasepd";
            desc = "VPLL FOUT output power-down control
- 0: normal clock output
- 1: no clock output";
            sw = rw; hw = r;
            reset = 0x0;
        } vpll_fout4phasepd[20:20];
        field {
            name = "reserved";
            desc = "Reserved";
            sw = r; hw = w;
            reset = 0x0;
        } reserved_19_18[19:18];
        field {
            name = "vpll_refdiv";
            desc = "Frequency division factor of the VPLL reference clock";
            sw = rw; hw = r;
            reset = 0x1;
        } vpll_refdiv[17:12];
        field {
            name = "vpll_fbdiv";
            desc = "Integral part of the frequency multiplication factor of the VPLL";
            sw = rw; hw = r;
            reset = 0x63;
        } vpll_fbdiv[11:0];
    } PERI_CRG_PLL7 @ 0x1C;
    reg {
        name = "PERI_CRG20";
        desc = "PERI_CRG20 is the APLL SS configuration register. (offset 0x50; total reset 0x00000004; PROVEN: Hi3516E V300 data sheet (Issue 00B06, 2019-05-15), section 3.2.6, PDF page 84).";
        field {
            name = "reserved";
            desc = "Reserved";
            sw = r; hw = w;
            reset = 0x0;
        } reserved_31_13[31:13];
        field {
            name = "apll_ssmod_cfg";
            desc = "ssmod divval[12: 9]: SSMOD divval control
- 0x0: not divided
- 0x1: not divided
- 0x2: divided by 2
- 0x3: divided by 3 …
- 0xF: divided by 15 ssmod spread[8: 4]: SSMOD spread control
- 0: 0
- 1: 0.1%
- 2: 0.2%
- 3: 0.3%
- 4: 0.4%
- 5: 0.5%
- 6: 0.6%
- 7: 0.7% ...
- 31: 3.1% ssmod downspread[3]: SSMOD downspread control
- 0: central spread spectrum
- 1: down spread spectrum ssmod_disable[2]: SSMOD disable control
- 0: enabled
- 1: disabled ssmod_rst_req[1]: SSMOD reset control
- 0: reset deasserted
- 1: reset ssmod_cken[0]: SSMOD clock gating, disabled by default
- 0: disabled
- 1: enabled";
            sw = rw; hw = r;
            reset = 0x4;
        } apll_ssmod_cfg[12:0];
    } PERI_CRG20 @ 0x50;
    reg {
        name = "PERI_CRG23";
        desc = "PERI_CRG23 is the VPLL SS configuration register. (offset 0x5C; total reset 0x00000004; PROVEN: Hi3516E V300 data sheet (Issue 00B06, 2019-05-15), section 3.2.6, PDF page 86).";
        field {
            name = "reserved";
            desc = "Reserved";
            sw = r; hw = w;
            reset = 0x0;
        } reserved_31_13[31:13];
        field {
            name = "vpll_ssmod_cfg";
            desc = "ssmod divval[12: 9]: SSMOD divval control
- 0x0: not divided
- 0x1: not divided
- 0x2: divided by 2
- 0x3: divided by 3 …
- 0xF: divided by 15 ssmod spread[8: 4]: SSMOD spread control
- 0: 0
- 1: 0.1%
- 2: 0.2%
- 3: 0.3%
- 4: 0.4%
- 5: 0.5%
- 6: 0.6%
- 7: 0.7% ...
- 31: 3.1% ssmod downspread[3]: SSMOD downspread control
- 0: central spread spectrum
- 1: down spread spectrum ssmod_disable[2]: SSMOD disable control
- 0: enabled
- 1: disabled ssmod_rst_req[1]: SSMOD reset control
- 0: reset deasserted
- 1: reset ssmod_cken[0]: SSMOD clock gating, disabled by default
- 0: disabled
- 1: enabled";
            sw = rw; hw = r;
            reset = 0x4;
        } vpll_ssmod_cfg[12:0];
    } PERI_CRG23 @ 0x5C;
    reg {
        name = "PERI_CRG30";
        desc = "PERI_CRG30 is the CPU frequency mode and reset configuration register. (offset 0x78; total reset 0x00000001; PROVEN: Hi3516E V300 data sheet (Issue 00B06, 2019-05-15), section 3.2.6, PDF page 87).";
        field {
            name = "reserved";
            desc = "Reserved";
            sw = r; hw = w;
            reset = 0x0;
        } reserved_31_11[31:11];
        field {
            name = "cs_srst_req";
            desc = "CS soft reset request
- 0: reset deasserted
- 1: reset";
            sw = rw; hw = r;
            reset = 0x0;
        } cs_srst_req[10:10];
        field {
            name = "socdbg_srst_req";
            desc = "SOCDBG soft reset request
- 0: reset deasserted
- 1: reset";
            sw = rw; hw = r;
            reset = 0x0;
        } socdbg_srst_req[9:9];
        field {
            name = "l2_srst_req";
            desc = "L2 soft reset request
- 0: reset deasserted
- 1: reset";
            sw = rw; hw = r;
            reset = 0x0;
        } l2_srst_req[8:8];
        field {
            name = "reserved";
            desc = "Reserved";
            sw = r; hw = w;
            reset = 0x0;
        } reserved_7_4[7:4];
        field {
            name = "arm_dbg0_srst_req";
            desc = "A7 DBG soft reset request
- 0: reset deasserted
- 1: reset";
            sw = rw; hw = r;
            reset = 0x0;
        } arm_dbg0_srst_req[3:3];
        field {
            name = "reserved";
            desc = "Reserved";
            sw = rw; hw = r;
            reset = 0x0;
        } reserved_2_2[2:2];
        field {
            name = "arm_core0_srst_req";
            desc = "A7 soft reset request
- 0: reset deasserted
- 1: reset";
            sw = rw; hw = r;
            reset = 0x0;
        } arm_core0_srst_req[1:1];
        field {
            name = "pclkdbg_cken";
            desc = "A7 PCLKDBG clock gating
- 0: disabled
- 1: enabled";
            sw = rw; hw = r;
            reset = 0x1;
        } pclkdbg_cken[0:0];
    } PERI_CRG30 @ 0x78;
    reg {
        name = "PERI_CRG31";
        desc = "PERI_CRG31 is the DDR SDRAM clock and reset configuration register. (offset 0x7C; total reset 0x00000070; PROVEN: Hi3516E V300 data sheet (Issue 00B06, 2019-05-15), section 3.2.6, PDF page 87).";
        field {
            name = "reserved";
            desc = "Reserved";
            sw = r; hw = w;
            reset = 0x0;
        } reserved_31_7[31:7];
        field {
            name = "ddr_apb_cken";
            desc = "DDR APB gating
- 0: disabled
- 1: enabled";
            sw = rw; hw = r;
            reset = 0x1;
        } ddr_apb_cken[6:6];
        field {
            name = "ddr_hipack_cken";
            desc = "DDR HiPACK gating
- 0: disabled
- 1: enabled";
            sw = rw; hw = r;
            reset = 0x1;
        } ddr_hipack_cken[5:5];
        field {
            name = "ddr_cfg_cken";
            desc = "DDR CFG gating
- 0: disabled
- 1: enabled";
            sw = rw; hw = r;
            reset = 0x1;
        } ddr_cfg_cken[4:4];
        field {
            name = "reserved";
            desc = "Reserved";
            sw = r; hw = w;
            reset = 0x1;
        } reserved_3_3[3:3];
        field {
            name = "ddr_pll_bypass_cksel";
            desc = "Bypass configuration of the DDR PHY PLL spread spectrum clock
- 0: The DDR PHY PLL spread spectrum clock is bypassed.
- 1: The DDR PHY PLL spread spectrum clock is used.";
            sw = rw; hw = r;
            reset = 0x0;
        } ddr_pll_bypass_cksel[2:2];
        field {
            name = "ddr_apb_srst_req";
            desc = "DDR APB soft reset request
- 0: reset deasserted
- 1: reset";
            sw = rw; hw = r;
            reset = 0x0;
        } ddr_apb_srst_req[1:1];
        field {
            name = "ddr_hipack_srst_req";
            desc = "DDR HiPACK soft reset request
- 0: reset deasserted
- 1: reset";
            sw = rw; hw = r;
            reset = 0x0;
        } ddr_hipack_srst_req[0:0];
    } PERI_CRG31 @ 0x7C;
    reg {
        name = "PERI_CRG32";
        desc = "PERI_CRG32 is the SoC clock selection register. (offset 0x80; total reset 0x00000000; PROVEN: Hi3516E V300 data sheet (Issue 00B06, 2019-05-15), section 3.2.6, PDF page 88).";
        field {
            name = "reserved";
            desc = "Reserved";
            sw = r; hw = w;
            reset = 0x0;
        } reserved_31_11[31:11];
        field {
            name = "sysapb_cksel";
            desc = "SYSAPB clock select
- 0: 24 MHz
- 1: 50 MHz";
            sw = rw; hw = r;
            reset = 0x0;
        } sysapb_cksel[10:10];
        field {
            name = "reserved";
            desc = "Reserved";
            sw = r; hw = w;
            reset = 0x0;
        } reserved_9_9[9:9];
        field {
            name = "syscfg_cksel";
            desc = "SYSCFG clock select
- 0: 24 MHz";
            sw = rw; hw = r;
            reset = 0x0;
        } syscfg_cksel[8:8];
        field {
            name = "reserved";
            desc = "Reserved";
            sw = r; hw = w;
            reset = 0x0;
        } reserved_7_7[7:7];
        field {
            name = "sysaxi_cksel";
            desc = "SYSAXI clock select
- 0: 24 MHz
- 1: 200 MHz";
            sw = rw; hw = r;
            reset = 0x0;
        } sysaxi_cksel[6:6];
        field {
            name = "ddr_cksel";
            desc = "DDR SDRAM clock select
- 000: 24 MHz
- 001: 450 MHz
- 011: 300 MHz

Other values: The clock cannot be selected.";
            sw = rw; hw = r;
            reset = 0x0;
        } ddr_cksel[5:3];
        field {
            name = "reserved";
            desc = "Reserved";
            sw = r; hw = w;
            reset = 0x0;
        } reserved_2_2[2:2];
        field {
            name = "a7_cksel";
            desc = "A7 clock select
- 00: 24 MHz
- 01: 900 MHz
- 11: 600 MHz

Other values: reserved";
            sw = rw; hw = r;
            reset = 0x0;
        } a7_cksel[1:0];
    } PERI_CRG32 @ 0x80;
    reg {
        name = "PERI_CRG40";
        desc = "PERI_CRG40 is the frequency configuration register for the media function module. (offset 0xA0; total reset 0x00000000; PROVEN: Hi3516E V300 data sheet (Issue 00B06, 2019-05-15), section 3.2.6, PDF page 89).";
        field {
            name = "reserved";
            desc = "Reserved";
            sw = r; hw = w;
            reset = 0x0;
        } reserved_31_23[31:23];
        field {
            name = "vpss_cksel";
            desc = "VPSS clock select
- 000: 257 MHz
- 001: 200 MHz
- 010: 150 MHz
- 011: 100 MHz
- 100: 75 MHz

Other values: reserved";
            sw = rw; hw = r;
            reset = 0x0;
        } vpss_cksel[22:20];
        field {
            name = "reserved";
            desc = "Reserved";
            sw = r; hw = w;
            reset = 0x0;
        } reserved_19_19[19:19];
        field {
            name = "jpge_cksel";
            desc = "JPGE clock select
- 0: 450 MHz
- 1: 300 MHz";
            sw = rw; hw = r;
            reset = 0x0;
        } jpge_cksel[18:18];
        field {
            name = "reserved";
            desc = "Reserved";
            sw = r; hw = w;
            reset = 0x0;
        } reserved_17_11[17:11];
        field {
            name = "reserved";
            desc = "Reserved";
            sw = r; hw = w;
            reset = 0x0;
        } reserved_9_3[9:3];
        field {
            name = "ive_cksel";
            desc = "IVE clock select
- 00: 450 MHz
- 01: 360 MHz
- 10: 300 MHz
- 11: 100 MHz";
            sw = rw; hw = r;
            reset = 0x0;
        } ive_cksel[2:1];
        field {
            name = "reserved";
            desc = "Reserved";
            sw = r; hw = w;
            reset = 0x0;
        } reserved_0_0[0:0];
    } PERI_CRG40 @ 0xA0;
    reg {
        name = "PERI_CRG41";
        desc = "PERI_CRG41 is the VEDU clock and soft reset control register. (offset 0xA4; total reset 0x00000000; PROVEN: Hi3516E V300 data sheet (Issue 00B06, 2019-05-15), section 3.2.6, PDF page 90).";
        field {
            name = "reserved";
            desc = "Reserved";
            sw = r; hw = w;
            reset = 0x0;
        } reserved_31_2[31:2];
        field {
            name = "vedu_cken";
            desc = "VEDU clock gating
- 0: disabled
- 1: enabled";
            sw = rw; hw = r;
            reset = 0x0;
        } vedu_cken[1:1];
        field {
            name = "vedu_srst_req";
            desc = "VEDU soft reset request
- 0: reset deasserted
- 1: reset";
            sw = rw; hw = r;
            reset = 0x0;
        } vedu_srst_req[0:0];
    } PERI_CRG41 @ 0xA4;
    reg {
        name = "PERI_CRG42";
        desc = "PERI_CRG42 is theVPSS clock and soft reset control register. (offset 0xA8; total reset 0x00000000; PROVEN: Hi3516E V300 data sheet (Issue 00B06, 2019-05-15), section 3.2.6, PDF page 90).";
        field {
            name = "reserved";
            desc = "Reserved";
            sw = r; hw = w;
            reset = 0x0;
        } reserved_31_3[31:3];
        field {
            name = "vpss_online_cksel";
            desc = "VPSS online mode clock select
- 0: clk_vpss (offline clock)
- 1: clk_viproc. This bit is used together with the viproc_vpss_online_mode register of

MIST_CTRL.";
            sw = rw; hw = r;
            reset = 0x0;
        } vpss_online_cksel[2:2];
        field {
            name = "vpss_cken";
            desc = "VPSS clock gating
- 0: disabled
- 1: enabled";
            sw = rw; hw = r;
            reset = 0x0;
        } vpss_cken[1:1];
        field {
            name = "vpss_srst_req";
            desc = "VPSS soft reset request
- 0: reset deasserted
- 1: reset";
            sw = rw; hw = r;
            reset = 0x0;
        } vpss_srst_req[0:0];
    } PERI_CRG42 @ 0xA8;
    reg {
        name = "PERI_CRG43";
        desc = "PERI_CRG43 is theVGS clock and soft reset control register. (offset 0xAC; total reset 0x00000000; PROVEN: Hi3516E V300 data sheet (Issue 00B06, 2019-05-15), section 3.2.6, PDF page 91).";
        field {
            name = "reserved";
            desc = "Reserved";
            sw = r; hw = w;
            reset = 0x0;
        } reserved_31_2[31:2];
        field {
            name = "vgs_cken";
            desc = "VGS clock gating
- 0: disabled
- 1: enabled";
            sw = rw; hw = r;
            reset = 0x0;
        } vgs_cken[1:1];
        field {
            name = "vgs_srst_req";
            desc = "VGS soft reset request
- 0: reset deasserted
- 1: reset";
            sw = rw; hw = r;
            reset = 0x0;
        } vgs_srst_req[0:0];
    } PERI_CRG43 @ 0xAC;
    reg {
        name = "PERI_CRG44";
        desc = "PERI_CRG44 is theJPGE clock and soft reset control register. (offset 0xB0; total reset 0x00000000; PROVEN: Hi3516E V300 data sheet (Issue 00B06, 2019-05-15), section 3.2.6, PDF page 91).";
        field {
            name = "reserved";
            desc = "Reserved";
            sw = r; hw = w;
            reset = 0x0;
        } reserved_31_2[31:2];
        field {
            name = "jpge_cken";
            desc = "JPGE clock gating
- 0: disabled
- 1: enabled";
            sw = rw; hw = r;
            reset = 0x0;
        } jpge_cken[1:1];
        field {
            name = "jpge_srst_req";
            desc = "JPGE soft reset request
- 0: reset deasserted
- 1: reset";
            sw = rw; hw = r;
            reset = 0x0;
        } jpge_srst_req[0:0];
    } PERI_CRG44 @ 0xB0;
    reg {
        name = "PERI_CRG47";
        desc = "PERI_CRG47 is the IVE clock and soft reset control register. (offset 0xBC; total reset 0x00000004; PROVEN: Hi3516E V300 data sheet (Issue 00B06, 2019-05-15), section 3.2.6, PDF page 91).";
        field {
            name = "reserved";
            desc = "Reserved";
            sw = r; hw = w;
            reset = 0x0;
        } reserved_31_3[31:3];
        field {
            name = "ive_glb_cken";
            desc = "IVE global clock gating
- 0: disabled
- 1: enabled";
            sw = rw; hw = r;
            reset = 0x1;
        } ive_glb_cken[2:2];
        field {
            name = "ive_cken";
            desc = "IVE core clock gating
- 0: disabled
- 1: enabled";
            sw = rw; hw = r;
            reset = 0x0;
        } ive_cken[1:1];
        field {
            name = "ive_srst_req";
            desc = "IVE soft reset request
- 0: reset deasserted
- 1: reset";
            sw = rw; hw = r;
            reset = 0x0;
        } ive_srst_req[0:0];
    } PERI_CRG47 @ 0xBC;
    reg {
        name = "PERI_CRG60";
        desc = "PERI_CRG60 is the sensor clock and reset configuration register. (offset 0xF0; total reset 0x00000041; PROVEN: Hi3516E V300 data sheet (Issue 00B06, 2019-05-15), section 3.2.6, PDF page 92).";
        field {
            name = "reserved";
            desc = "Reserved";
            sw = r; hw = w;
            reset = 0x0;
        } reserved_31_7[31:7];
        field {
            name = "sensor0_ctrl_srst_req";
            desc = "Soft reset request of the controller for the sensor in slave mode
- 0: reset deasserted
- 1: reset";
            sw = rw; hw = r;
            reset = 0x0;
        } sensor0_ctrl_srst_req[6:6];
        field {
            name = "sensor0_ctrl_cken";
            desc = "Clock gating of the controller for the sensor in slave mode
- 0: clock disabled
- 1: clock enabled";
            sw = rw; hw = r;
            reset = 0x0;
        } sensor0_ctrl_cken[5:5];
        field {
            name = "sensor0_cksel";
            desc = "Sensor clockout configuration
- 000: 74.25 MHz
- 001: 72 MHz
- 010: 54 MHz
- 011: 24 MHz
- 100: 37.125 MHz
- 101: 36 MHz
- 110: 27 MHz
- 111: 12 MHz";
            sw = rw; hw = r;
            reset = 0x0;
        } sensor0_cksel[4:2];
        field {
            name = "sensor0_srst_req";
            desc = "Sensor soft reset request";
            sw = rw; hw = r;
            reset = 0x0;
        } sensor0_srst_req[1:1];
        field {
            name = "sensor0_cken";
            desc = "Sensor clock gating
- 0: clock disabled
- 1: clock enabled";
            sw = rw; hw = r;
            reset = 0x0;
        } sensor0_cken[0:0];
    } PERI_CRG60 @ 0xF0;
    reg {
        name = "PERI_CRG61";
        desc = "PERI_CRG61 is the VI clock and soft reset control register. (offset 0xF4; total reset 0x00000000; PROVEN: Hi3516E V300 data sheet (Issue 00B06, 2019-05-15), section 3.2.6, PDF page 93). INFERRED: the data sheet prints vi_ppc_cksel (a 3-bit field, values 000-110) at [18] and again reserved at [18]; placed at [21:19] so that the neighboring fields stay disjoint. The field name of the VICAP soft reset (bit 12) is printed as \"vicap _srst_req\" in the data sheet and is vicap_srst_req.";
        field {
            name = "reserved";
            desc = "Reserved";
            sw = r; hw = w;
            reset = 0x0;
        } reserved_31_22[31:22];
        field {
            name = "vi_ppc_cksel";
            desc = "VICAP PPC clock select
- 000: 360 MHz (not available in online mode)
- 001: 300 MHz (not available in online mode)
- 010: 257 MHz
- 011: 200 MHz
- 100: 150 MHz
- 101: 100 MHz
- 110: 75 MHz

Other values: reserved";
            sw = rw; hw = r;
            reset = 0x0;
        } vi_ppc_cksel[21:19];
        field {
            name = "reserved";
            desc = "Reserved";
            sw = r; hw = w;
            reset = 0x0;
        } reserved_18_18[18:18];
        field {
            name = "vi_p0_cksel";
            desc = "MIPI CTRL pixel clock select
- 000: 360 MHz (not available in online mode)
- 001: 300 MHz (not available in online mode)
- 010: 257 MHz
- 011: 200 MHz
- 100: 150 MHz
- 101: 100 MHz
- 110: 75 MHz
- 111: CMOS clock(up to 148.5 MHz)";
            sw = rw; hw = r;
            reset = 0x0;
        } vi_p0_cksel[17:15];
        field {
            name = "vi_cmos_pctrl";
            desc = "VI CMOS clock phase select
- 0: not inverted
- 1: inverted";
            sw = rw; hw = r;
            reset = 0x0;
        } vi_cmos_pctrl[14:14];
        field {
            name = "reserved";
            desc = "Reserved";
            sw = r; hw = w;
            reset = 0x0;
        } reserved_13_13[13:13];
        field {
            name = "vicap_srst_req";
            desc = "VICAP soft reset request";
            sw = rw; hw = r;
            reset = 0x0;
        } vicap_srst_req[12:12];
        field {
            name = "reserved";
            desc = "Reserved";
            sw = r; hw = w;
            reset = 0x0;
        } reserved_11_11[11:11];
        field {
            name = "vi_p0_srst_req";
            desc = "VI port 0 soft reset request
- 0: reset deasserted
- 1: reset";
            sw = rw; hw = r;
            reset = 0x0;
        } vi_p0_srst_req[10:10];
        field {
            name = "vi_bus_cken";
            desc = "VI bus clock gating
- 0: disabled
- 1: enabled";
            sw = rw; hw = r;
            reset = 0x0;
        } vi_bus_cken[9:9];
        field {
            name = "vi_ppc_cken";
            desc = "VI PPC clock gating
- 0: disabled
- 1: enabled";
            sw = rw; hw = r;
            reset = 0x0;
        } vi_ppc_cken[8:8];
        field {
            name = "reserved";
            desc = "Reserved";
            sw = rw; hw = r;
            reset = 0x0;
        } reserved_7_7[7:7];
        field {
            name = "vi_p0_cken";
            desc = "VI port clock gating
- 0: disabled
- 1: enabled";
            sw = rw; hw = r;
            reset = 0x0;
        } vi_p0_cken[6:6];
        field {
            name = "reserved";
            desc = "Reserved";
            sw = r; hw = w;
            reset = 0x0;
        } reserved_5_0[5:0];
    } PERI_CRG61 @ 0xF4;
    reg {
        name = "PERI_CRG62";
        desc = "PERI_CRG62 is the MIPI RX clock and soft reset control register. (offset 0xF8; total reset 0x00000000; PROVEN: Hi3516E V300 data sheet (Issue 00B06, 2019-05-15), section 3.2.6, PDF page 94).";
        field {
            name = "reserved";
            desc = "Reserved";
            sw = r; hw = w;
            reset = 0x0;
        } reserved_31_8[31:8];
        field {
            name = "mipi_hs_pctrl";
            desc = "Clock phase control of the MIPIPHY HS interface. The phase is not inverted by default.
- 0: not inverted
- 1: inverted";
            sw = rw; hw = r;
            reset = 0x0;
        } mipi_hs_pctrl[7:7];
        field {
            name = "mipi_bus_srst_req";
            desc = "Soft reset request of the MIPI bus logic
- 0: reset deasserted
- 1: reset";
            sw = rw; hw = r;
            reset = 0x0;
        } mipi_bus_srst_req[6:6];
        field {
            name = "reserved";
            desc = "Reserved";
            sw = r; hw = w;
            reset = 0x0;
        } reserved_5_5[5:5];
        field {
            name = "mipi_pix0_core_srst_req";
            desc = "Soft reset request of the MIPI PIXEL core logic
- 0: reset deasserted
- 1: reset";
            sw = rw; hw = r;
            reset = 0x0;
        } mipi_pix0_core_srst_req[4:4];
        field {
            name = "mipi_bus_cken";
            desc = "MIPI bus logic clock gating
- 0: disabled
- 1: enabled";
            sw = rw; hw = r;
            reset = 0x0;
        } mipi_bus_cken[3:3];
        field {
            name = "mipi_pix0_cken";
            desc = "MIPI pixel clock gating
- 0: disabled
- 1: enabled";
            sw = rw; hw = r;
            reset = 0x0;
        } mipi_pix0_cken[2:2];
        field {
            name = "reserved";
            desc = "Reserved";
            sw = r; hw = w;
            reset = 0x0;
        } reserved_1_1[1:1];
        field {
            name = "cil_cken";
            desc = "MIPI CIL logic clock gating
- 0: disabled
- 1: enabled";
            sw = rw; hw = r;
            reset = 0x0;
        } cil_cken[0:0];
    } PERI_CRG62 @ 0xF8;
    reg {
        name = "PERI_CRG63";
        desc = "PERI_CRG63 is the VIPROC clock and soft reset control register. (offset 0xFC; total reset 0x00000000; PROVEN: Hi3516E V300 data sheet (Issue 00B06, 2019-05-15), section 3.2.6, PDF page 95).";
        field {
            name = "reserved";
            desc = "Reserved";
            sw = r; hw = w;
            reset = 0x0;
        } reserved_31_6[31:6];
        field {
            name = "viproc_srst_req";
            desc = "VIPROC soft reset request
- 0: reset deasserted
- 1: reset";
            sw = rw; hw = r;
            reset = 0x0;
        } viproc_srst_req[5:5];
        field {
            name = "viproc_cken";
            desc = "VIPROC clock gating
- 0: disabled
- 1: enabled";
            sw = rw; hw = r;
            reset = 0x0;
        } viproc_cken[4:4];
        field {
            name = "viproc_online_cksel";
            desc = "VIPROC0 online mode select
- 0: offline, clk_viproc
- 1: online, clk_isp0

This bit is used together with the vicap_viproc_online_mode register of MIST_CTRL.";
            sw = rw; hw = r;
            reset = 0x0;
        } viproc_online_cksel[3:3];
        field {
            name = "viproc_cksel";
            desc = "VIPROC offline mode clock select
- 000: 257 MHz
- 001: 200 MHz
- 010: 150 MHz
- 011: 100 MHz";
            sw = rw; hw = r;
            reset = 0x0;
        } viproc_cksel[2:0];
    } PERI_CRG63 @ 0xFC;
    reg {
        name = "PERI_CRG64";
        desc = "PERI_CRG64 is the ISP clock and soft reset control register. (offset 0x100; total reset 0x00000000; PROVEN: Hi3516E V300 data sheet (Issue 00B06, 2019-05-15), section 3.2.6, PDF page 96).";
        field {
            name = "reserved";
            desc = "Reserved";
            sw = r; hw = w;
            reset = 0x0;
        } reserved_31_18[31:18];
        field {
            name = "isp1_core_srst_req";
            desc = "Soft reset request of ISP1 CFG
- 0: reset deasserted
- 1: reset";
            sw = rw; hw = r;
            reset = 0x0;
        } isp1_core_srst_req[17:17];
        field {
            name = "isp0_core_srst_req";
            desc = "Soft reset request of ISP0 CFG
- 0: reset deasserted
- 1: reset";
            sw = rw; hw = r;
            reset = 0x0;
        } isp0_core_srst_req[16:16];
        field {
            name = "reserved";
            desc = "Reserved";
            sw = r; hw = w;
            reset = 0x0;
        } reserved_15_15[15:15];
        field {
            name = "reserved";
            desc = "Reserved";
            sw = r; hw = w;
            reset = 0x0;
        } reserved_14_14[14:14];
        field {
            name = "isp1_cfg_srst_req";
            desc = "ISP1 cfg soft reset request
- 0: reset deasserted
- 1: reset";
            sw = rw; hw = r;
            reset = 0x0;
        } isp1_cfg_srst_req[13:13];
        field {
            name = "isp0_cfg_srst_req";
            desc = "ISP0 cfg soft reset request
- 0: reset deasserted
- 1: reset";
            sw = rw; hw = r;
            reset = 0x0;
        } isp0_cfg_srst_req[12:12];
        field {
            name = "reserved";
            desc = "Reserved";
            sw = r; hw = w;
            reset = 0x0;
        } reserved_11_0[11:0];
    } PERI_CRG64 @ 0x100;
    reg {
        name = "PERI_CRG65";
        desc = "PERI_CRG65 is the LCD clock control register. (offset 0x104; total reset 0x000FFFFF; PROVEN: Hi3516E V300 data sheet (Issue 00B06, 2019-05-15), section 3.2.6, PDF page 96).";
        field {
            name = "reserved";
            desc = "Reserved";
            sw = r; hw = w;
            reset = 0x0;
        } reserved_31_28[31:28];
        field {
            name = "lcd_cken";
            desc = "Frequency division enable for the LCD frequency divider";
            sw = rw; hw = r;
            reset = 0x0;
        } lcd_cken[27:27];
        field {
            name = "lcd_div";
            desc = "Frequency division configuration for the LCD frequency divider Assume that the target frequency is X (MHz). lcd_div = (X/1800) x 2^27";
            sw = rw; hw = r;
            reset = 0xfffff;
        } lcd_div[26:0];
    } PERI_CRG65 @ 0x104;
    reg {
        name = "PERI_CRG66";
        desc = "PERI_CRG66 is the VDP clock and reset control register. (offset 0x108; total reset 0x00100000; PROVEN: Hi3516E V300 data sheet (Issue 00B06, 2019-05-15), section 3.2.6, PDF page 97).";
        field {
            name = "reserved";
            desc = "Reserved";
            sw = r; hw = w;
            reset = 0x0;
        } reserved_31_25[31:25];
        field {
            name = "vdp_hd0_cksel";
            desc = "VDP HD clock source select
- 0000: 148.5 MHz
- 0010: 54 MHz
- 0011: 37.125 MHz
- 0100: 13.5 MHz
- 0101: LCD frequency divider clock
- 1000: 74.25 MHz
- 1001: 108 MHz
- 1010: 27 MHz
- 1011: 18.5625 MHz
- 1100: 6.75 MHz

Other values: reserved";
            sw = rw; hw = r;
            reset = 0x0;
        } vdp_hd0_cksel[24:21];
        field {
            name = "vdp_out_pctrl";
            desc = "Phase control of the VDP output clock (chip output clock)
- 0: not inverted
- 1: inverted";
            sw = rw; hw = r;
            reset = 0x1;
        } vdp_out_pctrl[20:20];
        field {
            name = "reserved";
            desc = "Reserved";
            sw = r; hw = w;
            reset = 0x0;
        } reserved_19_14[19:14];
        field {
            name = "hd0_div_mode";
            desc = "VDP DHD0 channel clock frequency division ratio
- 00: not divided
- 01: divided by 2
- 10: divided by 3
- 11: divided by 4";
            sw = rw; hw = r;
            reset = 0x0;
        } hd0_div_mode[13:12];
        field {
            name = "reserved";
            desc = "Reserved";
            sw = r; hw = w;
            reset = 0x0;
        } reserved_11_10[11:10];
        field {
            name = "vdp_bt_cken";
            desc = "VDP BT clock gating
- 0: disabled
- 1: enabled";
            sw = rw; hw = r;
            reset = 0x0;
        } vdp_bt_cken[9:9];
        field {
            name = "vdp_bt_bp_cken";
            desc = "VDP bt_bp clock gating
- 0: disabled
- 1: enabled";
            sw = rw; hw = r;
            reset = 0x0;
        } vdp_bt_bp_cken[8:8];
        field {
            name = "reserved";
            desc = "Reserved";
            sw = r; hw = w;
            reset = 0x0;
        } reserved_7_7[7:7];
        field {
            name = "vdp_hd0_cken";
            desc = "VDP DHD clock gating
- 0: disabled
- 1: enabled";
            sw = rw; hw = r;
            reset = 0x0;
        } vdp_hd0_cken[6:6];
        field {
            name = "vdp_hd_ppc_cken";
            desc = "VDP DHD working clock gating
- 0: disabled
- 1: enabled";
            sw = rw; hw = r;
            reset = 0x0;
        } vdp_hd_ppc_cken[5:5];
        field {
            name = "reserved";
            desc = "Reserved";
            sw = r; hw = w;
            reset = 0x0;
        } reserved_4_4[4:4];
        field {
            name = "vdp_cfg_cken";
            desc = "VDP configuration clock gating
- 0: disabled
- 1: enabled";
            sw = rw; hw = r;
            reset = 0x0;
        } vdp_cfg_cken[3:3];
        field {
            name = "vdp_acken";
            desc = "VDP AXI bus clock gating
- 0: disabled
- 1: enabled";
            sw = rw; hw = r;
            reset = 0x0;
        } vdp_acken[2:2];
        field {
            name = "vdp_pcken";
            desc = "VDP APB clock gating
- 0: disabled
- 1: enabled";
            sw = rw; hw = r;
            reset = 0x0;
        } vdp_pcken[1:1];
        field {
            name = "vdp_srst_req";
            desc = "VDP soft reset request
- 0: reset deasserted
- 1: reset";
            sw = rw; hw = r;
            reset = 0x0;
        } vdp_srst_req[0:0];
    } PERI_CRG66 @ 0x108;
    reg {
        name = "PERI_CRG80";
        desc = "PERI_CRG80 is the USB 2.0 clock and soft reset control register. (offset 0x140; total reset 0x00003B2F; PROVEN: Hi3516E V300 data sheet (Issue 00B06, 2019-05-15), section 3.2.6, PDF page 98).";
        field {
            name = "reserved";
            desc = "Reserved";
            sw = r; hw = w;
            reset = 0x0;
        } reserved_31_14[31:14];
        field {
            name = "usb2_freeclk_cksel";
            desc = "Free clock select of the USB 2.0 controller
- 0: UTMI clock
- 1: free 60 MHz clock";
            sw = rw; hw = r;
            reset = 0x1;
        } usb2_freeclk_cksel[13:13];
        field {
            name = "usb2_utmi_cken";
            desc = "UTMI clock gating of the USB 2.0 controller
- 0: disabled";
            sw = rw; hw = r;
            reset = 0x1;
        } usb2_utmi_cken[12:12];
        field {
            name = "usb2_phy_apb_cken";
            desc = "APB clock gating of the USB 2.0 PHY
- 0: disabled
- 1: enabled";
            sw = rw; hw = r;
            reset = 0x1;
        } usb2_phy_apb_cken[11:11];
        field {
            name = "usb2_phy_apb_srst_req";
            desc = "Soft reset request of the USB 2.0 PHY APB
- 0: reset deasserted
- 1: reset";
            sw = rw; hw = r;
            reset = 0x0;
        } usb2_phy_apb_srst_req[10:10];
        field {
            name = "usb2_ref_cken";
            desc = "REF clock gating of the USB 2.0 controller
- 0: disabled
- 1: enabled";
            sw = rw; hw = r;
            reset = 0x1;
        } usb2_ref_cken[9:9];
        field {
            name = "usb2_bus_cken";
            desc = "Bus clock gating of the USB 2.0 controller
- 0: disabled
- 1: enabled";
            sw = rw; hw = r;
            reset = 0x1;
        } usb2_bus_cken[8:8];
        field {
            name = "reserved";
            desc = "Reserved";
            sw = r; hw = w;
            reset = 0x0;
        } reserved_7_4[7:4];
        field {
            name = "usb2_vcc_srst_req";
            desc = "VCC soft reset request of the USB 2.0 controller
- 0: reset deasserted
- 1: reset";
            sw = rw; hw = r;
            reset = 0x1;
        } usb2_vcc_srst_req[3:3];
        field {
            name = "usb2_phy_xtal_cken";
            desc = "Crystal oscillator reference clock gating of the USB 2.0 PHY
- 0: disabled
- 1: enabled";
            sw = rw; hw = r;
            reset = 0x1;
        } usb2_phy_xtal_cken[2:2];
        field {
            name = "usb2_phy_port_treq";
            desc = "TPOR soft reset request of the USB 2.0 PHY
- 0: reset deasserted
- 1: reset";
            sw = rw; hw = r;
            reset = 0x1;
        } usb2_phy_port_treq[1:1];
        field {
            name = "usb2_phy_req";
            desc = "POR soft reset request of the USB 2.0 PHY
- 0: reset deasserted
- 1: reset";
            sw = rw; hw = r;
            reset = 0x1;
        } usb2_phy_req[0:0];
    } PERI_CRG80 @ 0x140;
    reg {
        name = "PERI_CRG81";
        desc = "PERI_CRG81 is the FMC clock and soft reset control register. (offset 0x144; total reset 0x00000002; PROVEN: Hi3516E V300 data sheet (Issue 00B06, 2019-05-15), section 3.2.6, PDF page 99).";
        field {
            name = "reserved";
            desc = "Reserved";
            sw = r; hw = w;
            reset = 0x0;
        } reserved_31_5[31:5];
        field {
            name = "fmc_cksel";
            desc = "FMC clock source select (In SDR mode,";
            sw = rw; hw = r;
            reset = 0x0;
        } fmc_cksel[4:2];
        field {
            name = "fmc_cken";
            desc = "FMC clock gating
- 0: disabled
- 1: enabled";
            sw = rw; hw = r;
            reset = 0x1;
        } fmc_cken[1:1];
        field {
            name = "fmc_srst_req";
            desc = "FMC soft reset request
- 0: reset deasserted
- 1: reset";
            sw = rw; hw = r;
            reset = 0x0;
        } fmc_srst_req[0:0];
    } PERI_CRG81 @ 0x144;
    reg {
        name = "PERI_CRG91";
        desc = "PERI_CRG91 is the ETH clock and soft reset control register. (offset 0x16C; total reset 0x00000006; PROVEN: Hi3516E V300 data sheet (Issue 00B06, 2019-05-15), section 3.2.6, PDF page 100).";
        field {
            name = "reserved";
            desc = "Reserved";
            sw = r; hw = w;
            reset = 0x0;
        } reserved_31_8[31:8];
        field {
            name = "ethcore_cksel";
            desc = "ETH clock source select
- 0: 100 MHz
- 1: 54 MHz";
            sw = rw; hw = r;
            reset = 0x0;
        } ethcore_cksel[7:7];
        field {
            name = "reserved";
            desc = "Reserved";
            sw = r; hw = w;
            reset = 0x0;
        } reserved_6_4[6:4];
        field {
            name = "fephy_srst_req";
            desc = "FE PHY soft reset request
- 0: reset deasserted
- 1: reset";
            sw = rw; hw = r;
            reset = 0x0;
        } fephy_srst_req[3:3];
        field {
            name = "fephy_cken";
            desc = "FE PHY clock gating
- 0: disabled
- 1: enabled";
            sw = rw; hw = r;
            reset = 0x1;
        } fephy_cken[2:2];
        field {
            name = "eth_cken";
            desc = "ETH clock gating
- 0: disabled
- 1: enabled";
            sw = rw; hw = r;
            reset = 0x1;
        } eth_cken[1:1];
        field {
            name = "hrst_eth_s";
            desc = "ETH soft reset request
- 0: reset deasserted
- 1: reset";
            sw = rw; hw = r;
            reset = 0x0;
        } hrst_eth_s[0:0];
    } PERI_CRG91 @ 0x16C;
    reg {
        name = "PERI_CRG100";
        desc = "PERI_CRG100 is the GZIP clock and reset control register. (offset 0x190; total reset 0x00000001; PROVEN: Hi3516E V300 data sheet (Issue 00B06, 2019-05-15), section 3.2.6, PDF page 101).";
        field {
            name = "reserved";
            desc = "Reserved";
            sw = r; hw = w;
            reset = 0x0;
        } reserved_31_2[31:2];
        field {
            name = "gzip_srst_req";
            desc = "GZIP soft reset request
- 0: reset deasserted
- 1: reset";
            sw = rw; hw = r;
            reset = 0x0;
        } gzip_srst_req[1:1];
        field {
            name = "gzip_cken";
            desc = "GZIP clock gating
- 0: disabled
- 1: enabled";
            sw = rw; hw = r;
            reset = 0x1;
        } gzip_cken[0:0];
    } PERI_CRG100 @ 0x190;
    reg {
        name = "PERI_CRG101";
        desc = "PERI_CRG101 is the DMAC clock and soft reset control register. (offset 0x194; total reset 0x00000000; PROVEN: Hi3516E V300 data sheet (Issue 00B06, 2019-05-15), section 3.2.6, PDF page 101).";
        field {
            name = "reserved";
            desc = "Reserved";
            sw = r; hw = w;
            reset = 0x0;
        } reserved_31_3[31:3];
        field {
            name = "dmac_cken";
            desc = "DMAC AXI clock gating
- 0: disabled
- 1: enabled";
            sw = rw; hw = r;
            reset = 0x0;
        } dmac_cken[2:2];
        field {
            name = "dmac_apb_cken";
            desc = "DMAC APB clock gating
- 0: disabled
- 1: enabled";
            sw = rw; hw = r;
            reset = 0x0;
        } dmac_apb_cken[1:1];
        field {
            name = "dmac_srst_req";
            desc = "DMAC soft reset request
- 0: reset deasserted
- 1: reset";
            sw = rw; hw = r;
            reset = 0x0;
        } dmac_srst_req[0:0];
    } PERI_CRG101 @ 0x194;
    reg {
        name = "PERI_CRG102";
        desc = "PERI_CRG102 is the DDRT clock and soft reset control register. (offset 0x198; total reset 0x00000000; PROVEN: Hi3516E V300 data sheet (Issue 00B06, 2019-05-15), section 3.2.6, PDF page 102).";
        field {
            name = "reserved";
            desc = "Reserved";
            sw = r; hw = w;
            reset = 0x0;
        } reserved_31_2[31:2];
        field {
            name = "ddrtest_cken";
            desc = "DDRT clock gating
- 0: disabled
- 1: enabled";
            sw = rw; hw = r;
            reset = 0x0;
        } ddrtest_cken[1:1];
        field {
            name = "ddrtest_srst_req";
            desc = "DDRT soft reset request
- 0: reset deasserted
- 1: reset";
            sw = rw; hw = r;
            reset = 0x0;
        } ddrtest_srst_req[0:0];
    } PERI_CRG102 @ 0x198;
    reg {
        name = "PERI_CRG103";
        desc = "PERI_CRG103 is the AIAO/AUDIO CODEC clock and reset control register. (offset 0x19C; total reset 0x00000000; PROVEN: Hi3516E V300 data sheet (Issue 00B06, 2019-05-15), section 3.2.6, PDF page 102).";
        field {
            name = "reserved";
            desc = "Reserved";
            sw = r; hw = w;
            reset = 0x0;
        } reserved_31_6[31:6];
        field {
            name = "aiao_cksel";
            desc = "AIAO clock select
- 0: 50 MHz
- 1: 100 HMz";
            sw = rw; hw = r;
            reset = 0x0;
        } aiao_cksel[5:5];
        field {
            name = "codec_ana_rst_req";
            desc = "Analog reset request of the audio codec (The reset time must be at least 0.5 μs.)
- 0: reset deasserted
- 1: reset";
            sw = rw; hw = r;
            reset = 0x0;
        } codec_ana_rst_req[4:4];
        field {
            name = "codec_dig_rst_req";
            desc = "Digital logic reset request of the audio codec (The reset time must be at least 0.5 μs.)
- 0: reset deasserted
- 1: reset";
            sw = rw; hw = r;
            reset = 0x0;
        } codec_dig_rst_req[3:3];
        field {
            name = "aiao_pll_cken";
            desc = "AIAO PLL clock gating
- 0: disabled
- 1: enabled";
            sw = rw; hw = r;
            reset = 0x0;
        } aiao_pll_cken[2:2];
        field {
            name = "aiao_cken";
            desc = "AIAO clock gating
- 0: disabled
- 1: enabled";
            sw = rw; hw = r;
            reset = 0x0;
        } aiao_cken[1:1];
        field {
            name = "aiao_srst_req";
            desc = "AIAO soft reset request
- 0: reset deasserted
- 1: reset";
            sw = rw; hw = r;
            reset = 0x0;
        } aiao_srst_req[0:0];
    } PERI_CRG103 @ 0x19C;
    reg {
        name = "PERI_CRG104";
        desc = "PERI_CRG104 is the SPAcc/RSA/TRNG/KLAD clock and soft reset control register. (offset 0x1A0; total reset 0x0000002A; PROVEN: Hi3516E V300 data sheet (Issue 00B06, 2019-05-15), section 3.2.6, PDF page 103).";
        field {
            name = "reserved";
            desc = "Reserved";
            sw = r; hw = w;
            reset = 0x0;
        } reserved_31_10[31:10];
        field {
            name = "spacc_cken";
            desc = "SPAcc clock gating
- 0: disabled
- 1: enabled";
            sw = rw; hw = r;
            reset = 0x0;
        } spacc_cken[9:9];
        field {
            name = "spacc_srst_req_ini";
            desc = "SPAcc soft reset request
- 0: reset deasserted
- 1: reset";
            sw = rw; hw = r;
            reset = 0x0;
        } spacc_srst_req_ini[8:8];
        field {
            name = "reserved";
            desc = "Reserved";
            sw = r; hw = w;
            reset = 0x0;
        } reserved_7_6[7:6];
        field {
            name = "rsa0_cken";
            desc = "RSA clock gating
- 0: disabled
- 1: enabled";
            sw = rw; hw = r;
            reset = 0x1;
        } rsa0_cken[5:5];
        field {
            name = "rsa0_srst_req";
            desc = "RSA soft reset request
- 0: reset deasserted
- 1: reset";
            sw = rw; hw = r;
            reset = 0x0;
        } rsa0_srst_req[4:4];
        field {
            name = "trng_cken";
            desc = "TRNG clock gating
- 0: disabled
- 1: enabled";
            sw = rw; hw = r;
            reset = 0x1;
        } trng_cken[3:3];
        field {
            name = "trng_srst_req";
            desc = "TRNG soft reset request
- 0: reset deasserted
- 1: reset";
            sw = rw; hw = r;
            reset = 0x0;
        } trng_srst_req[2:2];
        field {
            name = "klad_cken";
            desc = "KLAD clock gating
- 0: disabled
- 1: enabled";
            sw = rw; hw = r;
            reset = 0x1;
        } klad_cken[1:1];
        field {
            name = "klad_srst_req";
            desc = "KLAD soft reset request
- 0: reset deasserted
- 1: reset";
            sw = rw; hw = r;
            reset = 0x0;
        } klad_srst_req[0:0];
    } PERI_CRG104 @ 0x1A0;
    reg {
        name = "PERI_CRG110";
        desc = "PERI_CRG110 is the I2C/UART clock and reset control register. (offset 0x1B8; total reset 0x00000001; PROVEN: Hi3516E V300 data sheet (Issue 00B06, 2019-05-15), section 3.2.6, PDF page 104).";
        field {
            name = "reserved";
            desc = "Reserved";
            sw = r; hw = w;
            reset = 0x0;
        } reserved_31_23[31:23];
        field {
            name = "i2c3_srst_req";
            desc = "I2C3 soft reset request
- 0: reset deasserted
- 1: reset

The chip has only I2C0 to I2C2; the data sheet lists this bit anyway (INFERRED: reserved range printed as [31:22], overlapping bit 22, corrected to [31:23]).";
            sw = rw; hw = r;
            reset = 0x0;
        } i2c3_srst_req[22:22];
        field {
            name = "i2c2_srst_req";
            desc = "I2C 2 soft reset request
- 0: reset deasserted
- 1: reset";
            sw = rw; hw = r;
            reset = 0x0;
        } i2c2_srst_req[21:21];
        field {
            name = "i2c1_srst_req";
            desc = "I2C1 soft reset request
- 0: reset deasserted
- 1: reset";
            sw = rw; hw = r;
            reset = 0x0;
        } i2c1_srst_req[20:20];
        field {
            name = "i2c0_srst_req";
            desc = "I2C 0 soft reset request
- 0: reset deasserted
- 1: reset";
            sw = rw; hw = r;
            reset = 0x0;
        } i2c0_srst_req[19:19];
        field {
            name = "reserved";
            desc = "Reserved";
            sw = r; hw = w;
            reset = 0x0;
        } reserved_18_14[18:14];
        field {
            name = "i2c2_cken";
            desc = "I2C 2 clock gating
- 0: disabled
- 1: enabled";
            sw = rw; hw = r;
            reset = 0x0;
        } i2c2_cken[13:13];
        field {
            name = "i2c1_cken";
            desc = "I2C 1 clock gating
- 0: disabled
- 1: enabled";
            sw = rw; hw = r;
            reset = 0x0;
        } i2c1_cken[12:12];
        field {
            name = "i2c0_cken";
            desc = "I2C 0 clock gating
- 0: disabled
- 1: enabled";
            sw = rw; hw = r;
            reset = 0x0;
        } i2c0_cken[11:11];
        field {
            name = "reserved";
            desc = "Reserved";
            sw = r; hw = w;
            reset = 0x0;
        } reserved_10_8[10:8];
        field {
            name = "uart2_srst_req";
            desc = "UART 2 soft reset request
- 0: reset deasserted
- 1: reset";
            sw = rw; hw = r;
            reset = 0x0;
        } uart2_srst_req[7:7];
        field {
            name = "uart1_srst_req";
            desc = "UART 1 soft reset request
- 0: reset deasserted
- 1: reset";
            sw = rw; hw = r;
            reset = 0x0;
        } uart1_srst_req[6:6];
        field {
            name = "uart0_srst_req";
            desc = "UART 0 soft reset request
- 0: reset deasserted";
            sw = rw; hw = r;
            reset = 0x0;
        } uart0_srst_req[5:5];
        field {
            name = "reserved";
            desc = "Reserved";
            sw = r; hw = w;
            reset = 0x0;
        } reserved_4_3[4:3];
        field {
            name = "uart2_cken";
            desc = "UART 2 clock gating
- 0: disabled
- 1: enabled";
            sw = rw; hw = r;
            reset = 0x0;
        } uart2_cken[2:2];
        field {
            name = "uart1_cken";
            desc = "UART 1 clock gating
- 0: disabled
- 1: enabled";
            sw = rw; hw = r;
            reset = 0x0;
        } uart1_cken[1:1];
        field {
            name = "uart0_cken";
            desc = "UART 0 clock gating
- 0: disabled
- 1: enabled";
            sw = rw; hw = r;
            reset = 0x1;
        } uart0_cken[0:0];
    } PERI_CRG110 @ 0x1B8;
    reg {
        name = "PERI_CRG111";
        desc = "PERI_CRG111 is the SPI/LSADC/UART/OTP/PWM clock and soft reset control register. (offset 0x1BC; total reset 0x00000003; PROVEN: Hi3516E V300 data sheet (Issue 00B06, 2019-05-15), section 3.2.6, PDF page 105).";
        field {
            name = "reserved";
            desc = "Reserved";
            sw = r; hw = w;
            reset = 0x0;
        } reserved_31_24[31:24];
        field {
            name = "ls_adc_cksel";
            desc = "LSADC clock select
- 0: reset deasserted
- 1: reset";
            sw = rw; hw = r;
            reset = 0x0;
        } ls_adc_cksel[23:23];
        field {
            name = "reserved";
            desc = "Reserved";
            sw = r; hw = w;
            reset = 0x0;
        } reserved_22_21[22:21];
        field {
            name = "uart2_cksel";
            desc = "UART 2 clock select
- 0: 24 MHz
- 1: 3 MHz";
            sw = rw; hw = r;
            reset = 0x0;
        } uart2_cksel[20:20];
        field {
            name = "uart1_cksel";
            desc = "UART 1 clock select
- 0: 24 MHz
- 1: 3 MHz";
            sw = rw; hw = r;
            reset = 0x0;
        } uart1_cksel[19:19];
        field {
            name = "uart0_cksel";
            desc = "UART 0 clock select
- 0: 24 MHz
- 1: 3 MHz";
            sw = rw; hw = r;
            reset = 0x0;
        } uart0_cksel[18:18];
        field {
            name = "reserved";
            desc = "Reserved";
            sw = r; hw = w;
            reset = 0x0;
        } reserved_17_17[17:17];
        field {
            name = "spi1_srst_req";
            desc = "SPI 1 soft reset request
- 0: reset deasserted
- 1: reset";
            sw = rw; hw = r;
            reset = 0x0;
        } spi1_srst_req[16:16];
        field {
            name = "spi0_srst_req";
            desc = "SPI 0 soft reset request
- 0: reset deasserted
- 1: reset";
            sw = rw; hw = r;
            reset = 0x0;
        } spi0_srst_req[15:15];
        field {
            name = "reserved";
            desc = "Reserved";
            sw = r; hw = w;
            reset = 0x0;
        } reserved_14_14[14:14];
        field {
            name = "ssp1_cken";
            desc = "SPI 1 clock gating
- 0: disabled
- 1: enabled";
            sw = rw; hw = r;
            reset = 0x0;
        } ssp1_cken[13:13];
        field {
            name = "ssp0_cken";
            desc = "SPI 0 clock gating
- 0: disabled
- 1: enabled";
            sw = rw; hw = r;
            reset = 0x0;
        } ssp0_cken[12:12];
        field {
            name = "reserved";
            desc = "Reserved";
            sw = r; hw = w;
            reset = 0x0;
        } reserved_11_11[11:11];
        field {
            name = "reserved";
            desc = "Reserved";
            sw = r; hw = w;
            reset = 0x0;
        } reserved_10_10[10:10];
        field {
            name = "pwm_cksel";
            desc = "PWM clock select
- 00: 3 MHz
- 01: 50 MHz 1X: 24 MHz";
            sw = rw; hw = r;
            reset = 0x0;
        } pwm_cksel[9:8];
        field {
            name = "pwm_cken";
            desc = "PWM clock gating
- 0: disabled
- 1: enabled";
            sw = rw; hw = r;
            reset = 0x0;
        } pwm_cken[7:7];
        field {
            name = "pwm_srst_req";
            desc = "PWM soft reset request
- 0: reset deasserted
- 1: reset";
            sw = rw; hw = r;
            reset = 0x0;
        } pwm_srst_req[6:6];
        field {
            name = "reserved";
            desc = "Reserved";
            sw = r; hw = w;
            reset = 0x0;
        } reserved_5_5[5:5];
        field {
            name = "svb_pwm_srst_req";
            desc = "SVB PWM soft reset request
- 0: reset deasserted
- 1: reset";
            sw = rw; hw = r;
            reset = 0x0;
        } svb_pwm_srst_req[4:4];
        field {
            name = "reserved";
            desc = "Reserved";
            sw = r; hw = w;
            reset = 0x0;
        } reserved_3_3[3:3];
        field {
            name = "ls_adc_srst_req";
            desc = "LSADC soft reset request
- 0: reset deasserted
- 1: reset";
            sw = rw; hw = r;
            reset = 0x0;
        } ls_adc_srst_req[2:2];
        field {
            name = "otp_cken";
            desc = "OTP clock gating
- 0: disabled
- 1: enabled";
            sw = rw; hw = r;
            reset = 0x1;
        } otp_cken[1:1];
        field {
            name = "test_clk_en";
            desc = "Test clock enable
- 0: All test clocks are disabled.";
            sw = rw; hw = r;
            reset = 0x1;
        } test_clk_en[0:0];
    } PERI_CRG111 @ 0x1BC;
    reg {
        name = "PERI_CRG112";
        desc = "PERI_CRG112 is the SHPM clock and reset control register. (offset 0x1C0; total reset 0x00000000; PROVEN: Hi3516E V300 data sheet (Issue 00B06, 2019-05-15), section 3.2.6, PDF page 107).";
        field {
            name = "reserved";
            desc = "Reserved";
            sw = r; hw = w;
            reset = 0x0;
        } reserved_31_3[31:3];
        field {
            name = "shpm_srst_req";
            desc = "SHPM soft reset request
- 0: reset deasserted
- 1: reset";
            sw = rw; hw = r;
            reset = 0x0;
        } shpm_srst_req[2:2];
        field {
            name = "shpm_cken";
            desc = "SHPM clock gating configuration
- 0: disabled
- 1: enabled";
            sw = rw; hw = r;
            reset = 0x0;
        } shpm_cken[1:1];
        field {
            name = "reserved";
            desc = "Reserved";
            sw = r; hw = w;
            reset = 0x0;
        } reserved_0_0[0:0];
    } PERI_CRG112 @ 0x1C0;
    reg {
        name = "PERI_CRG_PLL121";
        desc = "PERI_CRG_PLL121 is the reset state register. (offset 0x1E4; total reset 0x00000000; PROVEN: Hi3516E V300 data sheet (Issue 00B06, 2019-05-15), section 3.2.6, PDF page 107).";
        field {
            name = "reserved";
            desc = "Reserved";
            sw = r; hw = w;
            reset = 0x0;
        } reserved_31_6[31:6];
        field {
            name = "vgs_softrst_state";
            desc = "VGS reset state
- 0: reset deasserted
- 1: reset";
            sw = r; hw = w;
            reset = 0x0;
        } vgs_softrst_state[5:5];
        field {
            name = "viproc_softrst_state";
            desc = "VIPROC reset state
- 0: reset deasserted
- 1: reset";
            sw = r; hw = w;
            reset = 0x0;
        } viproc_softrst_state[4:4];
        field {
            name = "vpss_softrst_state";
            desc = "VPSS reset state
- 0: reset deasserted
- 1: reset";
            sw = r; hw = w;
            reset = 0x0;
        } vpss_softrst_state[3:3];
        field {
            name = "vicap_softrst_state";
            desc = "VICAP reset state
- 0: reset deasserted";
            sw = r; hw = w;
            reset = 0x0;
        } vicap_softrst_state[2:2];
        field {
            name = "gzip_rst_ok";
            desc = "GZIP reset state
- 0: reset deasserted
- 1: reset";
            sw = r; hw = w;
            reset = 0x0;
        } gzip_rst_ok[1:1];
        field {
            name = "reserved";
            desc = "Reserved";
            sw = r; hw = w;
            reset = 0x0;
        } reserved_0_0[0:0];
    } PERI_CRG_PLL121 @ 0x1E4;
    reg {
        name = "PERI_CRG_PLL122";
        desc = "PERI_CRG_PLL122 is the PLL lock status register. (offset 0x1E8; total reset 0x00000000; PROVEN: Hi3516E V300 data sheet (Issue 00B06, 2019-05-15), section 3.2.6, PDF page 108).";
        field {
            name = "reserved";
            desc = "Reserved";
            sw = r; hw = w;
            reset = 0x0;
        } reserved_31_3[31:3];
        field {
            name = "vpll_lock";
            desc = "VPLL lock status
- 0: unlocked
- 1: locked";
            sw = r; hw = w;
            reset = 0x0;
        } vpll_lock[2:2];
        field {
            name = "reserved";
            desc = "Reserved";
            sw = r; hw = w;
            reset = 0x0;
        } reserved_1_1[1:1];
        field {
            name = "apll_lock";
            desc = "APLL lock status
- 0: unlocked
- 1: locked";
            sw = r; hw = w;
            reset = 0x0;
        } apll_lock[0:0];
    } PERI_CRG_PLL122 @ 0x1E8;
    reg {
        name = "PERI_CRG_PLL124";
        desc = "PERI_CRG_PLL124 is the CPU high-speed MEM memory adjustment mode select register. (offset 0x1F0; total reset 0x00000001; PROVEN: Hi3516E V300 data sheet (Issue 00B06, 2019-05-15), section 3.2.6, PDF page 108).";
        field {
            name = "reserved";
            desc = "Reserved";
            sw = r; hw = w;
            reset = 0x0;
        } reserved_31_1[31:1];
        field {
            name = "mem_adjust_bypass";
            desc = "Speed adjustment mode of the CPU high-speed memory
- 0: non-bypass mode
- 1: bypass mode";
            sw = rw; hw = r;
            reset = 0x1;
        } mem_adjust_bypass[0:0];
    } PERI_CRG_PLL124 @ 0x1F0;
    reg {
        name = "PERI_CRG125";
        desc = "PERI_CRG125 is the eMMC/SDIO0 clock and reset control register. (offset 0x1F4; total reset 0x11010000; PROVEN: Hi3516E V300 data sheet (Issue 00B06, 2019-05-15), section 3.2.6, PDF page 109).";
        field {
            name = "reserved";
            desc = "Reserved";
            sw = r; hw = w;
            reset = 0x0;
        } reserved_31_29[31:29];
        field {
            name = "emmc_cken";
            desc = "eMMC clock gating
- 0: disabled
- 1: enabled";
            sw = rw; hw = r;
            reset = 0x1;
        } emmc_cken[28:28];
        field {
            name = "emmc_srst_req";
            desc = "eMMC soft reset request
- 0: reset deasserted
- 1: reset";
            sw = rw; hw = r;
            reset = 0x0;
        } emmc_srst_req[27:27];
        field {
            name = "emmc_cksel";
            desc = "eMMC clock select
- 000: 100 KHz
- 001: 400 KHz
- 010: 25 MHz
- 011: 50 MHz
- 100: 90 MHz (supported only in eMMC mode)
- 101: 112.5 MHz (supported only in eMMC mode)
- 110: 150 MHz (supported only in eMMC mode)

Other values: reserved";
            sw = rw; hw = r;
            reset = 0x1;
        } emmc_cksel[26:24];
        field {
            name = "emmc_tx_srst_req";
            desc = "eMMC TX soft reset request
- 0: reset deasserted
- 1: reset";
            sw = rw; hw = r;
            reset = 0x0;
        } emmc_tx_srst_req[23:23];
        field {
            name = "emmc_rx_srst_req";
            desc = "eMMC RX soft reset request
- 0: reset deasserted
- 1: reset";
            sw = rw; hw = r;
            reset = 0x0;
        } emmc_rx_srst_req[22:22];
        field {
            name = "reserved";
            desc = "Reserved";
            sw = r; hw = w;
            reset = 0x10000;
        } reserved_21_0[21:0];
    } PERI_CRG125 @ 0x1F4;
    reg {
        name = "PERI_CRG126";
        desc = "PERI_CRG126 is the eMMC/SDIO0 SAMB clock phase configuration register. (offset 0x1F8; total reset 0x00000008; PROVEN: Hi3516E V300 data sheet (Issue 00B06, 2019-05-15), section 3.2.6, PDF page 109).";
        field {
            name = "reserved";
            desc = "Reserved";
            sw = rw; hw = r;
            reset = 0x0;
        } reserved_31_5[31:5];
        field {
            name = "emmc_sample_b_cclk_sel";
            desc = "Clock phase configuration. It is used for sample B clock debugging when the edge detection function is used.
- 0x00: 0 degrees
- 0x01: 11.25 degrees
- 0x02: 22.5 degrees
- ...
- 0x1E: 337.5 degrees
- 0x1F: 348.75 degrees

The default value is 90 degrees, that is, 0x08. (The field name is split across the page break in the data sheet, PDF pages 109-110; completed by analogy with sdio1_sample_b_cclk_sel of PERI_CRG135.)";
            sw = rw; hw = r;
            reset = 0x8;
        } emmc_sample_b_cclk_sel[4:0];
    } PERI_CRG126 @ 0x1F8;
    reg {
        name = "PERI_CRG127";
        desc = "PERI_CRG127 is the eMMC/SDIO0 DRV clock phase configuration register. (offset 0x1FC; total reset 0x10014000; PROVEN: Hi3516E V300 data sheet (Issue 00B06, 2019-05-15), section 3.2.6, PDF page 110).";
        field {
            name = "reserved";
            desc = "Reserved";
            sw = rw; hw = r;
            reset = 0x0;
        } reserved_31_29[31:29];
        field {
            name = "emmc_drv_clk_phase_sel";
            desc = "eMMC DRV clock phase configuration. The default value is 180°.
- 0x00: 0°
- 0x01: 11.25°
- 0x02: 22.5° …
- 0x1E: 337.5°
- 0x1F: 348.75°";
            sw = rw; hw = r;
            reset = 0x10;
        } emmc_drv_clk_phase_sel[28:24];
        field {
            name = "reserved";
            desc = "Reserved";
            sw = rw; hw = r;
            reset = 0x14000;
        } reserved_23_0[23:0];
    } PERI_CRG127 @ 0x1FC;
    reg {
        name = "PERI_CRG129";
        desc = "PERI_CRG129 is the eMMC DS 180 clock phase configuration register. (offset 0x204; total reset 0x08010000; PROVEN: Hi3516E V300 data sheet (Issue 00B06, 2019-05-15), section 3.2.6, PDF page 110).";
        field {
            name = "reserved";
            desc = "Reserved";
            sw = rw; hw = r;
            reset = 0x0;
        } reserved_31_29[31:29];
        field {
            name = "emmc_ds_180_clk_phase_sel";
            desc = "eMMC DS 180 clock phase configuration. The default value is 90°.
- 0x00: 0°
- 0x01: 11.25°
- 0x02: 22.5° …
- 0x1E: 337.5°
- 0x1F: 348.75°";
            sw = rw; hw = r;
            reset = 0x8;
        } emmc_ds_180_clk_phase_sel[28:24];
        field {
            name = "reserved";
            desc = "Reserved";
            sw = rw; hw = r;
            reset = 0x10000;
        } reserved_23_0[23:0];
    } PERI_CRG129 @ 0x204;
    reg {
        name = "PERI_CRG135";
        desc = "PERI_CRG135 is the SDIO1 SAMB clock phase configuration register. (offset 0x21C; total reset 0x08000000; PROVEN: Hi3516E V300 data sheet (Issue 00B06, 2019-05-15), section 3.2.6, PDF page 111).";
        field {
            name = "reserved";
            desc = "Reserved";
            sw = rw; hw = r;
            reset = 0x0;
        } reserved_31_29[31:29];
        field {
            name = "sdio1_sample_b_cclk_sel";
            desc = "Clock phase configuration. It is used for sample B clock debugging when the edge detection function is used.
- 0x00: 0°
- 0x01: 11.25°
- 0x02: 22.5° …
- 0x1E: 337.5°
- 0x1F: 348.75°

The default value is 90°, that is, 0x08.";
            sw = rw; hw = r;
            reset = 0x8;
        } sdio1_sample_b_cclk_sel[28:24];
        field {
            name = "reserved";
            desc = "Reserved";
            sw = rw; hw = r;
            reset = 0x0;
        } reserved_23_0[23:0];
    } PERI_CRG135 @ 0x21C;
    reg {
        name = "PERI_CRG136";
        desc = "PERI_CRG136 is the SDIO1 DRV clock phase configuration register. (offset 0x220; total reset 0x10014000; PROVEN: Hi3516E V300 data sheet (Issue 00B06, 2019-05-15), section 3.2.6, PDF page 111).";
        field {
            name = "reserved";
            desc = "Reserved";
            sw = rw; hw = r;
            reset = 0x0;
        } reserved_31_29[31:29];
        field {
            name = "sdio1_drv_clk_phase_sel";
            desc = "SDIO1 DRV clock phase configuration. The default value is 180°.
- 0x00: 0°
- 0x01: 11.25°
- 0x02: 22.5° …
- 0x1E: 337.5°
- 0x1F: 348.75°";
            sw = rw; hw = r;
            reset = 0x10;
        } sdio1_drv_clk_phase_sel[28:24];
        field {
            name = "reserved";
            desc = "Reserved";
            sw = rw; hw = r;
            reset = 0x14000;
        } reserved_23_0[23:0];
    } PERI_CRG136 @ 0x220;
    reg {
        name = "PERI_CRG139";
        desc = "PERI_CRG139 is the SDIO1 clock and reset control register. (offset 0x22C; total reset 0x01010000; PROVEN: Hi3516E V300 data sheet (Issue 00B06, 2019-05-15), section 3.2.6, PDF page 112).";
        field {
            name = "reserved";
            desc = "Reserved";
            sw = r; hw = w;
            reset = 0x0;
        } reserved_31_29[31:29];
        field {
            name = "sdio1_cken";
            desc = "SDIO1 clock gating
- 0: disabled
- 1: enabled";
            sw = rw; hw = r;
            reset = 0x0;
        } sdio1_cken[28:28];
        field {
            name = "sdio1_srst_req";
            desc = "SDIO1 soft reset request
- 0: reset deasserted
- 1: reset";
            sw = rw; hw = r;
            reset = 0x0;
        } sdio1_srst_req[27:27];
        field {
            name = "sdio1_cksel";
            desc = "SDIO1 clock select
- 000: 100 KHz
- 001: 400 KHz
- 010: 25 MHz
- 011: 50 MHz

Other values: reserved";
            sw = rw; hw = r;
            reset = 0x1;
        } sdio1_cksel[26:24];
        field {
            name = "sdio1_tx_srst_req";
            desc = "SDIO1 TX soft reset request
- 0: reset deasserted
- 1: reset";
            sw = rw; hw = r;
            reset = 0x0;
        } sdio1_tx_srst_req[23:23];
        field {
            name = "sdio1_rx_srst_req";
            desc = "SDIO1 RX soft reset request
- 0: reset deasserted
- 1: reset";
            sw = rw; hw = r;
            reset = 0x0;
        } sdio1_rx_srst_req[22:22];
        field {
            name = "reserved";
            desc = "Reserved";
            sw = r; hw = w;
            reset = 0x10000;
        } reserved_21_0[21:0];
    } PERI_CRG139 @ 0x22C;

    reg {
        name = "Motion detection (MD) reset";
        desc = "NOT IN THE DATA SHEET: kept from the vendor-code derived register map of this chip (INFERRED, vendor evidence only). Only bit 0 is known. Evidence: PROVEN, sys.ko SYS_HAL_MdResetSel read-modify-writes bit 0 (1 = reset asserted).";
        field {
            name = "md_srst_req";
            desc = "MD (motion detect) module soft reset. PROVEN (sys.ko SYS_HAL_MdResetSel).";
            sw = rw;
            hw = r;
        } md_srst_req[0:0];
    } PERI_CRG26_V @ 0x68;

    reg {
        name = "eFuse/OTP controller clock and reset";
        desc = "NOT IN THE DATA SHEET: kept from the vendor-code derived register map of this chip (INFERRED, vendor evidence only). Evidence: PROVEN (vendor cipher driver hal_efuse.c REG_SYS_EFUSE_CLK_ADDR_PHY 0x120100D8: sets bit 0 and bit 1, then clears bit 0).";
        field {
            name = "efuse_srst_req";
            desc = "eFuse controller reset. PROVEN.";
            sw = rw;
            hw = r;
        } efuse_srst_req[0:0];
        field {
            name = "efuse_cken";
            desc = "eFuse controller clock enable. PROVEN.";
            sw = rw;
            hw = r;
        } efuse_cken[1:1];
    } PERI_CRG54_V @ 0xD8;

    reg {
        name = "eMMC DS DLL control";
        desc = "NOT IN THE DATA SHEET: kept from the vendor-code derived register map of this chip (INFERRED, vendor evidence only). Evidence: PROVEN (U-Boot EMMC_DS_DLL_MODE_SSEL bit 13, EMMC_DS_DLL_SSEL_MASK 0x7F; the EV300 U-Boot leaves both functions empty).";
        field {
            name = "ds_dll_ssel";
            desc = "DS DLL delay select. PROVEN position.";
            sw = rw;
            hw = r;
        } ds_dll_ssel[6:0];
        field {
            name = "ds_dll_mode_ssel";
            desc = "DS DLL mode select. PROVEN position.";
            sw = rw;
            hw = r;
        } ds_dll_mode_ssel[13:13];
    } PERI_CRG128_V @ 0x200;

    reg {
        name = "eMMC sample DLL status";
        desc = "NOT IN THE DATA SHEET: kept from the vendor-code derived register map of this chip (INFERRED, vendor evidence only). Evidence: PROVEN (U-Boot SDIO_SAMPL_DLL_SLAVE_READY bit 0).";
        field {
            name = "sampl_dll_slave_ready";
            desc = "Sampling DLL slave ready. PROVEN.";
            sw = r;
            hw = w;
        } sampl_dll_slave_ready[0:0];
    } PERI_CRG130_V @ 0x208;

    reg {
        name = "eMMC drive DLL status";
        desc = "NOT IN THE DATA SHEET: kept from the vendor-code derived register map of this chip (INFERRED, vendor evidence only). Evidence: PROVEN (U-Boot SDIO_DRV_DLL_LOCK bit 15, SDIO_DRV_DLL_READY bit 14).";
        field {
            name = "drv_dll_ready";
            desc = "Drive DLL ready. PROVEN.";
            sw = r;
            hw = w;
        } drv_dll_ready[14:14];
        field {
            name = "drv_dll_lock";
            desc = "Drive DLL master locked. PROVEN.";
            sw = r;
            hw = w;
        } drv_dll_lock[15:15];
    } PERI_CRG132_V @ 0x210;

    reg {
        name = "eMMC DS180 DLL status";
        desc = "NOT IN THE DATA SHEET: kept from the vendor-code derived register map of this chip (INFERRED, vendor evidence only). Evidence: PROVEN (U-Boot EMMC_DS180_DLL_READY bit 0).";
        field {
            name = "ds180_dll_ready";
            desc = "DS180 DLL ready. PROVEN.";
            sw = r;
            hw = w;
        } ds180_dll_ready[0:0];
    } PERI_CRG134_V @ 0x218;

    reg {
        name = "SDIO1 sample DLL status";
        desc = "NOT IN THE DATA SHEET: kept from the vendor-code derived register map of this chip (INFERRED, vendor evidence only). Evidence: PROVEN (U-Boot REG_SDIO1_SAMPL_DLL_STATUS).";
        field {
            name = "sampl_dll_slave_ready";
            desc = "Sampling DLL slave ready. PROVEN.";
            sw = r;
            hw = w;
        } sampl_dll_slave_ready[0:0];
    } PERI_CRG137_V @ 0x224;

    reg {
        name = "SDIO1 drive DLL status";
        desc = "NOT IN THE DATA SHEET: kept from the vendor-code derived register map of this chip (INFERRED, vendor evidence only). Evidence: PROVEN (U-Boot REG_SDIO1_DRV_DLL_STATUS).";
        field {
            name = "drv_dll_ready";
            desc = "Drive DLL ready. PROVEN.";
            sw = r;
            hw = w;
        } drv_dll_ready[14:14];
        field {
            name = "drv_dll_lock";
            desc = "Drive DLL master locked. PROVEN.";
            sw = r;
            hw = w;
        } drv_dll_lock[15:15];
    } PERI_CRG138_V @ 0x228;
};
`endif
