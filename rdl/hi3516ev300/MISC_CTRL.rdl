`ifndef HI3516EV300_MISC_CTRL_RDL
`define HI3516EV300_MISC_CTRL_RDL

regfile eMISC_CTRL_EV300 {
    name = "Miscellaneous control (MISC_CTRL), Hi3516EV300";
    desc = "MISC controller at 0x12028000 (32 KB window ioremapped by sys.ko). Names use the MISC_CTRLn scheme (offset = n x 4) shared with the Hi3516AV300 data sheet, whose register assignment is DIFFERENT in several places (SVB PWM at 0x90 there, 0xB0 here; DDR_CA at 0xD8 there, HPM here). Only registers with direct vendor evidence are described. PROVEN / INFERRED / UNKNOWN labels per register.";

    reg {
        name = "MISC control 0";
        desc = "Evidence: PROVEN offset (Goke sys_config.c sys_ctl writes 0 'VGS & GZIP, VEDU & Boot RAM'; the vendor DT lists 0x12028000 as the SPI1 chip-select register with hisi,spi_cs_sb = 2, hisi,spi_cs_mask_bit = 4), field layout UNKNOWN. The AV300 MISC_CTRL0 has per-peripheral chip-select polarity bits and vgs_bootram_mode; the EV300 layout is probably similar but unconfirmed (INFERRED).";
        field {
            name = "misc0";
            desc = "Raw register. PROVEN offset, layout UNKNOWN.";
            sw = rw;
            hw = r;
        } misc0[31:0];
    } MISC_CTRL0 @ 0x0;

    reg {
        name = "MISC control 1 (USB PHY trim value)";
        desc = "The vendor DT USB PHY node reads the trim value from 0x12028004 (trim_otp_addr, mask 0x1F, accepted range 0x09..0x1D). Evidence: PROVEN (DT).";
        field {
            name = "usb_trim";
            desc = "USB2 PHY trim value from OTP. PROVEN (DT).";
            sw = r;
            hw = w;
        } usb_trim[4:0];
    } MISC_CTRL1 @ 0x4;

    reg {
        name = "MISC control 4";
        desc = "Goke sys_config.c writes 0x35 ('VGS GZIP' memory control) here during sysconfig_init. Evidence: PROVEN offset and value, UNKNOWN fields (AV300: gzip/bootrom/ret1n bits).";
        field {
            name = "misc4";
            desc = "Raw register. PROVEN offset, UNKNOWN layout.";
            sw = rw;
            hw = r;
        } misc4[31:0];
    } MISC_CTRL4 @ 0x10;

    reg {
        name = "VI / VPSS mode select";
        desc = "Evidence: PROVEN (sys.ko SYS_HAL_ViCapProcOnlineSel bit 6, VpssOnlineSel bit 7, ViDevInputiSel bits 4 and 5), same register and bit positions as the AV300 sheet MISC_CTRL6 (viproc_vpss_online_mode [7], vicap_viproc_online_mode [6], vi_port1_input_sel [5]).";
        field {
            name = "vi_input_sel4";
            desc = "VI input select bit written by SYS_HAL_ViDevInputiSel. PROVEN bit, meaning UNKNOWN.";
            sw = rw;
            hw = r;
        } vi_input_sel4[4:4];
        field {
            name = "vi_input_sel5";
            desc = "VI input select bit written by SYS_HAL_ViDevInputiSel. PROVEN bit, meaning UNKNOWN.";
            sw = rw;
            hw = r;
        } vi_input_sel5[5:5];
        field {
            name = "vicap_viproc_online_mode";
            desc = "1 = VICAP feeds VIPROC online. PROVEN (see also PERI_CRG63[3]).";
            sw = rw;
            hw = r;
        } vicap_viproc_online_mode[6:6];
        field {
            name = "viproc_vpss_online_mode";
            desc = "1 = VIPROC feeds VPSS online. PROVEN (see also PERI_CRG42[2]).";
            sw = rw;
            hw = r;
        } viproc_vpss_online_mode[7:7];
    } MISC_CTRL6 @ 0x18;

    reg {
        name = "USB 2.0 control 0";
        desc = "Named MISC_CTRL7 and REG_USB2_CTRL0 by the vendor U-Boot (platform.h); the AV300 sheet has usb2 host control fields here. Evidence: PROVEN offset and name, UNKNOWN fields on the EV300.";
        field {
            name = "usb2_ctrl0";
            desc = "Raw register. PROVEN offset.";
            sw = rw;
            hw = r;
        } usb2_ctrl0[31:0];
    } MISC_CTRL7 @ 0x1C;

    reg {
        name = "Fast Ethernet PHY control 0";
        desc = "Named REG_FEPHY_CTRL0 by the vendor U-Boot. Evidence: PROVEN offset and name, UNKNOWN fields (the Hi3536DV100 FEPHY control bits sel 5 / RMII 8 / reset 9 / clock 10 are NOT confirmed for the EV300).";
        field {
            name = "fephy_ctrl0";
            desc = "Raw register. PROVEN offset.";
            sw = rw;
            hw = r;
        } fephy_ctrl0[31:0];
    } MISC_CTRL8 @ 0x20;

    reg {
        name = "Fast Ethernet PHY control 1 (PHY address)";
        desc = "RESOLVED (2026-11-11, source analysis): the register is in MISC at 0x12028024, not in SYS_CTRL. Evidence: both vendor DTs (Xiongmai and OpenIPC) pass 0x12028024 as the second reg of the hisi-femac-mdio node; the vendor/OpenIPC mdio driver (mdio-hisi-femac.c) reads and writes it as fephy_iobase (PHY address in [4:0], bit 5 FEPHY_SEL read as 'internal PHY in use' when 0); platform.h defines MISC_REG_BASE 0x12028000 + MISC_CTRL9 0x24 = REG_FEPHY_CTRL1 (the same macro idiom as the Hi3536DV100 branch of sys.c). The vendor U-Boot hisfv300 sys.c adds MISC_CTRL9 to SYS_CTRL_REG_BASE for the EV200/EV300/Hi3518EV300/Hi3516DV200 (0x12020024): treat as a U-Boot macro slip (in the same file the 3536 branch uses MISC_REG_BASE). The U-Boot bits ETH_INTERNAL_PHY_CLK_EN bit 2 / ETH_INTERNAL_PHY_RESET bit 3 overlap the PHY address field [4:0]; Linux drives clock and reset through the CRG (PERI_CRG91 bit 1 / bit 3, DT resets <crg 0x16c 3>), so the U-Boot bits are not used for the EV300 (INFERRED). Board confirmation still welcome.";
        field {
            name = "phy_addr";
            desc = "MDIO address given to the internal FE PHY (DT: PHY at address 1). PROVEN (mdio-hisi-femac.c BIT_MASK_FEPHY_ADDR).";
            sw = rw;
            hw = r;
        } phy_addr[4:0];
        field {
            name = "fephy_sel";
            desc = "0 = internal FE PHY in use (driver reads it that way). PROVEN position, polarity INFERRED from the driver.";
            sw = rw;
            hw = r;
        } fephy_sel[5:5];
    } MISC_CTRL9 @ 0x24;

    reg {
        name = "MISC control 17";
        desc = "Named MISC_CTRL17 by the vendor U-Boot platform.h. Evidence: PROVEN offset, UNKNOWN use.";
        field {
            name = "misc17";
            desc = "Raw register. PROVEN offset.";
            sw = rw;
            hw = r;
        } misc17[31:0];
    } MISC_CTRL17 @ 0x44;

    reg {
        name = "MISC control 18";
        desc = "Named MISC_CTRL18 by the vendor U-Boot platform.h (EMMC_ISO_EN bit 16 and RG_EMMC_LHEN_IN [22:17] macros nearby, use inferred from names). Evidence: PROVEN offset, INFERRED use.";
        field {
            name = "misc18";
            desc = "Raw register. PROVEN offset.";
            sw = rw;
            hw = r;
        } misc18[31:0];
    } MISC_CTRL18 @ 0x48;

    reg {
        name = "Bus priority / QoS 22";
        desc = "Written 1 by Goke sys_config.c set_vi_vpss_mode in the offline and online/online modes. AV300 MISC_CTRL22 is a bus-priority register. Evidence: PROVEN write, INFERRED role.";
        field {
            name = "qos22";
            desc = "Raw register.";
            sw = rw;
            hw = r;
        } qos22[31:0];
    } MISC_CTRL22 @ 0x58;

    reg {
        name = "Bus priority 28";
        desc = "Goke sys_config.c writes 0x123 in every VI/VPSS mode. AV300 MISC_CTRL28 = vivo port priorities. Evidence: PROVEN write, INFERRED role.";
        field {
            name = "pri28";
            desc = "Raw register.";
            sw = rw;
            hw = r;
        } pri28[31:0];
    } MISC_CTRL28 @ 0x70;

    reg {
        name = "QoS 31";
        desc = "Goke sys_config.c writes 0x123 in every VI/VPSS mode. AV300 MISC_CTRL31 = MDDRC write QoS. Evidence: PROVEN write, INFERRED role.";
        field {
            name = "qos31";
            desc = "Raw register.";
            sw = rw;
            hw = r;
        } qos31[31:0];
    } MISC_CTRL31 @ 0x7C;

    reg {
        name = "QoS / priority 32";
        desc = "Written by Goke sys_config.c set_vi_vpss_mode with 0x00060005. AV300 MISC_CTRL32 is a MDDRC read/write QoS or bus-priority register. Evidence: PROVEN write, INFERRED role; the EV300 value meanings are UNKNOWN.";
        field {
            name = "qos32";
            desc = "Raw register.";
            sw = rw;
            hw = r;
        } qos32[31:0];
    } MISC_CTRL32 @ 0x80;

    reg {
        name = "QoS / priority 33";
        desc = "Written by Goke sys_config.c set_vi_vpss_mode with 0x54755676 / 0x44654766 / 0x54655766 (mode dependent). AV300 MISC_CTRL33 is a MDDRC read/write QoS or bus-priority register. Evidence: PROVEN write, INFERRED role; the EV300 value meanings are UNKNOWN.";
        field {
            name = "qos33";
            desc = "Raw register.";
            sw = rw;
            hw = r;
        } qos33[31:0];
    } MISC_CTRL33 @ 0x84;

    reg {
        name = "QoS / priority 34";
        desc = "Written by Goke sys_config.c set_vi_vpss_mode with 0x00000006. AV300 MISC_CTRL34 is a MDDRC read/write QoS or bus-priority register. Evidence: PROVEN write, INFERRED role; the EV300 value meanings are UNKNOWN.";
        field {
            name = "qos34";
            desc = "Raw register.";
            sw = rw;
            hw = r;
        } qos34[31:0];
    } MISC_CTRL34 @ 0x88;

    reg {
        name = "QoS / priority 36";
        desc = "Written by Goke sys_config.c set_vi_vpss_mode with 0x00070005. AV300 MISC_CTRL36 is a MDDRC read/write QoS or bus-priority register. Evidence: PROVEN write, INFERRED role; the EV300 value meanings are UNKNOWN.";
        field {
            name = "qos36";
            desc = "Raw register.";
            sw = rw;
            hw = r;
        } qos36[31:0];
    } MISC_CTRL36 @ 0x90;

    reg {
        name = "QoS / priority 37";
        desc = "Written by Goke sys_config.c set_vi_vpss_mode with 0x54665677 / 0x54755777 (mode dependent). AV300 MISC_CTRL37 is a MDDRC read/write QoS or bus-priority register. Evidence: PROVEN write, INFERRED role; the EV300 value meanings are UNKNOWN.";
        field {
            name = "qos37";
            desc = "Raw register.";
            sw = rw;
            hw = r;
        } qos37[31:0];
    } MISC_CTRL37 @ 0x94;

    reg {
        name = "QoS / priority 38";
        desc = "Written by Goke sys_config.c set_vi_vpss_mode with 0x00000006. AV300 MISC_CTRL38 is a MDDRC read/write QoS or bus-priority register. Evidence: PROVEN write, INFERRED role; the EV300 value meanings are UNKNOWN.";
        field {
            name = "qos38";
            desc = "Raw register.";
            sw = rw;
            hw = r;
        } qos38[31:0];
    } MISC_CTRL38 @ 0x98;

    reg {
        name = "SVB PWM (core voltage)";
        desc = "Written word format PROVEN twice: vendor U-Boot start_svb writes ((duty << 16) | 0x0C75) with duty = ((1099 - volt) * 460 >> 10) - 1, and the SDK power module hi3516ev200_pm.ko (volt_timer_handler, the 0x3516E300 / 0x3516D200 branch, static disassembly) stores ((V >> 10) << 16) - 0xF38B, i.e. ((duty - 1) << 16) | 0x0C75 (0x10000 - 0xF38B = 0x0C75): the low half is a constant 0x0C75, the upper 16 bits carry the duty. For the other chips pm.ko instead programs PWM channel n of 0x12080000 (n = SYS_CTRL 0x9C [3:0]; CFG1 duty, CTRL = 5). The boot table writes 0x00580C75 (duty 0x58) and waits one second. Field boundaries inside the constant are INFERRED from the AV300 sheet (period [13:4] = 0xC7, [2] and [0] set); the 0x0C75 constant itself is the only thing the code shows.";
        field {
            name = "const_0c75";
            desc = "Constant 0x0C75 written by U-Boot and pm.ko (AV300 sheet analog: [0] enable, [13:4] period). PROVEN value, field split INFERRED.";
            sw = rw;
            hw = r;
        } const_0c75[15:0];
        field {
            name = "svb_pwm_duty";
            desc = "PWM duty minus 1 (16-bit in the written word). PROVEN (U-Boot, pm.ko).";
            sw = rw;
            hw = r;
        } svb_pwm_duty[31:16];
    } MISC_CTRL44 @ 0xB0;

    reg {
        name = "Temperature sensor status 0";
        desc = "Read by the vendor U-Boot (TSENSOR_STATUS0) and by pm.ko (temp_ctrl_init maps 0x120280B4 size 0x18; volt_timer_handler reads +8 = this register, ubfx [9:0]). pm.ko clamps the code to 117..915 and computes T = (code - 117) x 0.20625 - 40 degrees C ((165 x code - 19305) / 2 x 0xA4402911 >> 32 >> 8, minus 40). Evidence: PROVEN (static disassembly, formula only decoded, not run).";
        field {
            name = "tsensor_code";
            desc = "10-bit temperature code. PROVEN (pm.ko ubfx #0,#10; U-Boot).";
            sw = r;
            hw = w;
        } tsensor_code[9:0];
    } MISC_CTRL47 @ 0xBC;

    reg {
        name = "HPM core status 0";
        desc = "Vendor U-Boot get_hpm_value: core0 = [9:0], core1 = [25:16] (averaged over 4 reads). Evidence: PROVEN (source).";
        field {
            name = "hpm_core0";
            desc = "HPM core 0 value. PROVEN.";
            sw = r;
            hw = w;
        } hpm_core0[9:0];
        field {
            name = "hpm_core1";
            desc = "HPM core 1 value. PROVEN.";
            sw = r;
            hw = w;
        } hpm_core1[25:16];
    } MISC_CTRL54 @ 0xD8;

    reg {
        name = "HPM core status 1";
        desc = "Vendor U-Boot get_hpm_value: core2 = [9:0], core3 = [25:16]. Evidence: PROVEN (source).";
        field {
            name = "hpm_core2";
            desc = "HPM core 2 value. PROVEN.";
            sw = r;
            hw = w;
        } hpm_core2[9:0];
        field {
            name = "hpm_core3";
            desc = "HPM core 3 value. PROVEN.";
            sw = r;
            hw = w;
        } hpm_core3[25:16];
    } MISC_CTRL55 @ 0xDC;

};

`endif
