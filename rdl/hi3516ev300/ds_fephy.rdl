`ifndef HI3516EV300_FEPHY_RDL
`define HI3516EV300_FEPHY_RDL
regfile eHI3516EV300_FEPHY {
    name = "Fast Ethernet PHY (FEPHY_BASE) MII management registers";
    desc = "Fast Ethernet PHY (FEPHY_BASE) MII management registers of the Hi3516E V300 at base 0x00 (MDIO register number x 2). 14 registers extracted programmatically from the Hi3516E V300 data sheet (Issue 00B06, 2019-05-15) (Table 5-8 Summary of the FEPHY_BASE registers Offset Register Description Page Address): register headings, offsets, total reset values, field bit ranges, access types, names, reset values and descriptions, with PDF page numbers in each register description. Field names, bit ranges, access types and offsets are exact; the free-text descriptions are taken from the cell text of the field table and were checked by sampling only. Hardware not verified. These registers are NOT memory mapped: they are IEEE 802.3 clause 22 MII registers reached through the MDIO interface of the FEMAC (MDIO registers at 0x10041100); the RDL address is twice the MII register number (the convention of common/HISI_FEPHY.rdl) and the instance base in the SoC map (0x10048000) is a placeholder. The layout of BMCR, BMSR, OUI_1/OUI_2, ANAR, ANLPAR, ANER, MACR and MAADR matches common/HISI_FEPHY.rdl (the PHY of the Hi3520D family) but this PHY adds LINK_AN_SR, AUX_CTL, EXPMD, EXPMA and PHY_ADDRESS and has no PSMR, LPM, INTR or PGSEL, so it is modelled separately.";
    reg {
        name = "BMCR";
        desc = "BMCR is a basic mode control register. (offset 0x0; total reset 0x00003100; PROVEN: Hi3516E V300 data sheet (Issue 00B06, 2019-05-15), section 5.2.6, PDF page 371).";
        regwidth = 16;
        field {
            name = "mr_reset";
            desc = "Reset
- 1: initialization soft reset/reset during working
- 0: normal working mode

This bit resets the PHY status and control register to the default status. This bit is automatically cleared. When reset is not finished, the returned value remains 1 (with the duration of about 1.2 ms). Once auto-negotiation starts or the device enters the forcible mode, reset finishes.

Access type RWSC in the data sheet (self-clearing).";
            sw = rw; hw = rw;
            reset = 0x0;
        } mr_reset[15:15];
        field {
            name = "mr_loopback";
            desc = "Loopback enable";
            sw = rw; hw = r;
            reset = 0x0;
        } mr_loopback[14:14];
        field {
            name = "mr_speed_0";
            desc = "Speed selection When auto-negotiation is disabled, mr_speed_0 forcibly sets the device speed as follows: mr_speed_0 [1:0]
- 11: reserved
- 10: reserved
- 01: 100 Mbit/s
- 00: 10 Mbit/s

When auto-negotiation is enabled, this bit does not function. mr_speed_0[1:0] consists of HA_CONTROL[6] and LA_CONTROL[5].";
            sw = rw; hw = r;
            reset = 0x1;
        } mr_speed_0[13:13];
        field {
            name = "mr_an_enable";
            desc = "Auto-negotiation enable
- 1: enabled
- 0: disabled";
            sw = rw; hw = r;
            reset = 0x1;
        } mr_an_enable[12:12];
        field {
            name = "mr_power_down";
            desc = "Low power mode enable
- 1: low power mode (Only the MDIO interface functions normally.)
- 0: normal working mode";
            sw = rw; hw = r;
            reset = 0x0;
        } mr_power_down[11:11];
        field {
            name = "mr_isolate";
            desc = "Isolation enable
- 1: isolation enabled. The GPHY core does not respond to the MAC data transmission. The isolation mode sets the PHY to the low power mode and all media operations are interrupted.
- 0: normal working mode";
            sw = rw; hw = r;
            reset = 0x0;
        } mr_isolate[10:10];
        field {
            name = "mr_restart_an";
            desc = "Restart auto-negotiation enable
- 1: Restart and initialize auto-negotiation. If auto-negotiation is disabled, this bit does not function. After auto-negotiation is started, this bit is automatically cleared. The returned value remains 1 during the initialization.

Clearing this bit does not affect auto-negotiation.
- 0: normal working mode

Access type RWSC in the data sheet (self-clearing).";
            sw = rw; hw = rw;
            reset = 0x0;
        } mr_restart_an[9:9];
        field {
            name = "mr_duplex";
            desc = "Duplex mode
- 1: full duplex
- 0: half duplex

When auto-negotiation is enabled, this bit is invalid.";
            sw = rw; hw = r;
            reset = 0x1;
        } mr_duplex[8:8];
        field {
            name = "mr_col_test";
            desc = "Conflict test
- 1: conflict test enabled
- 0: normal working mode";
            sw = rw; hw = r;
            reset = 0x0;
        } mr_col_test[7:7];
        field {
            name = "mr_speed_1";
            desc = "Speed selection When auto-negotiation is disabled, mr_speed_1 forcibly sets the device speed as follows: mr_speed_1[1:0]
- 11: reserved
- 10: reserved
- 01: 100 Mbit/s
- 00: 10 Mbit/s

When auto-negotiation is enabled, this bit does not function. mr_speed_1[1:0] consists of HA_CONTROL[6] and LA_CONTROL[5].";
            sw = rw; hw = r;
            reset = 0x0;
        } mr_speed_1[6:6];
        field {
            name = "ieee_reserved";
            desc = "Reserved. Writing this field has no effect and reading this field returns 0. For all reserved bits, writing has no effect and the read value is 0.";
            sw = rw; hw = r;
            reset = 0x0;
        } ieee_reserved[5:0];
    } BMCR @ 0x0;
    reg {
        name = "BMSR";
        desc = "BMSR is an IEEE basic MII status register. (offset 0x2; total reset 0x00007849; PROVEN: Hi3516E V300 data sheet (Issue 00B06, 2019-05-15), section 5.2.6, PDF page 373).";
        regwidth = 16;
        field {
            name = "base_t4_100";
            desc = "Whether the 100BASE-T4 mode is supported
- 1: supported
- 0: not supported

When this bit is set to 1, the chip supports the 100BASE-T4 mode. When this bit is set to 0, the chip does not support this mode.";
            sw = r; hw = w;
            reset = 0x0;
        } base_t4_100[15:15];
        field {
            name = "base_xfd_100";
            desc = "Whether the full-duplex 100BASE-TX mode";
            sw = r; hw = w;
            reset = 0x1;
        } base_xfd_100[14:14];
        field {
            name = "base_xhd_100";
            desc = "Whether the half-duplex 100BASE-TX mode is supported
- 1: supported
- 0: not supported";
            sw = r; hw = w;
            reset = 0x1;
        } base_xhd_100[13:13];
        field {
            name = "base_fd_10";
            desc = "Whether the full-duplex 10BASE-T mode is supported
- 1: supported
- 0: not supported";
            sw = r; hw = w;
            reset = 0x1;
        } base_fd_10[12:12];
        field {
            name = "base_hd_10";
            desc = "Whether the half-duplex 10BASE-T mode is supported
- 1: supported
- 0: not supported";
            sw = r; hw = w;
            reset = 0x1;
        } base_hd_10[11:11];
        field {
            name = "base_t2fd_100";
            desc = "Whether the full-duplex 10BASE-T2 mode is supported
- 1: supported
- 0: not supported";
            sw = r; hw = w;
            reset = 0x0;
        } base_t2fd_100[10:10];
        field {
            name = "base_t2hd_100";
            desc = "Whether the half-duplex 10BASE-T2 mode is supported
- 1: supported
- 0: not supported";
            sw = r; hw = w;
            reset = 0x0;
        } base_t2hd_100[9:9];
        field {
            name = "extended_status";
            desc = "Whether the 1000BASE-T expand status register is supported
- 1: supported
- 0: not supported";
            sw = r; hw = w;
            reset = 0x0;
        } extended_status[8:8];
        field {
            name = "reserved";
            desc = "Reserved";
            sw = r; hw = w;
            reset = 0x0;
        } reserved_7_7[7:7];
        field {
            name = "mr_preamble_suppress";
            desc = "Preamble limitation enable
- 1: After the PHY is reset, only one 32-bit preamble is required for normal transmission.";
            sw = r; hw = w;
            reset = 0x1;
        } mr_preamble_suppress[6:6];
        field {
            name = "mr_an_complete";
            desc = "Auto-negotiation completion flag
- 1: complete
- 0: not complete";
            sw = r; hw = w;
            reset = 0x0;
        } mr_an_complete[5:5];
        field {
            name = "mr_rem_fault";
            desc = "Remote-end error detection indicator
- 1: remote-end error detected
- 0: no remote-end error detected

Reading or resetting clears this bit.";
            sw = r; hw = w;
            reset = 0x0;
        } mr_rem_fault[4:4];
        field {
            name = "mr_an_capable";
            desc = "Auto-negotiation enabling allowed or not
- 1: allowed
- 0: not allowed";
            sw = r; hw = w;
            reset = 0x1;
        } mr_an_capable[3:3];
        field {
            name = "mr_link_up";
            desc = "Connection status indicator
- 1: normal connection since the register is read last time
- 0: connection error since the register is read last time

This bit is cleared in the case of disconnection. If the connection is normal when the register is read, this bit is set to 1.";
            sw = r; hw = w;
            reset = 0x0;
        } mr_link_up[2:2];
        field {
            name = "mr_jabber";
            desc = "Jabber detection
- 1: jabber conflict detected
- 0: jabber conflict not detected

When jabber is detected in the 10BASE-T mode, this bit is set to 1.";
            sw = r; hw = w;
            reset = 0x0;
        } mr_jabber[1:1];
        field {
            name = "mr_extended_status";
            desc = "1000BASE-T expand status register enable
- 1: enabled
- 0: disabled";
            sw = r; hw = w;
            reset = 0x1;
        } mr_extended_status[0:0];
    } BMSR @ 0x2;
    reg {
        name = "OUI_1";
        desc = "OUI_1 is an IEEE PHY identifier 1 register. (offset 0x4; total reset 0x00002066; PROVEN: Hi3516E V300 data sheet (Issue 00B06, 2019-05-15), section 5.2.6, PDF page 375).";
        regwidth = 16;
        field {
            name = "oui_msb";
            desc = "Upper 16 bits of the unique official identifier";
            sw = r; hw = w;
            reset = 0x2066;
        } oui_msb[15:0];
    } OUI_1 @ 0x4;
    reg {
        name = "OUI_2";
        desc = "OUI_2 is an IEEE PHY identifier 2 register. (offset 0x6; total reset 0x00009903; PROVEN: Hi3516E V300 data sheet (Issue 00B06, 2019-05-15), section 5.2.6, PDF page 375).";
        regwidth = 16;
        field {
            name = "oui_lsb";
            desc = "Lower 16 bits of the unique official identifier";
            sw = r; hw = w;
            reset = 0x26;
        } oui_lsb[15:10];
        field {
            name = "mmn";
            desc = "Manufacturer model";
            sw = r; hw = w;
            reset = 0x10;
        } mmn[9:4];
        field {
            name = "revision";
            desc = "Version number";
            sw = r; hw = w;
            reset = 0x3;
        } revision[3:0];
    } OUI_2 @ 0x6;
    reg {
        name = "ANAR";
        desc = "ANAR is an IEEE auto-negotiation TX register. (offset 0x8; total reset 0x000001E1; PROVEN: Hi3516E V300 data sheet (Issue 00B06, 2019-05-15), section 5.2.6, PDF page 376).";
        regwidth = 16;
        field {
            name = "mr_an_adv_np";
            desc = "Next-page transmission indicator
- 0: next-page transmission not supported
- 1: next-page transmission supported";
            sw = rw; hw = r;
            reset = 0x0;
        } mr_an_adv_np[15:15];
        field {
            name = "reserved";
            desc = "Reserved";
            sw = r; hw = w;
            reset = 0x0;
        } reserved_14_14[14:14];
        field {
            name = "mr_an_adv_rf";
            desc = "Remote-end error flag
- 0: remote error not detected
- 1: remote error detected";
            sw = rw; hw = r;
            reset = 0x0;
        } mr_an_adv_rf[13:13];
        field {
            name = "reserved";
            desc = "Reserved";
            sw = r; hw = w;
            reset = 0x0;
        } reserved_12_11[12:11];
        field {
            name = "mr_pause";
            desc = "Stop control
- 0: MAC/controller frame transmission interrupt supported
- 1: not supported";
            sw = rw; hw = r;
            reset = 0x0;
        } mr_pause[10:10];
        field {
            name = "mr_t4_ability";
            desc = "Whether the 100BASE-T4 mode is supported
- 0: not supported
- 1: supported";
            sw = rw; hw = r;
            reset = 0x0;
        } mr_t4_ability[9:9];
        field {
            name = "mr_tech_ability_100_fd";
            desc = "Whether the full-duplex 100BASE-TX mode is supported
- 0: not supported
- 1: supported";
            sw = rw; hw = r;
            reset = 0x1;
        } mr_tech_ability_100_fd[8:8];
        field {
            name = "mr_tech_ability_100_hd";
            desc = "Whether the half-duplex 100BASE-TX mode is supported
- 0: not supported
- 1: supported";
            sw = rw; hw = r;
            reset = 0x1;
        } mr_tech_ability_100_hd[7:7];
        field {
            name = "mr_tech_ability_10_fd";
            desc = "Whether the full-duplex 10BASE-T mode is supported
- 0: not supported
- 1: supported";
            sw = rw; hw = r;
            reset = 0x1;
        } mr_tech_ability_10_fd[6:6];
        field {
            name = "mr_tech_ability_10_hd";
            desc = "Whether the half-duplex 10BASE-T mode is supported
- 0: not supported
- 1: supported";
            sw = rw; hw = r;
            reset = 0x1;
        } mr_tech_ability_10_hd[5:5];
        field {
            name = "mr_selector_filed";
            desc = "Protocol selection field defined by IEEE 802.3. The value 0x01 indicates that the chip";
            sw = rw; hw = r;
            reset = 0x1;
        } mr_selector_filed[4:0];
    } ANAR @ 0x8;
    reg {
        name = "ANLPAR";
        desc = "ANLPAR is an IEEE auto-negotiation RX register. (offset 0xA; total reset 0x00000000; PROVEN: Hi3516E V300 data sheet (Issue 00B06, 2019-05-15), section 5.2.6, PDF page 377).";
        regwidth = 16;
        field {
            name = "next_page";
            desc = "Next-page transmission indicator
- 0: The link partner does not support next-page transmission.
- 1: The link partner supports next-page transmission.";
            sw = r; hw = w;
            reset = 0x0;
        } next_page[15:15];
        field {
            name = "acknowledge";
            desc = "Remote-end RX response flag
- 0: The link partner does not respond to RX.
- 1: The link partner responds to RX.";
            sw = r; hw = w;
            reset = 0x0;
        } acknowledge[14:14];
        field {
            name = "remote_fault";
            desc = "Link partner remote-end error flag
- 0: remote error not detected
- 1: remote error detected";
            sw = r; hw = w;
            reset = 0x0;
        } remote_fault[13:13];
        field {
            name = "reserved";
            desc = "Reserved";
            sw = r; hw = w;
            reset = 0x0;
        } reserved_12_12[12:12];
        field {
            name = "asymetricalpause";
            desc = "Whether the link partner supports asymmetrical pause
- 0: not supported
- 1: supported";
            sw = r; hw = w;
            reset = 0x0;
        } asymetricalpause[11:11];
        field {
            name = "pause";
            desc = "Whether the link partner supports frame pause
- 0: not supported
- 1: supported";
            sw = r; hw = w;
            reset = 0x0;
        } pause[10:10];
        field {
            name = "lp_base_t4_100";
            desc = "Whether the link partner supports 100BASE-T4
- 0: not supported
- 1: supported";
            sw = r; hw = w;
            reset = 0x0;
        } lp_base_t4_100[9:9];
        field {
            name = "base_tx_fd_100";
            desc = "Whether the link partner supports full-duplex 100BASE-TX
- 0: not supported
- 1: supported";
            sw = r; hw = w;
            reset = 0x0;
        } base_tx_fd_100[8:8];
        field {
            name = "base_tx_100";
            desc = "Whether the link partner supports half-duplex 100BASE-TX
- 0: not supported";
            sw = r; hw = w;
            reset = 0x0;
        } base_tx_100[7:7];
        field {
            name = "base_tx_fd_10";
            desc = "Whether the link partner supports full-duplex 10BASE-TX
- 0: not supported
- 1: supported";
            sw = r; hw = w;
            reset = 0x0;
        } base_tx_fd_10[6:6];
        field {
            name = "base_tx_10";
            desc = "Whether the link partner supports half-duplex 10BASE-TX
- 0: not supported
- 1: supported";
            sw = r; hw = w;
            reset = 0x0;
        } base_tx_10[5:5];
        field {
            name = "lp_selector_filed";
            desc = "Link partner selection field defined by IEEE 802.3. The value 0x01 indicates that the chip supports IEEE 802.3.";
            sw = r; hw = w;
            reset = 0x0;
        } lp_selector_filed[4:0];
    } ANLPAR @ 0xA;
    reg {
        name = "ANER";
        desc = "ANER is an IEEE auto-negotiation expand register. (offset 0xC; total reset 0x00000004; PROVEN: Hi3516E V300 data sheet (Issue 00B06, 2019-05-15), section 5.2.6, PDF page 378).";
        regwidth = 16;
        field {
            name = "reserved";
            desc = "Reserved";
            sw = r; hw = w;
            reset = 0x0;
        } reserved_15_5[15:5];
        field {
            name = "mr_exp_pdf";
            desc = "Parallel error detection
- 0: no error detected
- 1: error detected";
            sw = r; hw = w;
            reset = 0x0;
        } mr_exp_pdf[4:4];
        field {
            name = "mr_exp_lp_np_able";
            desc = "Whether the link partner supports next-page negotiation
- 0: not supported
- 1: supported";
            sw = r; hw = w;
            reset = 0x0;
        } mr_exp_lp_np_able[3:3];
        field {
            name = "mr_exp_np_able";
            desc = "Whether next-page negotiation is supported
- 0: not supported
- 1: supported";
            sw = r; hw = w;
            reset = 0x1;
        } mr_exp_np_able[2:2];
        field {
            name = "mr_exp_page_rx";
            desc = "Whether connection codeword is received
- 0: not received
- 1: received";
            sw = r; hw = w;
            reset = 0x0;
        } mr_exp_page_rx[1:1];
        field {
            name = "mr_exp_la_an_enable";
            desc = "Whether the link partner supports auto-negotiation
- 0: not supported
- 1: supported";
            sw = r; hw = w;
            reset = 0x0;
        } mr_exp_la_an_enable[0:0];
    } ANER @ 0xC;
    reg {
        name = "MACR";
        desc = "MACR is an expand control register. (offset 0x1A; total reset 0x00000000; PROVEN: Hi3516E V300 data sheet (Issue 00B06, 2019-05-15), section 5.2.6, PDF page 379).";
        regwidth = 16;
        field {
            name = "function";
            desc = "Expand register function field
- 00: MAADR register address operation
- 01: MAADR register data operation

Other values: reserved";
            sw = rw; hw = r;
            reset = 0x0;
        } function[15:14];
        field {
            name = "reserved";
            desc = "Reserved";
            sw = r; hw = w;
            reset = 0x0;
        } reserved_13_5[13:5];
        field {
            name = "devad";
            desc = "Device address";
            sw = rw; hw = r;
            reset = 0x0;
        } devad[4:0];
    } MACR @ 0x1A;
    reg {
        name = "MAADR";
        desc = "MAADR is an expand address data register. (offset 0x1C; total reset 0x00000000; PROVEN: Hi3516E V300 data sheet (Issue 00B06, 2019-05-15), section 5.2.6, PDF page 379).";
        regwidth = 16;
        field {
            name = "address_data";
            desc = "Device address or data register";
            sw = rw; hw = r;
            reset = 0x0;
        } address_data[15:0];
    } MAADR @ 0x1C;
    reg {
        name = "LINK_AN_SR";
        desc = "LINK_AN_SR is a connection and auto-negotiation status register. (offset 0x22; total reset 0x00000000; PROVEN: Hi3516E V300 data sheet (Issue 00B06, 2019-05-15), section 5.2.6, PDF page 379).";
        regwidth = 16;
        field {
            name = "tp_polarity_3_0";
            desc = "Bits 7-4 indicate the polarity of cable pairs A to D, respectively.
- 1: inverted
- 0: normal";
            sw = r; hw = w;
            reset = 0x0;
        } tp_polarity_3_0[15:12];
        field {
            name = "power_down_status";
            desc = "Current power-on or power-off status of the port
- 1: power-off status
- 0: non-power-off status";
            sw = r; hw = w;
            reset = 0x0;
        } power_down_status[11:11];
        field {
            name = "mdix_status";
            desc = "Internal cross over status
- 1: internal cross over activated
- 0: no internal cross over";
            sw = r; hw = w;
            reset = 0x0;
        } mdix_status[10:10];
        field {
            name = "fifo_error";
            desc = "Whether overflow or underrun occurs in the";
            sw = r; hw = w;
            reset = 0x0;
        } fifo_error[9:9];
        field {
            name = "power_on_init_in_progress";
            desc = "Power-on process completion flag
- 0: complete
- 1: not complete";
            sw = r; hw = w;
            reset = 0x0;
        } power_on_init_in_progress[8:8];
        field {
            name = "shallow_loopback_status";
            desc = "Shallow loopback enable status
- 1: enabled
- 0: disabled";
            sw = r; hw = w;
            reset = 0x0;
        } shallow_loopback_status[7:7];
        field {
            name = "deep_loopback_status";
            desc = "Deep loopback enable status
- 1: enabled
- 0: disabled";
            sw = r; hw = w;
            reset = 0x0;
        } deep_loopback_status[6:6];
        field {
            name = "non_compliant_mode_status";
            desc = "Current compliant mode
- 1: 1000-BASE non-compliant mode
- 0: IEEE-compliant mode";
            sw = r; hw = w;
            reset = 0x0;
        } non_compliant_mode_status[5:5];
        field {
            name = "speed_status";
            desc = "Real-time speed display Speed[1:0]
- 11: reserved
- 10: reserved
- 01: 100 Mbit/s
- 00: 10 Mbit/s";
            sw = r; hw = w;
            reset = 0x0;
        } speed_status[4:3];
        field {
            name = "link_status";
            desc = "Real-time connection display
- 1: connected
- 0: disconnected";
            sw = r; hw = w;
            reset = 0x0;
        } link_status[2:2];
        field {
            name = "duplex_status";
            desc = "Real-time duplex status
- 1: full duplex
- 0: half duplex";
            sw = r; hw = w;
            reset = 0x0;
        } duplex_status[1:1];
        field {
            name = "config_status";
            desc = "Master-slave status
- 1: master status
- 0: slave status";
            sw = r; hw = w;
            reset = 0x0;
        } config_status[0:0];
    } LINK_AN_SR @ 0x22;
    reg {
        name = "AUX_CTL";
        desc = "AUX_CTL is an auxiliary control register. (offset 0x24; total reset 0x00009000; PROVEN: Hi3516E V300 data sheet (Issue 00B06, 2019-05-15), section 5.2.6, PDF page 380).";
        regwidth = 16;
        field {
            name = "auto_mdix_enable";
            desc = "MDIX mode selection
- 1: automatic MDIX mode
- 0: manual MDIX mode";
            sw = rw; hw = r;
            reset = 0x1;
        } auto_mdix_enable[15:15];
        field {
            name = "mdix_manual";
            desc = "Straight-through or crossover cable
- 1: crossover cable
- 0: straight-through cable";
            sw = rw; hw = r;
            reset = 0x0;
        } mdix_manual[14:14];
        field {
            name = "reserved";
            desc = "Reserved";
            sw = r; hw = w;
            reset = 0x0;
        } reserved_13_13[13:13];
        field {
            name = "loopback_10b_disable";
            desc = "10BASE half-duplex mode loopback enable
- 1: disabled
- 0: enabled";
            sw = rw; hw = r;
            reset = 0x1;
        } loopback_10b_disable[12:12];
        field {
            name = "force100";
            desc = "Forcible 100BASE-TX connection mode
- 1: forcible 100BASE-TX connection mode
- 0: normal mode";
            sw = rw; hw = r;
            reset = 0x0;
        } force100[11:11];
        field {
            name = "force10";
            desc = "Forcible 10BASE-T or 10BASE-Te connection mode
- 1: forcible 10BASE-T or 10BASE-Te connection mode
- 0: normal mode";
            sw = rw; hw = r;
            reset = 0x0;
        } force10[10:10];
        field {
            name = "reserved";
            desc = "Reserved";
            sw = rw; hw = r;
            reset = 0x0;
        } reserved_9_9[9:9];
        field {
            name = "en_ext_loop_detect";
            desc = "External loopback detection enable
- 1: enabled
- 0: disabled";
            sw = rw; hw = r;
            reset = 0x0;
        } en_ext_loop_detect[8:8];
        field {
            name = "reserved";
            desc = "Reserved";
            sw = r; hw = w;
            reset = 0x0;
        } reserved_7_0[7:0];
    } AUX_CTL @ 0x24;
    reg {
        name = "EXPMD";
        desc = "EXPMD is an expand access data register. (offset 0x3A; total reset 0x00000000; PROVEN: Hi3516E V300 data sheet (Issue 00B06, 2019-05-15), section 5.2.6, PDF page 381).";
        regwidth = 16;
        field {
            name = "exp_data_msb";
            desc = "Expand access data register";
            sw = rw; hw = r;
            reset = 0x0;
        } exp_data_msb[15:0];
    } EXPMD @ 0x3A;
    reg {
        name = "EXPMA";
        desc = "EXPMA is an expand access address register. (offset 0x3C; total reset 0x00000000; PROVEN: Hi3516E V300 data sheet (Issue 00B06, 2019-05-15), section 5.2.6, PDF page 381).";
        regwidth = 16;
        field {
            name = "exp_addr_msb";
            desc = "Expand access address register";
            sw = rw; hw = r;
            reset = 0x0;
        } exp_addr_msb[15:0];
    } EXPMA @ 0x3C;
    reg {
        name = "PHY_ADDRESS";
        desc = "PHY_ADDRESS is a broadcast address register. (offset 0x3E; total reset 0x00000000; PROVEN: Hi3516E V300 data sheet (Issue 00B06, 2019-05-15), section 5.2.6, PDF page 382).";
        regwidth = 16;
        field {
            name = "reserved";
            desc = "Reserved";
            sw = r; hw = w;
            reset = 0x0;
        } reserved_15_13[15:13];
        field {
            name = "broadcast_address";
            desc = "Broadcast access address when broadcast is enabled";
            sw = rw; hw = r;
            reset = 0x0;
        } broadcast_address[12:8];
        field {
            name = "reserved";
            desc = "Reserved";
            sw = r; hw = w;
            reset = 0x0;
        } reserved_7_5[7:5];
        field {
            name = "phyaddress";
            desc = "Address of the port accessed by the SM Contents";
            sw = rw; hw = r;
            reset = 0x0;
        } phyaddress[4:0];
    } PHY_ADDRESS @ 0x3E;
};
`endif
