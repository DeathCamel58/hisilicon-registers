`ifndef HI3516EV300_IOCFG_VIO_RDL
`define HI3516EV300_IOCFG_VIO_RDL

regfile eIOCFG_VIO {
    name = "IO configuration bank vio, Hi3516EV300";
    desc = "IO configuration bank 'vio' (video/sensor and general pads) at 0x112C0000, 64 KB, ioremapped by the Goke sys_config.c (gk7205v300 die = Hi3516EV300). Pad index = offset / 4. Pads used by the vendor pinmux tables (value = register word the vendor writes):
0x00..0x24 (pads 0..9) VI data/sync: 0x1000 = GPIO / MIPI mode, 0x1002 / 0x1003 = VI CMOS function;
0x28 / 0x2C: sensor clock/reset: 0x1001 (sensor clock out, MIPI sensor);
0x30 / 0x34: 0x1D00 = GPIO, 0x1D01 = I2C0_SCL / I2C0_SDA (Hi3516EV300 MIPI sensor bus); 0x38 / 0x3C: 0x1C01 = I2C2_SCL / SDA;
0x44: 0x1A00 = GPIO (AIC31 reset / I2C2 helper); 0x48: 0x1A02 = sensor clock for CMOS sensors, 0x1A46 / 0x1A43 = VO BT.1120 / BT.656 pin;
0x4C..0x94: VO BT.1120 / BT.656 / LCD data pins (0x1026, 0x1066, 0x1A26, 0x1033, 0x1023);
0x58 / 0x5C / 0x60 / 0x64: 0x1002 = I2C0 for VI raw sensors, also VO pins; 0x9C / 0xA0 / 0xA4: 0x1034 / 0x1024 / 0x1C01 = SPI0 / I2C1 pads.
Evidence: PROVEN (Goke GPL sys_config.c, writes verified by reading the source, not run on hardware). Function numbers differ per pad; no complete function table exists in the trees.";

    reg {
        name = "Pad configuration word";
        desc = "One 32-bit word per pad. Layout: INFERRED from the vendor values; no data sheet.";
        field {
            name = "func_sel";
            desc = "Pin function select (value meaning per pad, see the register description of the bank). PROVEN that [3:0] is written with the function number by the vendor sys_config.c (e.g. 0x1D01 selects function 1 = I2C0_SCL on vio+0x30); INFERRED as a generic field.";
            sw = rw;
            hw = r;
        } func_sel[3:0];
        field {
            name = "drv_str";
            desc = "Drive strength. INFERRED from the vendor U-Boot eMMC pad code (IO_CFG_DRV_STR_MASK 0xF << 4); consistent with the pad values of the Xiongmai boot register table (0x431 / 0x531 / 0x571 = function 1, drive 3 or 7, bit 10, optional bit 8).";
            sw = rw;
            hw = r;
        } drv_str[7:4];
        field {
            name = "pull_up";
            desc = "Pull-up enable. INFERRED (U-Boot IO_CFG_PULL_UP bit 8).";
            sw = rw;
            hw = r;
        } pull_up[8:8];
        field {
            name = "pull_down";
            desc = "Pull-down enable. INFERRED (U-Boot IO_CFG_PULL_DOWN bit 9).";
            sw = rw;
            hw = r;
        } pull_down[9:9];
        field {
            name = "slew";
            desc = "Slew-rate control. INFERRED (U-Boot IO_CFG_SR bit 10).";
            sw = rw;
            hw = r;
        } slew[10:10];
        field {
            name = "ctrl_hi";
            desc = "Bits 12:11 are set in most vendor values (0x1000, 0x1A00, 0x1C00, 0x1D00 ...); meaning GUESS (input/schmitt enable).";
            sw = rw;
            hw = r;
        } ctrl_hi[12:11];
    } PAD[42] @ 0x0 += 0x4;

};

`endif
`ifndef HI3516EV300_IOCFG_CORE_RDL
`define HI3516EV300_IOCFG_CORE_RDL

regfile eIOCFG_CORE {
    name = "IO configuration bank core, Hi3516EV300";
    desc = "IO configuration bank 'core' at 0x120C0000 (JTAG / UART / LSADC / I2S pads), 64 KB. Vendor values (sys_config.c): +0x00 0x1001 = LSADC_CH0 (0x1000 = GPIO1_0), +0x04 0x1001 = LSADC_CH1, +0x10..0x20 I2S pads (0x0025 MCLK, 0x1E65 BCLK, 0x1D35 WS, 0x1405 SD_RX, 0x1D35 SD_TX; shared with JTAG), +0x14 0x1E02 = GPIO1_5 on the Hi3518EV300 (alt functions: 0 JTAG_TCK, 1 SPI1_SCLK, 2 GPIO1_5, 4 UART2_TXD, 5 I2S_BCLK). Evidence: PROVEN (source reading).";

    reg {
        name = "Pad configuration word";
        desc = "One 32-bit word per pad. Layout: INFERRED from the vendor values; no data sheet.";
        field {
            name = "func_sel";
            desc = "Pin function select (value meaning per pad, see the register description of the bank). PROVEN that [3:0] is written with the function number by the vendor sys_config.c (e.g. 0x1D01 selects function 1 = I2C0_SCL on vio+0x30); INFERRED as a generic field.";
            sw = rw;
            hw = r;
        } func_sel[3:0];
        field {
            name = "drv_str";
            desc = "Drive strength. INFERRED from the vendor U-Boot eMMC pad code (IO_CFG_DRV_STR_MASK 0xF << 4); consistent with the pad values of the Xiongmai boot register table (0x431 / 0x531 / 0x571 = function 1, drive 3 or 7, bit 10, optional bit 8).";
            sw = rw;
            hw = r;
        } drv_str[7:4];
        field {
            name = "pull_up";
            desc = "Pull-up enable. INFERRED (U-Boot IO_CFG_PULL_UP bit 8).";
            sw = rw;
            hw = r;
        } pull_up[8:8];
        field {
            name = "pull_down";
            desc = "Pull-down enable. INFERRED (U-Boot IO_CFG_PULL_DOWN bit 9).";
            sw = rw;
            hw = r;
        } pull_down[9:9];
        field {
            name = "slew";
            desc = "Slew-rate control. INFERRED (U-Boot IO_CFG_SR bit 10).";
            sw = rw;
            hw = r;
        } slew[10:10];
        field {
            name = "ctrl_hi";
            desc = "Bits 12:11 are set in most vendor values (0x1000, 0x1A00, 0x1C00, 0x1D00 ...); meaning GUESS (input/schmitt enable).";
            sw = rw;
            hw = r;
        } ctrl_hi[12:11];
    } PAD[11] @ 0x0 += 0x4;

};

`endif
`ifndef HI3516EV300_IOCFG_AHB_RDL
`define HI3516EV300_IOCFG_AHB_RDL

regfile eIOCFG_AHB {
    name = "IO configuration bank ahb, Hi3516EV300";
    desc = "IO configuration bank 'ahb' (flash, eMMC, SDIO, misc pads) at 0x100C0000, 64 KB. The same window is referenced by the vendor DT as iocfg-controller (syscon) and used by the vendor U-Boot eMMC/SDIO code (hisi_hi3516ev300.c): eMMC pads CLK 0x14, CMD 0x18, DATA0 0x1C, DATA3 0x20, DATA2 0x24, DATA1 0x28, DATA4..7 0x30..0x3C, DS 0x58, RST 0x5C; SDIO0 pads CLK 0x40, CMD 0x44, DATA0..3 0x48..0x54 (PROVEN, source). Values loaded by the Xiongmai U-Boot register table (build image u-boot.bin.img): +0x00 0x531, +0x04 0x431, +0x40 0x441, +0x44..0x54 0x571, +0x58 0x431, +0x5C 0x531, +0xA4 0x601 (plus 0x112C0040 / 0x112C0044 = 0x501 in the vio bank). Other vendor values: +0x08 0x1D02 = IR_IN (0x0 = GPIO0_0, 0x1 = UPDATE_MODE), +0x0C / +0x10 0x1033 = I2C1_SCL / SDA (GPIO0_3 / 0_4), +0x84..0x90 SPI1 pins (0x1011, 0x1431, 0x1001, 0x1011), +0x9C 0x1000 = GPIO9_0, +0xA0 0x1000 = GPIO9_1 (0x1 = PWM3). Evidence: PROVEN (source reading).";

    reg {
        name = "Pad configuration word";
        desc = "One 32-bit word per pad. Layout: INFERRED from the vendor values; no data sheet.";
        field {
            name = "func_sel";
            desc = "Pin function select (value meaning per pad, see the register description of the bank). PROVEN that [3:0] is written with the function number by the vendor sys_config.c (e.g. 0x1D01 selects function 1 = I2C0_SCL on vio+0x30); INFERRED as a generic field.";
            sw = rw;
            hw = r;
        } func_sel[3:0];
        field {
            name = "drv_str";
            desc = "Drive strength. INFERRED from the vendor U-Boot eMMC pad code (IO_CFG_DRV_STR_MASK 0xF << 4); consistent with the pad values of the Xiongmai boot register table (0x431 / 0x531 / 0x571 = function 1, drive 3 or 7, bit 10, optional bit 8).";
            sw = rw;
            hw = r;
        } drv_str[7:4];
        field {
            name = "pull_up";
            desc = "Pull-up enable. INFERRED (U-Boot IO_CFG_PULL_UP bit 8).";
            sw = rw;
            hw = r;
        } pull_up[8:8];
        field {
            name = "pull_down";
            desc = "Pull-down enable. INFERRED (U-Boot IO_CFG_PULL_DOWN bit 9).";
            sw = rw;
            hw = r;
        } pull_down[9:9];
        field {
            name = "slew";
            desc = "Slew-rate control. INFERRED (U-Boot IO_CFG_SR bit 10).";
            sw = rw;
            hw = r;
        } slew[10:10];
        field {
            name = "ctrl_hi";
            desc = "Bits 12:11 are set in most vendor values (0x1000, 0x1A00, 0x1C00, 0x1D00 ...); meaning GUESS (input/schmitt enable).";
            sw = rw;
            hw = r;
        } ctrl_hi[12:11];
    } PAD[41] @ 0x0 += 0x4;

};

`endif
