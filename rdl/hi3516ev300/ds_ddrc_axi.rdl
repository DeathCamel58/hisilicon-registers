`ifndef HI3516EV300_DDRC_AXI_RDL
`define HI3516EV300_DDRC_AXI_RDL
regfile eHI3516EV300_DDRC_AXI {
    name = "DDRC AXI interface";
    desc = "DDRC AXI interface of the Hi3516E V300 at base 0x120D_0000. 17 registers extracted programmatically from the Hi3516E V300 data sheet (Issue 00B06, 2019-05-15) (Table 4-3 Summary of AXI registers (base address: 0x120D_0000)): register headings, offsets, total reset values, field bit ranges, access types, names, reset values and descriptions, with PDF page numbers in each register description. Field names, bit ranges, access types and offsets are exact; the free-text descriptions are taken from the cell text of the field table and were checked by sampling only. Hardware not verified.";
    reg {
        name = "AXI_CFG_LOCK";
        desc = "AXI_CFG_LOCK is the lock control register. (offset 0x4; total reset 0x00000000; PROVEN: Hi3516E V300 data sheet (Issue 00B06, 2019-05-15), section 4.1.5.2, PDF page 216).";
        field {
            name = "reserved";
            desc = "Reserved";
            sw = r; hw = w;
            reset = 0x0;
        } reserved_31_1[31:1];
        field {
            name = "apb_cfg_lock";
            desc = "Lock control of all the register configuration modules (AXI_IF/SEC/DMC/PUB) in the MDDRC
- 0: unlocked
- 1: locked (None of the AXI_IF configuration registers can be accessed except this register.";
            sw = rw; hw = r;
            reset = 0x0;
        } apb_cfg_lock[0:0];
    } AXI_CFG_LOCK @ 0x4;
    reg {
        name = "AXI_CKG";
        desc = "AXI_CKG is the module clock gating register. (offset 0x8; total reset 0x000F1FFF; PROVEN: Hi3516E V300 data sheet (Issue 00B06, 2019-05-15), section 4.1.5.2, PDF page 217).";
        field {
            name = "reserved";
            desc = "Reserved";
            sw = r; hw = w;
            reset = 0x0;
        } reserved_31_20[31:20];
        field {
            name = "sta_ckg_dmc";
            desc = "Static clock gating for each DMC When sta_ckg_dmc[n] is 0, the clocks for the DMCn and the corresponding PHY utility block (PUB) are disabled. When sta_ckg_dmc[n] is 1, the clocks for the DMCn and the corresponding PUB are enabled. Four channels are supported currently and the value range of n is 0 to 3.";
            sw = rw; hw = r;
            reset = 0xf;
        } sta_ckg_dmc[19:16];
        field {
            name = "reserved";
            desc = "Reserved";
            sw = r; hw = w;
            reset = 0x0;
        } reserved_15_13[15:13];
        field {
            name = "dyn_ckg_rdr";
            desc = "Dynamic clock gating for the reorder module
- 0: The clock is always enabled.
- 1: The clock is automatically disabled when the module is idle.";
            sw = rw; hw = r;
            reset = 0x1;
        } dyn_ckg_rdr[12:12];
        field {
            name = "dyn_ckg_axi";
            desc = "Dynamic clock gating for each AXI port When dyn_ckg_axi[n] is 0, the clock for AXI port n is always enabled. When dyn_ckg_axi[n] is 1, the clock is automatically disabled when modules in AXI port n are idle.";
            sw = rw; hw = r;
            reset = 0xfff;
        } dyn_ckg_axi[11:0];
    } AXI_CKG @ 0x8;
    reg {
        name = "AXI_ACTION";
        desc = "AXI_ACTION is the AXI operating mode register. (offset 0x20; total reset 0x00000003; PROVEN: Hi3516E V300 data sheet (Issue 00B06, 2019-05-15), section 4.1.5.2, PDF page 217).";
        field {
            name = "reserved";
            desc = "Reserved";
            sw = r; hw = w;
            reset = 0x0;
        } reserved_31_20[31:20];
        field {
            name = "wr_rcv_mode";
            desc = "Anti-deadlock mode enable When wr_rcv_mode[n] is 0, the anti-deadlock";
            sw = rw; hw = r;
            reset = 0x0;
        } wr_rcv_mode[19:8];
        field {
            name = "reserved";
            desc = "Reserved";
            sw = r; hw = w;
            reset = 0x0;
        } reserved_7_2[7:2];
        field {
            name = "rd_wrap_split_en";
            desc = "Wrap read command split enable
- 0: no split. The address is wrapped by the DMC.
- 1: split";
            sw = rw; hw = r;
            reset = 0x1;
        } rd_wrap_split_en[1:1];
        field {
            name = "exclusive_en";
            desc = "Exclusive command enable
- 0: disabled
- 1: enabled";
            sw = rw; hw = r;
            reset = 0x1;
        } exclusive_en[0:0];
    } AXI_ACTION @ 0x20;
    reg {
        name = "AXI_REGION_MAP";
        desc = "AXI_REGION_MAP is the address region mapping register. (offset 0x100; total reset 0x00000000; PROVEN: Hi3516E V300 data sheet (Issue 00B06, 2019-05-15), section 4.1.5.2, PDF page 218).";
        field {
            name = "reserved";
            desc = "Reserved";
            sw = r; hw = w;
            reset = 0x0;
        } reserved_31_13[31:13];
        field {
            name = "rgn_en";
            desc = "Current address region enable
- 0: disabled
- 1: enabled";
            sw = rw; hw = r;
            reset = 0x0;
        } rgn_en[12:12];
        field {
            name = "reserved";
            desc = "Reserved";
            sw = r; hw = w;
            reset = 0x0;
        } reserved_11_11[11:11];
        field {
            name = "rgn_size";
            desc = "Size of the current address region
- 0x0: 16 MB
- 0x1: 32 MB. In this case, rgn_base_addr/ch_offset[0] must be set to 0.
- 0x2: 64 MB. In this case, rgn_base_addr/ch_offset[1:0] must be set to 0.
- 0x3: 128 MB. In this case, rgn_base_addr/ch _offset[2:0] must be set to 0.
- 0x4: 256 MB. In this case, rgn_base_addr/ch _offset[3:0] must be set to 0.
- 0x5: 512 MB. In this case, rgn_base_addr/ch";
            sw = rw; hw = r;
            reset = 0x0;
        } rgn_size[10:8];
        field {
            name = "Base(upperrgn_base_addr";
            desc = "address of the current address region eight bits) The area address alignment granularity varies according to the address bit width because only the upper eight bits of the address can be configured. When the address bit width is 32 bits, the lower 24 bits of the base address of the address region are 0 and the area address is 16 MB aligned.";
            sw = rw; hw = r;
            reset = 0x0;
        } Base_upperrgn_base_addr[7:0];
    } AXI_REGION_MAP @ 0x100;
    reg {
        name = "AXI_REGION_ATTRIB";
        desc = "AXI_REGION_ATTRIB is the address region attribute register. (offset 0x104; total reset 0x00010004; PROVEN: Hi3516E V300 data sheet (Issue 00B06, 2019-05-15), section 4.1.5.2, PDF page 219).";
        field {
            name = "reserved";
            desc = "Reserved";
            sw = r; hw = w;
            reset = 0x0;
        } reserved_31_31[31:31];
        field {
            name = "bnk_mod";
            desc = "Bank interleaving granularity in the channel of the current address region (the interleaving granularity varies according to the component) 8 bytes x 2^n (8-bit components) 16 bytes x 2^n (16-bit components) 32 bytes x 2^n (32-bit components) 64 bytes x 2^n (64-bit components) n = 0-7 The bank interleaving granularity must be greater than or equal to the address alignment granularity (addr_aligned).";
            sw = rw; hw = r;
            reset = 0x0;
        } bnk_mod[30:28];
        field {
            name = "reserved";
            desc = "Reserved";
            sw = r; hw = w;
            reset = 0x0;
        } reserved_27_26[27:26];
        field {
            name = "rnk_mod";
            desc = "Rank interleaving mode of the channel of the current address region
- 0x0: The configuration in the DMC is used.
- 0x1: dual in-line memory module (DIMM) interleaving
- 0x2: Two rank addresses are interleaved.
- 0x3: Four rank addresses are interleaved.";
            sw = rw; hw = r;
            reset = 0x0;
        } rnk_mod[25:24];
        field {
            name = "reserved";
            desc = "Reserved";
            sw = r; hw = w;
            reset = 0x0;
        } reserved_23_19[23:19];
        field {
            name = "addr_aligned";
            desc = "Address boundary alignment granularity of the current address region
- 0x0: 8 bytes (valid only when the DMC data bit width is 64 bits)
- 0x1: 16 bytes
- 0x2: 32 bytes
- 0x3: 64 bytes
- 0x4: 128 bytes
- 0x5: 256 bytes
- 0x6: 512 bytes
- 0x7: 1 KB

Commands that cross the address alignment boundary will be split. The address alignment granularity must be less than or equal to the bank interleaving granularity (bnk_mod). When addresses are interleaved, the address alignment granularity must be less than or equal to the address interleaving granularity (ch_intlv). When the address is independent, the address alignment granularity must be less than or equal to the page size of the DDR.";
            sw = rw; hw = r;
            reset = 0x1;
        } addr_aligned[18:16];
        field {
            name = "ch_offset";
            desc = "Offset address of the current address region in the channel (upper eight bits) The offset address is used to replace the upper eight bits of the address in the channel to implement the offset of the mapping address in the channel. The offset address varies according to the address bit width. Bits [31:24] of the 32-bit address after channel mapping can be replaced.";
            sw = rw; hw = r;
            reset = 0x0;
        } ch_offset[15:8];
        field {
            name = "reserved";
            desc = "Reserved";
            sw = r; hw = w;
            reset = 0x0;
        } reserved_7_6[7:6];
        field {
            name = "ch_intlv";
            desc = "Address interleaving granularity of the current address region (invalid in single independent channel address mode)
- 0x0: 128 bytes
- 0x1: 256 bytes
- 0x2: 512 bytes
- 0x3: 1 KB

Commands are alternately sent to multiple channels based on this granularity. When channels are interleaved, the address interleaving granularity must be greater than or equal to the address alignment granularity (addr_aligned).";
            sw = rw; hw = r;
            reset = 0x0;
        } ch_intlv[5:4];
        field {
            name = "ch_mode";
            desc = "Channel mapping mode of the current address region
- 0x0: no mapping
- 0x1: The address of a single channel is mapped to the channel, and the address is independent
- 0x2: The addresses of two channels are mapped to the channel, and the addresses are interleaved.

Commands that attempt to access the unmapped address regions are processed as incorrect commands. In this case, interrupts are reported, command information is recorded, and the SLVERR response is returned from the AXI bus.";
            sw = rw; hw = r;
            reset = 0x1;
        } ch_mode[3:2];
        field {
            name = "ch_start";
            desc = "Mapping start channel of the current address region
- 0x0: channel 0
- 0x1: channel 1

In single-channel mapping mode, the mapping start channel can be any channel. In dual-channel mapping mode, the mapping start channel must be channel 0 (addresses of channel 0 and channel 1 are interleaved) or channel 2 (addresses of channel 2 and channel 3 are interleaved).";
            sw = rw; hw = r;
            reset = 0x0;
        } ch_start[1:0];
    } AXI_REGION_ATTRIB @ 0x104;
    reg {
        name = "AXI_QOS_MAP";
        desc = "AXI_QOS_MAP is the command priority mapping mode register. (offset 0x200; total reset 0x00000000; PROVEN: Hi3516E V300 data sheet (Issue 00B06, 2019-05-15), section 4.1.5.2, PDF page 222).";
        field {
            name = "reserved";
            desc = "Reserved";
            sw = r; hw = w;
            reset = 0x0;
        } reserved_31_22[31:22];
        field {
            name = "qos_rever";
            desc = "QoS inversion enable (for the priority arbitration of the read and write commands from the same port)
- 0: Priority 0 (axqos = 0) is the lowest priority.
- 1: Priority 0 (axqos = 0) is the highest priority.

This register is valid only when rw_arb_mode is 1.";
            sw = rw; hw = r;
            reset = 0x0;
        } qos_rever[21:21];
        field {
            name = "rw_arb_mode";
            desc = "Arbitration mode for the read and write commands from the same port
- 0: The arbitration is based on the command read/write type.

The command that arrives first is arbitrated first. When the read and write commands arrive simultaneously (or the backpressure is imposed on them simultaneously), the read command is arbitrated before the write command.
- 1: The arbitration is based on the command priority.

The command that arrives first is arbitrated first. When the read and write commands arrive simultaneously (or the backpressure is imposed on them simultaneously), the command with a higher priority is arbitrated first. If the priorities of the read and write commands are the same, the command that is not arbitrated last time is arbitrated according to the least recently used (LRU) rule.";
            sw = rw; hw = r;
            reset = 0x0;
        } rw_arb_mode[20:20];
        field {
            name = "reserved";
            desc = "Reserved";
            sw = r; hw = w;
            reset = 0x0;
        } reserved_19_13[19:13];
        field {
            name = "pri_map_mode";
            desc = "Priority mapping mode of the read/write command
- 0: Any three bits in the command ID or associated signal are used as the mapping index.
- 1: Any three bits in the lower 16 bits of the command ID are used as the mapping index.

The mapping index is obtained by using either of";
            sw = rw; hw = r;
            reset = 0x0;
        } pri_map_mode[12:12];
        field {
            name = "ThreemethodsforselectingbitsinthecommandIDasthemappingindexwhenthecommandIDisusedtomapthepriorityid_map_idx[11:8]:Anyonebitinthelower16bitsofthecommandIDisselectedasidx[2].id_map_idx[7:4]:Anyonebitinthelower16bitsofthecommandIDisselectedasidx[1].id_map_idx[3:0]:Anyonebitinthelower16bitsofthecommandIDisselectedasidx[0].id_map_idxForexample,ifid_map_idxissetto0x3A0,ID[3],ID[10],andID[0]ofthecommandformidx[2:0],whichisusedtomapthecommandpriorityfromtheprioritylookuptable.ThelookuptableindicatesthedescriptionofAXI_QOS_WRPRIorAXI_QOS_RDPRI.ThecommandIDindicatestheoriginalcommandID.";
            desc = "";
            sw = rw; hw = r;
            reset = 0x0;
        } ThreemethodsforselectingbitsinthecommandIDasthemappingindexwhenthecommandIDisusedtomapthepriorityid_map_idx_11_8_Anyonebitinthelower16bitsofthecommandIDisselectedasidx_2_id_map_idx_7_4_Anyonebitinthelower16bitsofthecommandIDisselectedasidx_1_id_map_idx_3_0_Anyonebitinthelower16bitsofthecommandIDisselectedasidx_0_id_map_idxForexample_ifid_map_idxissetto0x3A0_ID_3_ID_10_andID_0_ofthecommandformidx_2_0_whichisusedtomapthecommandpriorityfromtheprioritylookuptable_ThelookuptableindicatesthedescriptionofAXI_QOS_WRPRIorAXI_QOS_RDPRI_ThecommandIDindicatestheoriginalcommandID[11:0];
    } AXI_QOS_MAP @ 0x200;
    reg {
        name = "AXI_QOS_WRPRIn";
        desc = "AXI_QOS_WRPRIn is the write command priority mapping table register. (offset 0x204; total reset 0x00000000; PROVEN: Hi3516E V300 data sheet (Issue 00B06, 2019-05-15), section 4.1.5.2, PDF page 223).";
        field {
            name = "reserved";
            desc = "Reserved";
            sw = r; hw = w;
            reset = 0x0;
        } reserved_31_31[31:31];
        field {
            name = "wr_pri7";
            desc = "Priority of the write command when the mapping index is 7
- 0x0: highest priority …
- 0x7: lowest priority";
            sw = rw; hw = r;
            reset = 0x0;
        } wr_pri7[30:28];
        field {
            name = "reserved";
            desc = "Reserved";
            sw = r; hw = w;
            reset = 0x0;
        } reserved_27_27[27:27];
        field {
            name = "wr_pri6";
            desc = "Priority of the write command when the mapping index is 6
- 0x0: highest priority …";
            sw = rw; hw = r;
            reset = 0x0;
        } wr_pri6[26:24];
        field {
            name = "reserved";
            desc = "Reserved";
            sw = r; hw = w;
            reset = 0x0;
        } reserved_23_23[23:23];
        field {
            name = "wr_pri5";
            desc = "Priority of the write command when the mapping index is 5
- 0x0: highest priority …
- 0x7: lowest priority";
            sw = rw; hw = r;
            reset = 0x0;
        } wr_pri5[22:20];
        field {
            name = "reserved";
            desc = "Reserved";
            sw = r; hw = w;
            reset = 0x0;
        } reserved_19_19[19:19];
        field {
            name = "wr_pri4";
            desc = "Priority of the write command when the mapping index is 4
- 0x0: highest priority …
- 0x7: lowest priority";
            sw = rw; hw = r;
            reset = 0x0;
        } wr_pri4[18:16];
        field {
            name = "reserved";
            desc = "Reserved";
            sw = r; hw = w;
            reset = 0x0;
        } reserved_15_15[15:15];
        field {
            name = "wr_pri3";
            desc = "Priority of the write command when the mapping index is 3
- 0x0: highest priority …
- 0x7: lowest priority";
            sw = rw; hw = r;
            reset = 0x0;
        } wr_pri3[14:12];
        field {
            name = "reserved";
            desc = "Reserved";
            sw = r; hw = w;
            reset = 0x0;
        } reserved_11_11[11:11];
        field {
            name = "wr_pri2";
            desc = "Priority of the write command when the mapping index is 2
- 0x0: highest priority …
- 0x7: lowest priority";
            sw = rw; hw = r;
            reset = 0x0;
        } wr_pri2[10:8];
        field {
            name = "reserved";
            desc = "Reserved";
            sw = r; hw = w;
            reset = 0x0;
        } reserved_7_7[7:7];
        field {
            name = "wr_pri1";
            desc = "Priority of the write command when the mapping index is 1
- 0x0: highest priority …
- 0x7: lowest priority";
            sw = rw; hw = r;
            reset = 0x0;
        } wr_pri1[6:4];
        field {
            name = "reserved";
            desc = "Reserved";
            sw = r; hw = w;
            reset = 0x0;
        } reserved_3_3[3:3];
        field {
            name = "wr_pri0";
            desc = "Priority of the write command when the mapping index is 0
- 0x0: highest priority …
- 0x7: lowest priority";
            sw = rw; hw = r;
            reset = 0x0;
        } wr_pri0[2:0];
    } AXI_QOS_WRPRIn @ 0x204;
    reg {
        name = "AXI_QOS_RDPRIn";
        desc = "AXI_QOS_RDPRIn is the read command priority mapping table register. (offset 0x208; total reset 0x00000000; PROVEN: Hi3516E V300 data sheet (Issue 00B06, 2019-05-15), section 4.1.5.2, PDF page 225).";
        field {
            name = "reserved";
            desc = "Reserved";
            sw = r; hw = w;
            reset = 0x0;
        } reserved_31_31[31:31];
        field {
            name = "rd_pri7";
            desc = "Priority of the read command when the mapping index is 7
- 0x0: highest priority …
- 0x7: lowest priority";
            sw = rw; hw = r;
            reset = 0x0;
        } rd_pri7[30:28];
        field {
            name = "reserved";
            desc = "Reserved";
            sw = r; hw = w;
            reset = 0x0;
        } reserved_27_27[27:27];
        field {
            name = "rd_pri6";
            desc = "Priority of the read command when the mapping index is 6
- 0x0: highest priority …
- 0x7: lowest priority";
            sw = rw; hw = r;
            reset = 0x0;
        } rd_pri6[26:24];
        field {
            name = "reserved";
            desc = "Reserved";
            sw = r; hw = w;
            reset = 0x0;
        } reserved_23_23[23:23];
        field {
            name = "rd_pri5";
            desc = "Priority of the read command when the mapping index is 5
- 0x0: highest priority …
- 0x7: lowest priority";
            sw = rw; hw = r;
            reset = 0x0;
        } rd_pri5[22:20];
        field {
            name = "reserved";
            desc = "Reserved";
            sw = r; hw = w;
            reset = 0x0;
        } reserved_19_19[19:19];
        field {
            name = "rd_pri4";
            desc = "Priority of the read command when the mapping index is 4
- 0x0: highest priority …
- 0x7: lowest priority";
            sw = rw; hw = r;
            reset = 0x0;
        } rd_pri4[18:16];
        field {
            name = "reserved";
            desc = "Reserved";
            sw = r; hw = w;
            reset = 0x0;
        } reserved_15_15[15:15];
        field {
            name = "rd_pri3";
            desc = "Priority of the read command when the mapping index is 3
- 0x0: highest priority …
- 0x7: lowest priority";
            sw = rw; hw = r;
            reset = 0x0;
        } rd_pri3[14:12];
        field {
            name = "reserved";
            desc = "Reserved";
            sw = r; hw = w;
            reset = 0x0;
        } reserved_11_11[11:11];
        field {
            name = "rd_pri2";
            desc = "Priority of the read command when the";
            sw = rw; hw = r;
            reset = 0x0;
        } rd_pri2[10:8];
        field {
            name = "reserved";
            desc = "Reserved";
            sw = r; hw = w;
            reset = 0x0;
        } reserved_7_7[7:7];
        field {
            name = "rd_pri1";
            desc = "Priority of the read command when the mapping index is 1
- 0x0: highest priority …
- 0x7: lowest priority";
            sw = rw; hw = r;
            reset = 0x0;
        } rd_pri1[6:4];
        field {
            name = "reserved";
            desc = "Reserved";
            sw = r; hw = w;
            reset = 0x0;
        } reserved_3_3[3:3];
        field {
            name = "rd_pri0";
            desc = "Priority of the read command when the mapping index is 0
- 0x0: highest priority …
- 0x7: lowest priority";
            sw = rw; hw = r;
            reset = 0x0;
        } rd_pri0[2:0];
    } AXI_QOS_RDPRIn @ 0x208;
    reg {
        name = "AXI_QOS_ADPTn";
        desc = "AXI_QOS_ADPTn is the priority adaptation cycle mapping table register. (offset 0x20C; total reset 0x00000000; PROVEN: Hi3516E V300 data sheet (Issue 00B06, 2019-05-15), section 4.1.5.2, PDF page 226).";
        field {
            name = "reserved";
            desc = "Reserved";
            sw = r; hw = w;
            reset = 0x0;
        } reserved_31_28[31:28];
        field {
            name = "wr_adpt_high";
            desc = "Write command priority adaptation cycle (high-level)
- 0x0: The priority adaptation function is disabled. 0x1-0xF: (n x 16) clock cycles

The priority of a command is automatically increased by one level each time it reaches a priority adaptation cycle, until the priority becomes the second highest one.";
            sw = rw; hw = r;
            reset = 0x0;
        } wr_adpt_high[27:24];
        field {
            name = "reserved";
            desc = "Reserved";
            sw = r; hw = w;
            reset = 0x0;
        } reserved_23_23[23:23];
        field {
            name = "wr_adpt_lvl";
            desc = "Write command priority adaptation cycle threshold 0x0-0x1: reserved";
            sw = rw; hw = r;
            reset = 0x0;
        } wr_adpt_lvl[22:20];
        field {
            name = "wr_adpt_low";
            desc = "Write command priority adaptation cycle (low-level)
- 0x0: The priority adaptation function is disabled. 0x1-0xF: (n x 16) clock cycles

The priority of a command is automatically increased by one level each time it reaches a priority adaptation cycle, until the priority becomes the second highest one.";
            sw = rw; hw = r;
            reset = 0x0;
        } wr_adpt_low[19:16];
        field {
            name = "reserved";
            desc = "Reserved";
            sw = r; hw = w;
            reset = 0x0;
        } reserved_15_12[15:12];
        field {
            name = "rd_adpt_high";
            desc = "Read command priority adaptation cycle (high-level)
- 0x0: The priority adaptation function is disabled. 0x1-0xF: (n x 16) clock cycles

The priority of a command is automatically increased by one level each time it reaches a priority adaptation cycle, until the priority becomes the second highest one.";
            sw = rw; hw = r;
            reset = 0x0;
        } rd_adpt_high[11:8];
        field {
            name = "reserved";
            desc = "Reserved";
            sw = r; hw = w;
            reset = 0x0;
        } reserved_7_7[7:7];
        field {
            name = "rd_adpt_lvl";
            desc = "Read command priority adaptation cycle threshold 0x0-0x1: reserved 0x2-0x7: When the priority of a command is greater than or equal to the threshold, the command is mapped to the high-level cycle. Otherwise, the command is mapped to the low-level cycle. For example:
- 0x5: The priority adaptation cycle of read commands with priorities 2 to 5 is configured";
            sw = rw; hw = r;
            reset = 0x0;
        } rd_adpt_lvl[6:4];
        field {
            name = "Readcommandpriorityadaptationcycle(low-level)0x0:Thepriorityadaptationfunctionisdisabled.0x1-0xF:(nx16)clockcyclesrd_adpt_lowThepriorityofacommandisautomaticallyincreasedbyoneleveleachtimeitreachesapriorityadaptationcycle,untiltheprioritybecomesthesecondhighestone.";
            desc = "";
            sw = rw; hw = r;
            reset = 0x0;
        } Readcommandpriorityadaptationcycle_low_level_0x0_Thepriorityadaptationfunctionisdisabled_0x1_0xF_nx16_clockcyclesrd_adpt_lowThepriorityofacommandisautomaticallyincreasedbyoneleveleachtimeitreachesapriorityadaptationcycle_untiltheprioritybecomesthesecondhighestone[3:0];
    } AXI_QOS_ADPTn @ 0x20C;
    reg {
        name = "AXI_OSTD_PRTn";
        desc = "AXI_OSTD_PRTn is the port command OSTD restriction register. (offset 0x300; total reset 0x00000000; PROVEN: Hi3516E V300 data sheet (Issue 00B06, 2019-05-15), section 4.1.5.2, PDF page 228).";
        field {
            name = "reserved";
            desc = "Reserved";
            sw = r; hw = w;
            reset = 0x0;
        } reserved_31_7[31:7];
        field {
            name = "prt_ostd_lvl";
            desc = "Command OSTD threshold of a port
- 0x00: The number of command OSTDs of a port is not limited. 0x01-0x7F: maximum number of command

OSTDs allowed by the port In this document, the number of OSTDs is the number of commands in the back-end module QoSBuf. In this document, the threshold cannot be greater than the command queue depth of the QoSBuf that is specified by setting parameters.";
            sw = rw; hw = r;
            reset = 0x0;
        } prt_ostd_lvl[6:0];
    } AXI_OSTD_PRTn @ 0x300;
    reg {
        name = "AXI_OSTD_PRT_STn";
        desc = "AXI_OSTD_PRT_STn is the port command OSTD statistics register. (offset 0x304; total reset 0x00000000; PROVEN: Hi3516E V300 data sheet (Issue 00B06, 2019-05-15), section 4.1.5.2, PDF page 228).";
        field {
            name = "reserved";
            desc = "Reserved";
            sw = r; hw = w;
            reset = 0x0;
        } reserved_31_7[31:7];
        field {
            name = "prt_ostd_st";
            desc = "Command OSTD statistics of a port";
            sw = r; hw = w;
            reset = 0x0;
        } prt_ostd_st[6:0];
    } AXI_OSTD_PRT_STn @ 0x304;
    reg {
        name = "AXI_OSTD_GROUPn";
        desc = "AXI_OSTD_GROUPn is the command OSTD register for the port group. (offset 0x400; total reset 0x00000000; PROVEN: Hi3516E V300 data sheet (Issue 00B06, 2019-05-15), section 4.1.5.2, PDF page 229).";
        field {
            name = "reserved";
            desc = "Reserved";
            sw = r; hw = w;
            reset = 0x0;
        } reserved_31_28[31:28];
        field {
            name = "group_ostd_sel";
            desc = "Port select of a group When group_ostd_sel[n] is 0, port n is not selected. When group_ostd_sel[n] is 1, port n is selected. Only the selected ports are involved in the OSTD statistics of the port group.";
            sw = rw; hw = r;
            reset = 0x0;
        } group_ostd_sel[27:16];
        field {
            name = "reserved";
            desc = "Reserved";
            sw = r; hw = w;
            reset = 0x0;
        } reserved_15_7[15:7];
        field {
            name = "group_ostd_lvl";
            desc = "Command OSTD threshold of a port group
- 0x00: The number of command OSTDs of the port group is not limited. 0x01-0x7F: maximum number of accumulated command OSTDs allowed by the port group

The number of the command OSTDs of a port group is the sum of the command OSTDs of all the ports selected by the port group. When the number of command OSTDs exceeds the threshold, all the ports in the port group are blocked.";
            sw = rw; hw = r;
            reset = 0x0;
        } group_ostd_lvl[6:0];
    } AXI_OSTD_GROUPn @ 0x400;
    reg {
        name = "AXI_OSTD_PRI0";
        desc = "AXI_OSTD_PRI0 is priority-based port group command OSTD restriction register 0. (offset 0x404; total reset 0x00000000; PROVEN: Hi3516E V300 data sheet (Issue 00B06, 2019-05-15), section 4.1.5.2, PDF page 229).";
        field {
            name = "reserved";
            desc = "Reserved";
            sw = r; hw = w;
            reset = 0x0;
        } reserved_31_31[31:31];
        field {
            name = "pri3_ostd_lvl";
            desc = "Priority 3 command OSTD threshold
- 0x00: The number of accumulated command

OSTDs of the selected port group is not limited. 0x01-0x7F: When the number of accumulated command OSTDs of the selected port group reaches the threshold, only the commands whose priorities are higher than 1 are allowed. The command OSTD statistics and restriction are based on the port group. If the priority deliver function is enabled, the commands with low priorities may not be blocked because their priorities are increased.";
            sw = rw; hw = r;
            reset = 0x0;
        } pri3_ostd_lvl[30:24];
        field {
            name = "reserved";
            desc = "Reserved";
            sw = r; hw = w;
            reset = 0x0;
        } reserved_23_23[23:23];
        field {
            name = "pri2_ostd_lvl";
            desc = "Priority 2 command OSTD threshold
- 0x00: The number of accumulated command

OSTDs of the selected port group is not limited. 0x01-0x7F: When the number of accumulated command OSTDs of the selected port group reaches the threshold, only the commands whose priorities are higher than 1 are allowed. The command OSTD statistics and restriction are based on the port group. If the priority deliver function is enabled, the commands with low priorities may not be blocked because their priorities are increased.";
            sw = rw; hw = r;
            reset = 0x0;
        } pri2_ostd_lvl[22:16];
        field {
            name = "reserved";
            desc = "Reserved";
            sw = r; hw = w;
            reset = 0x0;
        } reserved_15_15[15:15];
        field {
            name = "pri1_ostd_lvl";
            desc = "Priority 1 command OSTD threshold
- 0x00: The number of accumulated command

OSTDs of the selected port group is not limited. 0x01-0x7F: When the number of accumulated command OSTDs of the selected port group reaches the threshold, only the commands whose priorities are higher than 1 are allowed. The command OSTD statistics and restriction are based on the port group.";
            sw = rw; hw = r;
            reset = 0x0;
        } pri1_ostd_lvl[14:8];
        field {
            name = "reserved";
            desc = "Reserved";
            sw = r; hw = w;
            reset = 0x0;
        } reserved_7_0[7:0];
    } AXI_OSTD_PRI0 @ 0x404;
    reg {
        name = "AXI_OSTD_PRI1";
        desc = "AXI_OSTD_PRI1 is priority-based port group command OSTD restriction register 1. (offset 0x408; total reset 0x00000000; PROVEN: Hi3516E V300 data sheet (Issue 00B06, 2019-05-15), section 4.1.5.2, PDF page 231).";
        field {
            name = "reserved";
            desc = "Reserved";
            sw = r; hw = w;
            reset = 0x0;
        } reserved_31_31[31:31];
        field {
            name = "pri7_ostd_lvl";
            desc = "Priority 7 command OSTD threshold
- 0x00: The number of accumulated command

OSTDs of the selected port group is not limited. 0x01-0x7F: When the number of accumulated command OSTDs of the selected port group reaches the threshold, only the commands whose priorities are higher than 1 are allowed. The command OSTD statistics and restriction are based on the port group. If the priority deliver function is enabled, the commands with low priorities may not be blocked because their priorities are increased.";
            sw = rw; hw = r;
            reset = 0x0;
        } pri7_ostd_lvl[30:24];
        field {
            name = "reserved";
            desc = "Reserved";
            sw = r; hw = w;
            reset = 0x0;
        } reserved_23_23[23:23];
        field {
            name = "pri6_ostd_lvl";
            desc = "Priority 6 command OSTD threshold
- 0x00: The number of accumulated command

OSTDs of the selected port group is not limited. 0x01-0x7F: When the number of accumulated command OSTDs of the selected port group reaches the threshold, only the commands whose priorities are higher than 1 are allowed. The command OSTD statistics and restriction are based on the port group. If the priority deliver function is enabled, the commands with low priorities may not be blocked because their priorities are increased.";
            sw = rw; hw = r;
            reset = 0x0;
        } pri6_ostd_lvl[22:16];
        field {
            name = "reserved";
            desc = "Reserved";
            sw = r; hw = w;
            reset = 0x0;
        } reserved_15_15[15:15];
        field {
            name = "pri5_ostd_lvl";
            desc = "Priority 5 command OSTD threshold
- 0x00: The number of accumulated command

OSTDs of the selected port group is not limited. 0x01-0x7F: When the number of accumulated command OSTDs of the selected port group reaches the threshold, only the commands whose priorities are higher than 1 are allowed. The command OSTD statistics and restriction are based on the port group. If the priority deliver function is enabled, the commands with low priorities may not be blocked because their priorities are increased.";
            sw = rw; hw = r;
            reset = 0x0;
        } pri5_ostd_lvl[14:8];
        field {
            name = "reserved";
            desc = "Reserved";
            sw = r; hw = w;
            reset = 0x0;
        } reserved_7_7[7:7];
        field {
            name = "pri4_ostd_lvl";
            desc = "Priority 4 command OSTD threshold
- 0x00: The number of accumulated command

OSTDs of the selected port group is not limited. 0x01-0x7F: When the number of accumulated command OSTDs of the selected port group reaches the threshold, only the commands whose priorities are higher than 1 are allowed. The command OSTD statistics and restriction are based on the port group. If the priority deliver function is enabled, the commands with low priorities may not be blocked because their priorities are increased.";
            sw = rw; hw = r;
            reset = 0x0;
        } pri4_ostd_lvl[6:0];
    } AXI_OSTD_PRI1 @ 0x408;
    reg {
        name = "AXI_OSTD_GROUP_STn";
        desc = "AXI_OSTD_GROUP_STn is the command OSTD statistics register for the port group. (offset 0x40C; total reset 0x00000000; PROVEN: Hi3516E V300 data sheet (Issue 00B06, 2019-05-15), section 4.1.5.2, PDF page 232).";
        field {
            name = "reserved";
            desc = "Reserved";
            sw = r; hw = w;
            reset = 0x0;
        } reserved_31_7[31:7];
        field {
            name = "group_ostd_st";
            desc = "Command OSTD statistics of a port group";
            sw = r; hw = w;
            reset = 0x0;
        } group_ostd_st[6:0];
    } AXI_OSTD_GROUP_STn @ 0x40C;
    reg {
        name = "AXI_STATUS";
        desc = "AXI_STATUS is the port operating mode register. (offset 0x60C; total reset 0x00000000; PROVEN: Hi3516E V300 data sheet (Issue 00B06, 2019-05-15), section 4.1.5.2, PDF page 233).";
        field {
            name = "reserved";
            desc = "Reserved";
            sw = r; hw = w;
            reset = 0x0;
        } reserved_31_12[31:12];
        field {
            name = "axi_if_busy";
            desc = "Operating mode of each AXI port When axi_prt_busy[n] is 0, AXI port n is idle. When axi_prt_busy[n] is 1, AXI port n is processing commands or data.";
            sw = r; hw = w;
            reset = 0x0;
        } axi_if_busy[11:0];
    } AXI_STATUS @ 0x60C;
    reg {
        name = "AXI_INT_STATUS";
        desc = "AXI_INT_STATUS is the interrupt status register. (offset 0x61C; total reset 0x00000000; PROVEN: Hi3516E V300 data sheet (Issue 00B06, 2019-05-15), section 4.1.5.2, PDF page 233).";
        field {
            name = "reserved";
            desc = "Reserved";
            sw = r; hw = w;
            reset = 0x0;
        } reserved_31_12[31:12];
        field {
            name = "int_ports";
            desc = "Interrupt source indicator When interrupt_ports[n] is 1, the interrupt source is port n. When the command does not pass the security permission check and the interrupt is enabled, the corresponding port generates interrupts.";
            sw = r; hw = w;
            reset = 0x0;
        } int_ports[11:0];
    } AXI_INT_STATUS @ 0x61C;
};
`endif
