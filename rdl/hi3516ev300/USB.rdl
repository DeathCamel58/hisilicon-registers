`ifndef HI3516EV300_USBPHY_RDL
`define HI3516EV300_USBPHY_RDL

regfile eUSB2_PHY_HIXVP {
    name = "USB 2.0 PHY (hixvp), Hi3516EV200/EV300 generation";
    desc = "PHY register page at 0x100D0000. Bring-up order (U-Boot phy_hiusb_init, PROVEN): pad VBUS 0x100C007C = 0x431 and PWREN 0x100C0080 = 1; CRG 0x140 = 0x3B2F then 200 us; set UTMI, PHY APB, ref, bus, PLL, XTAL clocks and free-clock select; release PHY APB reset (bit 10), POR (bit 0), write PLL_CFG = 3 and wait 2 ms, release TPOR (bit 1), release controller reset (bit 3); then the controller setup in eDWC3_GLOBAL_V4 and the eye/trim/SVB writes above.";

    reg {
        name = "PHY analog configuration 0";
        desc = "Data sheet 12.6.6 (PDF page 750-751): total reset 0x0433C003; fields [31:28] and [23:0] reserved, only [27:24] is documented. Source of the vendor detail: vendor U-Boot drivers/phy/hibvt/phy-hi3516ev300-usb.c (EV300 tree) and the vendor Linux DT `hixvp-usb2-phy` node. PROVEN offsets/bits (source), values are board-independent defaults. Vendor DT ana_cfg_0_eye_val 0x0433C003. [27:24] is written twice by U-Boot: HSTX pre-drive = 4 (usb2_eye_config) and then the SVB-dependent value 2..5 chosen from SYS_CTRL 0x158 (usb2_svb_config).";
        field {
            name = "reserved";
            desc = "Reserved";
            sw = r;
            hw = w;
            reset = 0x0;
        } reserved_31_28[31:28];
        field {
            name = "usb2_phy0_rg_hstx_pdrv_p";
            desc = "Pre-drive strength: Bit[0] x 1 + Bit[1] x 2 + Bit[2] x 4 + Bit[3] x 8 (data sheet Table 12-18 / PDF page 751, PROVEN, reset 0x4). Vendor use: HSTX pre-drive strength / SVB-dependent trim (4 by eye config; 5/4/3/2 by SVB range 0x2BC/0x32A/0x398/0x3CA/0x44C). PROVEN.";
            sw = rw;
            hw = r;
            reset = 0x4;
        } usb2_phy0_rg_hstx_pdrv_p[27:24];
            field {
            name = "reserved";
            desc = "Reserved";
            sw = r;
            hw = w;
            reset = 0x33c003;
        } reserved_23_0[23:0];
} ANA_CFG_0 @ 0x0;

    reg {
        name = "PHY analog configuration 2";
        desc = "Source: vendor U-Boot drivers/phy/hibvt/phy-hi3516ev300-usb.c (EV300 tree) and the vendor Linux DT `hixvp-usb2-phy` node. PROVEN offsets/bits (source), values are board-independent defaults. Vendor DT ana_cfg_2_eye_val 0x00120E0F.";
        field {
            name = "trim";
            desc = "Calibration trim from MISC 0x12028004 [4:0] (valid 0x09..0x1D, default 0x0E). PROVEN.";
            sw = rw;
            hw = r;
        } trim[12:8];
        field {
            name = "disc_ref";
            desc = "Disconnect reference voltage select, 2 by U-Boot. PROVEN.";
            sw = rw;
            hw = r;
        } disc_ref[18:16];
        field {
            name = "tx_test";
            desc = "TX test bit, set by U-Boot. PROVEN.";
            sw = rw;
            hw = r;
        } tx_test[20:20];
    } ANA_CFG_2 @ 0x8;

    reg {
        name = "PHY analog configuration 4";
        desc = "Data sheet 12.6.6 (PDF page 751): total reset 0x00000653; the vendor DT value 0x655 differs in the reserved bits [3:0] (3 in the data sheet, 5 in the vendor DT). Source of the vendor detail: vendor U-Boot drivers/phy/hibvt/phy-hi3516ev300-usb.c (EV300 tree) and the vendor Linux DT `hixvp-usb2-phy` node. PROVEN offsets/bits (source), values are board-independent defaults. Vendor DT ana_cfg_4_eye_val 0x00000655.";
        field {
            name = "reserved";
            desc = "Reserved";
            sw = r;
            hw = w;
            reset = 0xc;
        } reserved_31_7[31:7];
        field {
            name = "usb2_phy0_rg_vtxref_sel";
            desc = "Reference value for the amplitude of the HS eye pattern (an adjustment trend, not a precise value): 000 = 380 mV, 001 = 390 mV, 010 = 400 mV, 011 = 410 mV, 100 = 420 mV, 101 = 430 mV, 110 = 440 mV, 111 = 460 mV (data sheet PDF page 751, PROVEN, reset 0x5). Vendor U-Boot sets 5.";
            reset = 0x5;
            sw = rw;
            hw = r;
        } usb2_phy0_rg_vtxref_sel[6:4];
            field {
            name = "reserved";
            desc = "Reserved";
            sw = r;
            hw = w;
            reset = 0x3;
        } reserved_3_0[3:0];
} ANA_CFG_4 @ 0x10;

    reg {
        name = "PHY PLL enable";
        desc = "Source: vendor U-Boot drivers/phy/hibvt/phy-hi3516ev300-usb.c (EV300 tree) and the vendor Linux DT `hixvp-usb2-phy` node. PROVEN offsets/bits (source), values are board-independent defaults. phy_pll_offset 0x14, mask 3, value 3 (RG_PLL_EN).";
        field {
            name = "rg_pll_en";
            desc = "PLL enable; U-Boot writes 3 after releasing the POR reset. PROVEN.";
            sw = rw;
            hw = r;
        } rg_pll_en[1:0];
    } PLL_CFG @ 0x14;

};

`endif
