`ifndef HI3516EV300_SDHCI_RDL
`define HI3516EV300_SDHCI_RDL

regfile eSDHCI_HISI_V4 {
    name = "SDHCI host with HiSilicon vendor registers, Hi3516EV200/EV300 generation";
    desc = "SD Host Controller (standard SDHCI register set) at 0x10010000 (eMMC / SDIO0, SPI 30) and 0x10020000 (SDIO1, SPI 31); the vendor extension registers sit at 0x508..0x54C. Clock, reset and DLL phase control are in the CRG (PERI_CRG125..139). Standard registers are described from the public SDHCI spec (INFERRED), vendor registers from the vendor U-Boot (PROVEN source, not run); the layout looks like a Synopsys DWC MSHC core (MSHC_CTRL, AXI_MBIIU names) but no databook was available.";

    reg {
        name = "SDMA system address / Argument 2";
        desc = "Standard SD Host Controller register (SD Association Simplified Host Controller spec, offsets as used by U-Boot include/sdhci.h and drivers/mmc/sdhci.c). Evidence: INFERRED (public spec + vendor driver use), nothing read from the EV300. ";
        field {
            name = "value";
            desc = "DMA address.";
            sw = rw;
            hw = r;
        } value[31:0];
    } SDMA_ADDR @ 0x0;

    reg {
        name = "Block size and count";
        desc = "Standard SD Host Controller register (SD Association Simplified Host Controller spec, offsets as used by U-Boot include/sdhci.h and drivers/mmc/sdhci.c). Evidence: INFERRED (public spec + vendor driver use), nothing read from the EV300. ";
        field {
            name = "block_size";
            desc = "Transfer block size.";
            sw = rw;
            hw = r;
        } block_size[11:0];
        field {
            name = "sdma_boundary";
            desc = "SDMA buffer boundary.";
            sw = rw;
            hw = r;
        } sdma_boundary[14:12];
        field {
            name = "block_count";
            desc = "Block count.";
            sw = rw;
            hw = r;
        } block_count[31:16];
    } BLOCK @ 0x4;

    reg {
        name = "Command argument";
        desc = "Standard SD Host Controller register (SD Association Simplified Host Controller spec, offsets as used by U-Boot include/sdhci.h and drivers/mmc/sdhci.c). Evidence: INFERRED (public spec + vendor driver use), nothing read from the EV300. ";
        field {
            name = "value";
            desc = "Argument.";
            sw = rw;
            hw = r;
        } value[31:0];
    } ARGUMENT @ 0x8;

    reg {
        name = "Transfer mode and command";
        desc = "Standard SD Host Controller register (SD Association Simplified Host Controller spec, offsets as used by U-Boot include/sdhci.h and drivers/mmc/sdhci.c). Evidence: INFERRED (public spec + vendor driver use), nothing read from the EV300. ";
        field {
            name = "dma_en";
            desc = "DMA enable.";
            sw = rw;
            hw = r;
        } dma_en[0:0];
        field {
            name = "blk_cnt_en";
            desc = "Block count enable.";
            sw = rw;
            hw = r;
        } blk_cnt_en[1:1];
        field {
            name = "auto_cmd";
            desc = "Auto CMD12/CMD23.";
            sw = rw;
            hw = r;
        } auto_cmd[3:2];
        field {
            name = "data_dir_read";
            desc = "1 = read.";
            sw = rw;
            hw = r;
        } data_dir_read[4:4];
        field {
            name = "multi_blk";
            desc = "Multi-block.";
            sw = rw;
            hw = r;
        } multi_blk[5:5];
        field {
            name = "resp_type";
            desc = "Response type.";
            sw = rw;
            hw = r;
        } resp_type[17:16];
        field {
            name = "crc_chk";
            desc = "CRC check.";
            sw = rw;
            hw = r;
        } crc_chk[19:19];
        field {
            name = "idx_chk";
            desc = "Index check.";
            sw = rw;
            hw = r;
        } idx_chk[20:20];
        field {
            name = "data_present";
            desc = "Data present.";
            sw = rw;
            hw = r;
        } data_present[21:21];
        field {
            name = "cmd_index";
            desc = "Command index.";
            sw = rw;
            hw = r;
        } cmd_index[29:24];
    } CMD_XFER @ 0xC;

    reg {
        name = "Response";
        desc = "Standard SD Host Controller register (SD Association Simplified Host Controller spec, offsets as used by U-Boot include/sdhci.h and drivers/mmc/sdhci.c). Evidence: INFERRED (public spec + vendor driver use), nothing read from the EV300.";
        field {
            name = "resp";
            desc = "Response word.";
            sw = r;
            hw = w;
        } resp[31:0];
    } RESPONSE[4] @ 0x10 += 0x4;

    reg {
        name = "Buffer data port";
        desc = "Standard SD Host Controller register (SD Association Simplified Host Controller spec, offsets as used by U-Boot include/sdhci.h and drivers/mmc/sdhci.c). Evidence: INFERRED (public spec + vendor driver use), nothing read from the EV300. ";
        field {
            name = "value";
            desc = "PIO data.";
            sw = rw;
            hw = r;
        } value[31:0];
    } BUFFER_DATA @ 0x20;

    reg {
        name = "Present state";
        desc = "Standard SD Host Controller register (SD Association Simplified Host Controller spec, offsets as used by U-Boot include/sdhci.h and drivers/mmc/sdhci.c). Evidence: INFERRED (public spec + vendor driver use), nothing read from the EV300. ";
        field {
            name = "state";
            desc = "Present state bits (cmd/dat inhibit, card inserted, ...).";
            sw = r;
            hw = w;
        } state[31:0];
    } PRESENT_STATE @ 0x24;

    reg {
        name = "Host control 1, power, block gap, wake-up";
        desc = "Standard SD Host Controller register (SD Association Simplified Host Controller spec, offsets as used by U-Boot include/sdhci.h and drivers/mmc/sdhci.c). Evidence: INFERRED (public spec + vendor driver use), nothing read from the EV300. ";
        field {
            name = "led";
            desc = "LED.";
            sw = rw;
            hw = r;
        } led[0:0];
        field {
            name = "bus_4bit";
            desc = "4-bit bus.";
            sw = rw;
            hw = r;
        } bus_4bit[1:1];
        field {
            name = "high_speed";
            desc = "High speed enable.";
            sw = rw;
            hw = r;
        } high_speed[2:2];
        field {
            name = "dma_sel";
            desc = "DMA select (2 = ADMA2).";
            sw = rw;
            hw = r;
        } dma_sel[4:3];
        field {
            name = "bus_8bit";
            desc = "8-bit bus.";
            sw = rw;
            hw = r;
        } bus_8bit[5:5];
        field {
            name = "sd_bus_power";
            desc = "Bus power.";
            sw = rw;
            hw = r;
        } sd_bus_power[8:8];
        field {
            name = "sd_bus_voltage";
            desc = "Bus voltage select.";
            sw = rw;
            hw = r;
        } sd_bus_voltage[11:9];
    } HOST_CTRL1 @ 0x28;

    reg {
        name = "Clock control, timeout, software reset";
        desc = "Standard SD Host Controller register (SD Association Simplified Host Controller spec, offsets as used by U-Boot include/sdhci.h and drivers/mmc/sdhci.c). Evidence: INFERRED (public spec + vendor driver use), nothing read from the EV300. Bit 3 is 'PLL enable' per the sibling Hi3516E V200 notes (docs/research/hi3516ev200-blocks.md, vendor sdhci glue); UNVERIFIED here.";
        field {
            name = "int_clk_en";
            desc = "Internal clock enable.";
            sw = rw;
            hw = r;
        } int_clk_en[0:0];
        field {
            name = "int_clk_stable";
            desc = "Internal clock stable.";
            sw = r;
            hw = w;
        } int_clk_stable[1:1];
        field {
            name = "sd_clk_en";
            desc = "SD clock enable.";
            sw = rw;
            hw = r;
        } sd_clk_en[2:2];
        field {
            name = "pll_en";
            desc = "Programmable clock / PLL enable (vendor use, INFERRED).";
            sw = rw;
            hw = r;
        } pll_en[3:3];
        field {
            name = "freq_sel_hi";
            desc = "Upper divider bits.";
            sw = rw;
            hw = r;
        } freq_sel_hi[7:6];
        field {
            name = "freq_sel";
            desc = "SDCLK divider.";
            sw = rw;
            hw = r;
        } freq_sel[15:8];
        field {
            name = "data_timeout";
            desc = "Data timeout counter.";
            sw = rw;
            hw = r;
        } data_timeout[19:16];
        field {
            name = "reset_all";
            desc = "Software reset all.";
            sw = rw;
            hw = r;
        } reset_all[24:24];
        field {
            name = "reset_cmd";
            desc = "Reset CMD line.";
            sw = rw;
            hw = r;
        } reset_cmd[25:25];
        field {
            name = "reset_data";
            desc = "Reset DAT line.";
            sw = rw;
            hw = r;
        } reset_data[26:26];
    } CLK_CTRL @ 0x2C;

    reg {
        name = "Normal and error interrupt status";
        desc = "Standard SD Host Controller register (SD Association Simplified Host Controller spec, offsets as used by U-Boot include/sdhci.h and drivers/mmc/sdhci.c). Evidence: INFERRED (public spec + vendor driver use), nothing read from the EV300. ";
        field {
            name = "value";
            desc = "Status bits.";
            sw = rw;
            hw = r;
        } value[31:0];
    } INT_STATUS @ 0x30;

    reg {
        name = "Interrupt status enable";
        desc = "Standard SD Host Controller register (SD Association Simplified Host Controller spec, offsets as used by U-Boot include/sdhci.h and drivers/mmc/sdhci.c). Evidence: INFERRED (public spec + vendor driver use), nothing read from the EV300. ";
        field {
            name = "value";
            desc = "Enable bits.";
            sw = rw;
            hw = r;
        } value[31:0];
    } INT_ENABLE @ 0x34;

    reg {
        name = "Interrupt signal enable";
        desc = "Standard SD Host Controller register (SD Association Simplified Host Controller spec, offsets as used by U-Boot include/sdhci.h and drivers/mmc/sdhci.c). Evidence: INFERRED (public spec + vendor driver use), nothing read from the EV300. ";
        field {
            name = "value";
            desc = "Enable bits.";
            sw = rw;
            hw = r;
        } value[31:0];
    } SIGNAL_ENABLE @ 0x38;

    reg {
        name = "Auto CMD error status and host control 2";
        desc = "Standard SD Host Controller register (SD Association Simplified Host Controller spec, offsets as used by U-Boot include/sdhci.h and drivers/mmc/sdhci.c). Evidence: INFERRED (public spec + vendor driver use), nothing read from the EV300. ";
        field {
            name = "autocmd_err";
            desc = "Auto CMD error status.";
            sw = r;
            hw = w;
        } autocmd_err[15:0];
        field {
            name = "uhs_mode";
            desc = "UHS mode / timing select.";
            sw = rw;
            hw = r;
        } uhs_mode[18:16];
        field {
            name = "signal_1v8";
            desc = "1.8 V signaling.";
            sw = rw;
            hw = r;
        } signal_1v8[19:19];
        field {
            name = "driver_strength";
            desc = "Driver strength.";
            sw = rw;
            hw = r;
        } driver_strength[21:20];
        field {
            name = "exec_tuning";
            desc = "Execute tuning.";
            sw = rw;
            hw = r;
        } exec_tuning[22:22];
        field {
            name = "tuned_clk";
            desc = "Sampling clock select.";
            sw = rw;
            hw = r;
        } tuned_clk[23:23];
        field {
            name = "preset_en";
            desc = "Preset value enable.";
            sw = rw;
            hw = r;
        } preset_en[31:31];
    } AUTOCMD_HOST_CTRL2 @ 0x3C;

    reg {
        name = "Capabilities";
        desc = "Standard SD Host Controller register (SD Association Simplified Host Controller spec, offsets as used by U-Boot include/sdhci.h and drivers/mmc/sdhci.c). Evidence: INFERRED (public spec + vendor driver use), nothing read from the EV300. ";
        field {
            name = "caps";
            desc = "Capability bits.";
            sw = r;
            hw = w;
        } caps[31:0];
    } CAPABILITIES @ 0x40;

    reg {
        name = "Capabilities 1";
        desc = "Standard SD Host Controller register (SD Association Simplified Host Controller spec, offsets as used by U-Boot include/sdhci.h and drivers/mmc/sdhci.c). Evidence: INFERRED (public spec + vendor driver use), nothing read from the EV300. ";
        field {
            name = "caps1";
            desc = "Capability bits.";
            sw = r;
            hw = w;
        } caps1[31:0];
    } CAPABILITIES1 @ 0x44;

    reg {
        name = "ADMA error status";
        desc = "Standard SD Host Controller register (SD Association Simplified Host Controller spec, offsets as used by U-Boot include/sdhci.h and drivers/mmc/sdhci.c). Evidence: INFERRED (public spec + vendor driver use), nothing read from the EV300. ";
        field {
            name = "value";
            desc = "Status.";
            sw = rw;
            hw = r;
        } value[31:0];
    } ADMA_ERROR @ 0x54;

    reg {
        name = "ADMA system address (low)";
        desc = "Standard SD Host Controller register (SD Association Simplified Host Controller spec, offsets as used by U-Boot include/sdhci.h and drivers/mmc/sdhci.c). Evidence: INFERRED (public spec + vendor driver use), nothing read from the EV300. ";
        field {
            name = "value";
            desc = "Address.";
            sw = rw;
            hw = r;
        } value[31:0];
    } ADMA_ADDR @ 0x58;

    reg {
        name = "Slot interrupt status and host version";
        desc = "Standard SD Host Controller register (SD Association Simplified Host Controller spec, offsets as used by U-Boot include/sdhci.h and drivers/mmc/sdhci.c). Evidence: INFERRED (public spec + vendor driver use), nothing read from the EV300. ";
        field {
            name = "slot_int";
            desc = "Slot interrupt status.";
            sw = r;
            hw = w;
        } slot_int[15:0];
        field {
            name = "spec_version";
            desc = "Spec version (2 = v3.00).";
            sw = r;
            hw = w;
        } spec_version[23:16];
    } SLOT_VERSION @ 0xFC;

    reg {
        name = "Vendor MSHC control";
        desc = "Source: vendor U-Boot include/sdhci.h, drivers/mmc/hisi_sdhci.c, hisi_hi3516ev300.c. PROVEN offsets and bits (source, not run).";
        field {
            name = "cmd_conflict_check";
            desc = "Command conflict check; cleared by hisi_mmc_priv_init. PROVEN.";
            sw = rw;
            hw = r;
        } cmd_conflict_check[0:0];
    } MSHC_CTRL @ 0x508;

    reg {
        name = "Vendor AXI master interface control";
        desc = "Source: vendor U-Boot include/sdhci.h, drivers/mmc/hisi_sdhci.c, hisi_hi3516ev300.c. PROVEN offsets and bits (source, not run).";
        field {
            name = "undefl_incr_en";
            desc = "Undefined-length INCR enable; cleared. PROVEN.";
            sw = rw;
            hw = r;
        } undefl_incr_en[0:0];
        field {
            name = "gm_rd_osrc_lmt";
            desc = "Read outstanding limit; set to all ones (SDHCI_GM_RD_OSRC_LMT 0x30000). PROVEN.";
            sw = rw;
            hw = r;
        } gm_rd_osrc_lmt[17:16];
        field {
            name = "gm_wr_osrc_lmt";
            desc = "Write outstanding limit; set to all ones. PROVEN.";
            sw = rw;
            hw = r;
        } gm_wr_osrc_lmt[25:24];
    } AXI_MBIIU_CTRL @ 0x510;

    reg {
        name = "Vendor eMMC control";
        desc = "Source: vendor U-Boot include/sdhci.h, drivers/mmc/hisi_sdhci.c, hisi_hi3516ev300.c. PROVEN offsets and bits (source, not run).";
        field {
            name = "card_is_emmc";
            desc = "Card is eMMC; set for the eMMC port. PROVEN.";
            sw = rw;
            hw = r;
        } card_is_emmc[0:0];
        field {
            name = "enh_strobe_en";
            desc = "Enhanced strobe enable (HS400). PROVEN.";
            sw = rw;
            hw = r;
        } enh_strobe_en[8:8];
    } EMMC_CTRL @ 0x52C;

    reg {
        name = "Vendor tuning control";
        desc = "Source: vendor U-Boot include/sdhci.h, drivers/mmc/hisi_sdhci.c, hisi_hi3516ev300.c. PROVEN offsets and bits (source, not run).";
        field {
            name = "sample_en";
            desc = "Sampling phase enable. PROVEN.";
            sw = rw;
            hw = r;
        } sample_en[4:4];
    } AT_CTRL @ 0x540;

    reg {
        name = "Vendor tuning status / sampling phase";
        desc = "Source: vendor U-Boot include/sdhci.h, drivers/mmc/hisi_sdhci.c, hisi_hi3516ev300.c. PROVEN offsets and bits (source, not run).";
        field {
            name = "phase_sel";
            desc = "Sampling phase select (32 steps). PROVEN.";
            sw = rw;
            hw = r;
        } phase_sel[7:0];
    } AT_STAT @ 0x544;

    reg {
        name = "Vendor multi-cycle control";
        desc = "Source: vendor U-Boot include/sdhci.h, drivers/mmc/hisi_sdhci.c, hisi_hi3516ev300.c. PROVEN offsets and bits (source, not run).";
        field {
            name = "cmd_dly_en";
            desc = "Command delay enable; cleared. PROVEN.";
            sw = rw;
            hw = r;
        } cmd_dly_en[2:2];
        field {
            name = "data_dly_en";
            desc = "Data delay enable; set. PROVEN.";
            sw = rw;
            hw = r;
        } data_dly_en[3:3];
        field {
            name = "dout_en_f_edge";
            desc = "Data output on falling edge. PROVEN position.";
            sw = rw;
            hw = r;
        } dout_en_f_edge[6:6];
        field {
            name = "edge_detect_en";
            desc = "Edge detect enable; set. PROVEN.";
            sw = rw;
            hw = r;
        } edge_detect_en[8:8];
        field {
            name = "found_edge";
            desc = "Edge found. PROVEN position.";
            sw = r;
            hw = w;
        } found_edge[11:11];
    } MULTI_CYCLE @ 0x54C;

};

`endif
