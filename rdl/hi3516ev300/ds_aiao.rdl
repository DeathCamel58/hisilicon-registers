`ifndef HI3516EV300_AIAO_RDL
`define HI3516EV300_AIAO_RDL
regfile eHI3516EV300_AIAO {
    name = "Audio input/output (AIAO)";
    desc = "Audio input/output (AIAO) of the Hi3516E V300 at base 0x100E0000. 31 registers extracted programmatically from the Hi3516E V300 data sheet (Issue 00B06, 2019-05-15) (Table 11-1 Summary of the AIAO registers (base address: 0x100E _0000)): register headings, offsets, total reset values, field bit ranges, access types, names, reset values and descriptions, with PDF page numbers in each register description. Field names, bit ranges, access types and offsets are exact; the free-text descriptions are taken from the cell text of the field table and were checked by sampling only. Hardware not verified.";
    reg {
        name = "AIAO_INT_ENA";
        desc = "AIAO_INT_ENA is an AIAO interrupt enable register. (offset 0x0; total reset 0x00000000; PROVEN: Hi3516E V300 data sheet (Issue 00B06, 2019-05-15), section 11.1.6, PDF page 600).";
        field {
            name = "reserved";
            desc = "Reserved";
            sw = r; hw = w;
            reset = 0x0;
        } reserved_31_17[31:17];
        field {
            name = "tx_ch0_int_ena";
            desc = "TX channel 0 interrupt enable
- 0: disabled
- 1: enabled";
            sw = rw; hw = r;
            reset = 0x0;
        } tx_ch0_int_ena[16:16];
        field {
            name = "reserved";
            desc = "Reserved";
            sw = r; hw = w;
            reset = 0x0;
        } reserved_15_1[15:1];
        field {
            name = "rx_ch0_int_ena";
            desc = "RX channel 0 interrupt enable
- 0: disabled
- 1: enabled";
            sw = rw; hw = r;
            reset = 0x0;
        } rx_ch0_int_ena[0:0];
    } AIAO_INT_ENA @ 0x0;
    reg {
        name = "AIAO_INT_STATUS";
        desc = "AIAO_INT_STATUS is an AIAO interrupt status register. (offset 0x4; total reset 0x00000000; PROVEN: Hi3516E V300 data sheet (Issue 00B06, 2019-05-15), section 11.1.6, PDF page 601).";
        field {
            name = "reserved";
            desc = "Reserved";
            sw = r; hw = w;
            reset = 0x0;
        } reserved_31_17[31:17];
        field {
            name = "tx_ch0_int_status";
            desc = "Interrupt status of TX channel 0
- 0: No interrupt is generated.
- 1: An interrupt is generated.";
            sw = r; hw = w;
            reset = 0x0;
        } tx_ch0_int_status[16:16];
        field {
            name = "reserved";
            desc = "Reserved";
            sw = r; hw = w;
            reset = 0x0;
        } reserved_15_1[15:1];
        field {
            name = "rx_ch0_int_status";
            desc = "Interrupt status of RX channel 0
- 0: No interrupt is generated.
- 1: An interrupt is generated.";
            sw = r; hw = w;
            reset = 0x0;
        } rx_ch0_int_status[0:0];
    } AIAO_INT_STATUS @ 0x4;
    reg {
        name = "AIAO_INT_RAW";
        desc = "AIAO_INT_RAW is an AIAO raw interrupt register. (offset 0x8; total reset 0x00000000; PROVEN: Hi3516E V300 data sheet (Issue 00B06, 2019-05-15), section 11.1.6, PDF page 601).";
        field {
            name = "reserved";
            desc = "Reserved";
            sw = r; hw = w;
            reset = 0x0;
        } reserved_31_17[31:17];
        field {
            name = "tx_ch0_int_raw";
            desc = "Raw interrupt of TX channel 0
- 0: No raw interrupt is generated.
- 1: A raw interrupt is generated.";
            sw = r; hw = w;
            reset = 0x0;
        } tx_ch0_int_raw[16:16];
        field {
            name = "reserved";
            desc = "Reserved";
            sw = r; hw = w;
            reset = 0x0;
        } reserved_15_1[15:1];
        field {
            name = "rx_ch0_int_raw";
            desc = "Raw interrupt of RX channel 0
- 0: No raw interrupt is generated.
- 1: A raw interrupt is generated.";
            sw = r; hw = w;
            reset = 0x0;
        } rx_ch0_int_raw[0:0];
    } AIAO_INT_RAW @ 0x8;
    reg {
        name = "I2S_CRG_CFG0_00";
        desc = "I2S_CRG_CFG0_00 is I2S00 CRG configuration register 0. (offset 0x100; total reset 0x00AAAAAA; PROVEN: Hi3516E V300 data sheet (Issue 00B06, 2019-05-15), section 11.1.6, PDF page 602).";
        field {
            name = "reserved";
            desc = "Reserved";
            sw = r; hw = w;
            reset = 0x0;
        } reserved_31_27[31:27];
        field {
            name = "aiao_mclk_div";
            desc = "Configured value of the frequency division clock of the MCLK. The configured value is calculated as follows: (Target MCLK frequency/PLL frequency of the MCLK clock source) x 2^27. For details about the PLL frequency of the MCLK clock source, see section 3.2 \"Clock\" in chapter 3 \"System\" in the Hi3519 V101 Professional HD IP Camera SoC Data Sheet.";
            sw = rw; hw = r;
            reset = 0xaaaaa;
        } aiao_mclk_div[26:0];
    } I2S_CRG_CFG0_00 @ 0x100;
    reg {
        name = "I2S_CRG_CFG1_00";
        desc = "I2S_CRG_CFG1_00 is I2S00 CRG configuration register 1. (offset 0x104; total reset 0x00000131; PROVEN: Hi3516E V300 data sheet (Issue 00B06, 2019-05-15), section 11.1.6, PDF page 602).";
        field {
            name = "reserved";
            desc = "Reserved";
            sw = r; hw = w;
            reset = 0x0;
        } reserved_31_10[31:10];
        field {
            name = "aiao_srst_req";
            desc = "Independent soft reset request of the RX 0 channel
- 0: deassert reset
- 1: reset";
            sw = rw; hw = r;
            reset = 0x0;
        } aiao_srst_req[9:9];
        field {
            name = "aiao_cken";
            desc = "MCLK/BCLK/WS clock gating for CRG00
- 0: disabled
- 1: enabled";
            sw = rw; hw = r;
            reset = 0x1;
        } aiao_cken[8:8];
        field {
            name = "reserved";
            desc = "Reserved";
            sw = r; hw = w;
            reset = 0x0;
        } reserved_7_7[7:7];
        field {
            name = "aiao_fsclk_div";
            desc = "Frequency division relationship between the bit clock BCLK and the sampling clock FS
- 000: The FS is obtained by dividing the BCLK by 16.
- 001: The FS is obtained by dividing the BCLK by 32.
- 010: The FS is obtained by dividing the BCLK by 48.
- 011: The FS is obtained by dividing the BCLK by 64.
- 100: The FS is obtained by dividing the BCLK";
            sw = rw; hw = r;
            reset = 0x3;
        } aiao_fsclk_div[6:4];
        field {
            name = "FrequencydivisionrelationshipbetweenthemainclockMCLKandthebitclockBCLK0000:TheBCLKisobtainedbydividingtheMCLKby1.0001:TheBCLKisobtainedbydividingtheMCLKby3.0010:TheBCLKisobtainedbydividingtheMCLKby2.0011:TheBCLKisobtainedbydividingtheMCLKby4.0100:TheBCLKisobtainedbydividingtheMCLKby6.0101:TheBCLKisobtainedbydividingtheMCLKby8.aiao_bclk_div0110:TheBCLKisobtainedbydividingtheMCLKby12.0111:TheBCLKisobtainedbydividingtheMCLKby16.1000:TheBCLKisobtainedbydividingtheMCLKby24.1001:TheBCLKisobtainedbydividingtheMCLKby32.1010:TheBCLKisobtainedbydividingtheMCLKby48.1011:TheBCLKisobtainedbydividingtheMCLKby64.Othervalues:TheBCLKisobtainedbydividingtheMCLKby8.";
            desc = "";
            sw = rw; hw = r;
            reset = 0x1;
        } FrequencydivisionrelationshipbetweenthemainclockMCLKandthebitclockBCLK0000_TheBCLKisobtainedbydividingtheMCLKby1_0001_TheBCLKisobtainedbydividingtheMCLKby3_0010_TheBCLKisobtainedbydividingtheMCLKby2_0011_TheBCLKisobtainedbydividingtheMCLKby4_0100_TheBCLKisobtainedbydividingtheMCLKby6_0101_TheBCLKisobtainedbydividingtheMCLKby8_aiao_bclk_div0110_TheBCLKisobtainedbydividingtheMCLKby12_0111_TheBCLKisobtainedbydividingtheMCLKby16_1000_TheBCLKisobtainedbydividingtheMCLKby24_1001_TheBCLKisobtainedbydividingtheMCLKby32_1010_TheBCLKisobtainedbydividingtheMCLKby48_1011_TheBCLKisobtainedbydividingtheMCLKby64_Othervalues_TheBCLKisobtainedbydividingtheMCLKby8[3:0];
    } I2S_CRG_CFG1_00 @ 0x104;
    reg {
        name = "I2S_CRG_CFG0_08";
        desc = "I2S_CRG_CFG0_08 is I2S08 CRG configuration register 0. (offset 0x140; total reset 0x00AAAAAA; PROVEN: Hi3516E V300 data sheet (Issue 00B06, 2019-05-15), section 11.1.6, PDF page 603).";
        field {
            name = "reserved";
            desc = "Reserved";
            sw = r; hw = w;
            reset = 0x0;
        } reserved_31_27[31:27];
        field {
            name = "aiao_mclk_div";
            desc = "Configured value of the frequency division clock of the MCLK. The configured value is";
            sw = rw; hw = r;
            reset = 0xaaaaa;
        } aiao_mclk_div[26:0];
    } I2S_CRG_CFG0_08 @ 0x140;
    reg {
        name = "I2S_CRG_CFG1_08";
        desc = "I2S_CRG_CFG1_08 is I2S08 CRG configuration register 1. (offset 0x144; total reset 0x00000131; PROVEN: Hi3516E V300 data sheet (Issue 00B06, 2019-05-15), section 11.1.6, PDF page 604).";
        field {
            name = "reserved";
            desc = "Reserved";
            sw = r; hw = w;
            reset = 0x0;
        } reserved_31_10[31:10];
        field {
            name = "aiao_srst_req";
            desc = "Independent soft reset request of the TX 0 channel
- 0: deassert reset
- 1: reset";
            sw = rw; hw = r;
            reset = 0x0;
        } aiao_srst_req[9:9];
        field {
            name = "aiao_cken";
            desc = "MCLK/BCLK/WS clock gating for CRG08
- 0: disabled
- 1: enabled";
            sw = rw; hw = r;
            reset = 0x1;
        } aiao_cken[8:8];
        field {
            name = "reserved";
            desc = "Reserved";
            sw = r; hw = w;
            reset = 0x0;
        } reserved_7_7[7:7];
        field {
            name = "aiao_fsclk_div";
            desc = "Frequency division relationship between the bit clock BCLK and the sampling clock FS
- 000: The FS is obtained by dividing the BCLK by 16.
- 001: The FS is obtained by dividing the BCLK by 32.
- 010: The FS is obtained by dividing the BCLK by 48.
- 011: The FS is obtained by dividing the BCLK by 64.
- 100: The FS is obtained by dividing the BCLK by 128.
- 101: The FS is obtained by dividing the BCLK by 256.

Other values: The FS is obtained by dividing the BCLK by 8.";
            sw = rw; hw = r;
            reset = 0x3;
        } aiao_fsclk_div[6:4];
        field {
            name = "aiao_bclk_div";
            desc = "Frequency division relationship between the main clock MCLK and the bit clock BCLK";
            sw = rw; hw = r;
            reset = 0x1;
        } aiao_bclk_div[3:0];
    } I2S_CRG_CFG1_08 @ 0x144;
    reg {
        name = "RX_IF_ATTRI";
        desc = "RX_IF_ATTRI is an interface attribute configuration register for the RX channel. (offset 0x1000; total reset 0xE4000004; PROVEN: Hi3516E V300 data sheet (Issue 00B06, 2019-05-15), section 11.1.6, PDF page 605).";
        field {
            name = "reserved";
            desc = "Reserved";
            sw = r; hw = w;
            reset = 0xe4;
        } reserved_31_24[31:24];
        field {
            name = "rx_sd_source_sel";
            desc = "This bit is set to 0x1000 in normal mode.";
            sw = rw; hw = r;
            reset = 0x0;
        } rx_sd_source_sel[23:20];
        field {
            name = "reserved";
            desc = "Reserved";
            sw = r; hw = w;
            reset = 0x0;
        } reserved_19_19[19:19];
        field {
            name = "rx_trackmode";
            desc = "Audio-left and audio-right channel mode in I2S mode
- 000: The sound is not processed.
- 001: The sounds in two channels are audio-left channel sounds.
- 010: The sounds in two channels are audio-";
            sw = rw; hw = r;
            reset = 0x0;
        } rx_trackmode[18:16];
        field {
            name = "rx_sd_offset";
            desc = "PCM timing mode
- 0x0: left-aligned mode
- 0x1: standard mode

Other values: reserved";
            sw = rw; hw = r;
            reset = 0x0;
        } rx_sd_offset[15:8];
        field {
            name = "reserved";
            desc = "Reserved";
            sw = r; hw = w;
            reset = 0x0;
        } reserved_7_7[7:7];
        field {
            name = "rx_ch_num";
            desc = "Number of RX channels
- 00: 1
- 01: 2

Other values: reserved";
            sw = rw; hw = r;
            reset = 0x0;
        } rx_ch_num[6:4];
        field {
            name = "rx_i2s_precision";
            desc = "Data sampling precision I2S mode:
- 01: 16 bits
- 10: 24 bits

Other values: reserved PCM mode:
- 01: 16 bits

Other values: reserved";
            sw = rw; hw = r;
            reset = 0x1;
        } rx_i2s_precision[3:2];
        field {
            name = "rx_mode";
            desc = "Interface mode of the RX channel
- 00: I2S mode
- 01: PCM mode

Other values: reserved";
            sw = rw; hw = r;
            reset = 0x0;
        } rx_mode[1:0];
    } RX_IF_ATTRI @ 0x1000;
    reg {
        name = "RX_DSP_CTRL";
        desc = "RX_DSP_CTRL is an RX channel control register. (offset 0x1004; total reset 0x20000000; PROVEN: Hi3516E V300 data sheet (Issue 00B06, 2019-05-15), section 11.1.6, PDF page 607).";
        field {
            name = "reserved";
            desc = "Reserved";
            sw = r; hw = w;
            reset = 0x0;
        } reserved_31_30[31:30];
        field {
            name = "rx_disable_done";
            desc = "RX channel disable completion identifier
- 0: not complete
- 0: complete";
            sw = r; hw = w;
            reset = 0x1;
        } rx_disable_done[29:29];
        field {
            name = "rx_enable";
            desc = "RX channel start/stop control bit
- 0: stop
- 1: start";
            sw = rw; hw = r;
            reset = 0x0;
        } rx_enable[28:28];
        field {
            name = "bypass_en";
            desc = "Data processing disable bit. The control function still takes effect after data processing is disabled.
- 0: Data processing is implemented normally.
- 1: Operations such as trackmode are not implemented.";
            sw = rw; hw = r;
            reset = 0x0;
        } bypass_en[27:27];
        field {
            name = "reserved";
            desc = "Reserved";
            sw = r; hw = w;
            reset = 0x0;
        } reserved_26_0[26:0];
    } RX_DSP_CTRL @ 0x1004;
    reg {
        name = "RX_BUFF_SADDR";
        desc = "RX_BUFF_SADDR is a DDR buffer start address register for the RX channel. (offset 0x1080; total reset 0x00000000; PROVEN: Hi3516E V300 data sheet (Issue 00B06, 2019-05-15), section 11.1.6, PDF page 607).";
        field {
            name = "StartaddressfortheDDRbufferofRXchannel0.Itsunitisbyte.rx_buff_saddrThestartaddressmustbe128x8-bit-aligned.";
            desc = "";
            sw = rw; hw = r;
            reset = 0x0;
        } StartaddressfortheDDRbufferofRXchannel0_Itsunitisbyte_rx_buff_saddrThestartaddressmustbe128x8_bit_aligned[31:0];
    } RX_BUFF_SADDR @ 0x1080;
    reg {
        name = "RX_BUFF_SIZE";
        desc = "RX_BUFF_SIZE is a DDR buffer size register for the RX channel. (offset 0x1084; total reset 0x00000000; PROVEN: Hi3516E V300 data sheet (Issue 00B06, 2019-05-15), section 11.1.6, PDF page 607).";
        field {
            name = "reserved";
            desc = "Reserved";
            sw = r; hw = w;
            reset = 0x0;
        } reserved_31_24[31:24];
        field {
            name = "DDRbuffersizeoftheRXchannel.Itsunitisbyte.rx_buff_sizeThebuffersizemustbeanintegralmultipleof128bytes.";
            desc = "";
            sw = rw; hw = r;
            reset = 0x0;
        } DDRbuffersizeoftheRXchannel_Itsunitisbyte_rx_buff_sizeThebuffersizemustbeanintegralmultipleof128bytes[23:0];
    } RX_BUFF_SIZE @ 0x1084;
    reg {
        name = "RX_BUFF_WPTR";
        desc = "RX_BUFF_WPTR is a DDR buffer write address register for the RX channel. (offset 0x1088; total reset 0x00000000; PROVEN: Hi3516E V300 data sheet (Issue 00B06, 2019-05-15), section 11.1.6, PDF page 608).";
        field {
            name = "reserved";
            desc = "Reserved";
            sw = r; hw = w;
            reset = 0x0;
        } reserved_31_24[31:24];
        field {
            name = "rx_buff_wptr";
            desc = "Write address for the DDR buffer of the RX channel. Its unit is byte. The write address in the RX direction is maintained by the logic and is the offset address relative to the start address for the DDR buffer. The write address must be 128x2-bit-aligned.";
            sw = rw; hw = r;
            reset = 0x0;
        } rx_buff_wptr[23:0];
    } RX_BUFF_WPTR @ 0x1088;
    reg {
        name = "RX_BUFF_RPTR";
        desc = "RX_BUFF_RPTR is a DDR buffer read address register for the RX channel. (offset 0x108C; total reset 0x00000000; PROVEN: Hi3516E V300 data sheet (Issue 00B06, 2019-05-15), section 11.1.6, PDF page 608).";
        field {
            name = "reserved";
            desc = "Reserved";
            sw = r; hw = w;
            reset = 0x0;
        } reserved_31_24[31:24];
        field {
            name = "rx_buff_rptr";
            desc = "Read address for the DDR buffer of the RX channel. Its unit is byte. The read address in the RX direction is maintained by the logic and is the offset address relative to the start address for the DDR buffer. The software operation is performed by byte, and the hardware operation is performed based on 128 x 2-bit alignment.";
            sw = rw; hw = r;
            reset = 0x0;
        } rx_buff_rptr[23:0];
    } RX_BUFF_RPTR @ 0x108C;
    reg {
        name = "RX_BUFF_ALFULL_TH";
        desc = "RX_BUFF_ALFULL_TH is a DDR buffer almost full threshold register for the RX channel. (offset 0x1090; total reset 0x00000000; PROVEN: Hi3516E V300 data sheet (Issue 00B06, 2019-05-15), section 11.1.6, PDF page 609).";
        field {
            name = "reserved";
            desc = "Reserved";
            sw = r; hw = w;
            reset = 0x0;
        } reserved_31_24[31:24];
        field {
            name = "rx_buff_alfull_th";
            desc = "Almost full threshold for the DDR buffer of the RX channel. Its unit is byte. If the available space of the DDR buffer is below the almost full threshold, the almost full raw interrupt is generated. If the rx_alfull_int interrupt is used, the field value must be an integral multiple of 16 bytes and greater than or equal to 0x40.";
            sw = rw; hw = r;
            reset = 0x0;
        } rx_buff_alfull_th[23:0];
    } RX_BUFF_ALFULL_TH @ 0x1090;
    reg {
        name = "RX_TRANS_SIZE";
        desc = "RX_TRANS_SIZE is data transfer length register for the RX interrupt. (offset 0x1094; total reset 0x00000000; PROVEN: Hi3516E V300 data sheet (Issue 00B06, 2019-05-15), section 11.1.6, PDF page 609).";
        field {
            name = "reserved";
            desc = "Reserved";
            sw = r; hw = w;
            reset = 0x0;
        } reserved_31_24[31:24];
        field {
            name = "rx_trans_size";
            desc = "After the RX channel receives the audio data with the length of rx_trans_size (in byte), a transfer completion interrupt is generated.";
            sw = rw; hw = r;
            reset = 0x0;
        } rx_trans_size[23:0];
    } RX_TRANS_SIZE @ 0x1094;
    reg {
        name = "RX_INT_ENA";
        desc = "RX_INT_ENA is an interrupt enable register for the RX channel. (offset 0x10A0; total reset 0x00000000; PROVEN: Hi3516E V300 data sheet (Issue 00B06, 2019-05-15), section 11.1.6, PDF page 609).";
        field {
            name = "reserved";
            desc = "Reserved";
            sw = r; hw = w;
            reset = 0x0;
        } reserved_31_8[31:8];
        field {
            name = "rx_if_full_lost_int_ena";
            desc = "Interface data full loss raw interrupt enable for the RX channel
- 0: disabled
- 1: enabled";
            sw = rw; hw = r;
            reset = 0x0;
        } rx_if_full_lost_int_ena[7:7];
        field {
            name = "reserved";
            desc = "Reserved";
            sw = r; hw = w;
            reset = 0x0;
        } reserved_6_6[6:6];
        field {
            name = "rx_stop_int_ena";
            desc = "Stop interrupt enable for the RX channel
- 0: disabled
- 1: enabled";
            sw = rw; hw = r;
            reset = 0x0;
        } rx_stop_int_ena[5:5];
        field {
            name = "reserved";
            desc = "Reserved";
            sw = r; hw = w;
            reset = 0x0;
        } reserved_4_4[4:4];
        field {
            name = "rx_bfifo_full_int_ena";
            desc = "Bus fifo overflow interrupt enable for the RX channel
- 0: disabled
- 1: enabled";
            sw = rw; hw = r;
            reset = 0x0;
        } rx_bfifo_full_int_ena[3:3];
        field {
            name = "rx_alfull_int_ena";
            desc = "DDR buffer almost full interrupt enable for the RX channel
- 0: disabled
- 1: enabled";
            sw = rw; hw = r;
            reset = 0x0;
        } rx_alfull_int_ena[2:2];
        field {
            name = "rx_full_int_ena";
            desc = "DDR buffer full interrupt for the RX channel
- 0: disabled
- 1: enabled";
            sw = rw; hw = r;
            reset = 0x0;
        } rx_full_int_ena[1:1];
        field {
            name = "rx_trans_int_ena";
            desc = "Transfer completion interrupt enable for the RX channel
- 0: disabled
- 1: enabled";
            sw = rw; hw = r;
            reset = 0x0;
        } rx_trans_int_ena[0:0];
    } RX_INT_ENA @ 0x10A0;
    reg {
        name = "RX_INT_RAW";
        desc = "RX_INT_RAW is a raw interrupt register for the RX channel. (offset 0x10A4; total reset 0x00000000; PROVEN: Hi3516E V300 data sheet (Issue 00B06, 2019-05-15), section 11.1.6, PDF page 610).";
        field {
            name = "reserved";
            desc = "Reserved";
            sw = r; hw = w;
            reset = 0x0;
        } reserved_31_8[31:8];
        field {
            name = "rx_if_full_lost_int_raw";
            desc = "Data full lost raw interrupt of the RX channel
- 0: No raw interrupt is generated.
- 1: A raw interrupt is generated.";
            sw = r; hw = w;
            reset = 0x0;
        } rx_if_full_lost_int_raw[7:7];
        field {
            name = "reserved";
            desc = "Reserved";
            sw = r; hw = w;
            reset = 0x0;
        } reserved_6_6[6:6];
        field {
            name = "rx_stop_int_raw";
            desc = "Stop raw interrupt of the RX channel
- 0: No raw interrupt is generated.
- 1: A raw interrupt is generated.";
            sw = r; hw = w;
            reset = 0x0;
        } rx_stop_int_raw[5:5];
        field {
            name = "reserved";
            desc = "Reserved";
            sw = r; hw = w;
            reset = 0x0;
        } reserved_4_4[4:4];
        field {
            name = "rx_bfifo_full_int_raw";
            desc = "Bus FIFO overflow raw interrupt of the RX channel";
            sw = r; hw = w;
            reset = 0x0;
        } rx_bfifo_full_int_raw[3:3];
        field {
            name = "DDRbufferalmostfullrawinterruptoftheRXchannelrx_alfull_int_raw0:Norawinterruptisgenerated.1:Arawinterruptisgenerated.";
            desc = "";
            sw = r; hw = w;
            reset = 0x0;
        } DDRbufferalmostfullrawinterruptoftheRXchannelrx_alfull_int_raw0_Norawinterruptisgenerated_1_Arawinterruptisgenerated[2:2];
        field {
            name = "DDRbufferfullrawinterruptoftheRXchannelrx_full_int_raw0:Norawinterruptisgenerated.1:Arawinterruptisgenerated.";
            desc = "";
            sw = r; hw = w;
            reset = 0x0;
        } DDRbufferfullrawinterruptoftheRXchannelrx_full_int_raw0_Norawinterruptisgenerated_1_Arawinterruptisgenerated[1:1];
        field {
            name = "TransfercompletionrawinterruptoftheRXinterruptrx_trans_int_raw0:Norawinterruptisgenerated.1:Arawinterruptisgenerated.";
            desc = "";
            sw = r; hw = w;
            reset = 0x0;
        } TransfercompletionrawinterruptoftheRXinterruptrx_trans_int_raw0_Norawinterruptisgenerated_1_Arawinterruptisgenerated[0:0];
    } RX_INT_RAW @ 0x10A4;
    reg {
        name = "RX_INT_STATUS";
        desc = "RX_INT_STATUS is an interrupt status register for the RX channel. (offset 0x10A8; total reset 0x00000000; PROVEN: Hi3516E V300 data sheet (Issue 00B06, 2019-05-15), section 11.1.6, PDF page 611).";
        field {
            name = "reserved";
            desc = "Reserved";
            sw = r; hw = w;
            reset = 0x0;
        } reserved_31_8[31:8];
        field {
            name = "tx_if_full_lost_int_status";
            desc = "Status of the data full loss interrupt of the TX channel
- 0: No interrupt is generated.
- 1: An interrupt is generated.";
            sw = r; hw = w;
            reset = 0x0;
        } tx_if_full_lost_int_status[7:7];
        field {
            name = "reserved";
            desc = "Reserved";
            sw = r; hw = w;
            reset = 0x0;
        } reserved_6_6[6:6];
        field {
            name = "rx_stop_int_status";
            desc = "Status of the stop interrupt of the RX interrupt
- 0: No interrupt is generated.
- 1: An interrupt is generated.";
            sw = r; hw = w;
            reset = 0x0;
        } rx_stop_int_status[5:5];
        field {
            name = "reserved";
            desc = "Reserved";
            sw = r; hw = w;
            reset = 0x0;
        } reserved_4_4[4:4];
        field {
            name = "rx_bfifo_full_int_status";
            desc = "Status of the bus fifo overflow interrupt of the RC channel
- 0: No interrupt is generated.
- 1: An interrupt is generated.";
            sw = r; hw = w;
            reset = 0x0;
        } rx_bfifo_full_int_status[3:3];
        field {
            name = "rx_alfull_int_status";
            desc = "Status of the DDR buffer almost full interrupt of the RX channel
- 0: No interrupt is generated.";
            sw = r; hw = w;
            reset = 0x0;
        } rx_alfull_int_status[2:2];
        field {
            name = "StatusoftheDDRbufferfullinterruptoftheRXinterruptrx_full_int_status0:Nointerruptisgenerated.1:Aninterruptisgenerated.";
            desc = "";
            sw = r; hw = w;
            reset = 0x0;
        } StatusoftheDDRbufferfullinterruptoftheRXinterruptrx_full_int_status0_Nointerruptisgenerated_1_Aninterruptisgenerated[1:1];
        field {
            name = "StatusofthetransfercompletioninterruptoftheRXchannelrx_trans_int_status0:Nointerruptisgenerated.1:Aninterruptisgenerated.";
            desc = "";
            sw = r; hw = w;
            reset = 0x0;
        } StatusofthetransfercompletioninterruptoftheRXchannelrx_trans_int_status0_Nointerruptisgenerated_1_Aninterruptisgenerated[0:0];
    } RX_INT_STATUS @ 0x10A8;
    reg {
        name = "RX_INT_CLR";
        desc = "RX_INT_CLR is an interrupt clear register for the RX channel. (offset 0x10AC; total reset 0x00000000; PROVEN: Hi3516E V300 data sheet (Issue 00B06, 2019-05-15), section 11.1.6, PDF page 612).";
        field {
            name = "reserved";
            desc = "Reserved";
            sw = r; hw = w;
            reset = 0x0;
        } reserved_31_8[31:8];
        field {
            name = "tx_if_full_lost_int_clear";
            desc = "Data full loss interrupt clear for the TX channel
- 0: not cleared
- 1: cleared

Access type WC in the data sheet: written 1 clears the bit.";
            sw = rw; hw = w; onwrite = woclr;
            reset = 0x0;
        } tx_if_full_lost_int_clear[7:7];
        field {
            name = "reserved";
            desc = "Reserved";
            sw = r; hw = w;
            reset = 0x0;
        } reserved_6_6[6:6];
        field {
            name = "rx_stop_int_clear";
            desc = "Stop interrupt clear for the RX channel
- 0: not cleared
- 1: cleared

Access type WC in the data sheet: written 1 clears the bit.";
            sw = rw; hw = w; onwrite = woclr;
            reset = 0x0;
        } rx_stop_int_clear[5:5];
        field {
            name = "reserved";
            desc = "Reserved";
            sw = r; hw = w;
            reset = 0x0;
        } reserved_4_4[4:4];
        field {
            name = "rx_bfifo_full_int_clear";
            desc = "Bus fifo overflow interrupt clear for the RX channel
- 0: not cleared
- 1: cleared

Access type WC in the data sheet: written 1 clears the bit.";
            sw = rw; hw = w; onwrite = woclr;
            reset = 0x0;
        } rx_bfifo_full_int_clear[3:3];
        field {
            name = "rx_alfull_int_clear";
            desc = "DDR buffer almost full interrupt clear for the RX channel
- 0: not cleared
- 1: cleared

Access type WC in the data sheet: written 1 clears the bit.";
            sw = rw; hw = w; onwrite = woclr;
            reset = 0x0;
        } rx_alfull_int_clear[2:2];
        field {
            name = "rx_full_int_clear";
            desc = "DDR buffer full interrupt clear for the RX channel
- 0: not cleared
- 1: cleared

Access type WC in the data sheet: written 1 clears the bit.";
            sw = rw; hw = w; onwrite = woclr;
            reset = 0x0;
        } rx_full_int_clear[1:1];
        field {
            name = "TransfercompletioninterruptclearfortheRXinterruptrx_trans_int_clear0:notcleared1:cleared";
            desc = "";
            sw = w; hw = r;
            reset = 0x0;
        } TransfercompletioninterruptclearfortheRXinterruptrx_trans_int_clear0_notcleared1_cleared[0:0];
    } RX_INT_CLR @ 0x10AC;
    reg {
        name = "TX_IF_ATTRI";
        desc = "TX_IF_ATTRI is an interface attribute configuration register for the TX channel. (offset 0x2000; total reset 0xE4000004; PROVEN: Hi3516E V300 data sheet (Issue 00B06, 2019-05-15), section 11.1.6, PDF page 613).";
        field {
            name = "reserved";
            desc = "Reserved";
            sw = r; hw = w;
            reset = 0x400;
        } reserved_31_19[31:19];
        field {
            name = "tx_trackmode";
            desc = "Audio-left and audio-right channel mode in I2S mode
- 000: The sound is not processed.
- 001: The sounds in two channels are audio-left channel sounds.
- 010: The sounds in two channels are audio- right channel sounds.
- 011: The sounds in two channels are exchanged.
- 100: The sounds of two channels are added and then output.
- 101: The audio-left channel is muted, and the sound of the audio-right channel is from the original audio-right channel.
- 110: The audio-right channel is muted, and the sound of the audio-left channel is from the original audio-left channel.
- 111: The audio-left and audio-right channels are muted. tx_trackmode is still valid in 1-channel TX mode.";
            sw = rw; hw = r;
            reset = 0x0;
        } tx_trackmode[18:16];
        field {
            name = "tx_sd_offset";
            desc = "PCM timing mode
- 0x0: left-aligned mode
- 0x1: standard mode

Other values: reserved";
            sw = rw; hw = r;
            reset = 0x0;
        } tx_sd_offset[15:8];
        field {
            name = "reserved";
            desc = "Reserved";
            sw = r; hw = w;
            reset = 0x0;
        } reserved_7_6[7:6];
        field {
            name = "tx_ch_num";
            desc = "Select of the TX channel
- 00: Data is transmitted by one audio channel.";
            sw = rw; hw = r;
            reset = 0x0;
        } tx_ch_num[5:4];
        field {
            name = "DatasamplingprecisionI2Smode:01:16bits10:24bitstx_i2s_precisionOthervalues:reservedPCMmode:01:16bitsOthervalues:reserved";
            desc = "";
            sw = rw; hw = r;
            reset = 0x1;
        } DatasamplingprecisionI2Smode_01_16bits10_24bitstx_i2s_precisionOthervalues_reservedPCMmode_01_16bitsOthervalues_reserved[3:2];
        field {
            name = "InterfacemodeoftheTXchannel00:I2Smodetx_mode01:PCMmodeOthervalues:reserved";
            desc = "";
            sw = rw; hw = r;
            reset = 0x0;
        } InterfacemodeoftheTXchannel00_I2Smodetx_mode01_PCMmodeOthervalues_reserved[1:0];
    } TX_IF_ATTRI @ 0x2000;
    reg {
        name = "TX_DSP_CTRL";
        desc = "TX_DSP_CTRL is a TX channel control register. (offset 0x2004; total reset 0x20000000; PROVEN: Hi3516E V300 data sheet (Issue 00B06, 2019-05-15), section 11.1.6, PDF page 614).";
        field {
            name = "reserved";
            desc = "Reserved";
            sw = r; hw = w;
            reset = 0x0;
        } reserved_31_30[31:30];
        field {
            name = "tx_disable_done";
            desc = "TX channel disable completion identifier
- 0: not complete
- 1: complete";
            sw = r; hw = w;
            reset = 0x1;
        } tx_disable_done[29:29];
        field {
            name = "tx_enable";
            desc = "TX channel start/stop control bit
- 0: stop
- 1: start";
            sw = rw; hw = r;
            reset = 0x0;
        } tx_enable[28:28];
        field {
            name = "bypass_en";
            desc = "Data processing disable bit. The control function still takes effect after data processing is disabled.
- 0: Data processing is implemented normally.
- 1: Operations such as trackmode and volume processing are not implemented.";
            sw = rw; hw = r;
            reset = 0x0;
        } bypass_en[27:27];
        field {
            name = "reserved";
            desc = "Reserved";
            sw = r; hw = w;
            reset = 0x0;
        } reserved_26_24[26:24];
        field {
            name = "fade_out_rate";
            desc = "Fade-out rate
- 0000: The fade-out rate changes every one";
            sw = rw; hw = r;
            reset = 0x0;
        } fade_out_rate[23:20];
        field {
            name = "fade_in_rate";
            desc = "Fade-in rate
- 0000: The fade-in rate changes every one sampling point.
- 0001: The fade-in rate changes every two sampling points.
- 0010: The fade-in rate changes every four sampling points.
- 0011: The fade-in rate changes every eight sampling points.
- 0100: The fade-in rate changes every 16 sampling points.
- 0101: The fade-in rate changes every 32 sampling points.
- 0110: The fade-in rate changes every 64 sampling points.
- 0111: The fade-in rate changes every 128 sampling points.

Other values: reserved";
            sw = rw; hw = r;
            reset = 0x0;
        } fade_in_rate[19:16];
        field {
            name = "reserved";
            desc = "Reserved";
            sw = r; hw = w;
            reset = 0x0;
        } reserved_15_15[15:15];
        field {
            name = "volume";
            desc = "Volume. The volume is incremented by 1 dB when the field value is incremented by 1. 0x00-0x28: mute
- 0x29: -80 dB
- 0x2A: -79 dB …
- 0x75: -4 dB
- 0x77: -2 dB";
            sw = rw; hw = r;
            reset = 0x0;
        } volume[14:8];
        field {
            name = "reserved";
            desc = "Reserved.";
            sw = r; hw = w;
            reset = 0x0;
        } reserved_7_2[7:2];
        field {
            name = "mute_fade_en";
            desc = "Mute fade-in/fade-out control
- 0: disabled
- 1: enabled";
            sw = rw; hw = r;
            reset = 0x0;
        } mute_fade_en[1:1];
        field {
            name = "mute_en";
            desc = "Mute control
- 0: not muted
- 1: muted";
            sw = rw; hw = r;
            reset = 0x0;
        } mute_en[0:0];
    } TX_DSP_CTRL @ 0x2004;
    reg {
        name = "TX_BUFF_SADDR";
        desc = "TX_BUFF_SADDR is a DDR buffer start address register for the TX channel. (offset 0x2080; total reset 0x00000000; PROVEN: Hi3516E V300 data sheet (Issue 00B06, 2019-05-15), section 11.1.6, PDF page 616).";
        field {
            name = "StartaddressfortheDDRbufferoftheTXchannel.Itsunitisbyte.tx_buff_saddrThestartaddressmustbe128x8-bit-aligned.";
            desc = "";
            sw = rw; hw = r;
            reset = 0x0;
        } StartaddressfortheDDRbufferoftheTXchannel_Itsunitisbyte_tx_buff_saddrThestartaddressmustbe128x8_bit_aligned[31:0];
    } TX_BUFF_SADDR @ 0x2080;
    reg {
        name = "TX_BUFF_SIZE";
        desc = "TX_BUFF_SIZE is a DDR buffer size register for the TX channel. (offset 0x2084; total reset 0x00000000; PROVEN: Hi3516E V300 data sheet (Issue 00B06, 2019-05-15), section 11.1.6, PDF page 616).";
        field {
            name = "reserved";
            desc = "Reserved";
            sw = r; hw = w;
            reset = 0x0;
        } reserved_31_24[31:24];
        field {
            name = "tx_buff_size";
            desc = "DDR buffer size of the TX channel. Its unit is byte. The buffer size must be an integral multiple of 128 bytes.";
            sw = rw; hw = r;
            reset = 0x0;
        } tx_buff_size[23:0];
    } TX_BUFF_SIZE @ 0x2084;
    reg {
        name = "TX_BUFF_WPTR";
        desc = "TX_BUFF_WPTR is a DDR buffer write address register for the TX channel. (offset 0x2088; total reset 0x00000000; PROVEN: Hi3516E V300 data sheet (Issue 00B06, 2019-05-15), section 11.1.6, PDF page 617).";
        field {
            name = "reserved";
            desc = "Reserved";
            sw = r; hw = w;
            reset = 0x0;
        } reserved_31_24[31:24];
        field {
            name = "tx_buff_wptr";
            desc = "Write address for the DDR buffer of the TX channel The write address in the TX direction is maintained by the logic and is the offset address relative to the start address for the DDR buffer. The available space of the TX buffer must be greater than or equal to 128 bytes. The software operation is performed by byte, and the hardware operation is performed by 128 x 2 bytes.";
            sw = rw; hw = r;
            reset = 0x0;
        } tx_buff_wptr[23:0];
    } TX_BUFF_WPTR @ 0x2088;
    reg {
        name = "TX_BUFF_RPTR";
        desc = "TX_BUFF_RPTR is a DDR buffer read address register for the TX channel. (offset 0x208C; total reset 0x00000000; PROVEN: Hi3516E V300 data sheet (Issue 00B06, 2019-05-15), section 11.1.6, PDF page 617).";
        field {
            name = "reserved";
            desc = "Reserved";
            sw = r; hw = w;
            reset = 0x0;
        } reserved_31_24[31:24];
        field {
            name = "tx_buff_rptr";
            desc = "Read address for the DDR buffer of the TX channel The read address in the TX direction is maintained by the logic and is the offset address relative to the start address for the DDR buffer. The address must be 128x2-bit-aligned.";
            sw = rw; hw = r;
            reset = 0x0;
        } tx_buff_rptr[23:0];
    } TX_BUFF_RPTR @ 0x208C;
    reg {
        name = "TX_BUFF_ALEMPTY_TH";
        desc = "TX_BUFF_ALEMPTY_TH is a DDR buffer almost empty threshold register for the TX channel. (offset 0x2090; total reset 0x00000000; PROVEN: Hi3516E V300 data sheet (Issue 00B06, 2019-05-15), section 11.1.6, PDF page 617).";
        field {
            name = "reserved";
            desc = "Reserved";
            sw = r; hw = w;
            reset = 0x0;
        } reserved_31_24[31:24];
        field {
            name = "AlmostemptythresholdfortheDDRbufferoftheTXchannel.Itsunitisbyte.IftheavailablespaceoftheDDRbufferisbelowthealmostemptythreshold,thealmostemptyrawinterruptisgenerated.tx_buff_alempty_thIfthetx_alempty_intinterruptisused,thefieldvaluemustbeanintegralmultipleof16bytesandgreaterthanorequalto0x20.";
            desc = "";
            sw = rw; hw = r;
            reset = 0x0;
        } AlmostemptythresholdfortheDDRbufferoftheTXchannel_Itsunitisbyte_IftheavailablespaceoftheDDRbufferisbelowthealmostemptythreshold_thealmostemptyrawinterruptisgenerated_tx_buff_alempty_thIfthetx_alempty_intinterruptisused_thefieldvaluemustbeanintegralmultipleof16bytesandgreaterthanorequalto0x20[23:0];
    } TX_BUFF_ALEMPTY_TH @ 0x2090;
    reg {
        name = "TX_TRANS_SIZE";
        desc = "TX_TRANS_SIZE is a data transfer length register for the TX channel. (offset 0x2094; total reset 0x00000000; PROVEN: Hi3516E V300 data sheet (Issue 00B06, 2019-05-15), section 11.1.6, PDF page 618).";
        field {
            name = "reserved";
            desc = "Reserved";
            sw = r; hw = w;
            reset = 0x0;
        } reserved_31_24[31:24];
        field {
            name = "tx_trans_size";
            desc = "After the TX channel transmits the audio data with the length of tx_trans_size (in byte), a transfer completion interrupt is generated.";
            sw = rw; hw = r;
            reset = 0x0;
        } tx_trans_size[23:0];
    } TX_TRANS_SIZE @ 0x2094;
    reg {
        name = "TX_INT_ENA";
        desc = "TX_INT_ENA is an interrupt enable register for the TX channel. (offset 0x20A0; total reset 0x00000000; PROVEN: Hi3516E V300 data sheet (Issue 00B06, 2019-05-15), section 11.1.6, PDF page 618).";
        field {
            name = "reserved";
            desc = "Reserved";
            sw = r; hw = w;
            reset = 0x0;
        } reserved_31_8[31:8];
        field {
            name = "tx_dat_break_int_ena";
            desc = "Interface data break interrupt enable for the TX channel
- 0: No raw interrupt is generated.
- 1: A raw interrupt is generated.";
            sw = rw; hw = r;
            reset = 0x0;
        } tx_dat_break_int_ena[7:7];
        field {
            name = "tx_mfade_int_ena";
            desc = "Mute fade-in/fade-output completion interrupt enable for the TX channel
- 0: disabled
- 1: enabled";
            sw = rw; hw = r;
            reset = 0x0;
        } tx_mfade_int_ena[6:6];
        field {
            name = "tx_stop_int_ena";
            desc = "Stop interrupt enable for the TX channel
- 0: disabled
- 1: enabled";
            sw = rw; hw = r;
            reset = 0x0;
        } tx_stop_int_ena[5:5];
        field {
            name = "InterfacefifounderflowinterruptenablefortheTXchanneltx_ififo_empty_int_ena0:disabled1:enabled";
            desc = "";
            sw = rw; hw = r;
            reset = 0x0;
        } InterfacefifounderflowinterruptenablefortheTXchanneltx_ififo_empty_int_ena0_disabled1_enabled[4:4];
        field {
            name = "BusfifounderflowinterruptenablefortheTXchanneltx_bfifo_empty_int_ena0:disabled1:enabled";
            desc = "";
            sw = rw; hw = r;
            reset = 0x0;
        } BusfifounderflowinterruptenablefortheTXchanneltx_bfifo_empty_int_ena0_disabled1_enabled[3:3];
        field {
            name = "DDRbufferalmostemptyinterruptenablefortheTXchanneltx_alempty_int_ena0:disabled1:enabled";
            desc = "";
            sw = rw; hw = r;
            reset = 0x0;
        } DDRbufferalmostemptyinterruptenablefortheTXchanneltx_alempty_int_ena0_disabled1_enabled[2:2];
        field {
            name = "DDRbufferemptyinterruptfortheTXchanneltx_empty_int_ena0:disabled1:enabled";
            desc = "";
            sw = rw; hw = r;
            reset = 0x0;
        } DDRbufferemptyinterruptfortheTXchanneltx_empty_int_ena0_disabled1_enabled[1:1];
        field {
            name = "TransfercompletioninterruptenablefortheTXchanneltx_trans_int_ena0:disabled1:enabled";
            desc = "";
            sw = rw; hw = r;
            reset = 0x0;
        } TransfercompletioninterruptenablefortheTXchanneltx_trans_int_ena0_disabled1_enabled[0:0];
    } TX_INT_ENA @ 0x20A0;
    reg {
        name = "TX_INT_RAW";
        desc = "TX_INT_RAW is a raw interrupt register for the TX channel. (offset 0x20A4; total reset 0x00000000; PROVEN: Hi3516E V300 data sheet (Issue 00B06, 2019-05-15), section 11.1.6, PDF page 619).";
        field {
            name = "reserved";
            desc = "Reserved";
            sw = r; hw = w;
            reset = 0x0;
        } reserved_31_8[31:8];
        field {
            name = "tx_dat_break_int_raw";
            desc = "Interface data break raw interrupt of the TX channel
- 0: No raw interrupt is generated.
- 1: A raw interrupt is generated.";
            sw = r; hw = w;
            reset = 0x0;
        } tx_dat_break_int_raw[7:7];
        field {
            name = "tx_mfade_int_raw";
            desc = "Mute fade-in/fade-output completion raw interrupt of the TX channel
- 0: No raw interrupt is generated.
- 1: A raw interrupt is generated.";
            sw = r; hw = w;
            reset = 0x0;
        } tx_mfade_int_raw[6:6];
        field {
            name = "tx_stop_int_raw";
            desc = "Stop raw interrupt of the TX channel
- 0: No raw interrupt is generated.";
            sw = r; hw = w;
            reset = 0x0;
        } tx_stop_int_raw[5:5];
        field {
            name = "InterfacefifounderflowrawinterruptoftheTXchanneltx_ififo_empty_int_raw0:Norawinterruptisgenerated.1:Arawinterruptisgenerated.";
            desc = "";
            sw = r; hw = w;
            reset = 0x0;
        } InterfacefifounderflowrawinterruptoftheTXchanneltx_ififo_empty_int_raw0_Norawinterruptisgenerated_1_Arawinterruptisgenerated[4:4];
        field {
            name = "BusfifounderflowrawinterruptoftheTXchanneltx_bfifo_empty_int_raw0:Norawinterruptisgenerated.1:Arawinterruptisgenerated.";
            desc = "";
            sw = r; hw = w;
            reset = 0x0;
        } BusfifounderflowrawinterruptoftheTXchanneltx_bfifo_empty_int_raw0_Norawinterruptisgenerated_1_Arawinterruptisgenerated[3:3];
        field {
            name = "DDRbufferalmostemptyrawinterruptoftheTXchanneltx_alempty_int_raw0:Norawinterruptisgenerated.1:Arawinterruptisgenerated.";
            desc = "";
            sw = r; hw = w;
            reset = 0x0;
        } DDRbufferalmostemptyrawinterruptoftheTXchanneltx_alempty_int_raw0_Norawinterruptisgenerated_1_Arawinterruptisgenerated[2:2];
        field {
            name = "DDRbufferemptyrawinterruptoftheTXchanneltx_empty_int_raw0:Norawinterruptisgenerated.1:Arawinterruptisgenerated.";
            desc = "";
            sw = r; hw = w;
            reset = 0x0;
        } DDRbufferemptyrawinterruptoftheTXchanneltx_empty_int_raw0_Norawinterruptisgenerated_1_Arawinterruptisgenerated[1:1];
        field {
            name = "TransfercompletionrawinterruptoftheTXchanneltx_trans_int_raw0:Norawinterruptisgenerated.1:Arawinterruptisgenerated.";
            desc = "";
            sw = r; hw = w;
            reset = 0x0;
        } TransfercompletionrawinterruptoftheTXchanneltx_trans_int_raw0_Norawinterruptisgenerated_1_Arawinterruptisgenerated[0:0];
    } TX_INT_RAW @ 0x20A4;
    reg {
        name = "TX_INT_STATUS";
        desc = "TX_INT_STATUS is an interrupt status register for the TX channel. (offset 0x20A8; total reset 0x00000000; PROVEN: Hi3516E V300 data sheet (Issue 00B06, 2019-05-15), section 11.1.6, PDF page 620).";
        field {
            name = "reserved";
            desc = "Reserved";
            sw = r; hw = w;
            reset = 0x0;
        } reserved_31_8[31:8];
        field {
            name = "tx_dat_break_int_status";
            desc = "Status of the interface data break interrupt of the TX channel
- 0: No interrupt is generated.
- 1: An interrupt is generated.";
            sw = r; hw = w;
            reset = 0x0;
        } tx_dat_break_int_status[7:7];
        field {
            name = "tx_mfade_int_status";
            desc = "Status of the mute fade-in/fade-output completion interrupt of the TX channel
- 0: No interrupt is generated.
- 1: An interrupt is generated.";
            sw = r; hw = w;
            reset = 0x0;
        } tx_mfade_int_status[6:6];
        field {
            name = "tx_stop_int_status";
            desc = "Status of the stop interrupt of the TX interrupt";
            sw = r; hw = w;
            reset = 0x0;
        } tx_stop_int_status[5:5];
        field {
            name = "StatusoftheinterfaceFIFOunderflowinterruptoftheTXchanneltx_ififo_empty_int_status0:Nointerruptisgenerated.1:Aninterruptisgenerated.";
            desc = "";
            sw = r; hw = w;
            reset = 0x0;
        } StatusoftheinterfaceFIFOunderflowinterruptoftheTXchanneltx_ififo_empty_int_status0_Nointerruptisgenerated_1_Aninterruptisgenerated[4:4];
        field {
            name = "StatusofthebusFIFOunderflowinterruptoftheTXchanneltx_bfifo_empty_int_status0:Nointerruptisgenerated.1:Aninterruptisgenerated.";
            desc = "";
            sw = r; hw = w;
            reset = 0x0;
        } StatusofthebusFIFOunderflowinterruptoftheTXchanneltx_bfifo_empty_int_status0_Nointerruptisgenerated_1_Aninterruptisgenerated[3:3];
        field {
            name = "DDRbufferalmostemptyinterruptoftheTXchanneltx_alempty_int_status0:Nointerruptisgenerated.1:Aninterruptisgenerated.";
            desc = "";
            sw = r; hw = w;
            reset = 0x0;
        } DDRbufferalmostemptyinterruptoftheTXchanneltx_alempty_int_status0_Nointerruptisgenerated_1_Aninterruptisgenerated[2:2];
        field {
            name = "StatusoftheDDRbufferemptyinterruptoftheTXchanneltx_empty_int_status0:Nointerruptisgenerated.1:Aninterruptisgenerated.";
            desc = "";
            sw = r; hw = w;
            reset = 0x0;
        } StatusoftheDDRbufferemptyinterruptoftheTXchanneltx_empty_int_status0_Nointerruptisgenerated_1_Aninterruptisgenerated[1:1];
        field {
            name = "StatusofthetransfercompletioninterruptoftheTXchanneltx_trans_int_status0:Nointerruptisgenerated.1:Aninterruptisgenerated.";
            desc = "";
            sw = r; hw = w;
            reset = 0x0;
        } StatusofthetransfercompletioninterruptoftheTXchanneltx_trans_int_status0_Nointerruptisgenerated_1_Aninterruptisgenerated[0:0];
    } TX_INT_STATUS @ 0x20A8;
    reg {
        name = "TX_INT_CLR";
        desc = "TX_INT_CLR is an interrupt clear register for the TX channel. (offset 0x20AC; total reset 0x00000000; PROVEN: Hi3516E V300 data sheet (Issue 00B06, 2019-05-15), section 11.1.6, PDF page 621).";
        field {
            name = "reserved";
            desc = "Reserved";
            sw = r; hw = w;
            reset = 0x0;
        } reserved_31_8[31:8];
        field {
            name = "tx_dat_break_int_clear";
            desc = "Interface data break interrupt clear for the TX channel
- 0: No raw interrupt is generated.
- 1: A raw interrupt is generated.";
            sw = r; hw = w;
            reset = 0x0;
        } tx_dat_break_int_clear[7:7];
        field {
            name = "tx_mfade_int_clear";
            desc = "Mute fade-in/fade-output completion interrupt clear for the TX channel
- 0: not cleared
- 1: cleared

Access type WC in the data sheet: written 1 clears the bit.";
            sw = rw; hw = w; onwrite = woclr;
            reset = 0x0;
        } tx_mfade_int_clear[6:6];
        field {
            name = "tx_stop_int_clear";
            desc = "Stop interrupt clear for the TX channel
- 0: not cleared
- 1: cleared

Access type WC in the data sheet: written 1 clears the bit.";
            sw = rw; hw = w; onwrite = woclr;
            reset = 0x0;
        } tx_stop_int_clear[5:5];
        field {
            name = "tx_ififo_empty_int_clear";
            desc = "Interface fifo underflow interrupt clear for the TX channel
- 0: not cleared
- 1: cleared

Access type WC in the data sheet: written 1 clears the bit.";
            sw = rw; hw = w; onwrite = woclr;
            reset = 0x0;
        } tx_ififo_empty_int_clear[4:4];
        field {
            name = "tx_bfifo_empty_int_clear";
            desc = "Bus fifo underflow interrupt clear for the TX channel
- 0: not cleared
- 1: cleared

Access type WC in the data sheet: written 1 clears the bit.";
            sw = rw; hw = w; onwrite = woclr;
            reset = 0x0;
        } tx_bfifo_empty_int_clear[3:3];
        field {
            name = "tx_alempty_int_clear";
            desc = "DDR buffer almost empty interrupt clear for the TX channel
- 0: not cleared
- 1: cleared

Access type WC in the data sheet: written 1 clears the bit.";
            sw = rw; hw = w; onwrite = woclr;
            reset = 0x0;
        } tx_alempty_int_clear[2:2];
        field {
            name = "tx_empty_int_clear";
            desc = "DDR buffer empty interrupt clear for the RX channel
- 0: not cleared
- 1: cleared

Access type WC in the data sheet: written 1 clears the bit.";
            sw = rw; hw = w; onwrite = woclr;
            reset = 0x0;
        } tx_empty_int_clear[1:1];
        field {
            name = "tx_trans_int_clear";
            desc = "Transfer completion interrupt clear for the TX channel
- 0: not cleared
- 1: cleared

Access type WC in the data sheet: written 1 clears the bit.";
            sw = rw; hw = w; onwrite = woclr;
            reset = 0x0;
        } tx_trans_int_clear[0:0];
    } TX_INT_CLR @ 0x20AC;
};
`endif
