`ifndef HI3516EV300_VDP_RDL
`define HI3516EV300_VDP_RDL
regfile eHI3516EV300_VDP {
    name = "Video display processor (VDP)";
    desc = "Video display processor (VDP) of the Hi3516E V300 at base 0x11280000. 63 registers extracted programmatically from the Hi3516E V300 data sheet (Issue 00B06, 2019-05-15) (Table 9-3 Summary of VDP registers (base address: 0x1128)): register headings, offsets, total reset values, field bit ranges, access types, names, reset values and descriptions, with PDF page numbers in each register description. Field names, bit ranges, access types and offsets are exact; the free-text descriptions are taken from the cell text of the field table and were checked by sampling only. Hardware not verified.";
    reg {
        name = "VOCTRL";
        desc = "VOCTRL is a VDP control register. (offset 0x0; total reset 0x00000000; PROVEN: Hi3516E V300 data sheet (Issue 00B06, 2019-05-15), section 9.2.6, PDF page 474).";
        field {
            name = "vo_ck_gt_en";
            desc = "VDP clock gating enable, that is, low power consumption mode
- 0: disabled
- 1: enabled";
            sw = rw; hw = r;
            reset = 0x0;
        } vo_ck_gt_en[31:31];
        field {
            name = "reserved";
            desc = "Reserved";
            sw = r; hw = w;
            reset = 0x0;
        } reserved_30_0[30:0];
    } VOCTRL @ 0x0;
    reg {
        name = "VOINTSTA";
        desc = "VOINTSTA is a VDP interrupt status register. (offset 0x4; total reset 0x00000044; PROVEN: Hi3516E V300 data sheet (Issue 00B06, 2019-05-15), section 9.2.6, PDF page 474).";
        field {
            name = "reserved";
            desc = "Reserved";
            sw = r; hw = w;
            reset = 0x0;
        } reserved_31_4[31:4];
        field {
            name = "dhd0uf_int";
            desc = "HD0 low-bandwidth alarm interrupt
- 0: No interrupt is reported.
- 1: An interrupt is reported.";
            sw = r; hw = w;
            reset = 0x0;
        } dhd0uf_int[3:3];
        field {
            name = "reserved";
            desc = "Reserved";
            sw = r; hw = w;
            reset = 0x1;
        } reserved_2_2[2:2];
        field {
            name = "reserved";
            desc = "Reserved";
            sw = r; hw = w;
            reset = 0x0;
        } reserved_1_1[1:1];
        field {
            name = "dhd0vtthd1_int";
            desc = "HD0 vertical timing interrupt 1
- 0: No interrupt is reported.
- 1: An interrupt is reported.";
            sw = r; hw = w;
            reset = 0x0;
        } dhd0vtthd1_int[0:0];
    } VOINTSTA @ 0x4;
    reg {
        name = "VOMSKINTSTA";
        desc = "VOMSKINTSTA is a VO masked interrupt status register. Writing 1 clears this register. (offset 0x8; total reset 0x00000000; PROVEN: Hi3516E V300 data sheet (Issue 00B06, 2019-05-15), section 9.2.6, PDF page 475).";
        field {
            name = "reserved";
            desc = "Reserved";
            sw = r; hw = w;
            reset = 0x0;
        } reserved_31_4[31:4];
        field {
            name = "dhd0uf_clr";
            desc = "HD0 low-bandwidth alarm interrupt
- 0: No interrupt is reported.
- 1: An interrupt is reported.

Access type WC in the data sheet: written 1 clears the bit.";
            sw = rw; hw = w; onwrite = woclr;
            reset = 0x0;
        } dhd0uf_clr[3:3];
        field {
            name = "reserved";
            desc = "Reserved";
            sw = r; hw = w;
            reset = 0x0;
        } reserved_2_2[2:2];
        field {
            name = "reserved";
            desc = "Reserved";
            sw = r; hw = w;
            reset = 0x0;
        } reserved_1_1[1:1];
        field {
            name = "dhd0vtthd1_clr";
            desc = "HD0 vertical timing interrupt 1
- 0: No interrupt is reported.
- 1: An interrupt is reported.

Access type WC in the data sheet: written 1 clears the bit.";
            sw = rw; hw = w; onwrite = woclr;
            reset = 0x0;
        } dhd0vtthd1_clr[0:0];
    } VOMSKINTSTA @ 0x8;
    reg {
        name = "VOINTMSK";
        desc = "VOINTMSK is a VDP interrupt mask register. It corresponds to VOINTSTA. When the corresponding bit is set to 1, the interrupt is enabled; when the corresponding bit is set to 0, the interrupt is masked. (offset 0xC; total reset 0x00000000; PROVEN: Hi3516E V300 data sheet (Issue 00B06, 2019-05-15), section 9.2.6, PDF page 475).";
        field {
            name = "reserved";
            desc = "Reserved";
            sw = r; hw = w;
            reset = 0x0;
        } reserved_31_4[31:4];
        field {
            name = "dhd0uf_intmask";
            desc = "Mask for the HD0 low-bandwidth alarm interrupt
- 0: masked
- 1: enabled";
            sw = rw; hw = r;
            reset = 0x0;
        } dhd0uf_intmask[3:3];
        field {
            name = "reserved";
            desc = "Reserved";
            sw = r; hw = w;
            reset = 0x0;
        } reserved_2_2[2:2];
        field {
            name = "reserved";
            desc = "Reserved";
            sw = r; hw = w;
            reset = 0x0;
        } reserved_1_1[1:1];
        field {
            name = "dhd0vtthd1_intmask";
            desc = "Mask for the HD0 vertical timing interrupt 1
- 0: masked
- 1: enabled";
            sw = rw; hw = r;
            reset = 0x0;
        } dhd0vtthd1_intmask[0:0];
    } VOINTMSK @ 0xC;
    reg {
        name = "VOINTSTA1";
        desc = "VOINTSTA1 is a VDP interrupt status register 1. (offset 0x14; total reset 0x00000044; PROVEN: Hi3516E V300 data sheet (Issue 00B06, 2019-05-15), section 9.2.6, PDF page 476).";
        field {
            name = "reserved";
            desc = "Reserved";
            sw = r; hw = w;
            reset = 0x0;
        } reserved_31_4[31:4];
        field {
            name = "dhd0uf_int";
            desc = "HD0 low-bandwidth alarm interrupt
- 0: No interrupt is reported.
- 1: An interrupt is reported.";
            sw = r; hw = w;
            reset = 0x0;
        } dhd0uf_int[3:3];
        field {
            name = "reserved";
            desc = "Reserved";
            sw = r; hw = w;
            reset = 0x1;
        } reserved_2_2[2:2];
        field {
            name = "reserved";
            desc = "Reserved";
            sw = r; hw = w;
            reset = 0x0;
        } reserved_1_1[1:1];
        field {
            name = "dhd0vtthd1_int";
            desc = "HD0 vertical timing interrupt 1
- 0: No interrupt is reported.
- 1: An interrupt is reported.";
            sw = r; hw = w;
            reset = 0x0;
        } dhd0vtthd1_int[0:0];
    } VOINTSTA1 @ 0x14;
    reg {
        name = "VOMSKINTSTA1";
        desc = "VOMSKINTSTA1 is a VDP masked offline interrupt status register 1. Writing 1 clears this register. (offset 0x18; total reset 0x00000000; PROVEN: Hi3516E V300 data sheet (Issue 00B06, 2019-05-15), section 9.2.6, PDF page 476).";
        field {
            name = "reserved";
            desc = "Reserved";
            sw = r; hw = w;
            reset = 0x0;
        } reserved_31_4[31:4];
        field {
            name = "dhd0uf_clr";
            desc = "HD0 low-bandwidth alarm interrupt
- 0: No interrupt is reported.
- 1: An interrupt is reported.

Access type WC in the data sheet: written 1 clears the bit.";
            sw = rw; hw = w; onwrite = woclr;
            reset = 0x0;
        } dhd0uf_clr[3:3];
        field {
            name = "reserved";
            desc = "Reserved";
            sw = r; hw = w;
            reset = 0x0;
        } reserved_2_2[2:2];
        field {
            name = "reserved";
            desc = "Reserved";
            sw = r; hw = w;
            reset = 0x0;
        } reserved_1_1[1:1];
        field {
            name = "dhd0vtthd1_clr";
            desc = "HD0 vertical timing interrupt 1
- 0: No interrupt is reported.
- 1: An interrupt is reported.

Access type WC in the data sheet: written 1 clears the bit.";
            sw = rw; hw = w; onwrite = woclr;
            reset = 0x0;
        } dhd0vtthd1_clr[0:0];
    } VOMSKINTSTA1 @ 0x18;
    reg {
        name = "VOINTMSK1";
        desc = "VOINTMSK1 is a VDP interrupt mask register 1. It corresponds to VOINTSTA. (offset 0x1C; total reset 0x00000000; PROVEN: Hi3516E V300 data sheet (Issue 00B06, 2019-05-15), section 9.2.6, PDF page 476).";
        field {
            name = "reserved";
            desc = "Reserved";
            sw = r; hw = w;
            reset = 0x0;
        } reserved_31_4[31:4];
        field {
            name = "dhd0uf_intmask";
            desc = "Mask for the HD0 low-bandwidth alarm interrupt
- 0: masked
- 1: enabled";
            sw = rw; hw = r;
            reset = 0x0;
        } dhd0uf_intmask[3:3];
        field {
            name = "reserved";
            desc = "Reserved";
            sw = r; hw = w;
            reset = 0x0;
        } reserved_2_2[2:2];
        field {
            name = "reserved";
            desc = "Reserved";
            sw = r; hw = w;
            reset = 0x0;
        } reserved_1_1[1:1];
        field {
            name = "dhd0vtthd1_intmask";
            desc = "Mask for the HD0 vertical timing interrupt 1
- 0: masked
- 1: enabled";
            sw = rw; hw = r;
            reset = 0x0;
        } dhd0vtthd1_intmask[0:0];
    } VOINTMSK1 @ 0x1C;
    reg {
        name = "CBM_BKG1";
        desc = "CBM_BKG1 is a CBM mixer 1 overlay background color register. (offset 0x300; total reset 0x00000000; PROVEN: Hi3516E V300 data sheet (Issue 00B06, 2019-05-15), section 9.2.6, PDF page 477).";
        field {
            name = "reserved";
            desc = "Reserved";
            sw = r; hw = w;
            reset = 0x0;
        } reserved_31_30[31:30];
        field {
            name = "cbm_bkgy1";
            desc = "Overlay background color of CBM mixer 1, Y component";
            sw = rw; hw = r;
            reset = 0x0;
        } cbm_bkgy1[29:20];
        field {
            name = "cbm_bkgcb1";
            desc = "Overlay background color of CBM mixer 1, Cb component";
            sw = rw; hw = r;
            reset = 0x0;
        } cbm_bkgcb1[19:10];
        field {
            name = "cbm_bkgcr1";
            desc = "Overlay background color of CBM mixer 1, Cr component";
            sw = rw; hw = r;
            reset = 0x0;
        } cbm_bkgcr1[9:0];
    } CBM_BKG1 @ 0x300;
    reg {
        name = "CBM_MIX1";
        desc = "CBM_MIX2 is a CBM mixer 1 priority configuration register (instant register). The register configuration takes effect only when the vsync signal is valid. mixer_prio_x is overlay layer priority x. (offset 0x308; total reset 0x00000001; PROVEN: Hi3516E V300 data sheet (Issue 00B06, 2019-05-15), section 9.2.6, PDF page 477).";
        field {
            name = "reserved";
            desc = "Reserved";
            sw = r; hw = w;
            reset = 0x0;
        } reserved_31_8[31:8];
        field {
            name = "mixer_prio1";
            desc = "Drive layer of CBM mixer 1 with priority 1
- 0x0: no drive layer
- 0x1: V0";
            sw = rw; hw = r;
            reset = 0x0;
        } mixer_prio1[7:4];
        field {
            name = "mixer_prio0";
            desc = "Drive layer of CBM mixer 1 with priority 0
- 0x0: no drive layer
- 0x1: V0
- 0x2: G0

Other values: reserved";
            sw = rw; hw = r;
            reset = 0x1;
        } mixer_prio0[3:0];
    } CBM_MIX1 @ 0x308;
    reg {
        name = "V0_CTRL";
        desc = "V0_CTRL is a V0 configuration register (non-instant register). (offset 0x1000; total reset 0x400000FF; PROVEN: Hi3516E V300 data sheet (Issue 00B06, 2019-05-15), section 9.2.6, PDF page 478).";
        field {
            name = "surface_en";
            desc = "Surface enable (non-instant)
- 0: disabled
- 1: enabled";
            sw = rw; hw = r;
            reset = 0x0;
        } surface_en[31:31];
        field {
            name = "reserved";
            desc = "Reserved";
            sw = r; hw = w;
            reset = 0x1;
        } reserved_30_30[30:30];
        field {
            name = "reserved";
            desc = "Reserved";
            sw = r; hw = w;
            reset = 0x0;
        } reserved_29_8[29:8];
        field {
            name = "galpha";
            desc = "Overlay global alpha value. The value ranges from 0 to 255. The value 255 indicates opaque, and the value 0 indicates completely transparent.";
            sw = rw; hw = r;
            reset = 0xff;
        } galpha[7:0];
    } V0_CTRL @ 0x1000;
    reg {
        name = "V0_UPD";
        desc = "V0_UPD is a V0 channel update enable register. (offset 0x1004; total reset 0x00000000; PROVEN: Hi3516E V300 data sheet (Issue 00B06, 2019-05-15), section 9.2.6, PDF page 478).";
        field {
            name = "reserved";
            desc = "Reserved";
            sw = r; hw = w;
            reset = 0x0;
        } reserved_31_1[31:1];
        field {
            name = "regup";
            desc = "Surface register update. After the registers at this layer are configured, the registers are updated when the value 1 is written to this bit. After the registers are updated, this bit is automatically cleared by the hardware.

Access type WC in the data sheet: written 1 clears the bit.";
            sw = rw; hw = w; onwrite = woclr;
            reset = 0x0;
        } regup[0:0];
    } V0_UPD @ 0x1004;
    reg {
        name = "V0_0RESO_READ";
        desc = "V0_0RESO_READ is a V0 output resolution read register. (offset 0x1008; total reset 0x00000000; PROVEN: Hi3516E V300 data sheet (Issue 00B06, 2019-05-15), section 9.2.6, PDF page 479).";
        field {
            name = "oh";
            desc = "Height (in lines). The configured value is the actual height minus 1. The frame height is referenced and its unit is line.";
            sw = r; hw = w;
            reset = 0x0;
        } oh[31:16];
        field {
            name = "ow";
            desc = "Width (in pixels). The configured value is the actual width minus 1. The frame width is referenced and its unit is column.";
            sw = r; hw = w;
            reset = 0x0;
        } ow[15:0];
    } V0_0RESO_READ @ 0x1008;
    reg {
        name = "V0_DFPOS";
        desc = "V0_DFPOS is a V0 surface first position (in the display window) register (non-instant register). The unit of the position is pixel. (offset 0x1080; total reset 0x00000000; PROVEN: Hi3516E V300 data sheet (Issue 00B06, 2019-05-15), section 9.2.6, PDF page 479).";
        field {
            name = "disp_yfpos";
            desc = "Start coordinates of the display row The frame height is referenced and its unit is line.";
            sw = rw; hw = r;
            reset = 0x0;
        } disp_yfpos[31:16];
        field {
            name = "disp_xfpos";
            desc = "Start coordinates of the display column The frame width is referenced and its unit is column.";
            sw = rw; hw = r;
            reset = 0x0;
        } disp_xfpos[15:0];
    } V0_DFPOS @ 0x1080;
    reg {
        name = "V0_DLPOS";
        desc = "V0_DLPOS is a V0 surface last position (in the display window) register (non-instant register). The unit of the position is pixel. (offset 0x1084; total reset 0x00000000; PROVEN: Hi3516E V300 data sheet (Issue 00B06, 2019-05-15), section 9.2.6, PDF page 479).";
        field {
            name = "disp_ylpos";
            desc = "End coordinates of the display row The frame height is referenced and its unit is line.";
            sw = rw; hw = r;
            reset = 0x0;
        } disp_ylpos[31:16];
        field {
            name = "disp_xlpos";
            desc = "End coordinates of the display column The frame width is referenced and its unit is column.";
            sw = rw; hw = r;
            reset = 0x0;
        } disp_xlpos[15:0];
    } V0_DLPOS @ 0x1084;
    reg {
        name = "V0_VFPOS";
        desc = "V0_VFPOS is a V0 surface content first position (in the display window) register (non-instant register). The unit of the position is pixel. (offset 0x1088; total reset 0x00000000; PROVEN: Hi3516E V300 data sheet (Issue 00B06, 2019-05-15), section 9.2.6, PDF page 480).";
        field {
            name = "video_yfpos";
            desc = "Start coordinates of the video row The frame height is referenced and its unit is line.";
            sw = rw; hw = r;
            reset = 0x0;
        } video_yfpos[31:16];
        field {
            name = "video_xfpos";
            desc = "Start coordinates of the video column The frame width is referenced and its unit is column.";
            sw = rw; hw = r;
            reset = 0x0;
        } video_xfpos[15:0];
    } V0_VFPOS @ 0x1088;
    reg {
        name = "V0_VLPOS";
        desc = "V0_VLPOS is a V0 surface content last position (in the display window) register (non-instant register). The unit of the position is pixel. (offset 0x108C; total reset 0x00000000; PROVEN: Hi3516E V300 data sheet (Issue 00B06, 2019-05-15), section 9.2.6, PDF page 480).";
        field {
            name = "video_ylpos";
            desc = "End coordinates of the video row The frame height is referenced and its unit is line.";
            sw = rw; hw = r;
            reset = 0x0;
        } video_ylpos[31:16];
        field {
            name = "video_xlpos";
            desc = "End coordinates of the video column The frame width is referenced and its unit is column.";
            sw = rw; hw = r;
            reset = 0x0;
        } video_xlpos[15:0];
    } V0_VLPOS @ 0x108C;
    reg {
        name = "V0_BK";
        desc = "V0_BK is a surface background color register. (offset 0x1090; total reset 0x00000000; PROVEN: Hi3516E V300 data sheet (Issue 00B06, 2019-05-15), section 9.2.6, PDF page 480).";
        field {
            name = "reserved";
            desc = "Reserved";
            sw = r; hw = w;
            reset = 0x0;
        } reserved_31_30[31:30];
        field {
            name = "vbk_y";
            desc = "Y component";
            sw = rw; hw = r;
            reset = 0x0;
        } vbk_y[29:20];
        field {
            name = "vbk_cb";
            desc = "Cb component";
            sw = rw; hw = r;
            reset = 0x0;
        } vbk_cb[19:10];
        field {
            name = "vbk_cr";
            desc = "Cr component";
            sw = rw; hw = r;
            reset = 0x0;
        } vbk_cr[9:0];
    } V0_BK @ 0x1090;
    reg {
        name = "V0_ALPHA";
        desc = "V0_ALPHA is a surface background filling color alpha register. (offset 0x1094; total reset 0x00000000; PROVEN: Hi3516E V300 data sheet (Issue 00B06, 2019-05-15), section 9.2.6, PDF page 481).";
        field {
            name = "reserved";
            desc = "Reserved";
            sw = r; hw = w;
            reset = 0x0;
        } reserved_31_8[31:8];
        field {
            name = "vbk_alpha";
            desc = "Level 0-255 of the surface background filling color";
            sw = rw; hw = r;
            reset = 0x0;
        } vbk_alpha[7:0];
    } V0_ALPHA @ 0x1094;
    reg {
        name = "G0_CTRL";
        desc = "G0_CTRL is a G0 configuration register (non-instant register). (offset 0x7000; total reset 0x400000FF; PROVEN: Hi3516E V300 data sheet (Issue 00B06, 2019-05-15), section 9.2.6, PDF page 481).";
        field {
            name = "surface_en";
            desc = "Surface enable (non-instant)
- 0: disabled
- 1: enabled";
            sw = rw; hw = r;
            reset = 0x0;
        } surface_en[31:31];
        field {
            name = "reserved";
            desc = "Reserved";
            sw = r; hw = w;
            reset = 0x1;
        } reserved_30_30[30:30];
        field {
            name = "reserved";
            desc = "Reserved";
            sw = r; hw = w;
            reset = 0x0;
        } reserved_29_8[29:8];
        field {
            name = "galpha";
            desc = "Overlay global alpha value. The value ranges from 0 to 255. The value 255 indicates opaque, and the value 0 indicates completely transparent.";
            sw = rw; hw = r;
            reset = 0xff;
        } galpha[7:0];
    } G0_CTRL @ 0x7000;
    reg {
        name = "G0_UPD";
        desc = "G0_UPD is a G0 update enable register. (offset 0x7004; total reset 0x00000000; PROVEN: Hi3516E V300 data sheet (Issue 00B06, 2019-05-15), section 9.2.6, PDF page 481).";
        field {
            name = "reserved";
            desc = "Reserved";
            sw = r; hw = w;
            reset = 0x0;
        } reserved_31_1[31:1];
        field {
            name = "regup";
            desc = "Surface register update. After the registers at this layer are configured, the registers are updated when the value 1 is written to this bit. After updates, this bit is automatically cleared by the hardware.

Access type WC in the data sheet: written 1 clears the bit.";
            sw = rw; hw = w; onwrite = woclr;
            reset = 0x0;
        } regup[0:0];
    } G0_UPD @ 0x7004;
    reg {
        name = "G0_0RESO_READ";
        desc = "G0_0RESO_READ is a G0 output resolution register. (offset 0x700C; total reset 0x0000077F; PROVEN: Hi3516E V300 data sheet (Issue 00B06, 2019-05-15), section 9.2.6, PDF page 482).";
        field {
            name = "oh";
            desc = "Height (in lines). The configured value is the actual height minus 1. The frame height is referenced and its unit is line.";
            sw = r; hw = w;
            reset = 0x0;
        } oh[31:16];
        field {
            name = "ow";
            desc = "Width (in pixels). The configured value is the actual width minus 1. The frame width is referenced and its unit is column.";
            sw = r; hw = w;
            reset = 0x77f;
        } ow[15:0];
    } G0_0RESO_READ @ 0x700C;
    reg {
        name = "G0_DFPOS";
        desc = "G0_DFPOS is a G0 surface first position (in the display window) register (non-instant register). The unit of the position is pixel. (offset 0x7080; total reset 0x00000000; PROVEN: Hi3516E V300 data sheet (Issue 00B06, 2019-05-15), section 9.2.6, PDF page 482).";
        field {
            name = "disp_yfpos";
            desc = "Start coordinates of the display row The frame height is referenced and its unit is line.";
            sw = rw; hw = r;
            reset = 0x0;
        } disp_yfpos[31:16];
        field {
            name = "disp_xfpos";
            desc = "Start coordinates of the display column The frame width is referenced and its unit is column.";
            sw = rw; hw = r;
            reset = 0x0;
        } disp_xfpos[15:0];
    } G0_DFPOS @ 0x7080;
    reg {
        name = "G0_DLPOS";
        desc = "G0_DLPOS is a G0 surface last position (in the display window) register (non-instant register). The position unit is pixel. (offset 0x7084; total reset 0x00000000; PROVEN: Hi3516E V300 data sheet (Issue 00B06, 2019-05-15), section 9.2.6, PDF page 482).";
        field {
            name = "disp_ylpos";
            desc = "End coordinates of the display row The frame height is referenced and its unit is line.";
            sw = rw; hw = r;
            reset = 0x0;
        } disp_ylpos[31:16];
        field {
            name = "disp_xlpos";
            desc = "End coordinates of the display column The frame width is referenced and its unit is column.";
            sw = rw; hw = r;
            reset = 0x0;
        } disp_xlpos[15:0];
    } G0_DLPOS @ 0x7084;
    reg {
        name = "G0_VFPOS";
        desc = "G0_VFPOS is a G0 surface content first position (in the display window) register (non-instant register). The unit of the position is pixel. (offset 0x7088; total reset 0x00000000; PROVEN: Hi3516E V300 data sheet (Issue 00B06, 2019-05-15), section 9.2.6, PDF page 483).";
        field {
            name = "video_yfpos";
            desc = "Start coordinates of the video row The frame height is referenced and its unit is line.";
            sw = rw; hw = r;
            reset = 0x0;
        } video_yfpos[31:16];
        field {
            name = "video_xfpos";
            desc = "Start coordinates of the video column The frame width is referenced and its unit is column.";
            sw = rw; hw = r;
            reset = 0x0;
        } video_xfpos[15:0];
    } G0_VFPOS @ 0x7088;
    reg {
        name = "G0_VLPOS";
        desc = "G0_VLPOS is a G0 surface content end position (in the display window) register (non-instant register). The unit of the position is pixel. (offset 0x708C; total reset 0x00000000; PROVEN: Hi3516E V300 data sheet (Issue 00B06, 2019-05-15), section 9.2.6, PDF page 483).";
        field {
            name = "video_ylpos";
            desc = "End coordinates of the video row The frame height is referenced and its unit is line.";
            sw = rw; hw = r;
            reset = 0x0;
        } video_ylpos[31:16];
        field {
            name = "video_xlpos";
            desc = "End coordinates of the video column The frame width is referenced and its unit is column.";
            sw = rw; hw = r;
            reset = 0x0;
        } video_xlpos[15:0];
    } G0_VLPOS @ 0x708C;
    reg {
        name = "G0_BK";
        desc = "G0_BK is a G0 background color register. (offset 0x7090; total reset 0x00000000; PROVEN: Hi3516E V300 data sheet (Issue 00B06, 2019-05-15), section 9.2.6, PDF page 483).";
        field {
            name = "reserved";
            desc = "Reserved";
            sw = r; hw = w;
            reset = 0x0;
        } reserved_31_30[31:30];
        field {
            name = "vbk_y";
            desc = "Y component";
            sw = rw; hw = r;
            reset = 0x0;
        } vbk_y[29:20];
        field {
            name = "vbk_cb";
            desc = "Cb component";
            sw = rw; hw = r;
            reset = 0x0;
        } vbk_cb[19:10];
        field {
            name = "vbk_cr";
            desc = "Cr component";
            sw = rw; hw = r;
            reset = 0x0;
        } vbk_cr[9:0];
    } G0_BK @ 0x7090;
    reg {
        name = "G0_ALPHA";
        desc = "G0_ALPHA is a G0 background filling color alpha register. (offset 0x7094; total reset 0x00000000; PROVEN: Hi3516E V300 data sheet (Issue 00B06, 2019-05-15), section 9.2.6, PDF page 484).";
        field {
            name = "reserved";
            desc = "Reserved";
            sw = r; hw = w;
            reset = 0x0;
        } reserved_31_8[31:8];
        field {
            name = "vbk_alpha";
            desc = "Level 0-255 of the background filling color of the graphics layer";
            sw = rw; hw = r;
            reset = 0x0;
        } vbk_alpha[7:0];
    } G0_ALPHA @ 0x7094;
    reg {
        name = "DHD0_CTRL";
        desc = "DHD0_CTRL is a DHD0 global control register. You must configure all bits of this register before configuring DHD0_CTRL.regup. Otherwise, the configuration does not take effect. (offset 0xD000; total reset 0x00000000; PROVEN: Hi3516E V300 data sheet (Issue 00B06, 2019-05-15), section 9.2.6, PDF page 484).";
        field {
            name = "intf_en";
            desc = "Display interface enable
- 0: disabled
- 1: enabled";
            sw = rw; hw = r;
            reset = 0x0;
        } intf_en[31:31];
        field {
            name = "cbar_en";
            desc = "Color bar enable. The color bar is output over the interface when this field is enabled.
- 0: disabled
- 1: enabled";
            sw = rw; hw = r;
            reset = 0x0;
        } cbar_en[30:30];
        field {
            name = "cbar_sel";
            desc = "Color space select for the output color bar (instant)
- 0: VGA
- 1: YPbPr";
            sw = rw; hw = r;
            reset = 0x0;
        } cbar_sel[29:29];
        field {
            name = "reserved";
            desc = "Reserved";
            sw = r; hw = w;
            reset = 0x0;
        } reserved_28_1[28:1];
        field {
            name = "regup";
            desc = "DHD0 register update. After the registers at this layer are configured, the registers are updated when the value 1 is written to this bit. After the registers are updated, this bit is automatically cleared by the hardware.

Access type WC in the data sheet: written 1 clears the bit.";
            sw = rw; hw = w; onwrite = woclr;
            reset = 0x0;
        } regup[0:0];
    } DHD0_CTRL @ 0xD000;
    reg {
        name = "DHD0_VSYNC1";
        desc = "DHD0_VSYNC1 is a DHD0 vertical timing control register. In interlaced output mode, this register indicates top field vertical sync timing. In progressive output mode, this register indicates frame vertical sync timing. This register is a non-instant register. (offset 0xD004; total reset 0x00280437; PROVEN: Hi3516E V300 data sheet (Issue 00B06, 2019-05-15), section 9.2.6, PDF page 485).";
        field {
            name = "vbb";
            desc = "In interlaced output mode: top vertical back blanking (TVBB) In progressive output mode: vertical back blanking (VBB) + vertical pulse width (VPW)";
            sw = rw; hw = r;
            reset = 0x28;
        } vbb[31:16];
        field {
            name = "vact";
            desc = "In interlaced output mode: height of an active image on the top field In progressive output mode: height of an active image in a frame. The configured value is the actual value minus 1.";
            sw = rw; hw = r;
            reset = 0x437;
        } vact[15:0];
    } DHD0_VSYNC1 @ 0xD004;
    reg {
        name = "DHD0_VSYNC2";
        desc = "DHD0_VSYNC2 is a DHD0 vertical timing control register. In interlaced output mode, this register indicates top field vertical sync timing. In progressive output mode, this register indicates frame vertical sync timing. This register is a non-instant register. (offset 0xD008; total reset 0x00000003; PROVEN: Hi3516E V300 data sheet (Issue 00B06, 2019-05-15), section 9.2.6, PDF page 485).";
        field {
            name = "reserved";
            desc = "Reserved";
            sw = r; hw = w;
            reset = 0x0;
        } reserved_31_16[31:16];
        field {
            name = "vfb";
            desc = "In interlaced output mode: top vertical front blanking (TVFB) In progressive output mode: vertical front blanking (VFB)";
            sw = rw; hw = r;
            reset = 0x3;
        } vfb[15:0];
    } DHD0_VSYNC2 @ 0xD008;
    reg {
        name = "DHD0_HSYNC1";
        desc = "DHD0_HSYNC1 is a DHD0 horizontal timing control register 1 (non-instant register). The register has the horizontal sync function in interlaced or progressive output mode. (offset 0xD00C; total reset 0x00BF077F; PROVEN: Hi3516E V300 data sheet (Issue 00B06, 2019-05-15), section 9.2.6, PDF page 485).";
        field {
            name = "hbb";
            desc = "Horizontal back blanking (HBB), in pixels";
            sw = rw; hw = r;
            reset = 0xbf;
        } hbb[31:16];
        field {
            name = "hact";
            desc = "Number of horizontal pixels in an active region";
            sw = rw; hw = r;
            reset = 0x77f;
        } hact[15:0];
    } DHD0_HSYNC1 @ 0xD00C;
    reg {
        name = "DHD0_HSYNC2";
        desc = "DHD0_HSYNC2 is a DHD0 horizontal timing control register 2 (non-instant register). The register has the horizontal sync function in interlaced or progressive output mode. (offset 0xD010; total reset 0x00000057; PROVEN: Hi3516E V300 data sheet (Issue 00B06, 2019-05-15), section 9.2.6, PDF page 486).";
        field {
            name = "hmid";
            desc = "Active pixel for the bottom field vertical sync (active video region)";
            sw = rw; hw = r;
            reset = 0x0;
        } hmid[31:16];
        field {
            name = "hfb";
            desc = "HFB, in pixels";
            sw = rw; hw = r;
            reset = 0x57;
        } hfb[15:0];
    } DHD0_HSYNC2 @ 0xD010;
    reg {
        name = "DHD0_VPLUS1";
        desc = "DHD0_VPLUS1 is a DHD0 bottom field vertical timing control register in interlaced output mode (non-instant register). (offset 0xD014; total reset 0x00000000; PROVEN: Hi3516E V300 data sheet (Issue 00B06, 2019-05-15), section 9.2.6, PDF page 486).";
        field {
            name = "bvbb";
            desc = "Bottom vertical back blanking (BVBB) + VPW in interlaced output mode";
            sw = rw; hw = r;
            reset = 0x0;
        } bvbb[31:16];
        field {
            name = "bvact";
            desc = "Height of an active image in the bottom field in interlaced output mode The configured value is the actual value minus 1.";
            sw = rw; hw = r;
            reset = 0x0;
        } bvact[15:0];
    } DHD0_VPLUS1 @ 0xD014;
    reg {
        name = "DHD0_VPLUS2";
        desc = "DHD0_VPLUS2 is a DHD0 bottom field vertical timing control register in interlaced output mode (non-instant register). (offset 0xD018; total reset 0x00000000; PROVEN: Hi3516E V300 data sheet (Issue 00B06, 2019-05-15), section 9.2.6, PDF page 486).";
        field {
            name = "reserved";
            desc = "Reserved";
            sw = r; hw = w;
            reset = 0x0;
        } reserved_31_16[31:16];
        field {
            name = "bvfb";
            desc = "Bottom vertical front blanking (BVFB) in interlaced output mode";
            sw = rw; hw = r;
            reset = 0x0;
        } bvfb[15:0];
    } DHD0_VPLUS2 @ 0xD018;
    reg {
        name = "DHD0_PWR";
        desc = "DHD0_PWR is a sync signal pulse width register (non-instant register). (offset 0xD01C; total reset 0x0804002B; PROVEN: Hi3516E V300 data sheet (Issue 00B06, 2019-05-15), section 9.2.6, PDF page 486).";
        field {
            name = "reserved";
            desc = "Reserved";
            sw = r; hw = w;
            reset = 0x0;
        } reserved_31_29[31:29];
        field {
            name = "multichn_en";
            desc = "DHD0 interface output mode select register
- 00: one pixel per cycle

Other values: reserved";
            sw = rw; hw = r;
            reset = 0x1;
        } multichn_en[28:27];
        field {
            name = "reserved";
            desc = "Reserved";
            sw = r; hw = w;
            reset = 0x0;
        } reserved_26_24[26:24];
        field {
            name = "vpw";
            desc = "VPW. The configured value is the actual value minus 1.";
            sw = rw; hw = r;
            reset = 0x4;
        } vpw[23:16];
        field {
            name = "hpw";
            desc = "Horizontal pulse width (HPW). The configured value is the actual value minus 1.";
            sw = rw; hw = r;
            reset = 0x2b;
        } hpw[15:0];
    } DHD0_PWR @ 0xD01C;
    reg {
        name = "DHD0_VTTHD";
        desc = "DHD0_VTTHD is a vertical timing threshold register (instant register). It can be used to set two thresholds for generating two interrupts separately. (offset 0xD024; total reset 0x00010001; PROVEN: Hi3516E V300 data sheet (Issue 00B06, 2019-05-15), section 9.2.6, PDF page 487).";
        field {
            name = "reserved";
            desc = "Reserved";
            sw = r; hw = w;
            reset = 0x1;
        } reserved_31_16[31:16];
        field {
            name = "thd1_mode";
            desc = "Mode of generating threshold 1 interrupts
- 0: frame mode. The threshold count is by frame.
- 1: field mode. The threshold count is by field during interlaced displaying.";
            sw = rw; hw = r;
            reset = 0x0;
        } thd1_mode[15:15];
        field {
            name = "reserved";
            desc = "Reserved";
            sw = r; hw = w;
            reset = 0x0;
        } reserved_14_13[14:13];
        field {
            name = "vtmgthd1";
            desc = "Vertical timing threshold 1. When the vertical timing counter reaches this threshold, the VOINTSTA[dhdvtthd_int1] interrupt is triggered.";
            sw = rw; hw = r;
            reset = 0x1;
        } vtmgthd1[12:0];
    } DHD0_VTTHD @ 0xD024;
    reg {
        name = "DHD0_PARATHD";
        desc = "DHD0_PARATHD is a PARA coefficient update point threshold register. (offset 0xD028; total reset 0x00000002; PROVEN: Hi3516E V300 data sheet (Issue 00B06, 2019-05-15), section 9.2.6, PDF page 487).";
        field {
            name = "reserved";
            desc = "Reserved";
            sw = r; hw = w;
            reset = 0x0;
        } reserved_31_8[31:8];
        field {
            name = "para_thd";
            desc = "PARA coefficient update point threshold. It indicates the line where the update point";
            sw = rw; hw = r;
            reset = 0x2;
        } para_thd[7:0];
    } DHD0_PARATHD @ 0xD028;
    reg {
        name = "DHD0_START_POS";
        desc = "DHD0_START_POS is a DHD0 start signal start position register. (offset 0xD030; total reset 0x00A3030A; PROVEN: Hi3516E V300 data sheet (Issue 00B06, 2019-05-15), section 9.2.6, PDF page 488).";
        field {
            name = "reserved";
            desc = "Reserved";
            sw = r; hw = w;
            reset = 0xa;
        } reserved_31_20[31:20];
        field {
            name = "reserved";
            desc = "Reserved";
            sw = r; hw = w;
            reset = 0x3;
        } reserved_19_16[19:16];
        field {
            name = "timing_start_pos";
            desc = "Line where the timing_gen state machine starts to work before the active region";
            sw = rw; hw = r;
            reset = 0x3;
        } timing_start_pos[15:8];
        field {
            name = "start_pos";
            desc = "Line where the start signal is generated after the blanking interval. The line number starts from 0.";
            sw = rw; hw = r;
            reset = 0xa;
        } start_pos[7:0];
    } DHD0_START_POS @ 0xD030;
    reg {
        name = "DHD0_STATE";
        desc = "DHD0_STATE is a DHD0 status register. (offset 0xD088; total reset 0x01000006; PROVEN: Hi3516E V300 data sheet (Issue 00B06, 2019-05-15), section 9.2.6, PDF page 488).";
        field {
            name = "reserved";
            desc = "Reserved";
            sw = r; hw = w;
            reset = 0x0;
        } reserved_31_25[31:25];
        field {
            name = "reserved";
            desc = "Reserved";
            sw = r; hw = w;
            reset = 0x1;
        } reserved_24_24[24:24];
        field {
            name = "count_int";
            desc = "DHD0 interrupt count. The count value is increased by 1 each time a vertical timing interrupt is reported.";
            sw = r; hw = w;
            reset = 0x0;
        } count_int[23:16];
        field {
            name = "vcnt";
            desc = "DHD0 active display lines count, starting from 0. The line from vertical front blank to vertical back blank is the start line 0.";
            sw = r; hw = w;
            reset = 0x0;
        } vcnt[15:3];
        field {
            name = "bottom_field";
            desc = "DHD0 top/bottom field indicator
- 0: top field
- 1: bottom field";
            sw = r; hw = w;
            reset = 0x1;
        } bottom_field[2:2];
        field {
            name = "vblank";
            desc = "DHD0 blanking interval indicator
- 0: active region
- 1: blanking interval";
            sw = r; hw = w;
            reset = 0x1;
        } vblank[1:1];
        field {
            name = "vback_blank";
            desc = "DHD0 back blanking interval indicator
- 0: non-back blanking interval";
            sw = r; hw = w;
            reset = 0x0;
        } vback_blank[0:0];
    } DHD0_STATE @ 0xD088;
    reg {
        name = "VO_MUX";
        desc = "VO_MUX is a VO interface multiplexing register. (offset 0xD090; total reset 0x00000000; PROVEN: Hi3516E V300 data sheet (Issue 00B06, 2019-05-15), section 9.2.6, PDF page 489).";
        field {
            name = "digital_sel";
            desc = "Digital interface data select. The default value is 00.
- 00: BT.1120
- 01: BT.656
- 10: LCD

Other values: reserved";
            sw = rw; hw = r;
            reset = 0x0;
        } digital_sel[31:28];
        field {
            name = "reserved";
            desc = "Reserved";
            sw = r; hw = w;
            reset = 0x0;
        } reserved_27_12[27:12];
        field {
            name = "bt_sel";
            desc = "BT.1120/BT.656 data select
- 0: DHD0 BT.1120/BT.656 (default)
- 1: reserved";
            sw = rw; hw = r;
            reset = 0x0;
        } bt_sel[11:8];
        field {
            name = "lcd_sel";
            desc = "LCD data select
- 0: DHD0 LCD (default)
- 1:reserved";
            sw = rw; hw = r;
            reset = 0x0;
        } lcd_sel[7:4];
        field {
            name = "reserved";
            desc = "Reserved";
            sw = r; hw = w;
            reset = 0x0;
        } reserved_3_0[3:0];
    } VO_MUX @ 0xD090;
    reg {
        name = "INTF0_DITHER_CTRL";
        desc = "INTF0_DITHER_CTRL is a dither control register. (offset 0xD0B0; total reset 0x00001500; PROVEN: Hi3516E V300 data sheet (Issue 00B06, 2019-05-15), section 9.2.6, PDF page 489).";
        field {
            name = "reserved";
            desc = "Reserved";
            sw = r; hw = w;
            reset = 0x0;
        } reserved_31_13[31:13];
        field {
            name = "o_data_width_dither";
            desc = "Data width of the output pixel
- 001: 6
- 011: 8

Other values: reserved";
            sw = rw; hw = r;
            reset = 0x5;
        } o_data_width_dither[12:10];
        field {
            name = "reserved";
            desc = "Reserved";
            sw = rw; hw = r;
            reset = 0x2;
        } reserved_9_7[9:7];
        field {
            name = "dither_round_unlim";
            desc = "Round-off enable register for pixels beyond the threshold limit range";
            sw = rw; hw = r;
            reset = 0x0;
        } dither_round_unlim[6:6];
        field {
            name = "dither_en";
            desc = "Dither enable select
- 0: disabled and directly bypassed
- 1: enabled";
            sw = rw; hw = r;
            reset = 0x0;
        } dither_en[5:5];
        field {
            name = "reserved";
            desc = "Reserved";
            sw = rw; hw = r;
            reset = 0x0;
        } reserved_4_4[4:4];
        field {
            name = "dither_round";
            desc = "Dither round-off enable register
- 0: disabled
- 1: enable";
            sw = rw; hw = r;
            reset = 0x0;
        } dither_round[3:3];
        field {
            name = "dither_domain_mode";
            desc = "Dither time domain and spatial domain mode register
- 0: spatial domain
- 1: combination of time domain and spatial domain";
            sw = rw; hw = r;
            reset = 0x0;
        } dither_domain_mode[2:2];
        field {
            name = "dither_tap_mode";
            desc = "Dither cycle configuration
- 00: The cycle is 7.
- 01: The cycle is 15.
- 10: The cycle is 23.
- 11: The cycle is 31.";
            sw = rw; hw = r;
            reset = 0x0;
        } dither_tap_mode[1:0];
    } INTF0_DITHER_CTRL @ 0xD0B0;
    reg {
        name = "INTF_BT_UPD";
        desc = "INTF_BT_UPD is an INTF_BT update register. (offset 0xD204; total reset 0x00000000; PROVEN: Hi3516E V300 data sheet (Issue 00B06, 2019-05-15), section 9.2.6, PDF page 490).";
        field {
            name = "reserved";
            desc = "Reserved";
            sw = r; hw = w;
            reset = 0x0;
        } reserved_31_1[31:1];
        field {
            name = "regup";
            desc = "Update register. After the registers at this layer are configured, the registers are updated when the value 1 is written to this bit. After updates, this bit is automatically cleared by the hardware.

Access type WC in the data sheet: written 1 clears the bit.";
            sw = rw; hw = w; onwrite = woclr;
            reset = 0x0;
        } regup[0:0];
    } INTF_BT_UPD @ 0xD204;
    reg {
        name = "BT_CLIP0_L";
        desc = "BT_CLIP0_L is a BT.1120 clip lowest threshold register (instant register). (offset 0xD210; total reset 0x00000000; PROVEN: Hi3516E V300 data sheet (Issue 00B06, 2019-05-15), section 9.2.6, PDF page 490).";
        field {
            name = "clip_en";
            desc = "Clip enable
- 0: disabled
- 1: enabled";
            sw = rw; hw = r;
            reset = 0x0;
        } clip_en[31:31];
        field {
            name = "reserved";
            desc = "Reserved";
            sw = r; hw = w;
            reset = 0x0;
        } reserved_30_30[30:30];
        field {
            name = "clip_cl2";
            desc = "Lowest threshold Y/R of component 2, unsigned integer";
            sw = rw; hw = r;
            reset = 0x0;
        } clip_cl2[29:20];
        field {
            name = "clip_cl1";
            desc = "Lowest threshold Cb/G of component 1, unsigned integer";
            sw = rw; hw = r;
            reset = 0x0;
        } clip_cl1[19:10];
        field {
            name = "clip_cl0";
            desc = "Lowest threshold Cr/B of component 0, unsigned integer";
            sw = rw; hw = r;
            reset = 0x0;
        } clip_cl0[9:0];
    } BT_CLIP0_L @ 0xD210;
    reg {
        name = "BT_CLIP0_H";
        desc = "BT_CLIP0_H is a BT.1120 clip highest threshold register (instant register). (offset 0xD214; total reset 0x3FFFFFFF; PROVEN: Hi3516E V300 data sheet (Issue 00B06, 2019-05-15), section 9.2.6, PDF page 491).";
        field {
            name = "reserved";
            desc = "Reserved";
            sw = r; hw = w;
            reset = 0x0;
        } reserved_31_30[31:30];
        field {
            name = "clip_ch2";
            desc = "Highest threshold Y/R of component 2, unsigned integer";
            sw = rw; hw = r;
            reset = 0x3ff;
        } clip_ch2[29:20];
        field {
            name = "clip_ch1";
            desc = "Highest threshold Cb/G of component 1, unsigned integer";
            sw = rw; hw = r;
            reset = 0x3ff;
        } clip_ch1[19:10];
        field {
            name = "clip_ch0";
            desc = "Highest threshold Cr/B of component 0, unsigned integer";
            sw = rw; hw = r;
            reset = 0x3ff;
        } clip_ch0[9:0];
    } BT_CLIP0_H @ 0xD214;
    reg {
        name = "INTF_LCD_CTRL";
        desc = "INTF_LCD_CTRL is an interface channel configuration register. (offset 0xD300; total reset 0x00000000; PROVEN: Hi3516E V300 data sheet (Issue 00B06, 2019-05-15), section 9.2.6, PDF page 491).";
        field {
            name = "reserved";
            desc = "Reserved";
            sw = r; hw = w;
            reset = 0x0;
        } reserved_31_31[31:31];
        field {
            name = "reserved";
            desc = "Reserved";
            sw = r; hw = w;
            reset = 0x0;
        } reserved_30_30[30:30];
        field {
            name = "lcd_serial_mode";
            desc = "LCD mode
- 0: parallel mode
- 1: serial mode";
            sw = rw; hw = r;
            reset = 0x0;
        } lcd_serial_mode[29:29];
        field {
            name = "lcd_serial_perd";
            desc = "Number of output single-pixel clock cycles in";
            sw = rw; hw = r;
            reset = 0x0;
        } lcd_serial_perd[28:28];
        field {
            name = "lcd_parallel_order";
            desc = "LCD parallel output sequence
- 0: RGB
- 1: BGR";
            sw = rw; hw = r;
            reset = 0x0;
        } lcd_parallel_order[27:27];
        field {
            name = "lcd_data_inv";
            desc = "Inversion of the LCD output bits
- 0: Bits 15-0 are from upper bits to lower bits.
- 1: Bits 0-15 are from upper bits to lower bits.";
            sw = rw; hw = r;
            reset = 0x0;
        } lcd_data_inv[26:26];
        field {
            name = "reserved";
            desc = "Reserved";
            sw = r; hw = w;
            reset = 0x0;
        } reserved_25_0[25:0];
    } INTF_LCD_CTRL @ 0xD300;
    reg {
        name = "INTF_LCD_UPD";
        desc = "INTF_LCD_UPD is an INTF_LCD update register. (offset 0xD304; total reset 0x00000000; PROVEN: Hi3516E V300 data sheet (Issue 00B06, 2019-05-15), section 9.2.6, PDF page 492).";
        field {
            name = "reserved";
            desc = "Reserved";
            sw = r; hw = w;
            reset = 0x0;
        } reserved_31_1[31:1];
        field {
            name = "regup";
            desc = "Update register. After the registers at this layer are configured, the registers are updated when the value 1 is written to this bit. After updates, this bit is automatically cleared by the hardware.

Access type WC in the data sheet: written 1 clears the bit.";
            sw = rw; hw = w; onwrite = woclr;
            reset = 0x0;
        } regup[0:0];
    } INTF_LCD_UPD @ 0xD304;
    reg {
        name = "INTF_LCD_SYNC_INV";
        desc = "INTF_LCD_SYNC_INV is a sync signal polarity configuration register in LCD external sync timing input mode. The setting of this register takes effect immediately after configuration, that is, the polarity of the corresponding sync signal is immediately affected. (offset 0xD308; total reset 0x00000000; PROVEN: Hi3516E V300 data sheet (Issue 00B06, 2019-05-15), section 9.2.6, PDF page 492).";
        field {
            name = "reserved";
            desc = "Reserved";
            sw = r; hw = w;
            reset = 0x0;
        } reserved_31_4[31:4];
        field {
            name = "f_inv";
            desc = "Output phase inversion enable for the odd/even field indicator signal (instant)
- 0: disabled
- 1: enabled";
            sw = rw; hw = r;
            reset = 0x0;
        } f_inv[3:3];
        field {
            name = "vs_inv";
            desc = "Output phase inversion enable for the vertical";
            sw = rw; hw = r;
            reset = 0x0;
        } vs_inv[2:2];
        field {
            name = "hs_inv";
            desc = "Output phase inversion enable for the horizontal sync pulse (instant)
- 0: disabled
- 1: enabled";
            sw = rw; hw = r;
            reset = 0x0;
        } hs_inv[1:1];
        field {
            name = "dv_inv";
            desc = "Output phase inversion enable for the data validity signal (instant)
- 0: disabled
- 1: enabled";
            sw = rw; hw = r;
            reset = 0x0;
        } dv_inv[0:0];
    } INTF_LCD_SYNC_INV @ 0xD308;
    reg {
        name = "MAC_OUTSTANDING";
        desc = "MAC_OUTSTANDING is an outstanding register. (offset 0x10000; total reset 0x0000007F; PROVEN: Hi3516E V300 data sheet (Issue 00B06, 2019-05-15), section 9.2.6, PDF page 493).";
        field {
            name = "reserved";
            desc = "Reserved";
            sw = r; hw = w;
            reset = 0x0;
        } reserved_31_8[31:8];
        field {
            name = "mstr0_woutstanding";
            desc = "Master 0 write outstanding";
            sw = rw; hw = r;
            reset = 0x7;
        } mstr0_woutstanding[7:4];
        field {
            name = "mstr0_routstanding";
            desc = "Master 0 read outstanding";
            sw = rw; hw = r;
            reset = 0xf;
        } mstr0_routstanding[3:0];
    } MAC_OUTSTANDING @ 0x10000;
    reg {
        name = "VID_READ_CTRL";
        desc = "VID_READ_CTRL is a VID FDR read control register (non-instant register). (offset 0x10200; total reset 0x00020000; PROVEN: Hi3516E V300 data sheet (Issue 00B06, 2019-05-15), section 9.2.6, PDF page 493).";
        field {
            name = "reserved";
            desc = "Reserved";
            sw = r; hw = w;
            reset = 0x0;
        } reserved_31_14[31:14];
        field {
            name = "chm_copy_en";
            desc = "Repeated chrominance read enable
- 0: disabled
- 1: enabled";
            sw = rw; hw = r;
            reset = 0x0;
        } chm_copy_en[13:13];
        field {
            name = "reserved";
            desc = "Reserved";
            sw = r; hw = w;
            reset = 0x0;
        } reserved_12_7[12:7];
        field {
            name = "lm_rmode";
            desc = "Chrominance read mode register
- 000: The read mode is bound to the interface.
- 001: The data is read in progressive mode.
- 010: The top field is read in interlaced mode.
- 011: The bottom field is read in interlaced mode.

Other values: reserved";
            sw = rw; hw = r;
            reset = 0x0;
        } lm_rmode[6:4];
        field {
            name = "reserved";
            desc = "Reserved";
            sw = r; hw = w;
            reset = 0x0;
        } reserved_3_3[3:3];
        field {
            name = "chm_rmode";
            desc = "Chrominance read mode register
- 000: The read mode is bound to the interface.
- 001: The data is read in progressive mode.
- 010: The top field is read in interlaced mode.
- 011: The bottom field is read in interlaced mode.

Other values: reserved";
            sw = rw; hw = r;
            reset = 0x0;
        } chm_rmode[2:0];
    } VID_READ_CTRL @ 0x10200;
    reg {
        name = "VID_OUT_CTRL";
        desc = "VID_OUT_CTRL is a VID FDR output control register (non-instant register). (offset 0x10210; total reset 0x00000000; PROVEN: Hi3516E V300 data sheet (Issue 00B06, 2019-05-15), section 9.2.6, PDF page 494).";
        field {
            name = "reserved";
            desc = "Reserved";
            sw = r; hw = w;
            reset = 0x0;
        } reserved_31_5[31:5];
        field {
            name = "uv_order_en";
            desc = "UV sequence register of the input YUV data format
- 0: U for upper bits
- 1: V for upper bits";
            sw = rw; hw = r;
            reset = 0x0;
        } uv_order_en[4:4];
        field {
            name = "reserved";
            desc = "Reserved";
            sw = r; hw = w;
            reset = 0x0;
        } reserved_3_0[3:0];
    } VID_OUT_CTRL @ 0x10210;
    reg {
        name = "VID_SRC_INFO";
        desc = "VID_SRC_INFO is a VID FDR input picture attribute register (non-instant register). (offset 0x10240; total reset 0x00000000; PROVEN: Hi3516E V300 data sheet (Issue 00B06, 2019-05-15), section 9.2.6, PDF page 494).";
        field {
            name = "reserved";
            desc = "Reserved";
            sw = r; hw = w;
            reset = 0x0;
        } reserved_31_3[31:3];
        field {
            name = "data_type";
            desc = "Input data type
- 000: reserved. The default value is YUV422.
- 001: YUV400";
            sw = rw; hw = r;
            reset = 0x0;
        } data_type[2:0];
    } VID_SRC_INFO @ 0x10240;
    reg {
        name = "VID_SRC_RESO";
        desc = "VID_SRC_RESO is an original picture resolution register (non-instant register). (offset 0x10244; total reset 0x00000000; PROVEN: Hi3516E V300 data sheet (Issue 00B06, 2019-05-15), section 9.2.6, PDF page 495).";
        field {
            name = "src_h";
            desc = "Height (in lines). The configured value is the actual height minus 1. The frame height is referenced and its unit is line.";
            sw = rw; hw = r;
            reset = 0x0;
        } src_h[31:16];
        field {
            name = "src_w";
            desc = "Width (in pixels). The configured value is the actual width minus 1.";
            sw = rw; hw = r;
            reset = 0x0;
        } src_w[15:0];
    } VID_SRC_RESO @ 0x10244;
    reg {
        name = "VID_SRC_CROP";
        desc = "VID_SRC_CROP is an original picture crop register (non-instant register). (offset 0x10248; total reset 0x00000000; PROVEN: Hi3516E V300 data sheet (Issue 00B06, 2019-05-15), section 9.2.6, PDF page 495).";
        field {
            name = "reserved";
            desc = "Reserved";
            sw = r; hw = w;
            reset = 0x0;
        } reserved_31_16[31:16];
        field {
            name = "src_crop_x";
            desc = "Width (in pixels). The configured value is the actual crop value.";
            sw = rw; hw = r;
            reset = 0x0;
        } src_crop_x[15:0];
    } VID_SRC_CROP @ 0x10248;
    reg {
        name = "VID_IN_RESO";
        desc = "VID_IN_RESO is a VID input picture resolution register (non-instant register). (offset 0x1024C; total reset 0x00000000; PROVEN: Hi3516E V300 data sheet (Issue 00B06, 2019-05-15), section 9.2.6, PDF page 495).";
        field {
            name = "ireso_h";
            desc = "Height (in lines). The configured value is the actual height minus 1. The frame height is referenced and its unit is line.";
            sw = rw; hw = r;
            reset = 0x0;
        } ireso_h[31:16];
        field {
            name = "ireso_w";
            desc = "Width (in pixels). The configured value is the actual width minus 1.";
            sw = rw; hw = r;
            reset = 0x0;
        } ireso_w[15:0];
    } VID_IN_RESO @ 0x1024C;
    reg {
        name = "GFX_OUT_CTRL";
        desc = "GFX_OUT_CTRL is a GFX FDR output control register (non-instant register). (offset 0x10E08; total reset 0x00000001; PROVEN: Hi3516E V300 data sheet (Issue 00B06, 2019-05-15), section 9.2.6, PDF page 496).";
        field {
            name = "reserved";
            desc = "Reserved";
            sw = r; hw = w;
            reset = 0x0;
        } reserved_31_11[31:11];
        field {
            name = "premulti_en";
            desc = "GFX premultiplication enable register
- 0: enabled
- 1: disabled";
            sw = rw; hw = r;
            reset = 0x0;
        } premulti_en[10:10];
        field {
            name = "bitext";
            desc = "Bit extend mode of the input bitmap
- 00: extend 0s to lower bits
- 10: extend the value of the MSB to a lower bit
- 11: extend the values of upper bits to lower bits";
            sw = rw; hw = r;
            reset = 0x0;
        } bitext[9:8];
        field {
            name = "reserved";
            desc = "Reserved";
            sw = r; hw = w;
            reset = 0x0;
        } reserved_7_6[7:6];
        field {
            name = "key_en";
            desc = "Colorkey enable
- 0: disabled
- 1: enabled";
            sw = rw; hw = r;
            reset = 0x0;
        } key_en[5:5];
        field {
            name = "key_mode";
            desc = "Colorkey mode
- 0: The color is regarded as the colorkey when the following condition is met: Keymin ≤

Pixel ≤ Keymax
- 1: The color is regarded as the colorkey when either of the following conditions is met: Pixel ≤ Keymin or Pixel ≥ Keymax";
            sw = rw; hw = r;
            reset = 0x0;
        } key_mode[4:4];
        field {
            name = "reserved";
            desc = "Reserved";
            sw = r; hw = w;
            reset = 0x0;
        } reserved_3_2[3:2];
        field {
            name = "palpha_en";
            desc = "Pixel alpha enable
- 0: disabled
- 1: enabled";
            sw = rw; hw = r;
            reset = 0x0;
        } palpha_en[1:1];
        field {
            name = "palpha_range";
            desc = "Alpha range select of the pixel
- 0: The alpha range of the pixel is 0-128.
- 1: The alpha range of the pixel is 0-255.";
            sw = rw; hw = r;
            reset = 0x0;
        } palpha_range[0:0];
    } GFX_OUT_CTRL @ 0x10E08;
    reg {
        name = "GFX_1555_ALPHA";
        desc = "GFX_1555_ALPHA is an alpha value register in ARGB1555 format (non-instant register). (offset 0x10E28; total reset 0x00000000; PROVEN: Hi3516E V300 data sheet (Issue 00B06, 2019-05-15), section 9.2.6, PDF page 496).";
        field {
            name = "reserved";
            desc = "Reserved";
            sw = r; hw = w;
            reset = 0x0;
        } reserved_31_16[31:16];
        field {
            name = "alpha_1";
            desc = "Alpha1 value. When the data format is alphaRGB1555 and the alpha value is 1, the alpha1 value is used.";
            sw = rw; hw = r;
            reset = 0x0;
        } alpha_1[15:8];
        field {
            name = "alpha_0";
            desc = "Alpha0 value. When the data format is alphaRGB1555 and the alpha value is 1, the alpha0 value is used.";
            sw = rw; hw = r;
            reset = 0x0;
        } alpha_0[7:0];
    } GFX_1555_ALPHA @ 0x10E28;
    reg {
        name = "GFX_SRC_INFO";
        desc = "GFX_SRC_INFO is a GFX FDR original picture attribute register (non-instant register). (offset 0x10E40; total reset 0x00000000; PROVEN: Hi3516E V300 data sheet (Issue 00B06, 2019-05-15), section 9.2.6, PDF page 497).";
        field {
            name = "reserved";
            desc = "Reserved";
            sw = r; hw = w;
            reset = 0x0;
        } reserved_31_8[31:8];
        field {
            name = "ifmt";
            desc = "Input data format
- 0x48: ARGB4444
- 0x49: ARGB1555

Other values: reserved";
            sw = rw; hw = r;
            reset = 0x0;
        } ifmt[7:0];
    } GFX_SRC_INFO @ 0x10E40;
    reg {
        name = "GFX_SRC_RESO";
        desc = "GFX_SRC_RESO is an original picture resolution register (non-instant register). (offset 0x10E44; total reset 0x00000000; PROVEN: Hi3516E V300 data sheet (Issue 00B06, 2019-05-15), section 9.2.6, PDF page 497).";
        field {
            name = "src_h";
            desc = "Height (in lines). The configured value is the actual height minus 1. The frame height is referenced and its unit is line.";
            sw = rw; hw = r;
            reset = 0x0;
        } src_h[31:16];
        field {
            name = "src_w";
            desc = "Width (in pixels). The configured value is the actual width minus 1.";
            sw = rw; hw = r;
            reset = 0x0;
        } src_w[15:0];
    } GFX_SRC_RESO @ 0x10E44;
    reg {
        name = "GFX_SRC_CROP";
        desc = "GFX_SRC_CROP is an original picture crop register (non-instant register). (offset 0x10E48; total reset 0x00000000; PROVEN: Hi3516E V300 data sheet (Issue 00B06, 2019-05-15), section 9.2.6, PDF page 497).";
        field {
            name = "reserved";
            desc = "Reserved";
            sw = r; hw = w;
            reset = 0x0;
        } reserved_31_16[31:16];
        field {
            name = "src_crop_x";
            desc = "Width (in pixels). The configured value is the crop value of the left original picture. (The original coordinate offset function is implemented by this register.)";
            sw = rw; hw = r;
            reset = 0x0;
        } src_crop_x[15:0];
    } GFX_SRC_CROP @ 0x10E48;
    reg {
        name = "GFX_IRESO";
        desc = "GFX_IRESO is an input resolution register (non-instant register). (offset 0x10E4C; total reset 0x00000000; PROVEN: Hi3516E V300 data sheet (Issue 00B06, 2019-05-15), section 9.2.6, PDF page 498).";
        field {
            name = "ireso_h";
            desc = "Height (in lines). The configured value is the actual height minus 1. Note: The actual layer height must be an even number.";
            sw = rw; hw = r;
            reset = 0x0;
        } ireso_h[31:16];
        field {
            name = "ireso_w";
            desc = "Width (in pixels). The configured value is the actual width minus 1. Note: The actual layer width must be an even number.";
            sw = rw; hw = r;
            reset = 0x0;
        } ireso_w[15:0];
    } GFX_IRESO @ 0x10E4C;
    reg {
        name = "GFX_CKEY_MAX";
        desc = "GFX_CKEY_MAX is a maximum colorkey register (non-instant register). (offset 0x10F00; total reset 0x00000000; PROVEN: Hi3516E V300 data sheet (Issue 00B06, 2019-05-15), section 9.2.6, PDF page 498).";
        field {
            name = "reserved";
            desc = "Reserved";
            sw = r; hw = w;
            reset = 0x0;
        } reserved_31_24[31:24];
        field {
            name = "key_r_max";
            desc = "Maximum value of the color key R component";
            sw = rw; hw = r;
            reset = 0x0;
        } key_r_max[23:16];
        field {
            name = "key_g_max";
            desc = "Maximum value of the color key G component";
            sw = rw; hw = r;
            reset = 0x0;
        } key_g_max[15:8];
        field {
            name = "key_b_max";
            desc = "Maximum value of the color key B component";
            sw = rw; hw = r;
            reset = 0x0;
        } key_b_max[7:0];
    } GFX_CKEY_MAX @ 0x10F00;
    reg {
        name = "GFX_CKEY_MIN";
        desc = "GFX_CKEY_MIN is a minimum colorkey register (non-instant register). (offset 0x10F04; total reset 0x00000000; PROVEN: Hi3516E V300 data sheet (Issue 00B06, 2019-05-15), section 9.2.6, PDF page 498).";
        field {
            name = "reserved";
            desc = "Reserved";
            sw = r; hw = w;
            reset = 0x0;
        } reserved_31_24[31:24];
        field {
            name = "key_r_min";
            desc = "Minimum value of the color key R component";
            sw = rw; hw = r;
            reset = 0x0;
        } key_r_min[23:16];
        field {
            name = "key_g_min";
            desc = "Minimum value of the color key G component";
            sw = rw; hw = r;
            reset = 0x0;
        } key_g_min[15:8];
        field {
            name = "key_b_min";
            desc = "Minimum value of the color key B component";
            sw = rw; hw = r;
            reset = 0x0;
        } key_b_min[7:0];
    } GFX_CKEY_MIN @ 0x10F04;
    reg {
        name = "GFX_CKEY_MASK";
        desc = "GFX_CKEY_MASK is a masked colorkey register (non-instant register). The value 1 indicates that the bit corresponding to a pixel is retained during colorkey comparison; the value 0 indicates that the bit corresponding to a pixel is forcibly set to 0 during color comparison no matter whether the bit is 0 or 1. (offset 0x10F08; total reset 0x00FFFFFF; PROVEN: Hi3516E V300 data sheet (Issue 00B06, 2019-05-15), section 9.2.6, PDF page 499).";
        field {
            name = "reserved";
            desc = "Reserved";
            sw = r; hw = w;
            reset = 0x0;
        } reserved_31_24[31:24];
        field {
            name = "key_r_msk";
            desc = "R component of the masked colorkey";
            sw = rw; hw = r;
            reset = 0xff;
        } key_r_msk[23:16];
        field {
            name = "key_g_msk";
            desc = "G component of the masked colorkey";
            sw = rw; hw = r;
            reset = 0xff;
        } key_g_msk[15:8];
        field {
            name = "key_b_msk";
            desc = "B component of the masked colorkey";
            sw = rw; hw = r;
            reset = 0xff;
        } key_b_msk[7:0];
    } GFX_CKEY_MASK @ 0x10F08;
};
`endif
