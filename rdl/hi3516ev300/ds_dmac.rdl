`ifndef HI3516EV300_DMAC_RDL
`define HI3516EV300_DMAC_RDL
regfile eHI3516EV300_DMAC {
    name = "DMAC (EDMAC)";
    desc = "DMAC (EDMAC) of the Hi3516E V300 at base 0x100B0000. 27 registers extracted programmatically from the Hi3516E V300 data sheet (Issue 00B06, 2019-05-15) (Table 3-11 DMAC registers Offset Register Description Page Address): register headings, offsets, total reset values, field bit ranges, access types, names, reset values and descriptions, with PDF page numbers in each register description. Field names, bit ranges, access types and offsets are exact; the free-text descriptions are taken from the cell text of the field table and were checked by sampling only. Hardware not verified.";
    reg {
        name = "INT_STAT";
        desc = "INT_STATUS is an interrupt status register. (offset 0x0; total reset 0x00000000; PROVEN: Hi3516E V300 data sheet (Issue 00B06, 2019-05-15), section 3.6.6, PDF page 148).";
        field {
            name = "reserved";
            desc = "Reserved";
            sw = r; hw = w;
            reset = 0x0;
        } reserved_31_4[31:4];
        field {
            name = "int_stat";
            desc = "Status of the masked interrupts of each DMAC channel. Bit[3:0] corresponds to channels 3-0.
- 0: No interrupt is generated.
- 1: An interrupt is generated. The interrupt request may be an error interrupt or a transfer completion interrupt.";
            sw = r; hw = w;
            reset = 0x0;
        } int_stat[3:0];
    } INT_STAT @ 0x0;
    reg {
        name = "INT_TC1";
        desc = "INT_TC1 is a channel transfer completion interrupt status register. (offset 0x4; total reset 0x00000000; PROVEN: Hi3516E V300 data sheet (Issue 00B06, 2019-05-15), section 3.6.6, PDF page 148).";
        field {
            name = "reserved";
            desc = "Reserved";
            sw = r; hw = w;
            reset = 0x0;
        } reserved_31_4[31:4];
        field {
            name = "int_tc1";
            desc = "Status of the masked channel transfer completion interrupts of each DMAC channel. Bit[3:0] corresponds to channels 3-0.
- 0: No interrupt is generated.
- 1: An interrupt is generated.";
            sw = r; hw = w;
            reset = 0x0;
        } int_tc1[3:0];
    } INT_TC1 @ 0x4;
    reg {
        name = "INT_TC2";
        desc = "INT_TC2 is a linked list node transfer completion interrupt status register. (offset 0x8; total reset 0x00000000; PROVEN: Hi3516E V300 data sheet (Issue 00B06, 2019-05-15), section 3.6.6, PDF page 148).";
        field {
            name = "reserved";
            desc = "Reserved";
            sw = r; hw = w;
            reset = 0x0;
        } reserved_31_4[31:4];
        field {
            name = "int_tc2";
            desc = "Status of the masked linked list node transfer completion interrupts for each DMAC channel. Bit[3:0] corresponds to channels 3-0.
- 0: No interrupt is generated.
- 1: An interrupt is generated.";
            sw = r; hw = w;
            reset = 0x0;
        } int_tc2[3:0];
    } INT_TC2 @ 0x8;
    reg {
        name = "INT_ERR1";
        desc = "INT_ERR1 is a configuration error interrupt status register. (offset 0xC; total reset 0x00000000; PROVEN: Hi3516E V300 data sheet (Issue 00B06, 2019-05-15), section 3.6.6, PDF page 149).";
        field {
            name = "reserved";
            desc = "Reserved";
            sw = r; hw = w;
            reset = 0x0;
        } reserved_31_4[31:4];
        field {
            name = "int_err1";
            desc = "Status of the masked configuration error interrupts for each DMAC channel. Bit[3:0] corresponds to channels 3-0.
- 0: No interrupt is generated.
- 1: An interrupt is generated.";
            sw = r; hw = w;
            reset = 0x0;
        } int_err1[3:0];
    } INT_ERR1 @ 0xC;
    reg {
        name = "INT_ERR2";
        desc = "INT_ERR2 is a data transfer error interrupt status register. (offset 0x10; total reset 0x00000000; PROVEN: Hi3516E V300 data sheet (Issue 00B06, 2019-05-15), section 3.6.6, PDF page 149).";
        field {
            name = "reserved";
            desc = "Reserved";
            sw = r; hw = w;
            reset = 0x0;
        } reserved_31_4[31:4];
        field {
            name = "int_err2";
            desc = "Status of the masked data transfer error interrupts of each DMAC channel. Bit[3:0] corresponds to channels 3-0.
- 0: No interrupt is generated.
- 1: An interrupt is generated.";
            sw = r; hw = w;
            reset = 0x0;
        } int_err2[3:0];
    } INT_ERR2 @ 0x10;
    reg {
        name = "INT_ERR3";
        desc = "INT_ERR3 is a linked list read error interrupt status register. (offset 0x14; total reset 0x00000000; PROVEN: Hi3516E V300 data sheet (Issue 00B06, 2019-05-15), section 3.6.6, PDF page 149).";
        field {
            name = "reserved";
            desc = "Reserved";
            sw = r; hw = w;
            reset = 0x0;
        } reserved_31_4[31:4];
        field {
            name = "int_err3";
            desc = "Status of the masked linked list read error interrupts of each DMAC channel. Bit[3:0] corresponds to channels 3-0.
- 0: No interrupt is generated.
- 1: An interrupt is generated.";
            sw = r; hw = w;
            reset = 0x0;
        } int_err3[3:0];
    } INT_ERR3 @ 0x14;
    reg {
        name = "INT_TC1_MASK";
        desc = "INT_TC1_MASK is a channel transfer completion interrupt mask register. (offset 0x18; total reset 0x00000000; PROVEN: Hi3516E V300 data sheet (Issue 00B06, 2019-05-15), section 3.6.6, PDF page 150).";
        field {
            name = "reserved";
            desc = "Reserved";
            sw = r; hw = w;
            reset = 0x0;
        } reserved_31_4[31:4];
        field {
            name = "int_tc1_mask";
            desc = "Mask status of the transfer completion interrupts of each DMAC channel. Bit[3:0] corresponds to channels 3-0.
- 0: The interrupt is masked.
- 1: The interrupt is not masked.";
            sw = rw; hw = r;
            reset = 0x0;
        } int_tc1_mask[3:0];
    } INT_TC1_MASK @ 0x18;
    reg {
        name = "INT_TC2_MASK";
        desc = "INT_TC2_MASK is a linked list node transfer completion interrupt mask register. (offset 0x1C; total reset 0x00000000; PROVEN: Hi3516E V300 data sheet (Issue 00B06, 2019-05-15), section 3.6.6, PDF page 150).";
        field {
            name = "reserved";
            desc = "Reserved";
            sw = r; hw = w;
            reset = 0x0;
        } reserved_31_4[31:4];
        field {
            name = "int_tc2_mask";
            desc = "Mask status of the linked list node transfer completion interrupts of each DMAC channel. Bit[3:0] corresponds to channels 3-0.
- 0: The interrupt is masked.
- 1: The interrupt is not masked.";
            sw = rw; hw = r;
            reset = 0x0;
        } int_tc2_mask[3:0];
    } INT_TC2_MASK @ 0x1C;
    reg {
        name = "INT_ERR1_MASK";
        desc = "INT_ERR1_MASK is a configuration error interrupt mask register. (offset 0x20; total reset 0x00000000; PROVEN: Hi3516E V300 data sheet (Issue 00B06, 2019-05-15), section 3.6.6, PDF page 150).";
        field {
            name = "reserved";
            desc = "Reserved";
            sw = r; hw = w;
            reset = 0x0;
        } reserved_31_4[31:4];
        field {
            name = "int_err1_mask";
            desc = "Mask status of configuration error interrupts of each DMAC channel. Bit[3:0] corresponds to channels 3-0.
- 0: The interrupt is masked.
- 1: The interrupt is not masked.";
            sw = rw; hw = r;
            reset = 0x0;
        } int_err1_mask[3:0];
    } INT_ERR1_MASK @ 0x20;
    reg {
        name = "INT_ERR2_MASK";
        desc = "INT_ERR2_MASK is a data transfer error interrupt mask register. (offset 0x24; total reset 0x00000000; PROVEN: Hi3516E V300 data sheet (Issue 00B06, 2019-05-15), section 3.6.6, PDF page 151).";
        field {
            name = "reserved";
            desc = "Reserved";
            sw = r; hw = w;
            reset = 0x0;
        } reserved_31_4[31:4];
        field {
            name = "int_err2_mask";
            desc = "Mask status of data transfer error interrupts of each DMAC channel. Bit[3:0] corresponds to channels 3-0.
- 0: The interrupt is masked.
- 1: The interrupt is not masked.";
            sw = rw; hw = r;
            reset = 0x0;
        } int_err2_mask[3:0];
    } INT_ERR2_MASK @ 0x24;
    reg {
        name = "INT_ERR3_MASK";
        desc = "INT_ERR3_MASK is a linked list read error interrupt mask register. (offset 0x28; total reset 0x00000000; PROVEN: Hi3516E V300 data sheet (Issue 00B06, 2019-05-15), section 3.6.6, PDF page 151).";
        field {
            name = "reserved";
            desc = "Reserved";
            sw = r; hw = w;
            reset = 0x0;
        } reserved_31_4[31:4];
        field {
            name = "int_err3_mask";
            desc = "Mask status of linked list read error interrupts of each DMAC channel. Bit[3:0] corresponds to channels 3-0.
- 0: The interrupt is masked.
- 1: The interrupt is not masked.";
            sw = rw; hw = r;
            reset = 0x0;
        } int_err3_mask[3:0];
    } INT_ERR3_MASK @ 0x28;
    reg C_n_CURR_CNT0_t {
        name = "C(n)_CURR_CNT0";
        desc = "C(n)_CURR_CNT0 is a remaining data amount register of channel n. (offset 0x404, 4 instances at stride 0x20; total reset 0x00000000; PROVEN: Hi3516E V300 data sheet (Issue 00B06, 2019-05-15), section 3.6.6, PDF page 151).";
        field {
            name = "reserved";
            desc = "Reserved";
            sw = r; hw = w;
            reset = 0x0;
        } reserved_31_16[31:16];
        field {
            name = "curr_a_count";
            desc = "Number of remaining bytes in the current node of channel n";
            sw = r; hw = w;
            reset = 0x0;
        } curr_a_count[15:0];
    };
    C_n_CURR_CNT0_t C_0_CURR_CNT0 @ 0x404;
    C_n_CURR_CNT0_t C_1_CURR_CNT0 @ 0x424;
    C_n_CURR_CNT0_t C_2_CURR_CNT0 @ 0x444;
    C_n_CURR_CNT0_t C_3_CURR_CNT0 @ 0x464;
    reg C_n_CURR_SRC_ADDR_t {
        name = "C(n)_CURR_SRC_ADDR";
        desc = "C(n)_CURR_SRC_ADDR is a source address register of channel n. (offset 0x408, 4 instances at stride 0x20; total reset 0x00000000; PROVEN: Hi3516E V300 data sheet (Issue 00B06, 2019-05-15), section 3.6.6, PDF page 151).";
        field {
            name = "Sourceaddressofthedatabeingtransferredbycurr_src_addrchanneln";
            desc = "";
            sw = r; hw = w;
            reset = 0x0;
        } Sourceaddressofthedatabeingtransferredbycurr_src_addrchanneln[31:0];
    };
    C_n_CURR_SRC_ADDR_t C_0_CURR_SRC_ADDR @ 0x408;
    C_n_CURR_SRC_ADDR_t C_1_CURR_SRC_ADDR @ 0x428;
    C_n_CURR_SRC_ADDR_t C_2_CURR_SRC_ADDR @ 0x448;
    C_n_CURR_SRC_ADDR_t C_3_CURR_SRC_ADDR @ 0x468;
    reg C_n_CURR_DES_ADDR_t {
        name = "C(n)_CURR_DES_ADDR";
        desc = "C(n)_CURR_DES_ADDR is a destination address register of channel n. (offset 0x410, 4 instances at stride 0x20; total reset 0x00000000; PROVEN: Hi3516E V300 data sheet (Issue 00B06, 2019-05-15), section 3.6.6, PDF page 152).";
        field {
            name = "Destinationaddressofthedatabeingcurr_des_addrtransferredbychanneln";
            desc = "";
            sw = r; hw = w;
            reset = 0x0;
        } Destinationaddressofthedatabeingcurr_des_addrtransferredbychanneln[31:0];
    };
    C_n_CURR_DES_ADDR_t C_0_CURR_DES_ADDR @ 0x410;
    C_n_CURR_DES_ADDR_t C_1_CURR_DES_ADDR @ 0x430;
    C_n_CURR_DES_ADDR_t C_2_CURR_DES_ADDR @ 0x450;
    C_n_CURR_DES_ADDR_t C_3_CURR_DES_ADDR @ 0x470;
    reg {
        name = "INT_TC1_RAW";
        desc = "INT_TC1_RAW is a raw channel transfer completion interrupt status register. (offset 0x600; total reset 0x00000000; PROVEN: Hi3516E V300 data sheet (Issue 00B06, 2019-05-15), section 3.6.6, PDF page 152).";
        field {
            name = "reserved";
            desc = "Reserved";
            sw = r; hw = w;
            reset = 0x0;
        } reserved_31_4[31:4];
        field {
            name = "int_tc1_raw";
            desc = "Raw status of channel transfer completion interrupts of each channel. Bit[3:0] corresponds to channels 3-0. Read the register:
- 0: No interrupt is generated.
- 1: An interrupt is generated.

Write the register:
- 0: Reserve the previous values.
- 1: Clear channel transfer completion interrupts.

Access type RWC in the data sheet: written 1 clears the bit.";
            sw = rw; hw = w; onwrite = woclr;
            reset = 0x0;
        } int_tc1_raw[3:0];
    } INT_TC1_RAW @ 0x600;
    reg {
        name = "INT_TC2_RAW";
        desc = "INT_TC2_RAW is a raw linked list node transfer completion interrupt status register. (offset 0x608; total reset 0x00000000; PROVEN: Hi3516E V300 data sheet (Issue 00B06, 2019-05-15), section 3.6.6, PDF page 152).";
        field {
            name = "reserved";
            desc = "Reserved";
            sw = r; hw = w;
            reset = 0x0;
        } reserved_31_4[31:4];
        field {
            name = "int_tc2_raw";
            desc = "Raw status of linked list node transfer

Access type RWC in the data sheet: written 1 clears the bit.";
            sw = rw; hw = w; onwrite = woclr;
            reset = 0x0;
        } int_tc2_raw[3:0];
    } INT_TC2_RAW @ 0x608;
    reg {
        name = "INT_ERR1_RAW";
        desc = "INT_ERR1_RAW is a raw configuration error interrupt status register. (offset 0x610; total reset 0x00000000; PROVEN: Hi3516E V300 data sheet (Issue 00B06, 2019-05-15), section 3.6.6, PDF page 153).";
        field {
            name = "reserved";
            desc = "Reserved";
            sw = r; hw = w;
            reset = 0x0;
        } reserved_31_4[31:4];
        field {
            name = "int_err1_raw";
            desc = "Raw status of the configuration error interrupts for each channel. Bit[3:0] corresponds to channels 3-0. Read the register:
- 0: No interrupt is generated.
- 1: An interrupt is generated.

Write the register:
- 0: Reserve the previous values.
- 1: Clear configuration error interrupts.

Access type RWC in the data sheet: written 1 clears the bit.";
            sw = rw; hw = w; onwrite = woclr;
            reset = 0x0;
        } int_err1_raw[3:0];
    } INT_ERR1_RAW @ 0x610;
    reg {
        name = "INT_ERR2_RAW";
        desc = "INT_ERR2_RAW is a raw data transfer error interrupt status register. (offset 0x618; total reset 0x00000000; PROVEN: Hi3516E V300 data sheet (Issue 00B06, 2019-05-15), section 3.6.6, PDF page 153).";
        field {
            name = "reserved";
            desc = "Reserved";
            sw = r; hw = w;
            reset = 0x0;
        } reserved_31_8[31:8];
        field {
            name = "int_err2_raw";
            desc = "Raw status of data transfer error interrupts for each channel. Bit[3:0] corresponds to channels 3-0. Read the register:
- 0: No interrupt is generated.

Access type RWC in the data sheet: written 1 clears the bit.";
            sw = rw; hw = w; onwrite = woclr;
            reset = 0x0;
        } int_err2_raw[7:0];
    } INT_ERR2_RAW @ 0x618;
    reg {
        name = "INT_ERR3_RAW";
        desc = "INT_ERR3_RAW is a raw linked list read error interrupt status register. (offset 0x620; total reset 0x00000000; PROVEN: Hi3516E V300 data sheet (Issue 00B06, 2019-05-15), section 3.6.6, PDF page 154).";
        field {
            name = "reserved";
            desc = "Reserved";
            sw = r; hw = w;
            reset = 0x0;
        } reserved_31_4[31:4];
        field {
            name = "int_err3_raw";
            desc = "Raw status of linked list read error interrupts for each channel. Bit[3:0] corresponds to channels 3-0. Read the register:
- 0: No interrupt is generated.
- 1: An interrupt is generated.

Write the register:
- 0: Reserve the previous values.
- 1: Clear linked list read error interrupts.

Access type RWC in the data sheet: written 1 clears the bit.";
            sw = rw; hw = w; onwrite = woclr;
            reset = 0x0;
        } int_err3_raw[3:0];
    } INT_ERR3_RAW @ 0x620;
    reg {
        name = "CH_PRI";
        desc = "CH_PRI is a priority control register. (offset 0x688; total reset 0x00000000; PROVEN: Hi3516E V300 data sheet (Issue 00B06, 2019-05-15), section 3.6.6, PDF page 154).";
        field {
            name = "reserved";
            desc = "Reserved";
            sw = r; hw = w;
            reset = 0x0;
        } reserved_31_8[31:8];
        field {
            name = "ch3_pri";
            desc = "Priority configuration register of channel 3
- 00: priority 0 (highest)
- 01: priority 1
- 10: priority 2
- 11: priority 3 (lowest)";
            sw = rw; hw = r;
            reset = 0x0;
        } ch3_pri[7:6];
        field {
            name = "ch2_pri";
            desc = "Priority configuration register of channel 2
- 00: priority 0 (highest)
- 01: priority 1
- 10: priority 2";
            sw = rw; hw = r;
            reset = 0x0;
        } ch2_pri[5:4];
        field {
            name = "ch1_pri";
            desc = "Priority configuration register of channel 1
- 00: priority 0 (highest)
- 01: priority 1
- 10: priority 2
- 11: priority 3 (lowest)";
            sw = rw; hw = r;
            reset = 0x0;
        } ch1_pri[3:2];
        field {
            name = "ch0_pri";
            desc = "Priority configuration register of channel 0
- 00: priority 0 (highest)
- 01: priority 1
- 10: priority 2
- 11: priority 3 (lowest)";
            sw = rw; hw = r;
            reset = 0x0;
        } ch0_pri[1:0];
    } CH_PRI @ 0x688;
    reg {
        name = "CH_STAT";
        desc = "CH_STAT is a DMA status register. (offset 0x690; total reset 0x00000000; PROVEN: Hi3516E V300 data sheet (Issue 00B06, 2019-05-15), section 3.6.6, PDF page 155).";
        field {
            name = "reserved";
            desc = "Reserved";
            sw = r; hw = w;
            reset = 0x0;
        } reserved_31_4[31:4];
        field {
            name = "ch_stat";
            desc = "DMAC channel status register. Bit[3:0] corresponds to channels 3-0.
- 0: The corresponding DMA channels are not operating.
- 1: The corresponding DMA channels are operating.";
            sw = r; hw = w;
            reset = 0x0;
        } ch_stat[3:0];
    } CH_STAT @ 0x690;
    reg C_n_LLI_t {
        name = "C(n)_LLI";
        desc = "C(n)_LLI is a linked list address configuration register of channel n. (offset 0x800, 4 instances at stride 0x40; total reset 0x00000000; PROVEN: Hi3516E V300 data sheet (Issue 00B06, 2019-05-15), section 3.6.6, PDF page 155).";
        field {
            name = "lli";
            desc = "Bit[31:6] of the next linked list node address of channel n. The linked list address must be 512-bit aligned.";
            sw = rw; hw = r;
            reset = 0x0;
        } lli[31:6];
        field {
            name = "reserved";
            desc = "Reserved";
            sw = r; hw = w;
            reset = 0x0;
        } reserved_5_2[5:2];
        field {
            name = "chain_en";
            desc = "Channel link enable
- 00: The linked list link enable is invalid.";
            sw = rw; hw = r;
            reset = 0x0;
        } chain_en[1:0];
    };
    C_n_LLI_t C_0_LLI @ 0x800;
    C_n_LLI_t C_1_LLI @ 0x840;
    C_n_LLI_t C_2_LLI @ 0x880;
    C_n_LLI_t C_3_LLI @ 0x8C0;
    reg C_n_CNT0_t {
        name = "C(n)_CNT0";
        desc = "C(n)_CNT0 is a transfer length configuration register of channel n. (offset 0x81C, 4 instances at stride 0x40; total reset 0x00000000; PROVEN: Hi3516E V300 data sheet (Issue 00B06, 2019-05-15), section 3.6.6, PDF page 156).";
        field {
            name = "reserved";
            desc = "Reserved";
            sw = r; hw = w;
            reset = 0x0;
        } reserved_31_16[31:16];
        field {
            name = "a_count";
            desc = "Transfer length, that is, the transfer length of a single node of the linked list mode or the total transfer length of the non-linked list mode The valid length is 1-65535 bytes. A configuration error interrupt is reported when a_count is set to 0.";
            sw = rw; hw = r;
            reset = 0x0;
        } a_count[15:0];
    };
    C_n_CNT0_t C_0_CNT0 @ 0x81C;
    C_n_CNT0_t C_1_CNT0 @ 0x85C;
    C_n_CNT0_t C_2_CNT0 @ 0x89C;
    C_n_CNT0_t C_3_CNT0 @ 0x8DC;
    reg C_n_SRC_ADDR_t {
        name = "C(n)_SRC_ADDR";
        desc = "C(n)_SRC_ADDR is a source address configuration register of channel n. (offset 0x820, 4 instances at stride 0x40; total reset 0x00000000; PROVEN: Hi3516E V300 data sheet (Issue 00B06, 2019-05-15), section 3.6.6, PDF page 156).";
        field {
            name = "src_addr";
            desc = "Source address of channel n";
            sw = rw; hw = r;
            reset = 0x0;
        } src_addr[31:0];
    };
    C_n_SRC_ADDR_t C_0_SRC_ADDR @ 0x820;
    C_n_SRC_ADDR_t C_1_SRC_ADDR @ 0x860;
    C_n_SRC_ADDR_t C_2_SRC_ADDR @ 0x8A0;
    C_n_SRC_ADDR_t C_3_SRC_ADDR @ 0x8E0;
    reg C_n_DES_ADDR_t {
        name = "C(n)_DES_ADDR";
        desc = "C(n)_DES_ADDR is a destination address configuration register of channel n. (offset 0x828, 4 instances at stride 0x40; total reset 0x00000000; PROVEN: Hi3516E V300 data sheet (Issue 00B06, 2019-05-15), section 3.6.6, PDF page 156).";
        field {
            name = "des_addr";
            desc = "Destination address of channel n";
            sw = rw; hw = r;
            reset = 0x0;
        } des_addr[31:0];
    };
    C_n_DES_ADDR_t C_0_DES_ADDR @ 0x828;
    C_n_DES_ADDR_t C_1_DES_ADDR @ 0x868;
    C_n_DES_ADDR_t C_2_DES_ADDR @ 0x8A8;
    C_n_DES_ADDR_t C_3_DES_ADDR @ 0x8E8;
    reg C_n_CONFIG_t {
        name = "C(n)_CONFIG";
        desc = "C(n)_CONFIG is a configuration register of channel n. (offset 0x830, 4 instances at stride 0x40; total reset 0x00000000; PROVEN: Hi3516E V300 data sheet (Issue 00B06, 2019-05-15), section 3.6.6, PDF page 156).";
        field {
            name = "si";
            desc = "Source address increment
- 0: The source address is not incremented.
- 1: The source address is incremented once after a data segment is transferred.

If the source device is a peripheral, the source address is not incremented. If the source device is a memory, the source address is incremented.";
            sw = rw; hw = r;
            reset = 0x0;
        } si[31:31];
        field {
            name = "di";
            desc = "Destination address increment
- 0: The destination address is not incremented.
- 1: The destination address is incremented once after a data segment is transferred.

If the destination device is a peripheral, the destination address is not incremented. If the destination device is a memory, the destination address is incremented.";
            sw = rw; hw = r;
            reset = 0x0;
        } di[30:30];
        field {
            name = "reserved";
            desc = "Reserved";
            sw = r; hw = w;
            reset = 0x0;
        } reserved_29_28[29:28];
        field {
            name = "sl";
            desc = "Burst length on the source side
- 0x0: 1
- 0x1: 2
- 0x2: 3
- 0x3: 4
- 0x4: 5
- 0x5: 6
- 0x6: 7
- 0x7: 8
- 0x8: 9
- 0x9: 10
- 0xA: 11
- 0xB: 12
- 0xC: 13
- 0xD: 14
- 0xE: 15
- 0xF: 16";
            sw = rw; hw = r;
            reset = 0x0;
        } sl[27:24];
        field {
            name = "dl";
            desc = "Burst length on the destination side
- 0x0: 1
- 0x1: 2
- 0x2: 3
- 0x3: 4
- 0x4: 5";
            sw = rw; hw = r;
            reset = 0x0;
        } dl[23:20];
        field {
            name = "reserved";
            desc = "Reserved";
            sw = r; hw = w;
            reset = 0x0;
        } reserved_19_19[19:19];
        field {
            name = "sw";
            desc = "Source data width
- 000: 8 bits
- 001: 16 bits
- 010: 32 bits
- 011: 64 bits 1xx: reserved";
            sw = rw; hw = r;
            reset = 0x0;
        } sw_f[18:16];
        field {
            name = "reserved";
            desc = "Reserved";
            sw = r; hw = w;
            reset = 0x0;
        } reserved_15_15[15:15];
        field {
            name = "dw";
            desc = "Destination data width
- 000: 8 bits
- 001: 16 bits
- 010: 32 bits
- 011: 64 bits 1xx: reserved";
            sw = rw; hw = r;
            reset = 0x0;
        } dw[14:12];
        field {
            name = "reserved";
            desc = "Reserved";
            sw = r; hw = w;
            reset = 0x0;
        } reserved_11_9[11:9];
        field {
            name = "peri";
            desc = "Peripheral request signal If the data is transferred from a memory to another one, these bits are ignored.";
            sw = rw; hw = r;
            reset = 0x0;
        } peri[8:4];
        field {
            name = "flow_ctrl";
            desc = "Flow control type and transfer type
- 00: Transfer between two memories, DMAC flow control
- 01: Transfer between a memory and a peripheral, DMAC flow control 1x: reserved";
            sw = rw; hw = r;
            reset = 0x0;
        } flow_ctrl[3:2];
        field {
            name = "itc_en";
            desc = "Linked list node transfer completion interrupt enable. This bit is used to configure whether to trigger a linked list node transfer completion interrupt after the current linked";
            sw = rw; hw = r;
            reset = 0x0;
        } itc_en[1:1];
        field {
            name = "CurrentchannelenableRunningstatusofthecurrentchannelwhenthisregisteriswritten:0:Thechannelisdisabled.1:Thechannelisenabled.ch_enStatusofthecurrentchannelwhenthisregisterisread:0:Thecurrentchannelstopsrunning.1:Thecurrentchannelisrunning(thecurrentchannelisalwaysenabledwhenthelinkedlisttransferisenabled).";
            desc = "";
            sw = rw; hw = r;
            reset = 0x0;
        } CurrentchannelenableRunningstatusofthecurrentchannelwhenthisregisteriswritten_0_Thechannelisdisabled_1_Thechannelisenabled_ch_enStatusofthecurrentchannelwhenthisregisterisread_0_Thecurrentchannelstopsrunning_1_Thecurrentchannelisrunning_thecurrentchannelisalwaysenabledwhenthelinkedlisttransferisenabled[0:0];
    };
    C_n_CONFIG_t C_0_CONFIG @ 0x830;
    C_n_CONFIG_t C_1_CONFIG @ 0x870;
    C_n_CONFIG_t C_2_CONFIG @ 0x8B0;
    C_n_CONFIG_t C_3_CONFIG @ 0x8F0;
    reg {
        name = "DMAC_VERSION";
        desc = "DATE_VERSION is a version register. (offset 0xF00; total reset 0x0000B310; PROVEN: Hi3516E V300 data sheet (Issue 00B06, 2019-05-15), section 3.6.6, PDF page 159).";
        field {
            name = "dmac_version";
            desc = "Controller version information";
            sw = r; hw = w;
            reset = 0xb310;
        } dmac_version[31:0];
    } DMAC_VERSION @ 0xF00;
};
`endif
