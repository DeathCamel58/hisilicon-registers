`ifndef HI3516EV300_SPACC_RDL
`define HI3516EV300_SPACC_RDL
regfile eHI3516EV300_SPACC {
    name = "SPACC cipher";
    desc = "SPACC cipher of the Hi3516E V300 at base 0x1005_0000. 44 registers extracted programmatically from the Hi3516E V300 data sheet (Issue 00B06, 2019-05-15) (Table 13-2 Summary of the SPACC registers (base address: 0x1005_0000)): register headings, offsets, total reset values, field bit ranges, access types, names, reset values and descriptions, with PDF page numbers in each register description. Field names, bit ranges, access types and offsets are exact; the free-text descriptions are taken from the cell text of the field table and were checked by sampling only. Hardware not verified.";
    reg CHAN0_CIPHER_IV_t {
        name = "CHAN0_CIPHER_IV";
        desc = "CHAN0_CIPHER_IV is the IVin and IVout register for the symmetric algorithm of the channel 0. (offset 0x0, 4 instances at stride 0x4; total reset 0x00000000; PROVEN: Hi3516E V300 data sheet (Issue 00B06, 2019-05-15), section 13.2.6, PDF page 814).";
        field {
            name = "chan0_cipher_iv";
            desc = "IVin and IVout for the symmetric algorithm of channel 0 (little endian) (1) If the vector configuration update is not required (CHAN0_CIPHER_CTRL[sym_ch0_ivin_sel] ='b0)), the logic does not need to read this register again. (2) If the vector configuration update is required (CHAN0_CIPHER_CTRL[sym_ch0_ivin_sel] ='b1), the logic needs to read this register again.";
            sw = rw; hw = r;
            reset = 0x0;
        } chan0_cipher_iv[31:0];
    };
    CHAN0_CIPHER_IV_t CHAN0_CIPHER_IV_0 @ 0x0;
    CHAN0_CIPHER_IV_t CHAN0_CIPHER_IV_1 @ 0x4;
    CHAN0_CIPHER_IV_t CHAN0_CIPHER_IV_2 @ 0x8;
    CHAN0_CIPHER_IV_t CHAN0_CIPHER_IV_3 @ 0xC;
    reg CHANN_CIPHER_IVOUT_t {
        name = "CHANN_CIPHER_IVOUT";
        desc = "CHANN_CIPHER_IVOUT is the IVout register for the symmetric algorithm of channel n. (offset 0x10, 8 instances at stride 0x4; total reset 0x00000000; PROVEN: Hi3516E V300 data sheet (Issue 00B06, 2019-05-15), section 13.2.6, PDF page 815).";
        field {
            name = "chann_cipher_ivout";
            desc = "IVout of the symmetric algorithm (little endian). 0x00n0-0x00nC correspond to channel n. This register can be ignored in ECB mode.";
            sw = r; hw = w;
            reset = 0x0;
        } chann_cipher_ivout[31:0];
    };
    CHANN_CIPHER_IVOUT_t CHANN_CIPHER_IVOUT_0 @ 0x10;
    CHANN_CIPHER_IVOUT_t CHANN_CIPHER_IVOUT_1 @ 0x14;
    CHANN_CIPHER_IVOUT_t CHANN_CIPHER_IVOUT_2 @ 0x18;
    CHANN_CIPHER_IVOUT_t CHANN_CIPHER_IVOUT_3 @ 0x1C;
    CHANN_CIPHER_IVOUT_t CHANN_CIPHER_IVOUT_4 @ 0x20;
    CHANN_CIPHER_IVOUT_t CHANN_CIPHER_IVOUT_5 @ 0x24;
    CHANN_CIPHER_IVOUT_t CHANN_CIPHER_IVOUT_6 @ 0x28;
    CHANN_CIPHER_IVOUT_t CHANN_CIPHER_IVOUT_7 @ 0x2C;
    reg CHAN0_CIPHER_DOUT_t {
        name = "CHAN0_CIPHER_DOUT";
        desc = "CHAN0_CIPHER_DOUT is the Dout register for the symmetric algorithm of channel 0. (offset 0x80, 4 instances at stride 0x4; total reset 0x00000000; PROVEN: Hi3516E V300 data sheet (Issue 00B06, 2019-05-15), section 13.2.6, PDF page 815).";
        field {
            name = "chan0_cipher_dout";
            desc = "Channel 0 Dout for the symmetric algorithm (little endian) AES: (1) If the 1-CFB mode is selected, chan0_cipher_dout[0] is valid. (2) If the 8-CFB mode is selected, chan0_cipher_dout[7:0] is valid. (3) If the 128-CFB mode is selected, 128 bits are all valid. (4) In other modes, 128 bits are all valid.";
            sw = r; hw = w;
            reset = 0x0;
        } chan0_cipher_dout[31:0];
    };
    CHAN0_CIPHER_DOUT_t CHAN0_CIPHER_DOUT_0 @ 0x80;
    CHAN0_CIPHER_DOUT_t CHAN0_CIPHER_DOUT_1 @ 0x84;
    CHAN0_CIPHER_DOUT_t CHAN0_CIPHER_DOUT_2 @ 0x88;
    CHAN0_CIPHER_DOUT_t CHAN0_CIPHER_DOUT_3 @ 0x8C;
    reg CIPHER_KEY_t {
        name = "CIPHER_KEY";
        desc = "CIPHER_KEY is the CPU key register for the symmetric algorithm. (offset 0x100, 24 instances at stride 0x4; total reset 0x00000000; PROVEN: Hi3516E V300 data sheet (Issue 00B06, 2019-05-15), section 13.2.6, PDF page 816).";
        field {
            name = "cipher_key";
            desc = "CPU key register for the symmetric algorithm (little endian). It cannot be read, that is, the read result is 0. The value of j for each channel is 0-7, that is a total of 256 bits. 0x0100-0x011C correspond to the host key of channel 0. The rule applies to other similar situations. AES algorithm: a) If a 128-bit key is selected, cipher_key[127:0] is valid. b) If a 192-bit key is selected, cipher_key[191:0] is valid. c) If a 256-bit key operation is performed, 256 bits are all valid.";
            sw = w; hw = r;
            reset = 0x0;
        } cipher_key[31:0];
    };
    CIPHER_KEY_t CIPHER_KEY_0 @ 0x100;
    CIPHER_KEY_t CIPHER_KEY_1 @ 0x104;
    CIPHER_KEY_t CIPHER_KEY_2 @ 0x108;
    CIPHER_KEY_t CIPHER_KEY_3 @ 0x10C;
    CIPHER_KEY_t CIPHER_KEY_4 @ 0x110;
    CIPHER_KEY_t CIPHER_KEY_5 @ 0x114;
    CIPHER_KEY_t CIPHER_KEY_6 @ 0x118;
    CIPHER_KEY_t CIPHER_KEY_7 @ 0x11C;
    CIPHER_KEY_t CIPHER_KEY_8 @ 0x120;
    CIPHER_KEY_t CIPHER_KEY_9 @ 0x124;
    CIPHER_KEY_t CIPHER_KEY_10 @ 0x128;
    CIPHER_KEY_t CIPHER_KEY_11 @ 0x12C;
    CIPHER_KEY_t CIPHER_KEY_12 @ 0x130;
    CIPHER_KEY_t CIPHER_KEY_13 @ 0x134;
    CIPHER_KEY_t CIPHER_KEY_14 @ 0x138;
    CIPHER_KEY_t CIPHER_KEY_15 @ 0x13C;
    CIPHER_KEY_t CIPHER_KEY_16 @ 0x140;
    CIPHER_KEY_t CIPHER_KEY_17 @ 0x144;
    CIPHER_KEY_t CIPHER_KEY_18 @ 0x148;
    CIPHER_KEY_t CIPHER_KEY_19 @ 0x14C;
    CIPHER_KEY_t CIPHER_KEY_20 @ 0x150;
    CIPHER_KEY_t CIPHER_KEY_21 @ 0x154;
    CIPHER_KEY_t CIPHER_KEY_22 @ 0x158;
    CIPHER_KEY_t CIPHER_KEY_23 @ 0x15C;
    reg {
        name = "SPACC_VERSION";
        desc = "SPACC_VERSION is the SPACC version register. (offset 0x308; total reset 0x02018121; PROVEN: Hi3516E V300 data sheet (Issue 00B06, 2019-05-15), section 13.2.6, PDF page 816).";
        field {
            name = "spacc_version";
            desc = "SPACC version register. The macro definition is used.";
            sw = rw; hw = r;
            reset = 0x2018121;
        } spacc_version[31:0];
    } SPACC_VERSION @ 0x308;
    reg {
        name = "MEM_EMA_CFG";
        desc = "MEM_EMA_CFG is the memory EMA configuration register. (offset 0x310; total reset 0x00009B13; PROVEN: Hi3516E V300 data sheet (Issue 00B06, 2019-05-15), section 13.2.6, PDF page 816).";
        field {
            name = "reserved";
            desc = "Reserved";
            sw = r; hw = w;
            reset = 0x0;
        } reserved_31_16[31:16];
        field {
            name = "rft_colldisn";
            desc = "RFT colldisn signal";
            sw = rw; hw = r;
            reset = 0x1;
        } rft_colldisn[15:15];
        field {
            name = "rft_emasa";
            desc = "RFT emasa signal";
            sw = rw; hw = r;
            reset = 0x0;
        } rft_emasa[14:14];
        field {
            name = "rft_emab";
            desc = "RFT emab signal";
            sw = rw; hw = r;
            reset = 0x3;
        } rft_emab[13:11];
        field {
            name = "rft_emaa";
            desc = "RFT emaa signal";
            sw = rw; hw = r;
            reset = 0x3;
        } rft_emaa[10:8];
        field {
            name = "reserved";
            desc = "Reserved";
            sw = r; hw = w;
            reset = 0x0;
        } reserved_7_6[7:6];
        field {
            name = "rfs_emaw";
            desc = "RFS emaw signal";
            sw = rw; hw = r;
            reset = 0x1;
        } rfs_emaw[5:4];
        field {
            name = "reserved";
            desc = "Reserved";
            sw = r; hw = w;
            reset = 0x0;
        } reserved_3_3[3:3];
        field {
            name = "rfs_ema";
            desc = "RFS ema signal";
            sw = rw; hw = r;
            reset = 0x3;
        } rfs_ema[2:0];
    } MEM_EMA_CFG @ 0x310;
    reg {
        name = "CALC_ERR";
        desc = "CALC_ERR is the alarm status register for the algorithm core. (offset 0x320; total reset 0x00000000; PROVEN: Hi3516E V300 data sheet (Issue 00B06, 2019-05-15), section 13.2.6, PDF page 817).";
        field {
            name = "reserved";
            desc = "Reserved";
            sw = r; hw = w;
            reset = 0x0;
        } reserved_31_2[31:2];
        field {
            name = "alg_len_err";
            desc = "When the length of a node is 0, an error is reported.";
            sw = r; hw = w;
            reset = 0x0;
        } alg_len_err[1:1];
        field {
            name = "reserved";
            desc = "Reserved";
            sw = r; hw = w;
            reset = 0x0;
        } reserved_0_0[0:0];
    } CALC_ERR @ 0x320;
    reg CHANN_HASH_STATE_VAL_t {
        name = "CHANN_HASH_STATE_VAL";
        desc = "CHANN_HASH_STATE_VAL is the hash input and output state value register for channel z. (offset 0x340, 3 instances at stride 0x8; total reset 0x00000000; PROVEN: Hi3516E V300 data sheet (Issue 00B06, 2019-05-15), section 13.2.6, PDF page 817).";
        field {
            name = "hash_state_val";
            desc = "Hash result state value";
            sw = rw; hw = r;
            reset = 0x0;
        } hash_state_val[31:0];
    };
    CHANN_HASH_STATE_VAL_t CHANN_HASH_STATE_VAL_0 @ 0x340;
    CHANN_HASH_STATE_VAL_t CHANN_HASH_STATE_VAL_1 @ 0x348;
    CHANN_HASH_STATE_VAL_t CHANN_HASH_STATE_VAL_2 @ 0x350;
    reg CHANN_HASH_STATE_VAL_ADDR_t {
        name = "CHANN_HASH_STATE_VAL_ADDR";
        desc = "CHANN_HASH_STATE_VAL_ADDR is the hash input and output state value address register for channel z. (offset 0x344, 3 instances at stride 0x8; total reset 0x00000000; PROVEN: Hi3516E V300 data sheet (Issue 00B06, 2019-05-15), section 13.2.6, PDF page 817).";
        field {
            name = "reserved";
            desc = "Reserved";
            sw = r; hw = w;
            reset = 0x0;
        } reserved_31_3[31:3];
        field {
            name = "hash_state_val_addr";
            desc = "Hash state value address. The maximum length is 8 words, that is, 256 bits.";
            sw = rw; hw = r;
            reset = 0x0;
        } hash_state_val_addr[2:0];
    };
    CHANN_HASH_STATE_VAL_ADDR_t CHANN_HASH_STATE_VAL_ADDR_0 @ 0x344;
    CHANN_HASH_STATE_VAL_ADDR_t CHANN_HASH_STATE_VAL_ADDR_1 @ 0x34C;
    CHANN_HASH_STATE_VAL_ADDR_t CHANN_HASH_STATE_VAL_ADDR_2 @ 0x354;
    reg {
        name = "SPACC_CALC_CRG_CFG";
        desc = "SPACC_CALC_CRG_CFG is the SPACC internal algorithm core clock gating and reset configuration register. (offset 0x39C; total reset 0x801F2AAA; PROVEN: Hi3516E V300 data sheet (Issue 00B06, 2019-05-15), section 13.2.6, PDF page 818).";
        field {
            name = "spacc_core_auto_cken_bypass";
            desc = "Automatic clock gating enable for the algorithm core
- 0: enabled
- 1: disabled";
            sw = rw; hw = r;
            reset = 0x1;
        } spacc_core_auto_cken_bypass[31:31];
        field {
            name = "spacc_rft_mem_wr_clk_gt_en";
            desc = "Automatic write clock gating enable for the RFT memory
- 0: disabled
- 1: enabled";
            sw = rw; hw = r;
            reset = 0x0;
        } spacc_rft_mem_wr_clk_gt_en[30:30];
        field {
            name = "spacc_rft_mem_rd_clk_gt_en";
            desc = "Automatic read clock gating enable for the RFT memory
- 0: disabled
- 1: enabled";
            sw = rw; hw = r;
            reset = 0x0;
        } spacc_rft_mem_rd_clk_gt_en[29:29];
        field {
            name = "spacc_rfs_mem_clk_gt_en";
            desc = "Automatic clock gating enable for the RFS memory
- 0: disabled
- 1: enabled";
            sw = rw; hw = r;
            reset = 0x0;
        } spacc_rfs_mem_clk_gt_en[28:28];
        field {
            name = "reserved";
            desc = "Reserved";
            sw = r; hw = w;
            reset = 0x0;
        } reserved_27_21[27:21];
        field {
            name = "cken_in_ram";
            desc = "Clock enable for the RFT memory
- 0: disabled
- 1: enabled

It is used for internal debugging. For normal use, set the register to 1.";
            sw = rw; hw = r;
            reset = 0x1;
        } cken_in_ram[20:20];
        field {
            name = "cken_in_ram_a";
            desc = "Read port clock enable for the RFT memory
- 0: disabled
- 1: enabled

It is used for internal debugging. For normal use, set the register to 1.";
            sw = rw; hw = r;
            reset = 0x1;
        } cken_in_ram_a[19:19];
        field {
            name = "cken_in_ram_b";
            desc = "Write port clock enable for the RFT memory
- 0: disabled
- 1: enabled

It is used for internal debugging. For normal use, set the register to 1.";
            sw = rw; hw = r;
            reset = 0x1;
        } cken_in_ram_b[18:18];
        field {
            name = "cken_in_pipe_ib";
            desc = "pipe_ib clock enable for the RFT memory
- 0: disabled";
            sw = rw; hw = r;
            reset = 0x1;
        } cken_in_pipe_ib[17:17];
        field {
            name = "cken_in_pipe_i";
            desc = "pipe_i clock enable for the RFT memory
- 0: disabled
- 1: enabled

It is used for internal debugging. For normal use, set the register to 1.";
            sw = rw; hw = r;
            reset = 0x1;
        } cken_in_pipe_i[16:16];
        field {
            name = "reserved";
            desc = "Reserved";
            sw = r; hw = w;
            reset = 0x0;
        } reserved_15_14[15:14];
        field {
            name = "spacc_aes_core_srst_req";
            desc = "AES core soft reset request
- 0: not reset
- 1: reset";
            sw = rw; hw = r;
            reset = 0x0;
        } spacc_aes_core_srst_req[12:12];
        field {
            name = "reserved";
            desc = "Reserved";
            sw = r; hw = w;
            reset = 0xaa;
        } reserved_11_4[11:4];
        field {
            name = "spacc_sha1_core_clk_en";
            desc = "SHA1 core clock enable
- 0: disabled
- 1: enabled";
            sw = rw; hw = r;
            reset = 0x1;
        } spacc_sha1_core_clk_en[3:3];
        field {
            name = "spacc_sha1_core_srst_req";
            desc = "SHA1 core soft reset request
- 0: not reset
- 1: reset";
            sw = rw; hw = r;
            reset = 0x0;
        } spacc_sha1_core_srst_req[2:2];
        field {
            name = "spacc_sha2_core_clk_en";
            desc = "SHA2 core clock enable
- 0: disabled
- 1: enabled";
            sw = rw; hw = r;
            reset = 0x1;
        } spacc_sha2_core_clk_en[1:1];
        field {
            name = "spacc_sha2_core_srst_req";
            desc = "SHA2 core soft reset request
- 0: not reset
- 1: reset";
            sw = rw; hw = r;
            reset = 0x0;
        } spacc_sha2_core_srst_req[0:0];
    } SPACC_CALC_CRG_CFG @ 0x39C;
    reg {
        name = "CHAN0_CIPHER_CTRL";
        desc = "CHAN0_CIPHER_CTRL is the encryption/decryption control register for channel 0 of the symmetric algorithm. (offset 0x400; total reset 0x00000000; PROVEN: Hi3516E V300 data sheet (Issue 00B06, 2019-05-15), section 13.2.6, PDF page 819).";
        field {
            name = "reserved";
            desc = "Reserved";
            sw = r; hw = w;
            reset = 0x0;
        } reserved_31_16[31:16];
        field {
            name = "sym_ch0_ivin_sel";
            desc = "IVin input select for channel 0
- 0: IVin does not need to be configured.
- 1: IVin needs to be configured.";
            sw = rw; hw = r;
            reset = 0x0;
        } sym_ch0_ivin_sel[15:15];
        field {
            name = "sym_ch0_key_sel";
            desc = "Key source select
- 0: keys configured by the CPU
- 1: keys configured by hardware";
            sw = rw; hw = r;
            reset = 0x0;
        } sym_ch0_key_sel[14:14];
        field {
            name = "reserved";
            desc = "Reserved";
            sw = r; hw = w;
            reset = 0x0;
        } reserved_13_12[13:12];
        field {
            name = "sym_ch0_key_length";
            desc = "Key length AES:
- 00: 128 bits
- 01: 192 bits
- 10: 256 bits
- 11: 128 bits";
            sw = rw; hw = r;
            reset = 0x0;
        } sym_ch0_key_length[11:10];
        field {
            name = "sym_ch0_dat_width";
            desc = "Data bit width AES:
- 00: 128 bits
- 01: 8 bits
- 10: 1 bit
- 11: 128 bits";
            sw = rw; hw = r;
            reset = 0x0;
        } sym_ch0_dat_width[9:8];
        field {
            name = "sym_ch0_decrypt";
            desc = "Encryption or decryption
- 0: 0: encryption
- 1: decryption";
            sw = rw; hw = r;
            reset = 0x0;
        } sym_ch0_decrypt[7:7];
        field {
            name = "sym_ch0_alg_sel";
            desc = "Algorithm select
- 010: AES

Other values: AES";
            sw = rw; hw = r;
            reset = 0x0;
        } sym_ch0_alg_sel[6:4];
        field {
            name = "sym_ch0_alg_mode";
            desc = "Operating mode AES:
- 000: ECB
- 001: CBC
- 010: CFB
- 011: OFB
- 100: CTR

Other values: ECB";
            sw = rw; hw = r;
            reset = 0x0;
        } sym_ch0_alg_mode[3:1];
        field {
            name = "sym_ch0_start";
            desc = "Encryption/Decryption start signal for channel 0 (input transfer end)
- 0: not started (The input transfer is ended.)
- 1: started (The input transfer is not ended.)";
            sw = rw; hw = r;
            reset = 0x0;
        } sym_ch0_start[0:0];
    } CHAN0_CIPHER_CTRL @ 0x400;
    reg {
        name = "CIPHER_INT_STATUS";
        desc = "CIPHER_INT_STATUS is the interrupt status register for the symmetric algorithm. (offset 0x404; total reset 0x00000000; PROVEN: Hi3516E V300 data sheet (Issue 00B06, 2019-05-15), section 13.2.6, PDF page 821).";
        field {
            name = "reserved";
            desc = "Reserved";
            sw = r; hw = w;
            reset = 0x0;
        } reserved_31_17[31:17];
        field {
            name = "ahb_bus_err_int";
            desc = "AHB error interrupt
- 0: No interrupt is generated.
- 1: An interrupt is generated.";
            sw = r; hw = w;
            reset = 0x0;
        } ahb_bus_err_int[16:16];
        field {
            name = "cipher_chn_obuf_int";
            desc = "Output queue data interrupt for channel m
- 0: No interrupt is generated.
- 1: An interrupt is generated.

Bits 15-8 correspond to channels 7-0, respectively.";
            sw = r; hw = w;
            reset = 0x0;
        } cipher_chn_obuf_int[15:8];
        field {
            name = "cipher_chn_ibuf_int";
            desc = "Input queue data interrupt for channel n
- 0: No interrupt is generated.
- 1: An interrupt is generated.

Bits 7-1 correspond to channels 7-1, respectively.";
            sw = r; hw = w;
            reset = 0x0;
        } cipher_chn_ibuf_int[7:1];
        field {
            name = "reserved";
            desc = "Reserved";
            sw = r; hw = w;
            reset = 0x0;
        } reserved_0_0[0:0];
    } CIPHER_INT_STATUS @ 0x404;
    reg {
        name = "CIPHER_INT_EN";
        desc = "CIPHER_INT_EN is the interrupt enable register for the symmetric algorithm. (offset 0x408; total reset 0x00000000; PROVEN: Hi3516E V300 data sheet (Issue 00B06, 2019-05-15), section 13.2.6, PDF page 821).";
        field {
            name = "reserved";
            desc = "Reserved";
            sw = r; hw = w;
            reset = 0x0;
        } reserved_31_31[31:31];
        field {
            name = "cipher_int_en";
            desc = "Global channel interrupt enable for the Cipher module
- 0: disabled
- 1: enabled";
            sw = rw; hw = r;
            reset = 0x0;
        } cipher_int_en[30:30];
        field {
            name = "reserved";
            desc = "Reserved";
            sw = r; hw = w;
            reset = 0x0;
        } reserved_29_17[29:17];
        field {
            name = "ahb_bus_err_int_en";
            desc = "AHB error interrupt enable
- 0: disabled
- 1: enabled";
            sw = rw; hw = r;
            reset = 0x0;
        } ahb_bus_err_int_en[16:16];
        field {
            name = "cipher_chn_obuf_en";
            desc = "Output queue data interrupt enable for channel m
- 0: disabled
- 1: enabled

Bits 15-8 correspond to channels 7-0, respectively.";
            sw = rw; hw = r;
            reset = 0x0;
        } cipher_chn_obuf_en[15:8];
        field {
            name = "cipher_chn_ibuf_en";
            desc = "Input queue data interrupt enable for channel 7
- 0: disabled
- 1: enabled

Bits 7-1 correspond to channels 7-1, respectively.";
            sw = rw; hw = r;
            reset = 0x0;
        } cipher_chn_ibuf_en[7:1];
        field {
            name = "reserved";
            desc = "Reserved";
            sw = r; hw = w;
            reset = 0x0;
        } reserved_0_0[0:0];
    } CIPHER_INT_EN @ 0x408;
    reg {
        name = "CIPHER_INT_RAW";
        desc = "CIPHER_INT_RAW is the interrupt status register for the symmetric algorithm. (offset 0x40C; total reset 0x00000000; PROVEN: Hi3516E V300 data sheet (Issue 00B06, 2019-05-15), section 13.2.6, PDF page 822).";
        field {
            name = "reserved";
            desc = "Reserved";
            sw = r; hw = w;
            reset = 0x0;
        } reserved_31_17[31:17];
        field {
            name = "ahb_bus_err_int_raw";
            desc = "AHB error raw interrupt
- 0: No interrupt is generated.
- 1: An interrupt is generated.

Access type RWC in the data sheet: written 1 clears the bit.";
            sw = rw; hw = w; onwrite = woclr;
            reset = 0x0;
        } ahb_bus_err_int_raw[16:16];
        field {
            name = "cipher_chn_obuf_raw";
            desc = "Raw output queue data interrupt for channel m
- 0: No interrupt is generated.
- 1: An interrupt is generated.

Bits 15-8 correspond to channels 7-0, respectively.

Access type RWC in the data sheet: written 1 clears the bit.";
            sw = rw; hw = w; onwrite = woclr;
            reset = 0x0;
        } cipher_chn_obuf_raw[15:8];
        field {
            name = "cipher_chn_ibuf_raw";
            desc = "Raw input queue data interrupt for channel n
- 0: No interrupt is generated.
- 1: An interrupt is generated.

Bits 7-1 correspond to channels 7-1, respectively.

Access type RWC in the data sheet: written 1 clears the bit.";
            sw = rw; hw = w; onwrite = woclr;
            reset = 0x0;
        } cipher_chn_ibuf_raw[7:1];
        field {
            name = "reserved";
            desc = "Reserved";
            sw = r; hw = w;
            reset = 0x0;
        } reserved_0_0[0:0];
    } CIPHER_INT_RAW @ 0x40C;
    reg CHAN0_CIPHER_DIN_t {
        name = "CHAN0_CIPHER_DIN";
        desc = "CHAN0_CIPHER_DIN is the channel 0 Din register for the symmetric algorithm. (offset 0x420, 4 instances at stride 0x4; total reset 0x00000000; PROVEN: Hi3516E V300 data sheet (Issue 00B06, 2019-05-15), section 13.2.6, PDF page 823).";
        field {
            name = "chan0_cipher_din";
            desc = "Channel 0 Din for the symmetric algorithm (little endian) AES: (1) If the 1-CFB mode is selected, chan0_cipher_din[0] is valid. (2) If the 8-CFB mode is selected, chan0_cipher_din[7:0] is valid. (3) If the 128-CFB mode is selected, 128 bits are all valid. (4) In other modes, 128 bits are all valid.";
            sw = rw; hw = r;
            reset = 0x0;
        } chan0_cipher_din[31:0];
    };
    CHAN0_CIPHER_DIN_t CHAN0_CIPHER_DIN_0 @ 0x420;
    CHAN0_CIPHER_DIN_t CHAN0_CIPHER_DIN_1 @ 0x424;
    CHAN0_CIPHER_DIN_t CHAN0_CIPHER_DIN_2 @ 0x428;
    CHAN0_CIPHER_DIN_t CHAN0_CIPHER_DIN_3 @ 0x42C;
    reg CHANN_CIPHER_CTRL_t {
        name = "CHANN_CIPHER_CTRL";
        desc = "CHANN_CIPHER_CTRL is the encryption/decryption control register for the symmetric algorithm of channel n. (offset 0x480, 2 instances at stride 0x80; total reset 0x00400000; PROVEN: Hi3516E V300 data sheet (Issue 00B06, 2019-05-15), section 13.2.6, PDF page 823).";
        field {
            name = "weight";
            desc = "Weight of the current channel; weight x 4 blocks (Four blocks are used when the value is 0.)";
            sw = rw; hw = r;
            reset = 0x1;
        } weight[31:22];
        field {
            name = "reserved";
            desc = "Reserved";
            sw = r; hw = w;
            reset = 0x0;
        } reserved_21_18[21:18];
        field {
            name = "sym_chn_din_byte_swap_en";
            desc = "Din byte order change enable
- 0: disabled
- 1: enabled";
            sw = rw; hw = r;
            reset = 0x0;
        } sym_chn_din_byte_swap_en[17:17];
        field {
            name = "sym_chn_dout_byte_swap_en";
            desc = "Dout byte order change enable
- 0: disabled
- 1: enabled";
            sw = rw; hw = r;
            reset = 0x0;
        } sym_chn_dout_byte_swap_en[16:16];
        field {
            name = "reserved";
            desc = "Reserved";
            sw = r; hw = w;
            reset = 0x0;
        } reserved_15_15[15:15];
        field {
            name = "sym_chn_key_sel";
            desc = "Key source select
- 0: keys configured by the CPU
- 1: keys configured by hardware";
            sw = rw; hw = r;
            reset = 0x0;
        } sym_chn_key_sel[14:14];
        field {
            name = "reserved";
            desc = "Reserved";
            sw = r; hw = w;
            reset = 0x0;
        } reserved_13_12[13:12];
        field {
            name = "sym_chn_key_length";
            desc = "Key length AES:
- 00: 128 bits
- 01: 192 bits";
            sw = rw; hw = r;
            reset = 0x0;
        } sym_chn_key_length[11:10];
        field {
            name = "sym_chn_dat_width";
            desc = "Data bit width AES:
- 00: 128 bits
- 01: 8 bits
- 10: 1 bit
- 11: 128 bits";
            sw = rw; hw = r;
            reset = 0x0;
        } sym_chn_dat_width[9:8];
        field {
            name = "sym_chn_decrypt";
            desc = "Encryption or decryption
- 0: 0: encryption
- 1: decryption";
            sw = rw; hw = r;
            reset = 0x0;
        } sym_chn_decrypt[7:7];
        field {
            name = "sym_chn_alg_sel";
            desc = "Algorithm select
- 010: AES
- 101: DMA copy

Other values: AES";
            sw = rw; hw = r;
            reset = 0x0;
        } sym_chn_alg_sel[6:4];
        field {
            name = "sym_chn_alg_mode";
            desc = "Operating mode AES:
- 000: ECB
- 001: CBC
- 010: CFB
- 011: OFB
- 100: CTR

Other values: ECB";
            sw = rw; hw = r;
            reset = 0x0;
        } sym_chn_alg_mode[3:1];
        field {
            name = "reserved";
            desc = "Reserved";
            sw = r; hw = w;
            reset = 0x0;
        } reserved_0_0[0:0];
    };
    CHANN_CIPHER_CTRL_t CHANN_CIPHER_CTRL_1 @ 0x480;
    CHANN_CIPHER_CTRL_t CHANN_CIPHER_CTRL_2 @ 0x500;
    reg CHANN_CIPHER_IN_NODE_CFG_t {
        name = "CHANN_CIPHER_IN_NODE_CFG";
        desc = "CHANN_CIPHER_IN_NODE_CFG is the input node configuration register for channel n. (offset 0x484, 2 instances at stride 0x80; total reset 0x00000000; PROVEN: Hi3516E V300 data sheet (Issue 00B06, 2019-05-15), section 13.2.6, PDF page 824).";
        field {
            name = "reserved";
            desc = "Reserved";
            sw = r; hw = w;
            reset = 0x0;
        } reserved_31_31[31:31];
        field {
            name = "cipher_in_node_total_num";
            desc = "Total depth of the input node";
            sw = rw; hw = r;
            reset = 0x0;
        } cipher_in_node_total_num[30:24];
        field {
            name = "reserved";
            desc = "Reserved";
            sw = r; hw = w;
            reset = 0x0;
        } reserved_23_23[23:23];
        field {
            name = "cipher_in_node_wptr";
            desc = "Write pointer to the input node";
            sw = rw; hw = r;
            reset = 0x0;
        } cipher_in_node_wptr[22:16];
        field {
            name = "reserved";
            desc = "Reserved";
            sw = r; hw = w;
            reset = 0x0;
        } reserved_15_15[15:15];
        field {
            name = "cipher_in_node_rptr";
            desc = "Read pointer to the input node";
            sw = r; hw = w;
            reset = 0x0;
        } cipher_in_node_rptr[14:8];
        field {
            name = "reserved";
            desc = "Reserved";
            sw = r; hw = w;
            reset = 0x0;
        } reserved_7_7[7:7];
        field {
            name = "cipher_in_node_mpackage_int_level";
            desc = "Interrupt level of multiple input nodes";
            sw = rw; hw = r;
            reset = 0x0;
        } cipher_in_node_mpackage_int_level[6:0];
    };
    CHANN_CIPHER_IN_NODE_CFG_t CHANN_CIPHER_IN_NODE_CFG_1 @ 0x484;
    CHANN_CIPHER_IN_NODE_CFG_t CHANN_CIPHER_IN_NODE_CFG_2 @ 0x504;
    reg CHANN_CIPHER_IN_NODE_START_ADDR_t {
        name = "CHANN_CIPHER_IN_NODE_START_ADDR";
        desc = "CHANN_CIPHER_IN_NODE_START_ADDR is the input node start address register for channel n. (offset 0x488, 2 instances at stride 0x80; total reset 0x00000000; PROVEN: Hi3516E V300 data sheet (Issue 00B06, 2019-05-15), section 13.2.6, PDF page 825).";
        field {
            name = "cipher_in_node_start_addr";
            desc = "Start address of the input node, which is used to read this input node (name split across lines in the data sheet table)";
            sw = rw; hw = r;
            reset = 0x0;
        } cipher_in_node_start_addr[31:0];
    };
    CHANN_CIPHER_IN_NODE_START_ADDR_t CHANN_CIPHER_IN_NODE_START_ADDR_1 @ 0x488;
    CHANN_CIPHER_IN_NODE_START_ADDR_t CHANN_CIPHER_IN_NODE_START_ADDR_2 @ 0x508;
    reg CHANN_CIPHER_IN_BUF_RPTR_t {
        name = "CHANN_CIPHER_IN_BUF_RPTR";
        desc = "CHANN_CIPHER_IN_BUF_RPTR is the input buffer read address register for channel n. (offset 0x48C, 2 instances at stride 0x80; total reset 0x00000000; PROVEN: Hi3516E V300 data sheet (Issue 00B06, 2019-05-15), section 13.2.6, PDF page 825).";
        field {
            name = "cipher_in_buf_rptr";
            desc = "Read address of the input buffer";
            sw = r; hw = w;
            reset = 0x0;
        } cipher_in_buf_rptr[31:0];
    };
    CHANN_CIPHER_IN_BUF_RPTR_t CHANN_CIPHER_IN_BUF_RPTR_1 @ 0x48C;
    CHANN_CIPHER_IN_BUF_RPTR_t CHANN_CIPHER_IN_BUF_RPTR_2 @ 0x50C;
    reg CHANN_CIPHER_IN_LEFT_BYTE_t {
        name = "CHANN_CIPHER_IN_LEFT_BYTE";
        desc = "CHANN_CIPHER_IN_LEFT_BYTE is the left-byte count register for the current read data for channel n. (offset 0x490, 2 instances at stride 0x80; total reset 0x00000000; PROVEN: Hi3516E V300 data sheet (Issue 00B06, 2019-05-15), section 13.2.6, PDF page 825).";
        field {
            name = "reserved";
            desc = "Reserved";
            sw = r; hw = w;
            reset = 0x0;
        } reserved_31_4[31:4];
        field {
            name = "in_left_byte";
            desc = "Number of remaining bytes in the read data";
            sw = r; hw = w;
            reset = 0x0;
        } in_left_byte[3:0];
    };
    CHANN_CIPHER_IN_LEFT_BYTE_t CHANN_CIPHER_IN_LEFT_BYTE_1 @ 0x490;
    CHANN_CIPHER_IN_LEFT_BYTE_t CHANN_CIPHER_IN_LEFT_BYTE_2 @ 0x510;
    reg CHANN_CIPHER_IN_LEFT_WORD0_t {
        name = "CHANN_CIPHER_IN_LEFT_WORD0";
        desc = "CHANN_CIPHER_IN_LEFT_WORD0 is the left-word register for the current read data of channel n. (offset 0x494, 2 instances at stride 0x80; total reset 0x00000000; PROVEN: Hi3516E V300 data sheet (Issue 00B06, 2019-05-15), section 13.2.6, PDF page 825).";
        field {
            name = "cipher_in_left_wordFirst0";
            desc = "word in the remaining data";
            sw = r; hw = w;
            reset = 0x0;
        } cipher_in_left_wordFirst0[31:0];
    };
    CHANN_CIPHER_IN_LEFT_WORD0_t CHANN_CIPHER_IN_LEFT_WORD0_1 @ 0x494;
    CHANN_CIPHER_IN_LEFT_WORD0_t CHANN_CIPHER_IN_LEFT_WORD0_2 @ 0x514;
    reg CHANN_CIPHER_IN_LEFT_WORD1_t {
        name = "CHANN_CIPHER_IN_LEFT_WORD1";
        desc = "CHANN_CIPHER_IN_LEFT_WORD1 is the left-word register for the current read data of channel n. (offset 0x498, 2 instances at stride 0x80; total reset 0x00000000; PROVEN: Hi3516E V300 data sheet (Issue 00B06, 2019-05-15), section 13.2.6, PDF page 826).";
        field {
            name = "cipher_in_left_wordSecond1";
            desc = "word in the remaining data";
            sw = r; hw = w;
            reset = 0x0;
        } cipher_in_left_wordSecond1[31:0];
    };
    CHANN_CIPHER_IN_LEFT_WORD1_t CHANN_CIPHER_IN_LEFT_WORD1_1 @ 0x498;
    CHANN_CIPHER_IN_LEFT_WORD1_t CHANN_CIPHER_IN_LEFT_WORD1_2 @ 0x518;
    reg CHANN_CIPHER_IN_LEFT_WORD2_t {
        name = "CHANN_CIPHER_IN_LEFT_WORD2";
        desc = "CHANN_CIPHER_IN_LEFT_WORD2 is the left-word register for the current read data of channel n. (offset 0x49C, 2 instances at stride 0x80; total reset 0x00000000; PROVEN: Hi3516E V300 data sheet (Issue 00B06, 2019-05-15), section 13.2.6, PDF page 826).";
        field {
            name = "cipher_in_left_wordThird2";
            desc = "word in the remaining data";
            sw = r; hw = w;
            reset = 0x0;
        } cipher_in_left_wordThird2[31:0];
    };
    CHANN_CIPHER_IN_LEFT_WORD2_t CHANN_CIPHER_IN_LEFT_WORD2_1 @ 0x49C;
    CHANN_CIPHER_IN_LEFT_WORD2_t CHANN_CIPHER_IN_LEFT_WORD2_2 @ 0x51C;
    reg CHANN_CIPHER_IN_BUF_REST_LEN_t {
        name = "CHANN_CIPHER_IN_BUF_REST_LEN";
        desc = "CHANN_CIPHER_IN_BUF_REST_LEN is the remaining length register for the input buffer of channel n. (offset 0x4A0, 2 instances at stride 0x80; total reset 0x00000000; PROVEN: Hi3516E V300 data sheet (Issue 00B06, 2019-05-15), section 13.2.6, PDF page 826).";
        field {
            name = "cipher_in_buf_rest_len";
            desc = "Remaining length of the input buffer of channel n, in bytes (name split across lines in the data sheet table)";
            sw = r; hw = w;
            reset = 0x0;
        } cipher_in_buf_rest_len[31:0];
    };
    CHANN_CIPHER_IN_BUF_REST_LEN_t CHANN_CIPHER_IN_BUF_REST_LEN_1 @ 0x4A0;
    CHANN_CIPHER_IN_BUF_REST_LEN_t CHANN_CIPHER_IN_BUF_REST_LEN_2 @ 0x520;
    reg CHANN_CIPHER_OUT_NODE_CFG_t {
        name = "CHANN_CIPHER_OUT_NODE_CFG";
        desc = "CHANN_CIPHER_OUT_NODE_CFG is the output node configuration register for channel n. (offset 0x4B0, 2 instances at stride 0x80; total reset 0x00000000; PROVEN: Hi3516E V300 data sheet (Issue 00B06, 2019-05-15), section 13.2.6, PDF page 826).";
        field {
            name = "reserved";
            desc = "Reserved";
            sw = r; hw = w;
            reset = 0x0;
        } reserved_31_31[31:31];
        field {
            name = "cipher_out_node_total_num";
            desc = "Total depth of the output node";
            sw = rw; hw = r;
            reset = 0x0;
        } cipher_out_node_total_num[30:24];
        field {
            name = "reserved";
            desc = "Reserved";
            sw = r; hw = w;
            reset = 0x0;
        } reserved_23_23[23:23];
        field {
            name = "cipher_out_node_wptr";
            desc = "Write pointer to the output node";
            sw = rw; hw = r;
            reset = 0x0;
        } cipher_out_node_wptr[22:16];
        field {
            name = "reserved";
            desc = "Reserved";
            sw = r; hw = w;
            reset = 0x0;
        } reserved_15_15[15:15];
        field {
            name = "cipher_out_node_rptr";
            desc = "Read pointer to the output node";
            sw = r; hw = w;
            reset = 0x0;
        } cipher_out_node_rptr[14:8];
        field {
            name = "reserved";
            desc = "Reserved";
            sw = r; hw = w;
            reset = 0x0;
        } reserved_7_7[7:7];
        field {
            name = "cipher_out_node_mpackage_int_level";
            desc = "Interrupt level of multiple output nodes";
            sw = rw; hw = r;
            reset = 0x0;
        } cipher_out_node_mpackage_int_level[6:0];
    };
    CHANN_CIPHER_OUT_NODE_CFG_t CHANN_CIPHER_OUT_NODE_CFG_1 @ 0x4B0;
    CHANN_CIPHER_OUT_NODE_CFG_t CHANN_CIPHER_OUT_NODE_CFG_2 @ 0x530;
    reg CHANN_CIPHER_OUT_NODE_START_ADDR_t {
        name = "CHANN_CIPHER_OUT_NODE_START_ADDR";
        desc = "CHANN_CIPHER_OUT_NODE_START_ADDR is the output node start address register for channel n. (offset 0x4B4, 2 instances at stride 0x80; total reset 0x00000000; PROVEN: Hi3516E V300 data sheet (Issue 00B06, 2019-05-15), section 13.2.6, PDF page 827).";
        field {
            name = "cipher_out_node_start_addr";
            desc = "Start address of the output node, which is used to read this output node (name split across lines in the data sheet table)";
            sw = rw; hw = r;
            reset = 0x0;
        } cipher_out_node_start_addr[31:0];
    };
    CHANN_CIPHER_OUT_NODE_START_ADDR_t CHANN_CIPHER_OUT_NODE_START_ADDR_1 @ 0x4B4;
    CHANN_CIPHER_OUT_NODE_START_ADDR_t CHANN_CIPHER_OUT_NODE_START_ADDR_2 @ 0x534;
    reg CHANN_CIPHER_OUT_BUF_RPTR_t {
        name = "CHANN_CIPHER_OUT_BUF_RPTR";
        desc = "CHANN_CIPHER_OUT_BUF_RPTR is the output buffer read address register for channel n. (offset 0x4B8, 2 instances at stride 0x80; total reset 0x00000000; PROVEN: Hi3516E V300 data sheet (Issue 00B06, 2019-05-15), section 13.2.6, PDF page 827).";
        field {
            name = "cipher_out_buf_rptr";
            desc = "Read address of the output buffer";
            sw = r; hw = w;
            reset = 0x0;
        } cipher_out_buf_rptr[31:0];
    };
    CHANN_CIPHER_OUT_BUF_RPTR_t CHANN_CIPHER_OUT_BUF_RPTR_1 @ 0x4B8;
    CHANN_CIPHER_OUT_BUF_RPTR_t CHANN_CIPHER_OUT_BUF_RPTR_2 @ 0x538;
    reg CHANN_CIPHER_OUT_LEFT_BYTE_t {
        name = "CHANN_CIPHER_OUT_LEFT_BYTE";
        desc = "CHANN_CIPHER_OUT_LEFT_BYTE is the left-byte register for the current output data of channel n. (offset 0x4C0, 2 instances at stride 0x80; total reset 0x00000000; PROVEN: Hi3516E V300 data sheet (Issue 00B06, 2019-05-15), section 13.2.6, PDF page 827).";
        field {
            name = "reserved";
            desc = "Reserved";
            sw = r; hw = w;
            reset = 0x0;
        } reserved_31_7[31:7];
        field {
            name = "out_left_byte";
            desc = "Number of remaining bytes in the write data";
            sw = r; hw = w;
            reset = 0x0;
        } out_left_byte[6:0];
    };
    CHANN_CIPHER_OUT_LEFT_BYTE_t CHANN_CIPHER_OUT_LEFT_BYTE_1 @ 0x4C0;
    CHANN_CIPHER_OUT_LEFT_BYTE_t CHANN_CIPHER_OUT_LEFT_BYTE_2 @ 0x540;
    reg CHANN_CIPHER_OUT_LEFT_WORD0_t {
        name = "CHANN_CIPHER_OUT_LEFT_WORD0";
        desc = "CHANN_CIPHER_OUT_LEFT_WORD0 is the left-word register for the current output data of channel n. (offset 0x4C4, 2 instances at stride 0x80; total reset 0x00000000; PROVEN: Hi3516E V300 data sheet (Issue 00B06, 2019-05-15), section 13.2.6, PDF page 828).";
        field {
            name = "cipher_out_left_worFirstd0";
            desc = "word in the remaining data";
            sw = r; hw = w;
            reset = 0x0;
        } cipher_out_left_worFirstd0[31:0];
    };
    CHANN_CIPHER_OUT_LEFT_WORD0_t CHANN_CIPHER_OUT_LEFT_WORD0_1 @ 0x4C4;
    CHANN_CIPHER_OUT_LEFT_WORD0_t CHANN_CIPHER_OUT_LEFT_WORD0_2 @ 0x544;
    reg CHANN_CIPHER_OUT_LEFT_WORD1_t {
        name = "CHANN_CIPHER_OUT_LEFT_WORD1";
        desc = "CHANN_CIPHER_OUT_LEFT_WORD1 is the left-word register for the current output data of channel n. (offset 0x4C8, 2 instances at stride 0x80; total reset 0x00000000; PROVEN: Hi3516E V300 data sheet (Issue 00B06, 2019-05-15), section 13.2.6, PDF page 828).";
        field {
            name = "cipher_out_left_worSecondd1";
            desc = "word in the remaining data";
            sw = r; hw = w;
            reset = 0x0;
        } cipher_out_left_worSecondd1[31:0];
    };
    CHANN_CIPHER_OUT_LEFT_WORD1_t CHANN_CIPHER_OUT_LEFT_WORD1_1 @ 0x4C8;
    CHANN_CIPHER_OUT_LEFT_WORD1_t CHANN_CIPHER_OUT_LEFT_WORD1_2 @ 0x548;
    reg CHANN_CIPHER_OUT_LEFT_WORD2_t {
        name = "CHANN_CIPHER_OUT_LEFT_WORD2";
        desc = "CHANN_CIPHER_OUT_LEFT_WORD2 is the left-word register for the current output data of channel n. (offset 0x4CC, 2 instances at stride 0x80; total reset 0x00000000; PROVEN: Hi3516E V300 data sheet (Issue 00B06, 2019-05-15), section 13.2.6, PDF page 828).";
        field {
            name = "cipher_out_left_worThirdd2";
            desc = "word in the remaining data";
            sw = r; hw = w;
            reset = 0x0;
        } cipher_out_left_worThirdd2[31:0];
    };
    CHANN_CIPHER_OUT_LEFT_WORD2_t CHANN_CIPHER_OUT_LEFT_WORD2_1 @ 0x4CC;
    CHANN_CIPHER_OUT_LEFT_WORD2_t CHANN_CIPHER_OUT_LEFT_WORD2_2 @ 0x54C;
    reg CHANN_CIPHER_OUT_BUF_REST_LEN_t {
        name = "CHANN_CIPHER_OUT_BUF_REST_LEN";
        desc = "CHANN_CIPHER_OUT_BUF_REST_LEN is the remaining length register for the output buffer of channel n. (offset 0x4D0, 2 instances at stride 0x80; total reset 0x00000000; PROVEN: Hi3516E V300 data sheet (Issue 00B06, 2019-05-15), section 13.2.6, PDF page 828).";
        field {
            name = "cipher_out_buf_rest_len";
            desc = "Remaining length of the output buffer of channel n, in bytes (name split across lines in the data sheet table)";
            sw = r; hw = w;
            reset = 0x0;
        } cipher_out_buf_rest_len[31:0];
    };
    CHANN_CIPHER_OUT_BUF_REST_LEN_t CHANN_CIPHER_OUT_BUF_REST_LEN_1 @ 0x4D0;
    CHANN_CIPHER_OUT_BUF_REST_LEN_t CHANN_CIPHER_OUT_BUF_REST_LEN_2 @ 0x550;
    reg {
        name = "CHAN0_HASH_CTRL";
        desc = "CHAN0_HASH_CTRL is the hash control register of channel 0. (offset 0x800; total reset 0x00000200; PROVEN: Hi3516E V300 data sheet (Issue 00B06, 2019-05-15), section 13.2.6, PDF page 829).";
        field {
            name = "reserved";
            desc = "Reserved";
            sw = r; hw = w;
            reset = 0x0;
        } reserved_31_14[31:14];
        field {
            name = "reserved";
            desc = "Reserved";
            sw = r; hw = w;
            reset = 0x1;
        } reserved_13_13[13:13];
        field {
            name = "reserved";
            desc = "Reserved";
            sw = r; hw = w;
            reset = 0x0;
        } reserved_12_12[12:12];
        field {
            name = "hash_ch0_hmac_key_addr";
            desc = "Key address for HMAC key calculation. Key addresses 0-2 correspond to channels 0-2, respectively.";
            sw = rw; hw = r;
            reset = 0x0;
        } hash_ch0_hmac_key_addr[11:10];
        field {
            name = "reserved";
            desc = "Reserved";
            sw = r; hw = w;
            reset = 0x0;
        } reserved_9_9[9:9];
        field {
            name = "reserved";
            desc = "Reserved";
            sw = r; hw = w;
            reset = 0x0;
        } reserved_8_7[8:7];
        field {
            name = "hash_ch0_key_sel";
            desc = "HMAC key select
- 0: keys configured by the CPU
- 1: keys configured by hardware";
            sw = rw; hw = r;
            reset = 0x0;
        } hash_ch0_key_sel[6:6];
        field {
            name = "hash_ch0_mode";
            desc = "Calculation mode
- 0: Raw hash calculation
- 1: HMAC calculation";
            sw = rw; hw = r;
            reset = 0x0;
        } hash_ch0_mode[5:5];
        field {
            name = "hash_ch0_hmac_calc_step";
            desc = "HMAC calculation select for the HMAC calculation
- 0: key calculation
- 1: message hash calculation";
            sw = rw; hw = r;
            reset = 0x0;
        } hash_ch0_hmac_calc_step[4:4];
        field {
            name = "hash_ch0_agl_sel";
            desc = "Algorithm mode
- 000: SHA1
- 001: SHA244
- 010: SHA256

Other values: SHA256";
            sw = rw; hw = r;
            reset = 0x0;
        } hash_ch0_agl_sel[3:1];
        field {
            name = "hash_ch0_start";
            desc = "Whether the hash block is started
- 0: no
- 1: yes";
            sw = rw; hw = r;
            reset = 0x0;
        } hash_ch0_start[0:0];
    } CHAN0_HASH_CTRL @ 0x800;
    reg {
        name = "HASH_INT_STATUS";
        desc = "HASH_INT_STATUS is the hash interrupt status register. (offset 0x804; total reset 0x00000000; PROVEN: Hi3516E V300 data sheet (Issue 00B06, 2019-05-15), section 13.2.6, PDF page 830).";
        field {
            name = "reserved";
            desc = "Reserved";
            sw = r; hw = w;
            reset = 0x0;
        } reserved_31_26[31:26];
        field {
            name = "hash_chn_oram_int";
            desc = "Output RAM data interrupt for channel n
- 0: No interrupt is generated.
- 1: An interrupt is generated.

Bits 25-18 correspond to channels 7-0, respectively.";
            sw = r; hw = w;
            reset = 0x0;
        } hash_chn_oram_int[25:18];
        field {
            name = "reserved";
            desc = "Reserved";
            sw = r; hw = w;
            reset = 0x0;
        } reserved_17_0[17:0];
    } HASH_INT_STATUS @ 0x804;
    reg {
        name = "HASH_INT_EN";
        desc = "HASH_INT_EN is the hash interrupt enable register. (offset 0x808; total reset 0x00000000; PROVEN: Hi3516E V300 data sheet (Issue 00B06, 2019-05-15), section 13.2.6, PDF page 830).";
        field {
            name = "reserved";
            desc = "Reserved";
            sw = r; hw = w;
            reset = 0x0;
        } reserved_31_31[31:31];
        field {
            name = "hash_int_en";
            desc = "Global hash interrupt enable
- 0: disabled
- 1: enabled";
            sw = rw; hw = r;
            reset = 0x0;
        } hash_int_en[30:30];
        field {
            name = "reserved";
            desc = "Reserved";
            sw = r; hw = w;
            reset = 0x0;
        } reserved_29_26[29:26];
        field {
            name = "hash_chn_oram_en";
            desc = "Output queue data interrupt enable for channel 7. An interrupt is reported when the result is written to a RAM.
- 0: disabled
- 1: enabled

Bits 25-18 correspond to channels 7-0, respectively.";
            sw = rw; hw = r;
            reset = 0x0;
        } hash_chn_oram_en[25:18];
        field {
            name = "reserved";
            desc = "Reserved";
            sw = r; hw = w;
            reset = 0x0;
        } reserved_17_0[17:0];
    } HASH_INT_EN @ 0x808;
    reg {
        name = "HASH_INT_RAW";
        desc = "HASH_INT_RAW is the hash raw interrupt status register. (offset 0x80C; total reset 0x00000000; PROVEN: Hi3516E V300 data sheet (Issue 00B06, 2019-05-15), section 13.2.6, PDF page 830).";
        field {
            name = "reserved";
            desc = "Reserved";
            sw = r; hw = w;
            reset = 0x0;
        } reserved_31_26[31:26];
        field {
            name = "hash_chn_oram_raw";
            desc = "Raw output queue data interrupt for channel n
- 0: No interrupt is generated.
- 1: An interrupt is generated.

Bits 25-18 correspond to channels 7-0, respectively.";
            sw = rw; hw = r;
            reset = 0x0;
        } hash_chn_oram_raw[25:18];
        field {
            name = "reserved";
            desc = "Reserved";
            sw = r; hw = w;
            reset = 0x0;
        } reserved_17_0[17:0];
    } HASH_INT_RAW @ 0x80C;
    reg {
        name = "CHAN0_HASH_DAT_IN";
        desc = "CHAN0_HASH_DAT_IN is the CPU input data register. (offset 0x818; total reset 0x00000000; PROVEN: Hi3516E V300 data sheet (Issue 00B06, 2019-05-15), section 13.2.6, PDF page 831).";
        field {
            name = "chan0_hash_data_in";
            desc = "CPU data input register for channel 0";
            sw = w; hw = r;
            reset = 0x0;
        } chan0_hash_data_in[31:0];
    } CHAN0_HASH_DAT_IN @ 0x818;
    reg {
        name = "CHAN0_HASH_TOTAL_DAT_LEN";
        desc = "CHAN0_HASH_TOTAL_DAT_LEN is the CPU input data length register. (offset 0x81C; total reset 0x00000000; PROVEN: Hi3516E V300 data sheet (Issue 00B06, 2019-05-15), section 13.2.6, PDF page 831).";
        field {
            name = "chan0_hash_total_daCPUt_len";
            desc = "data length for channel 0, in bytes";
            sw = rw; hw = r;
            reset = 0x0;
        } chan0_hash_total_daCPUt_len[31:0];
    } CHAN0_HASH_TOTAL_DAT_LEN @ 0x81C;
    reg {
        name = "CHAN0_HASH_IN_DAT_LEN";
        desc = "CHAN0_HASH_IN_DAT_LEN is the input data length register for channel 0. (offset 0x820; total reset 0x00000000; PROVEN: Hi3516E V300 data sheet (Issue 00B06, 2019-05-15), section 13.2.6, PDF page 831).";
        field {
            name = "chan0_hash_in_dat_len";
            desc = "Length of the input data for channel 0, in hash blocks (name split across lines in the data sheet table)";
            sw = r; hw = w;
            reset = 0x0;
        } chan0_hash_in_dat_len[31:0];
    } CHAN0_HASH_IN_DAT_LEN @ 0x820;
    reg CHANN_HASH_CTRL_t {
        name = "CHANN_HASH_CTRL";
        desc = "CHANN_HASH_CTRL is the hash control register of channel y. (offset 0x880, 2 instances at stride 0x80; total reset 0x00000000; PROVEN: Hi3516E V300 data sheet (Issue 00B06, 2019-05-15), section 13.2.6, PDF page 832).";
        field {
            name = "reserved";
            desc = "Reserved";
            sw = r; hw = w;
            reset = 0x0;
        } reserved_31_8[31:8];
        field {
            name = "hash_chn_dat_in_byte_swap_en";
            desc = "Din byte order change enable
- 0: disabled
- 1: enabled";
            sw = rw; hw = r;
            reset = 0x0;
        } hash_chn_dat_in_byte_swap_en[7:7];
        field {
            name = "hash_chn_key_sel";
            desc = "HMAC key select
- 0: keys configured by the CPU
- 1: keys configured by hardware";
            sw = rw; hw = r;
            reset = 0x0;
        } hash_chn_key_sel[6:6];
        field {
            name = "hash_chn_mode";
            desc = "Calculation mode
- 0: Raw hash calculation
- 1: HMAC calculation";
            sw = rw; hw = r;
            reset = 0x0;
        } hash_chn_mode[5:5];
        field {
            name = "reserved";
            desc = "Reserved";
            sw = r; hw = w;
            reset = 0x0;
        } reserved_4_4[4:4];
        field {
            name = "hash_chn_agl_sel";
            desc = "Algorithm mode
- 000: SHA1
- 001: SHA244
- 010: SHA256

Other values: SHA256";
            sw = rw; hw = r;
            reset = 0x0;
        } hash_chn_agl_sel[3:1];
        field {
            name = "reserved";
            desc = "Reserved";
            sw = r; hw = w;
            reset = 0x0;
        } reserved_0_0[0:0];
    };
    CHANN_HASH_CTRL_t CHANN_HASH_CTRL_1 @ 0x880;
    CHANN_HASH_CTRL_t CHANN_HASH_CTRL_2 @ 0x900;
    reg CHANN_HASH_IN_NODE_CFG_t {
        name = "CHANN_HASH_IN_NODE_CFG";
        desc = "CHANN_HASH_IN_NODE_CFG is the input node configuration register for channel y. (offset 0x884, 2 instances at stride 0x80; total reset 0x00000000; PROVEN: Hi3516E V300 data sheet (Issue 00B06, 2019-05-15), section 13.2.6, PDF page 832).";
        field {
            name = "reserved";
            desc = "Reserved";
            sw = r; hw = w;
            reset = 0x0;
        } reserved_31_31[31:31];
        field {
            name = "hash_in_node_total_num";
            desc = "Total depth of the input node";
            sw = rw; hw = r;
            reset = 0x0;
        } hash_in_node_total_num[30:24];
        field {
            name = "reserved";
            desc = "Reserved";
            sw = r; hw = w;
            reset = 0x0;
        } reserved_23_23[23:23];
        field {
            name = "hash_in_node_wptr";
            desc = "Write pointer to the input node";
            sw = rw; hw = r;
            reset = 0x0;
        } hash_in_node_wptr[22:16];
        field {
            name = "reserved";
            desc = "Reserved";
            sw = r; hw = w;
            reset = 0x0;
        } reserved_15_15[15:15];
        field {
            name = "hash_in_node_rptr";
            desc = "Read pointer to the input node";
            sw = r; hw = w;
            reset = 0x0;
        } hash_in_node_rptr[14:8];
        field {
            name = "reserved";
            desc = "Reserved";
            sw = r; hw = w;
            reset = 0x0;
        } reserved_7_7[7:7];
        field {
            name = "hash_in_node_mpackage_int_level";
            desc = "Interrupt level of multiple input nodes";
            sw = r; hw = w;
            reset = 0x0;
        } hash_in_node_mpackage_int_level[6:0];
    };
    CHANN_HASH_IN_NODE_CFG_t CHANN_HASH_IN_NODE_CFG_1 @ 0x884;
    CHANN_HASH_IN_NODE_CFG_t CHANN_HASH_IN_NODE_CFG_2 @ 0x904;
    reg CHANN_HASH_IN_NODE_START_ADDR_t {
        name = "CHANN_HASH_IN_NODE_START_ADDR";
        desc = "CHANN_HASH_IN_NODE_START_ADDR is the input node start address register for channel y. (offset 0x888, 2 instances at stride 0x80; total reset 0x00000000; PROVEN: Hi3516E V300 data sheet (Issue 00B06, 2019-05-15), section 13.2.6, PDF page 833).";
        field {
            name = "hash_in_node_start_addr";
            desc = "Start address of the input node, which is used to read this input node (name split across lines in the data sheet table)";
            sw = rw; hw = r;
            reset = 0x0;
        } hash_in_node_start_addr[31:0];
    };
    CHANN_HASH_IN_NODE_START_ADDR_t CHANN_HASH_IN_NODE_START_ADDR_1 @ 0x888;
    CHANN_HASH_IN_NODE_START_ADDR_t CHANN_HASH_IN_NODE_START_ADDR_2 @ 0x908;
    reg CHANN_HASH_IN_BUF_RPTR_t {
        name = "CHANN_HASH_IN_BUF_RPTR";
        desc = "CHANN_HASH_IN_BUF_RPTR is the input buffer read address register for channel y. (offset 0x88C, 2 instances at stride 0x80; total reset 0x00000000; PROVEN: Hi3516E V300 data sheet (Issue 00B06, 2019-05-15), section 13.2.6, PDF page 833).";
        field {
            name = "hash_in_buf_rptr";
            desc = "Read address of the input buffer";
            sw = rw; hw = r;
            reset = 0x0;
        } hash_in_buf_rptr[31:0];
    };
    CHANN_HASH_IN_BUF_RPTR_t CHANN_HASH_IN_BUF_RPTR_1 @ 0x88C;
    CHANN_HASH_IN_BUF_RPTR_t CHANN_HASH_IN_BUF_RPTR_2 @ 0x90C;
    reg CHANN_HASH_IN_BUF_REST_LEN_t {
        name = "CHANN_HASH_IN_BUF_REST_LEN";
        desc = "CHANN_HASH_IN_BUF_REST_LEN is the remaining length register for the input buffer of channel y. (offset 0x890, 2 instances at stride 0x80; total reset 0x00000000; PROVEN: Hi3516E V300 data sheet (Issue 00B06, 2019-05-15), section 13.2.6, PDF page 833).";
        field {
            name = "hash_in_buf_rest_len";
            desc = "Remaining length of the input buffer of channel n, in bytes";
            sw = r; hw = w;
            reset = 0x0;
        } hash_in_buf_rest_len[31:0];
    };
    CHANN_HASH_IN_BUF_REST_LEN_t CHANN_HASH_IN_BUF_REST_LEN_1 @ 0x890;
    CHANN_HASH_IN_BUF_REST_LEN_t CHANN_HASH_IN_BUF_REST_LEN_2 @ 0x910;
};
`endif
