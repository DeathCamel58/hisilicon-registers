`ifndef HI3516EV300_SPACC_RDL
`define HI3516EV300_SPACC_RDL
regfile eHI3516EV300_SPACC {
    name = "SPACC cipher";
    desc = "SPACC cipher of the Hi3516E V300 at base 0x1005_0000. 34 registers extracted programmatically from the Hi3516E V300 data sheet (Issue 00B06, 2019-05-15) (Table 13-2 Summary of the SPACC registers (base address: 0x1005_0000)): register headings, offsets, total reset values, field bit ranges, access types, names, reset values and descriptions, with PDF page numbers in each register description. Field names, bit ranges, access types and offsets are exact; the free-text descriptions are taken from the cell text of the field table and were checked by sampling only. Hardware not verified.";
    reg {
        name = "CHAN0_CIPHER_IV";
        desc = "CHAN0_CIPHER_IV is the IVin and IVout register for the symmetric algorithm of the channel 0. (offset 0x0; total reset 0x00000000; PROVEN: Hi3516E V300 data sheet (Issue 00B06, 2019-05-15), section 13.2.6, PDF page 814).";
        field {
            name = "IVinandIVoutforthesymmetricalgorithmofchannel0(littleendian)(1)Ifthevectorconfigurationupdateisnotrequired(CHAN0_CIPHER_CTRL[sym_ch0_ivin_sel]='b0)),thelogicdoesnotneedtoreadthischan0_cipher_ivregisteragain.(2)Ifthevectorconfigurationupdateisrequired(CHAN0_CIPHER_CTRL[sym_ch0_ivin_sel]='b1),thelogicneedstoreadthisregisteragain.";
            desc = "";
            sw = rw; hw = r;
            reset = 0x0;
        } IVinandIVoutforthesymmetricalgorithmofchannel0_littleendian_1_Ifthevectorconfigurationupdateisnotrequired_CHAN0_CIPHER_CTRL_sym_ch0_ivin_sel_b0_thelogicdoesnotneedtoreadthischan0_cipher_ivregisteragain_2_Ifthevectorconfigurationupdateisrequired_CHAN0_CIPHER_CTRL_sym_ch0_ivin_sel_b1_thelogicneedstoreadthisregisteragain[31:0];
    } CHAN0_CIPHER_IV @ 0x0;
    reg {
        name = "CHAN0_CIPHER_DOUT";
        desc = "CHAN0_CIPHER_DOUT is the Dout register for the symmetric algorithm of channel 0. (offset 0x80; total reset 0x00000000; PROVEN: Hi3516E V300 data sheet (Issue 00B06, 2019-05-15), section 13.2.6, PDF page 815).";
        field {
            name = "Channel0Doutforthesymmetricalgorithm(littleendian)AES:(1)Ifthe1-CFBmodeisselected,chan0_cipher_dout[0]isvalid.chan0_cipher_dout(2)Ifthe8-CFBmodeisselected,chan0_cipher_dout[7:0]isvalid.(3)Ifthe128-CFBmodeisselected,128bitsareallvalid.(4)Inothermodes,128bitsareallvalid.";
            desc = "";
            sw = r; hw = w;
            reset = 0x0;
        } Channel0Doutforthesymmetricalgorithm_littleendian_AES_1_Ifthe1_CFBmodeisselected_chan0_cipher_dout_0_isvalid_chan0_cipher_dout_2_Ifthe8_CFBmodeisselected_chan0_cipher_dout_7_0_isvalid_3_Ifthe128_CFBmodeisselected_128bitsareallvalid_4_Inothermodes_128bitsareallvalid[31:0];
    } CHAN0_CIPHER_DOUT @ 0x80;
    reg {
        name = "CIPHER_KEY";
        desc = "CIPHER_KEY is the CPU key register for the symmetric algorithm. (offset 0x100; total reset 0x00000000; PROVEN: Hi3516E V300 data sheet (Issue 00B06, 2019-05-15), section 13.2.6, PDF page 816).";
        field {
            name = "CPUkeyregisterforthesymmetricalgorithm(littleendian).Itcannotberead,thatis,thereadresultis0.Thevalueofjforeachchannelis0-7,thatisatotalof256bits.0x0100-0x011Ccorrespondtothehostkeyofchannel0.Theruleappliestoothersimilarsituations.cipher_keyAESalgorithm:a)Ifa128-bitkeyisselected,cipher_key[127:0]isvalid.b)Ifa192-bitkeyisselected,cipher_key[191:0]isvalid.c)Ifa256-bitkeyoperationisperformed,256bitsareallvalid.";
            desc = "";
            sw = w; hw = r;
            reset = 0x0;
        } CPUkeyregisterforthesymmetricalgorithm_littleendian_Itcannotberead_thatis_thereadresultis0_Thevalueofjforeachchannelis0_7_thatisatotalof256bits_0x0100_0x011Ccorrespondtothehostkeyofchannel0_Theruleappliestoothersimilarsituations_cipher_keyAESalgorithm_a_Ifa128_bitkeyisselected_cipher_key_127_0_isvalid_b_Ifa192_bitkeyisselected_cipher_key_191_0_isvalid_c_Ifa256_bitkeyoperationisperformed_256bitsareallvalid[31:0];
    } CIPHER_KEY @ 0x100;
    reg {
        name = "SPACC_VERSION";
        desc = "SPACC_VERSION is the SPACC version register. (offset 0x308; total reset 0x02018121; PROVEN: Hi3516E V300 data sheet (Issue 00B06, 2019-05-15), section 13.2.6, PDF page 816).";
        field {
            name = "SPACCversionregister.Themacrodefinitionspacc_versionisused.";
            desc = "";
            sw = rw; hw = r;
            reset = 0x2018121;
        } SPACCversionregister_Themacrodefinitionspacc_versionisused[31:0];
    } SPACC_VERSION @ 0x308;
    reg {
        name = "MEM_EMA_CFG";
        desc = "MEM_EMA_CFG is the memory EMA configuration register. (offset 0x310; total reset 0x00009B13; PROVEN: Hi3516E V300 data sheet (Issue 00B06, 2019-05-15), section 13.2.6, PDF page 816).";
        field {
            name = "reserved";
            desc = "Reserved";
            sw = r; hw = w;
            reset = 0x0;
        } reserved_31_16[31:16];
        field {
            name = "rft_colldisn";
            desc = "RFT colldisn signal";
            sw = rw; hw = r;
            reset = 0x1;
        } rft_colldisn[15:15];
        field {
            name = "rft_emasa";
            desc = "RFT emasa signal";
            sw = rw; hw = r;
            reset = 0x0;
        } rft_emasa[14:14];
        field {
            name = "rft_emab";
            desc = "RFT emab signal";
            sw = rw; hw = r;
            reset = 0x3;
        } rft_emab[13:11];
        field {
            name = "rft_emaa";
            desc = "RFT emaa signal";
            sw = rw; hw = r;
            reset = 0x3;
        } rft_emaa[10:8];
        field {
            name = "reserved";
            desc = "Reserved";
            sw = r; hw = w;
            reset = 0x0;
        } reserved_7_6[7:6];
        field {
            name = "rfs_emaw";
            desc = "RFS emaw signal";
            sw = rw; hw = r;
            reset = 0x1;
        } rfs_emaw[5:4];
        field {
            name = "reserved";
            desc = "Reserved";
            sw = r; hw = w;
            reset = 0x0;
        } reserved_3_3[3:3];
        field {
            name = "rfs_ema";
            desc = "RFS ema signal";
            sw = rw; hw = r;
            reset = 0x3;
        } rfs_ema[2:0];
    } MEM_EMA_CFG @ 0x310;
    reg {
        name = "CALC_ERR";
        desc = "CALC_ERR is the alarm status register for the algorithm core. (offset 0x320; total reset 0x00000000; PROVEN: Hi3516E V300 data sheet (Issue 00B06, 2019-05-15), section 13.2.6, PDF page 817).";
        field {
            name = "reserved";
            desc = "Reserved";
            sw = r; hw = w;
            reset = 0x0;
        } reserved_31_2[31:2];
        field {
            name = "alg_len_err";
            desc = "When the length of a node is 0, an error is reported.";
            sw = r; hw = w;
            reset = 0x0;
        } alg_len_err[1:1];
        field {
            name = "reserved";
            desc = "Reserved";
            sw = r; hw = w;
            reset = 0x0;
        } reserved_0_0[0:0];
    } CALC_ERR @ 0x320;
    reg {
        name = "CHANN_HASH_STATE_VAL";
        desc = "CHANN_HASH_STATE_VAL is the hash input and output state value register for channel z. (offset 0x340; total reset 0x00000000; PROVEN: Hi3516E V300 data sheet (Issue 00B06, 2019-05-15), section 13.2.6, PDF page 817).";
        field {
            name = "hash_state_val";
            desc = "Hash result state value";
            sw = rw; hw = r;
            reset = 0x0;
        } hash_state_val[31:0];
    } CHANN_HASH_STATE_VAL @ 0x340;
    reg {
        name = "CHANN_HASH_STATE_VAL_ADDR";
        desc = "CHANN_HASH_STATE_VAL_ADDR is the hash input and output state value address register for channel z. (offset 0x344; total reset 0x00000000; PROVEN: Hi3516E V300 data sheet (Issue 00B06, 2019-05-15), section 13.2.6, PDF page 817).";
        field {
            name = "reserved";
            desc = "Reserved";
            sw = r; hw = w;
            reset = 0x0;
        } reserved_31_3[31:3];
        field {
            name = "hash_state_val_addr";
            desc = "Hash state value address. The maximum length is 8 words, that is, 256 bits.";
            sw = rw; hw = r;
            reset = 0x0;
        } hash_state_val_addr[2:0];
    } CHANN_HASH_STATE_VAL_ADDR @ 0x344;
    reg {
        name = "SPACC_CALC_CRG_CFG";
        desc = "SPACC_CALC_CRG_CFG is the SPACC internal algorithm core clock gating and reset configuration register. (offset 0x39C; total reset 0x801F2AAA; PROVEN: Hi3516E V300 data sheet (Issue 00B06, 2019-05-15), section 13.2.6, PDF page 818).";
        field {
            name = "spacc_core_auto_cken_bypass";
            desc = "Automatic clock gating enable for the algorithm core
- 0: enabled
- 1: disabled";
            sw = rw; hw = r;
            reset = 0x1;
        } spacc_core_auto_cken_bypass[31:31];
        field {
            name = "spacc_rft_mem_wr_clk_gt_en";
            desc = "Automatic write clock gating enable for the RFT memory
- 0: disabled
- 1: enabled";
            sw = rw; hw = r;
            reset = 0x0;
        } spacc_rft_mem_wr_clk_gt_en[30:30];
        field {
            name = "spacc_rft_mem_rd_clk_gt_en";
            desc = "Automatic read clock gating enable for the RFT memory
- 0: disabled
- 1: enabled";
            sw = rw; hw = r;
            reset = 0x0;
        } spacc_rft_mem_rd_clk_gt_en[29:29];
        field {
            name = "spacc_rfs_mem_clk_gt_en";
            desc = "Automatic clock gating enable for the RFS memory
- 0: disabled
- 1: enabled";
            sw = rw; hw = r;
            reset = 0x0;
        } spacc_rfs_mem_clk_gt_en[28:28];
        field {
            name = "reserved";
            desc = "Reserved";
            sw = r; hw = w;
            reset = 0x0;
        } reserved_27_21[27:21];
        field {
            name = "cken_in_ram";
            desc = "Clock enable for the RFT memory
- 0: disabled
- 1: enabled

It is used for internal debugging. For normal use, set the register to 1.";
            sw = rw; hw = r;
            reset = 0x1;
        } cken_in_ram[20:20];
        field {
            name = "cken_in_ram_a";
            desc = "Read port clock enable for the RFT memory
- 0: disabled
- 1: enabled

It is used for internal debugging. For normal use, set the register to 1.";
            sw = rw; hw = r;
            reset = 0x1;
        } cken_in_ram_a[19:19];
        field {
            name = "cken_in_ram_b";
            desc = "Write port clock enable for the RFT memory
- 0: disabled
- 1: enabled

It is used for internal debugging. For normal use, set the register to 1.";
            sw = rw; hw = r;
            reset = 0x1;
        } cken_in_ram_b[18:18];
        field {
            name = "cken_in_pipe_ib";
            desc = "pipe_ib clock enable for the RFT memory
- 0: disabled";
            sw = rw; hw = r;
            reset = 0x1;
        } cken_in_pipe_ib[17:17];
        field {
            name = "cken_in_pipe_i";
            desc = "pipe_i clock enable for the RFT memory
- 0: disabled
- 1: enabled

It is used for internal debugging. For normal use, set the register to 1.";
            sw = rw; hw = r;
            reset = 0x1;
        } cken_in_pipe_i[16:16];
        field {
            name = "reserved";
            desc = "Reserved";
            sw = r; hw = w;
            reset = 0x0;
        } reserved_15_14[15:14];
        field {
            name = "spacc_aes_core_srst_req";
            desc = "AES core soft reset request
- 0: not reset
- 1: reset";
            sw = rw; hw = r;
            reset = 0x0;
        } spacc_aes_core_srst_req[12:12];
        field {
            name = "reserved";
            desc = "Reserved";
            sw = r; hw = w;
            reset = 0xaa;
        } reserved_11_4[11:4];
        field {
            name = "spacc_sha1_core_clk_en";
            desc = "SHA1 core clock enable
- 0: disabled
- 1: enabled";
            sw = rw; hw = r;
            reset = 0x1;
        } spacc_sha1_core_clk_en[3:3];
        field {
            name = "spacc_sha1_core_srst_req";
            desc = "SHA1 core soft reset request
- 0: not reset
- 1: reset";
            sw = rw; hw = r;
            reset = 0x0;
        } spacc_sha1_core_srst_req[2:2];
        field {
            name = "spacc_sha2_core_clk_en";
            desc = "SHA2 core clock enable
- 0: disabled
- 1: enabled";
            sw = rw; hw = r;
            reset = 0x1;
        } spacc_sha2_core_clk_en[1:1];
        field {
            name = "spacc_sha2_core_srst_req";
            desc = "SHA2 core soft reset request
- 0: not reset
- 1: reset";
            sw = rw; hw = r;
            reset = 0x0;
        } spacc_sha2_core_srst_req[0:0];
    } SPACC_CALC_CRG_CFG @ 0x39C;
    reg {
        name = "CHAN0_CIPHER_CTRL";
        desc = "CHAN0_CIPHER_CTRL is the encryption/decryption control register for channel 0 of the symmetric algorithm. (offset 0x400; total reset 0x00000000; PROVEN: Hi3516E V300 data sheet (Issue 00B06, 2019-05-15), section 13.2.6, PDF page 819).";
        field {
            name = "reserved";
            desc = "Reserved";
            sw = r; hw = w;
            reset = 0x0;
        } reserved_31_16[31:16];
        field {
            name = "sym_ch0_ivin_sel";
            desc = "IVin input select for channel 0
- 0: IVin does not need to be configured.
- 1: IVin needs to be configured.";
            sw = rw; hw = r;
            reset = 0x0;
        } sym_ch0_ivin_sel[15:15];
        field {
            name = "sym_ch0_key_sel";
            desc = "Key source select
- 0: keys configured by the CPU
- 1: keys configured by hardware";
            sw = rw; hw = r;
            reset = 0x0;
        } sym_ch0_key_sel[14:14];
        field {
            name = "reserved";
            desc = "Reserved";
            sw = r; hw = w;
            reset = 0x0;
        } reserved_13_12[13:12];
        field {
            name = "sym_ch0_key_length";
            desc = "Key length AES:
- 00: 128 bits
- 01: 192 bits
- 10: 256 bits
- 11: 128 bits";
            sw = rw; hw = r;
            reset = 0x0;
        } sym_ch0_key_length[11:10];
        field {
            name = "sym_ch0_dat_width";
            desc = "Data bit width AES:
- 00: 128 bits
- 01: 8 bits
- 10: 1 bit
- 11: 128 bits";
            sw = rw; hw = r;
            reset = 0x0;
        } sym_ch0_dat_width[9:8];
        field {
            name = "sym_ch0_decrypt";
            desc = "Encryption or decryption
- 0: 0: encryption
- 1: decryption";
            sw = rw; hw = r;
            reset = 0x0;
        } sym_ch0_decrypt[7:7];
        field {
            name = "sym_ch0_alg_sel";
            desc = "Algorithm select
- 010: AES

Other values: AES";
            sw = rw; hw = r;
            reset = 0x0;
        } sym_ch0_alg_sel[6:4];
        field {
            name = "sym_ch0_alg_mode";
            desc = "Operating mode AES:
- 000: ECB
- 001: CBC
- 010: CFB
- 011: OFB
- 100: CTR

Other values: ECB";
            sw = rw; hw = r;
            reset = 0x0;
        } sym_ch0_alg_mode[3:1];
        field {
            name = "sym_ch0_start";
            desc = "Encryption/Decryption start signal for channel 0 (input transfer end)
- 0: not started (The input transfer is ended.)
- 1: started (The input transfer is not ended.)";
            sw = rw; hw = r;
            reset = 0x0;
        } sym_ch0_start[0:0];
    } CHAN0_CIPHER_CTRL @ 0x400;
    reg {
        name = "CIPHER_INT_STATUS";
        desc = "CIPHER_INT_STATUS is the interrupt status register for the symmetric algorithm. (offset 0x404; total reset 0x00000000; PROVEN: Hi3516E V300 data sheet (Issue 00B06, 2019-05-15), section 13.2.6, PDF page 821).";
        field {
            name = "reserved";
            desc = "Reserved";
            sw = r; hw = w;
            reset = 0x0;
        } reserved_31_17[31:17];
        field {
            name = "ahb_bus_err_int";
            desc = "AHB error interrupt
- 0: No interrupt is generated.
- 1: An interrupt is generated.";
            sw = r; hw = w;
            reset = 0x0;
        } ahb_bus_err_int[16:16];
        field {
            name = "cipher_chn_obuf_int";
            desc = "Output queue data interrupt for channel m
- 0: No interrupt is generated.
- 1: An interrupt is generated.

Bits 15-8 correspond to channels 7-0, respectively.";
            sw = r; hw = w;
            reset = 0x0;
        } cipher_chn_obuf_int[15:8];
        field {
            name = "cipher_chn_ibuf_int";
            desc = "Input queue data interrupt for channel n
- 0: No interrupt is generated.
- 1: An interrupt is generated.

Bits 7-1 correspond to channels 7-1, respectively.";
            sw = r; hw = w;
            reset = 0x0;
        } cipher_chn_ibuf_int[7:1];
        field {
            name = "reserved";
            desc = "Reserved";
            sw = r; hw = w;
            reset = 0x0;
        } reserved_0_0[0:0];
    } CIPHER_INT_STATUS @ 0x404;
    reg {
        name = "CIPHER_INT_EN";
        desc = "CIPHER_INT_EN is the interrupt enable register for the symmetric algorithm. (offset 0x408; total reset 0x00000000; PROVEN: Hi3516E V300 data sheet (Issue 00B06, 2019-05-15), section 13.2.6, PDF page 821).";
        field {
            name = "reserved";
            desc = "Reserved";
            sw = r; hw = w;
            reset = 0x0;
        } reserved_31_31[31:31];
        field {
            name = "cipher_int_en";
            desc = "Global channel interrupt enable for the Cipher module
- 0: disabled
- 1: enabled";
            sw = rw; hw = r;
            reset = 0x0;
        } cipher_int_en[30:30];
        field {
            name = "reserved";
            desc = "Reserved";
            sw = r; hw = w;
            reset = 0x0;
        } reserved_29_17[29:17];
        field {
            name = "ahb_bus_err_int_en";
            desc = "AHB error interrupt enable
- 0: disabled
- 1: enabled";
            sw = rw; hw = r;
            reset = 0x0;
        } ahb_bus_err_int_en[16:16];
        field {
            name = "cipher_chn_obuf_en";
            desc = "Output queue data interrupt enable for channel m
- 0: disabled
- 1: enabled

Bits 15-8 correspond to channels 7-0, respectively.";
            sw = rw; hw = r;
            reset = 0x0;
        } cipher_chn_obuf_en[15:8];
        field {
            name = "cipher_chn_ibuf_en";
            desc = "Input queue data interrupt enable for channel 7
- 0: disabled
- 1: enabled

Bits 7-1 correspond to channels 7-1, respectively.";
            sw = rw; hw = r;
            reset = 0x0;
        } cipher_chn_ibuf_en[7:1];
        field {
            name = "reserved";
            desc = "Reserved";
            sw = r; hw = w;
            reset = 0x0;
        } reserved_0_0[0:0];
    } CIPHER_INT_EN @ 0x408;
    reg {
        name = "CIPHER_INT_RAW";
        desc = "CIPHER_INT_RAW is the interrupt status register for the symmetric algorithm. (offset 0x40C; total reset 0x00000000; PROVEN: Hi3516E V300 data sheet (Issue 00B06, 2019-05-15), section 13.2.6, PDF page 822).";
        field {
            name = "reserved";
            desc = "Reserved";
            sw = r; hw = w;
            reset = 0x0;
        } reserved_31_17[31:17];
        field {
            name = "ahb_bus_err_int_raw";
            desc = "AHB error raw interrupt
- 0: No interrupt is generated.
- 1: An interrupt is generated.

Access type RWC in the data sheet: written 1 clears the bit.";
            sw = rw; hw = w; onwrite = woclr;
            reset = 0x0;
        } ahb_bus_err_int_raw[16:16];
        field {
            name = "cipher_chn_obuf_raw";
            desc = "Raw output queue data interrupt for channel m
- 0: No interrupt is generated.
- 1: An interrupt is generated.

Bits 15-8 correspond to channels 7-0, respectively.

Access type RWC in the data sheet: written 1 clears the bit.";
            sw = rw; hw = w; onwrite = woclr;
            reset = 0x0;
        } cipher_chn_obuf_raw[15:8];
        field {
            name = "cipher_chn_ibuf_raw";
            desc = "Raw input queue data interrupt for channel n
- 0: No interrupt is generated.
- 1: An interrupt is generated.

Bits 7-1 correspond to channels 7-1, respectively.

Access type RWC in the data sheet: written 1 clears the bit.";
            sw = rw; hw = w; onwrite = woclr;
            reset = 0x0;
        } cipher_chn_ibuf_raw[7:1];
        field {
            name = "reserved";
            desc = "Reserved";
            sw = r; hw = w;
            reset = 0x0;
        } reserved_0_0[0:0];
    } CIPHER_INT_RAW @ 0x40C;
    reg {
        name = "CHAN0_CIPHER_DIN";
        desc = "CHAN0_CIPHER_DIN is the channel 0 Din register for the symmetric algorithm. (offset 0x420; total reset 0x00000000; PROVEN: Hi3516E V300 data sheet (Issue 00B06, 2019-05-15), section 13.2.6, PDF page 823).";
        field {
            name = "Channel0Dinforthesymmetricalgorithm(littleendian)AES:(1)Ifthe1-CFBmodeisselected,chan0_cipher_din[0]isvalid.chan0_cipher_din(2)Ifthe8-CFBmodeisselected,chan0_cipher_din[7:0]isvalid.(3)Ifthe128-CFBmodeisselected,128bitsareallvalid.(4)Inothermodes,128bitsareallvalid.";
            desc = "";
            sw = rw; hw = r;
            reset = 0x0;
        } Channel0Dinforthesymmetricalgorithm_littleendian_AES_1_Ifthe1_CFBmodeisselected_chan0_cipher_din_0_isvalid_chan0_cipher_din_2_Ifthe8_CFBmodeisselected_chan0_cipher_din_7_0_isvalid_3_Ifthe128_CFBmodeisselected_128bitsareallvalid_4_Inothermodes_128bitsareallvalid[31:0];
    } CHAN0_CIPHER_DIN @ 0x420;
    reg {
        name = "CHANN_CIPHER_IN_LEFT_BYTE";
        desc = "CHANN_CIPHER_IN_LEFT_BYTE is the left-byte count register for the current read data for channel n. (offset 0x410; total reset 0x00000000; PROVEN: Hi3516E V300 data sheet (Issue 00B06, 2019-05-15), section 13.2.6, PDF page 825).";
        field {
            name = "reserved";
            desc = "Reserved";
            sw = r; hw = w;
            reset = 0x0;
        } reserved_31_4[31:4];
        field {
            name = "in_left_byte";
            desc = "Number of remaining bytes in the read data";
            sw = r; hw = w;
            reset = 0x0;
        } in_left_byte[3:0];
    } CHANN_CIPHER_IN_LEFT_BYTE @ 0x410;
    reg {
        name = "CHANN_CIPHER_IN_LEFT_WORD0";
        desc = "CHANN_CIPHER_IN_LEFT_WORD0 is the left-word register for the current read data of channel n. (offset 0x414; total reset 0x00000000; PROVEN: Hi3516E V300 data sheet (Issue 00B06, 2019-05-15), section 13.2.6, PDF page 825).";
        field {
            name = "cipher_in_left_wordFirst0";
            desc = "word in the remaining data";
            sw = r; hw = w;
            reset = 0x0;
        } cipher_in_left_wordFirst0[31:0];
    } CHANN_CIPHER_IN_LEFT_WORD0 @ 0x414;
    reg {
        name = "CHANN_CIPHER_IN_LEFT_WORD1";
        desc = "CHANN_CIPHER_IN_LEFT_WORD1 is the left-word register for the current read data of channel n. (offset 0x418; total reset 0x00000000; PROVEN: Hi3516E V300 data sheet (Issue 00B06, 2019-05-15), section 13.2.6, PDF page 826).";
        field {
            name = "cipher_in_left_wordSecond1";
            desc = "word in the remaining data";
            sw = r; hw = w;
            reset = 0x0;
        } cipher_in_left_wordSecond1[31:0];
    } CHANN_CIPHER_IN_LEFT_WORD1 @ 0x418;
    reg {
        name = "CHANN_CIPHER_IN_LEFT_WORD2";
        desc = "CHANN_CIPHER_IN_LEFT_WORD2 is the left-word register for the current read data of channel n. (offset 0x41C; total reset 0x00000000; PROVEN: Hi3516E V300 data sheet (Issue 00B06, 2019-05-15), section 13.2.6, PDF page 826).";
        field {
            name = "cipher_in_left_wordThird2";
            desc = "word in the remaining data";
            sw = r; hw = w;
            reset = 0x0;
        } cipher_in_left_wordThird2[31:0];
    } CHANN_CIPHER_IN_LEFT_WORD2 @ 0x41C;
    reg {
        name = "CHANN_CIPHER_OUT_NODE_CFG";
        desc = "CHANN_CIPHER_OUT_NODE_CFG is the output node configuration register for channel n. (offset 0x430; total reset 0x00000000; PROVEN: Hi3516E V300 data sheet (Issue 00B06, 2019-05-15), section 13.2.6, PDF page 826).";
        field {
            name = "reserved";
            desc = "Reserved";
            sw = r; hw = w;
            reset = 0x0;
        } reserved_31_31[31:31];
        field {
            name = "cipher_out_node_total_num";
            desc = "Total depth of the output node";
            sw = rw; hw = r;
            reset = 0x0;
        } cipher_out_node_total_num[30:24];
        field {
            name = "reserved";
            desc = "Reserved";
            sw = r; hw = w;
            reset = 0x0;
        } reserved_23_23[23:23];
        field {
            name = "cipher_out_node_wptr";
            desc = "Write pointer to the output node";
            sw = rw; hw = r;
            reset = 0x0;
        } cipher_out_node_wptr[22:16];
        field {
            name = "reserved";
            desc = "Reserved";
            sw = r; hw = w;
            reset = 0x0;
        } reserved_15_15[15:15];
        field {
            name = "cipher_out_node_rptr";
            desc = "Read pointer to the output node";
            sw = r; hw = w;
            reset = 0x0;
        } cipher_out_node_rptr[14:8];
        field {
            name = "reserved";
            desc = "Reserved";
            sw = r; hw = w;
            reset = 0x0;
        } reserved_7_7[7:7];
        field {
            name = "cipher_out_node_mpackage_int_level";
            desc = "Interrupt level of multiple output nodes";
            sw = rw; hw = r;
            reset = 0x0;
        } cipher_out_node_mpackage_int_level[6:0];
    } CHANN_CIPHER_OUT_NODE_CFG @ 0x430;
    reg {
        name = "CHANN_CIPHER_OUT_NODE_START_ADDR";
        desc = "CHANN_CIPHER_OUT_NODE_START_ADDR is the output node start address register for channel n. (offset 0x434; total reset 0x00000000; PROVEN: Hi3516E V300 data sheet (Issue 00B06, 2019-05-15), section 13.2.6, PDF page 827).";
        field {
            name = "cipher_out_node_staStartaddressoftheoutputnode,whichisusedrt_addrtoreadthisoutputnode";
            desc = "Start address of the output node, which is used to read this output node";
            sw = rw; hw = r;
            reset = 0x0;
        } cipher_out_node_staStartaddressoftheoutputnode_whichisusedrt_addrtoreadthisoutputnode[31:0];
    } CHANN_CIPHER_OUT_NODE_START_ADDR @ 0x434;
    reg {
        name = "CHANN_CIPHER_OUT_BUF_RPTR";
        desc = "CHANN_CIPHER_OUT_BUF_RPTR is the output buffer read address register for channel n. (offset 0x438; total reset 0x00000000; PROVEN: Hi3516E V300 data sheet (Issue 00B06, 2019-05-15), section 13.2.6, PDF page 827).";
        field {
            name = "cipher_out_buf_rptr";
            desc = "Read address of the output buffer";
            sw = r; hw = w;
            reset = 0x0;
        } cipher_out_buf_rptr[31:0];
    } CHANN_CIPHER_OUT_BUF_RPTR @ 0x438;
    reg {
        name = "CHANN_CIPHER_OUT_LEFT_BYTE";
        desc = "CHANN_CIPHER_OUT_LEFT_BYTE is the left-byte register for the current output data of channel n. (offset 0x440; total reset 0x00000000; PROVEN: Hi3516E V300 data sheet (Issue 00B06, 2019-05-15), section 13.2.6, PDF page 827).";
        field {
            name = "reserved";
            desc = "Reserved";
            sw = r; hw = w;
            reset = 0x0;
        } reserved_31_7[31:7];
        field {
            name = "out_left_byte";
            desc = "Number of remaining bytes in the write data";
            sw = r; hw = w;
            reset = 0x0;
        } out_left_byte[6:0];
    } CHANN_CIPHER_OUT_LEFT_BYTE @ 0x440;
    reg {
        name = "CHANN_CIPHER_OUT_LEFT_WORD0";
        desc = "CHANN_CIPHER_OUT_LEFT_WORD0 is the left-word register for the current output data of channel n. (offset 0x444; total reset 0x00000000; PROVEN: Hi3516E V300 data sheet (Issue 00B06, 2019-05-15), section 13.2.6, PDF page 828).";
        field {
            name = "cipher_out_left_worFirstd0";
            desc = "word in the remaining data";
            sw = r; hw = w;
            reset = 0x0;
        } cipher_out_left_worFirstd0[31:0];
    } CHANN_CIPHER_OUT_LEFT_WORD0 @ 0x444;
    reg {
        name = "CHANN_CIPHER_OUT_LEFT_WORD1";
        desc = "CHANN_CIPHER_OUT_LEFT_WORD1 is the left-word register for the current output data of channel n. (offset 0x448; total reset 0x00000000; PROVEN: Hi3516E V300 data sheet (Issue 00B06, 2019-05-15), section 13.2.6, PDF page 828).";
        field {
            name = "cipher_out_left_worSecondd1";
            desc = "word in the remaining data";
            sw = r; hw = w;
            reset = 0x0;
        } cipher_out_left_worSecondd1[31:0];
    } CHANN_CIPHER_OUT_LEFT_WORD1 @ 0x448;
    reg {
        name = "CHANN_CIPHER_OUT_LEFT_WORD2";
        desc = "CHANN_CIPHER_OUT_LEFT_WORD2 is the left-word register for the current output data of channel n. (offset 0x44C; total reset 0x00000000; PROVEN: Hi3516E V300 data sheet (Issue 00B06, 2019-05-15), section 13.2.6, PDF page 828).";
        field {
            name = "cipher_out_left_worThirdd2";
            desc = "word in the remaining data";
            sw = r; hw = w;
            reset = 0x0;
        } cipher_out_left_worThirdd2[31:0];
    } CHANN_CIPHER_OUT_LEFT_WORD2 @ 0x44C;
    reg {
        name = "CHANN_CIPHER_OUT_BUF_REST_LEN";
        desc = "CHANN_CIPHER_OUT_BUF_REST_LEN is the remaining length register for the output buffer of channel n. (offset 0x450; total reset 0x00000000; PROVEN: Hi3516E V300 data sheet (Issue 00B06, 2019-05-15), section 13.2.6, PDF page 828).";
        field {
            name = "cipher_out_buf_rest_Remaininglengthoftheoutputbufferoflenchanneln,inbytes";
            desc = "Remaining length of the output buffer of channel n, in bytes";
            sw = r; hw = w;
            reset = 0x0;
        } cipher_out_buf_rest_Remaininglengthoftheoutputbufferoflenchanneln_inbytes[31:0];
    } CHANN_CIPHER_OUT_BUF_REST_LEN @ 0x450;
    reg {
        name = "CHAN0_HASH_CTRL";
        desc = "CHAN0_HASH_CTRL is the hash control register of channel 0. (offset 0x800; total reset 0x00000200; PROVEN: Hi3516E V300 data sheet (Issue 00B06, 2019-05-15), section 13.2.6, PDF page 829).";
        field {
            name = "reserved";
            desc = "Reserved";
            sw = r; hw = w;
            reset = 0x0;
        } reserved_31_14[31:14];
        field {
            name = "reserved";
            desc = "Reserved";
            sw = r; hw = w;
            reset = 0x1;
        } reserved_13_13[13:13];
        field {
            name = "reserved";
            desc = "Reserved";
            sw = r; hw = w;
            reset = 0x0;
        } reserved_12_12[12:12];
        field {
            name = "hash_ch0_hmac_key_addr";
            desc = "Key address for HMAC key calculation. Key addresses 0-2 correspond to channels 0-2, respectively.";
            sw = rw; hw = r;
            reset = 0x0;
        } hash_ch0_hmac_key_addr[11:10];
        field {
            name = "reserved";
            desc = "Reserved";
            sw = r; hw = w;
            reset = 0x0;
        } reserved_9_9[9:9];
        field {
            name = "reserved";
            desc = "Reserved";
            sw = r; hw = w;
            reset = 0x0;
        } reserved_8_7[8:7];
        field {
            name = "hash_ch0_key_sel";
            desc = "HMAC key select
- 0: keys configured by the CPU
- 1: keys configured by hardware";
            sw = rw; hw = r;
            reset = 0x0;
        } hash_ch0_key_sel[6:6];
        field {
            name = "hash_ch0_mode";
            desc = "Calculation mode
- 0: Raw hash calculation
- 1: HMAC calculation";
            sw = rw; hw = r;
            reset = 0x0;
        } hash_ch0_mode[5:5];
        field {
            name = "hash_ch0_hmac_calc_step";
            desc = "HMAC calculation select for the HMAC calculation
- 0: key calculation
- 1: message hash calculation";
            sw = rw; hw = r;
            reset = 0x0;
        } hash_ch0_hmac_calc_step[4:4];
        field {
            name = "hash_ch0_agl_sel";
            desc = "Algorithm mode
- 000: SHA1
- 001: SHA244
- 010: SHA256

Other values: SHA256";
            sw = rw; hw = r;
            reset = 0x0;
        } hash_ch0_agl_sel[3:1];
        field {
            name = "hash_ch0_start";
            desc = "Whether the hash block is started
- 0: no
- 1: yes";
            sw = rw; hw = r;
            reset = 0x0;
        } hash_ch0_start[0:0];
    } CHAN0_HASH_CTRL @ 0x800;
    reg {
        name = "HASH_INT_STATUS";
        desc = "HASH_INT_STATUS is the hash interrupt status register. (offset 0x804; total reset 0x00000000; PROVEN: Hi3516E V300 data sheet (Issue 00B06, 2019-05-15), section 13.2.6, PDF page 830).";
        field {
            name = "reserved";
            desc = "Reserved";
            sw = r; hw = w;
            reset = 0x0;
        } reserved_31_26[31:26];
        field {
            name = "hash_chn_oram_int";
            desc = "Output RAM data interrupt for channel n
- 0: No interrupt is generated.
- 1: An interrupt is generated.

Bits 25-18 correspond to channels 7-0, respectively.";
            sw = r; hw = w;
            reset = 0x0;
        } hash_chn_oram_int[25:18];
        field {
            name = "reserved";
            desc = "Reserved";
            sw = r; hw = w;
            reset = 0x0;
        } reserved_17_0[17:0];
    } HASH_INT_STATUS @ 0x804;
    reg {
        name = "HASH_INT_EN";
        desc = "HASH_INT_EN is the hash interrupt enable register. (offset 0x808; total reset 0x00000000; PROVEN: Hi3516E V300 data sheet (Issue 00B06, 2019-05-15), section 13.2.6, PDF page 830).";
        field {
            name = "reserved";
            desc = "Reserved";
            sw = r; hw = w;
            reset = 0x0;
        } reserved_31_31[31:31];
        field {
            name = "hash_int_en";
            desc = "Global hash interrupt enable
- 0: disabled
- 1: enabled";
            sw = rw; hw = r;
            reset = 0x0;
        } hash_int_en[30:30];
        field {
            name = "reserved";
            desc = "Reserved";
            sw = r; hw = w;
            reset = 0x0;
        } reserved_29_26[29:26];
        field {
            name = "hash_chn_oram_en";
            desc = "Output queue data interrupt enable for channel 7. An interrupt is reported when the result is written to a RAM.
- 0: disabled
- 1: enabled

Bits 25-18 correspond to channels 7-0, respectively.";
            sw = rw; hw = r;
            reset = 0x0;
        } hash_chn_oram_en[25:18];
        field {
            name = "reserved";
            desc = "Reserved";
            sw = r; hw = w;
            reset = 0x0;
        } reserved_17_0[17:0];
    } HASH_INT_EN @ 0x808;
    reg {
        name = "HASH_INT_RAW";
        desc = "HASH_INT_RAW is the hash raw interrupt status register. (offset 0x80C; total reset 0x00000000; PROVEN: Hi3516E V300 data sheet (Issue 00B06, 2019-05-15), section 13.2.6, PDF page 830).";
        field {
            name = "reserved";
            desc = "Reserved";
            sw = r; hw = w;
            reset = 0x0;
        } reserved_31_26[31:26];
        field {
            name = "hash_chn_oram_raw";
            desc = "Raw output queue data interrupt for channel n
- 0: No interrupt is generated.
- 1: An interrupt is generated.

Bits 25-18 correspond to channels 7-0, respectively.";
            sw = rw; hw = r;
            reset = 0x0;
        } hash_chn_oram_raw[25:18];
        field {
            name = "reserved";
            desc = "Reserved";
            sw = r; hw = w;
            reset = 0x0;
        } reserved_17_0[17:0];
    } HASH_INT_RAW @ 0x80C;
    reg {
        name = "CHAN0_HASH_DAT_IN";
        desc = "CHAN0_HASH_DAT_IN is the CPU input data register. (offset 0x818; total reset 0x00000000; PROVEN: Hi3516E V300 data sheet (Issue 00B06, 2019-05-15), section 13.2.6, PDF page 831).";
        field {
            name = "chan0_hash_data_in";
            desc = "CPU data input register for channel 0";
            sw = w; hw = r;
            reset = 0x0;
        } chan0_hash_data_in[31:0];
    } CHAN0_HASH_DAT_IN @ 0x818;
    reg {
        name = "CHAN0_HASH_TOTAL_DAT_LEN";
        desc = "CHAN0_HASH_TOTAL_DAT_LEN is the CPU input data length register. (offset 0x81C; total reset 0x00000000; PROVEN: Hi3516E V300 data sheet (Issue 00B06, 2019-05-15), section 13.2.6, PDF page 831).";
        field {
            name = "chan0_hash_total_daCPUt_len";
            desc = "data length for channel 0, in bytes";
            sw = rw; hw = r;
            reset = 0x0;
        } chan0_hash_total_daCPUt_len[31:0];
    } CHAN0_HASH_TOTAL_DAT_LEN @ 0x81C;
    reg {
        name = "CHAN0_HASH_IN_DAT_LEN";
        desc = "CHAN0_HASH_IN_DAT_LEN is the input data length register for channel 0. (offset 0x820; total reset 0x00000000; PROVEN: Hi3516E V300 data sheet (Issue 00B06, 2019-05-15), section 13.2.6, PDF page 831).";
        field {
            name = "chan0_hash_in_dat_lLengthoftheinputdataforchannel0,inhashenblocks";
            desc = "Length of the input data for channel 0, in hash blocks";
            sw = r; hw = w;
            reset = 0x0;
        } chan0_hash_in_dat_lLengthoftheinputdataforchannel0_inhashenblocks[31:0];
    } CHAN0_HASH_IN_DAT_LEN @ 0x820;
    reg {
        name = "CHANN_HASH_IN_BUF_REST_LEN";
        desc = "CHANN_HASH_IN_BUF_REST_LEN is the remaining length register for the input buffer of channel y. (offset 0x810; total reset 0x00000000; PROVEN: Hi3516E V300 data sheet (Issue 00B06, 2019-05-15), section 13.2.6, PDF page 833).";
        field {
            name = "Remaininglengthoftheinputbufferofhash_in_buf_rest_lenchanneln,inbytes";
            desc = "";
            sw = r; hw = w;
            reset = 0x0;
        } Remaininglengthoftheinputbufferofhash_in_buf_rest_lenchanneln_inbytes[31:0];
    } CHANN_HASH_IN_BUF_REST_LEN @ 0x810;
};
`endif
