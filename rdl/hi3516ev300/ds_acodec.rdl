`ifndef HI3516EV300_ACODEC_RDL
`define HI3516EV300_ACODEC_RDL
regfile eHI3516EV300_ACODEC {
    name = "Audio codec";
    desc = "Audio codec of the Hi3516E V300 at base 0x100F_0000. 6 registers extracted programmatically from the Hi3516E V300 data sheet (Issue 00B06, 2019-05-15) (Table 11-2 Summary of AudioCodec registers (base address: 0x100F_0000)): register headings, offsets, total reset values, field bit ranges, access types, names, reset values and descriptions, with PDF page numbers in each register description. Field names, bit ranges, access types and offsets are exact; the free-text descriptions are taken from the cell text of the field table and were checked by sampling only. Hardware not verified.";
    reg {
        name = "AUDIO_CTRL_REG";
        desc = "AUDIO_CTRL_REG is audio codec DIG control register 0. (offset 0xCC; total reset 0x00F35A4A; PROVEN: Hi3516E V300 data sheet (Issue 00B06, 2019-05-15), section 11.2.4, PDF page 623).";
        field {
            name = "dacl_rst_n";
            desc = "DACL reset signal
- 0: reset
- 1: reset deasserted";
            sw = rw; hw = r;
            reset = 0x0;
        } dacl_rst_n[31:31];
        field {
            name = "dacr_rst_n";
            desc = "DACR reset signal
- 0: reset
- 1: reset deasserted";
            sw = rw; hw = r;
            reset = 0x0;
        } dacr_rst_n[30:30];
        field {
            name = "adcl_rst_n";
            desc = "ADCL reset signal
- 0: reset
- 1: reset deasserted";
            sw = rw; hw = r;
            reset = 0x0;
        } adcl_rst_n[29:29];
        field {
            name = "adcr_rst_n";
            desc = "ADCR reset signal
- 0: reset
- 1: reset deasserted";
            sw = rw; hw = r;
            reset = 0x0;
        } adcr_rst_n[28:28];
        field {
            name = "dacl_en";
            desc = "DACL enable
- 0: disabled
- 1: enabled";
            sw = rw; hw = r;
            reset = 0x0;
        } dacl_en[27:27];
        field {
            name = "dacr_en";
            desc = "DACR enable
- 0: disabled
- 1: enabled";
            sw = rw; hw = r;
            reset = 0x0;
        } dacr_en[26:26];
        field {
            name = "adcl_en";
            desc = "ADCL enable
- 0: disabled
- 1: enabled";
            sw = rw; hw = r;
            reset = 0x0;
        } adcl_en[25:25];
        field {
            name = "adcr_en";
            desc = "ADCR enable
- 0: disabled
- 1: enabled";
            sw = rw; hw = r;
            reset = 0x0;
        } adcr_en[24:24];
        field {
            name = "reserved";
            desc = "Reserved";
            sw = r; hw = w;
            reset = 0xf;
        } reserved_23_20[23:20];
        field {
            name = "reserved";
            desc = "Reserved";
            sw = r; hw = w;
            reset = 0x0;
        } reserved_19_18[19:18];
        field {
            name = "i2s1_fs_sel";
            desc = "Sampling rate of the I2S channel
- 11000: mclk/512/2
- 11001: mclk/256/2
- 11010: mclk/128/2
- 11011: mclk/64/2 111xx: mclk/32/2";
            sw = rw; hw = r;
            reset = 0x1a;
        } i2s1_fs_sel[17:13];
        field {
            name = "reserved";
            desc = "Reserved";
            sw = r; hw = w;
            reset = 0x1a;
        } reserved_12_8[12:8];
        field {
            name = "reserved";
            desc = "Reserved";
            sw = r; hw = w;
            reset = 0x4a;
        } reserved_7_0[7:0];
    } AUDIO_CTRL_REG @ 0xCC;
    reg {
        name = "AUDIO_DAC_REG_0";
        desc = "AUDIO_DAC_REG_0 is audio codec DIG control register 1. (offset 0xD0; total reset 0x00000001; PROVEN: Hi3516E V300 data sheet (Issue 00B06, 2019-05-15), section 11.2.4, PDF page 624).";
        field {
            name = "smutel";
            desc = "DACL soft mute control
- 0: disabled
- 1: enabled";
            sw = rw; hw = r;
            reset = 0x0;
        } smutel[31:31];
        field {
            name = "smuter";
            desc = "DACR soft mute control
- 0: disabled
- 1: enabled";
            sw = rw; hw = r;
            reset = 0x0;
        } smuter[30:30];
        field {
            name = "sunmutel";
            desc = "DACL soft unmute control
- 0: disabled
- 1: enabled";
            sw = rw; hw = r;
            reset = 0x0;
        } sunmutel[29:29];
        field {
            name = "sunmuter";
            desc = "DACR soft unmute control
- 0: disabled
- 1: enabled";
            sw = rw; hw = r;
            reset = 0x0;
        } sunmuter[28:28];
        field {
            name = "dacvu";
            desc = "DAC volume update control
- 0: not updated
- 1: updated";
            sw = rw; hw = r;
            reset = 0x0;
        } dacvu[27:27];
        field {
            name = "mutel_rate";
            desc = "DACL soft mute rate control
- 00: fs/2
- 01: fs/8
- 10: fs/32
- 11: fs/64";
            sw = rw; hw = r;
            reset = 0x0;
        } mutel_rate[26:25];
        field {
            name = "muter_rate";
            desc = "DACR soft mute rate control
- 00: fs/2
- 01: fs/8
- 10: fs/32
- 11: fs/64";
            sw = rw; hw = r;
            reset = 0x0;
        } muter_rate[24:23];
        field {
            name = "dacl_deemph";
            desc = "DACL de-emphasis control
- 00: none
- 01: 32 kHz
- 10: 44 kHz
- 11: 48 kHz";
            sw = rw; hw = r;
            reset = 0x0;
        } dacl_deemph[22:21];
        field {
            name = "dacr_deemph";
            desc = "DACR de-emphasis control
- 00: none
- 01: 32 kHz
- 10: 44 kHz
- 11: 48 kHz";
            sw = rw; hw = r;
            reset = 0x0;
        } dacr_deemph[20:19];
        field {
            name = "reserved";
            desc = "Reserved";
            sw = r; hw = w;
            reset = 0x0;
        } reserved_18_4[18:4];
        field {
            name = "dal_i2ssel";
            desc = "DACL I2S interface select
- 0: I2S1
- 1: reserved";
            sw = rw; hw = r;
            reset = 0x0;
        } dal_i2ssel[3:3];
        field {
            name = "dacl_lrsel";
            desc = "DACL channel data select
- 0: audio-left channel
- 1: audio-right channel";
            sw = rw; hw = r;
            reset = 0x0;
        } dacl_lrsel[2:2];
        field {
            name = "dacr_i2ssel";
            desc = "DACR I2S interface select
- 0: I2S1
- 1: reserved";
            sw = rw; hw = r;
            reset = 0x0;
        } dacr_i2ssel[1:1];
        field {
            name = "dacr_lrsel";
            desc = "DACR channel data select
- 0: audio-left channel
- 1: audio-right channel";
            sw = rw; hw = r;
            reset = 0x1;
        } dacr_lrsel[0:0];
    } AUDIO_DAC_REG_0 @ 0xD0;
    reg {
        name = "AUDIO_DAC_REG_1";
        desc = "AUDIO_DAC_REG_1 is audio codec DIG control register 2. (offset 0xD4; total reset 0x06062424; PROVEN: Hi3516E V300 data sheet (Issue 00B06, 2019-05-15), section 11.2.4, PDF page 626).";
        field {
            name = "dacl_mute";
            desc = "DACL digital mute control
- 0: normal working
- 1: muted";
            sw = rw; hw = r;
            reset = 0x0;
        } dacl_mute[31:31];
        field {
            name = "dacl_vol";
            desc = "DACL digital volume control The volume is calculated as follows: (6 - dacl_vol x 1) dB When dacl_vol is 0x7F, the DACL is muted.
- 0x00: 6 dB
- 0x01: 5 dB
- 0x02: 4 dB …
- 0x7E: -120 dB
- 0x7F: muted";
            sw = rw; hw = r;
            reset = 0x6;
        } dacl_vol[30:24];
        field {
            name = "dacr_mute";
            desc = "DACR digital mute control
- 0: normal working
- 1: muted";
            sw = rw; hw = r;
            reset = 0x0;
        } dacr_mute[23:23];
        field {
            name = "dacr_vol";
            desc = "DACR digital volume control The volume is calculated as follows: (6 -";
            sw = rw; hw = r;
            reset = 0x6;
        } dacr_vol[22:16];
        field {
            name = "dacr2dacl_en";
            desc = "DACR-to-DACL mixer enable
- 0: disabled
- 1: enabled";
            sw = rw; hw = r;
            reset = 0x0;
        } dacr2dacl_en[15:15];
        field {
            name = "dacr2dacl_vol";
            desc = "DACR-to-DACL volume control The volume is calculated as follows: (36 - dacr2dacl_vol x 1) dB
- 00: 36 dB
- 01: 35 dB
- 02: 34 dB … 7E: -90 dB 7F: -91 dB";
            sw = rw; hw = r;
            reset = 0x24;
        } dacr2dacl_vol[14:8];
        field {
            name = "dacl2dacr_en";
            desc = "DACL-to-DACR mixer enable
- 0: disabled
- 1: enabled";
            sw = rw; hw = r;
            reset = 0x0;
        } dacl2dacr_en[7:7];
        field {
            name = "dacl2dacr_vol";
            desc = "DACL-to-DACR volume control The volume is calculated as follows: (36 - dacl2dacr_vol x 1) dB
- 00: 36 dB
- 01: 35 dB
- 02: 34 dB … 7E: -90 dB 7F: -91 dB";
            sw = rw; hw = r;
            reset = 0x24;
        } dacl2dacr_vol[6:0];
    } AUDIO_DAC_REG_1 @ 0xD4;
    reg {
        name = "AUDIO_ADC_REG_0";
        desc = "AUDIO_ADC_REG_0 is audio codec DIG control register 3. (offset 0xD8; total reset 0x1E1E0001; PROVEN: Hi3516E V300 data sheet (Issue 00B06, 2019-05-15), section 11.2.4, PDF page 627).";
        field {
            name = "adcl_mute";
            desc = "ADCL digital mute control
- 0: unmuted
- 1: muted";
            sw = rw; hw = r;
            reset = 0x0;
        } adcl_mute[31:31];
        field {
            name = "adcl_vol";
            desc = "ADCL volume control bits. The volume is calculated as follows: (30 - adcl_vol x 1) dB
- 0x00: 30 dB
- 0x01: 29 dB
- 0x02: 28 dB …
- 0x7E: -96 dB
- 0x7F: -97 dB";
            sw = rw; hw = r;
            reset = 0x1e;
        } adcl_vol[30:24];
        field {
            name = "adcr_mute";
            desc = "ADCR digital mute control
- 0: unmuted
- 1: muted";
            sw = rw; hw = r;
            reset = 0x0;
        } adcr_mute[23:23];
        field {
            name = "adcr_vol";
            desc = "ADCR volume control The volume is calculated as follows: (30 - adcr_vol x 1) dB
- 0x00: 30 dB
- 0x01: 29 dB
- 0x02: 28 dB …
- 0x7E: -96 dB
- 0x7F: -97 dB";
            sw = rw; hw = r;
            reset = 0x1e;
        } adcr_vol[22:16];
        field {
            name = "adcl_hpf_en";
            desc = "ADCL high-pass filter enable
- 0: disabled
- 1: enabled";
            sw = rw; hw = r;
            reset = 0x0;
        } adcl_hpf_en[15:15];
        field {
            name = "adcr_hpf_en";
            desc = "ADCR high-pass filter enable
- 0: disabled
- 1: enabled";
            sw = rw; hw = r;
            reset = 0x0;
        } adcr_hpf_en[14:14];
        field {
            name = "reserved";
            desc = "Reserved";
            sw = r; hw = w;
            reset = 0x0;
        } reserved_13_4[13:4];
        field {
            name = "adcl_i2ssel";
            desc = "ADCL I2S interface select (high priority)
- 0: I2S1
- 1: reserved";
            sw = rw; hw = r;
            reset = 0x0;
        } adcl_i2ssel[3:3];
        field {
            name = "adcl_lrsel";
            desc = "ADCL channel data select.
- 0: audio-left channel
- 1: audio-right channel";
            sw = rw; hw = r;
            reset = 0x0;
        } adcl_lrsel[2:2];
        field {
            name = "adcr_i2ssel";
            desc = "ADCR I2S interface select (low priority).";
            sw = rw; hw = r;
            reset = 0x0;
        } adcr_i2ssel[1:1];
        field {
            name = "adcr_lrsel";
            desc = "ADCR channel data select.
- 0: audio-left channel
- 1: audio-right channel";
            sw = rw; hw = r;
            reset = 0x1;
        } adcr_lrsel[0:0];
    } AUDIO_ADC_REG_0 @ 0xD8;
    reg {
        name = "AUDIO_ADC_REG_1";
        desc = "AUDIO_ADC_REG_1 is audio codec DIG control register 4. (offset 0xDC; total reset 0x24242424; PROVEN: Hi3516E V300 data sheet (Issue 00B06, 2019-05-15), section 11.2.4, PDF page 629).";
        field {
            name = "adcl2dacl_en";
            desc = "ADCL-to-DACL mixer enable
- 0: disabled
- 1: enabled";
            sw = rw; hw = r;
            reset = 0x0;
        } adcl2dacl_en[31:31];
        field {
            name = "adcl2dacl_vol";
            desc = "ADCL-to-DACL volume control The volume is calculated as follows: (36 - adcl2dacl_vol x 1) dB
- 00: 36 dB
- 01: 35 dB
- 02: 34 dB … 7E: -90 dB 7F: -91 dB";
            sw = rw; hw = r;
            reset = 0x24;
        } adcl2dacl_vol[30:24];
        field {
            name = "adcr2dacl_en";
            desc = "ADCR-to-DACL mixer enable
- 0: disabled
- 1: enabled";
            sw = rw; hw = r;
            reset = 0x0;
        } adcr2dacl_en[23:23];
        field {
            name = "adcr2dacl_vol";
            desc = "ADCR-to-DACL volume control The volume is calculated as follows: (36 - adcr2dacl_vol x 1) dB
- 00: 36 dB
- 01: 35 dB
- 02: 34 dB … 7E: -90 dB 7F: -91 dB";
            sw = rw; hw = r;
            reset = 0x24;
        } adcr2dacl_vol[22:16];
        field {
            name = "adcl2dacr_en";
            desc = "ADCL-to-DACR mixer enable
- 0: disabled";
            sw = rw; hw = r;
            reset = 0x0;
        } adcl2dacr_en[15:15];
        field {
            name = "adcl2dacr_vol";
            desc = "ADCL-to-DACR volume control The volume is calculated as follows: (36 - adcl2dacr_vol x 1) dB
- 00: 36 dB
- 01: 35 dB
- 02: 34 dB … 7E: -90 dB 7F: -91 dB";
            sw = rw; hw = r;
            reset = 0x24;
        } adcl2dacr_vol[14:8];
        field {
            name = "adcr2dacr_en";
            desc = "ADCR-to-DACR mixer enable
- 0: disabled
- 1: enabled";
            sw = rw; hw = r;
            reset = 0x0;
        } adcr2dacr_en[7:7];
        field {
            name = "adcr2dacr_vol";
            desc = "ADCR-to-DACR volume control. The volume is calculated as follows: (36 - adcr2dacr_vol x 1) dB
- 00: 36 dB
- 01: 35 dB
- 02: 34 dB … 7E: -90 dB 7F: -91 dB";
            sw = rw; hw = r;
            reset = 0x24;
        } adcr2dacr_vol[6:0];
    } AUDIO_ADC_REG_1 @ 0xDC;
    reg {
        name = "AUDIO_IIS_MUX_CTRL";
        desc = "AUDIO_IIS_MUX_CTRL is I2S channel select control register. (offset 0xE0; total reset 0x0000000F; PROVEN: Hi3516E V300 data sheet (Issue 00B06, 2019-05-15), section 11.2.4, PDF page 630).";
        field {
            name = "reserved";
            desc = "Reserved";
            sw = r; hw = w;
            reset = 0x0;
        } reserved_31_4[31:4];
        field {
            name = "audio_mclk_sel";
            desc = "Select of the MCLK sent from the AIAO to the embedded ADAC. This control signal is for the iis_mux.
- 0: MCLK of CRG0 is sent to the codec.
- 1: MCLK of CRG8 is sent to the codec.";
            sw = rw; hw = r;
            reset = 0x1;
        } audio_mclk_sel[3:3];
        field {
            name = "rx_sd_sel";
            desc = "Select of the SD card signal of AIAO RX0. This control signal is for the iis_mux.
- 0: The SD signal of an external ADC is selected.";
            sw = rw; hw = r;
            reset = 0x1;
        } rx_sd_sel[2:2];
        field {
            name = "audio_rx_bclk_sel";
            desc = "Select of the clock sent from the AIAO to the codec_ADC. This control signal is for the iis_mux. It includes bclk and ws signals.
- 0: CRG0 clock
- 1: CRG8 clock";
            sw = rw; hw = r;
            reset = 0x1;
        } audio_rx_bclk_sel[1:1];
        field {
            name = "pad_tx_en";
            desc = "Whether to send the output signals (bclk, ws, and sd) of tx0 to the pin. This control signal is for the iis_mux.
- 0: The output of the iis tx0 pin is 0.
- 1: The iis tx0 pin outputs the tx0 signal. Contents";
            sw = rw; hw = r;
            reset = 0x1;
        } pad_tx_en[0:0];
    } AUDIO_IIS_MUX_CTRL @ 0xE0;
};
`endif
