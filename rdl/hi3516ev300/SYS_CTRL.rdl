`ifndef HI3516EV300_SYS_CTRL_RDL
`define HI3516EV300_SYS_CTRL_RDL

regfile eSYS_CTRL_EV300 {
    name = "System controller (SYS_CTRL), Hi3516EV300";
    desc = "System controller at 0x12020000 (compatible hisilicon,sysctrl, 32 KB window ioremapped by sys.ko). Only registers with direct vendor evidence (U-Boot macros, vendor DT, sys.ko disassembly) are described; everything else is unknown. PROVEN / INFERRED labels per field. Nothing was read from an EV300.";

    reg {
        name = "System control";
        desc = "Evidence: PROVEN (vendor U-Boot platform.h: TIMER0 clock select bit 16, 0 = 3 MHz, 1 = bus clock; SC_CTRL_REMAP_CLEAR bit 8). The qemu model and the clock driver use a 3 MHz fixed clock for the SP804 timers.";
        field {
            name = "remap_clear";
            desc = "Boot ROM remap clear (U-Boot SC_CTRL_REMAP_CLEAR). PROVEN (source).";
            sw = rw;
            hw = r;
        } remap_clear[8:8];
        field {
            name = "timer0_clk_sel";
            desc = "Timer 0/1 clock: 0 = 3 MHz, 1 = bus clock. PROVEN (source); the other timer selects (bits 18/20/22) are INFERRED from the older chips and not listed.";
            sw = rw;
            hw = r;
        } timer0_clk_sel[16:16];
    } SC_CTRL @ 0x0;

    reg {
        name = "System reset";
        desc = "The vendor DT names this register as the reboot register (reboot-offset 0x04, hisilicon,sysctrl). The qemu model resets the machine on a write of 0xDEADBEEF. Evidence: PROVEN offset (DT), INFERRED magic value.";
        field {
            name = "sysres";
            desc = "Write the reset magic (0xDEADBEEF per the qemu model) to reset the SoC. INFERRED.";
            sw = w;
            hw = r;
        } sysres[31:0];
    } SC_SYSRES @ 0x4;

    reg {
        name = "System status / boot strap";
        desc = "Evidence: PROVEN (vendor U-Boot macros GET_SYS_BOOT_MODE, GET_SPI_NOR_ADDR_MODE, GET_SPI_DEVICE_TYPE, NF_BOOTBW_MASK, SPI_INPUT_SLE). Values: boot mode 0 = SPI (NOR), 1 = SPI NAND (or eMMC, the U-Boot defines BOOT_FROM_SPI_NAND and BOOT_FROM_EMMC both as 1).";
        field {
            name = "boot_mode";
            desc = "Boot media strap: 0 = SPI NOR, 1 = SPI NAND / eMMC. PROVEN (source).";
            sw = r;
            hw = w;
        } boot_mode[4:4];
        field {
            name = "spi_nor_addr_mode";
            desc = "SPI NOR address mode strap (1 = 4-byte). PROVEN (source).";
            sw = r;
            hw = w;
        } spi_nor_addr_mode[7:7];
        field {
            name = "spi_device_type";
            desc = "SPI boot device type strap (0 = NOR, 1 = NAND). PROVEN (source).";
            sw = r;
            hw = w;
        } spi_device_type[10:10];
        field {
            name = "nf_bootbw";
            desc = "NAND boot bus width strap. PROVEN (source).";
            sw = r;
            hw = w;
        } nf_bootbw[11:11];
        field {
            name = "spi_input_sel";
            desc = "SPI input select strap. PROVEN (source).";
            sw = r;
            hw = w;
        } spi_input_sel[16:16];
    } SC_SYSSTAT @ 0x8C;

    reg {
        name = "General purpose register 0";
        desc = "Scratch register that survives a soft reset (U-Boot uses SC_GEN1 as REG_START_FLAG). Evidence: PROVEN offset (vendor U-Boot platform.h; note that SC_GEN9 is at 0x154, not at 0x15C).";
        field {
            name = "value";
            desc = "Software scratch value. PROVEN.";
            sw = rw;
            hw = r;
        } value[31:0];
    } SC_GEN0 @ 0x138;

    reg {
        name = "General purpose register 1";
        desc = "Scratch register that survives a soft reset (U-Boot uses SC_GEN1 as REG_START_FLAG). U-Boot START_MAGIC 0x444F574E ('DOWN') is the start flag written here. Evidence: PROVEN offset (vendor U-Boot platform.h; note that SC_GEN9 is at 0x154, not at 0x15C).";
        field {
            name = "value";
            desc = "Software scratch value. PROVEN.";
            sw = rw;
            hw = r;
        } value[31:0];
    } SC_GEN1 @ 0x13C;

    reg {
        name = "General purpose register 2";
        desc = "Scratch register that survives a soft reset (U-Boot uses SC_GEN1 as REG_START_FLAG). Evidence: PROVEN offset (vendor U-Boot platform.h; note that SC_GEN9 is at 0x154, not at 0x15C).";
        field {
            name = "value";
            desc = "Software scratch value. PROVEN.";
            sw = rw;
            hw = r;
        } value[31:0];
    } SC_GEN2 @ 0x140;

    reg {
        name = "General purpose register 3";
        desc = "Scratch register that survives a soft reset (U-Boot uses SC_GEN1 as REG_START_FLAG). Evidence: PROVEN offset (vendor U-Boot platform.h; note that SC_GEN9 is at 0x154, not at 0x15C).";
        field {
            name = "value";
            desc = "Software scratch value. PROVEN.";
            sw = rw;
            hw = r;
        } value[31:0];
    } SC_GEN3 @ 0x144;

    reg {
        name = "General purpose register 4";
        desc = "Scratch register that survives a soft reset (U-Boot uses SC_GEN1 as REG_START_FLAG). Evidence: PROVEN offset (vendor U-Boot platform.h; note that SC_GEN9 is at 0x154, not at 0x15C).";
        field {
            name = "value";
            desc = "Software scratch value. PROVEN.";
            sw = rw;
            hw = r;
        } value[31:0];
    } SC_GEN4 @ 0x148;

    reg {
        name = "General purpose register 9";
        desc = "Scratch register that survives a soft reset (U-Boot uses SC_GEN1 as REG_START_FLAG). Evidence: PROVEN offset (vendor U-Boot platform.h; note that SC_GEN9 is at 0x154, not at 0x15C).";
        field {
            name = "value";
            desc = "Software scratch value. PROVEN.";
            sw = rw;
            hw = r;
        } value[31:0];
    } SC_GEN9 @ 0x154;

    reg {
        name = "SVB voltage record";
        desc = "Used by vendor U-Boot (SYS_CTRL_VOLT_REG 0x12020158) and read by the USB PHY driver (svb_otp_addr 0x12020158 in the vendor DT; thresholds 0x2BC..0x44C select phy trim variants). Content: the SVB (adaptive voltage) value. Evidence: PROVEN offset (U-Boot, DT), field layout UNKNOWN.";
        field {
            name = "svb_volt";
            desc = "SVB voltage value. PROVEN offset, UNKNOWN layout.";
            sw = rw;
            hw = r;
        } svb_volt[31:0];
    } SC_VOLT @ 0x158;

    reg {
        name = "HPM check result";
        desc = "Evidence: PROVEN (U-Boot hpm_check: union sysboot10 {sys_hpm_core [24:16], hpm_core_err [26]}).";
        field {
            name = "sys_hpm_core";
            desc = "HPM core value. PROVEN (source).";
            sw = rw;
            hw = r;
        } sys_hpm_core[24:16];
        field {
            name = "hpm_core_err";
            desc = "HPM core error flag. PROVEN (source).";
            sw = rw;
            hw = r;
        } hpm_core_err[26:26];
    } SC_HPM_CHECK @ 0x15C;

    reg {
        name = "SVB version";
        desc = "Evidence: PROVEN (U-Boot start_svb: bits [23:16] set to SVB_VER_16EV300 = 0x10).";
        field {
            name = "svb_ver";
            desc = "SVB algorithm version, 0x10 on the EV300 (0x10 on the EV200, too). PROVEN (source).";
            sw = rw;
            hw = r;
        } svb_ver[23:16];
    } SC_SVB_VER @ 0x168;

    reg {
        name = "Custom code";
        desc = "Read by sys.ko SYS_HAL_GetCustomCode through the 32 KB window at 0x12020000. Evidence: PROVEN offset, UNKNOWN fields.";
        field {
            name = "custom_code";
            desc = "Customer code word. PROVEN offset.";
            sw = r;
            hw = w;
        } custom_code[31:0];
    } SC_CUSTOM_CODE @ 0x230;

    reg {
        name = "Unique chip ID words";
        desc = "Six words read by sys.ko SYS_HAL_GetUniqueID (0x400..0x414), 192 bits. Evidence: PROVEN offsets, UNKNOWN layout.";
        field {
            name = "uid";
            desc = "Unique ID word. PROVEN.";
            sw = r;
            hw = w;
        } uid[31:0];
    } SC_UID[6] @ 0x400 += 0x4;

    reg {
        name = "Chip ID";
        desc = "Read by sys.ko SYS_HAL_GetChipID. The vendor U-Boot defines _HI3516E_V300 = 0x003516E300 for the same register family, so 0x3516E300 is the INFERRED value on the EV300 (not read from hardware). The Hi3516AV300 sheet has 0x3516A300 here.";
        field {
            name = "chip_id";
            desc = "Chip ID. PROVEN offset, INFERRED value 0x3516E300.";
            sw = r;
            hw = w;
        } chip_id[31:0];
    } SC_SYSID @ 0xEE0;

};

`endif
