`ifndef HI3516EV300_GZIP_RDL
`define HI3516EV300_GZIP_RDL

regfile eGZIP_V4_EV300 {
    name = "GZIP hardware decompressor, Hi3516EV200/EV300 generation";
    desc = "GZIP at 0x11310000 (vendor DT: SPI 50; the vendor U-Boot constant HW_DEC_INTR 86 is only a nominal argument of the polled handler hw_dec_intr_proc and is not wired to the GIC: conflict resolved in favor of the DT). Clock enable PERI_CRG100 (CRG 0x190) bit 0. Not a complete register list.";

    reg {
        name = "Decompressor work enable";
        desc = "Source: vendor U-Boot arch/arm/cpu/armv7/hi3516ev200/hw_compressed/hw_decompress_v1.[ch] (the EV200 tree; the EV300 U-Boot has no hw_compressed decompressor files but the same GZIP window 0x11310000 and DT interrupt). PROVEN offsets/bits (source, not run). hw_dec_work_en_set(1) after init.";
        field {
            name = "work_en";
            desc = "Enable the decompressor ('emar'). PROVEN.";
            sw = rw;
            hw = r;
        } work_en[0:0];
    } WORK_EN @ 0x100;

    reg {
        name = "AXI read ID";
        desc = "Source: vendor U-Boot arch/arm/cpu/armv7/hi3516ev200/hw_compressed/hw_decompress_v1.[ch] (the EV200 tree; the EV300 U-Boot has no hw_compressed decompressor files but the same GZIP window 0x11310000 and DT interrupt). PROVEN offsets/bits (source, not run). Written 0 by hw_dec_init.";
        field {
            name = "value";
            desc = "AXI read ID. PROVEN offset.";
            sw = rw;
            hw = r;
        } value[31:0];
    } EAMR_RID @ 0x108;

    reg {
        name = "AXI read outstanding";
        desc = "Source: vendor U-Boot arch/arm/cpu/armv7/hi3516ev200/hw_compressed/hw_decompress_v1.[ch] (the EV200 tree; the EV300 U-Boot has no hw_compressed decompressor files but the same GZIP window 0x11310000 and DT interrupt). PROVEN offsets/bits (source, not run). Written 3 by hw_dec_init.";
        field {
            name = "value";
            desc = "AXI read outstanding depth. PROVEN offset.";
            sw = rw;
            hw = r;
        } value[31:0];
    } EAMR_ROSD @ 0x10C;

    reg {
        name = "AXI write ID";
        desc = "Source: vendor U-Boot arch/arm/cpu/armv7/hi3516ev200/hw_compressed/hw_decompress_v1.[ch] (the EV200 tree; the EV300 U-Boot has no hw_compressed decompressor files but the same GZIP window 0x11310000 and DT interrupt). PROVEN offsets/bits (source, not run). Written 0 by hw_dec_init.";
        field {
            name = "value";
            desc = "AXI write ID. PROVEN offset.";
            sw = rw;
            hw = r;
        } value[31:0];
    } EAMR_WID @ 0x110;

    reg {
        name = "AXI write outstanding";
        desc = "Source: vendor U-Boot arch/arm/cpu/armv7/hi3516ev200/hw_compressed/hw_decompress_v1.[ch] (the EV200 tree; the EV300 U-Boot has no hw_compressed decompressor files but the same GZIP window 0x11310000 and DT interrupt). PROVEN offsets/bits (source, not run). Written 3 by hw_dec_init.";
        field {
            name = "value";
            desc = "AXI write outstanding depth. PROVEN offset.";
            sw = rw;
            hw = r;
        } value[31:0];
    } EAMR_WOSD @ 0x114;

    reg {
        name = "Interrupt status";
        desc = "Source: vendor U-Boot arch/arm/cpu/armv7/hi3516ev200/hw_compressed/hw_decompress_v1.[ch] (the EV200 tree; the EV300 U-Boot has no hw_compressed decompressor files but the same GZIP window 0x11310000 and DT interrupt). PROVEN offsets/bits (source, not run). U_INTR_STATUS.";
        field {
            name = "task_intr";
            desc = "Task (whole stream) done. PROVEN.";
            sw = r;
            hw = w;
        } task_intr[0:0];
        field {
            name = "block_intr";
            desc = "Input block consumed. PROVEN.";
            sw = r;
            hw = w;
        } block_intr[1:1];
    } INT_STATUS @ 0x124;

    reg {
        name = "Interrupt enable";
        desc = "Source: vendor U-Boot arch/arm/cpu/armv7/hi3516ev200/hw_compressed/hw_decompress_v1.[ch] (the EV200 tree; the EV300 U-Boot has no hw_compressed decompressor files but the same GZIP window 0x11310000 and DT interrupt). PROVEN offsets/bits (source, not run). hw_dec_intr_en_set(1, 1).";
        field {
            name = "task_intr_en";
            desc = "Task interrupt enable. PROVEN.";
            sw = rw;
            hw = r;
        } task_intr_en[0:0];
        field {
            name = "block_intr_en";
            desc = "Block interrupt enable. PROVEN.";
            sw = rw;
            hw = r;
        } block_intr_en[1:1];
    } INT_EN @ 0x128;

    reg {
        name = "Interrupt clear";
        desc = "Source: vendor U-Boot arch/arm/cpu/armv7/hi3516ev200/hw_compressed/hw_decompress_v1.[ch] (the EV200 tree; the EV300 U-Boot has no hw_compressed decompressor files but the same GZIP window 0x11310000 and DT interrupt). PROVEN offsets/bits (source, not run). Read-modify-write by hw_dec_task_intr_status_clr / block_intr_status_clr; bit layout equals INT_STATUS (INFERRED).";
        field {
            name = "task_intr_clr";
            desc = "Clear task interrupt. INFERRED.";
            sw = rw;
            hw = r;
        } task_intr_clr[0:0];
        field {
            name = "block_intr_clr";
            desc = "Clear block interrupt. INFERRED.";
            sw = rw;
            hw = r;
        } block_intr_clr[1:1];
    } INT_CLEAR @ 0x130;

    reg {
        name = "Output buffer address";
        desc = "Source: vendor U-Boot arch/arm/cpu/armv7/hi3516ev200/hw_compressed/hw_decompress_v1.[ch] (the EV200 tree; the EV300 U-Boot has no hw_compressed decompressor files but the same GZIP window 0x11310000 and DT interrupt). PROVEN offsets/bits (source, not run). Destination buffer.";
        field {
            name = "value";
            desc = "Physical address. PROVEN.";
            sw = rw;
            hw = r;
        } value[31:0];
    } DPRS_DATA_RTN_BADDR @ 0x2020;

    reg {
        name = "Output buffer length";
        desc = "Source: vendor U-Boot arch/arm/cpu/armv7/hi3516ev200/hw_compressed/hw_decompress_v1.[ch] (the EV200 tree; the EV300 U-Boot has no hw_compressed decompressor files but the same GZIP window 0x11310000 and DT interrupt). PROVEN offsets/bits (source, not run).";
        field {
            name = "value";
            desc = "Length. PROVEN.";
            sw = rw;
            hw = r;
        } value[31:0];
    } DPRS_DATA_RTN_LEN @ 0x2024;

    reg {
        name = "Result info buffer address";
        desc = "Source: vendor U-Boot arch/arm/cpu/armv7/hi3516ev200/hw_compressed/hw_decompress_v1.[ch] (the EV200 tree; the EV300 U-Boot has no hw_compressed decompressor files but the same GZIP window 0x11310000 and DT interrupt). PROVEN offsets/bits (source, not run).";
        field {
            name = "value";
            desc = "Physical address. PROVEN.";
            sw = rw;
            hw = r;
        } value[31:0];
    } DPRS_DATA_INFO_BADDR @ 0x2028;

    reg {
        name = "Result info buffer length";
        desc = "Source: vendor U-Boot arch/arm/cpu/armv7/hi3516ev200/hw_compressed/hw_decompress_v1.[ch] (the EV200 tree; the EV300 U-Boot has no hw_compressed decompressor files but the same GZIP window 0x11310000 and DT interrupt). PROVEN offsets/bits (source, not run).";
        field {
            name = "value";
            desc = "Length. PROVEN.";
            sw = rw;
            hw = r;
        } value[31:0];
    } DPRS_DATA_INFO_LEN @ 0x202C;

    reg {
        name = "Expected CRC32";
        desc = "Source: vendor U-Boot arch/arm/cpu/armv7/hi3516ev200/hw_compressed/hw_decompress_v1.[ch] (the EV200 tree; the EV300 U-Boot has no hw_compressed decompressor files but the same GZIP window 0x11310000 and DT interrupt). PROVEN offsets/bits (source, not run).";
        field {
            name = "value";
            desc = "CRC32 compared when CRC_CHECK_EN is set. PROVEN.";
            sw = rw;
            hw = r;
        } value[31:0];
    } DPRS_DATA_CRC32 @ 0x2030;

    reg {
        name = "Source buffer address";
        desc = "Source: vendor U-Boot arch/arm/cpu/armv7/hi3516ev200/hw_compressed/hw_decompress_v1.[ch] (the EV200 tree; the EV300 U-Boot has no hw_compressed decompressor files but the same GZIP window 0x11310000 and DT interrupt). PROVEN offsets/bits (source, not run).";
        field {
            name = "value";
            desc = "Physical address of the compressed data. PROVEN.";
            sw = rw;
            hw = r;
        } value[31:0];
    } DPRS_DATA_SRC_BADDR @ 0x2040;

    reg {
        name = "Source buffer descriptor";
        desc = "Source: vendor U-Boot arch/arm/cpu/armv7/hi3516ev200/hw_compressed/hw_decompress_v1.[ch] (the EV200 tree; the EV300 U-Boot has no hw_compressed decompressor files but the same GZIP window 0x11310000 and DT interrupt). PROVEN offsets/bits (source, not run). U_DPRS_DATA_BUF_INFO.";
        field {
            name = "buf_len";
            desc = "Buffer length. PROVEN.";
            sw = rw;
            hw = r;
        } buf_len[23:0];
        field {
            name = "buf_id";
            desc = "Buffer ID. PROVEN.";
            sw = rw;
            hw = r;
        } buf_id[25:24];
        field {
            name = "eop";
            desc = "End of packet. PROVEN.";
            sw = rw;
            hw = r;
        } eop[28:28];
        field {
            name = "sop";
            desc = "Start of packet. PROVEN.";
            sw = rw;
            hw = r;
        } sop[29:29];
        field {
            name = "mode";
            desc = "Mode. PROVEN position, meaning UNKNOWN.";
            sw = rw;
            hw = r;
        } mode[31:31];
    } DPRS_DATA_SRC_LEN @ 0x2044;

    reg {
        name = "Input buffer status";
        desc = "Source: vendor U-Boot arch/arm/cpu/armv7/hi3516ev200/hw_compressed/hw_decompress_v1.[ch] (the EV200 tree; the EV300 U-Boot has no hw_compressed decompressor files but the same GZIP window 0x11310000 and DT interrupt). PROVEN offsets/bits (source, not run). U_BUF_STATUS.";
        field {
            name = "buf_id";
            desc = "Buffer ID. PROVEN.";
            sw = r;
            hw = w;
        } buf_id[1:0];
        field {
            name = "aval_flg";
            desc = "Status available. PROVEN.";
            sw = r;
            hw = w;
        } aval_flg[31:31];
    } BUF_INFO @ 0x2080;

    reg {
        name = "Decompression result status";
        desc = "Source: vendor U-Boot arch/arm/cpu/armv7/hi3516ev200/hw_compressed/hw_decompress_v1.[ch] (the EV200 tree; the EV300 U-Boot has no hw_compressed decompressor files but the same GZIP window 0x11310000 and DT interrupt). PROVEN offsets/bits (source, not run). U_DPRS_RTN_STATUS.";
        field {
            name = "err_info";
            desc = "Error code, 0 = ok. PROVEN.";
            sw = r;
            hw = w;
        } err_info[7:0];
        field {
            name = "aval_flg";
            desc = "Result available. PROVEN.";
            sw = r;
            hw = w;
        } aval_flg[31:31];
    } DPRS_RTN_INFO @ 0x2084;

    reg {
        name = "Decompressed length";
        desc = "Source: vendor U-Boot arch/arm/cpu/armv7/hi3516ev200/hw_compressed/hw_decompress_v1.[ch] (the EV200 tree; the EV300 U-Boot has no hw_compressed decompressor files but the same GZIP window 0x11310000 and DT interrupt). PROVEN offsets/bits (source, not run).";
        field {
            name = "len";
            desc = "Number of bytes produced. PROVEN.";
            sw = r;
            hw = w;
        } len[31:0];
    } DPRS_RTN_LEN @ 0x2088;

    reg {
        name = "Input buffer status clear";
        desc = "Source: vendor U-Boot arch/arm/cpu/armv7/hi3516ev200/hw_compressed/hw_decompress_v1.[ch] (the EV200 tree; the EV300 U-Boot has no hw_compressed decompressor files but the same GZIP window 0x11310000 and DT interrupt). PROVEN offsets/bits (source, not run).";
        field {
            name = "clr";
            desc = "Write 1 to clear. PROVEN.";
            sw = w;
            hw = r;
        } clr[0:0];
    } BUF_INFO_CLR @ 0x2090;

    reg {
        name = "Result status clear";
        desc = "Source: vendor U-Boot arch/arm/cpu/armv7/hi3516ev200/hw_compressed/hw_decompress_v1.[ch] (the EV200 tree; the EV300 U-Boot has no hw_compressed decompressor files but the same GZIP window 0x11310000 and DT interrupt). PROVEN offsets/bits (source, not run).";
        field {
            name = "clr";
            desc = "Write 1 to clear. PROVEN.";
            sw = w;
            hw = r;
        } clr[0:0];
    } RLT_INFO_CLR @ 0x2094;

    reg {
        name = "Task mode";
        desc = "Source: vendor U-Boot arch/arm/cpu/armv7/hi3516ev200/hw_compressed/hw_decompress_v1.[ch] (the EV200 tree; the EV300 U-Boot has no hw_compressed decompressor files but the same GZIP window 0x11310000 and DT interrupt). PROVEN offsets/bits (source, not run). Offset defined (TASK_MODE_REG), no access seen in the file.";
        field {
            name = "value";
            desc = "UNKNOWN layout.";
            sw = rw;
            hw = r;
        } value[31:0];
    } TASK_MODE @ 0x2134;

    reg {
        name = "CRC check enable";
        desc = "Source: vendor U-Boot arch/arm/cpu/armv7/hi3516ev200/hw_compressed/hw_decompress_v1.[ch] (the EV200 tree; the EV300 U-Boot has no hw_compressed decompressor files but the same GZIP window 0x11310000 and DT interrupt). PROVEN offsets/bits (source, not run).";
        field {
            name = "crc_en";
            desc = "Enable CRC32 check. PROVEN.";
            sw = rw;
            hw = r;
        } crc_en[0:0];
    } CRC_CHECK_EN @ 0x4000;

};

`endif
