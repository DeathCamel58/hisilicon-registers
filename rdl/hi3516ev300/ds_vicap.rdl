`ifndef HI3516EV300_VICAP_RDL
`define HI3516EV300_VICAP_RDL
regfile eHI3516EV300_VICAP {
    name = "Video capture (VICAP)";
    desc = "Video capture (VICAP) of the Hi3516E V300 at base 0x1100_0000. 77 registers extracted programmatically from the Hi3516E V300 data sheet (Issue 00B06, 2019-05-15) (Table 9-2 Summary of VICAP registers (base address: 0x1100_0000)): register headings, offsets, total reset values, field bit ranges, access types, names, reset values and descriptions, with PDF page numbers in each register description. Field names, bit ranges, access types and offsets are exact; the free-text descriptions are taken from the cell text of the field table and were checked by sampling only. Hardware not verified.";
    reg {
        name = "WK_MODE";
        desc = "WK_MODE is the global operating mode configuration register. (offset 0x0; total reset 0x00000003; PROVEN: Hi3516E V300 data sheet (Issue 00B06, 2019-05-15), section 9.1.6, PDF page 433).";
        field {
            name = "reserved";
            desc = "Reserved";
            sw = r; hw = w;
            reset = 0x0;
        } reserved_31_2[31:2];
        field {
            name = "reserved";
            desc = "Reserved";
            sw = r; hw = w;
            reset = 0x1;
        } reserved_1_1[1:1];
        field {
            name = "power_mode";
            desc = "Clock mode
- 0: The low-power mode is disabled.
- 1: The low-power mode is disabled.";
            sw = rw; hw = r;
            reset = 0x1;
        } power_mode[0:0];
    } WK_MODE @ 0x0;
    reg {
        name = "AXI_CFG";
        desc = "AXI_CFG is the bus configuration register. (offset 0x10; total reset 0x00000000; PROVEN: Hi3516E V300 data sheet (Issue 00B06, 2019-05-15), section 9.1.6, PDF page 434).";
        field {
            name = "reserved";
            desc = "Reserved";
            sw = r; hw = w;
            reset = 0x0;
        } reserved_31_8[31:8];
        field {
            name = "w_outstanding";
            desc = "Number of write request outstandings Value range: [0,7]";
            sw = rw; hw = r;
            reset = 0x0;
        } w_outstanding[7:4];
        field {
            name = "reserved";
            desc = "Reserved";
            sw = r; hw = w;
            reset = 0x0;
        } reserved_3_0[3:0];
    } AXI_CFG @ 0x10;
    reg {
        name = "CMUX_ID_CFG";
        desc = "CMUX_ID_CFG is the CMUX frame ID select register. (offset 0x54; total reset 0x00FFFFFF; PROVEN: Hi3516E V300 data sheet (Issue 00B06, 2019-05-15), section 9.1.6, PDF page 434).";
        field {
            name = "reserved";
            desc = "Reserved";
            sw = r; hw = w;
            reset = 0x0;
        } reserved_31_24[31:24];
        field {
            name = "reserved";
            desc = "Reserved";
            sw = r; hw = w;
            reset = 0xf;
        } reserved_23_20[23:20];
        field {
            name = "reserved";
            desc = "Reserved";
            sw = r; hw = w;
            reset = 0xf;
        } reserved_19_16[19:16];
        field {
            name = "reserved";
            desc = "Reserved";
            sw = r; hw = w;
            reset = 0xf;
        } reserved_15_12[15:12];
        field {
            name = "chn2_id";
            desc = "Channel 2 ID select register
- 0: Data with this ID is filtered.
- 1: Data with this ID is received. bit[0]: Channel RX enable for data with the ID 0 bit[1]: Channel RX enable for data with the ID 1 bit[2]: Channel RX enable for data with the ID 2 bit[3]: Channel RX enable for data with the ID 3";
            sw = rw; hw = r;
            reset = 0xf;
        } chn2_id[11:8];
        field {
            name = "chn1_id";
            desc = "Channel 1 ID select register";
            sw = rw; hw = r;
            reset = 0xf;
        } chn1_id[7:4];
        field {
            name = "chn0_id";
            desc = "Channel 0 ID select register
- 0: Data with this ID is filtered.
- 1: Data with this ID is received. bit[0]: Channel RX enable for data with the ID 0 bit[1]: Channel RX enable for data with the ID 1 bit[2]: Channel RX enable for data with the ID 2 bit[3]: Channel RX enable for data with the ID 3";
            sw = rw; hw = r;
            reset = 0xf;
        } chn0_id[3:0];
    } CMUX_ID_CFG @ 0x54;
    reg {
        name = "ISP_MODE";
        desc = "ISP_MODE is the ISP mode select register. (offset 0x58; total reset 0x00000000; PROVEN: Hi3516E V300 data sheet (Issue 00B06, 2019-05-15), section 9.1.6, PDF page 435).";
        field {
            name = "reserved";
            desc = "Reserved";
            sw = r; hw = w;
            reset = 0x0;
        } reserved_31_18[31:18];
        field {
            name = "isp1_in_yuv_mode";
            desc = "ISP 1 mode select configuration register
- 0: Raw data is input.
- 1: YUV data is input.";
            sw = rw; hw = r;
            reset = 0x0;
        } isp1_in_yuv_mode[17:17];
        field {
            name = "isp0_in_yuv_mode";
            desc = "ISP 0 mode select configuration register
- 0: Raw data is input.
- 1: YUV data is input.";
            sw = rw; hw = r;
            reset = 0x0;
        } isp0_in_yuv_mode[16:16];
        field {
            name = "reserved";
            desc = "Reserved";
            sw = r; hw = w;
            reset = 0x0;
        } reserved_15_2[15:2];
        field {
            name = "isp1_mode";
            desc = "ISP 1 mode select configuration register
- 0: Data is processed by the ISP.
- 1: Data is bypassed by the ISP.";
            sw = rw; hw = r;
            reset = 0x0;
        } isp1_mode[1:1];
        field {
            name = "isp0_mode";
            desc = "ISP 0 mode select configuration register
- 0: Data is processed by the ISP.
- 1: Data is bypassed by the ISP.";
            sw = rw; hw = r;
            reset = 0x0;
        } isp0_mode[0:0];
    } ISP_MODE @ 0x58;
    reg {
        name = "VICAP_INT";
        desc = "VICAP_INT is the interrupt status register. (offset 0xF0; total reset 0x00000000; PROVEN: Hi3516E V300 data sheet (Issue 00B06, 2019-05-15), section 9.1.6, PDF page 436).";
        field {
            name = "reserved";
            desc = "Reserved";
            sw = r; hw = w;
            reset = 0x0;
        } reserved_31_27[31:27];
        field {
            name = "int_dbg";
            desc = "System bus exception interrupt indicator
- 0: No interrupt is generated.
- 1: An interrupt is generated.";
            sw = r; hw = w;
            reset = 0x0;
        } int_dbg[26:26];
        field {
            name = "reserved";
            desc = "Reserved";
            sw = r; hw = w;
            reset = 0x0;
        } reserved_25_18[25:18];
        field {
            name = "int_isp1";
            desc = "ISP 1 interrupt indicator
- 0: No interrupt is generated.
- 1: An interrupt is generated.";
            sw = r; hw = w;
            reset = 0x0;
        } int_isp1[17:17];
        field {
            name = "int_isp0";
            desc = "ISP 0 interrupt indicator
- 0: No interrupt is generated.
- 1: An interrupt is generated.";
            sw = r; hw = w;
            reset = 0x0;
        } int_isp0[16:16];
        field {
            name = "reserved";
            desc = "Reserved";
            sw = r; hw = w;
            reset = 0x0;
        } reserved_15_10[15:10];
        field {
            name = "int_ch1";
            desc = "Channel 1 interrupt indicator
- 0: No interrupt is generated.
- 1: An interrupt is generated.";
            sw = r; hw = w;
            reset = 0x0;
        } int_ch1[9:9];
        field {
            name = "int_ch0";
            desc = "Channel 0 interrupt indicator
- 0: No interrupt is generated.
- 1: An interrupt is generated.";
            sw = r; hw = w;
            reset = 0x0;
        } int_ch0[8:8];
        field {
            name = "reserved";
            desc = "Reserved";
            sw = r; hw = w;
            reset = 0x0;
        } reserved_7_1[7:1];
        field {
            name = "int_pt0";
            desc = "Port 0 interrupt indicator
- 0: No interrupt is generated.
- 1: An interrupt is generated.";
            sw = r; hw = w;
            reset = 0x0;
        } int_pt0[0:0];
    } VICAP_INT @ 0xF0;
    reg {
        name = "VICAP_INT_MASK";
        desc = "VICAP_INT_MASK is the interrupt mask register. (offset 0xF8; total reset 0x00000000; PROVEN: Hi3516E V300 data sheet (Issue 00B06, 2019-05-15), section 9.1.6, PDF page 437).";
        field {
            name = "reserved";
            desc = "Reserved";
            sw = r; hw = w;
            reset = 0x0;
        } reserved_31_27[31:27];
        field {
            name = "mask_dbg";
            desc = "System bus exception interrupt enable
- 0: The interrupt is masked.
- 1: The interrupt is enabled.";
            sw = rw; hw = r;
            reset = 0x0;
        } mask_dbg[26:26];
        field {
            name = "reserved";
            desc = "Reserved";
            sw = r; hw = w;
            reset = 0x0;
        } reserved_25_18[25:18];
        field {
            name = "mask_isp1";
            desc = "ISP 1 interrupt enable
- 0: The interrupt is masked.
- 1: The interrupt is enabled.";
            sw = rw; hw = r;
            reset = 0x0;
        } mask_isp1[17:17];
        field {
            name = "mask_isp0";
            desc = "ISP 0 interrupt enable
- 0: The interrupt is masked.
- 1: The interrupt is enabled.";
            sw = rw; hw = r;
            reset = 0x0;
        } mask_isp0[16:16];
        field {
            name = "reserved";
            desc = "Reserved";
            sw = rw; hw = r;
            reset = 0x0;
        } reserved_15_10[15:10];
        field {
            name = "mask_ch1";
            desc = "Channel 1 interrupt enable
- 0: The interrupt is masked.
- 1: The interrupt is enabled.";
            sw = rw; hw = r;
            reset = 0x0;
        } mask_ch1[9:9];
        field {
            name = "mask_ch0";
            desc = "Channel 0 interrupt enable
- 0: The interrupt is masked.
- 1: The interrupt is enabled.";
            sw = rw; hw = r;
            reset = 0x0;
        } mask_ch0[8:8];
        field {
            name = "reserved";
            desc = "Reserved";
            sw = r; hw = w;
            reset = 0x0;
        } reserved_7_1[7:1];
        field {
            name = "mask_pt0";
            desc = "Port 0 interrupt enable
- 0: The interrupt is masked.
- 1: The interrupt is enabled.";
            sw = rw; hw = r;
            reset = 0x0;
        } mask_pt0[0:0];
    } VICAP_INT_MASK @ 0xF8;
    reg {
        name = "SLAVE0_MODE_CFG";
        desc = "SLAVE0_MODE_CFG is the sensor 0 slave mode configuration register. (offset 0x100; total reset 0x00000000; PROVEN: Hi3516E V300 data sheet (Issue 00B06, 2019-05-15), section 9.1.6, PDF page 437).";
        field {
            name = "slave0_vs_enable";
            desc = "Vsync output enable
- 0: disabled
- 1: enabled";
            sw = rw; hw = r;
            reset = 0x0;
        } slave0_vs_enable[31:31];
        field {
            name = "slave0_hs_enable";
            desc = "Hsync output enable
- 0: disabled
- 1: enabled";
            sw = rw; hw = r;
            reset = 0x0;
        } slave0_hs_enable[30:30];
        field {
            name = "slave0_vs_out_enable";
            desc = "VS_OUT output enable
- 0: disabled
- 1: enabled";
            sw = rw; hw = r;
            reset = 0x0;
        } slave0_vs_out_enable[29:29];
        field {
            name = "reserved";
            desc = "Reserved";
            sw = r; hw = w;
            reset = 0x0;
        } reserved_28_18[28:18];
        field {
            name = "slave0_vs_inv";
            desc = "Vsync output polarity
- 0: active high
- 1: active low";
            sw = rw; hw = r;
            reset = 0x0;
        } slave0_vs_inv[17:17];
        field {
            name = "slave0_hs_inv";
            desc = "Hsync output polarity
- 0: active high
- 1: active low";
            sw = rw; hw = r;
            reset = 0x0;
        } slave0_hs_inv[16:16];
        field {
            name = "slave0_vs_out_inv";
            desc = "VS_OUT output polarity
- 0: active high
- 1: active low";
            sw = rw; hw = r;
            reset = 0x0;
        } slave0_vs_out_inv[15:15];
        field {
            name = "slave0_vs_mux";
            desc = "VS/VS_OUT output signal switchover enable
- 0: disabled
- 1: enabled";
            sw = rw; hw = r;
            reset = 0x0;
        } slave0_vs_mux[14:14];
        field {
            name = "reserved";
            desc = "Reserved";
            sw = r; hw = w;
            reset = 0x0;
        } reserved_13_1[13:1];
        field {
            name = "slave0_update_mode";
            desc = "Update mode select
- 0: immediate update mode
- 1: frame update mode";
            sw = rw; hw = r;
            reset = 0x0;
        } slave0_update_mode[0:0];
    } SLAVE0_MODE_CFG @ 0x100;
    reg {
        name = "SLAVE0_MODE_VS_TIME_H";
        desc = "SLAVE0_MODE_VS_TIME_H is the Vsync output cycle configuration register in sensor 0 slave mode. (offset 0x104; total reset 0x00000000; PROVEN: Hi3516E V300 data sheet (Issue 00B06, 2019-05-15), section 9.1.6, PDF page 438).";
        field {
            name = "slave0_vs_time_h";
            desc = "Vsync output cycle configuration (unit: working clock cycle of the sensor)";
            sw = rw; hw = r;
            reset = 0x0;
        } slave0_vs_time_h[31:0];
    } SLAVE0_MODE_VS_TIME_H @ 0x104;
    reg {
        name = "SLAVE0_MODE_VS_TIME_L";
        desc = "SLAVE0_MODE_VS_TIME_L is the Vsync output cycle configuration register in sensor 0 slave mode. (offset 0x108; total reset 0x00000000; PROVEN: Hi3516E V300 data sheet (Issue 00B06, 2019-05-15), section 9.1.6, PDF page 438).";
        field {
            name = "slave0_vs_time_l";
            desc = "Vsync output cycle configuration (unit: working clock cycle of the sensor)";
            sw = rw; hw = r;
            reset = 0x0;
        } slave0_vs_time_l[31:0];
    } SLAVE0_MODE_VS_TIME_L @ 0x108;
    reg {
        name = "SLAVE0_MODE_HS_TIME";
        desc = "SLAVE0_MODE_HS_TIME is the Hsync (HS) output cycle configuration register in sensor 0 slave mode. (offset 0x10C; total reset 0x00000000; PROVEN: Hi3516E V300 data sheet (Issue 00B06, 2019-05-15), section 9.1.6, PDF page 439).";
        field {
            name = "slave0_hs_time";
            desc = "Hsync output cycle configuration (unit: working clock cycle of the sensor)";
            sw = rw; hw = r;
            reset = 0x0;
        } slave0_hs_time[31:0];
    } SLAVE0_MODE_HS_TIME @ 0x10C;
    reg {
        name = "SLAVE0_MODE_VS_CYC_H";
        desc = "SLAVE0_MODE_VS_CYC_H is the Vsync output pulse validity signal duration configuration register in sensor 0 slave mode (offset 0x118; total reset 0x00000000; PROVEN: Hi3516E V300 data sheet (Issue 00B06, 2019-05-15), section 9.1.6, PDF page 439).";
        field {
            name = "slave0_vs_cyc_h";
            desc = "Duration configuration of the Vsync output validity signal (unit: working clock cycle of the sensor)";
            sw = rw; hw = r;
            reset = 0x0;
        } slave0_vs_cyc_h[31:0];
    } SLAVE0_MODE_VS_CYC_H @ 0x118;
    reg {
        name = "SLAVE0_MODE_VS_CYC_L";
        desc = "SLAVE0_MODE_VS_CYC_L is the Vsync output pulse validity signal duration configuration register in sensor 0 slave mode. (offset 0x11C; total reset 0x00000000; PROVEN: Hi3516E V300 data sheet (Issue 00B06, 2019-05-15), section 9.1.6, PDF page 439).";
        field {
            name = "slave0_vs_cyc_l";
            desc = "Duration configuration of the Vsync output validity signal (unit: working clock cycle of the sensor)";
            sw = rw; hw = r;
            reset = 0x0;
        } slave0_vs_cyc_l[31:0];
    } SLAVE0_MODE_VS_CYC_L @ 0x11C;
    reg {
        name = "SLAVE0_MODE_HS_CYC";
        desc = "SLAVE0_MODE_HS_CYC is the Hsync output pulse validity signal duration configuration register in sensor 0 slave mode (offset 0x120; total reset 0x00000000; PROVEN: Hi3516E V300 data sheet (Issue 00B06, 2019-05-15), section 9.1.6, PDF page 440).";
        field {
            name = "slave0_hs_cyc";
            desc = "Duration configuration of the Hsync output validity signal (unit: working clock cycle of the sensor)";
            sw = rw; hw = r;
            reset = 0x0;
        } slave0_hs_cyc[31:0];
    } SLAVE0_MODE_HS_CYC @ 0x120;
    reg {
        name = "SLAVE0_MODE_HS_DLY_CYC";
        desc = "SLAVE0_MODE_HS_DLY_CYC is the Hsync pulse output relative to Vsync pulse delay cycle configuration register in sensor 0 slave mode. (offset 0x12C; total reset 0x00000000; PROVEN: Hi3516E V300 data sheet (Issue 00B06, 2019-05-15), section 9.1.6, PDF page 440).";
        field {
            name = "slave0_hs_dly_cyc";
            desc = "Hsync pulse output relative to Vsync pulse delay cycle configuration (unit: working clock cycle of the sensor)";
            sw = rw; hw = r;
            reset = 0x0;
        } slave0_hs_dly_cyc[31:0];
    } SLAVE0_MODE_HS_DLY_CYC @ 0x12C;
    reg {
        name = "SLAVE_MODE_SYN";
        desc = "SLAVE_MODE_SYN is the sensor synchronization signal, active on the rising edge. (offset 0x1FC; total reset 0x00000000; PROVEN: Hi3516E V300 data sheet (Issue 00B06, 2019-05-15), section 9.1.6, PDF page 440).";
        field {
            name = "reserved";
            desc = "Reserved";
            sw = r; hw = w;
            reset = 0x0;
        } reserved_31_3[31:3];
        field {
            name = "sensor2_sync";
            desc = "Sensor 2 sync signal";
            sw = rw; hw = r;
            reset = 0x0;
        } sensor2_sync[2:2];
        field {
            name = "sensor1_sync";
            desc = "Sensor 1 sync signal";
            sw = rw; hw = r;
            reset = 0x0;
        } sensor1_sync[1:1];
        field {
            name = "sensor0_sync";
            desc = "Sensor 0 sync signal";
            sw = rw; hw = r;
            reset = 0x0;
        } sensor0_sync[0:0];
    } SLAVE_MODE_SYN @ 0x1FC;
    reg {
        name = "ONLINE0_CFG";
        desc = "ONLINE0_CFG is the online channel 0 control register. (offset 0x200; total reset 0x00000003; PROVEN: Hi3516E V300 data sheet (Issue 00B06, 2019-05-15), section 9.1.6, PDF page 440).";
        field {
            name = "online0_en";
            desc = "Online output enable
- 0: disabled
- 1: enabled";
            sw = rw; hw = r;
            reset = 0x0;
        } online0_en[31:31];
        field {
            name = "reserved";
            desc = "Reserved";
            sw = r; hw = w;
            reset = 0x0;
        } reserved_30_2[30:2];
        field {
            name = "online0_vsync_mode";
            desc = "Whether to delay the Vsync signal
- 0: not processed
- 1: processed";
            sw = rw; hw = r;
            reset = 0x1;
        } online0_vsync_mode[1:1];
        field {
            name = "online0_hsync_mode";
            desc = "Whether to delay the Hsync signal
- 0: not processed
- 1: processed";
            sw = rw; hw = r;
            reset = 0x1;
        } online0_hsync_mode[0:0];
    } ONLINE0_CFG @ 0x200;
    reg {
        name = "ONLINE0_SIZE";
        desc = "ONLINE0_SIZE is the online 0 output active area size register. (offset 0x2AC; total reset 0x00000000; PROVEN: Hi3516E V300 data sheet (Issue 00B06, 2019-05-15), section 9.1.6, PDF page 441).";
        field {
            name = "online0_height";
            desc = "Height of the active image";
            sw = r; hw = w;
            reset = 0x0;
        } online0_height[31:16];
        field {
            name = "online0_width";
            desc = "Width of the active image";
            sw = r; hw = w;
            reset = 0x0;
        } online0_width[15:0];
    } ONLINE0_SIZE @ 0x2AC;
    reg {
        name = "VICAP_AXI0_WR_ERROR";
        desc = "VICAP_AXI0_WR_ERROR is the AXI 0 write error status register. (offset 0xFE4; total reset 0x00000000; PROVEN: Hi3516E V300 data sheet (Issue 00B06, 2019-05-15), section 9.1.6, PDF page 441).";
        field {
            name = "reserved";
            desc = "Reserved";
            sw = r; hw = w;
            reset = 0x0;
        } reserved_31_24[31:24];
        field {
            name = "isp1_stt_bus_err";
            desc = "Invalid access error of ISP 1 STT channel Writing 1 clears this bit.

Access type WC in the data sheet: written 1 clears the bit.";
            sw = rw; hw = w; onwrite = woclr;
            reset = 0x0;
        } isp1_stt_bus_err[23:23];
        field {
            name = "isp0_stt_bus_err";
            desc = "Invalid access error of ISP 0 STT channel Writing 1 clears this bit.

Access type WC in the data sheet: written 1 clears the bit.";
            sw = rw; hw = w; onwrite = woclr;
            reset = 0x0;
        } isp0_stt_bus_err[22:22];
        field {
            name = "reserved";
            desc = "Reserved";
            sw = r; hw = w;
            reset = 0x0;
        } reserved_21_4[21:4];
        field {
            name = "reserved";
            desc = "Reserved";
            sw = r; hw = w;
            reset = 0x0;
        } reserved_3_3[3:3];
        field {
            name = "ch1_y_bus_err";
            desc = "Invalid access error of CH1_Y channel Writing 1 clears this bit.

Access type WC in the data sheet: written 1 clears the bit.";
            sw = rw; hw = w; onwrite = woclr;
            reset = 0x0;
        } ch1_y_bus_err[2:2];
        field {
            name = "reserved";
            desc = "Reserved";
            sw = r; hw = w;
            reset = 0x0;
        } reserved_1_1[1:1];
        field {
            name = "ch0_y_bus_err";
            desc = "Invalid access error of CH0_Y channel Writing 1 clears this bit.

Access type WC in the data sheet: written 1 clears the bit.";
            sw = rw; hw = w; onwrite = woclr;
            reset = 0x0;
        } ch0_y_bus_err[0:0];
    } VICAP_AXI0_WR_ERROR @ 0xFE4;
    reg {
        name = "VICAP_DBG_INT";
        desc = "VICAP_DBG_INT is the system abnormal interrupt status register. (offset 0xFF0; total reset 0x00000000; PROVEN: Hi3516E V300 data sheet (Issue 00B06, 2019-05-15), section 9.1.6, PDF page 442).";
        field {
            name = "reserved";
            desc = "Reserved";
            sw = r; hw = w;
            reset = 0x0;
        } reserved_31_2[31:2];
        field {
            name = "apb_bus_err";
            desc = "Interrupt status of APB invalid access error Writing 1 clears this bit.
- 0: No interrupt is generated.
- 1: An interrupt is generated.

Access type WC in the data sheet: written 1 clears the bit.";
            sw = rw; hw = w; onwrite = woclr;
            reset = 0x0;
        } apb_bus_err[1:1];
        field {
            name = "axi_bus_err";
            desc = "Interrupt status of AXI invalid access error Writing 1 clears this bit.
- 0: No interrupt is generated.
- 1: An interrupt is generated.

Access type WC in the data sheet: written 1 clears the bit.";
            sw = rw; hw = w; onwrite = woclr;
            reset = 0x0;
        } axi_bus_err[0:0];
    } VICAP_DBG_INT @ 0xFF0;
    reg {
        name = "VICAP_DBG_INT_MASK";
        desc = "VICAP_DBG_INT_MASK is the system abnormal mask status register. (offset 0xFF8; total reset 0x00000000; PROVEN: Hi3516E V300 data sheet (Issue 00B06, 2019-05-15), section 9.1.6, PDF page 442).";
        field {
            name = "reserved";
            desc = "Reserved";
            sw = r; hw = w;
            reset = 0x0;
        } reserved_31_2[31:2];
        field {
            name = "apb_bus_err_mask";
            desc = "Interrupt enable for APB invalid access error
- 0: disabled
- 1: enabled";
            sw = rw; hw = r;
            reset = 0x0;
        } apb_bus_err_mask[1:1];
        field {
            name = "axi_bus_err_mask";
            desc = "Interrupt enable for AXI invalid access error
- 0: disabled
- 1: enabled";
            sw = rw; hw = r;
            reset = 0x0;
        } axi_bus_err_mask[0:0];
    } VICAP_DBG_INT_MASK @ 0xFF8;
    reg {
        name = "PT_INTF_MOD";
        desc = "PT_INTF_MOD is the interface mode register. (offset 0x1000; total reset 0x00000000; PROVEN: Hi3516E V300 data sheet (Issue 00B06, 2019-05-15), section 9.1.6, PDF page 442).";
        field {
            name = "pt_enable";
            desc = "Port enable
- 0: disabled
- 1: enabled";
            sw = rw; hw = r;
            reset = 0x0;
        } pt_enable[31:31];
        field {
            name = "reserved";
            desc = "Reserved";
            sw = rw; hw = r;
            reset = 0x0;
        } reserved_30_1[30:1];
        field {
            name = "pt_mode";
            desc = "Timing mode
- 0: external sync mode
- 1: internal sync";
            sw = rw; hw = r;
            reset = 0x0;
        } pt_mode[0:0];
    } PT_INTF_MOD @ 0x1000;
    reg {
        name = "PT_OFFSET0";
        desc = "PT_OFFSET0 is the component 0 offset register. (offset 0x1010; total reset 0xFFF00000; PROVEN: Hi3516E V300 data sheet (Issue 00B06, 2019-05-15), section 9.1.6, PDF page 443).";
        field {
            name = "offset0_mask";
            desc = "Component 0 mask";
            sw = rw; hw = r;
            reset = 0xfff0;
        } offset0_mask[31:16];
        field {
            name = "offset0_rev";
            desc = "Whether the data line is reversed
- 0: No.
- 1: Yes.";
            sw = rw; hw = r;
            reset = 0x0;
        } offset0_rev[15:15];
        field {
            name = "reserved";
            desc = "Reserved";
            sw = r; hw = w;
            reset = 0x0;
        } reserved_14_6[14:6];
        field {
            name = "offset0";
            desc = "Component 0 offset";
            sw = rw; hw = r;
            reset = 0x0;
        } offset0[5:0];
    } PT_OFFSET0 @ 0x1010;
    reg {
        name = "PT_OFFSET1";
        desc = "PT_OFFSET1 is the component 1 offset register. (offset 0x1014; total reset 0xFFF00010; PROVEN: Hi3516E V300 data sheet (Issue 00B06, 2019-05-15), section 9.1.6, PDF page 443).";
        field {
            name = "offset1_mask";
            desc = "Component 1 mask";
            sw = rw; hw = r;
            reset = 0xfff0;
        } offset1_mask[31:16];
        field {
            name = "offset1_rev";
            desc = "Whether the data line is reversed
- 0: No.
- 1: Yes.";
            sw = rw; hw = r;
            reset = 0x0;
        } offset1_rev[15:15];
        field {
            name = "reserved";
            desc = "Reserved";
            sw = r; hw = w;
            reset = 0x0;
        } reserved_14_6[14:6];
        field {
            name = "offset1";
            desc = "Component 1 offset";
            sw = rw; hw = r;
            reset = 0x10;
        } offset1[5:0];
    } PT_OFFSET1 @ 0x1014;
    reg {
        name = "PT_OFFSET2";
        desc = "PT_OFFSET2 is the component 2 offset register. (offset 0x1018; total reset 0xFFF00020; PROVEN: Hi3516E V300 data sheet (Issue 00B06, 2019-05-15), section 9.1.6, PDF page 443).";
        field {
            name = "offset2_mask";
            desc = "Component 2 mask";
            sw = rw; hw = r;
            reset = 0xfff0;
        } offset2_mask[31:16];
        field {
            name = "offset2_rev";
            desc = "Whether the data line is reversed
- 0: No.
- 1: Yes.";
            sw = rw; hw = r;
            reset = 0x0;
        } offset2_rev[15:15];
        field {
            name = "reserved";
            desc = "Reserved";
            sw = r; hw = w;
            reset = 0x0;
        } reserved_14_6[14:6];
        field {
            name = "offset2";
            desc = "Component 2 offset";
            sw = rw; hw = r;
            reset = 0x20;
        } offset2[5:0];
    } PT_OFFSET2 @ 0x1018;
    reg {
        name = "PT_BT656_CFG";
        desc = "PT_BT656_CFG is the BT.656 configuration register. (offset 0x1020; total reset 0x00000303; PROVEN: Hi3516E V300 data sheet (Issue 00B06, 2019-05-15), section 9.1.6, PDF page 444).";
        field {
            name = "bt656_enable";
            desc = "BT.656 enable
- 0: disabled
- 1: enabled";
            sw = rw; hw = r;
            reset = 0x0;
        } bt656_enable[31:31];
        field {
            name = "reserved";
            desc = "Reserved";
            sw = r; hw = w;
            reset = 0x0;
        } reserved_30_11[30:11];
        field {
            name = "bt656_field_inv";
            desc = "Field inversion control
- 0: not inverted
- 1: inverted";
            sw = rw; hw = r;
            reset = 0x0;
        } bt656_field_inv[10:10];
        field {
            name = "bt656_vsync_inv";
            desc = "Vsync inversion control
- 0: not inverted
- 1: inverted";
            sw = rw; hw = r;
            reset = 0x1;
        } bt656_vsync_inv[9:9];
        field {
            name = "bt656_hsync_inv";
            desc = "Hsync inversion control
- 0: not inverted
- 1: inverted";
            sw = rw; hw = r;
            reset = 0x1;
        } bt656_hsync_inv[8:8];
        field {
            name = "reserved";
            desc = "Reserved";
            sw = r; hw = w;
            reset = 0x0;
        } reserved_7_4[7:4];
        field {
            name = "bt656_mode";
            desc = "Mode select. bt656_mode[0]
- 0: Hsync is not an active signal.
- 1: Hsync is the active signal. bt656_mode[1]
- 0: The Hsync output is active low.
- 1: The Hsync output is active high. bt656_mode[3:2]
- 00: Component 0 is parsed.";
            sw = rw; hw = r;
            reset = 0x3;
        } bt656_mode[3:0];
    } PT_BT656_CFG @ 0x1020;
    reg {
        name = "PT_UNIFY_TIMING_CFG";
        desc = "PT_UNIFY_TIMING_CFG is the timing configuration register. (offset 0x1038; total reset 0x00000000; PROVEN: Hi3516E V300 data sheet (Issue 00B06, 2019-05-15), section 9.1.6, PDF page 445).";
        field {
            name = "reserved";
            desc = "Reserved";
            sw = r; hw = w;
            reset = 0x0;
        } reserved_31_27[31:27];
        field {
            name = "unify_field_inv";
            desc = "Field inversion (level-1 field processing).
- 0: not inverted
- 1: inverted";
            sw = rw; hw = r;
            reset = 0x0;
        } unify_field_inv[26:26];
        field {
            name = "unify_field_sel";
            desc = "Field source select (level-0 field processing).
- 00: input field
- 01: input Vsync
- 10: detected based on the relationship between

Vsync and Hsync
- 11: fixed at 0";
            sw = rw; hw = r;
            reset = 0x0;
        } unify_field_sel[25:24];
        field {
            name = "reserved";
            desc = "Reserved";
            sw = r; hw = w;
            reset = 0x0;
        } reserved_23_21[23:21];
        field {
            name = "unify_vsync_mode";
            desc = "Vsync processing mode (level-2 Vsync processing).
- 00: not processed
- 01: detect the rising edge
- 10: detect the rising edge and falling edge
- 11: reserved";
            sw = rw; hw = r;
            reset = 0x0;
        } unify_vsync_mode[20:19];
        field {
            name = "unify_vsync_inv";
            desc = "Vsync inversion (level-1 Vsync processing).
- 0: not inverted
- 1: inverted";
            sw = rw; hw = r;
            reset = 0x0;
        } unify_vsync_inv[18:18];
        field {
            name = "unify_vsync_sel";
            desc = "Vsync source select (level-0 Vsync processing).
- 00: input Vsync
- 01: input field
- 10: fixed at 0
- 11: reserved";
            sw = rw; hw = r;
            reset = 0x0;
        } unify_vsync_sel[17:16];
        field {
            name = "reserved";
            desc = "Reserved";
            sw = r; hw = w;
            reset = 0x0;
        } reserved_15_15[15:15];
        field {
            name = "unify_hsync_mode";
            desc = "Hsync processing mode (level-3 Hsync processing).
- 0: not processed
- 1: detect the rising edge";
            sw = rw; hw = r;
            reset = 0x0;
        } unify_hsync_mode[14:13];
        field {
            name = "unify_hsync_and";
            desc = "Whether Hsync is operated with the result of level-1 Vsync processing (level-2 Hsync processing).
- 00: not processed
- 01: ANDed
- 10: exclusive ORed
- 11: reserved";
            sw = rw; hw = r;
            reset = 0x0;
        } unify_hsync_and[12:11];
        field {
            name = "unify_hsync_inv";
            desc = "Hsync inversion (level-1 Hsync processing).
- 0: not inverted
- 1: inverted";
            sw = rw; hw = r;
            reset = 0x0;
        } unify_hsync_inv[10:10];
        field {
            name = "unify_hsync_sel";
            desc = "Hsync source select (level-0 Hsync processing).
- 00: input Hsync
- 01: input DE
- 10: fixed at 0
- 11: reserved";
            sw = rw; hw = r;
            reset = 0x0;
        } unify_hsync_sel[9:8];
        field {
            name = "reserved";
            desc = "Reserved";
            sw = r; hw = w;
            reset = 0x0;
        } reserved_7_3[7:3];
        field {
            name = "unify_de_inv";
            desc = "de inversion (level-1 de processing).
- 0: not inverted
- 1: inverted";
            sw = rw; hw = r;
            reset = 0x0;
        } unify_de_inv[2:2];
        field {
            name = "unify_de_sel";
            desc = "de source select (level-0 de processing).
- 00: input DE
- 01: result of level-2 Hsync processing
- 10: fixed at 1
- 11: fixed at 0";
            sw = rw; hw = r;
            reset = 0x0;
        } unify_de_sel[1:0];
    } PT_UNIFY_TIMING_CFG @ 0x1038;
    reg {
        name = "PT_GEN_TIMING_CFG";
        desc = "PT_GEN_TIMING_CFG is the timing recovery module configuration register. (offset 0x103C; total reset 0x40000006; PROVEN: Hi3516E V300 data sheet (Issue 00B06, 2019-05-15), section 9.1.6, PDF page 446).";
        field {
            name = "gen_enable";
            desc = "Timing recovery enable (timings are recovered based on timing parameters).";
            sw = rw; hw = r;
            reset = 0x0;
        } gen_enable[31:31];
        field {
            name = "gen_mode";
            desc = "Timing recovery mode (timings are recovered based on timing parameters).
- 0: Timings are generated based on the input valid signal of PT.
- 1: Timings are automatically calculated and generated internally.";
            sw = rw; hw = r;
            reset = 0x1;
        } gen_mode[30:30];
        field {
            name = "reserved";
            desc = "Reserved";
            sw = r; hw = w;
            reset = 0x0;
        } reserved_29_3[29:3];
        field {
            name = "gen_vsync_mode";
            desc = "Vsync recovery.
- 0: not recovered
- 1: recovered";
            sw = rw; hw = r;
            reset = 0x1;
        } gen_vsync_mode[2:2];
        field {
            name = "gen_hsync_mode";
            desc = "Hsync recovery.
- 0: not recovered
- 1: recovered";
            sw = rw; hw = r;
            reset = 0x1;
        } gen_hsync_mode[1:1];
        field {
            name = "reserved";
            desc = "Reserved";
            sw = r; hw = w;
            reset = 0x0;
        } reserved_0_0[0:0];
    } PT_GEN_TIMING_CFG @ 0x103C;
    reg {
        name = "PT_UNIFY_DATA_CFG";
        desc = "PT_UNIFY_DATA_CFG is the data configuration register. (offset 0x1040; total reset 0x00000000; PROVEN: Hi3516E V300 data sheet (Issue 00B06, 2019-05-15), section 9.1.6, PDF page 447).";
        field {
            name = "unify_data_enable";
            desc = "Data separation enable
- 0: disabled
- 1: enabled";
            sw = rw; hw = r;
            reset = 0x0;
        } unify_data_enable[31:31];
        field {
            name = "reserved";
            desc = "Reserved";
            sw = r; hw = w;
            reset = 0x0;
        } reserved_30_4[30:4];
        field {
            name = "unify_data_uv_seq";
            desc = "CbCr sequence
- 0: CbCr
- 1: CrCb";
            sw = rw; hw = r;
            reset = 0x0;
        } unify_data_uv_seq[3:3];
        field {
            name = "unify_data_yc_seq";
            desc = "YC sequence
- 0: CY
- 1: YC";
            sw = rw; hw = r;
            reset = 0x0;
        } unify_data_yc_seq[2:2];
        field {
            name = "Data00:unify_data_comp_nu01:m10:11:";
            desc = "component select component 1 component 2 component 3 reserved";
            sw = rw; hw = r;
            reset = 0x0;
        } Data00_unify_data_comp_nu01_m10_11[1:0];
    } PT_UNIFY_DATA_CFG @ 0x1040;
    reg {
        name = "PT_GEN_DATA_CFG";
        desc = "PT_GEN_DATA_CFG is the data generation module configuration register. (offset 0x1044; total reset 0x000000E9; PROVEN: Hi3516E V300 data sheet (Issue 00B06, 2019-05-15), section 9.1.6, PDF page 448).";
        field {
            name = "gen_data_enable";
            desc = "Data generation enable Data is generated based on the data generation parameter.
- 0: disabled
- 1: enabled";
            sw = rw; hw = r;
            reset = 0x0;
        } gen_data_enable[31:31];
        field {
            name = "reserved";
            desc = "Reserved";
            sw = r; hw = w;
            reset = 0x0;
        } reserved_30_8[30:8];
        field {
            name = "gen_data0_move";
            desc = "Whether data 0 increases progressively
- 0: No.
- 1: Yes.";
            sw = rw; hw = r;
            reset = 0x1;
        } gen_data0_move[7:7];
        field {
            name = "gen_data1_move";
            desc = "Whether data 1 increases progressively
- 0: No.
- 1: Yes.";
            sw = rw; hw = r;
            reset = 0x1;
        } gen_data1_move[6:6];
        field {
            name = "gen_data2_move";
            desc = "Whether data 2 increases progressively
- 0: No.
- 1: Yes.";
            sw = rw; hw = r;
            reset = 0x1;
        } gen_data2_move[5:5];
        field {
            name = "gen_data_vsync_reset";
            desc = "Whether to reset data based on the Vsync signal
- 0: No.
- 1: Yes.";
            sw = rw; hw = r;
            reset = 0x0;
        } gen_data_vsync_reset[4:4];
        field {
            name = "gen_data_hsync_reset";
            desc = "Whether to reset data based on the Hsync signal
- 0: No.
- 1: Yes.";
            sw = rw; hw = r;
            reset = 0x1;
        } gen_data_hsync_reset[3:3];
        field {
            name = "gen_data_vsync_move";
            desc = "Whether data is incremented progressively based on the Vsync signal
- 0: No.
- 1: Yes.";
            sw = rw; hw = r;
            reset = 0x0;
        } gen_data_vsync_move[2:2];
        field {
            name = "gen_data_hsync_move";
            desc = "Whether data is incremented progressively based on the Hsync signal
- 0: No.
- 1: Yes.";
            sw = rw; hw = r;
            reset = 0x0;
        } gen_data_hsync_move[1:1];
        field {
            name = "gen_data_de_move";
            desc = "Whether data is incremented progressively based on the de signal
- 0: No.
- 1: Yes.";
            sw = rw; hw = r;
            reset = 0x1;
        } gen_data_de_move[0:0];
    } PT_GEN_DATA_CFG @ 0x1044;
    reg {
        name = "PT_GEN_DATA_COEF";
        desc = "PT_GEN_DATA_COEF is the data generation module coefficient register. (offset 0x1048; total reset 0x01000100; PROVEN: Hi3516E V300 data sheet (Issue 00B06, 2019-05-15), section 9.1.6, PDF page 449).";
        field {
            name = "inc_frame";
            desc = "Incremental value between data frames The incremental values are accumulated in the upper 8 bits of data.";
            sw = rw; hw = r;
            reset = 0x1;
        } inc_frame[31:24];
        field {
            name = "step_frame";
            desc = "Interval for data frame increment The configured value is the actual value minus 1. The value 0 indicates the increment by frame.";
            sw = rw; hw = r;
            reset = 0x0;
        } step_frame[23:16];
        field {
            name = "inc_space";
            desc = "Incremental value between data pixels The incremental values are accumulated in the upper 10 bits of data.";
            sw = rw; hw = r;
            reset = 0x1;
        } inc_space[15:8];
        field {
            name = "step_space";
            desc = "Interval for data pixel increment The value 0 indicates the increment by pixel.";
            sw = rw; hw = r;
            reset = 0x0;
        } step_space[7:0];
    } PT_GEN_DATA_COEF @ 0x1048;
    reg {
        name = "PT_GEN_DATA_INIT";
        desc = "PT_GEN_DATA_INIT is the data generation initial value configuration register. (offset 0x104C; total reset 0x00000000; PROVEN: Hi3516E V300 data sheet (Issue 00B06, 2019-05-15), section 9.1.6, PDF page 449).";
        field {
            name = "reserved";
            desc = "Reserved";
            sw = r; hw = w;
            reset = 0x0;
        } reserved_31_24[31:24];
        field {
            name = "data2";
            desc = "Initial V/B value";
            sw = rw; hw = r;
            reset = 0x0;
        } data2[23:16];
        field {
            name = "data1";
            desc = "Initial U/G value";
            sw = rw; hw = r;
            reset = 0x0;
        } data1[15:8];
        field {
            name = "data0";
            desc = "Initial Y/R value";
            sw = rw; hw = r;
            reset = 0x0;
        } data0[7:0];
    } PT_GEN_DATA_INIT @ 0x104C;
    reg {
        name = "PT_YUV444_CFG";
        desc = "PT_YUV444_CFG is the YUV444 configuration register. (offset 0x1050; total reset 0x00000000; PROVEN: Hi3516E V300 data sheet (Issue 00B06, 2019-05-15), section 9.1.6, PDF page 450).";
        field {
            name = "yuv44_enable";
            desc = "YUV enable for converting YUV422 signals into YUV444 signals.
- 0: disabled
- 1: enabled";
            sw = rw; hw = r;
            reset = 0x0;
        } yuv44_enable[31:31];
        field {
            name = "reserved";
            desc = "Reserved";
            sw = r; hw = w;
            reset = 0x0;
        } reserved_30_0[30:0];
    } PT_YUV444_CFG @ 0x1050;
    reg {
        name = "PT_FSTART_DLY";
        desc = "PT_FSTART_DLY is the port fstart interrupt delay register. (offset 0x1060; total reset 0x00000000; PROVEN: Hi3516E V300 data sheet (Issue 00B06, 2019-05-15), section 9.1.6, PDF page 450).";
        field {
            name = "pt_fstart_dly";
            desc = "fstart interrupt delay time, in the unit of the port clock";
            sw = rw; hw = r;
            reset = 0x0;
        } pt_fstart_dly[31:0];
    } PT_FSTART_DLY @ 0x1060;
    reg {
        name = "PT_FSTART_H_DLY";
        desc = "PT_FSTART_H_DLY is the port fstart interrupt horizontal delay register. (offset 0x1064; total reset 0x00000000; PROVEN: Hi3516E V300 data sheet (Issue 00B06, 2019-05-15), section 9.1.6, PDF page 450).";
        field {
            name = "fstart_h_dly";
            desc = "fstart interrupt line delay time, in the unit of line number of the active area.";
            sw = rw; hw = r;
            reset = 0x0;
        } fstart_h_dly[31:16];
        field {
            name = "reserved";
            desc = "Reserved";
            sw = rw; hw = r;
            reset = 0x0;
        } reserved_15_4[15:4];
        field {
            name = "fstart_h_dly_id";
            desc = "Count frame ID. Bit[0]: Counting is triggered by the timing whose ID is 0. Bit[1]: Counting is triggered by the timing whose ID is 1. Bit[2]: Counting is triggered by the timing whose ID is 2. Bit[3]: Counting is triggered by the timing whose ID is 3.";
            sw = rw; hw = r;
            reset = 0x0;
        } fstart_h_dly_id[3:0];
    } PT_FSTART_H_DLY @ 0x1064;
    reg {
        name = "PT_INTF_HFB";
        desc = "PT_INTF_HFB is the horizontal front blanking width register. (offset 0x1080; total reset 0x00000058; PROVEN: Hi3516E V300 data sheet (Issue 00B06, 2019-05-15), section 9.1.6, PDF page 451).";
        field {
            name = "reserved";
            desc = "Reserved";
            sw = r; hw = w;
            reset = 0x0;
        } reserved_31_16[31:16];
        field {
            name = "hfb";
            desc = "Width of the horizontal front blanking interval (unit: working clock cycle)";
            sw = rw; hw = r;
            reset = 0x58;
        } hfb[15:0];
    } PT_INTF_HFB @ 0x1080;
    reg {
        name = "PT_INTF_HACT";
        desc = "PT_INTF_HACT is the horizontal active area width register. (offset 0x1084; total reset 0x00000780; PROVEN: Hi3516E V300 data sheet (Issue 00B06, 2019-05-15), section 9.1.6, PDF page 451).";
        field {
            name = "hact";
            desc = "Width of the horizontal active area (unit: working clock cycle)";
            sw = rw; hw = r;
            reset = 0x780;
        } hact[31:0];
    } PT_INTF_HACT @ 0x1084;
    reg {
        name = "PT_INTF_HBB";
        desc = "PT_INTF_HBB is the horizontal back blanking width register. (offset 0x1088; total reset 0x000000C0; PROVEN: Hi3516E V300 data sheet (Issue 00B06, 2019-05-15), section 9.1.6, PDF page 451).";
        field {
            name = "reserved";
            desc = "Reserved";
            sw = r; hw = w;
            reset = 0x0;
        } reserved_31_16[31:16];
        field {
            name = "hbb";
            desc = "Width of the horizontal back blanking interval (unit: working clock cycle)";
            sw = rw; hw = r;
            reset = 0xc0;
        } hbb[15:0];
    } PT_INTF_HBB @ 0x1088;
    reg {
        name = "PT_INTF_VFB";
        desc = "PT_INTF_VFB is the vertical front blanking width register. (offset 0x108C; total reset 0x00000004; PROVEN: Hi3516E V300 data sheet (Issue 00B06, 2019-05-15), section 9.1.6, PDF page 452).";
        field {
            name = "reserved";
            desc = "Reserved";
            sw = r; hw = w;
            reset = 0x0;
        } reserved_31_16[31:16];
        field {
            name = "vfb";
            desc = "Width of the vertical front blanking interval (unit: working clock cycle)";
            sw = rw; hw = r;
            reset = 0x4;
        } vfb[15:0];
    } PT_INTF_VFB @ 0x108C;
    reg {
        name = "PT_INTF_VACT";
        desc = "PT_INTF_VACT is the vertical active area width register. (offset 0x1090; total reset 0x00000438; PROVEN: Hi3516E V300 data sheet (Issue 00B06, 2019-05-15), section 9.1.6, PDF page 452).";
        field {
            name = "reserved";
            desc = "Reserved";
            sw = r; hw = w;
            reset = 0x0;
        } reserved_31_16[31:16];
        field {
            name = "vact";
            desc = "Width of the vertical active area (unit: working clock cycle)";
            sw = rw; hw = r;
            reset = 0x438;
        } vact[15:0];
    } PT_INTF_VACT @ 0x1090;
    reg {
        name = "PT_INTF_VBB";
        desc = "PT_INTF_VBB is the vertical back blanking width register. (offset 0x1094; total reset 0x00000029; PROVEN: Hi3516E V300 data sheet (Issue 00B06, 2019-05-15), section 9.1.6, PDF page 452).";
        field {
            name = "reserved";
            desc = "Reserved";
            sw = r; hw = w;
            reset = 0x0;
        } reserved_31_16[31:16];
        field {
            name = "vbb";
            desc = "Width of the vertical back blanking interval (unit: working clock cycle)";
            sw = rw; hw = r;
            reset = 0x29;
        } vbb[15:0];
    } PT_INTF_VBB @ 0x1094;
    reg {
        name = "PT_INTF_VBFB";
        desc = "PT_INTF_VBFB is the vertical bottom front blanking width register. (offset 0x1098; total reset 0x00000004; PROVEN: Hi3516E V300 data sheet (Issue 00B06, 2019-05-15), section 9.1.6, PDF page 452).";
        field {
            name = "reserved";
            desc = "Reserved";
            sw = r; hw = w;
            reset = 0x0;
        } reserved_31_16[31:16];
        field {
            name = "vbfb";
            desc = "Width of the vertical bottom front blanking interval (unit: working clock cycle)";
            sw = rw; hw = r;
            reset = 0x4;
        } vbfb[15:0];
    } PT_INTF_VBFB @ 0x1098;
    reg {
        name = "PT_INTF_VBACT";
        desc = "PT_INTF_VBACT is the vertical bottom active area width register. (offset 0x109C; total reset 0x00000438; PROVEN: Hi3516E V300 data sheet (Issue 00B06, 2019-05-15), section 9.1.6, PDF page 453).";
        field {
            name = "reserved";
            desc = "Reserved";
            sw = r; hw = w;
            reset = 0x0;
        } reserved_31_16[31:16];
        field {
            name = "vbact";
            desc = "Width of the vertical bottom active area (unit: working clock cycle)";
            sw = rw; hw = r;
            reset = 0x438;
        } vbact[15:0];
    } PT_INTF_VBACT @ 0x109C;
    reg {
        name = "PT_INTF_VBBB";
        desc = "PT_INTF_VBBB is the vertical bottom back blanking width register. (offset 0x10A0; total reset 0x00000029; PROVEN: Hi3516E V300 data sheet (Issue 00B06, 2019-05-15), section 9.1.6, PDF page 453).";
        field {
            name = "reserved";
            desc = "Reserved";
            sw = r; hw = w;
            reset = 0x0;
        } reserved_31_16[31:16];
        field {
            name = "vbbb";
            desc = "Width of the vertical bottom back blanking interval (unit: working clock cycle)";
            sw = rw; hw = r;
            reset = 0x29;
        } vbbb[15:0];
    } PT_INTF_VBBB @ 0x10A0;
    reg {
        name = "PT_ID_CFG";
        desc = "PT_ID_CFG is the ID configuration register. (offset 0x10A4; total reset 0x00000000; PROVEN: Hi3516E V300 data sheet (Issue 00B06, 2019-05-15), section 9.1.6, PDF page 453).";
        field {
            name = "id_enable";
            desc = "ID generation enable
- 0: disabled
- 1: enabled";
            sw = rw; hw = r;
            reset = 0x0;
        } id_enable[31:31];
        field {
            name = "id_mode";
            desc = "ID generation mode
- 0: automatic mode (the ID automatically increases for each frame)
- 1: non-automatic mode (the ID depends on the configured value)";
            sw = rw; hw = r;
            reset = 0x0;
        } id_mode[30:30];
        field {
            name = "id_reset";
            desc = "In automatic mode, setting this field to 1 restores the ID of the next frame to the initial value. This field is automatically cleared after restoration.";
            sw = w; hw = r;
            reset = 0x0;
        } id_reset[29:29];
        field {
            name = "reserved";
            desc = "Reserved";
            sw = r; hw = w;
            reset = 0x0;
        } reserved_28_4[28:4];
        field {
            name = "id_max";
            desc = "Maximum ID in automatic mode";
            sw = rw; hw = r;
            reset = 0x0;
        } id_max[3:2];
        field {
            name = "id";
            desc = "Initial ID in automatic mode or generated ID in non-automatic mode";
            sw = rw; hw = r;
            reset = 0x0;
        } id[1:0];
    } PT_ID_CFG @ 0x10A4;
    reg {
        name = "PT_FLASH_CFG";
        desc = "PT_FLASH_CFG is the flash configuration register. (offset 0x10C0; total reset 0x10000000; PROVEN: Hi3516E V300 data sheet (Issue 00B06, 2019-05-15), section 9.1.6, PDF page 454).";
        field {
            name = "id_sel";
            desc = "Trigger frame ID.
- 0x1: triggered by using the start of frame (SOF) interrupt whose ID is 0
- 0x2: triggered by using the SOF interrupt whose ID is 1
- 0x4: triggered by using the SOF interrupt whose ID is 2
- 0x8: triggered by using the SOF interrupt whose ID is 3

Other values: reserved";
            sw = rw; hw = r;
            reset = 0x1;
        } id_sel[31:28];
        field {
            name = "reserved";
            desc = "Reserved";
            sw = r; hw = w;
            reset = 0x0;
        } reserved_27_19[27:19];
        field {
            name = "shutter_times";
            desc = "Shutter pulse times.
- 0: twice
- 1: once";
            sw = rw; hw = r;
            reset = 0x0;
        } shutter_times[18:18];
        field {
            name = "shutter_phase";
            desc = "Shutter signal reverse.
- 0: not inverted
- 1: inverted";
            sw = rw; hw = r;
            reset = 0x0;
        } shutter_phase[17:17];
        field {
            name = "shutter_en";
            desc = "Shutter trigger enable This field is automatically cleared.
- 0: disabled
- 1: enabled";
            sw = w; hw = r;
            reset = 0x0;
        } shutter_en[16:16];
        field {
            name = "reserved";
            desc = "Reserved";
            sw = r; hw = w;
            reset = 0x0;
        } reserved_15_2[15:2];
        field {
            name = "flash_phase";
            desc = "Flash signal reverse.
- 0: not inverted
- 1: inverted";
            sw = rw; hw = r;
            reset = 0x0;
        } flash_phase[1:1];
        field {
            name = "flash_en";
            desc = "Flash trigger enable This field is automatically cleared.
- 0: disabled";
            sw = w; hw = r;
            reset = 0x0;
        } flash_en[0:0];
    } PT_FLASH_CFG @ 0x10C0;
    reg {
        name = "PT_FLASH_CYC0";
        desc = "PT_FLASH_CYC0 is the flash timing 0 width register. (offset 0x10C4; total reset 0x00000000; PROVEN: Hi3516E V300 data sheet (Issue 00B06, 2019-05-15), section 9.1.6, PDF page 455).";
        field {
            name = "pt_flash_cyc0";
            desc = "Flash timing 0 duration (unit: port clock) The configured value is the actual value minus 1.";
            sw = rw; hw = r;
            reset = 0x0;
        } pt_flash_cyc0[31:0];
    } PT_FLASH_CYC0 @ 0x10C4;
    reg {
        name = "PT_FLASH_CYC1";
        desc = "PT_FLASH_CYC1 is the flash timing 1 width register. (offset 0x10C8; total reset 0x00000000; PROVEN: Hi3516E V300 data sheet (Issue 00B06, 2019-05-15), section 9.1.6, PDF page 455).";
        field {
            name = "pt_flash_cyc1";
            desc = "Flash timing 1 duration (unit: port clock) The configured value is the actual value minus 1.";
            sw = rw; hw = r;
            reset = 0x0;
        } pt_flash_cyc1[31:0];
    } PT_FLASH_CYC1 @ 0x10C8;
    reg {
        name = "PT_SHUTTER_CYC0";
        desc = "PT_SHUTTER_CYC0 is the shutter timing 0 width register. (offset 0x10D0; total reset 0x00000000; PROVEN: Hi3516E V300 data sheet (Issue 00B06, 2019-05-15), section 9.1.6, PDF page 455).";
        field {
            name = "pt_shutter_cyc0";
            desc = "Shutter timing 0 duration (unit: port clock) The configured value is the actual value minus 1.";
            sw = rw; hw = r;
            reset = 0x0;
        } pt_shutter_cyc0[31:0];
    } PT_SHUTTER_CYC0 @ 0x10D0;
    reg {
        name = "PT_SHUTTER_CYC1";
        desc = "PT_SHUTTER_CYC1 is the shutter timing 1 width register. (offset 0x10D4; total reset 0x00000000; PROVEN: Hi3516E V300 data sheet (Issue 00B06, 2019-05-15), section 9.1.6, PDF page 455).";
        field {
            name = "pt_shutter_cyc1";
            desc = "Shutter timing 1 duration (unit: port clock) The configured value is the actual value minus 1.";
            sw = rw; hw = r;
            reset = 0x0;
        } pt_shutter_cyc1[31:0];
    } PT_SHUTTER_CYC1 @ 0x10D4;
    reg {
        name = "PT_SHUTTER_CYC2";
        desc = "PT_SHUTTER_CYC2 is the shutter timing 2 width register. (offset 0x10D8; total reset 0x00000000; PROVEN: Hi3516E V300 data sheet (Issue 00B06, 2019-05-15), section 9.1.6, PDF page 456).";
        field {
            name = "pt_shutter_cyc2";
            desc = "Shutter timing 2 duration (unit: port clock) The configured value is the actual value minus 1.";
            sw = rw; hw = r;
            reset = 0x0;
        } pt_shutter_cyc2[31:0];
    } PT_SHUTTER_CYC2 @ 0x10D8;
    reg {
        name = "PT_SHUTTER_CYC3";
        desc = "PT_SHUTTER_CYC3 is the shutter timing 3 width register. (offset 0x10DC; total reset 0x00000000; PROVEN: Hi3516E V300 data sheet (Issue 00B06, 2019-05-15), section 9.1.6, PDF page 456).";
        field {
            name = "pt_shutter_cyc3";
            desc = "Shutter timing 3 duration (unit: port clock) The configured value is the actual value minus 1.";
            sw = rw; hw = r;
            reset = 0x0;
        } pt_shutter_cyc3[31:0];
    } PT_SHUTTER_CYC3 @ 0x10DC;
    reg {
        name = "PT_STATUS";
        desc = "PT_STATUS is the port status register. (offset 0x10E0; total reset 0x00000000; PROVEN: Hi3516E V300 data sheet (Issue 00B06, 2019-05-15), section 9.1.6, PDF page 456).";
        field {
            name = "reserved";
            desc = "Reserved";
            sw = r; hw = w;
            reset = 0x0;
        } reserved_31_6[31:6];
        field {
            name = "pt_status_id";
            desc = "Port output ID";
            sw = r; hw = w;
            reset = 0x0;
        } pt_status_id[5:4];
        field {
            name = "pt_status_field";
            desc = "Field output over the port";
            sw = r; hw = w;
            reset = 0x0;
        } pt_status_field[3:3];
        field {
            name = "pt_status_vsync";
            desc = "Vsync signal over the port";
            sw = r; hw = w;
            reset = 0x0;
        } pt_status_vsync[2:2];
        field {
            name = "pt_status_hsync";
            desc = "Hsync signal over the port";
            sw = r; hw = w;
            reset = 0x0;
        } pt_status_hsync[1:1];
        field {
            name = "pt_status_de";
            desc = "de signal output over the port";
            sw = r; hw = w;
            reset = 0x0;
        } pt_status_de[0:0];
    } PT_STATUS @ 0x10E0;
    reg {
        name = "PT_BT656_STATUS";
        desc = "PT_BT656_STATUS is the BT.656 status register. (offset 0x10E4; total reset 0x00000000; PROVEN: Hi3516E V300 data sheet (Issue 00B06, 2019-05-15), section 9.1.6, PDF page 457).";
        field {
            name = "reserved";
            desc = "Reserved";
            sw = r; hw = w;
            reset = 0x0;
        } reserved_31_16[31:16];
        field {
            name = "pt_bt656_seav";
            desc = "Sync code";
            sw = r; hw = w;
            reset = 0x0;
        } pt_bt656_seav[15:8];
        field {
            name = "reserved";
            desc = "Reserved";
            sw = r; hw = w;
            reset = 0x0;
        } reserved_7_0[7:0];
    } PT_BT656_STATUS @ 0x10E4;
    reg {
        name = "PT_SIZE";
        desc = "PT_SIZE is the input image active area size indicator register (offset 0x10EC; total reset 0x00000000; PROVEN: Hi3516E V300 data sheet (Issue 00B06, 2019-05-15), section 9.1.6, PDF page 457).";
        field {
            name = "pt_height";
            desc = "Height of the active area of the image";
            sw = r; hw = w;
            reset = 0x0;
        } pt_height[31:16];
        field {
            name = "pt_width";
            desc = "Width of the active area of the image";
            sw = r; hw = w;
            reset = 0x0;
        } pt_width[15:0];
    } PT_SIZE @ 0x10EC;
    reg {
        name = "PT_INT";
        desc = "PT_INT is the port interrupt indicator register. (offset 0x10F0; total reset 0x00000000; PROVEN: Hi3516E V300 data sheet (Issue 00B06, 2019-05-15), section 9.1.6, PDF page 457).";
        field {
            name = "reserved";
            desc = "Reserved";
            sw = r; hw = w;
            reset = 0x0;
        } reserved_31_4[31:4];
        field {
            name = "pt_fstart_h_dly";
            desc = "Interrupt status of the field/frame start line delay Writing 1 clears this bit.
- 0: No interrupt is generated.
- 1: An interrupt is generated.

Access type WC in the data sheet: written 1 clears the bit.";
            sw = rw; hw = w; onwrite = woclr;
            reset = 0x0;
        } pt_fstart_h_dly[3:3];
        field {
            name = "pt_height_err";
            desc = "Interrupt status of the image height change Writing 1 clears this bit.
- 0: No interrupt is generated.
- 1: An interrupt is generated.

Access type WC in the data sheet: written 1 clears the bit.";
            sw = rw; hw = w; onwrite = woclr;
            reset = 0x0;
        } pt_height_err[2:2];
        field {
            name = "pt_width_err";
            desc = "Interrupt status of the image width change Writing 1 clears this bit.
- 0: No interrupt is generated.
- 1: An interrupt is generated.

Access type WC in the data sheet: written 1 clears the bit.";
            sw = rw; hw = w; onwrite = woclr;
            reset = 0x0;
        } pt_width_err[1:1];
        field {
            name = "pt_fstart";
            desc = "Interrupt status of the field/frame start Writing 1 clears this bit.
- 0: No interrupt is generated.
- 1: An interrupt is generated.

Access type WC in the data sheet: written 1 clears the bit.";
            sw = rw; hw = w; onwrite = woclr;
            reset = 0x0;
        } pt_fstart[0:0];
    } PT_INT @ 0x10F0;
    reg {
        name = "PT_INT_MASK";
        desc = "PT_INT_MASK is the port interrupt mask register. (offset 0x10F8; total reset 0x00000000; PROVEN: Hi3516E V300 data sheet (Issue 00B06, 2019-05-15), section 9.1.6, PDF page 458).";
        field {
            name = "reserved";
            desc = "Reserved";
            sw = r; hw = w;
            reset = 0x0;
        } reserved_31_4[31:4];
        field {
            name = "pt_mask_fstart_h_dly";
            desc = "Frame/Field start line delay interrupt enable
- 0: The interrupt is masked.
- 1: The interrupt is enabled.";
            sw = rw; hw = r;
            reset = 0x0;
        } pt_mask_fstart_h_dly[3:3];
        field {
            name = "pt_mask_height_err";
            desc = "Image height change interrupt enable
- 0: The interrupt is masked.
- 1: The interrupt is enabled.";
            sw = rw; hw = r;
            reset = 0x0;
        } pt_mask_height_err[2:2];
        field {
            name = "pt_mask_width_err";
            desc = "Image width change interrupt enable
- 0: The interrupt is masked.
- 1: The interrupt is enabled.";
            sw = rw; hw = r;
            reset = 0x0;
        } pt_mask_width_err[1:1];
        field {
            name = "pt_mask_fstart";
            desc = "Frame/Field start interrupt enable
- 0: The interrupt is masked.
- 1: The interrupt is enabled.";
            sw = rw; hw = r;
            reset = 0x0;
        } pt_mask_fstart[0:0];
    } PT_INT_MASK @ 0x10F8;
    reg CH_CTRL_t {
        name = "CH_CTRL";
        desc = "CH_CTRL is the channel control register. (offset 0x10000, 2 instances at stride 0x1000; total reset 0x00020000; PROVEN: Hi3516E V300 data sheet (Issue 00B06, 2019-05-15), section 9.1.6, PDF page 458).";
        field {
            name = "ch_enable";
            desc = "Channel enable
- 0: disabled
- 1: enabled";
            sw = rw; hw = r;
            reset = 0x0;
        } ch_enable[31:31];
        field {
            name = "ch_reg_newer_mode";
            desc = "Enable mode control
- 0: output when the reg_new register is valid and the module is enabled
- 1: output when the module is enabled";
            sw = rw; hw = r;
            reset = 0x0;
        } ch_reg_newer_mode[30:30];
        field {
            name = "reserved";
            desc = "Reserved";
            sw = r; hw = w;
            reset = 0x0;
        } reserved_29_18[29:18];
        field {
            name = "ch_finish_mode";
            desc = "Finish interrupt report time control
- 0: reported immediately
- 1: reported at the start of the next frame";
            sw = rw; hw = r;
            reset = 0x1;
        } ch_finish_mode[17:17];
        field {
            name = "reserved";
            desc = "Reserved";
            sw = r; hw = w;
            reset = 0x0;
        } reserved_16_0[16:0];
    };
    CH_CTRL_t CH_CTRL_0 @ 0x10000;
    CH_CTRL_t CH_CTRL_1 @ 0x11000;
    reg CH_REG_NEWER_t {
        name = "CH_REG_NEWER";
        desc = "CH_REG_NEWER is the channel update register. (offset 0x10004, 2 instances at stride 0x1000; total reset 0x00000000; PROVEN: Hi3516E V300 data sheet (Issue 00B06, 2019-05-15), section 9.1.6, PDF page 459).";
        field {
            name = "reserved";
            desc = "Reserved";
            sw = r; hw = w;
            reset = 0x0;
        } reserved_31_1[31:1];
        field {
            name = "ch_reg_newer";
            desc = "Channel update register This bit is automatically cleared for each frame.";
            sw = rw; hw = r;
            reset = 0x0;
        } ch_reg_newer[0:0];
    };
    CH_REG_NEWER_t CH_REG_NEWER_0 @ 0x10004;
    CH_REG_NEWER_t CH_REG_NEWER_1 @ 0x11004;
    reg CH_DLY_CFG_t {
        name = "CH_DLY_CFG";
        desc = "CH_DLY_CFG is the channel input image start interrupt delay configuration register. (offset 0x10034, 2 instances at stride 0x1000; total reset 0x00100000; PROVEN: Hi3516E V300 data sheet (Issue 00B06, 2019-05-15), section 9.1.6, PDF page 459).";
        field {
            name = "ch_v_dly_cfg";
            desc = "Vertical row delay";
            sw = rw; hw = r;
            reset = 0x10;
        } ch_v_dly_cfg[31:16];
        field {
            name = "reserved";
            desc = "Reserved";
            sw = r; hw = w;
            reset = 0x0;
        } reserved_15_0[15:0];
    };
    CH_DLY_CFG_t CH_DLY_CFG_0 @ 0x10034;
    CH_DLY_CFG_t CH_DLY_CFG_1 @ 0x11034;
    reg CH_CROP_CFG_t {
        name = "CH_CROP_CFG";
        desc = "CH_CROP_CFG is the channel crop enable register. (offset 0x10040, 2 instances at stride 0x1000; total reset 0x00000000; PROVEN: Hi3516E V300 data sheet (Issue 00B06, 2019-05-15), section 9.1.6, PDF page 459).";
        field {
            name = "reserved";
            desc = "Reserved";
            sw = r; hw = w;
            reset = 0x0;
        } reserved_31_1[31:1];
        field {
            name = "ch_crop_n0_en";
            desc = "Region 0 enable
- 0: disabled
- 1: enabled";
            sw = rw; hw = r;
            reset = 0x0;
        } ch_crop_n0_en[0:0];
    };
    CH_CROP_CFG_t CH_CROP_CFG_0 @ 0x10040;
    CH_CROP_CFG_t CH_CROP_CFG_1 @ 0x11040;
    reg CH_CROP0_START_t {
        name = "CH_CROP0_START";
        desc = "CH_CROP0_START is the channel region 0 crop start position register. (offset 0x10044, 2 instances at stride 0x1000; total reset 0x00000000; PROVEN: Hi3516E V300 data sheet (Issue 00B06, 2019-05-15), section 9.1.6, PDF page 460).";
        field {
            name = "ch_crop_y_start";
            desc = "Start row for obtaining the image";
            sw = rw; hw = r;
            reset = 0x0;
        } ch_crop_y_start[31:16];
        field {
            name = "ch_crop_x_start";
            desc = "Start pixel for obtaining the image";
            sw = rw; hw = r;
            reset = 0x0;
        } ch_crop_x_start[15:0];
    };
    CH_CROP0_START_t CH_CROP0_START_0 @ 0x10044;
    CH_CROP0_START_t CH_CROP0_START_1 @ 0x11044;
    reg CH_CROP0_SIZE_t {
        name = "CH_CROP0_SIZE";
        desc = "CH_CROP0_SIZE is the region 0 crop size configuration register. (offset 0x10048, 2 instances at stride 0x1000; total reset 0x00000000; PROVEN: Hi3516E V300 data sheet (Issue 00B06, 2019-05-15), section 9.1.6, PDF page 460).";
        field {
            name = "ch_crop_height";
            desc = "Height of the obtained image (unit: row) The configured value is the actual value minus 1.";
            sw = rw; hw = r;
            reset = 0x0;
        } ch_crop_height[31:16];
        field {
            name = "ch_crop_width";
            desc = "Width of the obtained image (unit: pixel) The configured value is the actual value minus 1.";
            sw = rw; hw = r;
            reset = 0x0;
        } ch_crop_width[15:0];
    };
    CH_CROP0_SIZE_t CH_CROP0_SIZE_0 @ 0x10048;
    CH_CROP0_SIZE_t CH_CROP0_SIZE_1 @ 0x11048;
    reg CH_SKIP_Y_CFG_t {
        name = "CH_SKIP_Y_CFG";
        desc = "CH_SKIP_Y_CFG is the channel Y component skip configuration register. (offset 0x10050, 2 instances at stride 0x1000; total reset 0xFFFFFFFF; PROVEN: Hi3516E V300 data sheet (Issue 00B06, 2019-05-15), section 9.1.6, PDF page 460).";
        field {
            name = "ch_skipy_cfg";
            desc = "Skip configuration";
            sw = rw; hw = r;
            reset = 0xffffffff;
        } ch_skipy_cfg[31:0];
    };
    CH_SKIP_Y_CFG_t CH_SKIP_Y_CFG_0 @ 0x10050;
    CH_SKIP_Y_CFG_t CH_SKIP_Y_CFG_1 @ 0x11050;
    reg CH_SKIP_C_CFG_t {
        name = "CH_SKIP_C_CFG";
        desc = "CH_SKIP_C_CFG is the channel C component skip configuration register. (offset 0x10058, 2 instances at stride 0x1000; total reset 0xFFFFFFFF; PROVEN: Hi3516E V300 data sheet (Issue 00B06, 2019-05-15), section 9.1.6, PDF page 460).";
        field {
            name = "ch_skipc_cfg";
            desc = "Skip configuration";
            sw = rw; hw = r;
            reset = 0xffffffff;
        } ch_skipc_cfg[31:0];
    };
    CH_SKIP_C_CFG_t CH_SKIP_C_CFG_0 @ 0x10058;
    CH_SKIP_C_CFG_t CH_SKIP_C_CFG_1 @ 0x11058;
    reg CH_WCH_Y_CFG_t {
        name = "CH_WCH_Y_CFG";
        desc = "CH_WCH_Y_CFG is the Y component configuration register. (offset 0x10080, 2 instances at stride 0x1000; total reset 0x00000000; PROVEN: Hi3516E V300 data sheet (Issue 00B06, 2019-05-15), section 9.1.6, PDF page 461).";
        field {
            name = "wch_y_enable";
            desc = "Channel write enable
- 0: disabled
- 1: enabled";
            sw = rw; hw = r;
            reset = 0x0;
        } wch_y_enable[31:31];
        field {
            name = "reserved";
            desc = "Reserved";
            sw = r; hw = w;
            reset = 0x0;
        } reserved_30_29[30:29];
        field {
            name = "wch_y_wrap_line";
            desc = "Number of winding buffer lines in the write channel";
            sw = rw; hw = r;
            reset = 0x0;
        } wch_y_wrap_line[28:15];
        field {
            name = "wch_y_wrap_en";
            desc = "Winding buffer enable register of the write channel
- 0: disabled
- 1: enabled";
            sw = rw; hw = r;
            reset = 0x0;
        } wch_y_wrap_en[14:14];
        field {
            name = "reserved";
            desc = "Reserved";
            sw = r; hw = w;
            reset = 0x0;
        } reserved_13_6[13:6];
        field {
            name = "wch_y_bit_width";
            desc = "Data bit width
- 0x08: 8 bits
- 0x0A: 10 bits
- 0x0C: 12 bits
- 0x0E: 14 bits
- 0x10: 16 bits

Other values: reserved";
            sw = rw; hw = r;
            reset = 0x0;
        } wch_y_bit_width[5:0];
    };
    CH_WCH_Y_CFG_t CH_WCH_Y_CFG_0 @ 0x10080;
    CH_WCH_Y_CFG_t CH_WCH_Y_CFG_1 @ 0x11080;
    reg CH_WCH_Y_SIZE_t {
        name = "CH_WCH_Y_SIZE";
        desc = "CH_WCH_Y_SIZE is the Y component storage size register for the WCH module. (offset 0x10084, 2 instances at stride 0x1000; total reset 0x00000000; PROVEN: Hi3516E V300 data sheet (Issue 00B06, 2019-05-15), section 9.1.6, PDF page 461).";
        field {
            name = "wch_y_height";
            desc = "Height of the stored image (unit: row) The configured value is the actual value minus 1.";
            sw = rw; hw = r;
            reset = 0x0;
        } wch_y_height[31:16];
        field {
            name = "wch_y_width";
            desc = "Width of the stored image (unit: pixel) The configured value is the actual value minus 1.";
            sw = rw; hw = r;
            reset = 0x0;
        } wch_y_width[15:0];
    };
    CH_WCH_Y_SIZE_t CH_WCH_Y_SIZE_0 @ 0x10084;
    CH_WCH_Y_SIZE_t CH_WCH_Y_SIZE_1 @ 0x11084;
    reg CH_WCH_Y_FADDR_L_t {
        name = "CH_WCH_Y_FADDR_L";
        desc = "CH_WCH_Y_FADDR_L is the lower 32 bits register of the Y component storage base address in the WCH module. (offset 0x10094, 2 instances at stride 0x1000; total reset 0x00000000; PROVEN: Hi3516E V300 data sheet (Issue 00B06, 2019-05-15), section 9.1.6, PDF page 462).";
        field {
            name = "wch_y_faddr_l";
            desc = "Lower 32 bits of the storage base address of the Y component";
            sw = rw; hw = r;
            reset = 0x0;
        } wch_y_faddr_l[31:0];
    };
    CH_WCH_Y_FADDR_L_t CH_WCH_Y_FADDR_L_0 @ 0x10094;
    CH_WCH_Y_FADDR_L_t CH_WCH_Y_FADDR_L_1 @ 0x11094;
    reg CH_WCH_Y_STRIDE_t {
        name = "CH_WCH_Y_STRIDE";
        desc = "CH_WCH_Y_STRIDE is the Y component stride register in the WCH module. (offset 0x100A0, 2 instances at stride 0x1000; total reset 0x00000000; PROVEN: Hi3516E V300 data sheet (Issue 00B06, 2019-05-15), section 9.1.6, PDF page 462).";
        field {
            name = "reserved";
            desc = "Reserved";
            sw = r; hw = w;
            reset = 0x0;
        } reserved_31_16[31:16];
        field {
            name = "wch_y_stride";
            desc = "Stride of the Y component stored in an image, in the unit of byte";
            sw = rw; hw = r;
            reset = 0x0;
        } wch_y_stride[15:0];
    };
    CH_WCH_Y_STRIDE_t CH_WCH_Y_STRIDE_0 @ 0x100A0;
    CH_WCH_Y_STRIDE_t CH_WCH_Y_STRIDE_1 @ 0x110A0;
    reg CH_Y_ACT_SIZE_t {
        name = "CH_Y_ACT_SIZE";
        desc = "CH_Y_ACT_SIZE is the output image active area size indicator register of the luminance channel. (offset 0x100E8, 2 instances at stride 0x1000; total reset 0x00000000; PROVEN: Hi3516E V300 data sheet (Issue 00B06, 2019-05-15), section 9.1.6, PDF page 462).";
        field {
            name = "ch_y_height_act";
            desc = "Height of the active area of the luminance channel";
            sw = r; hw = w;
            reset = 0x0;
        } ch_y_height_act[31:16];
        field {
            name = "ch_y_width_act";
            desc = "Width of the active area of the luminance channel";
            sw = r; hw = w;
            reset = 0x0;
        } ch_y_width_act[15:0];
    };
    CH_Y_ACT_SIZE_t CH_Y_ACT_SIZE_0 @ 0x100E8;
    CH_Y_ACT_SIZE_t CH_Y_ACT_SIZE_1 @ 0x110E8;
    reg CH_C_ACT_SIZE_t {
        name = "CH_C_ACT_SIZE";
        desc = "CH_C_ACT_SIZE is the output image active area size indicator register of the chrominance channel. (offset 0x100EC, 2 instances at stride 0x1000; total reset 0x00000000; PROVEN: Hi3516E V300 data sheet (Issue 00B06, 2019-05-15), section 9.1.6, PDF page 463).";
        field {
            name = "ch_c_height_act";
            desc = "Height of the active area of the chrominance channel";
            sw = r; hw = w;
            reset = 0x0;
        } ch_c_height_act[31:16];
        field {
            name = "ch_c_width_act";
            desc = "Width of the active area of the chrominance channel";
            sw = r; hw = w;
            reset = 0x0;
        } ch_c_width_act[15:0];
    };
    CH_C_ACT_SIZE_t CH_C_ACT_SIZE_0 @ 0x100EC;
    CH_C_ACT_SIZE_t CH_C_ACT_SIZE_1 @ 0x110EC;
    reg CH_INT_t {
        name = "CH_INT";
        desc = "CH_INT is the channel raw interrupt register. (offset 0x100F0, 2 instances at stride 0x1000; total reset 0x00000000; PROVEN: Hi3516E V300 data sheet (Issue 00B06, 2019-05-15), section 9.1.6, PDF page 463).";
        field {
            name = "reserved";
            desc = "Reserved";
            sw = r; hw = w;
            reset = 0x0;
        } reserved_31_17[31:17];
        field {
            name = "ch_stt_ae_finish";
            desc = "Status of the AE statistics completion interrupt Writing 1 clears this bit.
- 0: No interrupt is generated.
- 1: An interrupt is generated.

Access type WC in the data sheet: written 1 clears the bit.";
            sw = rw; hw = w; onwrite = woclr;
            reset = 0x0;
        } ch_stt_ae_finish[16:16];
        field {
            name = "ch_int_fstart_dly";
            desc = "Interrupt status of the frame/field start after delay Writing 1 clears this bit.
- 0: No interrupt is generated.
- 1: An interrupt is generated.

Access type WC in the data sheet: written 1 clears the bit.";
            sw = rw; hw = w; onwrite = woclr;
            reset = 0x0;
        } ch_int_fstart_dly[15:15];
        field {
            name = "reserved";
            desc = "Reserved";
            sw = r; hw = w;
            reset = 0x0;
        } reserved_14_5[14:5];
        field {
            name = "ch_int_update_cfg";
            desc = "Interrupt status of the register update Writing 1 clears this bit.
- 0: No interrupt is generated.
- 1: An interrupt is generated.

Access type WC in the data sheet: written 1 clears the bit.";
            sw = rw; hw = w; onwrite = woclr;
            reset = 0x0;
        } ch_int_update_cfg[4:4];
        field {
            name = "ch_int_field_throw";
            desc = "Interrupt status of the frame/field loss Writing 1 clears this bit.
- 0: No interrupt is generated.
- 1: An interrupt is generated.

Access type WC in the data sheet: written 1 clears the bit.";
            sw = rw; hw = w; onwrite = woclr;
            reset = 0x0;
        } ch_int_field_throw[3:3];
        field {
            name = "ch_int_buf_ovf";
            desc = "Interrupt status of the internal FIFO overflow error Writing 1 clears this bit.

Access type WC in the data sheet: written 1 clears the bit.";
            sw = rw; hw = w; onwrite = woclr;
            reset = 0x0;
        } ch_int_buf_ovf[2:2];
        field {
            name = "ch_int_cc_int";
            desc = "Interrupt status of the obtaining completion Writing 1 clears this bit.
- 0: No interrupt is generated.
- 1: An interrupt is generated.

Access type WC in the data sheet: written 1 clears the bit.";
            sw = rw; hw = w; onwrite = woclr;
            reset = 0x0;
        } ch_int_cc_int[1:1];
        field {
            name = "ch_int_fstart";
            desc = "Interrupt status of the field/frame start Writing 1 clears this bit.
- 0: No interrupt is generated.
- 1: An interrupt is generated.

Access type WC in the data sheet: written 1 clears the bit.";
            sw = rw; hw = w; onwrite = woclr;
            reset = 0x0;
        } ch_int_fstart[0:0];
    };
    CH_INT_t CH_INT_0 @ 0x100F0;
    CH_INT_t CH_INT_1 @ 0x110F0;
    reg CH_INT_MASK_t {
        name = "CH_INT_MASK";
        desc = "CH_INT_MASK is the channel interrupt mask register. (offset 0x100F8, 2 instances at stride 0x1000; total reset 0x00000000; PROVEN: Hi3516E V300 data sheet (Issue 00B06, 2019-05-15), section 9.1.6, PDF page 464).";
        field {
            name = "reserved";
            desc = "Reserved";
            sw = r; hw = w;
            reset = 0x0;
        } reserved_31_17[31:17];
        field {
            name = "mask_stt_ae_finish";
            desc = "Interrupt enable for the AE statistics completion
- 0: The interrupt is masked.
- 1: The interrupt is enabled.";
            sw = rw; hw = r;
            reset = 0x0;
        } mask_stt_ae_finish[16:16];
        field {
            name = "mask_fstart_dly";
            desc = "Delayed field/frame start interrupt enable
- 0: The interrupt is masked.
- 1: The interrupt is enabled.";
            sw = rw; hw = r;
            reset = 0x0;
        } mask_fstart_dly[15:15];
        field {
            name = "reserved";
            desc = "Reserved";
            sw = r; hw = w;
            reset = 0x0;
        } reserved_14_5[14:5];
        field {
            name = "mask_update_cfg";
            desc = "Register update interrupt enable
- 0: The interrupt is masked.
- 1: The interrupt is enabled.";
            sw = rw; hw = r;
            reset = 0x0;
        } mask_update_cfg[4:4];
        field {
            name = "mask_field_throw";
            desc = "Field/Frame loss interrupt enable
- 0: The interrupt is masked.
- 1: The interrupt is enabled.";
            sw = rw; hw = r;
            reset = 0x0;
        } mask_field_throw[3:3];
        field {
            name = "mask_buf_ovf";
            desc = "Internal FIFO overflow error interrupt enable
- 0: The interrupt is masked.
- 1: The interrupt is enabled.";
            sw = rw; hw = r;
            reset = 0x0;
        } mask_buf_ovf[2:2];
        field {
            name = "mask_cc_int";
            desc = "Capture completion interrupt enable
- 0: The interrupt is masked.";
            sw = rw; hw = r;
            reset = 0x0;
        } mask_cc_int[1:1];
        field {
            name = "mask_fstart";
            desc = "Field/Frame start interrupt enable
- 0: The interrupt is masked.
- 1: The interrupt is enabled.";
            sw = rw; hw = r;
            reset = 0x0;
        } mask_fstart[0:0];
    };
    CH_INT_MASK_t CH_INT_MASK_0 @ 0x100F8;
    CH_INT_MASK_t CH_INT_MASK_1 @ 0x110F8;
    reg CH_WCH_STT_AE_HIST_ADDR_L_t {
        name = "CH_WCH_STT_AE_HIST_ADDR_L";
        desc = "CH_WCH_STT_ADDR_L is the lower 32 bits register of the ISP statistics storage base address. (offset 0x10208, 2 instances at stride 0x1000; total reset 0x00000000; PROVEN: Hi3516E V300 data sheet (Issue 00B06, 2019-05-15), section 9.1.6, PDF page 465).";
        field {
            name = "ch_wch_stt_ae_hist_addr_l";
            desc = "Lower 32 bits of the ISP AE_HIST statistics storage base address (supported only by channel 0/1)";
            sw = rw; hw = r;
            reset = 0x0;
        } ch_wch_stt_ae_hist_addr_l[31:0];
    };
    CH_WCH_STT_AE_HIST_ADDR_L_t CH_WCH_STT_AE_HIST_ADDR_L_0 @ 0x10208;
    CH_WCH_STT_AE_HIST_ADDR_L_t CH_WCH_STT_AE_HIST_ADDR_L_1 @ 0x11208;
    reg CH_WCH_STT_AE_AVER_R_GR_ADDR_L_t {
        name = "CH_WCH_STT_AE_AVER_R_GR_ADDR_L";
        desc = "CH_WCH_STT_ADDR_L is the lower 32 bits register of the ISP statistics storage base address. (offset 0x10210, 2 instances at stride 0x1000; total reset 0x00000000; PROVEN: Hi3516E V300 data sheet (Issue 00B06, 2019-05-15), section 9.1.6, PDF page 465).";
        field {
            name = "ch_wch_stt_ae_aver_r_gr_addr_l";
            desc = "Lower 32 bits of the ISP AE_AVER_R_GR statistics storage base address (supported only by channel 0/1)";
            sw = rw; hw = r;
            reset = 0x0;
        } ch_wch_stt_ae_aver_r_gr_addr_l[31:0];
    };
    CH_WCH_STT_AE_AVER_R_GR_ADDR_L_t CH_WCH_STT_AE_AVER_R_GR_ADDR_L_0 @ 0x10210;
    CH_WCH_STT_AE_AVER_R_GR_ADDR_L_t CH_WCH_STT_AE_AVER_R_GR_ADDR_L_1 @ 0x11210;
    reg CH_WCH_STT_AE_AVER_GB_B_ADDR_L_t {
        name = "CH_WCH_STT_AE_AVER_GB_B_ADDR_L";
        desc = "CH_WCH_STT_ADDR_L is the lower 32 bits register of the ISP statistics storage base address. (offset 0x10218, 2 instances at stride 0x1000; total reset 0x00000000; PROVEN: Hi3516E V300 data sheet (Issue 00B06, 2019-05-15), section 9.1.6, PDF page 465).";
        field {
            name = "ch_wch_stt_ae_aver_gb_b_addr_l";
            desc = "Lower 32 bits of the ISP AE_AVER_GB_B statistics storage base address (supported only by channel 0/1)";
            sw = rw; hw = r;
            reset = 0x0;
        } ch_wch_stt_ae_aver_gb_b_addr_l[31:0];
    };
    CH_WCH_STT_AE_AVER_GB_B_ADDR_L_t CH_WCH_STT_AE_AVER_GB_B_ADDR_L_0 @ 0x10218;
    CH_WCH_STT_AE_AVER_GB_B_ADDR_L_t CH_WCH_STT_AE_AVER_GB_B_ADDR_L_1 @ 0x11218;
    reg CH_WCH_STT_AF_STAT_H1_ADDR_L_t {
        name = "CH_WCH_STT_AF_STAT_H1_ADDR_L";
        desc = "CH_WCH_STT_ADDR_L is the lower 32 bits register of the ISP statistics storage base address. (offset 0x10220, 2 instances at stride 0x1000; total reset 0x00000000; PROVEN: Hi3516E V300 data sheet (Issue 00B06, 2019-05-15), section 9.1.6, PDF page 466).";
        field {
            name = "ch_wch_stt_af_stat_h1_addr_l";
            desc = "Lower 32 bits of the ISP AF_STAT_H1 statistics storage base address (supported only by channel 0/1)";
            sw = rw; hw = r;
            reset = 0x0;
        } ch_wch_stt_af_stat_h1_addr_l[31:0];
    };
    CH_WCH_STT_AF_STAT_H1_ADDR_L_t CH_WCH_STT_AF_STAT_H1_ADDR_L_0 @ 0x10220;
    CH_WCH_STT_AF_STAT_H1_ADDR_L_t CH_WCH_STT_AF_STAT_H1_ADDR_L_1 @ 0x11220;
    reg CH_WCH_STT_AF_STAT_H2_ADDR_L_t {
        name = "CH_WCH_STT_AF_STAT_H2_ADDR_L";
        desc = "CH_WCH_STT_ADDR_L is the lower 32 bits register of the ISP statistics storage base address. (offset 0x10228, 2 instances at stride 0x1000; total reset 0x00000000; PROVEN: Hi3516E V300 data sheet (Issue 00B06, 2019-05-15), section 9.1.6, PDF page 466).";
        field {
            name = "ch_wch_stt_af_stat_h2_addr_l";
            desc = "Lower 32 bits of the ISP AF_STAT_H2 statistics storage base address (supported only by channel 0/1)";
            sw = rw; hw = r;
            reset = 0x0;
        } ch_wch_stt_af_stat_h2_addr_l[31:0];
    };
    CH_WCH_STT_AF_STAT_H2_ADDR_L_t CH_WCH_STT_AF_STAT_H2_ADDR_L_0 @ 0x10228;
    CH_WCH_STT_AF_STAT_H2_ADDR_L_t CH_WCH_STT_AF_STAT_H2_ADDR_L_1 @ 0x11228;
};
`endif
