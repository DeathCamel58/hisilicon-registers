`ifndef HI3516EV300_OTP_RDL
`define HI3516EV300_OTP_RDL
regfile eHI3516EV300_OTP {
    name = "OTP controller";
    desc = "OTP controller of the Hi3516E V300 at base 0x1009_0000. 19 registers extracted programmatically from the Hi3516E V300 data sheet (Issue 00B06, 2019-05-15) (Table 13-6 Summary of the OTP Ctrl registers (base address: 0x1009_0000)): register headings, offsets, total reset values, field bit ranges, access types, names, reset values and descriptions, with PDF page numbers in each register description. Field names, bit ranges, access types and offsets are exact; the free-text descriptions are taken from the cell text of the field table and were checked by sampling only. Hardware not verified.";
    reg {
        name = "OTP_USER_WORK_MODE";
        desc = "OTP_USER_WORK_MODE is OTP user interface register 0. (offset 0x0; total reset 0x00000000; PROVEN: Hi3516E V300 data sheet (Issue 00B06, 2019-05-15), section 13.6.5, PDF page 852).";
        field {
            name = "reserved";
            desc = "Reserved";
            sw = r; hw = w;
            reset = 0x0;
        } reserved_31_3[31:3];
        field {
            name = "otp_user_work_mode";
            desc = "Mode select
- 000: reading the lock status in the OTP memory
- 001: loading the keys of the OTP memory to the KLAD";
            sw = rw; hw = r;
            reset = 0x0;
        } otp_user_work_mode[2:0];
    } OTP_USER_WORK_MODE @ 0x0;
    reg {
        name = "OTP_USER_OP_START";
        desc = "OTP_USER_OP_START is OTP user interface register 1. (offset 0x4; total reset 0x00000000; PROVEN: Hi3516E V300 data sheet (Issue 00B06, 2019-05-15), section 13.6.5, PDF page 853).";
        field {
            name = "Write32'h1acce551totheregistertostartotp_user_op_startoperating";
            desc = "";
            sw = rw; hw = r;
            reset = 0x0;
        } Write32_h1acce551totheregistertostartotp_user_op_startoperating[31:0];
    } OTP_USER_OP_START @ 0x4;
    reg {
        name = "OTP_USER_KEY_INDEX";
        desc = "OTP_USER_KEY_INDEX is OTP user interface register 2. (offset 0x8; total reset 0x00000000; PROVEN: Hi3516E V300 data sheet (Issue 00B06, 2019-05-15), section 13.6.5, PDF page 853).";
        field {
            name = "reserved";
            desc = "Reserved";
            sw = r; hw = w;
            reset = 0x0;
        } reserved_31_3[31:3];
        field {
            name = "otp_index";
            desc = "Key address
- 000: key0
- 001: key1
- 010: key2
- 011: key3
- 100: reserved
- 101: reserved
- 110: rootkey
- 111: hmackey

Note: The data bit width of hmackey is 128 bits. The data bit widths of rootkey and key0- key3 are 256 bits.";
            sw = rw; hw = r;
            reset = 0x0;
        } otp_index[2:0];
    } OTP_USER_KEY_INDEX @ 0x8;
    reg {
        name = "OTP_USER_KEY_DATA0";
        desc = "OTP_USER_KEY_DATA0 is OTP user interface register 3. (offset 0xC; total reset 0x00000000; PROVEN: Hi3516E V300 data sheet (Issue 00B06, 2019-05-15), section 13.6.5, PDF page 854).";
        field {
            name = "otp_user_key_data0";
            desc = "OTP configuration data 0";
            sw = rw; hw = r;
            reset = 0x0;
        } otp_user_key_data0[31:0];
    } OTP_USER_KEY_DATA0 @ 0xC;
    reg {
        name = "OTP_USER_KEY_DATA1";
        desc = "OTP_USER_KEY_DATA1 is OTP user interface register 4. (offset 0x10; total reset 0x00000000; PROVEN: Hi3516E V300 data sheet (Issue 00B06, 2019-05-15), section 13.6.5, PDF page 854).";
        field {
            name = "otp_user_key_data1";
            desc = "OTP configuration data 1";
            sw = rw; hw = r;
            reset = 0x0;
        } otp_user_key_data1[31:0];
    } OTP_USER_KEY_DATA1 @ 0x10;
    reg {
        name = "OTP_USER_KEY_DATA2";
        desc = "OTP_USER_KEY_DATA2 is OTP user interface register 5. (offset 0x14; total reset 0x00000000; PROVEN: Hi3516E V300 data sheet (Issue 00B06, 2019-05-15), section 13.6.5, PDF page 854).";
        field {
            name = "otp_user_key_data2";
            desc = "OTP configuration data 2";
            sw = rw; hw = r;
            reset = 0x0;
        } otp_user_key_data2[31:0];
    } OTP_USER_KEY_DATA2 @ 0x14;
    reg {
        name = "OTP_USER_KEY_DATA3";
        desc = "OTP_USER_KEY_DATA3 is OTP user interface register 6. (offset 0x18; total reset 0x00000000; PROVEN: Hi3516E V300 data sheet (Issue 00B06, 2019-05-15), section 13.6.5, PDF page 854).";
        field {
            name = "otp_user_key_data3";
            desc = "OTP configuration data 3";
            sw = rw; hw = r;
            reset = 0x0;
        } otp_user_key_data3[31:0];
    } OTP_USER_KEY_DATA3 @ 0x18;
    reg {
        name = "OTP_USER_KEY_DATA4";
        desc = "OTP_USER_KEY_DATA4 is OTP user interface register 7. (offset 0x1C; total reset 0x00000000; PROVEN: Hi3516E V300 data sheet (Issue 00B06, 2019-05-15), section 13.6.5, PDF page 854).";
        field {
            name = "otp_user_key_data4";
            desc = "OTP configuration data 4";
            sw = rw; hw = r;
            reset = 0x0;
        } otp_user_key_data4[31:0];
    } OTP_USER_KEY_DATA4 @ 0x1C;
    reg {
        name = "OTP_USER_KEY_DATA5";
        desc = "OTP_USER_KEY_DATA5 is OTP user interface register 8. (offset 0x20; total reset 0x00000000; PROVEN: Hi3516E V300 data sheet (Issue 00B06, 2019-05-15), section 13.6.5, PDF page 855).";
        field {
            name = "otp_user_key_data5";
            desc = "OTP configuration data 5";
            sw = rw; hw = r;
            reset = 0x0;
        } otp_user_key_data5[31:0];
    } OTP_USER_KEY_DATA5 @ 0x20;
    reg {
        name = "OTP_USER_KEY_DATA6";
        desc = "OTP_USER_KEY_DATA6 is OTP user interface register 9. (offset 0x24; total reset 0x00000000; PROVEN: Hi3516E V300 data sheet (Issue 00B06, 2019-05-15), section 13.6.5, PDF page 855).";
        field {
            name = "otp_user_key_data6";
            desc = "OTP configuration data 6";
            sw = rw; hw = r;
            reset = 0x0;
        } otp_user_key_data6[31:0];
    } OTP_USER_KEY_DATA6 @ 0x24;
    reg {
        name = "OTP_USER_KEY_DATA7";
        desc = "OTP_USER_KEY_DATA7 is OTP user interface register 10. (offset 0x28; total reset 0x00000000; PROVEN: Hi3516E V300 data sheet (Issue 00B06, 2019-05-15), section 13.6.5, PDF page 855).";
        field {
            name = "otp_user_key_data7";
            desc = "OTP configuration data 7";
            sw = rw; hw = r;
            reset = 0x0;
        } otp_user_key_data7[31:0];
    } OTP_USER_KEY_DATA7 @ 0x28;
    reg {
        name = "OTP_USER_KEY_DATA8";
        desc = "OTP_USER_KEY_DATA8 is OTP user interface register 11. (offset 0x2C; total reset 0x00000000; PROVEN: Hi3516E V300 data sheet (Issue 00B06, 2019-05-15), section 13.6.5, PDF page 855).";
        field {
            name = "otp_user_key_data8";
            desc = "OTP configuration data 8";
            sw = rw; hw = r;
            reset = 0x0;
        } otp_user_key_data8[31:0];
    } OTP_USER_KEY_DATA8 @ 0x2C;
    reg {
        name = "OTP_USER_FLAG_VALUE";
        desc = "OTP_USER_FLAG_VALUE is OTP user interface register 12. (offset 0x30; total reset 0x00000000; PROVEN: Hi3516E V300 data sheet (Issue 00B06, 2019-05-15), section 13.6.5, PDF page 856).";
        field {
            name = "reserved";
            desc = "Reserved";
            sw = r; hw = w;
            reset = 0x0;
        } reserved_31_9[31:9];
        field {
            name = "uboot_redundance";
            desc = "uboot_redundance configuration
- 0: disabled
- 1: enabled";
            sw = rw; hw = r;
            reset = 0x0;
        } uboot_redundance[8:8];
        field {
            name = "reserved";
            desc = "Reserved";
            sw = r; hw = w;
            reset = 0x0;
        } reserved_7_3[7:3];
        field {
            name = "jtag_ca_en";
            desc = "jtag_ca_en configuration
- 0: enabled
- 1: always disabled";
            sw = rw; hw = r;
            reset = 0x0;
        } jtag_ca_en[2:2];
        field {
            name = "reserved";
            desc = "Reserved";
            sw = r; hw = w;
            reset = 0x0;
        } reserved_1_1[1:1];
        field {
            name = "secure_boot_en";
            desc = "secure_boot_en configuration
- 0: disabled
- 1: enabled";
            sw = rw; hw = r;
            reset = 0x0;
        } secure_boot_en[0:0];
    } OTP_USER_FLAG_VALUE @ 0x30;
    reg {
        name = "OTP_USER_FLAG_INDEX";
        desc = "OTP_USER_FLAG_INDEX is OTP user interface register 13. (offset 0x34; total reset 0x00000000; PROVEN: Hi3516E V300 data sheet (Issue 00B06, 2019-05-15), section 13.6.5, PDF page 856).";
        field {
            name = "reserved";
            desc = "Reserved";
            sw = r; hw = w;
            reset = 0x0;
        } reserved_31_3[31:3];
        field {
            name = "flag_index";
            desc = "Address select for the flag bit
- 000: The value of secure_boot_en is set to the

OTP memory.
- 010: The value of jtag_ca_en is set to the OTP memory.
- 101: The value of uboot_redundance is set to the OTP memory.

Other values: reserved";
            sw = rw; hw = r;
            reset = 0x0;
        } flag_index[2:0];
    } OTP_USER_FLAG_INDEX @ 0x34;
    reg {
        name = "OTP_USER_REV_ADDR";
        desc = "OTP_USER_REV_ADDR is OTP user interface register 14. (offset 0x38; total reset 0x00000000; PROVEN: Hi3516E V300 data sheet (Issue 00B06, 2019-05-15), section 13.6.5, PDF page 856).";
        field {
            name = "reserved";
            desc = "Reserved";
            sw = r; hw = w;
            reset = 0x0;
        } reserved_31_10[31:10];
        field {
            name = "otp_user_reserved_addr";
            desc = "Address of the space reserved for the OTP user. The address range is 0- 0x37F. One address corresponds to data of the 32-bit OTP space.";
            sw = rw; hw = r;
            reset = 0x0;
        } otp_user_reserved_addr[9:0];
    } OTP_USER_REV_ADDR @ 0x38;
    reg {
        name = "OTP_USER_REV_WDATA";
        desc = "OTP_USER_REV_WDATA is OTP user interface register 15. (offset 0x3C; total reset 0x00000000; PROVEN: Hi3516E V300 data sheet (Issue 00B06, 2019-05-15), section 13.6.5, PDF page 857).";
        field {
            name = "Writingdatatothespacereservedforotp_user_reserved_wdatatheOTPuser";
            desc = "";
            sw = rw; hw = r;
            reset = 0x0;
        } Writingdatatothespacereservedforotp_user_reserved_wdatatheOTPuser[31:0];
    } OTP_USER_REV_WDATA @ 0x3C;
    reg {
        name = "OTP_USER_REV_RDATA";
        desc = "OTP_USER_REV_RDATA is OTP user interface register 16. (offset 0x40; total reset 0x00000000; PROVEN: Hi3516E V300 data sheet (Issue 00B06, 2019-05-15), section 13.6.5, PDF page 857).";
        field {
            name = "Readingdatafromthespacereservedotp_user_reserved_rdatafortheOTPuser";
            desc = "";
            sw = r; hw = w;
            reset = 0x0;
        } Readingdatafromthespacereservedotp_user_reserved_rdatafortheOTPuser[31:0];
    } OTP_USER_REV_RDATA @ 0x40;
    reg {
        name = "OTP_USER_LOCK_STA0";
        desc = "OTP_USER_LOCK_STA0 is OTP user interface register 17. (offset 0x44; total reset 0x00000000; PROVEN: Hi3516E V300 data sheet (Issue 00B06, 2019-05-15), section 13.6.5, PDF page 857).";
        field {
            name = "reserved";
            desc = "Reserved";
            sw = r; hw = w;
            reset = 0x0;
        } reserved_31_16[31:16];
        field {
            name = "hmac_key_lock";
            desc = "HMAC key status indicator
- 0: configurable
- 1: configured and locked";
            sw = rw; hw = r;
            reset = 0x0;
        } hmac_key_lock[15:15];
        field {
            name = "reserved";
            desc = "Reserved";
            sw = r; hw = w;
            reset = 0x0;
        } reserved_14_13[14:13];
        field {
            name = "uboot_redundance_lock";
            desc = "uboot_redundance status indicator
- 0: configurable";
            sw = r; hw = w;
            reset = 0x0;
        } uboot_redundance_lock[12:12];
        field {
            name = "reserved";
            desc = "Reserved";
            sw = r; hw = w;
            reset = 0x0;
        } reserved_11_11[11:11];
        field {
            name = "reserved";
            desc = "Reserved";
            sw = r; hw = w;
            reset = 0x0;
        } reserved_10_10[10:10];
        field {
            name = "jtag_ca_en_lock";
            desc = "jtag_ca_en status indicator
- 0: configurable
- 1: configured and locked";
            sw = r; hw = w;
            reset = 0x0;
        } jtag_ca_en_lock[9:9];
        field {
            name = "key3_lock";
            desc = "key3 status indicator
- 0: configurable
- 1: configured and locked";
            sw = r; hw = w;
            reset = 0x0;
        } key3_lock[8:8];
        field {
            name = "key2_lock";
            desc = "key2 status indicator
- 0: configurable
- 1: configured and locked";
            sw = r; hw = w;
            reset = 0x0;
        } key2_lock[7:7];
        field {
            name = "key1_lock";
            desc = "key1 status indicator
- 0: configurable
- 1: configured and locked";
            sw = r; hw = w;
            reset = 0x0;
        } key1_lock[6:6];
        field {
            name = "key0_lock";
            desc = "key0 status indicator
- 0: configurable
- 1: configured and locked";
            sw = r; hw = w;
            reset = 0x0;
        } key0_lock[5:5];
        field {
            name = "root_key_lock";
            desc = "root_key status indicator.
- 0: configurable
- 1: configured and locked";
            sw = r; hw = w;
            reset = 0x0;
        } root_key_lock[4:4];
        field {
            name = "reserved";
            desc = "Reserved";
            sw = r; hw = w;
            reset = 0x0;
        } reserved_3_2[3:2];
        field {
            name = "ddr_ca_en_lock";
            desc = "ddr_ca_en status indicator
- 0: configurable
- 1: configured and locked";
            sw = r; hw = w;
            reset = 0x0;
        } ddr_ca_en_lock[1:1];
        field {
            name = "secure_boot_en_lock";
            desc = "secure_boot_en status indicator
- 0: configurable
- 1: configured and locked";
            sw = r; hw = w;
            reset = 0x0;
        } secure_boot_en_lock[0:0];
    } OTP_USER_LOCK_STA0 @ 0x44;
    reg {
        name = "OTP_USER_CTRL_STA";
        desc = "OTP_USER_CTRL_STA is OTP user interface register 19. (offset 0x4C; total reset 0x00000000; PROVEN: Hi3516E V300 data sheet (Issue 00B06, 2019-05-15), section 13.6.5, PDF page 858).";
        field {
            name = "reserved";
            desc = "Reserved";
            sw = r; hw = w;
            reset = 0x0;
        } reserved_31_26[31:26];
        field {
            name = "flag_index_finish";
            desc = "Flag bit index corresponding to the finish operation";
            sw = r; hw = w;
            reset = 0x0;
        } flag_index_finish[25:24];
        field {
            name = "user_rev_addr_finish";
            desc = "Address of the space reserved for the user and corresponds the finish operation";
            sw = r; hw = w;
            reset = 0x0;
        } user_rev_addr_finish[23:16];
        field {
            name = "key_index_finish";
            desc = "Key index corresponding to the finish operation";
            sw = r; hw = w;
            reset = 0x0;
        } key_index_finish[15:12];
        field {
            name = "rd_lock_sta_finish";
            desc = "Lock status indicator
- 0: not finished
- 1: finished";
            sw = r; hw = w;
            reset = 0x0;
        } rd_lock_sta_finish[11:11];
        field {
            name = "key_load_finish";
            desc = "Status indicator for the key loading mode
- 0: not finished
- 1: finished";
            sw = r; hw = w;
            reset = 0x0;
        } key_load_finish[10:10];
        field {
            name = "key_pgm_finish";
            desc = "Status indicator for the key write mode
- 0: not finished
- 1: finished";
            sw = r; hw = w;
            reset = 0x0;
        } key_pgm_finish[9:9];
        field {
            name = "key_crc_check_finish";
            desc = "Status indicator for the CRC mode
- 0: not finished
- 1: finished";
            sw = r; hw = w;
            reset = 0x0;
        } key_crc_check_finish[8:8];
        field {
            name = "flag_pgm_finish";
            desc = "Status indicator for the flag bit
- 0: not finished
- 1: finished";
            sw = r; hw = w;
            reset = 0x0;
        } flag_pgm_finish[7:7];
        field {
            name = "user_rev_pgm_finish";
            desc = "Write operation status of the space reserved for the user
- 0: not finished
- 1: finished";
            sw = r; hw = w;
            reset = 0x0;
        } user_rev_pgm_finish[6:6];
        field {
            name = "user_rev_rd_finish";
            desc = "Read operation status of the space reserved for the user
- 0: not finished
- 1: finished";
            sw = r; hw = w;
            reset = 0x0;
        } user_rev_rd_finish[5:5];
        field {
            name = "key_crc_check_ok_flag";
            desc = "CRC status of the key
- 0: failed
- 1: passed";
            sw = r; hw = w;
            reset = 0x0;
        } key_crc_check_ok_flag[4:4];
        field {
            name = "key_rd_back_check_err";
            desc = "Comparison status of the key read back
- 0: The key configured by the user is normal.
- 1: A read back error occurs in the key configured by the user.";
            sw = r; hw = w;
            reset = 0x0;
        } key_rd_back_check_err[3:3];
        field {
            name = "otp_user_lock_err";
            desc = "Alarm for the locked space configured by the user";
            sw = r; hw = w;
            reset = 0x0;
        } otp_user_lock_err[2:2];
        field {
            name = "otp_user_cmd_finish";
            desc = "Operation completion indicator for the OTP controller
- 0: The operation on the OTP controller is not finished.
- 1: The operation on the OTP controller is finished. You can query the command execution result.";
            sw = r; hw = w;
            reset = 0x0;
        } otp_user_cmd_finish[1:1];
        field {
            name = "otp_op_busy";
            desc = "Operating status indicator for the OTP controller
- 0: The OTP controller is idle and can be operated.
- 1: The OTP controller is busy and cannot be operated. Contents";
            sw = r; hw = w;
            reset = 0x0;
        } otp_op_busy[0:0];
    } OTP_USER_CTRL_STA @ 0x4C;
};
`endif
