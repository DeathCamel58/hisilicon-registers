`ifndef HI3516EV300_MMC_RDL
`define HI3516EV300_MMC_RDL
regfile eHI3516EV300_MMC {
    name = "eMMC/SDIO controller";
    desc = "eMMC/SDIO controller of the Hi3516E V300 at base 0x1001_0000. 42 registers extracted programmatically from the Hi3516E V300 data sheet (Issue 00B06, 2019-05-15) (Table 12-15 Summary of MMC registers (eMMC/SDIO0 base address: 0x1001_0000; SDIO1): register headings, offsets, total reset values, field bit ranges, access types, names, reset values and descriptions, with PDF page numbers in each register description. Field names, bit ranges, access types and offsets are exact; the free-text descriptions are taken from the cell text of the field table and were checked by sampling only. Hardware not verified.";
    reg {
        name = "SDMASA_R";
        desc = "SDMASA_R is an SDMA system address register. (offset 0x0; total reset 0x00000000; PROVEN: Hi3516E V300 data sheet (Issue 00B06, 2019-05-15), section 12.4.4, PDF page 711).";
        field {
            name = "blockcnt_sdmasa";
            desc = "When Host Version Enable is set to 0, the register indicates the SDMA system address. When Host Version Enable is set to 1, the register indicates the block count. The value 1 indicates one block.";
            sw = rw; hw = r;
            reset = 0x0;
        } blockcnt_sdmasa[31:0];
    } SDMASA_R @ 0x0;
    reg {
        name = "BLOCKSIZE_R";
        desc = "BLOCKSIZE_R is a block size register. (offset 0x4; total reset 0x00000000; PROVEN: Hi3516E V300 data sheet (Issue 00B06, 2019-05-15), section 12.4.4, PDF page 712).";
        regwidth = 16;
        field {
            name = "reserved";
            desc = "Reserved";
            sw = r; hw = w;
            reset = 0x0;
        } reserved_15_15[15:15];
        field {
            name = "sdma_buf_bdary";
            desc = "Boundary value of an SDMA data block
- 000: 4K bytes
- 001: 8K bytes ...
- 111: 512K bytes";
            sw = rw; hw = r;
            reset = 0x0;
        } sdma_buf_bdary[14:12];
        field {
            name = "xfer_block_size";
            desc = "Transferred block size
- 0x800: 2048 bytes";
            sw = rw; hw = r;
            reset = 0x0;
        } xfer_block_size[11:0];
    } BLOCKSIZE_R @ 0x4;
    reg {
        name = "BLOCKCOUNT_R";
        desc = "BLOCKCOUNT_R is a block count register. (offset 0x6; total reset 0x00000000; PROVEN: Hi3516E V300 data sheet (Issue 00B06, 2019-05-15), section 12.4.4, PDF page 712).";
        regwidth = 16;
        field {
            name = "block_cnt";
            desc = "Block count
- 0x1: 1 ...
- 0xFFFF: 65,535";
            sw = rw; hw = r;
            reset = 0x0;
        } block_cnt[15:0];
    } BLOCKCOUNT_R @ 0x6;
    reg {
        name = "ARGUMENT_R";
        desc = "ARGUMENT_R is an SD card or eMMC command content register. (offset 0x8; total reset 0x00000000; PROVEN: Hi3516E V300 data sheet (Issue 00B06, 2019-05-15), section 12.4.4, PDF page 713).";
        field {
            name = "argument";
            desc = "Content value of the 32-bit command";
            sw = rw; hw = r;
            reset = 0x0;
        } argument[31:0];
    } ARGUMENT_R @ 0x8;
    reg {
        name = "XFER_MODE_R";
        desc = "XFER_MODE_R is a transfer mode command register. (offset 0xC; total reset 0x00000000; PROVEN: Hi3516E V300 data sheet (Issue 00B06, 2019-05-15), section 12.4.4, PDF page 713).";
        regwidth = 16;
        field {
            name = "reserved";
            desc = "Reserved";
            sw = r; hw = w;
            reset = 0x0;
        } reserved_15_9[15:9];
        field {
            name = "resp_int_disable";
            desc = "Response interrupt disable
- 0: enabled
- 1: disabled";
            sw = rw; hw = r;
            reset = 0x0;
        } resp_int_disable[8:8];
        field {
            name = "resp_err_chk_enable";
            desc = "Response error check enable
- 0: disabled
- 1: enabled";
            sw = rw; hw = r;
            reset = 0x0;
        } resp_err_chk_enable[7:7];
        field {
            name = "resp_type";
            desc = "Response R1/R5 type
- 0: R1
- 1: R5";
            sw = rw; hw = r;
            reset = 0x0;
        } resp_type[6:6];
        field {
            name = "multi_blk_sel";
            desc = "Multiple/single block select
- 0: single block
- 1: multiple blocks";
            sw = rw; hw = r;
            reset = 0x0;
        } multi_blk_sel[5:5];
        field {
            name = "data_xfer_dir";
            desc = "Data transfer direction
- 0: from the controller to the card
- 1: from the card to the controller";
            sw = rw; hw = r;
            reset = 0x0;
        } data_xfer_dir[4:4];
        field {
            name = "auto_cmd_enable";
            desc = "Auto command enable
- 00: disabled
- 01: auto CMD12 enabled
- 10: auto CMD23 enabled
- 11: auto CMD auto select (The value is fixed at 00 in the SDIO.)";
            sw = rw; hw = r;
            reset = 0x0;
        } auto_cmd_enable[3:2];
        field {
            name = "block_count_enable";
            desc = "Block count enable
- 0: disabled
- 1: enabled";
            sw = rw; hw = r;
            reset = 0x0;
        } block_count_enable[1:1];
        field {
            name = "dma_enable";
            desc = "DMA enable";
            sw = rw; hw = r;
            reset = 0x0;
        } dma_enable[0:0];
    } XFER_MODE_R @ 0xC;
    reg {
        name = "CMD_R";
        desc = "CMD_R is a transfer mode command register. (offset 0xE; total reset 0x00000000; PROVEN: Hi3516E V300 data sheet (Issue 00B06, 2019-05-15), section 12.4.4, PDF page 714).";
        regwidth = 16;
        field {
            name = "reserved";
            desc = "Reserved";
            sw = r; hw = w;
            reset = 0x0;
        } reserved_15_14[15:14];
        field {
            name = "cmd_index";
            desc = "Command index";
            sw = rw; hw = r;
            reset = 0x0;
        } cmd_index[13:8];
        field {
            name = "cmd_type";
            desc = "Command type
- 00: normal command
- 01: suspend command
- 10: resume command
- 11: abort command";
            sw = rw; hw = r;
            reset = 0x0;
        } cmd_type[7:6];
        field {
            name = "data_present_sel";
            desc = "Data transmission select
- 0: No data is transmitted.
- 1: Data is transmitted.";
            sw = rw; hw = r;
            reset = 0x0;
        } data_present_sel[5:5];
        field {
            name = "cmd_idx_chk_enable";
            desc = "Command ID check enable
- 0: disabled
- 1: enabled";
            sw = rw; hw = r;
            reset = 0x0;
        } cmd_idx_chk_enable[4:4];
        field {
            name = "cmd_crc_chk_enable";
            desc = "Command cyclic redundancy check (CRC) enable
- 0: disabled
- 1: enabled";
            sw = rw; hw = r;
            reset = 0x0;
        } cmd_crc_chk_enable[3:3];
        field {
            name = "sub_cmd_flag";
            desc = "Subcommand flag
- 0: main
- 1: subcommand";
            sw = rw; hw = r;
            reset = 0x0;
        } sub_cmd_flag[2:2];
        field {
            name = "resp_type_select";
            desc = "Response type
- 00: no response
- 01: response length 136
- 10: response length 48
- 11: response length 48 check";
            sw = rw; hw = r;
            reset = 0x0;
        } resp_type_select[1:0];
    } CMD_R @ 0xE;
    reg {
        name = "RESP01_R";
        desc = "RESP01_R is a RESP 0/1 register. (offset 0x10; total reset 0x00000000; PROVEN: Hi3516E V300 data sheet (Issue 00B06, 2019-05-15), section 12.4.4, PDF page 715).";
        field {
            name = "resp01";
            desc = "RESP 0/1 register. This register stores the content of the response bits [39:8] of the send command of the controller.";
            sw = r; hw = w;
            reset = 0x0;
        } resp01[31:0];
    } RESP01_R @ 0x10;
    reg {
        name = "RESP23_R";
        desc = "RESP23_R is a RESP 2/3 register. (offset 0x14; total reset 0x00000000; PROVEN: Hi3516E V300 data sheet (Issue 00B06, 2019-05-15), section 12.4.4, PDF page 715).";
        field {
            name = "resp23";
            desc = "RESP 2/3 register. This register stores the content of the response bits [71:40] of the send command of the controller.";
            sw = r; hw = w;
            reset = 0x0;
        } resp23[31:0];
    } RESP23_R @ 0x14;
    reg {
        name = "RESP45_R";
        desc = "RESP45_R is a RESP 4/5 register. (offset 0x18; total reset 0x00000000; PROVEN: Hi3516E V300 data sheet (Issue 00B06, 2019-05-15), section 12.4.4, PDF page 715).";
        field {
            name = "resp45";
            desc = "RESP 4/5 register. This register stores the content of the response bits [103:72] of the send command of the controller.";
            sw = r; hw = w;
            reset = 0x0;
        } resp45[31:0];
    } RESP45_R @ 0x18;
    reg {
        name = "RESP67_R";
        desc = "RESP67_R is a RESP 6/7 register. (offset 0x1C; total reset 0x00000000; PROVEN: Hi3516E V300 data sheet (Issue 00B06, 2019-05-15), section 12.4.4, PDF page 715).";
        field {
            name = "resp67";
            desc = "RESP 6/7 register. This register stores the content of the response bits [135:104] of the send command of the controller.";
            sw = r; hw = w;
            reset = 0x0;
        } resp67[31:0];
    } RESP67_R @ 0x1C;
    reg {
        name = "BUF_DATA_R";
        desc = "BUF_DATA_R is a buffer data register. (offset 0x20; total reset 0x00000000; PROVEN: Hi3516E V300 data sheet (Issue 00B06, 2019-05-15), section 12.4.4, PDF page 716).";
        field {
            name = "buf_data";
            desc = "In slave mode, the buffer used to store the RX data and TX data in the controller writes data to the card by continuously writing data to this register and read data from the card by continuously reading data in this register.";
            sw = rw; hw = r;
            reset = 0x0;
        } buf_data[31:0];
    } BUF_DATA_R @ 0x20;
    reg {
        name = "PSTATE_R";
        desc = "PSTATE_R is a current state register. (offset 0x24; total reset 0x00000000; PROVEN: Hi3516E V300 data sheet (Issue 00B06, 2019-05-15), section 12.4.4, PDF page 716).";
        field {
            name = "reserved";
            desc = "Reserved";
            sw = r; hw = w;
            reset = 0x0;
        } reserved_31_28[31:28];
        field {
            name = "cmd_issue_err";
            desc = "Command issuing error
- 0: There is no command issuing error.
- 1: The command cannot be issued.";
            sw = r; hw = w;
            reset = 0x0;
        } cmd_issue_err[27:27];
        field {
            name = "reserved";
            desc = "Reserved";
            sw = r; hw = w;
            reset = 0x0;
        } reserved_26_25[26:25];
        field {
            name = "cmd_line_lvl";
            desc = "Level state the command pin
- 0: low
- 1: high";
            sw = r; hw = w;
            reset = 0x0;
        } cmd_line_lvl[24:24];
        field {
            name = "sd_dat_in[3:0]";
            desc = "State of the data[3:0] pin, corresponding to each bit 0 The data pin is in low level.
- 1: The data pin is in high level.";
            sw = r; hw = w;
            reset = 0x0;
        } sd_dat_in_3_0[23:20];
        field {
            name = "reserved";
            desc = "Reserved";
            sw = r; hw = w;
            reset = 0x0;
        } reserved_19_19[19:19];
        field {
            name = "Card_detect_pin_lvl";
            desc = "Card_detect_npin state
- 0: The Card_detect_n pin is in low level.
- 1: The Card_detect_n pin is in high level.";
            sw = r; hw = w;
            reset = 0x0;
        } Card_detect_pin_lvl[18:18];
        field {
            name = "reserved";
            desc = "Reserved";
            sw = r; hw = w;
            reset = 0x0;
        } reserved_17_12[17:12];
        field {
            name = "buf_rd_enable";
            desc = "Buffer read enable
- 0: disabled";
            sw = r; hw = w;
            reset = 0x0;
        } buf_rd_enable[11:11];
        field {
            name = "buf_wr_enable";
            desc = "Buffer write enable
- 0: disabled
- 1: enabled";
            sw = r; hw = w;
            reset = 0x0;
        } buf_wr_enable[10:10];
        field {
            name = "Rd_xfer_active";
            desc = "Read transfer active
- 0: No data is transferred (idle state).
- 1: Data is being read.";
            sw = r; hw = w;
            reset = 0x0;
        } Rd_xfer_active[9:9];
        field {
            name = "Wr_xfer_active";
            desc = "Write transfer active
- 0: No data is transferred (idle state).
- 1: Data is being written.";
            sw = r; hw = w;
            reset = 0x0;
        } Wr_xfer_active[8:8];
        field {
            name = "sd_dat_in[7:4]";
            desc = "State of the data[7:4] pin, corresponding to each bit
- 0: The data pin is in low level.
- 1: The data pin is in high level.";
            sw = r; hw = w;
            reset = 0x0;
        } sd_dat_in_7_4[7:4];
        field {
            name = "reserved";
            desc = "Reserved";
            sw = r; hw = w;
            reset = 0x0;
        } reserved_3_3[3:3];
        field {
            name = "Dat_line_active";
            desc = "Data line active
- 0: No data is transmitted (idle state).
- 1: Data is being transmitted.";
            sw = r; hw = w;
            reset = 0x0;
        } Dat_line_active[2:2];
        field {
            name = "cmd_inhibit_dat";
            desc = "Flag indicating whether the command with data is active
- 0: No data is transmitted (idle state).

Commands with data can be transmitted.
- 1: Data line is transmitting data or the read operation is being valid.";
            sw = r; hw = w;
            reset = 0x0;
        } cmd_inhibit_dat[1:1];
        field {
            name = "cmd_inhibit";
            desc = "Data line active
- 0: idle state. The controller can send commands.
- 1: busy state. The controller cannot send commands.";
            sw = r; hw = w;
            reset = 0x0;
        } cmd_inhibit[0:0];
    } PSTATE_R @ 0x24;
    reg {
        name = "HOST_CTRL1_R";
        desc = "HOST_CTRL1_R is HOST control 1 register. (offset 0x28; total reset 0x00000000; PROVEN: Hi3516E V300 data sheet (Issue 00B06, 2019-05-15), section 12.4.4, PDF page 717).";
        regwidth = 8;
        field {
            name = "card_detect_sig_lvl";
            desc = "Card detection signal select";
            sw = rw; hw = r;
            reset = 0x0;
        } card_detect_sig_lvl[7:7];
        field {
            name = "card_detect_test_lvl";
            desc = "Test level for card detection
- 0: No card is inserted.
- 1: A card is inserted.";
            sw = rw; hw = r;
            reset = 0x0;
        } card_detect_test_lvl[6:6];
        field {
            name = "ext_dat_xfer";
            desc = "Bit width of the extended data transfer
- 0: selected by dat_xfer_width
- 1: 8 bits";
            sw = rw; hw = r;
            reset = 0x0;
        } ext_dat_xfer[5:5];
        field {
            name = "dma_sel";
            desc = "DMA select When Host Version 4 Enable in the HOST_CTRL2_R register is set to 1:
- 00: SDMA
- 01: reserved
- 10: ADMA2
- 11: ADMA2 or ADMA3

When Host Version 4 Enable in the HOST_CTRL2_R register is set to 0:
- 00: SDMA
- 01: reserved
- 10: 32-bit address ADMA2
- 11: 64-bit address ADMA2";
            sw = rw; hw = r;
            reset = 0x0;
        } dma_sel[4:3];
        field {
            name = "high_speed_en";
            desc = "High speed enable
- 0: normal speed
- 1: high speed";
            sw = rw; hw = r;
            reset = 0x0;
        } high_speed_en[2:2];
        field {
            name = "dat_xfer_width";
            desc = "TX data bit width
- 0: 1 bit
- 1: 4 bits";
            sw = rw; hw = r;
            reset = 0x0;
        } dat_xfer_width[1:1];
        field {
            name = "reserved";
            desc = "Reserved";
            sw = r; hw = w;
            reset = 0x0;
        } reserved_0_0[0:0];
    } HOST_CTRL1_R @ 0x28;
    reg {
        name = "PWR_CTRL_R";
        desc = "PWR_CTRL_R is a host basic configuration control register. (offset 0x29; total reset 0x00000000; PROVEN: Hi3516E V300 data sheet (Issue 00B06, 2019-05-15), section 12.4.4, PDF page 718).";
        regwidth = 8;
        field {
            name = "reserved";
            desc = "Reserved";
            sw = r; hw = w;
            reset = 0x0;
        } reserved_7_1[7:1];
        field {
            name = "sd_bus_pwr_vdd1";
            desc = "VDD2 power enable
- 0: powered off
- 1: powered on";
            sw = rw; hw = r;
            reset = 0x0;
        } sd_bus_pwr_vdd1[0:0];
    } PWR_CTRL_R @ 0x29;
    reg {
        name = "WUP_CTRL_R";
        desc = "WUP_CTRL_R is a wakeup control register. (offset 0x2B; total reset 0x00000020; PROVEN: Hi3516E V300 data sheet (Issue 00B06, 2019-05-15), section 12.4.4, PDF page 719).";
        regwidth = 8;
        field {
            name = "reserved";
            desc = "Reserved";
            sw = r; hw = w;
            reset = 0x0;
        } reserved_7_6[7:6];
        field {
            name = "sd_vdd1_on_polarity";
            desc = "sd_vdd1_on polarity control
- 0: positive
- 1: negative";
            sw = rw; hw = r;
            reset = 0x1;
        } sd_vdd1_on_polarity[5:5];
        field {
            name = "Write_prot_polarity";
            desc = "Write_protect polarity control
- 0: positive
- 1: negative";
            sw = rw; hw = r;
            reset = 0x0;
        } Write_prot_polarity[4:4];
        field {
            name = "card_detect_polarity";
            desc = "Card_detect polarity control
- 0: positive
- 1: negative";
            sw = rw; hw = r;
            reset = 0x0;
        } card_detect_polarity[3:3];
        field {
            name = "reserved";
            desc = "Reserved";
            sw = r; hw = w;
            reset = 0x0;
        } reserved_2_0[2:0];
    } WUP_CTRL_R @ 0x2B;
    reg {
        name = "CLK_CTRL_R";
        desc = "CLK_CTRL_R is a clock control register. (offset 0x2C; total reset 0x00000000; PROVEN: Hi3516E V300 data sheet (Issue 00B06, 2019-05-15), section 12.4.4, PDF page 719).";
        regwidth = 16;
        field {
            name = "reserved";
            desc = "Reserved";
            sw = r; hw = w;
            reset = 0x0;
        } reserved_15_4[15:4];
        field {
            name = "pll_enable";
            desc = "PLL enable
- 0: The PLL is in low power mode.
- 1: The PLL is enabled.";
            sw = rw; hw = r;
            reset = 0x0;
        } pll_enable[3:3];
        field {
            name = "sd_clk_en";
            desc = "SD/eMMC clock enable
- 0: disabled";
            sw = rw; hw = r;
            reset = 0x0;
        } sd_clk_en[2:2];
        field {
            name = "internal_clk_statable";
            desc = "Internal clock state
- 0: unstable
- 1: stable";
            sw = r; hw = w;
            reset = 0x0;
        } internal_clk_statable[1:1];
        field {
            name = "internal_clk_en";
            desc = "Internal clock enable
- 0: disabled
- 1: enabled";
            sw = rw; hw = r;
            reset = 0x1;
        } internal_clk_en[0:0];
    } CLK_CTRL_R @ 0x2C;
    reg {
        name = "TOUT_CTRL_R";
        desc = "TOUT_CTRL_R is a timeout control register. (offset 0x2E; total reset 0x00000000; PROVEN: Hi3516E V300 data sheet (Issue 00B06, 2019-05-15), section 12.4.4, PDF page 720).";
        regwidth = 8;
        field {
            name = "reserved";
            desc = "Reserved";
            sw = r; hw = w;
            reset = 0x0;
        } reserved_7_4[7:4];
        field {
            name = "tout_cnt";
            desc = "Data timeout count
- 0x0: TMCLK x 2^13
- 0xe: TMCLK x 2^27

Other values: reserved";
            sw = rw; hw = r;
            reset = 0x0;
        } tout_cnt[3:0];
    } TOUT_CTRL_R @ 0x2E;
    reg {
        name = "SW_RST_R";
        desc = "SW_RST_R is a soft reset control register. (offset 0x2F; total reset 0x00000000; PROVEN: Hi3516E V300 data sheet (Issue 00B06, 2019-05-15), section 12.4.4, PDF page 720).";
        regwidth = 8;
        field {
            name = "reserved";
            desc = "Reserved";
            sw = r; hw = w;
            reset = 0x0;
        } reserved_7_3[7:3];
        field {
            name = "sw_rst_dat";
            desc = "Data line request for soft reset
- 0: reset deasserted
- 1: reset";
            sw = rw; hw = r;
            reset = 0x0;
        } sw_rst_dat[2:2];
        field {
            name = "sw_rst_cmd";
            desc = "Command line request for soft reset
- 0: reset deasserted
- 1: reset";
            sw = rw; hw = r;
            reset = 0x0;
        } sw_rst_cmd[1:1];
        field {
            name = "sw_rst_all";
            desc = "Controller request for soft reset
- 0: reset deasserted";
            sw = rw; hw = r;
            reset = 0x0;
        } sw_rst_all[0:0];
    } SW_RST_R @ 0x2F;
    reg {
        name = "NORMAL_INT_STAT_R";
        desc = "NORMAL_INT_STAT_R is a normal interrupt status register. (offset 0x30; total reset 0x00000000; PROVEN: Hi3516E V300 data sheet (Issue 00B06, 2019-05-15), section 12.4.4, PDF page 721).";
        regwidth = 16;
        field {
            name = "err_interrupt";
            desc = "Error interrupt status
- 0: No interrupt is generated.
- 1: An interrupt is generated.";
            sw = r; hw = w;
            reset = 0x0;
        } err_interrupt[15:15];
        field {
            name = "reserved";
            desc = "Reserved";
            sw = r; hw = w;
            reset = 0x0;
        } reserved_14_14[14:14];
        field {
            name = "fx_event";
            desc = "TX event interrupt status
- 0: No interrupt is generated.
- 1: An interrupt is generated.";
            sw = r; hw = w;
            reset = 0x0;
        } fx_event[13:13];
        field {
            name = "re_tune_event";
            desc = "Retuning event interrupt status
- 0: No interrupt is generated.
- 1: An interrupt is generated.";
            sw = r; hw = w;
            reset = 0x0;
        } re_tune_event[12:12];
        field {
            name = "int_c";
            desc = "INT_C interrupt status
- 0: No interrupt is generated.
- 1: An interrupt is generated.";
            sw = r; hw = w;
            reset = 0x0;
        } int_c[11:11];
        field {
            name = "int_b";
            desc = "INT_B interrupt status
- 0: No interrupt is generated.
- 1: An interrupt is generated.";
            sw = r; hw = w;
            reset = 0x0;
        } int_b[10:10];
        field {
            name = "int_a";
            desc = "INT_A interrupt status
- 0: No interrupt is generated.
- 1: An interrupt is generated.";
            sw = r; hw = w;
            reset = 0x0;
        } int_a[9:9];
        field {
            name = "card_interrupt";
            desc = "Card interrupt status
- 0: No interrupt is generated.
- 1: An interrupt is generated.";
            sw = r; hw = w;
            reset = 0x0;
        } card_interrupt[8:8];
        field {
            name = "card_removal";
            desc = "Card remove interrupt status
- 0: No interrupt is generated.
- 1: An interrupt is generated.

Access type WC in the data sheet: written 1 clears the bit.";
            sw = rw; hw = w; onwrite = woclr;
            reset = 0x0;
        } card_removal[7:7];
        field {
            name = "card_insertion";
            desc = "Card insertion interrupt status
- 0: No interrupt is generated.

Access type WC in the data sheet: written 1 clears the bit.";
            sw = rw; hw = w; onwrite = woclr;
            reset = 0x0;
        } card_insertion[6:6];
        field {
            name = "buf_rd_ready";
            desc = "Ready interrupt status for buffer read
- 0: No interrupt is generated.
- 1: An interrupt is generated.

Access type WC in the data sheet: written 1 clears the bit.";
            sw = rw; hw = w; onwrite = woclr;
            reset = 0x0;
        } buf_rd_ready[5:5];
        field {
            name = "buf_wr_ready";
            desc = "Ready interrupt status for buffer write
- 0: No interrupt is generated.
- 1: An interrupt is generated.

Access type WC in the data sheet: written 1 clears the bit.";
            sw = rw; hw = w; onwrite = woclr;
            reset = 0x0;
        } buf_wr_ready[4:4];
        field {
            name = "dma_interrupt";
            desc = "DMA interrupt status
- 0: No interrupt is generated.
- 1: An interrupt is generated.

Access type WC in the data sheet: written 1 clears the bit.";
            sw = rw; hw = w; onwrite = woclr;
            reset = 0x0;
        } dma_interrupt[3:3];
        field {
            name = "bgap_event";
            desc = "Block gap event interrupt due to a request stop
- 0: No interrupt is generated.
- 1: An interrupt is generated.

Access type WC in the data sheet: written 1 clears the bit.";
            sw = rw; hw = w; onwrite = woclr;
            reset = 0x0;
        } bgap_event[2:2];
        field {
            name = "xfer_comlete";
            desc = "Read/write transfer completion interrupt status
- 0: No interrupt is generated.
- 1: An interrupt is generated.

Access type WC in the data sheet: written 1 clears the bit.";
            sw = rw; hw = w; onwrite = woclr;
            reset = 0x0;
        } xfer_comlete[1:1];
        field {
            name = "cmd_complete";
            desc = "Command completion interrupt status
- 0: No interrupt is generated.
- 1: An interrupt is generated.

Access type WC in the data sheet: written 1 clears the bit.";
            sw = rw; hw = w; onwrite = woclr;
            reset = 0x0;
        } cmd_complete[0:0];
    } NORMAL_INT_STAT_R @ 0x30;
    reg {
        name = "ERROR_INT_STAT_R";
        desc = "ERROR_INT_STAT_R is an error interrupt status register. (offset 0x32; total reset 0x00000000; PROVEN: Hi3516E V300 data sheet (Issue 00B06, 2019-05-15), section 12.4.4, PDF page 722).";
        regwidth = 16;
        field {
            name = "vendor_err3";
            desc = "Reserved";
            sw = r; hw = w;
            reset = 0x0;
        } vendor_err3[15:15];
        field {
            name = "vendor_err2";
            desc = "Reserved";
            sw = r; hw = w;
            reset = 0x0;
        } vendor_err2[14:14];
        field {
            name = "vendor_err1";
            desc = "Reserved";
            sw = r; hw = w;
            reset = 0x0;
        } vendor_err1[13:13];
        field {
            name = "boot_ack_err";
            desc = "Boot acknowledgement error interrupt, used only in eMMC mode
- 0: No interrupt is generated.
- 1: An interrupt is generated.

Access type WC in the data sheet: written 1 clears the bit.";
            sw = rw; hw = w; onwrite = woclr;
            reset = 0x0;
        } boot_ack_err[12:12];
        field {
            name = "resp_err";
            desc = "Response error interrupt, used only in SD card mode

Access type WC in the data sheet: written 1 clears the bit.";
            sw = rw; hw = w; onwrite = woclr;
            reset = 0x0;
        } resp_err[11:11];
        field {
            name = "reserved";
            desc = "Reserved";
            sw = r; hw = w;
            reset = 0x0;
        } reserved_10_10[10:10];
        field {
            name = "adma_err";
            desc = "ADMA error interrupt, that is, response to a system bus error, or invalid ADMA 2/3 descriptor
- 0: No interrupt is generated.
- 1: An interrupt is generated.

Access type WC in the data sheet: written 1 clears the bit.";
            sw = rw; hw = w; onwrite = woclr;
            reset = 0x0;
        } adma_err[9:9];
        field {
            name = "auto_cmd_err";
            desc = "Interrupt status of an auto command error
- 0: No interrupt is generated.
- 1: An interrupt is generated.

Access type WC in the data sheet: written 1 clears the bit.";
            sw = rw; hw = w; onwrite = woclr;
            reset = 0x0;
        } auto_cmd_err[8:8];
        field {
            name = "cur_lmt_err";
            desc = "Interrupt status of a current limit error
- 0: No interrupt is generated.
- 1: An interrupt is generated.

Access type WC in the data sheet: written 1 clears the bit.";
            sw = rw; hw = w; onwrite = woclr;
            reset = 0x0;
        } cur_lmt_err[7:7];
        field {
            name = "data_end_bit_err";
            desc = "Interrupt status of a data end bit error
- 0: No interrupt is generated.
- 1: An interrupt is generated.

Access type WC in the data sheet: written 1 clears the bit.";
            sw = rw; hw = w; onwrite = woclr;
            reset = 0x0;
        } data_end_bit_err[6:6];
        field {
            name = "data_crc_err";
            desc = "Interrupt status of a data CRC error
- 0: No interrupt is generated.
- 1: An interrupt is generated.

Access type WC in the data sheet: written 1 clears the bit.";
            sw = rw; hw = w; onwrite = woclr;
            reset = 0x0;
        } data_crc_err[5:5];
        field {
            name = "data_tout_err";
            desc = "Interrupt status of a data timeout error
- 0: No interrupt is generated.
- 1: An interrupt is generated.

Access type WC in the data sheet: written 1 clears the bit.";
            sw = rw; hw = w; onwrite = woclr;
            reset = 0x0;
        } data_tout_err[4:4];
        field {
            name = "cmd_idx_err";
            desc = "Interrupt status of a command index error
- 0: No interrupt is generated.
- 1: An interrupt is generated.

Access type WC in the data sheet: written 1 clears the bit.";
            sw = rw; hw = w; onwrite = woclr;
            reset = 0x0;
        } cmd_idx_err[3:3];
        field {
            name = "cmd_end_bit_err";
            desc = "Interrupt status of a command end bit error
- 0: No interrupt is generated.
- 1: An interrupt is generated.

Access type WC in the data sheet: written 1 clears the bit.";
            sw = rw; hw = w; onwrite = woclr;
            reset = 0x0;
        } cmd_end_bit_err[2:2];
        field {
            name = "cmd_crc_err";
            desc = "Interrupt status of a command CRC error
- 0: No interrupt is generated.
- 1: An interrupt is generated.

Access type WC in the data sheet: written 1 clears the bit.";
            sw = rw; hw = w; onwrite = woclr;
            reset = 0x0;
        } cmd_crc_err[1:1];
        field {
            name = "cmd_tout_err";
            desc = "Interrupt status of a command timeout error
- 0: No interrupt is generated.
- 1: An interrupt is generated.

Access type WC in the data sheet: written 1 clears the bit.";
            sw = rw; hw = w; onwrite = woclr;
            reset = 0x0;
        } cmd_tout_err[0:0];
    } ERROR_INT_STAT_R @ 0x32;
    reg {
        name = "NORMAL_INT_STAT_EN_R";
        desc = "NORMAL_INT_STAT_EN_R is a normal interrupt status enable register. (offset 0x34; total reset 0x00000000; PROVEN: Hi3516E V300 data sheet (Issue 00B06, 2019-05-15), section 12.4.4, PDF page 724).";
        regwidth = 16;
        field {
            name = "reserved";
            desc = "Reserved";
            sw = r; hw = w;
            reset = 0x0;
        } reserved_15_15[15:15];
        field {
            name = "cqe_event_stat_en";
            desc = "CMD event interrupt status enable
- 0: disabled
- 1: enabled";
            sw = rw; hw = r;
            reset = 0x0;
        } cqe_event_stat_en[14:14];
        field {
            name = "fx_event_stat_en";
            desc = "TX event interrupt status enable
- 0: disabled
- 1: enabled";
            sw = rw; hw = r;
            reset = 0x0;
        } fx_event_stat_en[13:13];
        field {
            name = "re_tune_event_stat_en";
            desc = "Retuning event interrupt status enable
- 0: disabled
- 1: enabled";
            sw = rw; hw = r;
            reset = 0x0;
        } re_tune_event_stat_en[12:12];
        field {
            name = "int_c_stat_en";
            desc = "INT_C interrupt status enable
- 0: disabled
- 1: enabled";
            sw = rw; hw = r;
            reset = 0x0;
        } int_c_stat_en[11:11];
        field {
            name = "int_b_stat_en";
            desc = "INT_B interrupt status enable
- 0: disabled
- 1: enabled";
            sw = rw; hw = r;
            reset = 0x0;
        } int_b_stat_en[10:10];
        field {
            name = "int_a_stat_en";
            desc = "INT_A interrupt status enable
- 0: disabled
- 1: enabled";
            sw = rw; hw = r;
            reset = 0x0;
        } int_a_stat_en[9:9];
        field {
            name = "card_interrupt_stat_en";
            desc = "Card interrupt status enable
- 0: disabled
- 1: enabled";
            sw = rw; hw = r;
            reset = 0x0;
        } card_interrupt_stat_en[8:8];
        field {
            name = "card_removal_stat_en";
            desc = "Card remove interrupt enable
- 0: disabled
- 1: enabled";
            sw = rw; hw = r;
            reset = 0x0;
        } card_removal_stat_en[7:7];
        field {
            name = "card_insertion_stat_en";
            desc = "Card insertion interrupt enable
- 0: disabled
- 1: enabled";
            sw = rw; hw = r;
            reset = 0x0;
        } card_insertion_stat_en[6:6];
        field {
            name = "buf_rd_ready_stat_en";
            desc = "Ready interrupt enable for buffer read
- 0: disabled
- 1: enabled";
            sw = rw; hw = r;
            reset = 0x0;
        } buf_rd_ready_stat_en[5:5];
        field {
            name = "buf_wr_ready_stat_en";
            desc = "Ready interrupt enable for buffer write
- 0: disabled
- 1: enabled";
            sw = rw; hw = r;
            reset = 0x0;
        } buf_wr_ready_stat_en[4:4];
        field {
            name = "dma_interrupt_stat_en";
            desc = "DMA interrupt enable
- 0: disabled
- 1: enabled";
            sw = rw; hw = r;
            reset = 0x0;
        } dma_interrupt_stat_en[3:3];
        field {
            name = "bgap_event_stat_en";
            desc = "Block gap event interrupt enable due to request stop
- 0: disabled
- 1: enabled";
            sw = rw; hw = r;
            reset = 0x0;
        } bgap_event_stat_en[2:2];
        field {
            name = "xfer_comlete_stat_en";
            desc = "Interrupt status enable for read/write transfer completion
- 0: disabled
- 1: enabled";
            sw = rw; hw = r;
            reset = 0x0;
        } xfer_comlete_stat_en[1:1];
        field {
            name = "cmd_complete_stat_en";
            desc = "Interrupt status enable for command completion
- 0: disabled
- 1: enabled";
            sw = rw; hw = r;
            reset = 0x0;
        } cmd_complete_stat_en[0:0];
    } NORMAL_INT_STAT_EN_R @ 0x34;
    reg {
        name = "ERROR_INT_STAT_EN_R";
        desc = "ERROR_INT_STAT_EN_R is an error interrupt status enable register. (offset 0x36; total reset 0x00000000; PROVEN: Hi3516E V300 data sheet (Issue 00B06, 2019-05-15), section 12.4.4, PDF page 725).";
        regwidth = 16;
        field {
            name = "vendor_err_stat_en3";
            desc = "Reserved";
            sw = rw; hw = r;
            reset = 0x0;
        } vendor_err_stat_en3[15:15];
        field {
            name = "vendor_err_stat_en2";
            desc = "Reserved";
            sw = rw; hw = r;
            reset = 0x0;
        } vendor_err_stat_en2[14:14];
        field {
            name = "vendor_err_stat_en1";
            desc = "Reserved";
            sw = rw; hw = r;
            reset = 0x0;
        } vendor_err_stat_en1[13:13];
        field {
            name = "boot_ack_err_stat_en";
            desc = "Interrupt status enable for a boot acknowledgement error, used only in eMMC mode
- 0: disabled
- 1: enabled";
            sw = rw; hw = r;
            reset = 0x0;
        } boot_ack_err_stat_en[12:12];
        field {
            name = "resp_err_stat_en";
            desc = "Interrupt status enable for a response error, used only in SD card mode
- 0: disabled";
            sw = rw; hw = r;
            reset = 0x0;
        } resp_err_stat_en[11:11];
        field {
            name = "reserved";
            desc = "Reserved";
            sw = r; hw = w;
            reset = 0x0;
        } reserved_10_10[10:10];
        field {
            name = "adma_err_stat_en";
            desc = "Interrupt status enable for a timing error Response to a system bus error, or invalid ADMA 2/3 descriptor
- 0: disabled
- 1: enabled";
            sw = rw; hw = r;
            reset = 0x0;
        } adma_err_stat_en[9:9];
        field {
            name = "auto_cmd_err_stat_en";
            desc = "Interrupt status enable for an auto command error
- 0: disabled
- 1: enabled";
            sw = rw; hw = r;
            reset = 0x0;
        } auto_cmd_err_stat_en[8:8];
        field {
            name = "cur_lmt_err_stat_en";
            desc = "Interrupt status enable for a current limit error
- 0: disabled
- 1: enabled";
            sw = rw; hw = r;
            reset = 0x0;
        } cur_lmt_err_stat_en[7:7];
        field {
            name = "data_end_bit_err_stat_en";
            desc = "Interrupt status enable for a data end bit error
- 0: disabled
- 1: enabled";
            sw = rw; hw = r;
            reset = 0x0;
        } data_end_bit_err_stat_en[6:6];
        field {
            name = "data_crc_err_stat_en";
            desc = "Interrupt status enable for a data CRC error
- 0: disabled
- 1: enabled";
            sw = rw; hw = r;
            reset = 0x0;
        } data_crc_err_stat_en[5:5];
        field {
            name = "data_tout_err_stat_en";
            desc = "Interrupt status enable for a data timeout error
- 0: disabled
- 1: enabled";
            sw = rw; hw = r;
            reset = 0x0;
        } data_tout_err_stat_en[4:4];
        field {
            name = "cmd_idx_err_stat_en";
            desc = "Interrupt status enable for a command index error
- 0: disabled
- 1: enabled";
            sw = rw; hw = r;
            reset = 0x0;
        } cmd_idx_err_stat_en[3:3];
        field {
            name = "cmd_end_bit_err_stat_en";
            desc = "Interrupt status enable for a command end bit error
- 0: disabled
- 1: enabled";
            sw = rw; hw = r;
            reset = 0x0;
        } cmd_end_bit_err_stat_en[2:2];
        field {
            name = "cmd_crc_err_stat_en";
            desc = "Interrupt status enable for a command CRC error
- 0: disabled
- 1: enabled";
            sw = rw; hw = r;
            reset = 0x0;
        } cmd_crc_err_stat_en[1:1];
        field {
            name = "cmd_tout_err_stat_en";
            desc = "Interrupt status enable for a command timeout error";
            sw = rw; hw = r;
            reset = 0x0;
        } cmd_tout_err_stat_en[0:0];
    } ERROR_INT_STAT_EN_R @ 0x36;
    reg {
        name = "NORMAL_INT_SIGNAL_EN_R";
        desc = "NORMAL_INT_SIGNAL_EN_R is a normal interrupt signal enable register. (offset 0x38; total reset 0x00000000; PROVEN: Hi3516E V300 data sheet (Issue 00B06, 2019-05-15), section 12.4.4, PDF page 727).";
        regwidth = 16;
        field {
            name = "reserved";
            desc = "Reserved";
            sw = r; hw = w;
            reset = 0x0;
        } reserved_15_15[15:15];
        field {
            name = "cqe_event_signal_en";
            desc = "CMD event interrupt signal enable
- 0: disabled
- 1: enabled";
            sw = rw; hw = r;
            reset = 0x0;
        } cqe_event_signal_en[14:14];
        field {
            name = "fx_event_signal_en";
            desc = "TX event interrupt signal enable
- 0: disabled
- 1: enabled";
            sw = rw; hw = r;
            reset = 0x0;
        } fx_event_signal_en[13:13];
        field {
            name = "re_tune_event_signal_en";
            desc = "Retuning event interrupt signal enable
- 0: disabled
- 1: enabled";
            sw = rw; hw = r;
            reset = 0x0;
        } re_tune_event_signal_en[12:12];
        field {
            name = "int_c_signal_en";
            desc = "INT_C interrupt signal enable
- 0: disabled
- 1: enabled";
            sw = rw; hw = r;
            reset = 0x0;
        } int_c_signal_en[11:11];
        field {
            name = "int_b_signal_en";
            desc = "INT_B interrupt signal enable
- 0: disabled
- 1: enabled";
            sw = rw; hw = r;
            reset = 0x0;
        } int_b_signal_en[10:10];
        field {
            name = "int_a_signal_en";
            desc = "INT_A interrupt signal enable
- 0: disabled
- 1: enabled";
            sw = rw; hw = r;
            reset = 0x0;
        } int_a_signal_en[9:9];
        field {
            name = "card_interrupt_signal_en";
            desc = "Card interrupt signal enable
- 0: disabled
- 1: enabled";
            sw = rw; hw = r;
            reset = 0x0;
        } card_interrupt_signal_en[8:8];
        field {
            name = "card_removal_signal_en";
            desc = "Card remove interrupt signal enable
- 0: disabled
- 1: enabled";
            sw = rw; hw = r;
            reset = 0x0;
        } card_removal_signal_en[7:7];
        field {
            name = "card_insertion_signal";
            desc = "Card insertion interrupt signal enable";
            sw = rw; hw = r;
            reset = 0x0;
        } card_insertion_signal[6:6];
        field {
            name = "buf_rd_ready_signal_en";
            desc = "Ready signal enable for buffer read
- 0: disabled
- 1: enabled";
            sw = rw; hw = r;
            reset = 0x0;
        } buf_rd_ready_signal_en[5:5];
        field {
            name = "buf_wr_ready_signal_en";
            desc = "Ready signal enable for buffer write
- 0: disabled
- 1: enabled";
            sw = rw; hw = r;
            reset = 0x0;
        } buf_wr_ready_signal_en[4:4];
        field {
            name = "dma_interrupt_signal_en";
            desc = "DMA interrupt signal enable
- 0: disabled
- 1: enabled";
            sw = rw; hw = r;
            reset = 0x0;
        } dma_interrupt_signal_en[3:3];
        field {
            name = "bgap_event_signal_en";
            desc = "Block gap event interrupt signal enable due to request stop
- 0: disabled
- 1: enabled";
            sw = rw; hw = r;
            reset = 0x0;
        } bgap_event_signal_en[2:2];
        field {
            name = "xfer_comlete_signal_en";
            desc = "Interrupt signal enable for read/write transfer completion
- 0: disabled
- 1: enabled";
            sw = rw; hw = r;
            reset = 0x0;
        } xfer_comlete_signal_en[1:1];
        field {
            name = "cmd_complete_signal_en";
            desc = "Interrupt signal enable for command completion
- 0: disabled
- 1: enabled";
            sw = rw; hw = r;
            reset = 0x0;
        } cmd_complete_signal_en[0:0];
    } NORMAL_INT_SIGNAL_EN_R @ 0x38;
    reg {
        name = "ERROR_INT_SIGNAL_EN_R";
        desc = "ERROR_INT_SIGNAL_EN_R is an error interrupt signal enable register. (offset 0x3A; total reset 0x00000000; PROVEN: Hi3516E V300 data sheet (Issue 00B06, 2019-05-15), section 12.4.4, PDF page 728).";
        regwidth = 16;
        field {
            name = "vendor_err_signal_en3";
            desc = "Reserved";
            sw = rw; hw = r;
            reset = 0x0;
        } vendor_err_signal_en3[15:15];
        field {
            name = "vendor_err_signal_en2";
            desc = "Reserved";
            sw = rw; hw = r;
            reset = 0x0;
        } vendor_err_signal_en2[14:14];
        field {
            name = "vendor_err_signal_en1";
            desc = "Reserved";
            sw = rw; hw = r;
            reset = 0x0;
        } vendor_err_signal_en1[13:13];
        field {
            name = "boot_ack_err_signal_en";
            desc = "Interrupt signal enable for a boot acknowledgement error, used only in eMMC mode
- 0: disabled
- 1: enabled";
            sw = rw; hw = r;
            reset = 0x0;
        } boot_ack_err_signal_en[12:12];
        field {
            name = "resp_err_signal_en";
            desc = "Interrupt signal enable for a response error, used only in SD card mode
- 0: disabled
- 1: enabled";
            sw = rw; hw = r;
            reset = 0x0;
        } resp_err_signal_en[11:11];
        field {
            name = "reserved";
            desc = "Reserved";
            sw = r; hw = w;
            reset = 0x0;
        } reserved_10_10[10:10];
        field {
            name = "adma_err_signal_en";
            desc = "Interrupt signal enable for an ADMA error, that is, response to a system bus error, or invalid ADMA 2/3 descriptor
- 0: disabled
- 1: enabled";
            sw = rw; hw = r;
            reset = 0x0;
        } adma_err_signal_en[9:9];
        field {
            name = "auto_cmd_err_signal_en";
            desc = "Interrupt signal enable for an auto command error
- 0: disabled
- 1: enabled";
            sw = rw; hw = r;
            reset = 0x0;
        } auto_cmd_err_signal_en[8:8];
        field {
            name = "cur_lmt_err_signal_en";
            desc = "Interrupt signal enable for a current limit error
- 0: disabled
- 1: enabled";
            sw = rw; hw = r;
            reset = 0x0;
        } cur_lmt_err_signal_en[7:7];
        field {
            name = "data_end_bit_err_signal_en";
            desc = "Interrupt signal enable for a data end bit error
- 0: disabled
- 1: enabled";
            sw = rw; hw = r;
            reset = 0x0;
        } data_end_bit_err_signal_en[6:6];
        field {
            name = "data_crc_err_signal_en";
            desc = "Interrupt signal enable for a data CRC error
- 0: disabled
- 1: enabled";
            sw = rw; hw = r;
            reset = 0x0;
        } data_crc_err_signal_en[5:5];
        field {
            name = "data_tout_err_signal_en";
            desc = "Interrupt signal enable for a data timeout error
- 0: disabled
- 1: enabled";
            sw = rw; hw = r;
            reset = 0x0;
        } data_tout_err_signal_en[4:4];
        field {
            name = "cmd_idx_err_signal_en";
            desc = "Interrupt signal enable for a command index error
- 0: disabled
- 1: enabled";
            sw = rw; hw = r;
            reset = 0x0;
        } cmd_idx_err_signal_en[3:3];
        field {
            name = "cmd_end_bit_err_signal_en";
            desc = "Interrupt signal enable for a command end bit error";
            sw = rw; hw = r;
            reset = 0x0;
        } cmd_end_bit_err_signal_en[2:2];
        field {
            name = "cmd_crc_err_signal_en";
            desc = "Interrupt signal enable for a command CRC error
- 0: disabled
- 1: enabled";
            sw = rw; hw = r;
            reset = 0x0;
        } cmd_crc_err_signal_en[1:1];
        field {
            name = "cmd_tout_err_signal_en";
            desc = "Interrupt signal enable for a command timeout error
- 0: disabled
- 1: enabled";
            sw = rw; hw = r;
            reset = 0x0;
        } cmd_tout_err_signal_en[0:0];
    } ERROR_INT_SIGNAL_EN_R @ 0x3A;
    reg {
        name = "AUTO_CMD_STAT_R";
        desc = "AUTO_CMD_STAT_R is an auto command status register. (offset 0x3C; total reset 0x00000000; PROVEN: Hi3516E V300 data sheet (Issue 00B06, 2019-05-15), section 12.4.4, PDF page 730).";
        regwidth = 16;
        field {
            name = "reserved";
            desc = "Reserved";
            sw = r; hw = w;
            reset = 0x0;
        } reserved_15_8[15:8];
        field {
            name = "cmd_not_issued_auto_cmd12";
            desc = "Subsequent command sending status when an auto CMD12 error occurs
- 0: No error occurs.
- 1: The CMD is not sent through the data line.";
            sw = r; hw = w;
            reset = 0x0;
        } cmd_not_issued_auto_cmd12[7:7];
        field {
            name = "reserved";
            desc = "Reserved";
            sw = r; hw = w;
            reset = 0x0;
        } reserved_6_6[6:6];
        field {
            name = "auto_cmd_resp_err";
            desc = "Auto CMD response status
- 0: No error occurs.
- 1: An error occurs.";
            sw = r; hw = w;
            reset = 0x0;
        } auto_cmd_resp_err[5:5];
        field {
            name = "auto_cmd_idx_err";
            desc = "Auto CMD index status
- 0: No error occurs.
- 1: An error occurs.";
            sw = r; hw = w;
            reset = 0x0;
        } auto_cmd_idx_err[4:4];
        field {
            name = "auto_cmd_endbit_err";
            desc = "Auto CMD end bit status
- 0: No error occurs.
- 1: An error occurs.";
            sw = r; hw = w;
            reset = 0x0;
        } auto_cmd_endbit_err[3:3];
        field {
            name = "auto_cmd_crc_err";
            desc = "Auto CMD CRC status
- 0: No error occurs.
- 1: An error occurs.";
            sw = r; hw = w;
            reset = 0x0;
        } auto_cmd_crc_err[2:2];
        field {
            name = "auto_cmd_tout_err";
            desc = "Auto CMD timeout status";
            sw = r; hw = w;
            reset = 0x0;
        } auto_cmd_tout_err[1:1];
        field {
            name = "auto_cmd12_not_exec";
            desc = "Auto CMD12 execution status
- 0: executed
- 1: not executed";
            sw = r; hw = w;
            reset = 0x0;
        } auto_cmd12_not_exec[0:0];
    } AUTO_CMD_STAT_R @ 0x3C;
    reg {
        name = "HOST_CTRL2_R";
        desc = "HOST_CTRL2_R is host control 2 register. (offset 0x3E; total reset 0x00000000; PROVEN: Hi3516E V300 data sheet (Issue 00B06, 2019-05-15), section 12.4.4, PDF page 731).";
        regwidth = 16;
        field {
            name = "preset_val_enable";
            desc = "Automatic select enable of the preset value
- 0: disabled. The SDCLK and drive capability are controlled by the driver.
- 1: enabled";
            sw = rw; hw = r;
            reset = 0x0;
        } preset_val_enable[15:15];
        field {
            name = "async_int_enable";
            desc = "Asynchronization interrupt enable
- 0: disabled
- 1: enabled";
            sw = rw; hw = r;
            reset = 0x0;
        } async_int_enable[14:14];
        field {
            name = "addressing";
            desc = "64-bit address enable for the bus
- 0: disable. A 32-bit address is used.
- 1: enabled. A 64-bit address is used.";
            sw = rw; hw = r;
            reset = 0x0;
        } addressing[13:13];
        field {
            name = "host_ver4_enable";
            desc = "Controller version 4.0 enable
- 0: version 3.0
- 1: version 4.0";
            sw = rw; hw = r;
            reset = 0x0;
        } host_ver4_enable[12:12];
        field {
            name = "cmd23_enable";
            desc = "CMD23 enable
- 0: disabled
- 1: enabled";
            sw = rw; hw = r;
            reset = 0x0;
        } cmd23_enable[11:11];
        field {
            name = "adma2_len_mode";
            desc = "ADMA2 length
- 0: 16-bit data length
- 1: 26-bit data length";
            sw = rw; hw = r;
            reset = 0x0;
        } adma2_len_mode[10:10];
        field {
            name = "reserved";
            desc = "Reserved";
            sw = r; hw = w;
            reset = 0x0;
        } reserved_9_8[9:8];
        field {
            name = "sample_clk_sel";
            desc = "Sample clock select
- 0: fixed clock
- 1: tuned clock";
            sw = rw; hw = r;
            reset = 0x0;
        } sample_clk_sel[7:7];
        field {
            name = "exec_tuning";
            desc = "Tuning execution. After the operation is complete, this register is automatically cleared and set to 0.
- 0: Tuning is not executed or has been executed.
- 1: Tuning is executed.";
            sw = rw; hw = r;
            reset = 0x0;
        } exec_tuning[6:6];
        field {
            name = "drv_strength_sel";
            desc = "Drive capability select
- 00:TYPEB
- 01: TYPEA
- 10: TYPEC
- 11: TYPED";
            sw = rw; hw = r;
            reset = 0x0;
        } drv_strength_sel[5:4];
        field {
            name = "reserved";
            desc = "Reserved";
            sw = r; hw = w;
            reset = 0x0;
        } reserved_3_3[3:3];
        field {
            name = "uhs_mode_sel";
            desc = "eMMC mode
- 000: legacy
- 001: high speed SDR
- 011: HS200
- 111: HS400

Other values: reserved";
            sw = rw; hw = r;
            reset = 0x0;
        } uhs_mode_sel[2:0];
    } HOST_CTRL2_R @ 0x3E;
    reg {
        name = "CAPABILITIES1_R";
        desc = "CAPABILITIES1_R is capabilities 1 register. (offset 0x40; total reset 0x3F6E0181; PROVEN: Hi3516E V300 data sheet (Issue 00B06, 2019-05-15), section 12.4.4, PDF page 732).";
        field {
            name = "slot_type_r";
            desc = "Slot type
- 00: removable card slot
- 01: embedded slot
- 10: shared bus slot, used in SD card mode
- 11: UHS2 (not supported currently)";
            sw = r; hw = w;
            reset = 0x0;
        } slot_type_r[31:30];
        field {
            name = "async_int_support";
            desc = "Whether the synchronization interrupt is supported
- 0: not supported
- 1: supported";
            sw = r; hw = w;
            reset = 0x1;
        } async_int_support[29:29];
        field {
            name = "sys_addr_64_v3";
            desc = "Whether the 64-bit system is supported by version 3.0
- 0: not supported";
            sw = r; hw = w;
            reset = 0x1;
        } sys_addr_64_v3[28:28];
        field {
            name = "sys_addr_64_v4";
            desc = "Whether the 64-bit system is supported by version 4.0
- 0: not supported
- 1: supported";
            sw = r; hw = w;
            reset = 0x1;
        } sys_addr_64_v4[27:27];
        field {
            name = "volt_18";
            desc = "Whether the 1.8 V voltage is supported
- 0: not supported
- 1: supported";
            sw = r; hw = w;
            reset = 0x1;
        } volt_18[26:26];
        field {
            name = "volt_30";
            desc = "Whether the 3.0 V voltage is supported
- 0: not supported
- 1: supported";
            sw = r; hw = w;
            reset = 0x1;
        } volt_30[25:25];
        field {
            name = "volt_33";
            desc = "Whether the 3.3 V voltage is supported
- 0: not supported
- 1: supported";
            sw = r; hw = w;
            reset = 0x1;
        } volt_33[24:24];
        field {
            name = "sus_res_support";
            desc = "Whether pausing and resuming are supported
- 0: not supported
- 1: supported";
            sw = r; hw = w;
            reset = 0x0;
        } sus_res_support[23:23];
        field {
            name = "sdma_support";
            desc = "Whether the SDMA is supported
- 0: not supported
- 1: supported";
            sw = r; hw = w;
            reset = 0x1;
        } sdma_support[22:22];
        field {
            name = "high_speed_support";
            desc = "Whether a high speed is supported
- 0: not supported
- 1: supported";
            sw = r; hw = w;
            reset = 0x1;
        } high_speed_support[21:21];
        field {
            name = "reserved";
            desc = "Reserved";
            sw = r; hw = w;
            reset = 0x0;
        } reserved_20_20[20:20];
        field {
            name = "adma2_support";
            desc = "Whether ADMA2 is supported
- 0: not supported
- 1: supported";
            sw = r; hw = w;
            reset = 0x1;
        } adma2_support[19:19];
        field {
            name = "embedded_8_bit";
            desc = "Whether 8-bit embedded components are supported
- 0: not supported
- 1: supported";
            sw = r; hw = w;
            reset = 0x1;
        } embedded_8_bit[18:18];
        field {
            name = "max_blk_len";
            desc = "Maximum block length
- 0x0: 512 bytes
- 0x1: 1024 bytes
- 0x2: 2048 bytes
- 0x3: reserved";
            sw = r; hw = w;
            reset = 0x2;
        } max_blk_len[17:16];
        field {
            name = "base_clk_freq";
            desc = "Basic frequency of the SD clock
- 0x0: 1 MHz
- 0x3f: 63 MHz 0x40-0xff: not supported";
            sw = r; hw = w;
            reset = 0x1;
        } base_clk_freq[15:8];
        field {
            name = "tout_clk_unit";
            desc = "Timeout clock unit
- 0: KHz
- 1: MHz";
            sw = r; hw = w;
            reset = 0x1;
        } tout_clk_unit[7:7];
        field {
            name = "reserved";
            desc = "Reserved";
            sw = r; hw = w;
            reset = 0x0;
        } reserved_6_6[6:6];
        field {
            name = "tout_clk_freq";
            desc = "Timeout frequency
- 0x1: 1 KHz/1 MHz
- 0x2: 2 KHz/2 MHz ...
- 0x3f: 63 KHz/63 MHz";
            sw = r; hw = w;
            reset = 0x1;
        } tout_clk_freq[5:0];
    } CAPABILITIES1_R @ 0x40;
    reg {
        name = "CAPABILITIES2_R";
        desc = "CAPABILITIES2_R is capabilities 2 register. (offset 0x44; total reset 0x08002077; PROVEN: Hi3516E V300 data sheet (Issue 00B06, 2019-05-15), section 12.4.4, PDF page 734).";
        field {
            name = "reserved";
            desc = "Reserved";
            sw = r; hw = w;
            reset = 0x0;
        } reserved_31_29[31:29];
        field {
            name = "vdd2_18v_support";
            desc = "Whether the 1.8 V VDDR is supported
- 0: not supported
- 1: supported";
            sw = r; hw = w;
            reset = 0x0;
        } vdd2_18v_support[28:28];
        field {
            name = "adma3_support";
            desc = "Whether ADMA3 is supported
- 0: not supported
- 1: supported";
            sw = r; hw = w;
            reset = 0x1;
        } adma3_support[27:27];
        field {
            name = "reserved";
            desc = "Reserved";
            sw = r; hw = w;
            reset = 0x0;
        } reserved_26_16[26:16];
        field {
            name = "re_tuning_modes";
            desc = "Retuning mode
- 00: mode 1, timer
- 01: mode 2, timer, and retuning requests
- 10: mode 3, auto retuning timer, and retuning requests
- 11: reserved";
            sw = r; hw = w;
            reset = 0x0;
        } re_tuning_modes[15:14];
        field {
            name = "use_tuning_ser50";
            desc = "Whether tuning is performed for SDR50";
            sw = r; hw = w;
            reset = 0x1;
        } use_tuning_ser50[13:13];
        field {
            name = "reserved";
            desc = "Reserved";
            sw = r; hw = w;
            reset = 0x0;
        } reserved_12_12[12:12];
        field {
            name = "retune_cnt";
            desc = "Retuning count
- 0x1: 1 second
- 0x3: 4 seconds

Other values: reserved";
            sw = r; hw = w;
            reset = 0x0;
        } retune_cnt[11:8];
        field {
            name = "reserved";
            desc = "Reserved";
            sw = r; hw = w;
            reset = 0x0;
        } reserved_7_7[7:7];
        field {
            name = "drv_typed";
            desc = "Whether TYPED is supported
- 0: not supported
- 1: supported";
            sw = r; hw = w;
            reset = 0x1;
        } drv_typed[6:6];
        field {
            name = "drv_typec";
            desc = "Whether TYPEC is supported
- 0: not supported
- 1: supported";
            sw = r; hw = w;
            reset = 0x1;
        } drv_typec[5:5];
        field {
            name = "drv_typea";
            desc = "Whether TYPEA is supported
- 0: not supported
- 1: supported";
            sw = r; hw = w;
            reset = 0x1;
        } drv_typea[4:4];
        field {
            name = "uhs2_support";
            desc = "Whether UHS2 is supported
- 0: not supported
- 1: supported";
            sw = r; hw = w;
            reset = 0x0;
        } uhs2_support[3:3];
        field {
            name = "ddr50_support";
            desc = "Whether DDR50 is supported
- 0: not supported
- 1: supported";
            sw = r; hw = w;
            reset = 0x1;
        } ddr50_support[2:2];
        field {
            name = "sdr104_support";
            desc = "Whether SDR104 is supported
- 0: not supported
- 1: supported";
            sw = r; hw = w;
            reset = 0x1;
        } sdr104_support[1:1];
        field {
            name = "sdr50_support";
            desc = "Whether SDR50 is supported
- 0: not supported
- 1: supported";
            sw = r; hw = w;
            reset = 0x1;
        } sdr50_support[0:0];
    } CAPABILITIES2_R @ 0x44;
    reg {
        name = "CURR_CAPBILITIES1_R";
        desc = "CURR_CAPBILITIES1_R is current capabilities 1 register. (offset 0x48; total reset 0x00000000; PROVEN: Hi3516E V300 data sheet (Issue 00B06, 2019-05-15), section 12.4.4, PDF page 735).";
        field {
            name = "reserved";
            desc = "Reserved";
            sw = r; hw = w;
            reset = 0x0;
        } reserved_31_24[31:24];
        field {
            name = "max_cur_18v";
            desc = "Current value at 1.8 V";
            sw = r; hw = w;
            reset = 0x0;
        } max_cur_18v[23:16];
        field {
            name = "max_cur_30v";
            desc = "Current value at 3.0 V";
            sw = r; hw = w;
            reset = 0x0;
        } max_cur_30v[15:8];
        field {
            name = "mac_cur_33v";
            desc = "Current value at 3.3 V";
            sw = r; hw = w;
            reset = 0x0;
        } mac_cur_33v[7:0];
    } CURR_CAPBILITIES1_R @ 0x48;
    reg {
        name = "ADMA_ERR_STAT_R";
        desc = "ADMA_ERR_STAT_R is an ADMA error status register. (offset 0x54; total reset 0x00000000; PROVEN: Hi3516E V300 data sheet (Issue 00B06, 2019-05-15), section 12.4.4, PDF page 736).";
        field {
            name = "reserved";
            desc = "Reserved";
            sw = r; hw = w;
            reset = 0x0;
        } reserved_7_3[7:3];
        field {
            name = "adma_len_err";
            desc = "ADMA length mismatch error status
- 0: No error occurs.
- 1: An error occurs.";
            sw = r; hw = w;
            reset = 0x0;
        } adma_len_err[2:2];
        field {
            name = "adma_err_states";
            desc = "ADMA error status
- 00: ST_STOP
- 01: ST_FDS
- 10: ST_UNUSED
- 11: ST_TFR";
            sw = r; hw = w;
            reset = 0x0;
        } adma_err_states[1:0];
    } ADMA_ERR_STAT_R @ 0x54;
    reg {
        name = "ADMA_SA_LOW_R";
        desc = "ADMA_SA_LOW_R is a lower 32-bit register for the ADMA system address. (offset 0x58; total reset 0x00000000; PROVEN: Hi3516E V300 data sheet (Issue 00B06, 2019-05-15), section 12.4.4, PDF page 736).";
        field {
            name = "adma_sa_low";
            desc = "Lower 32 bits of the ADMA system address";
            sw = rw; hw = r;
            reset = 0x0;
        } adma_sa_low[31:0];
    } ADMA_SA_LOW_R @ 0x58;
    reg {
        name = "ADMA_SA_HIGH_R";
        desc = "ADMA_SA_HIGH_R is an upper 32-bit register for the ADMA system address. (offset 0x5C; total reset 0x00000000; PROVEN: Hi3516E V300 data sheet (Issue 00B06, 2019-05-15), section 12.4.4, PDF page 736).";
        field {
            name = "adma_sa_high";
            desc = "Upper 32 bits of the ADMA system address";
            sw = rw; hw = r;
            reset = 0x0;
        } adma_sa_high[31:0];
    } ADMA_SA_HIGH_R @ 0x5C;
    reg {
        name = "ADMA_ID_LOW_R";
        desc = "ADMA_ID_LOW_R is a lower 32-bit register for the ADMA integrated descriptor address. (offset 0x78; total reset 0x00000000; PROVEN: Hi3516E V300 data sheet (Issue 00B06, 2019-05-15), section 12.4.4, PDF page 737).";
        field {
            name = "adma_id_low";
            desc = "Lower 32 bits of the ADMA integrated descriptor address";
            sw = rw; hw = r;
            reset = 0x0;
        } adma_id_low[31:0];
    } ADMA_ID_LOW_R @ 0x78;
    reg {
        name = "ADMA_ID_HIGH_R";
        desc = "ADMA_ID_HIGH_R is an upper 32-bit register for the ADMA integrated descriptor address. (offset 0x7C; total reset 0x00000000; PROVEN: Hi3516E V300 data sheet (Issue 00B06, 2019-05-15), section 12.4.4, PDF page 737).";
        field {
            name = "adma_id_high";
            desc = "Upper 32 bits of the ADMA integrated descriptor address";
            sw = rw; hw = r;
            reset = 0x0;
        } adma_id_high[31:0];
    } ADMA_ID_HIGH_R @ 0x7C;
    reg {
        name = "MSHC_VER_ID_R";
        desc = "MSHC_VER_ID_R is a controller version ID register. (offset 0x500; total reset 0x3137302A; PROVEN: Hi3516E V300 data sheet (Issue 00B06, 2019-05-15), section 12.4.4, PDF page 737).";
        field {
            name = "mshc_ver_id";
            desc = "Controller version ID register";
            sw = r; hw = w;
            reset = 0x3137302a;
        } mshc_ver_id[31:0];
    } MSHC_VER_ID_R @ 0x500;
    reg {
        name = "MSHC_VER_TYPE_R";
        desc = "MSHC_VER_TYPE_R is a controller version type register. (offset 0x504; total reset 0x67612A2A; PROVEN: Hi3516E V300 data sheet (Issue 00B06, 2019-05-15), section 12.4.4, PDF page 737).";
        field {
            name = "mshc_ver_id";
            desc = "Controller version type register";
            sw = r; hw = w;
            reset = 0x67612a2a;
        } mshc_ver_id[31:0];
    } MSHC_VER_TYPE_R @ 0x504;
    reg {
        name = "MBIU_CTRL_R";
        desc = "MBIU_CTRL_R is an MBIU control register. (offset 0x510; total reset 0x0000000F; PROVEN: Hi3516E V300 data sheet (Issue 00B06, 2019-05-15), section 12.4.4, PDF page 738).";
        field {
            name = "reserved";
            desc = "Reserved";
            sw = r; hw = w;
            reset = 0x0;
        } reserved_31_4[31:4];
        field {
            name = "gm_enburst16";
            desc = "16-burst enable
- 0: disabled
- 1: enabled";
            sw = rw; hw = r;
            reset = 0x1;
        } gm_enburst16[3:3];
        field {
            name = "gm_enburst8";
            desc = "8-burst enable
- 0: disabled
- 1: enabled";
            sw = rw; hw = r;
            reset = 0x1;
        } gm_enburst8[2:2];
        field {
            name = "gm_enburst4";
            desc = "4-burst enable
- 0: disabled
- 1: enabled";
            sw = rw; hw = r;
            reset = 0x1;
        } gm_enburst4[1:1];
        field {
            name = "gm_enburst_undef";
            desc = "Validity enable for burst configurations
- 0: A fixed burst is generated based on gm_enburst4/8/16.
- 1: A corresponding burst is generated based on the actual data length.";
            sw = rw; hw = r;
            reset = 0x1;
        } gm_enburst_undef[0:0];
    } MBIU_CTRL_R @ 0x510;
    reg {
        name = "EMMC_CTRL_R";
        desc = "EMMC_CTRL_R is an eMMC control register. (offset 0x52C; total reset 0x00000000; PROVEN: Hi3516E V300 data sheet (Issue 00B06, 2019-05-15), section 12.4.4, PDF page 738).";
        regwidth = 16;
        field {
            name = "reserved";
            desc = "Reserved";
            sw = r; hw = w;
            reset = 0x0;
        } reserved_15_10[15:10];
        field {
            name = "cqe_algo_sel";
            desc = "Task arrangement algorithm select
- 0: High-priority tasks are implemented first.

For tasks with the same priority, those coming first will be implemented first.
- 1: The tasks coming first will be implemented";
            sw = rw; hw = r;
            reset = 0x0;
        } cqe_algo_sel[9:9];
        field {
            name = "reserved";
            desc = "Reserved";
            sw = r; hw = w;
            reset = 0x0;
        } reserved_8_2[8:2];
        field {
            name = "disable_data_crc_chk";
            desc = "Data CRC disable
- 0: Data CRC is enabled.
- 1: Data CRC is disabled.";
            sw = rw; hw = r;
            reset = 0x0;
        } disable_data_crc_chk[1:1];
        field {
            name = "card_is_emmc";
            desc = "Type of the connected card
- 0: non-eMMC card
- 1: eMMC card";
            sw = rw; hw = r;
            reset = 0x0;
        } card_is_emmc[0:0];
    } EMMC_CTRL_R @ 0x52C;
    reg {
        name = "BOOT_CTRL_R";
        desc = "BOOT_CTRL_R is a boot control register. (offset 0x52E; total reset 0x00000000; PROVEN: Hi3516E V300 data sheet (Issue 00B06, 2019-05-15), section 12.4.4, PDF page 739).";
        regwidth = 16;
        field {
            name = "boot_tout_cnt";
            desc = "Timeout count of boot acknowledgement
- 0x0: TMCLK x 2^13
- 0x1: TMCLK x 2^14 ...
- 0xE: TMCLK x 2^27

Other values: reserved";
            sw = rw; hw = r;
            reset = 0x0;
        } boot_tout_cnt[15:12];
        field {
            name = "reserved";
            desc = "Reserved";
            sw = r; hw = w;
            reset = 0x0;
        } reserved_11_9[11:9];
        field {
            name = "boot_ack_enable";
            desc = "Boot acknowledgement enable
- 0: disabled
- 1: enabled";
            sw = rw; hw = r;
            reset = 0x0;
        } boot_ack_enable[8:8];
        field {
            name = "validate_boot";
            desc = "Validity enable for forcible boot
- 0: There is no effect.
- 1: The boot enable is valid.";
            sw = w; hw = r;
            reset = 0x0;
        } validate_boot[7:7];
        field {
            name = "reserved";
            desc = "Reserved";
            sw = r; hw = w;
            reset = 0x0;
        } reserved_6_1[6:1];
        field {
            name = "man_boot_en";
            desc = "Forcible boot enable. This bit must be configured together with validate_boot. It is automatically cleared after the boot transfer is complete.
- 0: There is no effect.
- 1: The boot enable is valid.";
            sw = rw; hw = r;
            reset = 0x0;
        } man_boot_en[0:0];
    } BOOT_CTRL_R @ 0x52E;
    reg {
        name = "GP_OUT_R";
        desc = "GP_OUT_R is an eMMC reset and GPIO register. (offset 0x534; total reset 0x00000001; PROVEN: Hi3516E V300 data sheet (Issue 00B06, 2019-05-15), section 12.4.4, PDF page 740).";
        field {
            name = "reserved";
            desc = "Reserved";
            sw = r; hw = w;
            reset = 0x0;
        } reserved_31_1[31:1];
        field {
            name = "emmc_rst_n";
            desc = "eMMC card reset signal
- 0: reset
- 1: not reset";
            sw = rw; hw = r;
            reset = 0x1;
        } emmc_rst_n[0:0];
    } GP_OUT_R @ 0x534;
    reg {
        name = "AT_CTRL_R";
        desc = "AT_CTRL_R is a tuning control register. (offset 0x540; total reset 0x00000000; PROVEN: Hi3516E V300 data sheet (Issue 00B06, 2019-05-15), section 12.4.4, PDF page 740).";
        field {
            name = "reserved";
            desc = "Reserved";
            sw = r; hw = w;
            reset = 0x0;
        } reserved_31_5[31:5];
        field {
            name = "sw_tuning_en";
            desc = "Software configuration tuning enable
- 0: disabled
- 1: enabled";
            sw = rw; hw = r;
            reset = 0x0;
        } sw_tuning_en[4:4];
        field {
            name = "reserved";
            desc = "Reserved";
            sw = r; hw = w;
            reset = 0x0;
        } reserved_3_0[3:0];
    } AT_CTRL_R @ 0x540;
    reg {
        name = "AT_STAT_R";
        desc = "AT_STAT_R is a tuning status register. (offset 0x544; total reset 0x00000000; PROVEN: Hi3516E V300 data sheet (Issue 00B06, 2019-05-15), section 12.4.4, PDF page 740).";
        field {
            name = "reserved";
            desc = "Reserved";
            sw = r; hw = w;
            reset = 0x0;
        } reserved_31_8[31:8];
        field {
            name = "sw_ph_sel_code";
            desc = "Phase value of the software configuration";
            sw = rw; hw = r;
            reset = 0x0;
        } sw_ph_sel_code[7:0];
    } AT_STAT_R @ 0x544;
};
`endif
