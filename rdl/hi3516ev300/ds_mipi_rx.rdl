`ifndef HI3516EV300_MIPI_RX_RDL
`define HI3516EV300_MIPI_RX_RDL
regfile eHI3516EV300_MIPI_RX {
    name = "MIPI RX";
    desc = "MIPI RX of the Hi3516E V300 at base 0x1124_0000. 84 registers extracted programmatically from the Hi3516E V300 data sheet (Issue 00B06, 2019-05-15) (Table 9-12 Summary of MIPI RX registers (base address: 0x1124_0000)): register headings, offsets, total reset values, field bit ranges, access types, names, reset values and descriptions, with PDF page numbers in each register description. Field names, bit ranges, access types and offsets are exact; the free-text descriptions are taken from the cell text of the field table and were checked by sampling only. Hardware not verified.";
    reg {
        name = "PHY_MODE_LINK";
        desc = "PHY_MODE_LINK is the link PHY operating mode register. (offset 0x0; total reset 0x00000000; PROVEN: Hi3516E V300 data sheet (Issue 00B06, 2019-05-15), section 9.3.6, PDF page 518).";
        field {
            name = "reserved";
            desc = "Reserved";
            sw = r; hw = w;
            reset = 0x0;
        } reserved_31_26[31:26];
        field {
            name = "phy0_rg_mipi_mode1";
            desc = "MIPI/LVDS input mode select. When the PHY works in LVDS mode and the common voltage is greater than or equal to 1.2 V, this bit is set to 0.
- 0: The common voltage is greater than or equal to 1.2 V.
- 1: The common voltage is less than 1.2 V.";
            sw = rw; hw = r;
            reset = 0x0;
        } phy0_rg_mipi_mode1[25:25];
        field {
            name = "phy0_rg_mipi_mode0";
            desc = "MIPI/LVDS input mode select. When the PHY works in LVDS mode and the common voltage is greater than or equal to 1.2 V, this bit is set to 0.";
            sw = rw; hw = r;
            reset = 0x0;
        } phy0_rg_mipi_mode0[24:24];
        field {
            name = "reserved";
            desc = "Reserved";
            sw = r; hw = w;
            reset = 0x0;
        } reserved_23_17[23:17];
        field {
            name = "phy0_rg_faclk0_en";
            desc = "Phase of associated clock 0 for the PHY output data
- 0: Output data on the rising edge of the clock
- 1: Output data on the falling edge of the clock";
            sw = rw; hw = r;
            reset = 0x0;
        } phy0_rg_faclk0_en[16:16];
        field {
            name = "reserved";
            desc = "Reserved";
            sw = r; hw = w;
            reset = 0x0;
        } reserved_15_14[15:14];
        field {
            name = "phy0_rg_en_lp1";
            desc = "PHY LP1 mode enable. The LP1 mode is enabled in MIPI mode and disabled in other modes.
- 0: disabled
- 1: enabled";
            sw = rw; hw = r;
            reset = 0x0;
        } phy0_rg_en_lp1[13:13];
        field {
            name = "phy0_rg_en_lp0";
            desc = "PHY LP0 mode enable. The LP0 mode is enabled in MIPI mode and disabled in other modes.
- 0: disabled
- 1: enabled";
            sw = rw; hw = r;
            reset = 0x0;
        } phy0_rg_en_lp0[12:12];
        field {
            name = "reserved";
            desc = "Reserved";
            sw = r; hw = w;
            reset = 0x0;
        } reserved_11_5[11:5];
        field {
            name = "phy0_rg_en_clk0";
            desc = "Clock lane 0 enable
- 0: disabled
- 1: enabled";
            sw = rw; hw = r;
            reset = 0x0;
        } phy0_rg_en_clk0[4:4];
        field {
            name = "phy0_rg_en_d";
            desc = "Data lane enable
- 0: disabled
- 1: enabled";
            sw = rw; hw = r;
            reset = 0x0;
        } phy0_rg_en_d[3:0];
    } PHY_MODE_LINK @ 0x0;
    reg {
        name = "PHY_SKEW_LINK";
        desc = "PHY_SKEW_LINK is the link PHY channel delay adjustment register. (offset 0x4; total reset 0x00000000; PROVEN: Hi3516E V300 data sheet (Issue 00B06, 2019-05-15), section 9.3.6, PDF page 519).";
        field {
            name = "reserved";
            desc = "Reserved";
            sw = r; hw = w;
            reset = 0x0;
        } reserved_31_23[31:23];
        field {
            name = "phy0_d3_skew";
            desc = "Timing delay adjustment for data lane 3. The phase is delayed by about 62.5 ps each time the register value is incremented by 1.";
            sw = rw; hw = r;
            reset = 0x0;
        } phy0_d3_skew[22:20];
        field {
            name = "reserved";
            desc = "Reserved";
            sw = r; hw = w;
            reset = 0x0;
        } reserved_19_19[19:19];
        field {
            name = "phy0_d2_skew";
            desc = "Timing delay adjustment for data lane 2. The phase is delayed by about 62.5 ps each time the register value is incremented by 1.";
            sw = rw; hw = r;
            reset = 0x0;
        } phy0_d2_skew[18:16];
        field {
            name = "reserved";
            desc = "Reserved";
            sw = r; hw = w;
            reset = 0x0;
        } reserved_15_15[15:15];
        field {
            name = "phy0_d1_skew";
            desc = "Timing delay adjustment for data lane 1. The phase is delayed by about 62.5 ps each time the register value is incremented by 1.";
            sw = rw; hw = r;
            reset = 0x0;
        } phy0_d1_skew[14:12];
        field {
            name = "reserved";
            desc = "Reserved";
            sw = r; hw = w;
            reset = 0x0;
        } reserved_11_11[11:11];
        field {
            name = "phy0_d0_skew";
            desc = "Timing delay adjustment for data lane 0. The phase is delayed by about 62.5 ps each time the register value is incremented by 1.";
            sw = rw; hw = r;
            reset = 0x0;
        } phy0_d0_skew[10:8];
        field {
            name = "reserved";
            desc = "Reserved";
            sw = r; hw = w;
            reset = 0x0;
        } reserved_7_3[7:3];
        field {
            name = "phy0_clk0_skew";
            desc = "Timing delay adjustment for the clock0 lane. The phase is delayed by about 62.5 ps each time the register value is incremented by 1.";
            sw = rw; hw = r;
            reset = 0x0;
        } phy0_clk0_skew[2:0];
    } PHY_SKEW_LINK @ 0x4;
    reg {
        name = "PHY_EN_LINK";
        desc = "PHY_EN_LINK is the link PHY channel enable register. (offset 0xC; total reset 0x00000000; PROVEN: Hi3516E V300 data sheet (Issue 00B06, 2019-05-15), section 9.3.6, PDF page 520).";
        field {
            name = "reserved";
            desc = "Reserved";
            sw = r; hw = w;
            reset = 0x0;
        } reserved_31_13[31:13];
        field {
            name = "phy_clk0_term_en";
            desc = "Termination matched impedance enable for the clock0 lane
- 0: The internal matched resistor is disabled.
- 1: The internal matched resistor is enabled.";
            sw = rw; hw = r;
            reset = 0x0;
        } phy_clk0_term_en[12:12];
        field {
            name = "phy_d3_term_en";
            desc = "Termination matched impedance enable for data lane 3
- 0: The internal matched resistor is disabled.
- 1: The internal matched resistor is enabled.";
            sw = rw; hw = r;
            reset = 0x0;
        } phy_d3_term_en[11:11];
        field {
            name = "phy_d2_term_en";
            desc = "Termination matched impedance enable for data lane 2
- 0: The internal matched resistor is disabled.
- 1: The internal matched resistor is enabled.";
            sw = rw; hw = r;
            reset = 0x0;
        } phy_d2_term_en[10:10];
        field {
            name = "phy_d1_term_en";
            desc = "Termination matched impedance enable for data lane 1
- 0: The internal matched resistor is disabled.
- 1: The internal matched resistor is enabled.";
            sw = rw; hw = r;
            reset = 0x0;
        } phy_d1_term_en[9:9];
        field {
            name = "phy_d0_term_en";
            desc = "Termination matched impedance enable for data lane 0
- 0: The internal matched resistor is disabled.
- 1: The internal matched resistor is enabled.";
            sw = rw; hw = r;
            reset = 0x0;
        } phy_d0_term_en[8:8];
        field {
            name = "reserved";
            desc = "Reserved";
            sw = r; hw = w;
            reset = 0x0;
        } reserved_7_4[7:4];
        field {
            name = "phy_da_d3_valid";
            desc = "High-speed mode enable for data lane 3
- 0: disabled
- 1: enabled";
            sw = rw; hw = r;
            reset = 0x0;
        } phy_da_d3_valid[3:3];
        field {
            name = "phy_da_d2_valid";
            desc = "High-speed mode enable for data lane 2
- 0: disabled
- 1: enabled";
            sw = rw; hw = r;
            reset = 0x0;
        } phy_da_d2_valid[2:2];
        field {
            name = "phy_da_d1_valid";
            desc = "High-speed mode enable for data lane 1
- 0: disabled
- 1: enabled";
            sw = rw; hw = r;
            reset = 0x0;
        } phy_da_d1_valid[1:1];
        field {
            name = "phy_da_d0_valid";
            desc = "High-speed mode enable for data lane 0
- 0: disabled
- 1: enabled";
            sw = rw; hw = r;
            reset = 0x0;
        } phy_da_d0_valid[0:0];
    } PHY_EN_LINK @ 0xC;
    reg {
        name = "PHY_DATA_LINK";
        desc = "PHY_DATA_LINK is the link PHY output parallel data register. (offset 0x18; total reset 0x00000000; PROVEN: Hi3516E V300 data sheet (Issue 00B06, 2019-05-15), section 9.3.6, PDF page 521).";
        field {
            name = "phy_data3_mipi";
            desc = "Data received by data lane 3";
            sw = r; hw = w;
            reset = 0x0;
        } phy_data3_mipi[31:24];
        field {
            name = "phy_data2_mipi";
            desc = "Data received by data lane 2";
            sw = r; hw = w;
            reset = 0x0;
        } phy_data2_mipi[23:16];
        field {
            name = "phy_data1_mipi";
            desc = "Data received by data lane 1";
            sw = r; hw = w;
            reset = 0x0;
        } phy_data1_mipi[15:8];
        field {
            name = "phy_data0_mipi";
            desc = "Data received by data lane 0";
            sw = r; hw = w;
            reset = 0x0;
        } phy_data0_mipi[7:0];
    } PHY_DATA_LINK @ 0x18;
    reg {
        name = "PHY_PH_MIPI_LINK";
        desc = "PHY_PH_MIPI_LINK is the link MIPI data packet header register. (offset 0x1C; total reset 0x00000000; PROVEN: Hi3516E V300 data sheet (Issue 00B06, 2019-05-15), section 9.3.6, PDF page 521).";
        field {
            name = "phy_ph3_mipi";
            desc = "Data packet header received by data lane 3";
            sw = r; hw = w;
            reset = 0x0;
        } phy_ph3_mipi[31:24];
        field {
            name = "phy_ph2_mipi";
            desc = "Data packet header received by data lane 2";
            sw = r; hw = w;
            reset = 0x0;
        } phy_ph2_mipi[23:16];
        field {
            name = "phy_ph1_mipi";
            desc = "Data packet header received by data lane 1";
            sw = r; hw = w;
            reset = 0x0;
        } phy_ph1_mipi[15:8];
        field {
            name = "phy_ph0_mipi";
            desc = "Data packet header received by data lane 0";
            sw = r; hw = w;
            reset = 0x0;
        } phy_ph0_mipi[7:0];
    } PHY_PH_MIPI_LINK @ 0x1C;
    reg {
        name = "PHY_DATA_MIPI_LINK";
        desc = "PHY_DATA_MIPI_LINK is the link MIPI mode data register. (offset 0x20; total reset 0x00000000; PROVEN: Hi3516E V300 data sheet (Issue 00B06, 2019-05-15), section 9.3.6, PDF page 522).";
        field {
            name = "phy_data3_mipi_hs";
            desc = "MIPI data for data lane 3";
            sw = r; hw = w;
            reset = 0x0;
        } phy_data3_mipi_hs[31:24];
        field {
            name = "phy_data2_mipi_hs";
            desc = "MIPI data for data lane 2";
            sw = r; hw = w;
            reset = 0x0;
        } phy_data2_mipi_hs[23:16];
        field {
            name = "phy_data1_mipi_hs";
            desc = "MIPI data for data lane 1";
            sw = r; hw = w;
            reset = 0x0;
        } phy_data1_mipi_hs[15:8];
        field {
            name = "phy_data0_mipi_hs";
            desc = "MIPI data for data lane 0";
            sw = r; hw = w;
            reset = 0x0;
        } phy_data0_mipi_hs[7:0];
    } PHY_DATA_MIPI_LINK @ 0x20;
    reg {
        name = "PHY_SYNC_DCT_LINK";
        desc = "PHY_SYNC_DCT_LINK is thelink PHY sync header detection control register in LVDS mode. (offset 0x24; total reset 0x00101101; PROVEN: Hi3516E V300 data sheet (Issue 00B06, 2019-05-15), section 9.3.6, PDF page 522).";
        field {
            name = "reserved";
            desc = "Reserved";
            sw = r; hw = w;
            reset = 0x0;
        } reserved_31_21[31:21];
        field {
            name = "cil_code_big_endian1";
            desc = "Serial bit transmission sequence 1 for the synchronization code (sync_code) of raw data to be transmitted in LVDS or HiSPI mode.
- 0: LSB. The lower bits are transmitted first.

The serial data sequence of the received synchronization code is bit 0, bit 1, ..., and bit 11.
- 1: MSB. The upper bits are transmitted first.

The serial data sequence of the received synchronization code is bit 11, bit 10, ..., and bit 0.";
            sw = rw; hw = r;
            reset = 0x1;
        } cil_code_big_endian1[20:20];
        field {
            name = "reserved";
            desc = "Reserved";
            sw = r; hw = w;
            reset = 0x0;
        } reserved_19_15[19:15];
        field {
            name = "cil_raw_type1";
            desc = "Type1 of the raw data to be transmitted in LVDS or HiSPI mode
- 001: 8-bit raw data
- 010: 10-bit raw data";
            sw = rw; hw = r;
            reset = 0x1;
        } cil_raw_type1[14:12];
        field {
            name = "reserved";
            desc = "Reserved";
            sw = r; hw = w;
            reset = 0x0;
        } reserved_11_9[11:9];
        field {
            name = "cil_code_big_endian0";
            desc = "Serial bit transmission sequence 0 for the synchronization code (sync_code) of raw data to be transmitted in LVDS or HiSPI mode.
- 0: LSB. The lower bits are transmitted first.

The serial data sequence of the received synchronization code is bit 0, bit 1, ..., and bit 11.
- 1: MSB. The upper bits are transmitted first.

The serial data sequence of the received synchronization code is bit 11, bit 10, ..., and bit 0.";
            sw = rw; hw = r;
            reset = 0x1;
        } cil_code_big_endian0[8:8];
        field {
            name = "reserved";
            desc = "Reserved";
            sw = r; hw = w;
            reset = 0x0;
        } reserved_7_3[7:3];
        field {
            name = "cil_raw_type0";
            desc = "Type0 of the raw data to be transmitted in LVDS or HiSPI mode
- 001: 8-bit raw data
- 010: 10-bit raw data
- 011: 12-bit raw data
- 100: 14-bit raw data

Other values: reserved";
            sw = rw; hw = r;
            reset = 0x1;
        } cil_raw_type0[2:0];
    } PHY_SYNC_DCT_LINK @ 0x24;
    reg {
        name = "PHY_SYNC_SOF0_LINK";
        desc = "PHY_SYNC_SOF0_LINK is the link PHY sync header register for lane 0 in LVDS mode. (offset 0x30; total reset 0x00000000; PROVEN: Hi3516E V300 data sheet (Issue 00B06, 2019-05-15), section 9.3.6, PDF page 523).";
        field {
            name = "Lane0SOFsynchronizationcode(forframecil_sof1_word4_0N+1)";
            desc = "";
            sw = rw; hw = r;
            reset = 0x0;
        } Lane0SOFsynchronizationcode_forframecil_sof1_word4_0N_1[31:16];
        field {
            name = "Lane0SOFsynchronizationcode(forframecil_sof0_word4_0N)";
            desc = "";
            sw = rw; hw = r;
            reset = 0x0;
        } Lane0SOFsynchronizationcode_forframecil_sof0_word4_0N[15:0];
    } PHY_SYNC_SOF0_LINK @ 0x30;
    reg {
        name = "PHY_SYNC_SOF1_LINK";
        desc = "PHY_SYNC_SOF1_LINK is the link PHY sync header register for lane 1 in LVDS mode. (offset 0x34; total reset 0x00000000; PROVEN: Hi3516E V300 data sheet (Issue 00B06, 2019-05-15), section 9.3.6, PDF page 523).";
        field {
            name = "Lane1SOFsynchronizationcode(forframecil_sof1_word4_1N+1)";
            desc = "";
            sw = rw; hw = r;
            reset = 0x0;
        } Lane1SOFsynchronizationcode_forframecil_sof1_word4_1N_1[31:16];
        field {
            name = "Lane1SOFsynchronizationcode(forframecil_sof0_word4_1N)";
            desc = "";
            sw = rw; hw = r;
            reset = 0x0;
        } Lane1SOFsynchronizationcode_forframecil_sof0_word4_1N[15:0];
    } PHY_SYNC_SOF1_LINK @ 0x34;
    reg {
        name = "PHY_SYNC_SOF2_LINK";
        desc = "PHY_SYNC_SOF2_LINK is the link PHY sync header register for lane 2 in LVDS mode. (offset 0x38; total reset 0x00000000; PROVEN: Hi3516E V300 data sheet (Issue 00B06, 2019-05-15), section 9.3.6, PDF page 524).";
        field {
            name = "Lane2SOFsynchronizationcode(forframecil_sof1_word4_2N+1)";
            desc = "";
            sw = rw; hw = r;
            reset = 0x0;
        } Lane2SOFsynchronizationcode_forframecil_sof1_word4_2N_1[31:16];
        field {
            name = "Lane2SOFsynchronizationcode(forframecil_sof0_word4_2N)";
            desc = "";
            sw = rw; hw = r;
            reset = 0x0;
        } Lane2SOFsynchronizationcode_forframecil_sof0_word4_2N[15:0];
    } PHY_SYNC_SOF2_LINK @ 0x38;
    reg {
        name = "PHY_SYNC_SOF3_LINK";
        desc = "PHY_SYNC_SOF3_LINK is the link PHY sync header register for lane 3 in LVDS mode. (offset 0x3C; total reset 0x00000000; PROVEN: Hi3516E V300 data sheet (Issue 00B06, 2019-05-15), section 9.3.6, PDF page 524).";
        field {
            name = "Lane3SOFsynchronizationcode(forframecil_sof1_word4_3N+1)";
            desc = "";
            sw = rw; hw = r;
            reset = 0x0;
        } Lane3SOFsynchronizationcode_forframecil_sof1_word4_3N_1[31:16];
        field {
            name = "Lane3SOFsynchronizationcode(forframecil_sof0_word4_3N)";
            desc = "";
            sw = rw; hw = r;
            reset = 0x0;
        } Lane3SOFsynchronizationcode_forframecil_sof0_word4_3N[15:0];
    } PHY_SYNC_SOF3_LINK @ 0x3C;
    reg {
        name = "CIL_FSM0_LINK";
        desc = "CIL_FSM0_LINK is the link FSM0 parameter register. (offset 0x104; total reset 0x00001D0C; PROVEN: Hi3516E V300 data sheet (Issue 00B06, 2019-05-15), section 9.3.6, PDF page 524).";
        field {
            name = "reserved";
            desc = "Reserved";
            sw = r; hw = w;
            reset = 0x0;
        } reserved_31_22[31:22];
        field {
            name = "cil_cyc_clk_hs_exit";
            desc = "FSM LP-11 status duration cycle count for the clock lane on the link. The configured value is the actual value minus 1. 0 indicates that the status lasts for one";
            sw = rw; hw = r;
            reset = 0x0;
        } cil_cyc_clk_hs_exit[21:16];
        field {
            name = "reserved";
            desc = "Reserved";
            sw = r; hw = w;
            reset = 0x0;
        } reserved_15_14[15:14];
        field {
            name = "cil_cyc_clk_hs0";
            desc = "FSM HS-0 status duration cycle count for the clock lane on the link. The configured value is the actual value minus 1. 0 indicates that the status lasts for one cycle.";
            sw = rw; hw = r;
            reset = 0x1d;
        } cil_cyc_clk_hs0[13:8];
        field {
            name = "reserved";
            desc = "Reserved";
            sw = r; hw = w;
            reset = 0x0;
        } reserved_7_6[7:6];
        field {
            name = "cil_cyc_clk_lp00";
            desc = "FSM LP-00 status duration cycle count for the clock lane on the link. The configured value is the actual value minus 1. 0 indicates that the status lasts for one cycle.";
            sw = rw; hw = r;
            reset = 0xc;
        } cil_cyc_clk_lp00[5:0];
    } CIL_FSM0_LINK @ 0x104;
    reg {
        name = "PHY_ST2_LINK";
        desc = "PHY_ST2_LINK is the link PHY status register 2. (offset 0x118; total reset 0x00000000; PROVEN: Hi3516E V300 data sheet (Issue 00B06, 2019-05-15), section 9.3.6, PDF page 525).";
        field {
            name = "reserved";
            desc = "Reserved";
            sw = r; hw = w;
            reset = 0x0;
        } reserved_31_14[31:14];
        field {
            name = "reserved";
            desc = "Reserved";
            sw = r; hw = w;
            reset = 0x0;
        } reserved_13_13[13:13];
        field {
            name = "physt_clk0_term_en";
            desc = "Termination matched impedance enable for the clock lane
- 0: disabled
- 1: enabled";
            sw = r; hw = w;
            reset = 0x0;
        } physt_clk0_term_en[12:12];
        field {
            name = "physt_d3_term_en";
            desc = "Termination matched impedance enable for data lane 3
- 0: disabled
- 1: enabled";
            sw = r; hw = w;
            reset = 0x0;
        } physt_d3_term_en[11:11];
        field {
            name = "physt_d2_term_en";
            desc = "Termination matched impedance enable for data lane 2
- 0: disabled
- 1: enabled";
            sw = r; hw = w;
            reset = 0x0;
        } physt_d2_term_en[10:10];
        field {
            name = "physt_d1_term_en";
            desc = "Termination matched impedance enable for data lane 1
- 0: disabled
- 1: enabled";
            sw = r; hw = w;
            reset = 0x0;
        } physt_d1_term_en[9:9];
        field {
            name = "physt_d0_term_en";
            desc = "Termination matched impedance enable for data lane 0";
            sw = r; hw = w;
            reset = 0x0;
        } physt_d0_term_en[8:8];
        field {
            name = "reserved";
            desc = "Reserved";
            sw = r; hw = w;
            reset = 0x0;
        } reserved_7_0[7:0];
    } PHY_ST2_LINK @ 0x118;
    reg {
        name = "CIL_FSM1_LINK";
        desc = "CIL_FSM1_LINK is the link FSM1parameter register. (offset 0x12C; total reset 0x0000000D; PROVEN: Hi3516E V300 data sheet (Issue 00B06, 2019-05-15), section 9.3.6, PDF page 526).";
        field {
            name = "reserved";
            desc = "Reserved";
            sw = r; hw = w;
            reset = 0x0;
        } reserved_31_22[31:22];
        field {
            name = "cil_cyc_data_hs_exit";
            desc = "FSM LP-11 status duration cycle count for the clock lane on the link. The configured value is the actual value minus 1. 0 indicates that the status lasts for one cycle.";
            sw = rw; hw = r;
            reset = 0x0;
        } cil_cyc_data_hs_exit[21:16];
        field {
            name = "reserved";
            desc = "Reserved";
            sw = r; hw = w;
            reset = 0x0;
        } reserved_15_14[15:14];
        field {
            name = "cil_cyc_data_hs0";
            desc = "FSM HS-0 status duration cycle count for the clock lane on the link. The configured value is the actual value minus 1. 0 indicates that the status lasts for one cycle.";
            sw = rw; hw = r;
            reset = 0x0;
        } cil_cyc_data_hs0[13:8];
        field {
            name = "reserved";
            desc = "Reserved";
            sw = r; hw = w;
            reset = 0x0;
        } reserved_7_6[7:6];
        field {
            name = "cil_cyc_data_lp00";
            desc = "FSM LP-00 status duration cycle count for the clock lane on the link. The configured value is the actual value minus 1. 0 indicates that the status lasts for one cycle.";
            sw = rw; hw = r;
            reset = 0xd;
        } cil_cyc_data_lp00[5:0];
    } CIL_FSM1_LINK @ 0x12C;
    reg {
        name = "MIPI_CIL_INT_RAW_LINK";
        desc = "MIPI_CIL_INT_RAW_LINK is the link MIPI CIL raw interrupt status register. (offset 0x1F0; total reset 0x00000000; PROVEN: Hi3516E V300 data sheet (Issue 00B06, 2019-05-15), section 9.3.6, PDF page 526).";
        field {
            name = "reserved";
            desc = "Reserved";
            sw = r; hw = w;
            reset = 0x0;
        } reserved_31_13[31:13];
        field {
            name = "err0_timeout_ck0_raw";
            desc = "Status of the raw FSM timeout interrupt for the clock0 lane
- 0: No raw interrupt is generated.

Access type WC in the data sheet: written 1 clears the bit.";
            sw = rw; hw = w; onwrite = woclr;
            reset = 0x0;
        } err0_timeout_ck0_raw[12:12];
        field {
            name = "err0_timeout_d3_raw";
            desc = "Status of the raw FSM timeout interrupt for data lane 3
- 0: No raw interrupt is generated.
- 1: A raw interrupt is generated.

Access type WC in the data sheet: written 1 clears the bit.";
            sw = rw; hw = w; onwrite = woclr;
            reset = 0x0;
        } err0_timeout_d3_raw[11:11];
        field {
            name = "err0_timeout_d2_raw";
            desc = "Status of the raw FSM timeout interrupt for data lane 2
- 0: No raw interrupt is generated.
- 1: A raw interrupt is generated.

Access type WC in the data sheet: written 1 clears the bit.";
            sw = rw; hw = w; onwrite = woclr;
            reset = 0x0;
        } err0_timeout_d2_raw[10:10];
        field {
            name = "err0_timeout_d1_raw";
            desc = "Status of the raw FSM timeout interrupt for data lane 1
- 0: No raw interrupt is generated.
- 1: A raw interrupt is generated.

Access type WC in the data sheet: written 1 clears the bit.";
            sw = rw; hw = w; onwrite = woclr;
            reset = 0x0;
        } err0_timeout_d1_raw[9:9];
        field {
            name = "err0_timeout_d0_raw";
            desc = "Status of the raw FSM timeout interrupt for data lane 0
- 0: No raw interrupt is generated.
- 1: A raw interrupt is generated.

Access type WC in the data sheet: written 1 clears the bit.";
            sw = rw; hw = w; onwrite = woclr;
            reset = 0x0;
        } err0_timeout_d0_raw[8:8];
        field {
            name = "reserved";
            desc = "Reserved";
            sw = r; hw = w;
            reset = 0x0;
        } reserved_7_5[7:5];
        field {
            name = "err0_escape_ck0_raw";
            desc = "Status of the raw escape sequence interrupt for the clock0 lane
- 0: No raw interrupt is generated.
- 1: A raw interrupt is generated.

Access type WC in the data sheet: written 1 clears the bit.";
            sw = rw; hw = w; onwrite = woclr;
            reset = 0x0;
        } err0_escape_ck0_raw[4:4];
        field {
            name = "err0_escape_d3_raw";
            desc = "Status of the raw escape sequence interrupt for data lane 3
- 0: No raw interrupt is generated.
- 1: A raw interrupt is generated.

Access type WC in the data sheet: written 1 clears the bit.";
            sw = rw; hw = w; onwrite = woclr;
            reset = 0x0;
        } err0_escape_d3_raw[3:3];
        field {
            name = "err0_escape_d2_raw";
            desc = "Status of the raw escape sequence interrupt for data lane 2
- 0: No raw interrupt is generated.
- 1: A raw interrupt is generated.

Access type WC in the data sheet: written 1 clears the bit.";
            sw = rw; hw = w; onwrite = woclr;
            reset = 0x0;
        } err0_escape_d2_raw[2:2];
        field {
            name = "err0_escape_d1_raw";
            desc = "Status of the raw escape sequence interrupt for data lane 1
- 0: No raw interrupt is generated.
- 1: A raw interrupt is generated.

Access type WC in the data sheet: written 1 clears the bit.";
            sw = rw; hw = w; onwrite = woclr;
            reset = 0x0;
        } err0_escape_d1_raw[1:1];
        field {
            name = "err0_escape_d0_raw";
            desc = "Status of the raw escape sequence interrupt for data lane 0
- 0: No raw interrupt is generated.
- 1: A raw interrupt is generated.

Access type WC in the data sheet: written 1 clears the bit.";
            sw = rw; hw = w; onwrite = woclr;
            reset = 0x0;
        } err0_escape_d0_raw[0:0];
    } MIPI_CIL_INT_RAW_LINK @ 0x1F0;
    reg {
        name = "MIPI_CIL_INT_LINK";
        desc = "MIPI_CIL_INT_LINK is the link MIPI CIL interrupt status register. (offset 0x1F4; total reset 0x00000000; PROVEN: Hi3516E V300 data sheet (Issue 00B06, 2019-05-15), section 9.3.6, PDF page 528).";
        field {
            name = "reserved";
            desc = "Reserved";
            sw = r; hw = w;
            reset = 0x0;
        } reserved_31_13[31:13];
        field {
            name = "err0_timeout_ck0_st";
            desc = "Status of the FSM timeout interrupt for the clock0 lane
- 0: No interrupt is generated.
- 1: An interrupt is generated.";
            sw = r; hw = w;
            reset = 0x0;
        } err0_timeout_ck0_st[12:12];
        field {
            name = "err0_timeout_d3_st";
            desc = "Status of the FSM timeout interrupt for data lane 3
- 0: No interrupt is generated.
- 1: An interrupt is generated.";
            sw = r; hw = w;
            reset = 0x0;
        } err0_timeout_d3_st[11:11];
        field {
            name = "err0_timeout_d2_st";
            desc = "Status of the FSM timeout interrupt for data lane 2
- 0: No interrupt is generated.
- 1: An interrupt is generated.";
            sw = r; hw = w;
            reset = 0x0;
        } err0_timeout_d2_st[10:10];
        field {
            name = "err0_timeout_d1_st";
            desc = "Status of the FSM timeout interrupt for data lane 1
- 0: No interrupt is generated.
- 1: An interrupt is generated.";
            sw = r; hw = w;
            reset = 0x0;
        } err0_timeout_d1_st[9:9];
        field {
            name = "err0_timeout_d0_st";
            desc = "Status of the FSM timeout interrupt for data lane 0
- 0: No interrupt is generated.
- 1: An interrupt is generated.";
            sw = r; hw = w;
            reset = 0x0;
        } err0_timeout_d0_st[8:8];
        field {
            name = "reserved";
            desc = "Reserved";
            sw = r; hw = w;
            reset = 0x0;
        } reserved_7_5[7:5];
        field {
            name = "err0_escape_ck0_st";
            desc = "Status of the escape sequence interrupt for the clock0 lane
- 0: No interrupt is generated.
- 1: An interrupt is generated.";
            sw = r; hw = w;
            reset = 0x0;
        } err0_escape_ck0_st[4:4];
        field {
            name = "err0_escape_d3_st";
            desc = "Status of the escape sequence interrupt for data lane 3
- 0: No interrupt is generated.
- 1: An interrupt is generated.";
            sw = r; hw = w;
            reset = 0x0;
        } err0_escape_d3_st[3:3];
        field {
            name = "err0_escape_d2_st";
            desc = "Status of the escape sequence interrupt for data lane 2
- 0: No interrupt is generated.
- 1: An interrupt is generated.";
            sw = r; hw = w;
            reset = 0x0;
        } err0_escape_d2_st[2:2];
        field {
            name = "err0_escape_d1_st";
            desc = "Status of the escape sequence interrupt for";
            sw = r; hw = w;
            reset = 0x0;
        } err0_escape_d1_st[1:1];
        field {
            name = "Statusoftheescapesequenceinterruptfordatalane0err0_escape_d0_st0:Nointerruptisgenerated.1:Aninterruptisgenerated.";
            desc = "";
            sw = r; hw = w;
            reset = 0x0;
        } Statusoftheescapesequenceinterruptfordatalane0err0_escape_d0_st0_Nointerruptisgenerated_1_Aninterruptisgenerated[0:0];
    } MIPI_CIL_INT_LINK @ 0x1F4;
    reg {
        name = "MIPI_CIL_INT_MSK_LINK";
        desc = "MIPI_CIL_INT_MSK_LINK is the link MIPI CIL interrupt mask register. (offset 0x1F8; total reset 0x00000000; PROVEN: Hi3516E V300 data sheet (Issue 00B06, 2019-05-15), section 9.3.6, PDF page 529).";
        field {
            name = "reserved";
            desc = "Reserved";
            sw = r; hw = w;
            reset = 0x0;
        } reserved_31_13[31:13];
        field {
            name = "err3_timeout_ck0_msk";
            desc = "Enable of the FSM timeout interrupt for the clock0 lane
- 0: masked
- 1: enabled";
            sw = rw; hw = r;
            reset = 0x0;
        } err3_timeout_ck0_msk[12:12];
        field {
            name = "err3_timeout_d3_msk";
            desc = "Enable of the FSM timeout interrupt for data lane 3
- 0: masked
- 1: enabled";
            sw = rw; hw = r;
            reset = 0x0;
        } err3_timeout_d3_msk[11:11];
        field {
            name = "err3_timeout_d2_msk";
            desc = "Enable of the FSM timeout interrupt for data lane 2
- 0: masked
- 1: enabled";
            sw = rw; hw = r;
            reset = 0x0;
        } err3_timeout_d2_msk[10:10];
        field {
            name = "err3_timeout_d1_msk";
            desc = "Enable of the FSM timeout interrupt for data lane 1
- 0: masked
- 1: enabled";
            sw = rw; hw = r;
            reset = 0x0;
        } err3_timeout_d1_msk[9:9];
        field {
            name = "err3_timeout_d0_msk";
            desc = "Enable of the FSM timeout interrupt for data lane 0
- 0: masked
- 1: enabled";
            sw = rw; hw = r;
            reset = 0x0;
        } err3_timeout_d0_msk[8:8];
        field {
            name = "reserved";
            desc = "Reserved";
            sw = r; hw = w;
            reset = 0x0;
        } reserved_7_5[7:5];
        field {
            name = "err3_escape_ck0_msk";
            desc = "Enable of the escape sequence interrupt for the clock0 lane";
            sw = rw; hw = r;
            reset = 0x0;
        } err3_escape_ck0_msk[4:4];
        field {
            name = "Enableoftheescapesequenceinterruptfordatalane3err3_escape_d3_msk0:masked1:enabled";
            desc = "";
            sw = rw; hw = r;
            reset = 0x0;
        } Enableoftheescapesequenceinterruptfordatalane3err3_escape_d3_msk0_masked1_enabled[3:3];
        field {
            name = "Enableoftheescapesequenceinterruptfordatalane2err3_escape_d2_msk0:masked1:enabled";
            desc = "";
            sw = rw; hw = r;
            reset = 0x0;
        } Enableoftheescapesequenceinterruptfordatalane2err3_escape_d2_msk0_masked1_enabled[2:2];
        field {
            name = "Enableoftheescapesequenceinterruptfordatalane1err3_escape_d1_msk0:masked1:enabled";
            desc = "";
            sw = rw; hw = r;
            reset = 0x0;
        } Enableoftheescapesequenceinterruptfordatalane1err3_escape_d1_msk0_masked1_enabled[1:1];
        field {
            name = "Enableoftheescapesequenceinterruptfordatalane0err3_escape_d0_msk0:masked1:enabled";
            desc = "";
            sw = rw; hw = r;
            reset = 0x0;
        } Enableoftheescapesequenceinterruptfordatalane0err3_escape_d0_msk0_masked1_enabled[0:0];
    } MIPI_CIL_INT_MSK_LINK @ 0x1F8;
    reg {
        name = "PHY_EN";
        desc = "PHY_EN is the PHY enable register. (offset 0x808; total reset 0x00000000; PROVEN: Hi3516E V300 data sheet (Issue 00B06, 2019-05-15), section 9.3.6, PDF page 530).";
        field {
            name = "reserved";
            desc = "Reserved";
            sw = r; hw = w;
            reset = 0x0;
        } reserved_31_8[31:8];
        field {
            name = "d_p_swap_data3";
            desc = "Swapping enable of differential P and differential N signals for lane 3
- 0: disabled
- 1: enabled";
            sw = rw; hw = r;
            reset = 0x0;
        } d_p_swap_data3[7:7];
        field {
            name = "d_p_swap_data2";
            desc = "Swapping enable of differential P and differential N signals for lane 2
- 0: disabled
- 1: enabled";
            sw = rw; hw = r;
            reset = 0x0;
        } d_p_swap_data2[6:6];
        field {
            name = "d_p_swap_data1";
            desc = "Swapping enable of differential P and differential N signals for lane 1
- 0: disabled
- 1: enabled";
            sw = rw; hw = r;
            reset = 0x0;
        } d_p_swap_data1[5:5];
        field {
            name = "d_p_swap_data0";
            desc = "Swapping enable of differential P and differential N signals for lane 0
- 0: disabled
- 1: enabled";
            sw = rw; hw = r;
            reset = 0x0;
        } d_p_swap_data0[4:4];
        field {
            name = "reserved";
            desc = "Reserved";
            sw = r; hw = w;
            reset = 0x0;
        } reserved_3_1[3:1];
        field {
            name = "phy0_en";
            desc = "PHY 0 enable
- 0: disabled
- 1: enabled";
            sw = rw; hw = r;
            reset = 0x0;
        } phy0_en[0:0];
    } PHY_EN @ 0x808;
    reg {
        name = "LANE_EN";
        desc = "LANE_EN is the LANE_EN enable register. (offset 0x80C; total reset 0x00000000; PROVEN: Hi3516E V300 data sheet (Issue 00B06, 2019-05-15), section 9.3.6, PDF page 531).";
        field {
            name = "reserved";
            desc = "Reserved";
            sw = r; hw = w;
            reset = 0x0;
        } reserved_31_4[31:4];
        field {
            name = "lane3_en";
            desc = "Lane 3 enable
- 0: disabled
- 1: enabled";
            sw = rw; hw = r;
            reset = 0x0;
        } lane3_en[3:3];
        field {
            name = "lane2_en";
            desc = "Lane 2 enable
- 0: disabled
- 1: enabled";
            sw = rw; hw = r;
            reset = 0x0;
        } lane2_en[2:2];
        field {
            name = "lane1_en";
            desc = "Lane 1 enable
- 0: disabled
- 1: enabled";
            sw = rw; hw = r;
            reset = 0x0;
        } lane1_en[1:1];
        field {
            name = "lane0_en";
            desc = "Lane 0 enable
- 0: disabled
- 1: enabled";
            sw = rw; hw = r;
            reset = 0x0;
        } lane0_en[0:0];
    } LANE_EN @ 0x80C;
    reg {
        name = "PHY_CIL_CTRL";
        desc = "PHY_CIL_CTRL is the PHY CIL control register. (offset 0x810; total reset 0x00000000; PROVEN: Hi3516E V300 data sheet (Issue 00B06, 2019-05-15), section 9.3.6, PDF page 531).";
        field {
            name = "reserved";
            desc = "Reserved";
            sw = r; hw = w;
            reset = 0x0;
        } reserved_31_9[31:9];
        field {
            name = "cil0_rst_req";
            desc = "CIL 0 reset
- 0: not reset
- 1: reset";
            sw = rw; hw = r;
            reset = 0x0;
        } cil0_rst_req[8:8];
        field {
            name = "reserved";
            desc = "Reserved";
            sw = r; hw = w;
            reset = 0x0;
        } reserved_7_1[7:1];
        field {
            name = "phycil0_cken";
            desc = "PHYCIL0 clock gating
- 0: disabled
- 1: enabled";
            sw = rw; hw = r;
            reset = 0x0;
        } phycil0_cken[0:0];
    } PHY_CIL_CTRL @ 0x810;
    reg {
        name = "PHYCFG_MODE";
        desc = "PHYCFG_MODE is the PHY configuration mode register. (offset 0x818; total reset 0x00000000; PROVEN: Hi3516E V300 data sheet (Issue 00B06, 2019-05-15), section 9.3.6, PDF page 532).";
        field {
            name = "reserved";
            desc = "Reserved";
            sw = r; hw = w;
            reset = 0x0;
        } reserved_31_4[31:4];
        field {
            name = "phycil0_cfg_mode_sel";
            desc = "PHY0 configuration mode
- 0: controlled by PHYCFG_EN
- 1: controlled by the register value (CMOS)";
            sw = rw; hw = r;
            reset = 0x0;
        } phycil0_cfg_mode_sel[3:3];
        field {
            name = "phycil0_0_cfg_mode";
            desc = "PHY0 lane 0/lane 2 configuration mode
- 000: The PHY configuration is controlled by

PHYCFG_EN and FSM (MIPI).
- 001: The PHY configuration is controlled by

PHYCFG_EN (LVDS).
- 010: The PHY configuration is controlled by the register value.
- 011: The PHY configuration is controlled by

PHYCFG_EN and FSM, and the clock channel enable is controlled by PHYCFG_EN. Other values: reserved";
            sw = rw; hw = r;
            reset = 0x0;
        } phycil0_0_cfg_mode[2:0];
    } PHYCFG_MODE @ 0x818;
    reg {
        name = "PHYCFG_EN";
        desc = "PHYCFG_EN is the PHY configuration enable register. (offset 0x81C; total reset 0x00000000; PROVEN: Hi3516E V300 data sheet (Issue 00B06, 2019-05-15), section 9.3.6, PDF page 532).";
        field {
            name = "reserved";
            desc = "Reserved";
            sw = r; hw = w;
            reset = 0x0;
        } reserved_31_1[31:1];
        field {
            name = "phycil0_cfg_en";
            desc = "PHY0 configuration enable
- 0: disabled
- 1: enabled";
            sw = w; hw = r;
            reset = 0x0;
        } phycil0_cfg_en[0:0];
    } PHYCFG_EN @ 0x81C;
    reg {
        name = "CHN0_MEM_CTRL";
        desc = "CHN0_MEM_CTRL is the channel 0 memory control register. (offset 0x820; total reset 0x00004420; PROVEN: Hi3516E V300 data sheet (Issue 00B06, 2019-05-15), section 9.3.6, PDF page 533).";
        field {
            name = "reserved";
            desc = "Reserved";
            sw = r; hw = w;
            reset = 0x0;
        } reserved_31_15[31:15];
        field {
            name = "reserved";
            desc = "Reserved";
            sw = r; hw = w;
            reset = 0x3;
        } reserved_14_12[14:12];
        field {
            name = "reserved";
            desc = "Reserved";
            sw = r; hw = w;
            reset = 0x0;
        } reserved_11_11[11:11];
        field {
            name = "reserved";
            desc = "Reserved";
            sw = r; hw = w;
            reset = 0x3;
        } reserved_10_8[10:8];
        field {
            name = "reserved";
            desc = "Reserved";
            sw = r; hw = w;
            reset = 0x0;
        } reserved_7_7[7:7];
        field {
            name = "reserved";
            desc = "Reserved";
            sw = r; hw = w;
            reset = 0x1;
        } reserved_6_6[6:6];
        field {
            name = "reserved";
            desc = "Reserved";
            sw = r; hw = w;
            reset = 0x1;
        } reserved_5_5[5:5];
        field {
            name = "reserved";
            desc = "Reserved";
            sw = r; hw = w;
            reset = 0x0;
        } reserved_4_4[4:4];
        field {
            name = "reserved";
            desc = "Reserved";
            sw = r; hw = w;
            reset = 0x0;
        } reserved_3_1[3:1];
        field {
            name = "chn0_mem_ck_gt";
            desc = "Clock gating port for channel 0 memory
- 0: disabled
- 1: enabled";
            sw = rw; hw = r;
            reset = 0x0;
        } chn0_mem_ck_gt[0:0];
    } CHN0_MEM_CTRL @ 0x820;
    reg {
        name = "CHN0_CLR_EN";
        desc = "CHN0_CLR_EN is the channel 0 forcible set enable register. (offset 0x824; total reset 0x00000000; PROVEN: Hi3516E V300 data sheet (Issue 00B06, 2019-05-15), section 9.3.6, PDF page 533).";
        field {
            name = "reserved";
            desc = "Reserved";
            sw = r; hw = w;
            reset = 0x0;
        } reserved_31_2[31:2];
        field {
            name = "chn0_clr_en_align";
            desc = "Forcible reset control for the channel 0 ALIGN module
- 0: The reset request for the channel 0 ALIGN module is disabled.
- 1: The reset request for the channel 0 ALIGN module is enabled.";
            sw = rw; hw = r;
            reset = 0x0;
        } chn0_clr_en_align[1:1];
        field {
            name = "chn0_clr_en_lvds";
            desc = "Forcible reset control for the channel 0";
            sw = rw; hw = r;
            reset = 0x0;
        } chn0_clr_en_lvds[0:0];
    } CHN0_CLR_EN @ 0x824;
    reg {
        name = "MIPI_INT_RAW";
        desc = "MIPI_INT_RAW is the MIPI system raw interrupt status register. (offset 0xFF0; total reset 0x00000000; PROVEN: Hi3516E V300 data sheet (Issue 00B06, 2019-05-15), section 9.3.6, PDF page 534).";
        field {
            name = "reserved";
            desc = "Reserved";
            sw = r; hw = w;
            reset = 0x0;
        } reserved_31_5[31:5];
        field {
            name = "int_chn0_raw";
            desc = "Raw interrupt status of channel 0
- 0: There is no raw interrupt.
- 1: There is a raw interrupt.

Access type WC in the data sheet: written 1 clears the bit.";
            sw = rw; hw = w; onwrite = woclr;
            reset = 0x0;
        } int_chn0_raw[4:4];
        field {
            name = "reserved";
            desc = "Reserved";
            sw = r; hw = w;
            reset = 0x0;
        } reserved_3_1[3:1];
        field {
            name = "int_phycil0_raw";
            desc = "PHYCIL0 raw interrupt status
- 0: There is no raw interrupt.
- 1: There is a raw interrupt.

Access type WC in the data sheet: written 1 clears the bit.";
            sw = rw; hw = w; onwrite = woclr;
            reset = 0x0;
        } int_phycil0_raw[0:0];
    } MIPI_INT_RAW @ 0xFF0;
    reg {
        name = "MIPI_INT_ST";
        desc = "MIPI_INT_ST is the MIPI system interrupt status register. (offset 0xFF4; total reset 0x00000000; PROVEN: Hi3516E V300 data sheet (Issue 00B06, 2019-05-15), section 9.3.6, PDF page 534).";
        field {
            name = "reserved";
            desc = "Reserved";
            sw = r; hw = w;
            reset = 0x0;
        } reserved_31_5[31:5];
        field {
            name = "int_chn0_st";
            desc = "Interrupt status of channel 0
- 0: No interrupt is generated.
- 1: An interrupt is generated.";
            sw = r; hw = w;
            reset = 0x0;
        } int_chn0_st[4:4];
        field {
            name = "reserved";
            desc = "Reserved";
            sw = r; hw = w;
            reset = 0x0;
        } reserved_3_1[3:1];
        field {
            name = "int_phycil0_st";
            desc = "PHYCIL0 interrupt status
- 0: No interrupt is generated.
- 1: An interrupt is generated.";
            sw = r; hw = w;
            reset = 0x0;
        } int_phycil0_st[0:0];
    } MIPI_INT_ST @ 0xFF4;
    reg {
        name = "MIPI_INT_MSK";
        desc = "MIPI_INT_MSK is the MIPI system interrupt mask register. (offset 0xFF8; total reset 0x00000000; PROVEN: Hi3516E V300 data sheet (Issue 00B06, 2019-05-15), section 9.3.6, PDF page 535).";
        field {
            name = "reserved";
            desc = "Reserved";
            sw = r; hw = w;
            reset = 0x0;
        } reserved_31_5[31:5];
        field {
            name = "int_chn0_mask";
            desc = "Interrupt enable of channel 0
- 0: masked
- 1: enabled";
            sw = rw; hw = r;
            reset = 0x0;
        } int_chn0_mask[4:4];
        field {
            name = "reserved";
            desc = "Reserved";
            sw = r; hw = w;
            reset = 0x0;
        } reserved_3_1[3:1];
        field {
            name = "int_phycil0_mask";
            desc = "PHYCIL0 interrupt enable
- 0: masked
- 1: enabled";
            sw = rw; hw = r;
            reset = 0x0;
        } int_phycil0_mask[0:0];
    } MIPI_INT_MSK @ 0xFF8;
    reg {
        name = "MIPI_LANES_NUM";
        desc = "MIPI_LANES_NUM is the MIPI 1 enabled data channel quantity register. (offset 0x1004; total reset 0x00000003; PROVEN: Hi3516E V300 data sheet (Issue 00B06, 2019-05-15), section 9.3.6, PDF page 535).";
        field {
            name = "reserved";
            desc = "Reserved";
            sw = r; hw = w;
            reset = 0x0;
        } reserved_31_3[31:3];
        field {
            name = "lane_num";
            desc = "Number of enabled data channels
- 000:1
- 001: 2
- 010: 3
- 011: 4

Other values: reserved";
            sw = rw; hw = r;
            reset = 0x3;
        } lane_num[2:0];
    } MIPI_LANES_NUM @ 0x1004;
    reg {
        name = "MIPI_MAIN_INT_ST";
        desc = "MIPI_MAIN_INT_ST is the MIPI global interrupt status register. (offset 0x100C; total reset 0x00000000; PROVEN: Hi3516E V300 data sheet (Issue 00B06, 2019-05-15), section 9.3.6, PDF page 535).";
        field {
            name = "reserved";
            desc = "Reserved";
            sw = r; hw = w;
            reset = 0x0;
        } reserved_31_19[31:19];
        field {
            name = "status_int_line";
            desc = "Line interrupt status. This bit is set to 1 when any of the bits in the MIPI_LINE_INTR_ST register is set to 1. This bit is cleared when it is read. To clear the reported interrupt, this bit and MIPI_LINE_INTR_ST must be cleared.";
            sw = r; hw = w;
            reset = 0x0;
        } status_int_line[18:18];
        field {
            name = "status_int_pkt";
            desc = "Packet interrupt status. This bit is set to 1 when any of the bits in the MIPI_PKT_INTR2_ST register is set to 1. This bit is cleared when it is read. To clear the reported interrupt, this bit and MIPI_PKT_INTR2_ST must be cleared.";
            sw = r; hw = w;
            reset = 0x0;
        } status_int_pkt[17:17];
        field {
            name = "reserved";
            desc = "Reserved";
            sw = r; hw = w;
            reset = 0x0;
        } reserved_16_3[16:3];
        field {
            name = "status_int_frame_fatal";
            desc = "Frame interrupt status. This bit is set to 1 when any of the bits in the MIPI_FRAME_INTR_ST register is set to 1. This bit is cleared when it is read. To clear the reported interrupt, this bit and MIPI_FRAME_INTR_ST must be cleared.";
            sw = r; hw = w;
            reset = 0x0;
        } status_int_frame_fatal[2:2];
        field {
            name = "status_int_pkt_fatal";
            desc = "Packet interrupt status. This bit is set to 1 when any of the bits in the MIPI_PKT_INTR_ST register is set to 1. This bit is cleared when it is read. To clear the reported interrupt, this bit and MIPI_PKT_INTR_ST must be cleared.";
            sw = r; hw = w;
            reset = 0x0;
        } status_int_pkt_fatal[1:1];
        field {
            name = "reserved";
            desc = "Reserved";
            sw = r; hw = w;
            reset = 0x0;
        } reserved_0_0[0:0];
    } MIPI_MAIN_INT_ST @ 0x100C;
    reg {
        name = "MIPI_DI_1";
        desc = "MIPI_DI_1 is the MIPI controller data ID register 1. (offset 0x1010; total reset 0x00000000; PROVEN: Hi3516E V300 data sheet (Issue 00B06, 2019-05-15), section 9.3.6, PDF page 536).";
        field {
            name = "di3_vc";
            desc = "Virtual channel ID of data with the ID 3";
            sw = rw; hw = r;
            reset = 0x0;
        } di3_vc[31:30];
        field {
            name = "di3_dt";
            desc = "Type of data with the ID 3
- 0x2A: raw8
- 0x2B: raw10
- 0x2C: raw12
- 0x2D: raw14

Other values: reserved";
            sw = rw; hw = r;
            reset = 0x0;
        } di3_dt[29:24];
        field {
            name = "di2_vc";
            desc = "Virtual channel ID of data with the ID 2";
            sw = rw; hw = r;
            reset = 0x0;
        } di2_vc[23:22];
        field {
            name = "di2_dt";
            desc = "Type of data with the ID 2
- 0x2A: raw8";
            sw = rw; hw = r;
            reset = 0x0;
        } di2_dt[21:16];
        field {
            name = "di1_vc";
            desc = "Virtual channel ID of data with the ID 1";
            sw = rw; hw = r;
            reset = 0x0;
        } di1_vc[15:14];
        field {
            name = "di1_dt";
            desc = "Type of data with the ID 1
- 0x2A: raw8
- 0x2B: raw10
- 0x2C: raw12
- 0x2D: raw14

Other values: reserved";
            sw = rw; hw = r;
            reset = 0x0;
        } di1_dt[13:8];
        field {
            name = "di0_vc";
            desc = "Virtual channel ID of data with the ID 0";
            sw = rw; hw = r;
            reset = 0x0;
        } di0_vc[7:6];
        field {
            name = "di0_dt";
            desc = "Type of data with the ID 0
- 0x2A: raw8
- 0x2B: raw10
- 0x2C: raw12
- 0x2D: raw14

Other values: reserved";
            sw = rw; hw = r;
            reset = 0x0;
        } di0_dt[5:0];
    } MIPI_DI_1 @ 0x1010;
    reg {
        name = "MIPI_DI_2";
        desc = "MIPI_DI_2 is the MIPI controller data ID register 2. (offset 0x1014; total reset 0x00000000; PROVEN: Hi3516E V300 data sheet (Issue 00B06, 2019-05-15), section 9.3.6, PDF page 537).";
        field {
            name = "di7_vc";
            desc = "Virtual channel ID of data with the ID 7";
            sw = rw; hw = r;
            reset = 0x0;
        } di7_vc[31:30];
        field {
            name = "di7_dt";
            desc = "Type of data with the ID 7
- 0x2A: raw8
- 0x2B: raw10
- 0x2C: raw12
- 0x2D: raw14

Other values: reserved";
            sw = rw; hw = r;
            reset = 0x0;
        } di7_dt[29:24];
        field {
            name = "di6_vc";
            desc = "Virtual channel ID of data with the ID 6";
            sw = rw; hw = r;
            reset = 0x0;
        } di6_vc[23:22];
        field {
            name = "di6_dt";
            desc = "Type of data with the ID 6
- 0x2A: raw8
- 0x2B: raw10
- 0x2C: raw12";
            sw = rw; hw = r;
            reset = 0x0;
        } di6_dt[21:16];
        field {
            name = "di5_vc";
            desc = "Virtual channel ID of data with the ID 5";
            sw = rw; hw = r;
            reset = 0x0;
        } di5_vc[15:14];
        field {
            name = "di5_dt";
            desc = "Type of data with the ID 5
- 0x2A: raw8
- 0x2B: raw10
- 0x2C: raw12
- 0x2D: raw14

Other values: reserved";
            sw = rw; hw = r;
            reset = 0x0;
        } di5_dt[13:8];
        field {
            name = "di4_vc";
            desc = "Virtual channel ID of data with the ID 4";
            sw = rw; hw = r;
            reset = 0x0;
        } di4_vc[7:6];
        field {
            name = "di4_dt";
            desc = "Type of data with the ID 4
- 0x2A: raw8
- 0x2B: raw10
- 0x2C: raw12
- 0x2D: raw14

Other values: reserved";
            sw = rw; hw = r;
            reset = 0x0;
        } di4_dt[5:0];
    } MIPI_DI_2 @ 0x1014;
    reg {
        name = "MIPI_PKT_INTR_ST";
        desc = "MIPI_PKT_INTR_ST is the MIPI packet interrupt status register. (offset 0x1060; total reset 0x00000000; PROVEN: Hi3516E V300 data sheet (Issue 00B06, 2019-05-15), section 9.3.6, PDF page 538).";
        field {
            name = "reserved";
            desc = "Reserved";
            sw = r; hw = w;
            reset = 0x0;
        } reserved_31_17[31:17];
        field {
            name = "err_ecc_double";
            desc = "Whether the header has at least two uncorrectable ECC errors. This bit is cleared when it is read.
- 0: No ECC error occurs.
- 1: ECC errors occur.";
            sw = r; hw = w;
            reset = 0x0;
        } err_ecc_double[16:16];
        field {
            name = "reserved";
            desc = "Reserved";
            sw = r; hw = w;
            reset = 0x0;
        } reserved_15_4[15:4];
        field {
            name = "vc3_err_crc";
            desc = "Whether the VC 3 data has CRC errors. This bit is cleared when it is read.
- 0: no
- 1: yes";
            sw = r; hw = w;
            reset = 0x0;
        } vc3_err_crc[3:3];
        field {
            name = "vc2_err_crc";
            desc = "Whether the VC 2 data has CRC errors. This bit is cleared when it is read.
- 0: no
- 1: yes";
            sw = r; hw = w;
            reset = 0x0;
        } vc2_err_crc[2:2];
        field {
            name = "WhethertheVC1datahasCRCerrors.Thisbitisclearedwhenitisread.vc1_err_crc0:no1:yes";
            desc = "";
            sw = r; hw = w;
            reset = 0x0;
        } WhethertheVC1datahasCRCerrors_Thisbitisclearedwhenitisread_vc1_err_crc0_no1_yes[1:1];
        field {
            name = "WhethertheVC0datahasCRCerrors.Thisbitisclearedwhenitisread.vc0_err_crc0:no1:yes";
            desc = "";
            sw = r; hw = w;
            reset = 0x0;
        } WhethertheVC0datahasCRCerrors_Thisbitisclearedwhenitisread_vc0_err_crc0_no1_yes[0:0];
    } MIPI_PKT_INTR_ST @ 0x1060;
    reg {
        name = "MIPI_PKT_INTR_MSK";
        desc = "MIPI_PKT_INTR_MSK is the MIPI packet interrupt mask register. (offset 0x1064; total reset 0x00000000; PROVEN: Hi3516E V300 data sheet (Issue 00B06, 2019-05-15), section 9.3.6, PDF page 539).";
        field {
            name = "reserved";
            desc = "Reserved";
            sw = r; hw = w;
            reset = 0x0;
        } reserved_31_17[31:17];
        field {
            name = "mask_err_ecc_double";
            desc = "err_ecc_double interrupt mask
- 0: masked
- 1: enabled";
            sw = rw; hw = r;
            reset = 0x0;
        } mask_err_ecc_double[16:16];
        field {
            name = "reserved";
            desc = "Reserved";
            sw = r; hw = w;
            reset = 0x0;
        } reserved_15_4[15:4];
        field {
            name = "mask_vc3_err_crc";
            desc = "vc3_err_crc interrupt mask
- 0: masked
- 1: enabled";
            sw = rw; hw = r;
            reset = 0x0;
        } mask_vc3_err_crc[3:3];
        field {
            name = "mask_vc2_err_crc";
            desc = "vc2_err_crc interrupt mask
- 0: masked
- 1: enabled";
            sw = rw; hw = r;
            reset = 0x0;
        } mask_vc2_err_crc[2:2];
        field {
            name = "mask_vc1_err_crc";
            desc = "vc1_err_crc interrupt mask
- 0: masked
- 1: enabled";
            sw = rw; hw = r;
            reset = 0x0;
        } mask_vc1_err_crc[1:1];
        field {
            name = "mask_vc0_err_crc";
            desc = "vc0_err_crc interrupt mask
- 0: masked
- 1: enabled";
            sw = rw; hw = r;
            reset = 0x0;
        } mask_vc0_err_crc[0:0];
    } MIPI_PKT_INTR_MSK @ 0x1064;
    reg {
        name = "MIPI_PKT_INTR2_ST";
        desc = "MIPI_PKT_INTR2_ST is the MIPI packet interrupt status register 2. (offset 0x1070; total reset 0x00000000; PROVEN: Hi3516E V300 data sheet (Issue 00B06, 2019-05-15), section 9.3.6, PDF page 539).";
        field {
            name = "reserved";
            desc = "Reserved";
            sw = r; hw = w;
            reset = 0x0;
        } reserved_31_20[31:20];
        field {
            name = "vc3_err_ecc_corrected";
            desc = "Whether the VC 3 channel header has ECC errors. This bit is cleared when it is read.
- 0: no
- 1: yes. The ECC errors have been corrected.";
            sw = r; hw = w;
            reset = 0x0;
        } vc3_err_ecc_corrected[19:19];
        field {
            name = "vc2_err_ecc_corrected";
            desc = "Whether the VC 2 channel header has ECC errors. This bit is cleared when it is read.
- 0: no
- 1: yes. The ECC errors have been corrected.";
            sw = r; hw = w;
            reset = 0x0;
        } vc2_err_ecc_corrected[18:18];
        field {
            name = "vc1_err_ecc_corrected";
            desc = "Whether the VC 1 channel header has ECC errors. This bit is cleared when it is read.
- 0: no
- 1: yes. The ECC errors have been corrected.";
            sw = r; hw = w;
            reset = 0x0;
        } vc1_err_ecc_corrected[17:17];
        field {
            name = "vc0_err_ecc_corrected";
            desc = "Whether the VC 0 channel header has ECC errors. This bit is cleared when it is read.
- 0: no
- 1: yes. The ECC errors have been corrected.";
            sw = r; hw = w;
            reset = 0x0;
        } vc0_err_ecc_corrected[16:16];
        field {
            name = "reserved";
            desc = "Reserved";
            sw = r; hw = w;
            reset = 0x0;
        } reserved_15_4[15:4];
        field {
            name = "err_id_vc3";
            desc = "Whether the VC 3 channel data type is supported. This bit is cleared when it is read.
- 0: supported
- 1: not supported";
            sw = r; hw = w;
            reset = 0x0;
        } err_id_vc3[3:3];
        field {
            name = "err_id_vc2";
            desc = "Whether the VC 2 channel data type is supported. This bit is cleared when it is read.
- 0: supported
- 1: not supported";
            sw = r; hw = w;
            reset = 0x0;
        } err_id_vc2[2:2];
        field {
            name = "err_id_vc1";
            desc = "Whether the VC 1 channel data type is supported. This bit is cleared when it is read.
- 0: supported
- 1: not supported";
            sw = r; hw = w;
            reset = 0x0;
        } err_id_vc1[1:1];
        field {
            name = "err_id_vc0";
            desc = "Whether the VC 0 channel data type is supported. This bit is cleared when it is read.
- 0: supported
- 1: not supported";
            sw = r; hw = w;
            reset = 0x0;
        } err_id_vc0[0:0];
    } MIPI_PKT_INTR2_ST @ 0x1070;
    reg {
        name = "MIPI_PKT_INTR2_MSK";
        desc = "MIPI_PKT_INTR2_MSK is the MIPI packet interrupt mask register 2. (offset 0x1074; total reset 0x00000000; PROVEN: Hi3516E V300 data sheet (Issue 00B06, 2019-05-15), section 9.3.6, PDF page 541).";
        field {
            name = "reserved";
            desc = "Reserved";
            sw = r; hw = w;
            reset = 0x0;
        } reserved_31_20[31:20];
        field {
            name = "mask_vc3_err_ecc_corrected";
            desc = "vc3_err_ecc_corrected interrupt mask
- 0: masked
- 1: enabled";
            sw = rw; hw = r;
            reset = 0x0;
        } mask_vc3_err_ecc_corrected[19:19];
        field {
            name = "mask_vc2_err_ecc_corrected";
            desc = "vc2_err_ecc_corrected interrupt mask
- 0: masked
- 1: enabled";
            sw = rw; hw = r;
            reset = 0x0;
        } mask_vc2_err_ecc_corrected[18:18];
        field {
            name = "mask_vc1_err_ecc_corrected";
            desc = "vc1_err_ecc_corrected interrupt mask
- 0: masked
- 1: enabled";
            sw = rw; hw = r;
            reset = 0x0;
        } mask_vc1_err_ecc_corrected[17:17];
        field {
            name = "mask_vc0_err_ecc_corrected";
            desc = "vc0_err_ecc_corrected interrupt mask
- 0: masked
- 1: enabled";
            sw = rw; hw = r;
            reset = 0x0;
        } mask_vc0_err_ecc_corrected[16:16];
        field {
            name = "reserved";
            desc = "Reserved";
            sw = r; hw = w;
            reset = 0x0;
        } reserved_15_4[15:4];
        field {
            name = "mask_err_id_vc3";
            desc = "err_id_vc3 interrupt mask
- 0: masked
- 1: enabled";
            sw = rw; hw = r;
            reset = 0x0;
        } mask_err_id_vc3[3:3];
        field {
            name = "mask_err_id_vc2";
            desc = "err_id_vc2 interrupt mask
- 0: masked
- 1: enabled";
            sw = rw; hw = r;
            reset = 0x0;
        } mask_err_id_vc2[2:2];
        field {
            name = "mask_err_id_vc1";
            desc = "err_id_vc1 interrupt mask
- 0: masked
- 1: enabled";
            sw = rw; hw = r;
            reset = 0x0;
        } mask_err_id_vc1[1:1];
        field {
            name = "mask_err_id_vc0";
            desc = "err_id_vc0 interrupt mask
- 0: masked
- 1: enabled";
            sw = rw; hw = r;
            reset = 0x0;
        } mask_err_id_vc0[0:0];
    } MIPI_PKT_INTR2_MSK @ 0x1074;
    reg {
        name = "MIPI_FRAME_INTR_ST";
        desc = "MIPI_FRAME_INTR_ST is the MIPI frame interrupt status register. (offset 0x1080; total reset 0x00000000; PROVEN: Hi3516E V300 data sheet (Issue 00B06, 2019-05-15), section 9.3.6, PDF page 541).";
        field {
            name = "reserved";
            desc = "Reserved";
            sw = r; hw = w;
            reset = 0x0;
        } reserved_31_20[31:20];
        field {
            name = "err_frame_data_vc3";
            desc = "Whether the last frame of VC 3 channel data";
            sw = r; hw = w;
            reset = 0x0;
        } err_frame_data_vc3[19:19];
        field {
            name = "err_frame_data_vc2";
            desc = "Whether the last frame of VC 2 channel data has at least one CRC error. This bit is cleared when it is read.
- 0: No CRC error occurs.
- 1: CRC errors occur.";
            sw = r; hw = w;
            reset = 0x0;
        } err_frame_data_vc2[18:18];
        field {
            name = "err_frame_data_vc1";
            desc = "Whether the last frame of VC 1 channel data has at least one CRC error. This bit is cleared when it is read.
- 0: No CRC error occurs.
- 1: CRC errors occur.";
            sw = r; hw = w;
            reset = 0x0;
        } err_frame_data_vc1[17:17];
        field {
            name = "err_frame_data_vc0";
            desc = "Whether the last frame of VC 0 channel data has at least one CRC error. This bit is cleared when it is read.
- 0: No CRC error occurs.
- 1: CRC errors occur.";
            sw = r; hw = w;
            reset = 0x0;
        } err_frame_data_vc0[16:16];
        field {
            name = "reserved";
            desc = "Reserved";
            sw = r; hw = w;
            reset = 0x0;
        } reserved_15_12[15:12];
        field {
            name = "err_f_seq_vc3";
            desc = "Whether the VC 3 frame sequence is correct. This bit is cleared when it is read.
- 0: yes
- 1: no";
            sw = r; hw = w;
            reset = 0x0;
        } err_f_seq_vc3[11:11];
        field {
            name = "err_f_seq_vc2";
            desc = "Whether the VC 2 frame sequence is correct. This bit is cleared when it is read.
- 0: yes
- 1: no";
            sw = r; hw = w;
            reset = 0x0;
        } err_f_seq_vc2[10:10];
        field {
            name = "err_f_seq_vc1";
            desc = "Whether the VC 1 frame sequence is correct. This bit is cleared when it is read.
- 0: yes
- 1: no";
            sw = r; hw = w;
            reset = 0x0;
        } err_f_seq_vc1[9:9];
        field {
            name = "err_f_seq_vc0";
            desc = "Whether the VC 0 frame sequence is correct. This bit is cleared when it is read.
- 0: yes
- 1: no";
            sw = r; hw = w;
            reset = 0x0;
        } err_f_seq_vc0[8:8];
        field {
            name = "reserved";
            desc = "Reserved";
            sw = r; hw = w;
            reset = 0x0;
        } reserved_7_4[7:4];
        field {
            name = "err_f_bndry_match_vc3";
            desc = "Whether the SOF matches the EOF for the VC 3 channel. This bit is cleared when it is read.
- 0: yes";
            sw = r; hw = w;
            reset = 0x0;
        } err_f_bndry_match_vc3[3:3];
        field {
            name = "Whetherthematchestheforthe2channel.Thisbitisclearedwhenitisread.err_f_bndry_match_vc20:yes1:no";
            desc = "Whether the SOF matches the EOF for the VC 2 channel. This bit is cleared when it is read.
- 0: yes
- 1: no

Access type 'SOFEOFVCRO' in the data sheet (mapped to rw).";
            sw = rw; hw = r;
            reset = 0x0;
        } Whetherthematchestheforthe2channel_Thisbitisclearedwhenitisread_err_f_bndry_match_vc20_yes1_no[2:2];
        field {
            name = "Whetherthematchestheforthe1channel.Thisbitisclearedwhenitisread.err_f_bndry_match_vc10:yes1:no";
            desc = "Whether the SOF matches the EOF for the VC 1 channel. This bit is cleared when it is read.
- 0: yes
- 1: no

Access type 'SOFEOFVCRO' in the data sheet (mapped to rw).";
            sw = rw; hw = r;
            reset = 0x0;
        } Whetherthematchestheforthe1channel_Thisbitisclearedwhenitisread_err_f_bndry_match_vc10_yes1_no[1:1];
        field {
            name = "Whetherthematchestheforthe0channel.Thisbitisclearedwhenitisread.err_f_bndry_match_vc00:yes1:no";
            desc = "Whether the SOF matches the EOF for the VC 0 channel. This bit is cleared when it is read.
- 0: yes
- 1: no

Access type 'SOFEOFVCRO' in the data sheet (mapped to rw).";
            sw = rw; hw = r;
            reset = 0x0;
        } Whetherthematchestheforthe0channel_Thisbitisclearedwhenitisread_err_f_bndry_match_vc00_yes1_no[0:0];
    } MIPI_FRAME_INTR_ST @ 0x1080;
    reg {
        name = "MIPI_FRAME_INTR_MSK";
        desc = "MIPI_FRAME_INTR_MSK is the MIPI frame interrupt mask register. (offset 0x1084; total reset 0x00000000; PROVEN: Hi3516E V300 data sheet (Issue 00B06, 2019-05-15), section 9.3.6, PDF page 543).";
        field {
            name = "reserved";
            desc = "Reserved";
            sw = r; hw = w;
            reset = 0x0;
        } reserved_31_20[31:20];
        field {
            name = "mask_err_frame_data_vc3";
            desc = "err_frame_data_vc3 interrupt mask
- 0: masked
- 1: enabled";
            sw = rw; hw = r;
            reset = 0x0;
        } mask_err_frame_data_vc3[19:19];
        field {
            name = "mask_err_frame_data_vc2";
            desc = "err_frame_data_vc2 interrupt mask
- 0: masked
- 1: enabled";
            sw = rw; hw = r;
            reset = 0x0;
        } mask_err_frame_data_vc2[18:18];
        field {
            name = "mask_err_frame_data_vc1";
            desc = "err_frame_data_vc1 interrupt mask
- 0: masked
- 1: enabled";
            sw = rw; hw = r;
            reset = 0x0;
        } mask_err_frame_data_vc1[17:17];
        field {
            name = "mask_err_frame_data_vc0";
            desc = "err_frame_data_vc0 interrupt mask
- 0: masked
- 1: enabled";
            sw = rw; hw = r;
            reset = 0x0;
        } mask_err_frame_data_vc0[16:16];
        field {
            name = "reserved";
            desc = "Reserved";
            sw = r; hw = w;
            reset = 0x0;
        } reserved_15_12[15:12];
        field {
            name = "mask_err_f_seq_vc3";
            desc = "err_f_seq_vc3 interrupt mask
- 0: masked
- 1: enabled";
            sw = rw; hw = r;
            reset = 0x0;
        } mask_err_f_seq_vc3[11:11];
        field {
            name = "mask_err_f_seq_vc2";
            desc = "err_f_seq_vc2 interrupt mask
- 0: masked
- 1: enabled";
            sw = rw; hw = r;
            reset = 0x0;
        } mask_err_f_seq_vc2[10:10];
        field {
            name = "mask_err_f_seq_vc1";
            desc = "err_f_seq_vc1 interrupt mask
- 0: masked
- 1: enabled";
            sw = rw; hw = r;
            reset = 0x0;
        } mask_err_f_seq_vc1[9:9];
        field {
            name = "mask_err_f_seq_vc0";
            desc = "err_f_seq_vc0 interrupt mask
- 0: masked
- 1: enabled";
            sw = rw; hw = r;
            reset = 0x0;
        } mask_err_f_seq_vc0[8:8];
        field {
            name = "reserved";
            desc = "Reserved";
            sw = r; hw = w;
            reset = 0x0;
        } reserved_7_4[7:4];
        field {
            name = "mask_err_f_bndry_match_vc3";
            desc = "err_f_bndry_match_vc3 interrupt mask
- 0: masked
- 1: enabled";
            sw = rw; hw = r;
            reset = 0x0;
        } mask_err_f_bndry_match_vc3[3:3];
        field {
            name = "mask_err_f_bndry_match_vc2";
            desc = "err_f_bndry_match_vc2 interrupt mask
- 0: masked
- 1: enabled";
            sw = rw; hw = r;
            reset = 0x0;
        } mask_err_f_bndry_match_vc2[2:2];
        field {
            name = "mask_err_f_bndry_match_vc1";
            desc = "err_f_bndry_match_vc1 interrupt mask
- 0: masked
- 1: enabled";
            sw = rw; hw = r;
            reset = 0x0;
        } mask_err_f_bndry_match_vc1[1:1];
        field {
            name = "mask_err_f_bndry_match_vc0";
            desc = "err_f_bndry_match_vc0 interrupt mask
- 0: masked
- 1: enabled";
            sw = rw; hw = r;
            reset = 0x0;
        } mask_err_f_bndry_match_vc0[0:0];
    } MIPI_FRAME_INTR_MSK @ 0x1084;
    reg {
        name = "MIPI_LINE_INTR_ST";
        desc = "MIPI_LINE_INTR_ST is the MIPI line interrupt status register. (offset 0x1090; total reset 0x00000000; PROVEN: Hi3516E V300 data sheet (Issue 00B06, 2019-05-15), section 9.3.6, PDF page 544).";
        field {
            name = "reserved";
            desc = "Reserved";
            sw = r; hw = w;
            reset = 0x0;
        } reserved_31_24[31:24];
        field {
            name = "err_l_seq_di7";
            desc = "Whether the line sequence of VC 7 and DT 7 is correct. This bit is cleared when it is read.
- 0: yes
- 1: no";
            sw = r; hw = w;
            reset = 0x0;
        } err_l_seq_di7[23:23];
        field {
            name = "err_l_seq_di6";
            desc = "Whether the line sequence of VC 6 and DT 6 is correct. This bit is cleared when it is read.
- 0: yes";
            sw = r; hw = w;
            reset = 0x0;
        } err_l_seq_di6[22:22];
        field {
            name = "err_l_seq_di5";
            desc = "Whether the line sequence of VC 5 and DT 5 is correct. This bit is cleared when it is read.
- 0: yes
- 1: no";
            sw = r; hw = w;
            reset = 0x0;
        } err_l_seq_di5[21:21];
        field {
            name = "err_l_seq_di4";
            desc = "Whether the line sequence of VC 4 and DT 4 is correct. This bit is cleared when it is read.
- 0: yes
- 1: no";
            sw = r; hw = w;
            reset = 0x0;
        } err_l_seq_di4[20:20];
        field {
            name = "err_l_seq_di3";
            desc = "Whether the line sequence of VC 3 and DT 3 is correct. This bit is cleared when it is read.
- 0: yes
- 1: no";
            sw = r; hw = w;
            reset = 0x0;
        } err_l_seq_di3[19:19];
        field {
            name = "err_l_seq_di2";
            desc = "Whether the line sequence of VC 2 and DT 2 is correct. This bit is cleared when it is read.
- 0: yes
- 1: no";
            sw = r; hw = w;
            reset = 0x0;
        } err_l_seq_di2[18:18];
        field {
            name = "err_l_seq_di1";
            desc = "Whether the line sequence of VC 1 and DT 1 is correct. This bit is cleared when it is read.
- 0: yes
- 1: no";
            sw = r; hw = w;
            reset = 0x0;
        } err_l_seq_di1[17:17];
        field {
            name = "err_l_seq_di0";
            desc = "Whether the line sequence of VC 0 and DT 0 is correct. This bit is cleared when it is read.
- 0: yes
- 1: no";
            sw = r; hw = w;
            reset = 0x0;
        } err_l_seq_di0[16:16];
        field {
            name = "reserved";
            desc = "Reserved";
            sw = r; hw = w;
            reset = 0x0;
        } reserved_15_8[15:8];
        field {
            name = "err_l_bndry_match_di7";
            desc = "Whether the SOL matches the EOL for VC 7 and DT 7. This bit is cleared when it is read.
- 0: yes
- 1: no";
            sw = r; hw = w;
            reset = 0x0;
        } err_l_bndry_match_di7[7:7];
        field {
            name = "err_l_bndry_match_di6";
            desc = "Whether the SOL matches the EOL for VC 6 and DT 6. This bit is cleared when it is read.
- 0: yes
- 1: no";
            sw = r; hw = w;
            reset = 0x0;
        } err_l_bndry_match_di6[6:6];
        field {
            name = "err_l_bndry_match_di5";
            desc = "Whether the SOL matches the EOL for VC 5 and DT 5. This bit is cleared when it is read.
- 0: yes
- 1: no";
            sw = r; hw = w;
            reset = 0x0;
        } err_l_bndry_match_di5[5:5];
        field {
            name = "err_l_bndry_match_";
            desc = "Whether the SOL matches the EOL for VC 4";
            sw = r; hw = w;
            reset = 0x0;
        } err_l_bndry_match[4:4];
        field {
            name = "Whetherthematchesthefor3and3.Thisbitisclearedwhenitisread.err_l_bndry_match_di30:yes1:no";
            desc = "Whether the SOL matches the EOL for VC 3 and DT 3. This bit is cleared when it is read.
- 0: yes
- 1: no

Access type 'SOLEOLVCDTRO' in the data sheet (mapped to rw).";
            sw = rw; hw = r;
            reset = 0x0;
        } Whetherthematchesthefor3and3_Thisbitisclearedwhenitisread_err_l_bndry_match_di30_yes1_no[3:3];
        field {
            name = "Whetherthematchesthefor2and2.Thisbitisclearedwhenitisread.err_l_bndry_match_di20:yes1:no";
            desc = "Whether the SOL matches the EOL for VC 2 and DT 2. This bit is cleared when it is read.
- 0: yes
- 1: no

Access type 'SOLEOLVCDTRO' in the data sheet (mapped to rw).";
            sw = rw; hw = r;
            reset = 0x0;
        } Whetherthematchesthefor2and2_Thisbitisclearedwhenitisread_err_l_bndry_match_di20_yes1_no[2:2];
        field {
            name = "Whetherthematchesthefor1and1.Thisbitisclearedwhenitisread.err_l_bndry_match_di10:yes1:no";
            desc = "Whether the SOL matches the EOL for VC 1 and DT 1. This bit is cleared when it is read.
- 0: yes
- 1: no

Access type 'SOLEOLVCDTRO' in the data sheet (mapped to rw).";
            sw = rw; hw = r;
            reset = 0x0;
        } Whetherthematchesthefor1and1_Thisbitisclearedwhenitisread_err_l_bndry_match_di10_yes1_no[1:1];
        field {
            name = "Whetherthematchesthefor0and0.Thisbitisclearedwhenitisread.err_l_bndry_match_di00:yes1:no";
            desc = "Whether the SOL matches the EOL for VC 0 and DT 0. This bit is cleared when it is read.
- 0: yes
- 1: no

Access type 'SOLEOLVCDTRO' in the data sheet (mapped to rw).";
            sw = rw; hw = r;
            reset = 0x0;
        } Whetherthematchesthefor0and0_Thisbitisclearedwhenitisread_err_l_bndry_match_di00_yes1_no[0:0];
    } MIPI_LINE_INTR_ST @ 0x1090;
    reg {
        name = "MIPI_LINE_INTR_MSK";
        desc = "MIPI_LINE_INTR_MSK is the MIPI line interrupt mask register. (offset 0x1094; total reset 0x00000000; PROVEN: Hi3516E V300 data sheet (Issue 00B06, 2019-05-15), section 9.3.6, PDF page 546).";
        field {
            name = "reserved";
            desc = "Reserved";
            sw = r; hw = w;
            reset = 0x0;
        } reserved_31_24[31:24];
        field {
            name = "mask_err_l_seq_di7";
            desc = "err_l_seq_di7 interrupt mask
- 0: masked
- 1: enabled";
            sw = rw; hw = r;
            reset = 0x0;
        } mask_err_l_seq_di7[23:23];
        field {
            name = "mask_err_l_seq_di6";
            desc = "err_l_seq_di6 interrupt mask
- 0: masked
- 1: enabled";
            sw = rw; hw = r;
            reset = 0x0;
        } mask_err_l_seq_di6[22:22];
        field {
            name = "mask_err_l_seq_di5";
            desc = "err_l_seq_di5 interrupt mask
- 0: masked
- 1: enabled";
            sw = rw; hw = r;
            reset = 0x0;
        } mask_err_l_seq_di5[21:21];
        field {
            name = "mask_err_l_seq_di4";
            desc = "err_l_seq_di4 interrupt mask
- 0: masked";
            sw = rw; hw = r;
            reset = 0x0;
        } mask_err_l_seq_di4[20:20];
        field {
            name = "mask_err_l_seq_di3";
            desc = "err_l_seq_di3 interrupt mask
- 0: masked
- 1: enabled";
            sw = rw; hw = r;
            reset = 0x0;
        } mask_err_l_seq_di3[19:19];
        field {
            name = "mask_err_l_seq_di2";
            desc = "err_l_seq_di2 interrupt mask
- 0: masked
- 1: enabled";
            sw = rw; hw = r;
            reset = 0x0;
        } mask_err_l_seq_di2[18:18];
        field {
            name = "mask_err_l_seq_di1";
            desc = "err_l_seq_di1 interrupt mask
- 0: masked
- 1: enabled";
            sw = rw; hw = r;
            reset = 0x0;
        } mask_err_l_seq_di1[17:17];
        field {
            name = "mask_err_l_seq_di0";
            desc = "err_l_seq_di0 interrupt mask
- 0: masked
- 1: enabled";
            sw = rw; hw = r;
            reset = 0x0;
        } mask_err_l_seq_di0[16:16];
        field {
            name = "reserved";
            desc = "Reserved";
            sw = r; hw = w;
            reset = 0x0;
        } reserved_15_8[15:8];
        field {
            name = "mask_err_l_bndry_match_di7";
            desc = "err_l_bndry_match_di7 interrupt mask
- 0: masked
- 1: enabled";
            sw = rw; hw = r;
            reset = 0x0;
        } mask_err_l_bndry_match_di7[7:7];
        field {
            name = "mask_err_l_bndry_match_di6";
            desc = "err_l_bndry_match_di6 interrupt mask
- 0: masked
- 1: enabled";
            sw = rw; hw = r;
            reset = 0x0;
        } mask_err_l_bndry_match_di6[6:6];
        field {
            name = "mask_err_l_bndry_match_di5";
            desc = "err_l_bndry_match_di5 interrupt mask
- 0: masked
- 1: enabled";
            sw = rw; hw = r;
            reset = 0x0;
        } mask_err_l_bndry_match_di5[5:5];
        field {
            name = "mask_err_l_bndry_match_di4";
            desc = "err_l_bndry_match_di4 interrupt mask
- 0: masked
- 1: enabled";
            sw = rw; hw = r;
            reset = 0x0;
        } mask_err_l_bndry_match_di4[4:4];
        field {
            name = "mask_err_l_bndry_match_di3";
            desc = "err_l_bndry_match_di3 interrupt mask
- 0: masked
- 1: enabled";
            sw = rw; hw = r;
            reset = 0x0;
        } mask_err_l_bndry_match_di3[3:3];
        field {
            name = "mask_err_l_bndry_match_di2";
            desc = "err_l_bndry_match_di2 interrupt mask
- 0: masked
- 1: enabled";
            sw = rw; hw = r;
            reset = 0x0;
        } mask_err_l_bndry_match_di2[2:2];
        field {
            name = "mask_err_l_bndry_match_di1";
            desc = "err_l_bndry_match_di1 interrupt mask
- 0: masked
- 1: enabled";
            sw = rw; hw = r;
            reset = 0x0;
        } mask_err_l_bndry_match_di1[1:1];
        field {
            name = "mask_err_l_bndry_m";
            desc = "err_l_bndry_match_di0 interrupt mask";
            sw = rw; hw = r;
            reset = 0x0;
        } mask_err_l_bndry_m[0:0];
    } MIPI_LINE_INTR_MSK @ 0x1094;
    reg {
        name = "MIPI_USERDEF_DT";
        desc = "MIPI_USERDEF_DT is the MIPI pixel bit width configuration register for the user-defined data type. (offset 0x1100; total reset 0x00000000; PROVEN: Hi3516E V300 data sheet (Issue 00B06, 2019-05-15), section 9.3.6, PDF page 548).";
        field {
            name = "reserved";
            desc = "Reserved";
            sw = r; hw = w;
            reset = 0x0;
        } reserved_31_15[31:15];
        field {
            name = "user_def3_dt";
            desc = "Bit width of the transferred pixel when the data type is user_def3
- 000: 8 bits
- 001: 10 bits
- 010: 12 bits
- 011: 14 bits
- 101:embed_data

Other values: reserved";
            sw = rw; hw = r;
            reset = 0x0;
        } user_def3_dt[14:12];
        field {
            name = "reserved";
            desc = "Reserved";
            sw = r; hw = w;
            reset = 0x0;
        } reserved_11_11[11:11];
        field {
            name = "user_def2_dt";
            desc = "Bit width of the transferred pixel when the data type is user_def2
- 000: 8 bits
- 001: 10 bits
- 010: 12 bits
- 011: 14 bits
- 101:embed_data

Other values: reserved";
            sw = rw; hw = r;
            reset = 0x0;
        } user_def2_dt[10:8];
        field {
            name = "reserved";
            desc = "Reserved";
            sw = r; hw = w;
            reset = 0x0;
        } reserved_7_7[7:7];
        field {
            name = "user_def1_dt";
            desc = "Bit width of the transferred pixel when the data type is user_def1
- 000: 8 bits
- 001: 10 bits
- 010: 12 bits
- 011: 14 bits
- 100: 16 bits
- 101:embed_data

Other values: reserved";
            sw = rw; hw = r;
            reset = 0x0;
        } user_def1_dt[6:4];
        field {
            name = "reserved";
            desc = "Reserved";
            sw = r; hw = w;
            reset = 0x0;
        } reserved_3_3[3:3];
        field {
            name = "user_def0_dt";
            desc = "Bit width of the transferred pixel when the data type is user_def0
- 000: 8 bits
- 001: 10 bits
- 010: 12 bits
- 011: 14 bits
- 101:embed_data

Other values: reserved";
            sw = rw; hw = r;
            reset = 0x0;
        } user_def0_dt[2:0];
    } MIPI_USERDEF_DT @ 0x1100;
    reg {
        name = "MIPI_USER_DEF";
        desc = "MIPI_USER_DEF is the MIPI enable configuration register for the user-defined data type. (offset 0x1104; total reset 0x10363534; PROVEN: Hi3516E V300 data sheet (Issue 00B06, 2019-05-15), section 9.3.6, PDF page 549).";
        field {
            name = "reserved";
            desc = "Reserved";
            sw = r; hw = w;
            reset = 0x0;
        } reserved_31_30[31:30];
        field {
            name = "user_def3";
            desc = "User-defined data type 3 The value of this field is used for matching the type of the sensor output data. This field works with user_def3_dt.";
            sw = rw; hw = r;
            reset = 0x10;
        } user_def3[29:24];
        field {
            name = "reserved";
            desc = "Reserved";
            sw = r; hw = w;
            reset = 0x0;
        } reserved_23_22[23:22];
        field {
            name = "user_def2";
            desc = "User-defined data type 2 The value of this field is used for matching the type of the sensor output data. This field works with user_def2_dt.";
            sw = rw; hw = r;
            reset = 0x36;
        } user_def2[21:16];
        field {
            name = "reserved";
            desc = "Reserved";
            sw = r; hw = w;
            reset = 0x0;
        } reserved_15_14[15:14];
        field {
            name = "user_def1";
            desc = "User-defined data type 1 The value of this field is used for matching the type of the sensor output data. This field works with user_def1_dt.";
            sw = rw; hw = r;
            reset = 0x35;
        } user_def1[13:8];
        field {
            name = "reserved";
            desc = "Reserved";
            sw = r; hw = w;
            reset = 0x0;
        } reserved_7_6[7:6];
        field {
            name = "user_def0";
            desc = "User-defined data type 0 The value of this field is used for matching the type of the sensor output data. This field works with user_def0_dt.";
            sw = rw; hw = r;
            reset = 0x34;
        } user_def0[5:0];
    } MIPI_USER_DEF @ 0x1104;
    reg {
        name = "MIPI_CTRL_MODE_HS";
        desc = "MIPI_CTRL_MODE_HS is the MIPI operating mode enable register. (offset 0x1108; total reset 0x00000000; PROVEN: Hi3516E V300 data sheet (Issue 00B06, 2019-05-15), section 9.3.6, PDF page 550).";
        field {
            name = "reserved";
            desc = "Reserved";
            sw = r; hw = w;
            reset = 0x0;
        } reserved_31_9[31:9];
        field {
            name = "user_def_en";
            desc = "User-defined mode enable
- 0: disabled
- 1: enabled";
            sw = rw; hw = r;
            reset = 0x0;
        } user_def_en[8:8];
        field {
            name = "reserved";
            desc = "Reserved";
            sw = r; hw = w;
            reset = 0x0;
        } reserved_7_5[7:5];
        field {
            name = "vc_mode";
            desc = "Share Vsync mode enable when the virtual channel distinguishes data of different exposure lengths
- 0: disabled
- 1: enabled";
            sw = rw; hw = r;
            reset = 0x0;
        } vc_mode[4:4];
        field {
            name = "reserved";
            desc = "Reserved";
            sw = r; hw = w;
            reset = 0x0;
        } reserved_3_1[3:1];
        field {
            name = "hdr_mode";
            desc = "Whether to enable data of different exposure lengths to be distinguished by data types
- 0: disabled
- 1: enabled";
            sw = rw; hw = r;
            reset = 0x0;
        } hdr_mode[0:0];
    } MIPI_CTRL_MODE_HS @ 0x1108;
    reg {
        name = "MIPI_DOL_ID_CODE0";
        desc = "MIPI_DOL_ID_CODE0 is MIPI DOL mode frame identification register 0. (offset 0x1200; total reset 0x02420241; PROVEN: Hi3516E V300 data sheet (Issue 00B06, 2019-05-15), section 9.3.6, PDF page 550).";
        field {
            name = "id_code_reg1";
            desc = "ID of SEF1 frame N in MIPI DOL mode";
            sw = rw; hw = r;
            reset = 0x242;
        } id_code_reg1[31:16];
        field {
            name = "id_code_reg0";
            desc = "ID of LEF frame N in MIPI DOL mode";
            sw = rw; hw = r;
            reset = 0x241;
        } id_code_reg0[15:0];
    } MIPI_DOL_ID_CODE0 @ 0x1200;
    reg {
        name = "MIPI_DOL_ID_CODE1";
        desc = "MIPI_DOL_ID_CODE1 is MIPI DOL mode frame identification register 1. (offset 0x1204; total reset 0x02510244; PROVEN: Hi3516E V300 data sheet (Issue 00B06, 2019-05-15), section 9.3.6, PDF page 550).";
        field {
            name = "id_code_reg3";
            desc = "ID of LEF frame (N + 1) in MIPI DOL mode";
            sw = rw; hw = r;
            reset = 0x251;
        } id_code_reg3[31:16];
        field {
            name = "id_code_reg2";
            desc = "ID of SEF2 frame N in MIPI DOL mode";
            sw = rw; hw = r;
            reset = 0x244;
        } id_code_reg2[15:0];
    } MIPI_DOL_ID_CODE1 @ 0x1204;
    reg {
        name = "MIPI_DOL_ID_CODE2";
        desc = "MIPI_DOL_ID_CODE2 is MIPI DOL mode frame identification register 2. (offset 0x1208; total reset 0x02540252; PROVEN: Hi3516E V300 data sheet (Issue 00B06, 2019-05-15), section 9.3.6, PDF page 551).";
        field {
            name = "id_code_reg5";
            desc = "ID of SEF2 frame (N + 1) in MIPI DOL mode";
            sw = rw; hw = r;
            reset = 0x254;
        } id_code_reg5[31:16];
        field {
            name = "id_code_reg4";
            desc = "ID of SEF1 frame (N + 1) in MIPI DOL mode";
            sw = rw; hw = r;
            reset = 0x252;
        } id_code_reg4[15:0];
    } MIPI_DOL_ID_CODE2 @ 0x1208;
    reg {
        name = "MIPI_CROP_START_CHN0";
        desc = "MIPI_CROP_START_CHN0 is the cropping start register for MIPI channel 0. (offset 0x1210; total reset 0x00000000; PROVEN: Hi3516E V300 data sheet (Issue 00B06, 2019-05-15), section 9.3.6, PDF page 551).";
        field {
            name = "Verticalcoordinateofthecropstartpointofmipi_start_y_chn0virtualchannel0";
            desc = "";
            sw = rw; hw = r;
            reset = 0x0;
        } Verticalcoordinateofthecropstartpointofmipi_start_y_chn0virtualchannel0[31:16];
        field {
            name = "Horizontalcoordinateofthecropstartpointofmipi_start_x_chn0virtualchannel0";
            desc = "";
            sw = rw; hw = r;
            reset = 0x0;
        } Horizontalcoordinateofthecropstartpointofmipi_start_x_chn0virtualchannel0[15:0];
    } MIPI_CROP_START_CHN0 @ 0x1210;
    reg {
        name = "MIPI_CROP_START_CHN1";
        desc = "MIPI_CROP_START_CHN1 is the cropping start register for MIPI channel 1. (offset 0x1214; total reset 0x00000000; PROVEN: Hi3516E V300 data sheet (Issue 00B06, 2019-05-15), section 9.3.6, PDF page 551).";
        field {
            name = "Verticalcoordinateofthecropstartpointofmipi_start_y_chn1virtualchannel1";
            desc = "";
            sw = rw; hw = r;
            reset = 0x0;
        } Verticalcoordinateofthecropstartpointofmipi_start_y_chn1virtualchannel1[31:16];
        field {
            name = "Horizontalcoordinateofthecropstartpointofmipi_start_x_chn1virtualchannel1";
            desc = "";
            sw = rw; hw = r;
            reset = 0x0;
        } Horizontalcoordinateofthecropstartpointofmipi_start_x_chn1virtualchannel1[15:0];
    } MIPI_CROP_START_CHN1 @ 0x1214;
    reg {
        name = "MIPI_IMGSIZE";
        desc = "MIPI_IMGSIZE is the MIPI image size register. (offset 0x1224; total reset 0x00000000; PROVEN: Hi3516E V300 data sheet (Issue 00B06, 2019-05-15), section 9.3.6, PDF page 551).";
        field {
            name = "Imageheight.Theconfiguredvalueisthemipi_imgheightactualvalueminus1.";
            desc = "";
            sw = rw; hw = r;
            reset = 0x0;
        } Imageheight_Theconfiguredvalueisthemipi_imgheightactualvalueminus1[31:16];
        field {
            name = "Imagewidth.Theconfiguredvalueisthemipi_imgwidthactualvalueminus1.";
            desc = "";
            sw = rw; hw = r;
            reset = 0x0;
        } Imagewidth_Theconfiguredvalueisthemipi_imgwidthactualvalueminus1[15:0];
    } MIPI_IMGSIZE @ 0x1224;
    reg {
        name = "MIPI_CTRL_MODE_PIXEL";
        desc = "MIPI_CTRL_MODE_PIXEL is the MIPI output operating mode enable register. (offset 0x1230; total reset 0x00000000; PROVEN: Hi3516E V300 data sheet (Issue 00B06, 2019-05-15), section 9.3.6, PDF page 552).";
        field {
            name = "reserved";
            desc = "Reserved";
            sw = r; hw = w;
            reset = 0x0;
        } reserved_31_15[31:15];
        field {
            name = "stagger_frm_num";
            desc = "Number of frames in staggered HDR mode
- 01: 2-frame HDR

Other values: reserved";
            sw = rw; hw = r;
            reset = 0x0;
        } stagger_frm_num[14:13];
        field {
            name = "stagger_hdr_mode";
            desc = "OmniVision staggered HDR mode enable
- 0: disabled
- 1: enabled";
            sw = rw; hw = r;
            reset = 0x0;
        } stagger_hdr_mode[12:12];
        field {
            name = "sync_clear_en";
            desc = "EOF auto clear enable
- 0: disabled
- 1: enabled";
            sw = rw; hw = r;
            reset = 0x0;
        } sync_clear_en[11:11];
        field {
            name = "reserved";
            desc = "Reserved";
            sw = r; hw = w;
            reset = 0x0;
        } reserved_10_5[10:5];
        field {
            name = "mipi_dol_mode";
            desc = "MIPI DOL mode enable
- 0: disabled
- 1: enabled";
            sw = rw; hw = r;
            reset = 0x0;
        } mipi_dol_mode[4:4];
        field {
            name = "reserved";
            desc = "Reserved";
            sw = r; hw = w;
            reset = 0x0;
        } reserved_3_1[3:1];
        field {
            name = "crop_en";
            desc = "Cropping enable
- 0: disabled
- 1: enabled";
            sw = rw; hw = r;
            reset = 0x0;
        } crop_en[0:0];
    } MIPI_CTRL_MODE_PIXEL @ 0x1230;
    reg {
        name = "MIPI_DUMMY_PIX_REG";
        desc = "MIPI_DUMMY_PIX_REG is the MIPI dummy line pixel value register. (offset 0x1240; total reset 0x00000000; PROVEN: Hi3516E V300 data sheet (Issue 00B06, 2019-05-15), section 9.3.6, PDF page 552).";
        field {
            name = "reserved";
            desc = "Reserved";
            sw = r; hw = w;
            reset = 0x0;
        } reserved_31_16[31:16];
        field {
            name = "dummy_pix_reg";
            desc = "Dummy line pixel value in staggered HDR mode";
            sw = rw; hw = r;
            reset = 0x0;
        } dummy_pix_reg[15:0];
    } MIPI_DUMMY_PIX_REG @ 0x1240;
    reg {
        name = "MIPI_IMGSIZE0_STATIS";
        desc = "MIPI_IMGSIZE0_STATIS is the MIPI VC 0 transferred image size register. (offset 0x1250; total reset 0x00000000; PROVEN: Hi3516E V300 data sheet (Issue 00B06, 2019-05-15), section 9.3.6, PDF page 553).";
        field {
            name = "Heightofthepreviousframeofimageimgheight_statis_vc0transferredbyvirtualchannel0inMIPImode";
            desc = "";
            sw = r; hw = w;
            reset = 0x0;
        } Heightofthepreviousframeofimageimgheight_statis_vc0transferredbyvirtualchannel0inMIPImode[31:16];
        field {
            name = "Widthofthepreviousframeofimageimgwidth_statis_vc0transferredbyvirtualchannel0inMIPImode";
            desc = "";
            sw = r; hw = w;
            reset = 0x0;
        } Widthofthepreviousframeofimageimgwidth_statis_vc0transferredbyvirtualchannel0inMIPImode[15:0];
    } MIPI_IMGSIZE0_STATIS @ 0x1250;
    reg {
        name = "MIPI_IMGSIZE1_STATIS";
        desc = "MIPI_IMGSIZE1_STATIS is the MIPI VC 1 transferred image size register. (offset 0x1254; total reset 0x00000000; PROVEN: Hi3516E V300 data sheet (Issue 00B06, 2019-05-15), section 9.3.6, PDF page 553).";
        field {
            name = "Heightofthepreviousframeofimageimgheight_statis_vc1transferredbyvirtualchannel1inMIPImode";
            desc = "";
            sw = r; hw = w;
            reset = 0x0;
        } Heightofthepreviousframeofimageimgheight_statis_vc1transferredbyvirtualchannel1inMIPImode[31:16];
        field {
            name = "Widthofthepreviousframeofimageimgwidth_statis_vc1transferredbyvirtualchannel1inMIPImode";
            desc = "";
            sw = r; hw = w;
            reset = 0x0;
        } Widthofthepreviousframeofimageimgwidth_statis_vc1transferredbyvirtualchannel1inMIPImode[15:0];
    } MIPI_IMGSIZE1_STATIS @ 0x1254;
    reg {
        name = "MIPI_CTRL_INT_RAW";
        desc = "MIPI_CTRL_INT_RAW is the MIPI read data error raw interrupt status register. (offset 0x12F0; total reset 0x00000000; PROVEN: Hi3516E V300 data sheet (Issue 00B06, 2019-05-15), section 9.3.6, PDF page 553).";
        field {
            name = "reserved";
            desc = "Reserved";
            sw = r; hw = w;
            reset = 0x0;
        } reserved_31_18[31:18];
        field {
            name = "int_dfifo_rderr_raw";
            desc = "MIPI CTRL read data FIFO raw interrupt status
- 0: No raw interrupt is generated.
- 1: A raw interrupt is generated.

Access type WC in the data sheet: written 1 clears the bit.";
            sw = rw; hw = w; onwrite = woclr;
            reset = 0x0;
        } int_dfifo_rderr_raw[17:17];
        field {
            name = "int_cfifo_rderr_raw";
            desc = "MIPI CTRL read command FIFO raw interrupt status
- 0: No raw interrupt is generated.
- 1: A raw interrupt is generated.

Access type WC in the data sheet: written 1 clears the bit.";
            sw = rw; hw = w; onwrite = woclr;
            reset = 0x0;
        } int_cfifo_rderr_raw[16:16];
        field {
            name = "reserved";
            desc = "Reserved";
            sw = r; hw = w;
            reset = 0x0;
        } reserved_15_5[15:5];
        field {
            name = "int_vsync_raw";
            desc = "MIPI CTR Vsync raw interrupt status
- 0: There is no raw interrupt.
- 1: There is a raw interrupt.

Access type WC in the data sheet: written 1 clears the bit.";
            sw = rw; hw = w; onwrite = woclr;
            reset = 0x0;
        } int_vsync_raw[4:4];
        field {
            name = "reserved";
            desc = "Reserved";
            sw = r; hw = w;
            reset = 0x0;
        } reserved_3_2[3:2];
        field {
            name = "int_dfifo_wrerr_raw";
            desc = "MIPI CTRL write data FIFO raw interrupt status
- 0: No raw interrupt is generated.
- 1: A raw interrupt is generated.

Access type WC in the data sheet: written 1 clears the bit.";
            sw = rw; hw = w; onwrite = woclr;
            reset = 0x0;
        } int_dfifo_wrerr_raw[1:1];
        field {
            name = "int_cfifo_wrerr_raw";
            desc = "MIPI CTRL write command FIFO raw interrupt status
- 0: No raw interrupt is generated.
- 1: A raw interrupt is generated.

Access type WC in the data sheet: written 1 clears the bit.";
            sw = rw; hw = w; onwrite = woclr;
            reset = 0x0;
        } int_cfifo_wrerr_raw[0:0];
    } MIPI_CTRL_INT_RAW @ 0x12F0;
    reg {
        name = "MIPI_CTRL_INT";
        desc = "MIPI_CTRL_INT is the MIPI read data error interrupt status register. (offset 0x12F4; total reset 0x00000000; PROVEN: Hi3516E V300 data sheet (Issue 00B06, 2019-05-15), section 9.3.6, PDF page 554).";
        field {
            name = "reserved";
            desc = "Reserved";
            sw = r; hw = w;
            reset = 0x0;
        } reserved_31_18[31:18];
        field {
            name = "int_dfifo_rderr_st";
            desc = "MIPI CTRL read data FIFO interrupt status
- 0: No interrupt is generated.
- 1: An interrupt is generated.";
            sw = r; hw = w;
            reset = 0x0;
        } int_dfifo_rderr_st[17:17];
        field {
            name = "int_cfifo_rderr_st";
            desc = "MIPI CTRL read command FIFO interrupt status
- 0: No interrupt is generated.
- 1: An interrupt is generated.";
            sw = r; hw = w;
            reset = 0x0;
        } int_cfifo_rderr_st[16:16];
        field {
            name = "reserved";
            desc = "Reserved";
            sw = r; hw = w;
            reset = 0x0;
        } reserved_15_5[15:5];
        field {
            name = "int_vsync_st";
            desc = "MIPI CTR Vsync interrupt status
- 0: No interrupt is generated.
- 1: An interrupt is generated.";
            sw = r; hw = w;
            reset = 0x0;
        } int_vsync_st[4:4];
        field {
            name = "reserved";
            desc = "Reserved";
            sw = r; hw = w;
            reset = 0x0;
        } reserved_3_2[3:2];
        field {
            name = "int_dfifo_wrerr_st";
            desc = "MIPI CTRL write data FIFO interrupt status
- 0: No interrupt is generated.
- 1: An interrupt is generated.";
            sw = r; hw = w;
            reset = 0x0;
        } int_dfifo_wrerr_st[1:1];
        field {
            name = "int_cfifo_wrerr_st";
            desc = "MIPI CTRL write command FIFO interrupt status
- 0: No interrupt is generated.
- 1: An interrupt is generated.";
            sw = r; hw = w;
            reset = 0x0;
        } int_cfifo_wrerr_st[0:0];
    } MIPI_CTRL_INT @ 0x12F4;
    reg {
        name = "MIPI_CTRL_INT_MSK";
        desc = "MIPI_CTRL_INT_MSK is the MIPI read data error interrupt mask register. (offset 0x12F8; total reset 0x00000000; PROVEN: Hi3516E V300 data sheet (Issue 00B06, 2019-05-15), section 9.3.6, PDF page 555).";
        field {
            name = "reserved";
            desc = "Reserved";
            sw = r; hw = w;
            reset = 0x0;
        } reserved_31_18[31:18];
        field {
            name = "int_dfifo_rderr_msk";
            desc = "MIPI CTRL read data FIFO interrupt enable
- 0: masked
- 1: enabled";
            sw = rw; hw = r;
            reset = 0x0;
        } int_dfifo_rderr_msk[17:17];
        field {
            name = "int_cfifo_rderr_msk";
            desc = "MIPI CTRL read command FIFO interrupt enable
- 0: masked
- 1: enabled";
            sw = rw; hw = r;
            reset = 0x0;
        } int_cfifo_rderr_msk[16:16];
        field {
            name = "reserved";
            desc = "Reserved";
            sw = r; hw = w;
            reset = 0x0;
        } reserved_15_5[15:5];
        field {
            name = "int_vsync_msk";
            desc = "MIPI CTR Vsync interrupt enable
- 0: masked
- 1: enabled";
            sw = rw; hw = r;
            reset = 0x0;
        } int_vsync_msk[4:4];
        field {
            name = "reserved";
            desc = "Reserved";
            sw = r; hw = w;
            reset = 0x0;
        } reserved_3_2[3:2];
        field {
            name = "int_dfifo_wrerr_msk";
            desc = "MIPI CTRL write data FIFO interrupt enable
- 0: masked
- 1: enabled";
            sw = rw; hw = r;
            reset = 0x0;
        } int_dfifo_wrerr_msk[1:1];
        field {
            name = "int_cfifo_wrerr_msk";
            desc = "MIPI CTRL write command FIFO interrupt enable
- 0: masked
- 1: enabled";
            sw = rw; hw = r;
            reset = 0x0;
        } int_cfifo_wrerr_msk[0:0];
    } MIPI_CTRL_INT_MSK @ 0x12F8;
    reg {
        name = "LVDS_WDR";
        desc = "LVDS_WDR is the LVDS WDR control register. (offset 0x1300; total reset 0x00000000; PROVEN: Hi3516E V300 data sheet (Issue 00B06, 2019-05-15), section 9.3.6, PDF page 556).";
        field {
            name = "reserved";
            desc = "Reserved";
            sw = r; hw = w;
            reset = 0x0;
        } reserved_31_16[31:16];
        field {
            name = "lvds_wdr_id_shift";
            desc = "IMX136 frame ID shift register, indicating the number of bits to be shifted rightwards to make the frame ID be in bit 0";
            sw = rw; hw = r;
            reset = 0x0;
        } lvds_wdr_id_shift[15:12];
        field {
            name = "lvds_wdr_mode";
            desc = "LVDS WDR mode select
- 0x0: WDR mode with the SOF-EOF flag. In this mode, the long exposure frame and short exposure frame have independent synchronization codes.
- 0x2: HiSPI WDR mode. In this mode, the long and short exposure frames share one SOF-

EOF flag, and the first several lines of the short exposure frame are stuffed with 0x04.
- 0x4: SONY DOL WDR mode. In this mode, the synchronization code consists of four fields, the SAV-EAV flag is used, and the long exposure frame and short exposure frame have independent synchronization codes.
- 0x5: SONY DOL mode. In this mode, the synchronization code consists of four fields.

The SAV-EAV flag mode is used. The long and short exposure frames share a group of sync code, and the region between the long and short exposure frames is the blanking region.
- 0x6: SONY DOL WDR mode. In this mode, the synchronization code consists of five fields, and the fifth field indicates the long or short frame.
- 0x8: SONY IMX136 mode, frame WDR mode. Do not enable WDR_EN.
- 0x9: SHARP long and short exposure frame interleaving mode. The long exposure frame is before the short exposure frame.
- 0xA: SHARP long and short exposure frame interleaving mode. The short exposure frame is before the long exposure frame.

Other values: reserved";
            sw = rw; hw = r;
            reset = 0x0;
        } lvds_wdr_mode[11:8];
        field {
            name = "reserved";
            desc = "Reserved";
            sw = r; hw = w;
            reset = 0x0;
        } reserved_7_6[7:6];
        field {
            name = "lvds_wdr_num";
            desc = "WDR mode configuration
- 01: 2-frame WDR

Other values: reserved";
            sw = rw; hw = r;
            reset = 0x0;
        } lvds_wdr_num[5:4];
        field {
            name = "reserved";
            desc = "Reserved";
            sw = r; hw = w;
            reset = 0x0;
        } reserved_3_1[3:1];
        field {
            name = "lvds_wdr_en";
            desc = "WDR enable
- 0: linear mode
- 1: WDR mode";
            sw = rw; hw = r;
            reset = 0x0;
        } lvds_wdr_en[0:0];
    } LVDS_WDR @ 0x1300;
    reg {
        name = "LVDS_DOLSCD_HBLK";
        desc = "LVDS_DOLSCD_HBLK is the LVDS SCD control register. (offset 0x1304; total reset 0x00000000; PROVEN: Hi3516E V300 data sheet (Issue 00B06, 2019-05-15), section 9.3.6, PDF page 557).";
        field {
            name = "dol_hblank2";
            desc = "HBLANK2 value in DOL mode";
            sw = rw; hw = r;
            reset = 0x0;
        } dol_hblank2[31:16];
        field {
            name = "dol_hblank1";
            desc = "HBLANK1 value in DOL mode";
            sw = rw; hw = r;
            reset = 0x0;
        } dol_hblank1[15:0];
    } LVDS_DOLSCD_HBLK @ 0x1304;
    reg {
        name = "LVDS_CTRL";
        desc = "LVDS_CTRL is the LVDS control register. (offset 0x1308; total reset 0x00000330; PROVEN: Hi3516E V300 data sheet (Issue 00B06, 2019-05-15), section 9.3.6, PDF page 557).";
        field {
            name = "reserved";
            desc = "Reserved";
            sw = r; hw = w;
            reset = 0x0;
        } reserved_31_13[31:13];
        field {
            name = "lvds_crop_en";
            desc = "Image cropping enable in LVDS or HiSPi mode
- 0: disabled
- 1: enabled";
            sw = rw; hw = r;
            reset = 0x0;
        } lvds_crop_en[12:12];
        field {
            name = "reserved";
            desc = "Reserved";
            sw = r; hw = w;
            reset = 0x0;
        } reserved_11_10[11:10];
        field {
            name = "lvds_code_big_endian";
            desc = "Transfer sequence of serial bits of transferred RAW data sync code (sync_code) in LVDS/HiSPI mode
- 0: LSB. Lower bits are transferred first. The sequence of the received sync code (sync_code) serial data is bit 0, bit 1, ..., and bit 11.
- 1: MSB. Upper bits are transferred first. The sequence of the received sync code (sync_code) serial data is bit 11, bit 10, ..., and bit 0.";
            sw = rw; hw = r;
            reset = 0x1;
        } lvds_code_big_endian[9:9];
        field {
            name = "lvds_pix_big_endian";
            desc = "Transfer sequence of serial bits of transferred RAW data valid pixels in LVDS/HiSPI mode
- 0: LSB. Lower bits are transferred first. The";
            sw = rw; hw = r;
            reset = 0x1;
        } lvds_pix_big_endian[8:8];
        field {
            name = "reserved";
            desc = "Reserved";
            sw = r; hw = w;
            reset = 0x0;
        } reserved_7_7[7:7];
        field {
            name = "lvds_raw_type";
            desc = "Type of transferred RAW data in LVDS/HiSPI mode
- 001: Raw 8-bit
- 010: Raw 10-bit
- 011: Raw 12-bit
- 100: Raw 14-bit

Other values: reserved";
            sw = rw; hw = r;
            reset = 0x3;
        } lvds_raw_type[6:4];
        field {
            name = "reserved";
            desc = "Reserved";
            sw = r; hw = w;
            reset = 0x0;
        } reserved_3_1[3:1];
        field {
            name = "lvds_sync_mode";
            desc = "Frame/Line sync mode in LVDS mode
- 0: The sync mode is SOF/EOF/SOL/EOL mode. SOF indicates the start of the first line of the valid region, EOF indicates the end of the last line of the valid region, and SOL and

EOL indicate the start and end of other valid regions respectively.
- 1: The sync mode is SAV/EAV mode.

SAV(Invalid) and EAV(Invalid) indicate the invalid data of the blanking region, and SAV(Valid) and EAV(Valid) indicate pixel data of the valid region.";
            sw = rw; hw = r;
            reset = 0x0;
        } lvds_sync_mode[0:0];
    } LVDS_CTRL @ 0x1308;
    reg {
        name = "LVDS_IMGSIZE";
        desc = "LVDS_IMGSIZE is the LVDS image size register. (offset 0x130C; total reset 0x00000000; PROVEN: Hi3516E V300 data sheet (Issue 00B06, 2019-05-15), section 9.3.6, PDF page 558).";
        field {
            name = "lvds_imgheight";
            desc = "Image height minus 1";
            sw = rw; hw = r;
            reset = 0x0;
        } lvds_imgheight[31:16];
        field {
            name = "lvds_imgwidth_lane";
            desc = "Width of the image transferred by each channel minus 1";
            sw = rw; hw = r;
            reset = 0x0;
        } lvds_imgwidth_lane[15:0];
    } LVDS_IMGSIZE @ 0x130C;
    reg {
        name = "LVDS_CROP_START0";
        desc = "LVDS_CROP_START0 is the LVDS frame 1 cropping register. (offset 0x1310; total reset 0x00000000; PROVEN: Hi3516E V300 data sheet (Issue 00B06, 2019-05-15), section 9.3.6, PDF page 559).";
        field {
            name = "Heightofthecroppingstartpointforthefirstlvds_start_y0frame";
            desc = "";
            sw = rw; hw = r;
            reset = 0x0;
        } Heightofthecroppingstartpointforthefirstlvds_start_y0frame[31:16];
        field {
            name = "Widthofthecroppingstartpointforthefirstframe.Theconfiguredvalueisthestartpixellvds_start_x0_lanetobecroppeddividedbythenumberofchannels.";
            desc = "";
            sw = rw; hw = r;
            reset = 0x0;
        } Widthofthecroppingstartpointforthefirstframe_Theconfiguredvalueisthestartpixellvds_start_x0_lanetobecroppeddividedbythenumberofchannels[15:0];
    } LVDS_CROP_START0 @ 0x1310;
    reg {
        name = "LVDS_CROP_START1";
        desc = "LVDS_CROP_START1 is the LVDS frame 2 cropping register. (offset 0x1314; total reset 0x00000000; PROVEN: Hi3516E V300 data sheet (Issue 00B06, 2019-05-15), section 9.3.6, PDF page 559).";
        field {
            name = "Heightofthecroppingstartpointforthelvds_start_y1secondframe";
            desc = "";
            sw = rw; hw = r;
            reset = 0x0;
        } Heightofthecroppingstartpointforthelvds_start_y1secondframe[31:16];
        field {
            name = "Widthofthecroppingstartpointforthesecondframe.Theconfiguredvalueisthestartlvds_start_x1_lanepixeltobecroppeddividedbythenumberofchannels.";
            desc = "";
            sw = rw; hw = r;
            reset = 0x0;
        } Widthofthecroppingstartpointforthesecondframe_Theconfiguredvalueisthestartlvds_start_x1_lanepixeltobecroppeddividedbythenumberofchannels[15:0];
    } LVDS_CROP_START1 @ 0x1314;
    reg {
        name = "LVDS_LANE(M)_SOF_01";
        desc = "LVDS_LANE(M)_SOF_01 is the SOF synchronization code configuration register for lane (M) in LVDS or HiSPI mode. (offset 0x1320; total reset 0x00000000; PROVEN: Hi3516E V300 data sheet (Issue 00B06, 2019-05-15), section 9.3.6, PDF page 559).";
        field {
            name = "Lane(M)SOFsynchronizationcodeofframe1inLVDSorHiSPImodelane(M)_sof_1ThisfieldisconfigurableonlyinWDRmode,andtheconfigurationisinvalidinlinearmode.";
            desc = "";
            sw = rw; hw = r;
            reset = 0x0;
        } Lane_M_SOFsynchronizationcodeofframe1inLVDSorHiSPImodelane_M_sof_1ThisfieldisconfigurableonlyinWDRmode_andtheconfigurationisinvalidinlinearmode[31:16];
        field {
            name = "Lane(M)SOFsynchronizationcodeofframe0inLVDSorHiSPImodelane(M)_sof_0InWDRmode,thevalueistheSOFofframe0.Inlinearmode,thevalueistheSOF.";
            desc = "";
            sw = rw; hw = r;
            reset = 0x0;
        } Lane_M_SOFsynchronizationcodeofframe0inLVDSorHiSPImodelane_M_sof_0InWDRmode_thevalueistheSOFofframe0_Inlinearmode_thevalueistheSOF[15:0];
    } LVDS_LANE_M_SOF_01 @ 0x1320;
    reg {
        name = "LVDS_LANE(M)_EOF_01";
        desc = "LVDS_LANE(M)_EOF_01 is the EOF synchronization code configuration register for lane (M) in LVDS or HiSPI mode. (offset 0x1328; total reset 0x00000000; PROVEN: Hi3516E V300 data sheet (Issue 00B06, 2019-05-15), section 9.3.6, PDF page 560).";
        field {
            name = "Lane(M)EOFsynchronizationcodeofframe1inLVDSorHiSPImodelane(M)_eof_1ThisfieldisconfigurableonlyinWDRmode,andtheconfigurationisinvalidinlinearmode.";
            desc = "";
            sw = rw; hw = r;
            reset = 0x0;
        } Lane_M_EOFsynchronizationcodeofframe1inLVDSorHiSPImodelane_M_eof_1ThisfieldisconfigurableonlyinWDRmode_andtheconfigurationisinvalidinlinearmode[31:16];
        field {
            name = "Lane(M)0EOFsynchronizationcodeofframe0inLVDSorHiSPImodelane(M)_eof_0InWDRmode,thevalueistheEOFofframe0.Inlinearmode,thevalueistheEOF.";
            desc = "";
            sw = rw; hw = r;
            reset = 0x0;
        } Lane_M_0EOFsynchronizationcodeofframe0inLVDSorHiSPImodelane_M_eof_0InWDRmode_thevalueistheEOFofframe0_Inlinearmode_thevalueistheEOF[15:0];
    } LVDS_LANE_M_EOF_01 @ 0x1328;
    reg {
        name = "LVDS_LANE(M)_SOL_01";
        desc = "LVDS_LANE(M)_SOL_01 is the SOL synchronization code configuration register for lane (M) in LVDS or HiSPI mode. (offset 0x1330; total reset 0x00000000; PROVEN: Hi3516E V300 data sheet (Issue 00B06, 2019-05-15), section 9.3.6, PDF page 560).";
        field {
            name = "Lane(M)SOLsynchronizationcodeofframe1inLVDSorHiSPImodelane(M)_sol_1ThisfieldisconfigurableonlyinWDRmode,andtheconfigurationisinvalidinlinearmode.";
            desc = "";
            sw = rw; hw = r;
            reset = 0x0;
        } Lane_M_SOLsynchronizationcodeofframe1inLVDSorHiSPImodelane_M_sol_1ThisfieldisconfigurableonlyinWDRmode_andtheconfigurationisinvalidinlinearmode[31:16];
        field {
            name = "Lane(M)SOLsynchronizationcodeofframe0inLVDSorHiSPImodelane(M)_sol_0InWDRmode,thevalueistheSOLofframe0.Inlinearmode,thevalueistheSOL.";
            desc = "";
            sw = rw; hw = r;
            reset = 0x0;
        } Lane_M_SOLsynchronizationcodeofframe0inLVDSorHiSPImodelane_M_sol_0InWDRmode_thevalueistheSOLofframe0_Inlinearmode_thevalueistheSOL[15:0];
    } LVDS_LANE_M_SOL_01 @ 0x1330;
    reg {
        name = "LVDS_LANE(M)_EOL_01";
        desc = "LVDS_LANE(M)_EOL_01 is the EOL synchronization code configuration register for lane (M) in LVDS or HiSPI mode. (offset 0x1338; total reset 0x00000000; PROVEN: Hi3516E V300 data sheet (Issue 00B06, 2019-05-15), section 9.3.6, PDF page 560).";
        field {
            name = "Lane(M)EOLsynchronizationcodeofframe1inLVDSorHiSPImodelane(M)_eol_1ThisfieldisconfigurableonlyinWDRmode,andtheconfigurationisinvalidinlinearmode.";
            desc = "";
            sw = rw; hw = r;
            reset = 0x0;
        } Lane_M_EOLsynchronizationcodeofframe1inLVDSorHiSPImodelane_M_eol_1ThisfieldisconfigurableonlyinWDRmode_andtheconfigurationisinvalidinlinearmode[31:16];
    } LVDS_LANE_M_EOL_01 @ 0x1338;
    reg {
        name = "LVDS_LANE(M)_NXT_SOF_01";
        desc = "LVDS_LANE(M)_NXT_SOF_01 is the lane (M) SOF synchronization code configuration register for frame (N + 1) in LVDS or HiSPI mode. (offset 0x1520; total reset 0x00000000; PROVEN: Hi3516E V300 data sheet (Issue 00B06, 2019-05-15), section 9.3.6, PDF page 561).";
        field {
            name = "Lane(M)SOFsynchronizationcodeofframe1inLVDSorHiSPImodelane(M)_nxt_sof_1ThisfieldisconfigurableonlyinWDRmode,andtheconfigurationisinvalidinlinearmode.";
            desc = "";
            sw = rw; hw = r;
            reset = 0x0;
        } Lane_M_SOFsynchronizationcodeofframe1inLVDSorHiSPImodelane_M_nxt_sof_1ThisfieldisconfigurableonlyinWDRmode_andtheconfigurationisinvalidinlinearmode[31:16];
        field {
            name = "Lane(M)SOFsynchronizationcodeofframe0inLVDSorHiSPImodelane(M)_nxt_sof_0InWDRmode,thevalueistheSOFofframe0.Inlinearmode,thevalueistheSOF.";
            desc = "";
            sw = rw; hw = r;
            reset = 0x0;
        } Lane_M_SOFsynchronizationcodeofframe0inLVDSorHiSPImodelane_M_nxt_sof_0InWDRmode_thevalueistheSOFofframe0_Inlinearmode_thevalueistheSOF[15:0];
    } LVDS_LANE_M_NXT_SOF_01 @ 0x1520;
    reg {
        name = "LVDS_LANE(M)_NXT_EOF_01";
        desc = "LVDS_LANE(M)_NXT_EOF_01 is the lane (M) EOF synchronization code configuration register for frame (N + 1) in LVDS or HiSPI mode. (offset 0x1528; total reset 0x00000000; PROVEN: Hi3516E V300 data sheet (Issue 00B06, 2019-05-15), section 9.3.6, PDF page 561).";
        field {
            name = "Lane(M)EOFsynchronizationcodeofframe1inLVDSorHiSPImodelane(M)_nxt_eof_1ThisfieldisconfigurableonlyinWDRmode,andtheconfigurationisinvalidinlinearmode.";
            desc = "";
            sw = rw; hw = r;
            reset = 0x0;
        } Lane_M_EOFsynchronizationcodeofframe1inLVDSorHiSPImodelane_M_nxt_eof_1ThisfieldisconfigurableonlyinWDRmode_andtheconfigurationisinvalidinlinearmode[31:16];
        field {
            name = "Lane(M)EOFsynchronizationcodeofframe0inLVDSorHiSPImodelane(M)_nxt_eof_0InWDRmode,thevalueistheEOFofframe0.Inlinearmode,thevalueistheEOF.";
            desc = "";
            sw = rw; hw = r;
            reset = 0x0;
        } Lane_M_EOFsynchronizationcodeofframe0inLVDSorHiSPImodelane_M_nxt_eof_0InWDRmode_thevalueistheEOFofframe0_Inlinearmode_thevalueistheEOF[15:0];
    } LVDS_LANE_M_NXT_EOF_01 @ 0x1528;
    reg {
        name = "LVDS_LANE(M)_NXT_SOL_01";
        desc = "LVDS_LANE(M)_NXT_SOL_01 is the lane (M) SOL synchronization code configuration register for fame (N + 1) in LVDS or HiSPI mode. (offset 0x1530; total reset 0x00000000; PROVEN: Hi3516E V300 data sheet (Issue 00B06, 2019-05-15), section 9.3.6, PDF page 562).";
        field {
            name = "Lane(M)SOLsynchronizationcodeofframe1inLVDSorHiSPImodelane(M)_nxt_sol_1ThisfieldisconfigurableonlyinWDRmode,andtheconfigurationisinvalidinlinearmode.";
            desc = "";
            sw = rw; hw = r;
            reset = 0x0;
        } Lane_M_SOLsynchronizationcodeofframe1inLVDSorHiSPImodelane_M_nxt_sol_1ThisfieldisconfigurableonlyinWDRmode_andtheconfigurationisinvalidinlinearmode[31:16];
        field {
            name = "Lane(M)SOLsynchronizationcodeofframe0inLVDSorHiSPImodelane(M)_nxt_sol_0InWDRmode,thevalueistheSOLofframe0.Inlinearmode,thevalueistheSOL.";
            desc = "";
            sw = rw; hw = r;
            reset = 0x0;
        } Lane_M_SOLsynchronizationcodeofframe0inLVDSorHiSPImodelane_M_nxt_sol_0InWDRmode_thevalueistheSOLofframe0_Inlinearmode_thevalueistheSOL[15:0];
    } LVDS_LANE_M_NXT_SOL_01 @ 0x1530;
    reg {
        name = "LVDS_LANE(M)_NXT_EOL_01";
        desc = "LVDS_LANE(M)_NXT_EOL_01 is the lane (M) EOL synchronization code configuration register for frame (N + 1) in LVDS or HiSPI mode. (offset 0x1538; total reset 0x00000000; PROVEN: Hi3516E V300 data sheet (Issue 00B06, 2019-05-15), section 9.3.6, PDF page 562).";
        field {
            name = "Lane(M)EOLsynchronizationcodeofframe1inLVDSorHiSPImodelane(M)_nxt_eol_1ThisfieldisconfigurableonlyinWDRmode,andtheconfigurationisinvalidinlinearmode.";
            desc = "";
            sw = rw; hw = r;
            reset = 0x0;
        } Lane_M_EOLsynchronizationcodeofframe1inLVDSorHiSPImodelane_M_nxt_eol_1ThisfieldisconfigurableonlyinWDRmode_andtheconfigurationisinvalidinlinearmode[31:16];
        field {
            name = "Lane(M)EOLsynchronizationcodeofframe0inLVDSorHiSPImodelane(M)_nxt_eol_0InWDRmode,thevalueistheEOLofframe0.Inlinearmode,thevalueistheEOL.";
            desc = "";
            sw = rw; hw = r;
            reset = 0x0;
        } Lane_M_EOLsynchronizationcodeofframe0inLVDSorHiSPImodelane_M_nxt_eol_0InWDRmode_thevalueistheEOLofframe0_Inlinearmode_thevalueistheEOL[15:0];
    } LVDS_LANE_M_NXT_EOL_01 @ 0x1538;
    reg {
        name = "LVDS_LI_WORD0";
        desc = "LVDS_LI_WORD0 is the LVDS DOL mode frame 0 LI register. (offset 0x1720; total reset 0x02110201; PROVEN: Hi3516E V300 data sheet (Issue 00B06, 2019-05-15), section 9.3.6, PDF page 562).";
        field {
            name = "LEFlineinformationinDOLmode(forframeli_word0_1N+1)";
            desc = "";
            sw = rw; hw = r;
            reset = 0x211;
        } LEFlineinformationinDOLmode_forframeli_word0_1N_1[31:16];
        field {
            name = "LEFlineinformationinDOLmode(forframeli_word0_0N)";
            desc = "";
            sw = rw; hw = r;
            reset = 0x201;
        } LEFlineinformationinDOLmode_forframeli_word0_0N[15:0];
    } LVDS_LI_WORD0 @ 0x1720;
    reg {
        name = "LVDS_LI_WORD1";
        desc = "LVDS_LI_WORD1 is the LVDS DOL mode frame 1 LI register. (offset 0x1724; total reset 0x02120202; PROVEN: Hi3516E V300 data sheet (Issue 00B06, 2019-05-15), section 9.3.6, PDF page 563).";
        field {
            name = "SEF1lineinformationinDOLmode(forli_word1_1frameN+1)";
            desc = "";
            sw = rw; hw = r;
            reset = 0x212;
        } SEF1lineinformationinDOLmode_forli_word1_1frameN_1[31:16];
        field {
            name = "SEF1lineinformationinDOLmode(forli_word1_0frameN)";
            desc = "";
            sw = rw; hw = r;
            reset = 0x202;
        } SEF1lineinformationinDOLmode_forli_word1_0frameN[15:0];
    } LVDS_LI_WORD1 @ 0x1724;
    reg {
        name = "LVDS_LI_WORD3";
        desc = "LVDS_LI_WORD3 is the LVDS DOL mode frame 3 LI register. (offset 0x172C; total reset 0x02180208; PROVEN: Hi3516E V300 data sheet (Issue 00B06, 2019-05-15), section 9.3.6, PDF page 563).";
        field {
            name = "SEF3lineinformationinDOLmode(forli_word3_1frameN+1)";
            desc = "";
            sw = rw; hw = r;
            reset = 0x218;
        } SEF3lineinformationinDOLmode_forli_word3_1frameN_1[31:16];
        field {
            name = "SEF3lineinformationinDOLmode(forli_word3_0frameN)";
            desc = "";
            sw = rw; hw = r;
            reset = 0x208;
        } SEF3lineinformationinDOLmode_forli_word3_0frameN[15:0];
    } LVDS_LI_WORD3 @ 0x172C;
    reg {
        name = "LVDS_IMGSIZE0_STATIS";
        desc = "LVDS_IMGSIZE0_STATIS is the LVDS LEF image size statistics register. (offset 0x1780; total reset 0x00000000; PROVEN: Hi3516E V300 data sheet (Issue 00B06, 2019-05-15), section 9.3.6, PDF page 563).";
        field {
            name = "Heightoftheimagetransferredbyvirtuallvds_imgheight0channel0inLVDSorHiSPImode";
            desc = "";
            sw = r; hw = w;
            reset = 0x0;
        } Heightoftheimagetransferredbyvirtuallvds_imgheight0channel0inLVDSorHiSPImode[31:16];
        field {
            name = "Widthoftheimagetransferredbyvirtuallvds_imgwidth0channel0inLVDSorHiSPImode";
            desc = "";
            sw = r; hw = w;
            reset = 0x0;
        } Widthoftheimagetransferredbyvirtuallvds_imgwidth0channel0inLVDSorHiSPImode[15:0];
    } LVDS_IMGSIZE0_STATIS @ 0x1780;
    reg {
        name = "LVDS_IMGSIZE1_STATIS";
        desc = "LVDS_IMGSIZE1_STATIS is the LVDS SEF 1 image size statistics register. (offset 0x1784; total reset 0x00000000; PROVEN: Hi3516E V300 data sheet (Issue 00B06, 2019-05-15), section 9.3.6, PDF page 563).";
        field {
            name = "lvds_imgheight1";
            desc = "Height of the image transferred by virtual";
            sw = r; hw = w;
            reset = 0x0;
        } lvds_imgheight1[31:16];
        field {
            name = "Widthoftheimagetransferredbyvirtuallvds_imgwidth1channel1inLVDSorHiSPImode";
            desc = "";
            sw = r; hw = w;
            reset = 0x0;
        } Widthoftheimagetransferredbyvirtuallvds_imgwidth1channel1inLVDSorHiSPImode[15:0];
    } LVDS_IMGSIZE1_STATIS @ 0x1784;
    reg {
        name = "LVDS_CTRL_INT_RAW";
        desc = "LVDS_CTRL_INT_RAW is the LVDS read data raw interrupt status register. (offset 0x17F0; total reset 0x00000000; PROVEN: Hi3516E V300 data sheet (Issue 00B06, 2019-05-15), section 9.3.6, PDF page 564).";
        field {
            name = "reserved";
            desc = "Reserved";
            sw = r; hw = w;
            reset = 0x0;
        } reserved_31_29[31:29];
        field {
            name = "lvds_vsync_raw";
            desc = "LVDS Vsync raw interrupt status
- 0: There is no raw interrupt.
- 1: There is a raw interrupt.

Access type WC in the data sheet: written 1 clears the bit.";
            sw = rw; hw = w; onwrite = woclr;
            reset = 0x0;
        } lvds_vsync_raw[28:28];
        field {
            name = "cmd_rd_err_raw";
            desc = "Status of the LVDS CMD_FIFO read error raw interrupt
- 0: There is no raw interrupt.
- 1: There is a raw interrupt.

Access type WC in the data sheet: written 1 clears the bit.";
            sw = rw; hw = w; onwrite = woclr;
            reset = 0x0;
        } cmd_rd_err_raw[27:27];
        field {
            name = "cmd_wr_err_raw";
            desc = "Status of the LVDS CMD_FIFO read error raw interrupt
- 0: There is no raw interrupt.
- 1: There is a raw interrupt.

Access type WC in the data sheet: written 1 clears the bit.";
            sw = rw; hw = w; onwrite = woclr;
            reset = 0x0;
        } cmd_wr_err_raw[26:26];
        field {
            name = "pop_err_raw";
            desc = "Status of the LVDS line_buf read error raw interrupt
- 0: There is no raw interrupt.
- 1: There is a raw interrupt.

Access type WC in the data sheet: written 1 clears the bit.";
            sw = rw; hw = w; onwrite = woclr;
            reset = 0x0;
        } pop_err_raw[25:25];
        field {
            name = "lvds_state_err_raw";
            desc = "Status of the LVDS lane synchronization error raw interrupt
- 0: There is no raw interrupt.
- 1: There is a raw interrupt.

Access type WC in the data sheet: written 1 clears the bit.";
            sw = rw; hw = w; onwrite = woclr;
            reset = 0x0;
        } lvds_state_err_raw[24:24];
        field {
            name = "reserved";
            desc = "Reserved";
            sw = r; hw = w;
            reset = 0x0;
        } reserved_23_21[23:21];
        field {
            name = "link0_rd_err_raw";
            desc = "Status of the link FIFO read error raw interrupt
- 0: There is no raw interrupt.
- 1: There is a raw interrupt.

Access type WC in the data sheet: written 1 clears the bit.";
            sw = rw; hw = w; onwrite = woclr;
            reset = 0x0;
        } link0_rd_err_raw[20:20];
        field {
            name = "reserved";
            desc = "Reserved";
            sw = r; hw = w;
            reset = 0x0;
        } reserved_19_17[19:17];
        field {
            name = "link0_wr_err_raw";
            desc = "Status of the link FIFO write error raw interrupt

Access type WC in the data sheet: written 1 clears the bit.";
            sw = rw; hw = w; onwrite = woclr;
            reset = 0x0;
        } link0_wr_err_raw[16:16];
        field {
            name = "reserved";
            desc = "Reserved";
            sw = r; hw = w;
            reset = 0x0;
        } reserved_15_4[15:4];
        field {
            name = "lane3_sync_err_raw";
            desc = "Status of the lane 3 synchronization error raw interrupt
- 0: There is no raw interrupt.
- 1: There is a raw interrupt.

Access type WC in the data sheet: written 1 clears the bit.";
            sw = rw; hw = w; onwrite = woclr;
            reset = 0x0;
        } lane3_sync_err_raw[3:3];
        field {
            name = "lane2_sync_err_raw";
            desc = "Status of the lane 2 synchronization error raw interrupt
- 0: There is no raw interrupt.
- 1: There is a raw interrupt.

Access type WC in the data sheet: written 1 clears the bit.";
            sw = rw; hw = w; onwrite = woclr;
            reset = 0x0;
        } lane2_sync_err_raw[2:2];
        field {
            name = "lane1_sync_err_raw";
            desc = "Status of the lane 1 synchronization error raw interrupt
- 0: There is no raw interrupt.
- 1: There is a raw interrupt.

Access type WC in the data sheet: written 1 clears the bit.";
            sw = rw; hw = w; onwrite = woclr;
            reset = 0x0;
        } lane1_sync_err_raw[1:1];
        field {
            name = "lane0_sync_err_raw";
            desc = "Status of the lane 0 synchronization error raw interrupt
- 0: There is no raw interrupt.
- 1: There is a raw interrupt.

Access type WC in the data sheet: written 1 clears the bit.";
            sw = rw; hw = w; onwrite = woclr;
            reset = 0x0;
        } lane0_sync_err_raw[0:0];
    } LVDS_CTRL_INT_RAW @ 0x17F0;
    reg {
        name = "LVDS_CTRL_INT";
        desc = "LVDS_CTRL_INT is the LVDS read data interrupt status register. (offset 0x17F4; total reset 0x00000000; PROVEN: Hi3516E V300 data sheet (Issue 00B06, 2019-05-15), section 9.3.6, PDF page 565).";
        field {
            name = "reserved";
            desc = "Reserved";
            sw = r; hw = w;
            reset = 0x0;
        } reserved_31_29[31:29];
        field {
            name = "lvds_vsync_st";
            desc = "LVDS Vsync interrupt status
- 0: No interrupt is generated.
- 1: An interrupt is generated.";
            sw = r; hw = w;
            reset = 0x0;
        } lvds_vsync_st[28:28];
        field {
            name = "cmd_rd_err_st";
            desc = "Status of the LVDS CMD_FIFO read error interrupt
- 0: No interrupt is generated.
- 1: An interrupt is generated.";
            sw = r; hw = w;
            reset = 0x0;
        } cmd_rd_err_st[27:27];
        field {
            name = "cmd_wr_err_st";
            desc = "Status of the LVDS CMD_FIFO write error interrupt
- 0: No interrupt is generated.
- 1: An interrupt is generated.";
            sw = r; hw = w;
            reset = 0x0;
        } cmd_wr_err_st[26:26];
        field {
            name = "pop_err_st";
            desc = "Status of the LVDS line_buf read error interrupt
- 0: No interrupt is generated.
- 1: An interrupt is generated.";
            sw = r; hw = w;
            reset = 0x0;
        } pop_err_st[25:25];
        field {
            name = "lvds_state_err_st";
            desc = "Status of the LVDS lane synchronization error interrupt
- 0: No interrupt is generated.
- 1: An interrupt is generated.";
            sw = r; hw = w;
            reset = 0x0;
        } lvds_state_err_st[24:24];
        field {
            name = "reserved";
            desc = "Reserved";
            sw = r; hw = w;
            reset = 0x0;
        } reserved_23_21[23:21];
        field {
            name = "link0_rd_err_st";
            desc = "Status of the link FIFO read error interrupt
- 0: No interrupt is generated.
- 1: An interrupt is generated.";
            sw = r; hw = w;
            reset = 0x0;
        } link0_rd_err_st[20:20];
        field {
            name = "reserved";
            desc = "Reserved";
            sw = r; hw = w;
            reset = 0x0;
        } reserved_19_17[19:17];
        field {
            name = "link0_wr_err_st";
            desc = "Status of the link FIFO write error interrupt
- 0: No interrupt is generated.
- 1: An interrupt is generated.";
            sw = r; hw = w;
            reset = 0x0;
        } link0_wr_err_st[16:16];
        field {
            name = "reserved";
            desc = "Reserved";
            sw = r; hw = w;
            reset = 0x0;
        } reserved_15_4[15:4];
        field {
            name = "lane3_sync_err_st";
            desc = "Status of the lane 3 synchronization error interrupt
- 0: No interrupt is generated.
- 1: An interrupt is generated.";
            sw = r; hw = w;
            reset = 0x0;
        } lane3_sync_err_st[3:3];
        field {
            name = "lane2_sync_err_st";
            desc = "Status of the lane 2 synchronization error interrupt
- 0: No interrupt is generated.
- 1: An interrupt is generated.";
            sw = r; hw = w;
            reset = 0x0;
        } lane2_sync_err_st[2:2];
        field {
            name = "lane1_sync_err_st";
            desc = "Status of the lane 1 synchronization error interrupt
- 0: No interrupt is generated.
- 1: An interrupt is generated.";
            sw = r; hw = w;
            reset = 0x0;
        } lane1_sync_err_st[1:1];
        field {
            name = "lane0_sync_err_st";
            desc = "Status of the lane 0 synchronization error interrupt
- 0: No interrupt is generated.
- 1: An interrupt is generated.";
            sw = r; hw = w;
            reset = 0x0;
        } lane0_sync_err_st[0:0];
    } LVDS_CTRL_INT @ 0x17F4;
    reg {
        name = "LVDS_CTRL_INT_MSK";
        desc = "LVDS_CTRL_INT_MSK is the LVDS read data interrupt mask register. (offset 0x17F8; total reset 0x00000000; PROVEN: Hi3516E V300 data sheet (Issue 00B06, 2019-05-15), section 9.3.6, PDF page 566).";
        field {
            name = "reserved";
            desc = "Reserved";
            sw = r; hw = w;
            reset = 0x0;
        } reserved_31_29[31:29];
        field {
            name = "lvds_vsync_msk";
            desc = "LVDS Vsync interrupt enable
- 0: masked
- 1: enabled";
            sw = rw; hw = r;
            reset = 0x0;
        } lvds_vsync_msk[28:28];
        field {
            name = "cmd_rd_err_msk";
            desc = "LVDS CMD_FIFO read error interrupt enable
- 0: masked
- 1: enabled";
            sw = rw; hw = r;
            reset = 0x0;
        } cmd_rd_err_msk[27:27];
        field {
            name = "cmd_wr_err_msk";
            desc = "LVDS CMD_FIFO write error interrupt enable
- 0: masked
- 1: enabled";
            sw = rw; hw = r;
            reset = 0x0;
        } cmd_wr_err_msk[26:26];
        field {
            name = "pop_err_msk";
            desc = "LVDS line_buf read error interrupt enable
- 0: masked
- 1: enabled";
            sw = rw; hw = r;
            reset = 0x0;
        } pop_err_msk[25:25];
        field {
            name = "lvds_state_err_msk";
            desc = "LVDS lane synchronization error interrupt enable
- 0: masked
- 1: enabled";
            sw = rw; hw = r;
            reset = 0x0;
        } lvds_state_err_msk[24:24];
        field {
            name = "reserved";
            desc = "Reserved";
            sw = r; hw = w;
            reset = 0x0;
        } reserved_23_21[23:21];
        field {
            name = "link0_rd_err_msk";
            desc = "Link FIFO read error interrupt enable
- 0: masked
- 1: enabled";
            sw = rw; hw = r;
            reset = 0x0;
        } link0_rd_err_msk[20:20];
        field {
            name = "reserved";
            desc = "Reserved";
            sw = r; hw = w;
            reset = 0x0;
        } reserved_19_17[19:17];
        field {
            name = "link0_wr_err_msk";
            desc = "Link FIFO write error interrupt enable
- 0: masked
- 1: enabled";
            sw = rw; hw = r;
            reset = 0x0;
        } link0_wr_err_msk[16:16];
        field {
            name = "reserved";
            desc = "Reserved";
            sw = r; hw = w;
            reset = 0x0;
        } reserved_15_4[15:4];
        field {
            name = "lane3_sync_err_msk";
            desc = "Lane 3 synchronization error interrupt enable
- 0: masked
- 1: enabled";
            sw = rw; hw = r;
            reset = 0x0;
        } lane3_sync_err_msk[3:3];
        field {
            name = "lane2_sync_err_msk";
            desc = "Lane 2 synchronization error interrupt enable
- 0: masked
- 1: enabled";
            sw = rw; hw = r;
            reset = 0x0;
        } lane2_sync_err_msk[2:2];
        field {
            name = "lane1_sync_err_msk";
            desc = "Lane 1 synchronization error interrupt enable
- 0: masked
- 1: enabled";
            sw = rw; hw = r;
            reset = 0x0;
        } lane1_sync_err_msk[1:1];
        field {
            name = "lane0_sync_err_msk";
            desc = "Lane 0 synchronization error interrupt enable
- 0: masked
- 1: enabled";
            sw = rw; hw = r;
            reset = 0x0;
        } lane0_sync_err_msk[0:0];
    } LVDS_CTRL_INT_MSK @ 0x17F8;
    reg {
        name = "LANE_ID0_CHN";
        desc = "LANE_ID0_CHN is lane priority configuration register 0. (offset 0x1800; total reset 0x00003210; PROVEN: Hi3516E V300 data sheet (Issue 00B06, 2019-05-15), section 9.3.6, PDF page 568).";
        field {
            name = "reserved";
            desc = "Reserved";
            sw = r; hw = w;
            reset = 0x0;
        } reserved_31_16[31:16];
        field {
            name = "lane3_id";
            desc = "Channel ID of lane 3 Value range: 0-15 The field value indicates the ID of the image sensor channel connected to lane 3.";
            sw = rw; hw = r;
            reset = 0x3;
        } lane3_id[15:12];
        field {
            name = "lane2_id";
            desc = "Channel ID of lane 2 Value range: 0-15 The field value indicates the ID of the image sensor channel connected to lane 2.";
            sw = rw; hw = r;
            reset = 0x2;
        } lane2_id[11:8];
        field {
            name = "lane1_id";
            desc = "Channel ID of lane 1 Value range: 0-15 The field value indicates the ID of the image sensor channel connected to lane 1.";
            sw = rw; hw = r;
            reset = 0x1;
        } lane1_id[7:4];
        field {
            name = "lane0_id";
            desc = "Channel ID of lane 0 Value range: 0-15 The field value indicates the ID of the image sensor channel connected to lane 0.";
            sw = rw; hw = r;
            reset = 0x0;
        } lane0_id[3:0];
    } LANE_ID0_CHN @ 0x1800;
    reg {
        name = "ALIGN_INT_RAW";
        desc = "ALIGN_INT_RAW is the MIPI_ALIGN raw interrupt status register. (offset 0x18F0; total reset 0x00000000; PROVEN: Hi3516E V300 data sheet (Issue 00B06, 2019-05-15), section 9.3.6, PDF page 568).";
        field {
            name = "reserved";
            desc = "Reserved";
            sw = r; hw = w;
            reset = 0x0;
        } reserved_31_5[31:5];
        field {
            name = "err_lane3_raw";
            desc = "ALIGN lane 3 raw interrupt status
- 0: There is no raw interrupt.
- 1: There is a raw interrupt.

Access type WC in the data sheet: written 1 clears the bit.";
            sw = rw; hw = w; onwrite = woclr;
            reset = 0x0;
        } err_lane3_raw[4:4];
        field {
            name = "err_lane2_raw";
            desc = "ALIGN lane 2 raw interrupt status
- 0: There is no raw interrupt.
- 1: There is a raw interrupt.

Access type WC in the data sheet: written 1 clears the bit.";
            sw = rw; hw = w; onwrite = woclr;
            reset = 0x0;
        } err_lane2_raw[3:3];
        field {
            name = "err_lane1_raw";
            desc = "ALIGN lane 1 raw interrupt status
- 0: There is no raw interrupt.
- 1: There is a raw interrupt.

Access type WC in the data sheet: written 1 clears the bit.";
            sw = rw; hw = w; onwrite = woclr;
            reset = 0x0;
        } err_lane1_raw[2:2];
        field {
            name = "err_lane0_raw";
            desc = "ALIGN lane 0 raw interrupt status
- 0: There is no raw interrupt.
- 1: There is a raw interrupt.

Access type WC in the data sheet: written 1 clears the bit.";
            sw = rw; hw = w; onwrite = woclr;
            reset = 0x0;
        } err_lane0_raw[1:1];
        field {
            name = "err_full_raw";
            desc = "ALIGN FIFO raw interrupt status
- 0: There is no raw interrupt.
- 1: There is a raw interrupt.

Access type WC in the data sheet: written 1 clears the bit.";
            sw = rw; hw = w; onwrite = woclr;
            reset = 0x0;
        } err_full_raw[0:0];
    } ALIGN_INT_RAW @ 0x18F0;
    reg {
        name = "ALIGN_INT";
        desc = "ALIGN_INT is the MIPI_ALIGN interrupt status register. (offset 0x18F4; total reset 0x00000000; PROVEN: Hi3516E V300 data sheet (Issue 00B06, 2019-05-15), section 9.3.6, PDF page 569).";
        field {
            name = "reserved";
            desc = "Reserved";
            sw = r; hw = w;
            reset = 0x0;
        } reserved_31_5[31:5];
        field {
            name = "err_lane3_st";
            desc = "ALIGN lane 3 interrupt status
- 0: No interrupt is generated.
- 1: An interrupt is generated.";
            sw = r; hw = w;
            reset = 0x0;
        } err_lane3_st[4:4];
        field {
            name = "err_lane2_st";
            desc = "ALIGN lane 2 interrupt status
- 0: No interrupt is generated.
- 1: An interrupt is generated.";
            sw = r; hw = w;
            reset = 0x0;
        } err_lane2_st[3:3];
        field {
            name = "err_lane1_st";
            desc = "ALIGN lane 1 interrupt status
- 0: No interrupt is generated.
- 1: An interrupt is generated.";
            sw = r; hw = w;
            reset = 0x0;
        } err_lane1_st[2:2];
        field {
            name = "err_lane0_st";
            desc = "ALIGN lane 0 interrupt status
- 0: No interrupt is generated.
- 1: An interrupt is generated.";
            sw = r; hw = w;
            reset = 0x0;
        } err_lane0_st[1:1];
        field {
            name = "err_full_st";
            desc = "ALIGN FIFO interrupt status
- 0: No interrupt is generated.
- 1: An interrupt is generated.";
            sw = r; hw = w;
            reset = 0x0;
        } err_full_st[0:0];
    } ALIGN_INT @ 0x18F4;
    reg {
        name = "ALIGN_INT_MSK";
        desc = "ALIGN_INT_MSK is the MIPI_ALIGN interrupt mask register. (offset 0x18F8; total reset 0x00000000; PROVEN: Hi3516E V300 data sheet (Issue 00B06, 2019-05-15), section 9.3.6, PDF page 570).";
        field {
            name = "reserved";
            desc = "Reserved";
            sw = r; hw = w;
            reset = 0x0;
        } reserved_31_5[31:5];
        field {
            name = "err_lane3_mask";
            desc = "ALIGN lane 3 interrupt enable
- 0: masked
- 1: enabled";
            sw = rw; hw = r;
            reset = 0x0;
        } err_lane3_mask[4:4];
        field {
            name = "err_lane2_mask";
            desc = "ALIGN lane 2 interrupt enable
- 0: masked
- 1: enabled";
            sw = rw; hw = r;
            reset = 0x0;
        } err_lane2_mask[3:3];
        field {
            name = "err_lane1_mask";
            desc = "ALIGN lane 1 interrupt enable
- 0: masked
- 1: enabled";
            sw = rw; hw = r;
            reset = 0x0;
        } err_lane1_mask[2:2];
        field {
            name = "err_lane0_mask";
            desc = "ALIGN lane 0 interrupt enable
- 0: masked
- 1: enabled";
            sw = rw; hw = r;
            reset = 0x0;
        } err_lane0_mask[1:1];
        field {
            name = "err_full_mask";
            desc = "ALIGN FIFO interrupt enable
- 0: masked
- 1: enabled";
            sw = rw; hw = r;
            reset = 0x0;
        } err_full_mask[0:0];
    } ALIGN_INT_MSK @ 0x18F8;
    reg {
        name = "CHN_INT_RAW";
        desc = "CHN_INT_RAW is the channel raw interrupt register. (offset 0x1FF0; total reset 0x00000000; PROVEN: Hi3516E V300 data sheet (Issue 00B06, 2019-05-15), section 9.3.6, PDF page 570).";
        field {
            name = "reserved";
            desc = "Reserved";
            sw = r; hw = w;
            reset = 0x0;
        } reserved_31_4[31:4];
        field {
            name = "int_data_align_raw";
            desc = "DATA_ALIGN raw interrupt status
- 0: There is no raw interrupt.
- 1: There is a raw interrupt.

Access type WC in the data sheet: written 1 clears the bit.";
            sw = rw; hw = w; onwrite = woclr;
            reset = 0x0;
        } int_data_align_raw[3:3];
        field {
            name = "int_mipi_ctrl_raw";
            desc = "MIPI CTRL raw interrupt status
- 0: There is no raw interrupt.
- 1: There is a raw interrupt.

Access type WC in the data sheet: written 1 clears the bit.";
            sw = rw; hw = w; onwrite = woclr;
            reset = 0x0;
        } int_mipi_ctrl_raw[2:2];
        field {
            name = "int_mipi_csi_raw";
            desc = "MIPI_CSI raw interrupt status
- 0: There is no raw interrupt.

Access type WC in the data sheet: written 1 clears the bit.";
            sw = rw; hw = w; onwrite = woclr;
            reset = 0x0;
        } int_mipi_csi_raw[1:1];
        field {
            name = "int_lvds_ctrl_raw";
            desc = "LVDS_CTRL raw interrupt status
- 0: There is no raw interrupt.
- 1: There is a raw interrupt.

Access type WC in the data sheet: written 1 clears the bit.";
            sw = rw; hw = w; onwrite = woclr;
            reset = 0x0;
        } int_lvds_ctrl_raw[0:0];
    } CHN_INT_RAW @ 0x1FF0;
    reg {
        name = "CHN_INT";
        desc = "CHN_INT is the channel interrupt status register. (offset 0x1FF4; total reset 0x00000000; PROVEN: Hi3516E V300 data sheet (Issue 00B06, 2019-05-15), section 9.3.6, PDF page 571).";
        field {
            name = "reserved";
            desc = "Reserved";
            sw = r; hw = w;
            reset = 0x0;
        } reserved_31_4[31:4];
        field {
            name = "int_data_align_st";
            desc = "DATA_ALIGN interrupt status
- 0: No interrupt is generated.
- 1: An interrupt is generated.";
            sw = r; hw = w;
            reset = 0x0;
        } int_data_align_st[3:3];
        field {
            name = "int_mipi_ctrl_st";
            desc = "MIPI_CTRL interrupt status
- 0: No interrupt is generated.
- 1: An interrupt is generated.";
            sw = r; hw = w;
            reset = 0x0;
        } int_mipi_ctrl_st[2:2];
        field {
            name = "int_mipi_csi_st";
            desc = "MIPI_CSI interrupt status
- 0: No interrupt is generated.
- 1: An interrupt is generated.";
            sw = r; hw = w;
            reset = 0x0;
        } int_mipi_csi_st[1:1];
        field {
            name = "int_lvds_ctrl_st";
            desc = "LVDS_CTRL interrupt status
- 0: No interrupt is generated.
- 1: An interrupt is generated.";
            sw = r; hw = w;
            reset = 0x0;
        } int_lvds_ctrl_st[0:0];
    } CHN_INT @ 0x1FF4;
    reg {
        name = "CHN_INT_MASK";
        desc = "CHN_INT_MASK is the channel interrupt mask register. (offset 0x1FF8; total reset 0x00000000; PROVEN: Hi3516E V300 data sheet (Issue 00B06, 2019-05-15), section 9.3.6, PDF page 571).";
        field {
            name = "reserved";
            desc = "Reserved";
            sw = r; hw = w;
            reset = 0x0;
        } reserved_31_4[31:4];
        field {
            name = "int_data_align_mask";
            desc = "DATA_ALIGN interrupt enable
- 0: masked
- 1: enabled";
            sw = rw; hw = r;
            reset = 0x0;
        } int_data_align_mask[3:3];
        field {
            name = "int_mipi_ctrl_mask";
            desc = "MIPI_CTRL interrupt enable";
            sw = rw; hw = r;
            reset = 0x0;
        } int_mipi_ctrl_mask[2:2];
        field {
            name = "int_mipi_csi_mask";
            desc = "MIPI_CSI interrupt enable
- 0: masked
- 1: enabled";
            sw = rw; hw = r;
            reset = 0x0;
        } int_mipi_csi_mask[1:1];
        field {
            name = "int_lvds_ctrl_mask";
            desc = "LVDS_CTRL interrupt enable
- 0: masked
- 1: enabled Contents";
            sw = rw; hw = r;
            reset = 0x0;
        } int_lvds_ctrl_mask[0:0];
    } CHN_INT_MASK @ 0x1FF8;
};
`endif
