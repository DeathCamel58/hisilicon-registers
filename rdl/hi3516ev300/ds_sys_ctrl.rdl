`ifndef HI3516EV300_SYS_CTRL_RDL
`define HI3516EV300_SYS_CTRL_RDL
regfile eHI3516EV300_SYS_CTRL {
    name = "System controller (SC) and peripheral control registers";
    desc = "System controller (SC) and peripheral control registers of the Hi3516E V300 at base 0x1202_0000. 45 registers extracted programmatically (plus 14 registers kept from the vendor-derived map, marked INFERRED) from the Hi3516E V300 data sheet (Issue 00B06, 2019-05-15) (Table 3-7 Summary of system controller registers (base address: 0x1202_0000)): register headings, offsets, total reset values, field bit ranges, access types, names, reset values and descriptions, with PDF page numbers in each register description. Field names, bit ranges, access types and offsets are exact; the free-text descriptions are taken from the cell text of the field table and were checked by sampling only. Hardware not verified.";
    reg {
        name = "SC_CTRL";
        desc = "SC_CTRL is a system control register. It is used to specify the operations to be performed by the system. Write protection for this register can be enabled by configuring SC_LOCKEN. This register can be written only when write protection is disabled. (offset 0x0; total reset 0x00000200; PROVEN: Hi3516E V300 data sheet (Issue 00B06, 2019-05-15), section 3.5.3, PDF page 116).";
        field {
            name = "reserved";
            desc = "Reserved";
            sw = r; hw = w;
            reset = 0x0;
        } reserved_31_20[31:20];
        field {
            name = "timeren3ov";
            desc = "Timer 3 count clock select
- 0: 3 MHz clock
- 1: bus clock";
            sw = rw; hw = r;
            reset = 0x0;
        } timeren3ov[19:19];
        field {
            name = "timeren2ov";
            desc = "Timer 2 count clock select
- 0: 3 MHz clock
- 1: bus clock";
            sw = rw; hw = r;
            reset = 0x0;
        } timeren2ov[18:18];
        field {
            name = "timeren1ov";
            desc = "Timer 1 count clock select
- 0: 3 MHz clock
- 1: bus clock";
            sw = rw; hw = r;
            reset = 0x0;
        } timeren1ov[17:17];
        field {
            name = "timeren0ov";
            desc = "Timer 0 count clock select
- 0: 3 MHz clock
- 1: bus clock";
            sw = rw; hw = r;
            reset = 0x0;
        } timeren0ov[16:16];
        field {
            name = "reserved";
            desc = "Reserved";
            sw = r; hw = w;
            reset = 0x0;
        } reserved_15_10[15:10];
        field {
            name = "remapstat";
            desc = "Address remapping state
- 0: The address is not remapped.
- 1: The address is remapped. The bootrom is remapped to address 0.";
            sw = r; hw = w;
            reset = 0x1;
        } remapstat[9:9];
        field {
            name = "remapclear";
            desc = "Address remapping clear
- 0: The remapping state is retained.
- 1: The remapping state is cleared.

For details about the address mapping relationships before and after remapping is cleared, see section 1.5 \"Address Space Mapping.\"";
            sw = rw; hw = r;
            reset = 0x0;
        } remapclear[8:8];
        field {
            name = "reserved";
            desc = "Reserved";
            sw = r; hw = w;
            reset = 0x0;
        } reserved_7_0[7:0];
    } SC_CTRL @ 0x0;
    reg {
        name = "SC_SYSRES";
        desc = "SC_SYSRES is a system soft reset register. Write protection for this register can be enabled by configuring SC_LOCKEN. This register can be written only when write protection is disabled. (offset 0x4; total reset 0x00000002; PROVEN: Hi3516E V300 data sheet (Issue 00B06, 2019-05-15), section 3.5.3, PDF page 117).";
        field {
            name = "softresreq";
            desc = "Writing any value to this register soft-resets the system.";
            sw = w; hw = r;
            reset = 0x2;
        } softresreq[31:0];
    } SC_SYSRES @ 0x4;
    reg {
        name = "SC_VERSIONID";
        desc = "SC_VERSIONID is a version ID register. (offset 0x18; total reset 0x00000002; PROVEN: Hi3516E V300 data sheet (Issue 00B06, 2019-05-15), section 3.5.3, PDF page 118).";
        field {
            name = "reserved";
            desc = "Reserved";
            sw = r; hw = w;
            reset = 0x0;
        } reserved_31_8[31:8];
        field {
            name = "version_id";
            desc = "Chip version ID. The readback value is 0x2.";
            sw = r; hw = w;
            reset = 0x2;
        } version_id[7:0];
    } SC_VERSIONID @ 0x18;
    reg {
        name = "SOFTINT";
        desc = "SOFTINT is a software interrupt register. (offset 0x1C; total reset 0x00000000; PROVEN: Hi3516E V300 data sheet (Issue 00B06, 2019-05-15), section 3.5.3, PDF page 118).";
        field {
            name = "reserved";
            desc = "Reserved";
            sw = r; hw = w;
            reset = 0x0;
        } reserved_31_1[31:1];
        field {
            name = "software_int";
            desc = "Writing 1 to this bit generates the software interrupt.";
            sw = rw; hw = r;
            reset = 0x0;
        } software_int[0:0];
    } SOFTINT @ 0x1C;
    reg {
        name = "SOFTTYPE";
        desc = "SOFTTYPE is a software interrupt vector register. (offset 0x20; total reset 0x00000000; PROVEN: Hi3516E V300 data sheet (Issue 00B06, 2019-05-15), section 3.5.3, PDF page 118).";
        field {
            name = "software_int_vector";
            desc = "Software interrupt vector";
            sw = r; hw = w;
            reset = 0x0;
        } software_int_vector[31:0];
    } SOFTTYPE @ 0x20;
    reg {
        name = "SC_LOCKEN";
        desc = "SC_LOCKEN is a lock register for the key system control registers. (offset 0x44; total reset 0x00000000; PROVEN: Hi3516E V300 data sheet (Issue 00B06, 2019-05-15), section 3.5.3, PDF page 118).";
        field {
            name = "scper_lockl";
            desc = "Lock register for the key system control registers. The key registers include SC_CTRL and SC_SYSRES. When 0x1ACC_E551 is written to SC_LOCKEN, the write permission for all registers is enabled; when any other value is written to SC_LOCKEN, the write permission is disabled. Reading this register returns the lock status but not the written value. 0x0000_0000: The write permission is enabled (unlocked). 0x0000_0001: The write permission is disabled (locked).";
            sw = rw; hw = r;
            reset = 0x0;
        } scper_lockl[31:0];
    } SC_LOCKEN @ 0x44;
    reg {
        name = "OTP_PO_BIT2";
        desc = "OTP_PO_BIT2 is OTP power-on read back register 2. (offset 0x88; total reset 0x00000000; PROVEN: Hi3516E V300 data sheet (Issue 00B06, 2019-05-15), section 3.5.3, PDF page 119).";
        field {
            name = "reserved";
            desc = "Reserved";
            sw = r; hw = w;
            reset = 0x0;
        } reserved_31_22[31:22];
        field {
            name = "otp_jtag_disable";
            desc = "JTAG debugging disable
- 0: JTAG debugging is not disabled.
- 1: JTAG debugging is disabled.";
            sw = r; hw = w;
            reset = 0x0;
        } otp_jtag_disable[21:21];
        field {
            name = "otp_ddrca_en";
            desc = "DDR scrambling enable
- 0: disabled
- 1: enabled";
            sw = r; hw = w;
            reset = 0x0;
        } otp_ddrca_en[20:20];
        field {
            name = "reserved";
            desc = "Reserved";
            sw = r; hw = w;
            reset = 0x0;
        } reserved_19_0[19:0];
    } OTP_PO_BIT2 @ 0x88;
    reg {
        name = "SYSSTAT";
        desc = "SYSSTAT is a system status register. (offset 0x8C; total reset 0x00000000; PROVEN: Hi3516E V300 data sheet (Issue 00B06, 2019-05-15), section 3.5.3, PDF page 119).";
        field {
            name = "sec_boot_mode";
            desc = "Secure boot mode
- 0: non-secure boot mode
- 1: secure boot mode";
            sw = r; hw = w;
            reset = 0x0;
        } sec_boot_mode[31:31];
        field {
            name = "reserved";
            desc = "Reserved";
            sw = r; hw = w;
            reset = 0x0;
        } reserved_30_17[30:17];
        field {
            name = "sfc_input_sel";
            desc = "SFC pin select
- 0: SFC
- 1: SDIO1";
            sw = r; hw = w;
            reset = 0x0;
        } sfc_input_sel[16:16];
        field {
            name = "por_enable";
            desc = "Reset solution select
- 0: external reset
- 1: internal POR";
            sw = r; hw = w;
            reset = 0x0;
        } por_enable[15:15];
        field {
            name = "reserved";
            desc = "Reserved";
            sw = r; hw = w;
            reset = 0x0;
        } reserved_14_12[14:12];
        field {
            name = "sfc_emmc_boot_mode";
            desc = "Boot address mode of the SPI NOR flash (when boot_sel[0] is 0 and sfc_device_mode is 0)
- 0: 3-byte mode
- 1: 4-byte mode

Boot mode of the SPI NAND flash (when boot_sel[0] is 0 and sfc_device_mode is 1)
- 0: 1-wire boot mode
- 1: 4-wire boot mode

When boot_sel[0] is 1, it indicates the boot mode of the eMMC flash.
- 0: 4-wire boot mode
- 1: 8-wire boot mode";
            sw = r; hw = w;
            reset = 0x0;
        } sfc_emmc_boot_mode[11:11];
        field {
            name = "sfc_device_mode";
            desc = "SPI flash component type
- 0: SPI NOR flash
- 1: SPI NAND flash";
            sw = r; hw = w;
            reset = 0x0;
        } sfc_device_mode[10:10];
        field {
            name = "reserved";
            desc = "Reserved";
            sw = r; hw = w;
            reset = 0x0;
        } reserved_9_6[9:6];
        field {
            name = "boot_sel";
            desc = "Boot mode
- 00: booting from the SPI NOR flash or SPI

NAND flash
- 01: booting from the eMMC
- 10: fast boot. The SPI NOR flash or SPI

NAND flash is burnt over the serial port.
- 11: fast boot. The eMMC is burnt over the serial port.";
            sw = r; hw = w;
            reset = 0x0;
        } boot_sel[5:4];
        field {
            name = "reserved";
            desc = "Reserved";
            sw = r; hw = w;
            reset = 0x0;
        } reserved_3_0[3:0];
    } SYSSTAT @ 0x8C;
    reg {
        name = "DIE_ID0";
        desc = "DIE_ID0 is a DIE ID0 register. (offset 0x400; total reset 0x00000000; PROVEN: Hi3516E V300 data sheet (Issue 00B06, 2019-05-15), section 3.5.3, PDF page 121).";
        field {
            name = "die_id0";
            desc = "DIE_ID[31:0]";
            sw = r; hw = w;
            reset = 0x0;
        } die_id0[31:0];
    } DIE_ID0 @ 0x400;
    reg {
        name = "DIE_ID1";
        desc = "DIE_ID1 is a DIE ID1 register. (offset 0x404; total reset 0x00000000; PROVEN: Hi3516E V300 data sheet (Issue 00B06, 2019-05-15), section 3.5.3, PDF page 121).";
        field {
            name = "die_id1";
            desc = "DIE_ID[63:32]";
            sw = r; hw = w;
            reset = 0x0;
        } die_id1[31:0];
    } DIE_ID1 @ 0x404;
    reg {
        name = "DIE_ID2";
        desc = "DIE_ID2 is a DIE ID2 register. (offset 0x408; total reset 0x00000000; PROVEN: Hi3516E V300 data sheet (Issue 00B06, 2019-05-15), section 3.5.3, PDF page 121).";
        field {
            name = "die_id2";
            desc = "DIE_ID[95:64]";
            sw = r; hw = w;
            reset = 0x0;
        } die_id2[31:0];
    } DIE_ID2 @ 0x408;
    reg {
        name = "DIE_ID3";
        desc = "DIE_ID3 is a DIE ID3 register. (offset 0x40C; total reset 0x00000000; PROVEN: Hi3516E V300 data sheet (Issue 00B06, 2019-05-15), section 3.5.3, PDF page 121).";
        field {
            name = "die_id3";
            desc = "DIE_ID[127:96]";
            sw = r; hw = w;
            reset = 0x0;
        } die_id3[31:0];
    } DIE_ID3 @ 0x40C;
    reg {
        name = "DIE_ID4";
        desc = "DIE_ID4 is a DIE ID4 register. (offset 0x410; total reset 0x00000000; PROVEN: Hi3516E V300 data sheet (Issue 00B06, 2019-05-15), section 3.5.3, PDF page 121).";
        field {
            name = "die_id4";
            desc = "DIE_ID[159:128]";
            sw = r; hw = w;
            reset = 0x0;
        } die_id4[31:0];
    } DIE_ID4 @ 0x410;
    reg {
        name = "DIE_ID5";
        desc = "DIE_ID5 is a DIE ID5 register. (offset 0x414; total reset 0x00000000; PROVEN: Hi3516E V300 data sheet (Issue 00B06, 2019-05-15), section 3.5.3, PDF page 122).";
        field {
            name = "die_id5";
            desc = "DIE_ID[191:160]";
            sw = r; hw = w;
            reset = 0x0;
        } die_id5[31:0];
    } DIE_ID5 @ 0x414;
    reg {
        name = "CHIP_ID";
        desc = "CHIP_ID is a chip ID register. (offset 0xEE0; total reset 0x3516E300; PROVEN: Hi3516E V300 data sheet (Issue 00B06, 2019-05-15), section 3.5.3, PDF page 122).";
        field {
            name = "chip_id";
            desc = "Chip ID register. The read back value is 0x3516E300.";
            sw = r; hw = w;
            reset = 0x3516e300;
        } chip_id[31:0];
    } CHIP_ID @ 0xEE0;
    reg {
        name = "VENDOR_ID";
        desc = "VENDOR_ID is a vendor ID register. (offset 0xEEC; total reset 0x00000035; PROVEN: Hi3516E V300 data sheet (Issue 00B06, 2019-05-15), section 3.5.3, PDF page 122).";
        field {
            name = "vendor_id";
            desc = "Vendor ID. The fixed value is 0x35.";
            sw = r; hw = w;
            reset = 0x35;
        } vendor_id[31:0];
    } VENDOR_ID @ 0xEEC;
    reg {
        name = "MISC_CTRL0";
        desc = "MISC_CTRL0 is MSIC function select register 0. (offset 0x8000; total reset 0x0000A000; PROVEN: Hi3516E V300 data sheet (Issue 00B06, 2019-05-15), section 3.5.4, PDF page 122).";
        field {
            name = "reserved";
            desc = "Reserved";
            sw = r; hw = w;
            reset = 0x0;
        } reserved_31_20[31:20];
        field {
            name = "test_clk_sel";
            desc = "Test clock source select
- 0x0: pll_test_out[0]
- 0x1: pll_test_out[1]
- 0x4: clk_24m
- 0x5: audiocodec_mclk";
            sw = rw; hw = r;
            reset = 0x0;
        } test_clk_sel[19:16];
        field {
            name = "gzip_vgs_ram_sel";
            desc = "Enable of multiplexing the RAM of the VGS module as the GZIP RAM
- 0: VGS
- 1: GZIP";
            sw = rw; hw = r;
            reset = 0x1;
        } gzip_vgs_ram_sel[15:15];
        field {
            name = "jtag_on_sdio";
            desc = "JTAG multiplexing switch for the SDIO0 pin
- 0: disabled
- 1: enabled";
            sw = rw; hw = r;
            reset = 0x0;
        } jtag_on_sdio[14:14];
        field {
            name = "bootram_vedu_ram_sel";
            desc = "Enable of multiplexing the RAM of the VEDU module as the boot RAM
- 0: VEDU
- 1: boot RAM";
            sw = rw; hw = r;
            reset = 0x1;
        } bootram_vedu_ram_sel[13:13];
        field {
            name = "reserved";
            desc = "Reserved";
            sw = r; hw = w;
            reset = 0x0;
        } reserved_12_5[12:5];
        field {
            name = "spi1_cs1_pctrl";
            desc = "Polarity control of SPI1 CS1
- 0: active low
- 1: active high";
            sw = rw; hw = r;
            reset = 0x0;
        } spi1_cs1_pctrl[4:4];
        field {
            name = "spi1_cs0_pctrl";
            desc = "Polarity control of SPI1 CS0
- 0: active low
- 1: active high";
            sw = rw; hw = r;
            reset = 0x0;
        } spi1_cs0_pctrl[3:3];
        field {
            name = "ssp1_cs_sel";
            desc = "CS select for the SPI1 signal output
- 0: CS0
- 1: CS1";
            sw = rw; hw = r;
            reset = 0x0;
        } ssp1_cs_sel[2:2];
        field {
            name = "reserved";
            desc = "Reserved";
            sw = r; hw = w;
            reset = 0x0;
        } reserved_1_1[1:1];
        field {
            name = "spi0_cs_pctrl";
            desc = "Polarity control of SPI0 CS
- 0: active low
- 1: active high";
            sw = rw; hw = r;
            reset = 0x0;
        } spi0_cs_pctrl[0:0];
    } MISC_CTRL0 @ 0x8000;
    reg {
        name = "MISC_CTRL1";
        desc = "MISC_CTRL1 is a USB PHY trim parameter register. (offset 0x8004; total reset 0x00000000; PROVEN: Hi3516E V300 data sheet (Issue 00B06, 2019-05-15), section 3.5.4, PDF page 123).";
        field {
            name = "reserved";
            desc = "Reserved";
            sw = r; hw = w;
            reset = 0x0;
        } reserved_31_6[31:6];
        field {
            name = "usb_vbus_in";
            desc = "Input value of the USB Vbus pin";
            sw = r; hw = w;
            reset = 0x0;
        } usb_vbus_in[5:5];
        field {
            name = "otp_usb_phy_rg_rt_trim";
            desc = "Trim parameter value of the USB PHY";
            sw = r; hw = w;
            reset = 0x0;
        } otp_usb_phy_rg_rt_trim[4:0];
    } MISC_CTRL1 @ 0x8004;
    reg {
        name = "MISC_CTRL3";
        desc = "MISC_CTRL3 is CPU control register 1. (offset 0x800C; total reset 0x00000000; PROVEN: Hi3516E V300 data sheet (Issue 00B06, 2019-05-15), section 3.5.4, PDF page 124).";
        field {
            name = "reserved";
            desc = "Reserved";
            sw = r; hw = w;
            reset = 0x0;
        } reserved_31_5[31:5];
        field {
            name = "a7_cp15sdisable";
            desc = "Disabling modification of some CPU CP15 registers
- 0: CPU CP15 registers can be modified.
- 1: CPU CP15 registers cannot be modified.";
            sw = rw; hw = r;
            reset = 0x0;
        } a7_cp15sdisable[4:4];
        field {
            name = "reserved";
            desc = "Reserved";
            sw = r; hw = w;
            reset = 0x0;
        } reserved_3_3[3:3];
        field {
            name = "a7_standbywfi_l2";
            desc = "WFI low-power state indicator of Cortex-A7 L2
- 0: not in the WFI low-power state
- 1: in the WFI low-power state";
            sw = r; hw = w;
            reset = 0x0;
        } a7_standbywfi_l2[2:2];
        field {
            name = "a7_standbywfi";
            desc = "WFI low-power state indicator of Cortex-A7
- 0: not in the WFI low-power state
- 1: in the WFI low-power state";
            sw = r; hw = w;
            reset = 0x0;
        } a7_standbywfi[1:1];
        field {
            name = "a7_standbywfe";
            desc = "WFE low-power state indicator of Cortex-A7
- 0: not in the WFE low-power state
- 1: in the WFE low-power state";
            sw = r; hw = w;
            reset = 0x0;
        } a7_standbywfe[0:0];
    } MISC_CTRL3 @ 0x800C;
    reg {
        name = "MISC_CTRL4";
        desc = "MISC_CTRL4 is MISC function select register 4. (offset 0x8010; total reset 0x0000000D; PROVEN: Hi3516E V300 data sheet (Issue 00B06, 2019-05-15), section 3.5.4, PDF page 124).";
        field {
            name = "reserved";
            desc = "Reserved";
            sw = r; hw = w;
            reset = 0x0;
        } reserved_31_6[31:6];
        field {
            name = "ive_ddrt_mst_sel";
            desc = "Channel select of the IVE and DDRT bus
- 0: DDRT
- 1: IVE";
            sw = rw; hw = r;
            reset = 0x0;
        } ive_ddrt_mst_sel[5:5];
        field {
            name = "vgs_gzip_mst_sel";
            desc = "Channel select of the VGS and GZIP bus";
            sw = rw; hw = r;
            reset = 0x0;
        } vgs_gzip_mst_sel[4:4];
        field {
            name = "reserved";
            desc = "Reserved";
            sw = r; hw = w;
            reset = 0xd;
        } reserved_3_0[3:0];
    } MISC_CTRL4 @ 0x8010;
    reg {
        name = "MISC_CTRL6";
        desc = "MISC_CTRL6 is VICAP mode control register 1. (offset 0x8018; total reset 0x00000000; PROVEN: Hi3516E V300 data sheet (Issue 00B06, 2019-05-15), section 3.5.4, PDF page 125).";
        field {
            name = "reserved";
            desc = "Reserved";
            sw = r; hw = w;
            reset = 0x0;
        } reserved_31_12[31:12];
        field {
            name = "vo_data_inv_order";
            desc = "Bit flipping enable for the VDP output
- 0: disabled
- 1: enabled";
            sw = rw; hw = r;
            reset = 0x0;
        } vo_data_inv_order[11:11];
        field {
            name = "lcd_mode";
            desc = "LCD output mode select
- 000: serial 6 bits of LCD data
- 001: serial 8 bits of LCD data
- 010: serial 16 bits of LCD data

Other values: reserved";
            sw = rw; hw = r;
            reset = 0x0;
        } lcd_mode[10:8];
        field {
            name = "viproc_vpss_online_mode";
            desc = "Operating mode select of VIPROC and VPSS
- 0: offline mode
- 1: online mode";
            sw = rw; hw = r;
            reset = 0x0;
        } viproc_vpss_online_mode[7:7];
        field {
            name = "vicap_viproc_online_mode";
            desc = "Operating mode select of VICAP and VIPROC
- 0: offline mode
- 1: online mode";
            sw = rw; hw = r;
            reset = 0x0;
        } vicap_viproc_online_mode[6:6];
        field {
            name = "vi_port_input_sel";
            desc = "Input select of VICAP PORT
- 0: MIPI_CTRL
- 1: COMS";
            sw = rw; hw = r;
            reset = 0x0;
        } vi_port_input_sel[5:5];
        field {
            name = "vi_input_sel";
            desc = "Input select of VICAP COMS
- 0: raw data
- 1: BT1120";
            sw = rw; hw = r;
            reset = 0x0;
        } vi_input_sel[4:4];
        field {
            name = "reserved";
            desc = "Reserved";
            sw = r; hw = w;
            reset = 0x0;
        } reserved_3_2[3:2];
        field {
            name = "mipirx0_work_mode";
            desc = "Mode select of MIPI RX channel 0
- 0: MIPI mode
- 1: LVDS mode

Other values: reserved";
            sw = rw; hw = r;
            reset = 0x0;
        } mipirx0_work_mode[1:0];
    } MISC_CTRL6 @ 0x8018;
    reg {
        name = "MISC_CTRL7";
        desc = "MISC_CTRL7 is USB 2.0 control register 0. (offset 0x801C; total reset 0x000400DF; PROVEN: Hi3516E V300 data sheet (Issue 00B06, 2019-05-15), section 3.5.4, PDF page 126).";
        field {
            name = "reserved";
            desc = "Reserved";
            sw = r; hw = w;
            reset = 0x0;
        } reserved_31_19[31:19];
        field {
            name = "usb2_fladj_30mhz_reg";
            desc = "Horizontal synchronization (HS) clock jitter control of the USB 2.0 port";
            sw = rw; hw = r;
            reset = 0x20;
        } usb2_fladj_30mhz_reg[18:13];
        field {
            name = "reserved";
            desc = "Reserved";
            sw = r; hw = w;
            reset = 0x0;
        } reserved_12_9[12:9];
        field {
            name = "usb2_hub_port_perm_attach";
            desc = "USB 2.0 device attaching mode
- 0: The attached device of USB 2.0 is removable.
- 1: The attached device of USB 2.0 is irremovable.";
            sw = rw; hw = r;
            reset = 0x0;
        } usb2_hub_port_perm_attach[8:8];
        field {
            name = "usb2_port_ovrcur_pol";
            desc = "Polarity control for USB 2.0 overcurrent protection
- 0: active low
- 1: active high";
            sw = rw; hw = r;
            reset = 0x1;
        } usb2_port_ovrcur_pol[7:7];
        field {
            name = "usb2_port_pwren_pol";
            desc = "Polarity control for USB 2.0 power enable
- 0: active low
- 1: active high";
            sw = rw; hw = r;
            reset = 0x1;
        } usb2_port_pwren_pol[6:6];
        field {
            name = "usb2_port_ovrcur_ctrl_en";
            desc = "USB 2.0 overcurrent protection enable
- 0: disabled
- 1: enabled";
            sw = rw; hw = r;
            reset = 0x0;
        } usb2_port_ovrcur_ctrl_en[5:5];
        field {
            name = "usb2_port_pwr_ctrl_en";
            desc = "USB 2.0 power supply enable
- 0: disabled
- 1: enabled (output by the USB controller)";
            sw = rw; hw = r;
            reset = 0x1;
        } usb2_port_pwr_ctrl_en[4:4];
        field {
            name = "reserved";
            desc = "Reserved";
            sw = r; hw = w;
            reset = 0xf;
        } reserved_3_0[3:0];
    } MISC_CTRL7 @ 0x801C;
    reg {
        name = "MISC_CTRL8";
        desc = "MISC_CTRL8 is embedded FE PHY control register 0. (offset 0x8020; total reset 0x00000300; PROVEN: Hi3516E V300 data sheet (Issue 00B06, 2019-05-15), section 3.5.4, PDF page 126).";
        field {
            name = "reserved";
            desc = "Reserved";
            sw = r; hw = w;
            reset = 0x0;
        } reserved_31_22[31:22];
        field {
            name = "fun_fephy_mdio_io_test";
            desc = "Test mode control for the MDIO and MDCKIO of the FE PHY In this mode, the communication of the FE PHY is implemented by the MDIO and MDCK pins. Note: The patch mode and the I/O test mode do not take effect at the same time.";
            sw = rw; hw = r;
            reset = 0x0;
        } fun_fephy_mdio_io_test[21:21];
        field {
            name = "fun_fephy_patch_mdio_enb";
            desc = "mdio_enb output of the FE PHY in patch mode";
            sw = r; hw = w;
            reset = 0x0;
        } fun_fephy_patch_mdio_enb[20:20];
        field {
            name = "fun_fephy_patch_mdio_o";
            desc = "mdio_o output of the FE PHY in patch mode";
            sw = r; hw = w;
            reset = 0x0;
        } fun_fephy_patch_mdio_o[19:19];
        field {
            name = "fun_fephy_patch_mdio_i";
            desc = "mdio_i input of the FE PHY in patch mode";
            sw = rw; hw = r;
            reset = 0x0;
        } fun_fephy_patch_mdio_i[18:18];
        field {
            name = "fun_fephy_patch_mdck";
            desc = "mdck input of the FE PHY in patch mode";
            sw = rw; hw = r;
            reset = 0x0;
        } fun_fephy_patch_mdck[17:17];
        field {
            name = "fun_fephy_patch_en";
            desc = "Patch mode control of the FE PHY
- 0: disabled
- 1: enabled

Note: The patch mode and the I/O test mode do not take effect at the same time.";
            sw = rw; hw = r;
            reset = 0x0;
        } fun_fephy_patch_en[16:16];
        field {
            name = "fephy_gp_i";
            desc = "GP_i input of the FE PHY";
            sw = rw; hw = r;
            reset = 0x300;
        } fephy_gp_i[15:0];
    } MISC_CTRL8 @ 0x8020;
    reg {
        name = "MISC_CTRL9";
        desc = "MISC_CTRL9 is embedded FE PHY control register 1. (offset 0x8024; total reset 0x00000180; PROVEN: Hi3516E V300 data sheet (Issue 00B06, 2019-05-15), section 3.5.4, PDF page 127).";
        field {
            name = "keep_reserved0";
            desc = "Reserved";
            sw = r; hw = w;
            reset = 0x0;
        } keep_reserved0[31:31];
        field {
            name = "reserved";
            desc = "Reserved";
            sw = r; hw = w;
            reset = 0x0;
        } reserved_30_30[30:30];
        field {
            name = "otp_fephy_ld_set";
            desc = "Adjustment parameter 0 of the embedded FE PHY";
            sw = r; hw = w;
            reset = 0x0;
        } otp_fephy_ld_set[29:25];
        field {
            name = "otp_fephy_ldo_set";
            desc = "Adjustment parameter 1 of the embedded FE PHY";
            sw = r; hw = w;
            reset = 0x0;
        } otp_fephy_ldo_set[24:22];
        field {
            name = "otp_fephy_r_tuning";
            desc = "Adjustment parameter 2 of the embedded FE PHY";
            sw = r; hw = w;
            reset = 0x0;
        } otp_fephy_r_tuning[21:16];
        field {
            name = "fun_fephy_afe_tclk0_div_sel";
            desc = "Frequency division select control
- 00: not divided
- 01: divided by 2";
            sw = rw; hw = r;
            reset = 0x0;
        } fun_fephy_afe_tclk0_div_sel[15:14];
        field {
            name = "fun_fephy_ck_sys_div_sel";
            desc = "Frequency division select control
- 00: not divided
- 01: divided by 2
- 10: divided by 4
- 11: divided by 8";
            sw = rw; hw = r;
            reset = 0x0;
        } fun_fephy_ck_sys_div_sel[13:12];
        field {
            name = "fephy_led_pol";
            desc = "Polarity control for the FE PHY output LED
- 0: active high
- 1: active low";
            sw = rw; hw = r;
            reset = 0x0;
        } fephy_led_pol[11:11];
        field {
            name = "fun_fephy_test_en";
            desc = "Test mode control of the FE PHY
- 0: disabled
- 1: enabled";
            sw = rw; hw = r;
            reset = 0x0;
        } fun_fephy_test_en[10:10];
        field {
            name = "fun_fephy_iddq_mode";
            desc = "Low-power mode control of the FE PHY
- 0: disabled
- 1: enabled";
            sw = rw; hw = r;
            reset = 0x0;
        } fun_fephy_iddq_mode[9:9];
        field {
            name = "fun_fephy_rstn_ldo";
            desc = "LDO reset enable of the FE PHY
- 0: reset
- 1: reset deasserted";
            sw = rw; hw = r;
            reset = 0x1;
        } fun_fephy_rstn_ldo[8:8];
        field {
            name = "fun_fephy_en_ldo";
            desc = "LDO output control of the FE PHY
- 0: disabled
- 1: enabled";
            sw = rw; hw = r;
            reset = 0x1;
        } fun_fephy_en_ldo[7:7];
        field {
            name = "fun_fephy_enz_ldo";
            desc = "High impedance control for the LDO output of the FE PHY
- 0: normal
- 1: high impedance";
            sw = rw; hw = r;
            reset = 0x0;
        } fun_fephy_enz_ldo[6:6];
        field {
            name = "reserved";
            desc = "Reserved";
            sw = r; hw = w;
            reset = 0x0;
        } reserved_5_5[5:5];
        field {
            name = "fephy_addr";
            desc = "MDIO address configuration of the embedded FE PHY";
            sw = rw; hw = r;
            reset = 0x0;
        } fephy_addr[4:0];
    } MISC_CTRL9 @ 0x8024;
    reg {
        name = "MISC_CTRL28";
        desc = "MISC_CTRL28 is bus priority control register 15. (offset 0x8070; total reset 0x00000123; PROVEN: Hi3516E V300 data sheet (Issue 00B06, 2019-05-15), section 3.5.4, PDF page 128).";
        field {
            name = "reserved";
            desc = "Reserved";
            sw = r; hw = w;
            reset = 0x0;
        } reserved_31_11[31:11];
        field {
            name = "media1_port2_pri_in";
            desc = "Priority of the JPGE bus port The value 3 indicates the highest priority.";
            sw = rw; hw = r;
            reset = 0x1;
        } media1_port2_pri_in[10:8];
        field {
            name = "reserved";
            desc = "Reserved";
            sw = r; hw = w;
            reset = 0x0;
        } reserved_7_7[7:7];
        field {
            name = "media1_port1_pri_in";
            desc = "Priority of the VEDU bus port The value 3 indicates the highest priority.";
            sw = rw; hw = r;
            reset = 0x2;
        } media1_port1_pri_in[6:4];
        field {
            name = "reserved";
            desc = "Reserved";
            sw = r; hw = w;
            reset = 0x0;
        } reserved_3_3[3:3];
        field {
            name = "media1_port0_pri_in";
            desc = "Priority of the VPSS bus port The value 3 indicates the highest priority.";
            sw = rw; hw = r;
            reset = 0x3;
        } media1_port0_pri_in[2:0];
    } MISC_CTRL28 @ 0x8070;
    reg {
        name = "MISC_CTRL32";
        desc = "MISC_CTRL32 is MDDRC W QOS register 0. (offset 0x8080; total reset 0x00000000; PROVEN: Hi3516E V300 data sheet (Issue 00B06, 2019-05-15), section 3.5.4, PDF page 129).";
        field {
            name = "reserved";
            desc = "Reserved";
            sw = r; hw = w;
            reset = 0x0;
        } reserved_31_31[31:31];
        field {
            name = "eth_w_qos";
            desc = "QOS group of the ETH write channel";
            sw = rw; hw = r;
            reset = 0x0;
        } eth_w_qos[30:28];
        field {
            name = "reserved";
            desc = "Reserved";
            sw = r; hw = w;
            reset = 0x0;
        } reserved_27_27[27:27];
        field {
            name = "sdio1_w_qos";
            desc = "QOS group of the SDIO1 write channel";
            sw = rw; hw = r;
            reset = 0x0;
        } sdio1_w_qos[26:24];
        field {
            name = "reserved";
            desc = "Reserved";
            sw = r; hw = w;
            reset = 0x0;
        } reserved_23_23[23:23];
        field {
            name = "sdio0_w_qos";
            desc = "QOS group of the SDIO0 write channel";
            sw = rw; hw = r;
            reset = 0x0;
        } sdio0_w_qos[22:20];
        field {
            name = "reserved";
            desc = "Reserved";
            sw = r; hw = w;
            reset = 0x0;
        } reserved_19_19[19:19];
        field {
            name = "usb_w_qos";
            desc = "QOS group of the USB write channel";
            sw = rw; hw = r;
            reset = 0x0;
        } usb_w_qos[18:16];
        field {
            name = "reserved";
            desc = "Reserved";
            sw = r; hw = w;
            reset = 0x0;
        } reserved_15_15[15:15];
        field {
            name = "fmc_w_qos";
            desc = "QOS group of the FMC write channel";
            sw = rw; hw = r;
            reset = 0x0;
        } fmc_w_qos[14:12];
        field {
            name = "reserved";
            desc = "Reserved";
            sw = r; hw = w;
            reset = 0x0;
        } reserved_11_11[11:11];
        field {
            name = "spacc_w_qos";
            desc = "QOS group of the SPACC write channel";
            sw = rw; hw = r;
            reset = 0x0;
        } spacc_w_qos[10:8];
        field {
            name = "reserved";
            desc = "Reserved";
            sw = r; hw = w;
            reset = 0x0;
        } reserved_7_7[7:7];
        field {
            name = "dmac_w_qos";
            desc = "QOS group of the DMAC write channel";
            sw = rw; hw = r;
            reset = 0x0;
        } dmac_w_qos[6:4];
        field {
            name = "reserved";
            desc = "Reserved";
            sw = r; hw = w;
            reset = 0x0;
        } reserved_3_3[3:3];
        field {
            name = "cpu_w_qos";
            desc = "QOS group of the CPU write channel";
            sw = rw; hw = r;
            reset = 0x0;
        } cpu_w_qos[2:0];
    } MISC_CTRL32 @ 0x8080;
    reg {
        name = "MISC_CTRL33";
        desc = "MISC_CTRL33 is MDDRC W QOS register 1. (offset 0x8084; total reset 0x00000000; PROVEN: Hi3516E V300 data sheet (Issue 00B06, 2019-05-15), section 3.5.4, PDF page 130).";
        field {
            name = "reserved";
            desc = "Reserved";
            sw = r; hw = w;
            reset = 0x0;
        } reserved_31_31[31:31];
        field {
            name = "vgs_gzip_w_qos";
            desc = "QOS group of the VGS/GZIP read channel";
            sw = rw; hw = r;
            reset = 0x0;
        } vgs_gzip_w_qos[30:28];
        field {
            name = "reserved";
            desc = "Reserved";
            sw = r; hw = w;
            reset = 0x0;
        } reserved_27_27[27:27];
        field {
            name = "ive_ddrt_w_qos";
            desc = "QOS group of the IVE/DDRT read channel";
            sw = rw; hw = r;
            reset = 0x0;
        } ive_ddrt_w_qos[26:24];
        field {
            name = "reserved";
            desc = "Reserved";
            sw = r; hw = w;
            reset = 0x0;
        } reserved_23_23[23:23];
        field {
            name = "vpss_w_qos";
            desc = "QOS group of the VPSS read channel";
            sw = rw; hw = r;
            reset = 0x0;
        } vpss_w_qos[22:20];
        field {
            name = "reserved";
            desc = "Reserved";
            sw = r; hw = w;
            reset = 0x0;
        } reserved_19_19[19:19];
        field {
            name = "vedu_w_qos";
            desc = "QOS group of the VEDU read channel";
            sw = rw; hw = r;
            reset = 0x0;
        } vedu_w_qos[18:16];
        field {
            name = "reserved";
            desc = "Reserved";
            sw = r; hw = w;
            reset = 0x0;
        } reserved_15_15[15:15];
        field {
            name = "jpge_w_qos";
            desc = "QOS group of the JPGE read channel";
            sw = rw; hw = r;
            reset = 0x0;
        } jpge_w_qos[14:12];
        field {
            name = "reserved";
            desc = "Reserved";
            sw = r; hw = w;
            reset = 0x0;
        } reserved_11_11[11:11];
        field {
            name = "viproc_w_qos";
            desc = "QOS group of the VIPROC read channel";
            sw = rw; hw = r;
            reset = 0x0;
        } viproc_w_qos[10:8];
        field {
            name = "reserved";
            desc = "Reserved";
            sw = r; hw = w;
            reset = 0x0;
        } reserved_7_7[7:7];
        field {
            name = "vicap_w_qos";
            desc = "QOS group of the VICAP read channel";
            sw = rw; hw = r;
            reset = 0x0;
        } vicap_w_qos[6:4];
        field {
            name = "reserved";
            desc = "Reserved";
            sw = r; hw = w;
            reset = 0x0;
        } reserved_3_3[3:3];
        field {
            name = "vdp_w_qos";
            desc = "QOS group of the VDP read channel";
            sw = rw; hw = r;
            reset = 0x0;
        } vdp_w_qos[2:0];
    } MISC_CTRL33 @ 0x8084;
    reg {
        name = "MISC_CTRL34";
        desc = "MISC_CTRL34 is MDDRC W QOS register 2. (offset 0x8088; total reset 0x00000000; PROVEN: Hi3516E V300 data sheet (Issue 00B06, 2019-05-15), section 3.5.4, PDF page 130).";
        field {
            name = "reserved";
            desc = "Reserved";
            sw = r; hw = w;
            reset = 0x0;
        } reserved_31_3[31:3];
        field {
            name = "aiao_w_qos";
            desc = "QOS group of the AIAO read channel";
            sw = rw; hw = r;
            reset = 0x0;
        } aiao_w_qos[2:0];
    } MISC_CTRL34 @ 0x8088;
    reg {
        name = "MISC_CTRL36";
        desc = "MISC_CTRL36 is MDDRC R QOS register 0. (offset 0x8090; total reset 0x00000000; PROVEN: Hi3516E V300 data sheet (Issue 00B06, 2019-05-15), section 3.5.4, PDF page 131).";
        field {
            name = "reserved";
            desc = "Reserved";
            sw = r; hw = w;
            reset = 0x0;
        } reserved_31_31[31:31];
        field {
            name = "eth_r_qos";
            desc = "QOS group of the ETH read channel";
            sw = rw; hw = r;
            reset = 0x0;
        } eth_r_qos[30:28];
        field {
            name = "reserved";
            desc = "Reserved";
            sw = r; hw = w;
            reset = 0x0;
        } reserved_27_27[27:27];
        field {
            name = "sdio1_r_qos";
            desc = "QOS group of the SDIO1 read channel";
            sw = rw; hw = r;
            reset = 0x0;
        } sdio1_r_qos[26:24];
        field {
            name = "reserved";
            desc = "Reserved";
            sw = r; hw = w;
            reset = 0x0;
        } reserved_23_23[23:23];
        field {
            name = "sdio0_r_qos";
            desc = "QOS group of the SDIO0 read channel";
            sw = rw; hw = r;
            reset = 0x0;
        } sdio0_r_qos[22:20];
        field {
            name = "reserved";
            desc = "Reserved";
            sw = r; hw = w;
            reset = 0x0;
        } reserved_19_19[19:19];
        field {
            name = "usb_r_qos";
            desc = "QOS group of the USB read channel";
            sw = rw; hw = r;
            reset = 0x0;
        } usb_r_qos[18:16];
        field {
            name = "reserved";
            desc = "Reserved";
            sw = r; hw = w;
            reset = 0x0;
        } reserved_15_15[15:15];
        field {
            name = "fmc_r_qos";
            desc = "QOS group of the FMC read channel";
            sw = rw; hw = r;
            reset = 0x0;
        } fmc_r_qos[14:12];
        field {
            name = "reserved";
            desc = "Reserved";
            sw = r; hw = w;
            reset = 0x0;
        } reserved_11_11[11:11];
        field {
            name = "spacc_r_qos";
            desc = "QOS group of the SPACC read channel";
            sw = rw; hw = r;
            reset = 0x0;
        } spacc_r_qos[10:8];
        field {
            name = "reserved";
            desc = "Reserved";
            sw = r; hw = w;
            reset = 0x0;
        } reserved_7_7[7:7];
        field {
            name = "dmac_r_qos";
            desc = "QOS group of the DMAC read channel";
            sw = rw; hw = r;
            reset = 0x0;
        } dmac_r_qos[6:4];
        field {
            name = "reserved";
            desc = "Reserved";
            sw = r; hw = w;
            reset = 0x0;
        } reserved_3_3[3:3];
        field {
            name = "vicap_r_qos";
            desc = "QOS group of the CPU read channel";
            sw = rw; hw = r;
            reset = 0x0;
        } vicap_r_qos[2:0];
    } MISC_CTRL36 @ 0x8090;
    reg {
        name = "MISC_CTRL37";
        desc = "MISC_CTRL37 is MDDRC R QOS register 1. (offset 0x8094; total reset 0x00000000; PROVEN: Hi3516E V300 data sheet (Issue 00B06, 2019-05-15), section 3.5.4, PDF page 131).";
        field {
            name = "reserved";
            desc = "Reserved";
            sw = r; hw = w;
            reset = 0x0;
        } reserved_31_31[31:31];
        field {
            name = "vgs_gzip_r_qos";
            desc = "QOS group of the VGS/GZIP read channel";
            sw = rw; hw = r;
            reset = 0x0;
        } vgs_gzip_r_qos[30:28];
        field {
            name = "reserved";
            desc = "Reserved";
            sw = r; hw = w;
            reset = 0x0;
        } reserved_27_27[27:27];
        field {
            name = "ive_ddrt_r_qos";
            desc = "QOS group of the IVE/DDRT read channel";
            sw = rw; hw = r;
            reset = 0x0;
        } ive_ddrt_r_qos[26:24];
        field {
            name = "reserved";
            desc = "Reserved";
            sw = r; hw = w;
            reset = 0x0;
        } reserved_23_23[23:23];
        field {
            name = "vpss_r_qos";
            desc = "QOS group of the VPSS read channel";
            sw = rw; hw = r;
            reset = 0x0;
        } vpss_r_qos[22:20];
        field {
            name = "reserved";
            desc = "Reserved";
            sw = r; hw = w;
            reset = 0x0;
        } reserved_19_19[19:19];
        field {
            name = "vedu_r_qos";
            desc = "QOS group of the VEDU read channel";
            sw = rw; hw = r;
            reset = 0x0;
        } vedu_r_qos[18:16];
        field {
            name = "reserved";
            desc = "Reserved";
            sw = r; hw = w;
            reset = 0x0;
        } reserved_15_15[15:15];
        field {
            name = "jpge_r_qos";
            desc = "QOS group of the JPGE read channel";
            sw = rw; hw = r;
            reset = 0x0;
        } jpge_r_qos[14:12];
        field {
            name = "reserved";
            desc = "Reserved";
            sw = r; hw = w;
            reset = 0x0;
        } reserved_11_11[11:11];
        field {
            name = "viproc_r_qos";
            desc = "QOS group of the VIPROC read channel";
            sw = rw; hw = r;
            reset = 0x0;
        } viproc_r_qos[10:8];
        field {
            name = "reserved";
            desc = "Reserved";
            sw = r; hw = w;
            reset = 0x0;
        } reserved_7_7[7:7];
        field {
            name = "vicap_r_qos";
            desc = "QOS group of the VICAP read channel";
            sw = rw; hw = r;
            reset = 0x0;
        } vicap_r_qos[6:4];
        field {
            name = "reserved";
            desc = "Reserved";
            sw = r; hw = w;
            reset = 0x0;
        } reserved_3_3[3:3];
        field {
            name = "vdp_r_qos";
            desc = "QOS group of the VDP read channel";
            sw = rw; hw = r;
            reset = 0x0;
        } vdp_r_qos[2:0];
    } MISC_CTRL37 @ 0x8094;
    reg {
        name = "MISC_CTRL38";
        desc = "MISC_CTRL38 is MDDRC R QOS register 2. (offset 0x8098; total reset 0x00000000; PROVEN: Hi3516E V300 data sheet (Issue 00B06, 2019-05-15), section 3.5.4, PDF page 132).";
        field {
            name = "reserved";
            desc = "Reserved";
            sw = r; hw = w;
            reset = 0x0;
        } reserved_31_3[31:3];
        field {
            name = "aiao_r_qos";
            desc = "QOS group of the AIAO read channel";
            sw = rw; hw = r;
            reset = 0x0;
        } aiao_r_qos[2:0];
    } MISC_CTRL38 @ 0x8098;
    reg {
        name = "MISC_CTRL44";
        desc = "MISC_CTRL44 is the SVB control register. (offset 0x80B0; total reset 0x00000000; PROVEN: Hi3516E V300 data sheet (Issue 00B06, 2019-05-15), section 3.5.4, PDF page 132).";
        field {
            name = "reserved";
            desc = "Reserved";
            sw = r; hw = w;
            reset = 0x0;
        } reserved_31_26[31:26];
        field {
            name = "svb_pwm_duty";
            desc = "Number of high level times in a PWM period of the SVB output. The actual number is the configured value plus 1.";
            sw = rw; hw = r;
            reset = 0x0;
        } svb_pwm_duty[25:16];
        field {
            name = "reserved";
            desc = "Reserved";
            sw = r; hw = w;
            reset = 0x0;
        } reserved_15_14[15:14];
        field {
            name = "svb_pwm_period";
            desc = "PWM period of the SVB output. The actual number is the configured value plus 1.";
            sw = rw; hw = r;
            reset = 0x0;
        } svb_pwm_period[13:4];
        field {
            name = "reserved";
            desc = "Reserved";
            sw = r; hw = w;
            reset = 0x0;
        } reserved_3_3[3:3];
        field {
            name = "svb_pwm_load";
            desc = "Parameter load control of the SVB output. Writing 1 to this bit enables the parameters to take effect.";
            sw = w; hw = r;
            reset = 0x0;
        } svb_pwm_load[2:2];
        field {
            name = "svb_pwm_inv";
            desc = "Phase control of the SVB output";
            sw = rw; hw = r;
            reset = 0x0;
        } svb_pwm_inv[1:1];
        field {
            name = "svb_pwm_enable";
            desc = "SVB enable
- 0: disabled
- 1: enabled";
            sw = rw; hw = r;
            reset = 0x0;
        } svb_pwm_enable[0:0];
    } MISC_CTRL44 @ 0x80B0;
    reg {
        name = "MISC_CTRL45";
        desc = "MISC_CTRL45 is the temperature sensor (T-Sensor) control register. (offset 0x80B4; total reset 0x00000000; PROVEN: Hi3516E V300 data sheet (Issue 00B06, 2019-05-15), section 3.5.4, PDF page 133).";
        field {
            name = "tsensor_en";
            desc = "T-Sensor enable
- 0: disabled
- 1: enabled";
            sw = rw; hw = r;
            reset = 0x0;
        } tsensor_en[31:31];
        field {
            name = "tsensor_monitor_en";
            desc = "Cyclic temperature monitoring enable of the T-Sensor
- 0: single measurement mode
- 1: cyclic measurement mode";
            sw = rw; hw = r;
            reset = 0x0;
        } tsensor_monitor_en[30:30];
        field {
            name = "reserved";
            desc = "Reserved";
            sw = r; hw = w;
            reset = 0x0;
        } reserved_29_28[29:28];
        field {
            name = "tsensor_monitor_period";
            desc = "Cycle monitoring period of the T-Sensor. The timing reference is 2 ms.";
            sw = rw; hw = r;
            reset = 0x0;
        } tsensor_monitor_period[27:20];
        field {
            name = "tsensor_uplimit";
            desc = "Upper limit of the temperature";
            sw = rw; hw = r;
            reset = 0x0;
        } tsensor_uplimit[19:10];
        field {
            name = "tsensor_lowlimit";
            desc = "Lower limit of the temperature";
            sw = rw; hw = r;
            reset = 0x0;
        } tsensor_lowlimit[9:0];
    } MISC_CTRL45 @ 0x80B4;
    reg {
        name = "MISC_CTRL46";
        desc = "MISC_CTRL46 is the T-Sensor status register. (offset 0x80B8; total reset 0x00000000; PROVEN: Hi3516E V300 data sheet (Issue 00B06, 2019-05-15), section 3.5.4, PDF page 133).";
        field {
            name = "reserved";
            desc = "Reserved";
            sw = r; hw = w;
            reset = 0x0;
        } reserved_31_4[31:4];
        field {
            name = "tsensor_temp_ct_sel";
            desc = "Time for the T-Sensor to convert the temperature code value
- 00: 0.512 ms
- 01: 1.024 ms
- 10: 0.256 ms";
            sw = rw; hw = r;
            reset = 0x0;
        } tsensor_temp_ct_sel[3:2];
        field {
            name = "tsensor_low_warning";
            desc = "Temperature underflow warning, active high";
            sw = r; hw = w;
            reset = 0x0;
        } tsensor_low_warning[1:1];
        field {
            name = "tsensor_up_warning";
            desc = "Temperature overflow warning, active high";
            sw = r; hw = w;
            reset = 0x0;
        } tsensor_up_warning[0:0];
    } MISC_CTRL46 @ 0x80B8;
    reg {
        name = "MISC_CTRL47";
        desc = "MISC_CTRL47 is T-Sensor temperature record register 0. (offset 0x80BC; total reset 0x00000000; PROVEN: Hi3516E V300 data sheet (Issue 00B06, 2019-05-15), section 3.5.4, PDF page 134).";
        field {
            name = "reserved";
            desc = "Reserved";
            sw = r; hw = w;
            reset = 0x0;
        } reserved_31_26[31:26];
        field {
            name = "tsensor_result1";
            desc = "Temperature record value 1";
            sw = r; hw = w;
            reset = 0x0;
        } tsensor_result1[25:16];
        field {
            name = "reserved";
            desc = "Reserved";
            sw = r; hw = w;
            reset = 0x0;
        } reserved_15_10[15:10];
        field {
            name = "tsensor_result0";
            desc = "Temperature record value 0";
            sw = r; hw = w;
            reset = 0x0;
        } tsensor_result0[9:0];
    } MISC_CTRL47 @ 0x80BC;
    reg {
        name = "MISC_CTRL48";
        desc = "MISC_CTRL48 is T-Sensor temperature record register 1. (offset 0x80C0; total reset 0x00000000; PROVEN: Hi3516E V300 data sheet (Issue 00B06, 2019-05-15), section 3.5.4, PDF page 134).";
        field {
            name = "reserved";
            desc = "Reserved";
            sw = r; hw = w;
            reset = 0x0;
        } reserved_31_26[31:26];
        field {
            name = "tsensor_result3";
            desc = "Temperature record value 3";
            sw = r; hw = w;
            reset = 0x0;
        } tsensor_result3[25:16];
        field {
            name = "reserved";
            desc = "Reserved";
            sw = r; hw = w;
            reset = 0x0;
        } reserved_15_10[15:10];
        field {
            name = "tsensor_result2";
            desc = "Temperature record value 2";
            sw = r; hw = w;
            reset = 0x0;
        } tsensor_result2[9:0];
    } MISC_CTRL48 @ 0x80C0;
    reg {
        name = "MISC_CTRL49";
        desc = "MISC_CTRL49 is T-Sensor temperature record register 2. (offset 0x80C4; total reset 0x00000000; PROVEN: Hi3516E V300 data sheet (Issue 00B06, 2019-05-15), section 3.5.4, PDF page 134).";
        field {
            name = "reserved";
            desc = "Reserved";
            sw = r; hw = w;
            reset = 0x0;
        } reserved_31_26[31:26];
        field {
            name = "tsensor_result5";
            desc = "Temperature record value 5";
            sw = r; hw = w;
            reset = 0x0;
        } tsensor_result5[25:16];
        field {
            name = "reserved";
            desc = "Reserved";
            sw = r; hw = w;
            reset = 0x0;
        } reserved_15_10[15:10];
        field {
            name = "tsensor_result4";
            desc = "Temperature record value 4";
            sw = r; hw = w;
            reset = 0x0;
        } tsensor_result4[9:0];
    } MISC_CTRL49 @ 0x80C4;
    reg {
        name = "MISC_CTRL50";
        desc = "MISC_CTRL50 is T-Sensor temperature record register 3. (offset 0x80C8; total reset 0x00000000; PROVEN: Hi3516E V300 data sheet (Issue 00B06, 2019-05-15), section 3.5.4, PDF page 135).";
        field {
            name = "reserved";
            desc = "Reserved";
            sw = r; hw = w;
            reset = 0x0;
        } reserved_31_26[31:26];
        field {
            name = "tsensor_result7";
            desc = "Temperature record value 7";
            sw = r; hw = w;
            reset = 0x0;
        } tsensor_result7[25:16];
        field {
            name = "reserved";
            desc = "Reserved";
            sw = r; hw = w;
            reset = 0x0;
        } reserved_15_10[15:10];
        field {
            name = "tsensor_result6";
            desc = "Temperature record value 6";
            sw = r; hw = w;
            reset = 0x0;
        } tsensor_result6[9:0];
    } MISC_CTRL50 @ 0x80C8;
    reg {
        name = "MISC_CTRL52";
        desc = "MISC_CTRL52 is CPU HPM control register 0. (offset 0x80D0; total reset 0x00000000; PROVEN: Hi3516E V300 data sheet (Issue 00B06, 2019-05-15), section 3.5.4, PDF page 135).";
        field {
            name = "cpu_hpm_srst_req";
            desc = "CPU HPM reset request, active high.
- 0: reset deasserted
- 1: reset asserted";
            sw = rw; hw = r;
            reset = 0x0;
        } cpu_hpm_srst_req[31:31];
        field {
            name = "cpu_hpm_monitor_en";
            desc = "CPU HPM cyclic monitoring enable.
- 0: disabled (single monitoring)
- 1: enabled";
            sw = rw; hw = r;
            reset = 0x0;
        } cpu_hpm_monitor_en[30:30];
        field {
            name = "cpu_hpm_en";
            desc = "CPU HPM measurement enable
- 0: disabled
- 1: enabled";
            sw = rw; hw = r;
            reset = 0x0;
        } cpu_hpm_en[29:29];
        field {
            name = "reserved";
            desc = "Reserved";
            sw = r; hw = w;
            reset = 0x0;
        } reserved_28_16[28:16];
        field {
            name = "cpu_hpm_monitor_period";
            desc = "CPU HPM cyclic monitoring period. Monitoring period = CPU_hpm_monitor_period_period x 2.048 ms.";
            sw = rw; hw = r;
            reset = 0x0;
        } cpu_hpm_monitor_period[15:8];
        field {
            name = "reserved";
            desc = "Reserved";
            sw = r; hw = w;
            reset = 0x0;
        } reserved_7_6[7:6];
        field {
            name = "cpu_hpm_div";
            desc = "Frequency division ratio of the CPU HPM reference clock. The actual frequency divider is the configured value plus 1.";
            sw = rw; hw = r;
            reset = 0x0;
        } cpu_hpm_div[5:0];
    } MISC_CTRL52 @ 0x80D0;
    reg {
        name = "MISC_CTRL53";
        desc = "MISC_CTRL53 is CPU HPM control register 1. (offset 0x80D4; total reset 0x00000000; PROVEN: Hi3516E V300 data sheet (Issue 00B06, 2019-05-15), section 3.5.4, PDF page 136).";
        field {
            name = "reserved";
            desc = "Reserved";
            sw = r; hw = w;
            reset = 0x0;
        } reserved_31_24[31:24];
        field {
            name = "cpu_hpm_offset";
            desc = "CPU HPM offset value";
            sw = rw; hw = r;
            reset = 0x0;
        } cpu_hpm_offset[23:22];
        field {
            name = "cpu_hpm_shift";
            desc = "CPU HPM shift value";
            sw = rw; hw = r;
            reset = 0x0;
        } cpu_hpm_shift[21:20];
        field {
            name = "cpu_hpm_lowlimit";
            desc = "CPU HPM lower limit";
            sw = rw; hw = r;
            reset = 0x0;
        } cpu_hpm_lowlimit[19:10];
        field {
            name = "cpu_hpm_uplimit";
            desc = "CPU HPM upper limit";
            sw = rw; hw = r;
            reset = 0x0;
        } cpu_hpm_uplimit[9:0];
    } MISC_CTRL53 @ 0x80D4;
    reg {
        name = "MISC_CTRL54";
        desc = "MISC_CTRL54 is CPU HPM status register 0. (offset 0x80D8; total reset 0x00000000; PROVEN: Hi3516E V300 data sheet (Issue 00B06, 2019-05-15), section 3.5.4, PDF page 136).";
        field {
            name = "cpu_hpm_up_warning";
            desc = "CPU HPM overflow warning, active high";
            sw = r; hw = w;
            reset = 0x0;
        } cpu_hpm_up_warning[31:31];
        field {
            name = "cpu_hpm_low_warning";
            desc = "CPU HPM underflow warning, active high";
            sw = r; hw = w;
            reset = 0x0;
        } cpu_hpm_low_warning[30:30];
        field {
            name = "cpu_hpm_pc_valid";
            desc = "CPU HPM output validity indicator
- 0: invalid
- 1: valid";
            sw = r; hw = w;
            reset = 0x0;
        } cpu_hpm_pc_valid[29:29];
        field {
            name = "reserved";
            desc = "Reserved";
            sw = r; hw = w;
            reset = 0x0;
        } reserved_28_26[28:26];
        field {
            name = "cpu_hpm_pc_record1";
            desc = "CPU HPM original code pattern 1";
            sw = r; hw = w;
            reset = 0x0;
        } cpu_hpm_pc_record1[25:16];
        field {
            name = "reserved";
            desc = "Reserved";
            sw = r; hw = w;
            reset = 0x0;
        } reserved_15_10[15:10];
        field {
            name = "cpu_hpm_pc_record0";
            desc = "CPU HPM original code pattern 0";
            sw = r; hw = w;
            reset = 0x0;
        } cpu_hpm_pc_record0[9:0];
    } MISC_CTRL54 @ 0x80D8;
    reg {
        name = "MISC_CTRL55";
        desc = "MISC_CTRL55 is CPU HPM status register 1. (offset 0x80DC; total reset 0x00000000; PROVEN: Hi3516E V300 data sheet (Issue 00B06, 2019-05-15), section 3.5.4, PDF page 136).";
        field {
            name = "cpu_hpm_rcc";
            desc = "CPU HPM output with RCC code";
            sw = r; hw = w;
            reset = 0x0;
        } cpu_hpm_rcc[31:27];
        field {
            name = "reserved";
            desc = "Reserved";
            sw = r; hw = w;
            reset = 0x0;
        } reserved_26_26[26:26];
        field {
            name = "cpu_hpm_pc_record3";
            desc = "CPU HPM original code pattern 3";
            sw = r; hw = w;
            reset = 0x0;
        } cpu_hpm_pc_record3[25:16];
        field {
            name = "reserved";
            desc = "Reserved";
            sw = r; hw = w;
            reset = 0x0;
        } reserved_15_10[15:10];
        field {
            name = "cpu_hpm_pc_record2";
            desc = "CPU HPM original code pattern 2";
            sw = r; hw = w;
            reset = 0x0;
        } cpu_hpm_pc_record2[9:0];
    } MISC_CTRL55 @ 0x80DC;
    reg {
        name = "MISC_CTRL61";
        desc = "MISC_CTRL61 is the core SHPM control register. (offset 0x80F4; total reset 0x00000000; PROVEN: Hi3516E V300 data sheet (Issue 00B06, 2019-05-15), section 3.5.4, PDF page 137).";
        field {
            name = "core_shpm_stat";
            desc = "Core SHPM status";
            sw = r; hw = w;
            reset = 0x0;
        } core_shpm_stat[31:16];
        field {
            name = "core_shpm_cfg";
            desc = "Core SHPM configuration";
            sw = rw; hw = r;
            reset = 0x0;
        } core_shpm_cfg[15:0];
    } MISC_CTRL61 @ 0x80F4;
    reg {
        name = "MISC_CTRL62";
        desc = "MISC_CTRL62 is a stopwatch control register. (offset 0x80F8; total reset 0x00000000; PROVEN: Hi3516E V300 data sheet (Issue 00B06, 2019-05-15), section 3.5.4, PDF page 137).";
        field {
            name = "reserved";
            desc = "Reserved";
            sw = r; hw = w;
            reset = 0x0;
        } reserved_31_5[31:5];
        field {
            name = "startup_timer_sel";
            desc = "Timer point result select
- 000: The time of timer point 0 is displayed in startup_timer_result.
- 001: The time of timer point 1 is displayed in startup_timer_result.
- 010: The time of timer point 2 is displayed in startup_timer_result.
- 011: The time of timer point 3 is displayed in startup_timer_result.
- 100: The time of timer point 4 is displayed in startup_timer_result.

There can be at most five timer points.";
            sw = rw; hw = r;
            reset = 0x0;
        } startup_timer_sel[4:2];
        field {
            name = "startup_timer_clear";
            desc = "Timer result clear. Writing 1 to this bit clears the timer result.";
            sw = w; hw = r;
            reset = 0x0;
        } startup_timer_clear[1:1];
        field {
            name = "startup_timer_trigger";
            desc = "Timer enable. Writing 1 to this bit records the current time.";
            sw = w; hw = r;
            reset = 0x0;
        } startup_timer_trigger[0:0];
    } MISC_CTRL62 @ 0x80F8;
    reg {
        name = "MISC_CTRL63";
        desc = "MISC_CTRL63 is a stopwatch timer value register. (offset 0x80FC; total reset 0x00000000; PROVEN: Hi3516E V300 data sheet (Issue 00B06, 2019-05-15), section 3.5.4, PDF page 138).";
        field {
            name = "startup_timer_result";
            desc = "Time of the timer point specified by startup_timer_sel. The unit is ms.";
            sw = r; hw = w;
            reset = 0x0;
        } startup_timer_result[31:0];
    } MISC_CTRL63 @ 0x80FC;

    reg {
        name = "General purpose register 0";
        desc = "NOT IN THE DATA SHEET: kept from the vendor-code derived register map of this chip (INFERRED, vendor evidence only). Scratch register that survives a soft reset (U-Boot uses SC_GEN1 as REG_START_FLAG). Evidence: PROVEN offset (vendor U-Boot platform.h; note that SC_GEN9 is at 0x154, not at 0x15C).";
        field {
            name = "value";
            desc = "Software scratch value. PROVEN.";
            sw = rw;
            hw = r;
        } value[31:0];
    } SC_GEN0_V @ 0x138;

    reg {
        name = "General purpose register 1";
        desc = "NOT IN THE DATA SHEET: kept from the vendor-code derived register map of this chip (INFERRED, vendor evidence only). Scratch register that survives a soft reset (U-Boot uses SC_GEN1 as REG_START_FLAG). U-Boot START_MAGIC 0x444F574E ('DOWN') is the start flag written here. Evidence: PROVEN offset (vendor U-Boot platform.h; note that SC_GEN9 is at 0x154, not at 0x15C).";
        field {
            name = "value";
            desc = "Software scratch value. PROVEN.";
            sw = rw;
            hw = r;
        } value[31:0];
    } SC_GEN1_V @ 0x13C;

    reg {
        name = "General purpose register 2";
        desc = "NOT IN THE DATA SHEET: kept from the vendor-code derived register map of this chip (INFERRED, vendor evidence only). Scratch register that survives a soft reset (U-Boot uses SC_GEN1 as REG_START_FLAG). Evidence: PROVEN offset (vendor U-Boot platform.h; note that SC_GEN9 is at 0x154, not at 0x15C).";
        field {
            name = "value";
            desc = "Software scratch value. PROVEN.";
            sw = rw;
            hw = r;
        } value[31:0];
    } SC_GEN2_V @ 0x140;

    reg {
        name = "General purpose register 3";
        desc = "NOT IN THE DATA SHEET: kept from the vendor-code derived register map of this chip (INFERRED, vendor evidence only). Scratch register that survives a soft reset (U-Boot uses SC_GEN1 as REG_START_FLAG). Evidence: PROVEN offset (vendor U-Boot platform.h; note that SC_GEN9 is at 0x154, not at 0x15C).";
        field {
            name = "value";
            desc = "Software scratch value. PROVEN.";
            sw = rw;
            hw = r;
        } value[31:0];
    } SC_GEN3_V @ 0x144;

    reg {
        name = "General purpose register 4";
        desc = "NOT IN THE DATA SHEET: kept from the vendor-code derived register map of this chip (INFERRED, vendor evidence only). Scratch register that survives a soft reset (U-Boot uses SC_GEN1 as REG_START_FLAG). Evidence: PROVEN offset (vendor U-Boot platform.h; note that SC_GEN9 is at 0x154, not at 0x15C).";
        field {
            name = "value";
            desc = "Software scratch value. PROVEN.";
            sw = rw;
            hw = r;
        } value[31:0];
    } SC_GEN4_V @ 0x148;

    reg {
        name = "General purpose register 9";
        desc = "NOT IN THE DATA SHEET: kept from the vendor-code derived register map of this chip (INFERRED, vendor evidence only). Scratch register that survives a soft reset (U-Boot uses SC_GEN1 as REG_START_FLAG). Evidence: PROVEN offset (vendor U-Boot platform.h; note that SC_GEN9 is at 0x154, not at 0x15C).";
        field {
            name = "value";
            desc = "Software scratch value. PROVEN.";
            sw = rw;
            hw = r;
        } value[31:0];
    } SC_GEN9_V @ 0x154;

    reg {
        name = "SVB voltage record";
        desc = "NOT IN THE DATA SHEET: kept from the vendor-code derived register map of this chip (INFERRED, vendor evidence only). Used by vendor U-Boot (SYS_CTRL_VOLT_REG 0x12020158) and read by the USB PHY driver (svb_otp_addr 0x12020158 in the vendor DT; thresholds 0x2BC..0x44C select phy trim variants). Content: the SVB (adaptive voltage) value. Evidence: PROVEN offset (U-Boot, DT), field layout UNKNOWN.";
        field {
            name = "svb_volt";
            desc = "SVB voltage value. PROVEN offset, UNKNOWN layout.";
            sw = rw;
            hw = r;
        } svb_volt[31:0];
    } SC_VOLT_V @ 0x158;

    reg {
        name = "HPM check result";
        desc = "NOT IN THE DATA SHEET: kept from the vendor-code derived register map of this chip (INFERRED, vendor evidence only). Evidence: PROVEN (U-Boot hpm_check: union sysboot10 {sys_hpm_core [24:16], hpm_core_err [26]}).";
        field {
            name = "sys_hpm_core";
            desc = "HPM core value. PROVEN (source).";
            sw = rw;
            hw = r;
        } sys_hpm_core[24:16];
        field {
            name = "hpm_core_err";
            desc = "HPM core error flag. PROVEN (source).";
            sw = rw;
            hw = r;
        } hpm_core_err[26:26];
    } SC_HPM_CHECK_V @ 0x15C;

    reg {
        name = "SVB version";
        desc = "NOT IN THE DATA SHEET: kept from the vendor-code derived register map of this chip (INFERRED, vendor evidence only). Evidence: PROVEN (U-Boot start_svb: bits [23:16] set to SVB_VER_16EV300 = 0x10).";
        field {
            name = "svb_ver";
            desc = "SVB algorithm version, 0x10 on the EV300 (0x10 on the EV200, too). PROVEN (source).";
            sw = rw;
            hw = r;
        } svb_ver[23:16];
    } SC_SVB_VER_V @ 0x168;

    reg {
        name = "Custom code";
        desc = "NOT IN THE DATA SHEET: kept from the vendor-code derived register map of this chip (INFERRED, vendor evidence only). Read by sys.ko SYS_HAL_GetCustomCode through the 32 KB window at 0x12020000. Evidence: PROVEN offset, UNKNOWN fields.";
        field {
            name = "custom_code";
            desc = "Customer code word. PROVEN offset.";
            sw = r;
            hw = w;
        } custom_code[31:0];
    } SC_CUSTOM_CODE_V @ 0x230;

    reg {
        name = "MISC control 17";
        desc = "NOT IN THE DATA SHEET: kept from the vendor-code derived register map of this chip (INFERRED, vendor evidence only). Named MISC_CTRL17 by the vendor U-Boot platform.h. Evidence: PROVEN offset, UNKNOWN use.";
        field {
            name = "misc17";
            desc = "Raw register. PROVEN offset.";
            sw = rw;
            hw = r;
        } misc17[31:0];
    } MISC_CTRL17_V @ 0x8044;

    reg {
        name = "MISC control 18";
        desc = "NOT IN THE DATA SHEET: kept from the vendor-code derived register map of this chip (INFERRED, vendor evidence only). Named MISC_CTRL18 by the vendor U-Boot platform.h (EMMC_ISO_EN bit 16 and RG_EMMC_LHEN_IN [22:17] macros nearby, use inferred from names). Evidence: PROVEN offset, INFERRED use.";
        field {
            name = "misc18";
            desc = "Raw register. PROVEN offset.";
            sw = rw;
            hw = r;
        } misc18[31:0];
    } MISC_CTRL18_V @ 0x8048;

    reg {
        name = "Bus priority / QoS 22";
        desc = "NOT IN THE DATA SHEET: kept from the vendor-code derived register map of this chip (INFERRED, vendor evidence only). Written 1 by Goke sys_config.c set_vi_vpss_mode in the offline and online/online modes. AV300 MISC_CTRL22 is a bus-priority register. Evidence: PROVEN write, INFERRED role.";
        field {
            name = "qos22";
            desc = "Raw register.";
            sw = rw;
            hw = r;
        } qos22[31:0];
    } MISC_CTRL22_V @ 0x8058;

    reg {
        name = "QoS 31";
        desc = "NOT IN THE DATA SHEET: kept from the vendor-code derived register map of this chip (INFERRED, vendor evidence only). Goke sys_config.c writes 0x123 in every VI/VPSS mode. AV300 MISC_CTRL31 = MDDRC write QoS. Evidence: PROVEN write, INFERRED role.";
        field {
            name = "qos31";
            desc = "Raw register.";
            sw = rw;
            hw = r;
        } qos31[31:0];
    } MISC_CTRL31_V @ 0x807C;
};
`endif
