`ifndef HI3516EV300_DDRC_QOSB_RDL
`define HI3516EV300_DDRC_QOSB_RDL
regfile eHI3516EV300_DDRC_QOSB {
    name = "DDRC QoS buffer";
    desc = "DDRC QoS buffer of the Hi3516E V300 at base 0x120D_4000. 29 registers extracted programmatically from the Hi3516E V300 data sheet (Issue 00B06, 2019-05-15) (Table 4-5 Summary of QoSBuf registers (base address: 0x120D_4000)): register headings, offsets, total reset values, field bit ranges, access types, names, reset values and descriptions, with PDF page numbers in each register description. Field names, bit ranges, access types and offsets are exact; the free-text descriptions are taken from the cell text of the field table and were checked by sampling only. Hardware not verified.";
    reg {
        name = "QOSB_ADPT_CTRL";
        desc = "QOSB_ADPT_CTRL is the QoSBuf adaptation configuration register. (offset 0x4; total reset 0x00000FF0; PROVEN: Hi3516E V300 data sheet (Issue 00B06, 2019-05-15), section 4.1.6.2, PDF page 235).";
        field {
            name = "reserved";
            desc = "Reserved";
            sw = r; hw = w;
            reset = 0x0;
        } reserved_31_20[31:20];
        field {
            name = "adpt_share_cnt";
            desc = "Adapt counter for lower bits. When the value of this counter decreases to 0, the counter for upper bits corresponding to each CMD";
            sw = rw; hw = r;
            reset = 0xff;
        } adpt_share_cnt[19:4];
        field {
            name = "reserved";
            desc = "Reserved";
            sw = r; hw = w;
            reset = 0x0;
        } reserved_3_3[3:3];
        field {
            name = "adpt_pri_lmt";
            desc = "Adaptivity priority control when the adapt function is enabled
- 0: The command priority can adapt to the second-highest priority when the adapt function is enabled.
- 1: The command priority can adapt to the highest priority when the adapt function is enabled.";
            sw = rw; hw = r;
            reset = 0x0;
        } adpt_pri_lmt[2:2];
        field {
            name = "wr_adpt_en";
            desc = "Write command adapt enable
- 0: The write command adapt function takes effect only when the write command is pushed by the read command.
- 1: The write command adapt function takes effect without the write command being pushed by the read command.";
            sw = rw; hw = r;
            reset = 0x0;
        } wr_adpt_en[1:1];
        field {
            name = "adpt_en";
            desc = "Adapt enable
- 0: disabled
- 1: enabled";
            sw = rw; hw = r;
            reset = 0x0;
        } adpt_en[0:0];
    } QOSB_ADPT_CTRL @ 0x4;
    reg {
        name = "QOSB_BUF_BYP";
        desc = "QOSB_BUF_BYP is the QoSBuf bypass control register. (offset 0x88; total reset 0x00000000; PROVEN: Hi3516E V300 data sheet (Issue 00B06, 2019-05-15), section 4.1.6.2, PDF page 236).";
        field {
            name = "reserved";
            desc = "Reserved";
            sw = r; hw = w;
            reset = 0x0;
        } reserved_31_2[31:2];
        field {
            name = "qos_buf_byp";
            desc = "QoSBuf bypass control x0: forcible non-bypass mode. That is, all the commands enter the QoSBuf module when the value is set to 00 or 10.
- 01: whether to bypass depends on the queue status in the DMC
- 11: forcible bypass mode. None of the commands enters the QoSBuf module.

These modes need to be configured before the access. The dynamic configuration is forbidden during the access.";
            sw = rw; hw = r;
            reset = 0x0;
        } qos_buf_byp[1:0];
    } QOSB_BUF_BYP @ 0x88;
    reg {
        name = "QOSB_WRTOUT0";
        desc = "QOSB_WRTOUT0 is QoSBuf write command timeout period register 0. (offset 0x9C; total reset 0x00000000; PROVEN: Hi3516E V300 data sheet (Issue 00B06, 2019-05-15), section 4.1.6.2, PDF page 237).";
        field {
            name = "reserved";
            desc = "Reserved.";
            sw = r; hw = w;
            reset = 0x0;
        } reserved_31_30[31:30];
        field {
            name = "wr_tout2";
            desc = "Write command timeout period (level 2)
- 0x0: The timeout function is disabled. 0x01-0xFF: (n x 4) clock cycles

When the timeout period is set to 10 bits, the actual count value is 12 bits. That is, the lower two bits are fixed at 0.";
            sw = rw; hw = r;
            reset = 0x0;
        } wr_tout2[29:20];
        field {
            name = "wr_tout1";
            desc = "Write command timeout period (level 1)
- 0x0: The timeout function is disabled. 0x01-0xFF: (n x 4) clock cycles

When the timeout period is set to 10 bits, the actual count value is 12 bits. That is, the lower two bits are fixed at 0.";
            sw = rw; hw = r;
            reset = 0x0;
        } wr_tout1[19:10];
        field {
            name = "wr_tout0";
            desc = "Write command timeout period (level 0)
- 0x0: The timeout function is disabled. 0x01-0xFF: (n x 4) clock cycles

When the timeout period is set to 10 bits, the actual count value is 12 bits. That is, the lower two bits are fixed at 0.";
            sw = rw; hw = r;
            reset = 0x0;
        } wr_tout0[9:0];
    } QOSB_WRTOUT0 @ 0x9C;
    reg {
        name = "QOSB_WRTOUT1";
        desc = "QOSB_WRTOUT1 is QoSBuf write command timeout period register 1. (offset 0xA0; total reset 0x00000000; PROVEN: Hi3516E V300 data sheet (Issue 00B06, 2019-05-15), section 4.1.6.2, PDF page 237).";
        field {
            name = "reserved";
            desc = "Reserved.";
            sw = r; hw = w;
            reset = 0x0;
        } reserved_31_30[31:30];
        field {
            name = "wr_tout5";
            desc = "Write command timeout period (level 5)
- 0x0: The timeout function is disabled. 0x01-0xFF: (n x 4) clock cycles

When the timeout period is set to 10 bits, the actual";
            sw = rw; hw = r;
            reset = 0x0;
        } wr_tout5[29:20];
        field {
            name = "wr_tout4";
            desc = "Write command timeout period (level 4)
- 0x0: The timeout function is disabled. 0x01-0xFF: (n x 4) clock cycles

When the timeout period is set to 10 bits, the actual count value is 12 bits. That is, the lower two bits are fixed at 0.";
            sw = rw; hw = r;
            reset = 0x0;
        } wr_tout4[19:10];
        field {
            name = "wr_tout3";
            desc = "Write command timeout period (level 3)
- 0x0: The timeout function is disabled. 0x01-0xFF: (n x 4) clock cycles

When the timeout period is set to 10 bits, the actual count value is 12 bits. That is, the lower two bits are fixed at 0.";
            sw = rw; hw = r;
            reset = 0x0;
        } wr_tout3[9:0];
    } QOSB_WRTOUT1 @ 0xA0;
    reg {
        name = "QOSB_WRTOUT2";
        desc = "QOSB_WRTOUT2 is QoSBuf write command timeout period register 2. (offset 0xA4; total reset 0x00000000; PROVEN: Hi3516E V300 data sheet (Issue 00B06, 2019-05-15), section 4.1.6.2, PDF page 238).";
        field {
            name = "reserved";
            desc = "Reserved.";
            sw = r; hw = w;
            reset = 0x0;
        } reserved_31_30[31:30];
        field {
            name = "wr_tout8";
            desc = "Write command timeout period (level 8) The configuration mode is the same as that of wr_tout0.";
            sw = rw; hw = r;
            reset = 0x0;
        } wr_tout8[29:20];
        field {
            name = "wr_tout7";
            desc = "Write command timeout period (level 7) The configuration mode is the same as that of wr_tout0.";
            sw = rw; hw = r;
            reset = 0x0;
        } wr_tout7[19:10];
        field {
            name = "wr_tout6";
            desc = "Write command timeout period (level 6) The configuration mode is the same as that of wr_tout0.";
            sw = rw; hw = r;
            reset = 0x0;
        } wr_tout6[9:0];
    } QOSB_WRTOUT2 @ 0xA4;
    reg {
        name = "QOSB_WRTOUT3";
        desc = "QOSB_WRTOUT3 is QoSBuf write command timeout period register 3. (offset 0xA8; total reset 0x00000000; PROVEN: Hi3516E V300 data sheet (Issue 00B06, 2019-05-15), section 4.1.6.2, PDF page 238).";
        field {
            name = "reserved";
            desc = "Reserved.";
            sw = r; hw = w;
            reset = 0x0;
        } reserved_31_30[31:30];
        field {
            name = "wr_tout11";
            desc = "Write command timeout period (level 11) The configuration mode is the same as that of wr_tout0.";
            sw = rw; hw = r;
            reset = 0x0;
        } wr_tout11[29:20];
        field {
            name = "wr_tout10";
            desc = "Write command timeout period (level 10) The configuration mode is the same as that of wr_tout0.";
            sw = rw; hw = r;
            reset = 0x0;
        } wr_tout10[19:10];
        field {
            name = "wr_tout9";
            desc = "Write command timeout period (level 9) The configuration mode is the same as that of wr_tout0.";
            sw = rw; hw = r;
            reset = 0x0;
        } wr_tout9[9:0];
    } QOSB_WRTOUT3 @ 0xA8;
    reg {
        name = "QOSB_WRTOUT4";
        desc = "QOSB_WRTOUT4 is QoSBuf write command timeout period register 4. (offset 0xAC; total reset 0x00000000; PROVEN: Hi3516E V300 data sheet (Issue 00B06, 2019-05-15), section 4.1.6.2, PDF page 239).";
        field {
            name = "reserved";
            desc = "Reserved.";
            sw = r; hw = w;
            reset = 0x0;
        } reserved_31_30[31:30];
        field {
            name = "wr_tout14";
            desc = "Write command timeout period (level 14) The configuration mode is the same as that of wr_tout0.";
            sw = rw; hw = r;
            reset = 0x0;
        } wr_tout14[29:20];
        field {
            name = "wr_tout13";
            desc = "Write command timeout period (level 13) The configuration mode is the same as that of wr_tout0.";
            sw = rw; hw = r;
            reset = 0x0;
        } wr_tout13[19:10];
        field {
            name = "wr_tout12";
            desc = "Write command timeout period (level 12) The configuration mode is the same as that of wr_tout0.";
            sw = rw; hw = r;
            reset = 0x0;
        } wr_tout12[9:0];
    } QOSB_WRTOUT4 @ 0xAC;
    reg {
        name = "QOSB_WRTOUT5";
        desc = "QOSB_WRTOUT5 is QoSBuf write command timeout period register 5. (offset 0xB0; total reset 0x00000000; PROVEN: Hi3516E V300 data sheet (Issue 00B06, 2019-05-15), section 4.1.6.2, PDF page 239).";
        field {
            name = "reserved";
            desc = "Reserved.";
            sw = r; hw = w;
            reset = 0x0;
        } reserved_31_30[31:30];
        field {
            name = "wr_tout15";
            desc = "Write command timeout period (level 15) The configuration mode is the same as that";
            sw = rw; hw = r;
            reset = 0x0;
        } wr_tout15[9:0];
    } QOSB_WRTOUT5 @ 0xB0;
    reg {
        name = "QOSB_WRTOUT_MAP";
        desc = "QOSB_WRTOUT_MAP is the QoSBuf write command timeout mapping mode control register. (offset 0xBC; total reset 0x00000000; PROVEN: Hi3516E V300 data sheet (Issue 00B06, 2019-05-15), section 4.1.6.2, PDF page 240).";
        field {
            name = "reserved";
            desc = "Reserved";
            sw = r; hw = w;
            reset = 0x0;
        } reserved_31_29[31:29];
        field {
            name = "wrtout_map3";
            desc = "There are 16 levels of timeout periods. Four bits are selected from the ID and the level is determined based on the four bits. wrtout_map3 indicates the position of bit 3 in the ID.";
            sw = rw; hw = r;
            reset = 0x0;
        } wrtout_map3[28:24];
        field {
            name = "reserved";
            desc = "Reserved";
            sw = r; hw = w;
            reset = 0x0;
        } reserved_23_21[23:21];
        field {
            name = "wrtout_map2";
            desc = "There are 16 levels of timeout periods. Four bits are selected from the ID and the level is determined based on the four bits. wrtout_map2 indicates the position of bit 2 in the ID.";
            sw = rw; hw = r;
            reset = 0x0;
        } wrtout_map2[20:16];
        field {
            name = "reserved";
            desc = "Reserved";
            sw = r; hw = w;
            reset = 0x0;
        } reserved_15_13[15:13];
        field {
            name = "wrtout_map1";
            desc = "There are 16 levels of timeout periods. Four bits are selected from the ID and the level is determined based on the four bits. wrtout_map1 indicates the position of bit 1 in the ID.";
            sw = rw; hw = r;
            reset = 0x0;
        } wrtout_map1[12:8];
        field {
            name = "reserved";
            desc = "Reserved";
            sw = r; hw = w;
            reset = 0x0;
        } reserved_7_5[7:5];
        field {
            name = "wrtout_map0";
            desc = "There are 16 levels of timeout periods. Four bits are selected from the ID and the level is determined based on the four bits. wrtout_map0 indicates the position of bit 0 in the ID.";
            sw = rw; hw = r;
            reset = 0x0;
        } wrtout_map0[4:0];
    } QOSB_WRTOUT_MAP @ 0xBC;
    reg {
        name = "QOSB_RDTOUT_MAP";
        desc = "QOSB_RDTOUT_MAP is the QoSBuf read command timeout mapping mode control register. (offset 0xD0; total reset 0x00000000; PROVEN: Hi3516E V300 data sheet (Issue 00B06, 2019-05-15), section 4.1.6.2, PDF page 240).";
        field {
            name = "reserved";
            desc = "Reserved";
            sw = r; hw = w;
            reset = 0x0;
        } reserved_31_29[31:29];
        field {
            name = "rdtout_map3";
            desc = "There are 16 levels of timeout periods. Four bits are selected from the ID and the level is determined based on the four bits. rdtout_map3 indicates the position of bit 3 in the ID.";
            sw = rw; hw = r;
            reset = 0x0;
        } rdtout_map3[28:24];
        field {
            name = "reserved";
            desc = "Reserved";
            sw = r; hw = w;
            reset = 0x0;
        } reserved_23_21[23:21];
        field {
            name = "rdtout_map2";
            desc = "There are 16 levels of timeout periods. Four bits are selected from the ID and the level is determined based on the four bits. rdtout_map2 indicates the position of bit 2 in the ID.";
            sw = rw; hw = r;
            reset = 0x0;
        } rdtout_map2[20:16];
        field {
            name = "reserved";
            desc = "Reserved";
            sw = r; hw = w;
            reset = 0x0;
        } reserved_15_13[15:13];
        field {
            name = "rdtout_map1";
            desc = "There are 16 levels of timeout periods. Four bits are selected from the ID and the level is determined based on the four bits. rdtout_map1 indicates the position of bit 1 in the ID.";
            sw = rw; hw = r;
            reset = 0x0;
        } rdtout_map1[12:8];
        field {
            name = "reserved";
            desc = "Reserved";
            sw = r; hw = w;
            reset = 0x0;
        } reserved_7_5[7:5];
        field {
            name = "rdtout_map0";
            desc = "There are 16 levels of timeout periods. Four bits are selected from the ID and the level is determined based on the four bits. rdtout_map0 indicates the position of bit 0 in the ID.";
            sw = rw; hw = r;
            reset = 0x0;
        } rdtout_map0[4:0];
    } QOSB_RDTOUT_MAP @ 0xD0;
    reg {
        name = "QOSB_CKG_CFG";
        desc = "QOSB_CKG_CFG is the QoSBuf clock control register. (offset 0x108; total reset 0x00000001; PROVEN: Hi3516E V300 data sheet (Issue 00B06, 2019-05-15), section 4.1.6.2, PDF page 241).";
        field {
            name = "reserved";
            desc = "Reserved";
            sw = r; hw = w;
            reset = 0x0;
        } reserved_31_1[31:1];
        field {
            name = "dyn_ck_gate";
            desc = "Dynamic clock gating for the QoSBuf module
- 0: The clock is always enabled.
- 1: The clock gating is automatic when the module is idle.";
            sw = rw; hw = r;
            reset = 0x1;
        } dyn_ck_gate[0:0];
    } QOSB_CKG_CFG @ 0x108;
    reg {
        name = "QOSB_DMC_LVL";
        desc = "QOSB_DMC_LVL is the QoSBuf threshold control register for commands that enter the DMC module. (offset 0x10C; total reset 0x0000000F; PROVEN: Hi3516E V300 data sheet (Issue 00B06, 2019-05-15), section 4.1.6.2, PDF page 242).";
        field {
            name = "reserved";
            desc = "Reserved";
            sw = r; hw = w;
            reset = 0x0;
        } reserved_31_5[31:5];
        field {
            name = "dmc_cmd_full_lvl";
            desc = "Number of QoSBuf commands that enter the DMC module. When this threshold is reached, the DMC queue is full. When this field is set to N, the actual number of commands that enter the DMC module is (N + 1) because of the pipeline issue. This register cannot be dynamically configured when it is being accessed.";
            sw = rw; hw = r;
            reset = 0xf;
        } dmc_cmd_full_lvl[4:0];
    } QOSB_DMC_LVL @ 0x10C;
    reg {
        name = "QOSB_CMD_SUM";
        desc = "QOSB_CMD_SUM is the QoSBuf accumulated command count register. (offset 0x124; total reset 0x00000000; PROVEN: Hi3516E V300 data sheet (Issue 00B06, 2019-05-15), section 4.1.6.2, PDF page 242).";
        field {
            name = "qos_cmd_sum";
            desc = "Accumulated value of the commands that are temporarily stored in the QoSBuf in the cycle. The value is wrapped if overflow occurs.";
            sw = r; hw = w;
            reset = 0x0;
        } qos_cmd_sum[31:0];
    } QOSB_CMD_SUM @ 0x124;
    reg {
        name = "QOSB_CMD_CNT";
        desc = "QOSB_CMD_CNT is the QoSBuf command statistics register. (offset 0x180; total reset 0x00000000; PROVEN: Hi3516E V300 data sheet (Issue 00B06, 2019-05-15), section 4.1.6.2, PDF page 242).";
        field {
            name = "reserved";
            desc = "Reserved";
            sw = r; hw = w;
            reset = 0x0;
        } reserved_31_8[31:8];
        field {
            name = "qos_cmd_cnt";
            desc = "Number of commands in the QoSBuf, including those on the pipeline

Access type INT (interrupt status) in the data sheet.";
            sw = r; hw = w;
            reset = 0x0;
        } qos_cmd_cnt[7:0];
    } QOSB_CMD_CNT @ 0x180;
    reg {
        name = "QOSB_RNK_CNT";
        desc = "QOSB_RNK_CNT is the QoSBuf command (in each rank) statistics register. (offset 0x190; total reset 0x00000000; PROVEN: Hi3516E V300 data sheet (Issue 00B06, 2019-05-15), section 4.1.6.2, PDF page 243).";
        field {
            name = "reserved";
            desc = "Reserved";
            sw = r; hw = w;
            reset = 0x0;
        } reserved_31_8[31:8];
        field {
            name = "rnk0_cmd_cnt";
            desc = "Number of rank 0 commands in the current channel in the QoSBuf";
            sw = r; hw = w;
            reset = 0x0;
        } rnk0_cmd_cnt[7:0];
    } QOSB_RNK_CNT @ 0x190;
    reg {
        name = "QOSB_BNK_CNT0";
        desc = "QOSB_BNK_CNT0 is the QoSBuf command (in each bank) statistics register. (offset 0x1A0; total reset 0x00000000; PROVEN: Hi3516E V300 data sheet (Issue 00B06, 2019-05-15), section 4.1.6.2, PDF page 243).";
        field {
            name = "bnk3_cmd_cnt";
            desc = "Number of bank 3 commands in the current channel in the DMC";
            sw = r; hw = w;
            reset = 0x0;
        } bnk3_cmd_cnt[31:24];
        field {
            name = "bnk2_cmd_cnt";
            desc = "Number of bank 2 commands in the current channel in the DMC";
            sw = r; hw = w;
            reset = 0x0;
        } bnk2_cmd_cnt[23:16];
        field {
            name = "bnk1_cmd_cnt";
            desc = "Number of bank 1 commands in the current channel in the DMC";
            sw = r; hw = w;
            reset = 0x0;
        } bnk1_cmd_cnt[15:8];
        field {
            name = "bnk0_cmd_cnt";
            desc = "Number of bank 0 commands in the current channel in the DMC";
            sw = r; hw = w;
            reset = 0x0;
        } bnk0_cmd_cnt[7:0];
    } QOSB_BNK_CNT0 @ 0x1A0;
    reg {
        name = "QOSB_BNK_CNT1";
        desc = "QOSB_BNK_CNT1 is the QoSBuf command (in each bank) statistics register. (offset 0x1B0; total reset 0x00000000; PROVEN: Hi3516E V300 data sheet (Issue 00B06, 2019-05-15), section 4.1.6.2, PDF page 243).";
        field {
            name = "bnk7_cmd_cnt";
            desc = "Number of bank 7 commands in the current channel in the DMC";
            sw = r; hw = w;
            reset = 0x0;
        } bnk7_cmd_cnt[31:24];
        field {
            name = "bnk6_cmd_cnt";
            desc = "Number of bank 6 commands in the current channel in the DMC";
            sw = r; hw = w;
            reset = 0x0;
        } bnk6_cmd_cnt[23:16];
        field {
            name = "bnk5_cmd_cnt";
            desc = "Number of bank 5 commands in the current channel in the DMC";
            sw = r; hw = w;
            reset = 0x0;
        } bnk5_cmd_cnt[15:8];
        field {
            name = "bnk4_cmd_cnt";
            desc = "Number of bank 4 commands in the current channel in the DMC";
            sw = r; hw = w;
            reset = 0x0;
        } bnk4_cmd_cnt[7:0];
    } QOSB_BNK_CNT1 @ 0x1B0;
    reg {
        name = "QOSB_BNK_CNT2";
        desc = "QOSB_BNK_CNT2 is the QoSBuf command (in each bank) statistics register. (offset 0x1C0; total reset 0x00000000; PROVEN: Hi3516E V300 data sheet (Issue 00B06, 2019-05-15), section 4.1.6.2, PDF page 244).";
        field {
            name = "bnk11_cmd_cnt";
            desc = "Number of bank 11 commands in the current channel in the DMC";
            sw = r; hw = w;
            reset = 0x0;
        } bnk11_cmd_cnt[31:24];
        field {
            name = "bnk10_cmd_cnt";
            desc = "Number of bank 10 commands in the current channel in the DMC";
            sw = r; hw = w;
            reset = 0x0;
        } bnk10_cmd_cnt[23:16];
        field {
            name = "bnk9_cmd_cnt";
            desc = "Number of bank 9 commands in the current channel in the DMC";
            sw = r; hw = w;
            reset = 0x0;
        } bnk9_cmd_cnt[15:8];
        field {
            name = "bnk8_cmd_cnt";
            desc = "Number of bank 8 commands in the current channel in the DMC";
            sw = r; hw = w;
            reset = 0x0;
        } bnk8_cmd_cnt[7:0];
    } QOSB_BNK_CNT2 @ 0x1C0;
    reg {
        name = "QOSB_BNK_CNT3";
        desc = "QOSB_BNK_CNT3 is the QoSBuf command (in each bank) statistics register. (offset 0x1D0; total reset 0x00000000; PROVEN: Hi3516E V300 data sheet (Issue 00B06, 2019-05-15), section 4.1.6.2, PDF page 244).";
        field {
            name = "bnk15_cmd_cnt";
            desc = "Number of bank 15 commands in the current channel in the DMC";
            sw = r; hw = w;
            reset = 0x0;
        } bnk15_cmd_cnt[31:24];
        field {
            name = "bnk14_cmd_cnt";
            desc = "Number of bank 14 commands in the current channel in the DMC";
            sw = r; hw = w;
            reset = 0x0;
        } bnk14_cmd_cnt[23:16];
        field {
            name = "bnk13_cmd_cnt";
            desc = "Number of bank 13 commands in the current channel in the DMC";
            sw = r; hw = w;
            reset = 0x0;
        } bnk13_cmd_cnt[15:8];
        field {
            name = "bnk12_cmd_cnt";
            desc = "Number of bank 12 commands in the current channel in the DMC";
            sw = r; hw = w;
            reset = 0x0;
        } bnk12_cmd_cnt[7:0];
    } QOSB_BNK_CNT3 @ 0x1D0;
    reg {
        name = "QOSB_OSTD_CNT";
        desc = "QOSB_OSTD_CNT is the QoSBuf OSTD command (in each channel) statistics register. (offset 0x1E0; total reset 0x00000000; PROVEN: Hi3516E V300 data sheet (Issue 00B06, 2019-05-15), section 4.1.6.2, PDF page 244).";
        field {
            name = "reserved";
            desc = "Reserved";
            sw = r; hw = w;
            reset = 0x0;
        } reserved_31_16[31:16];
        field {
            name = "ch1_cmd_ostd";
            desc = "Number of OSTD commands in channel 1 in the QoSBuf";
            sw = r; hw = w;
            reset = 0x0;
        } ch1_cmd_ostd[15:8];
        field {
            name = "ch0_cmd_ostd";
            desc = "Number of OSTD commands in channel 0 in the QoSBuf";
            sw = r; hw = w;
            reset = 0x0;
        } ch0_cmd_ostd[7:0];
    } QOSB_OSTD_CNT @ 0x1E0;
    reg {
        name = "QOSB_WR_CMD_SUM";
        desc = "QOSB_WR_CMD_SUM is the QoSBuf accumulated write command count register. (offset 0x1E4; total reset 0x00000000; PROVEN: Hi3516E V300 data sheet (Issue 00B06, 2019-05-15), section 4.1.6.2, PDF page 245).";
        field {
            name = "qos_wr_cmd_sum";
            desc = "Accumulated value of the write commands that are temporarily stored in the QoSBuf in the cycle. The value is wrapped if overflow occurs.";
            sw = r; hw = w;
            reset = 0x0;
        } qos_wr_cmd_sum[31:0];
    } QOSB_WR_CMD_SUM @ 0x1E4;
    reg {
        name = "QOSB_RD_CMD_SUM";
        desc = "QOSB_RD_CMD_SUM is the QoSBuf accumulated read command count register. (offset 0x1E8; total reset 0x00000000; PROVEN: Hi3516E V300 data sheet (Issue 00B06, 2019-05-15), section 4.1.6.2, PDF page 245).";
        field {
            name = "qos_rd_cmd_sum";
            desc = "Accumulated value of the read commands that are temporarily stored in the QoSBuf in the cycle. The value is wrapped if overflow occurs.";
            sw = r; hw = w;
            reset = 0x0;
        } qos_rd_cmd_sum[31:0];
    } QOSB_RD_CMD_SUM @ 0x1E8;
    reg {
        name = "QOSB_TIMEOUT_MODE";
        desc = "QOSB_TIMEOUT_MODE is the QoSBuf timeout mode selection register. (offset 0x1F0; total reset 0x00000000; PROVEN: Hi3516E V300 data sheet (Issue 00B06, 2019-05-15), section 4.1.6.2, PDF page 245).";
        field {
            name = "reserved";
            desc = "Reserved";
            sw = r; hw = w;
            reset = 0x0;
        } reserved_31_1[31:1];
        field {
            name = "timeout_mode";
            desc = "Read/Write command timeout mapping mode select
- 0: The timeout mode is mapped by using the

ID and there are 16 levels of timeout periods. For details about the definition of each level, see QOSB_WRTOUT0 to QOSB_WRTOUT3 or QOSB_RDTOUT0 to QOSB_RDTOUT3.";
            sw = rw; hw = r;
            reset = 0x0;
        } timeout_mode[0:0];
    } QOSB_TIMEOUT_MODE @ 0x1F0;
    reg {
        name = "QOSB_RDTOUT0";
        desc = "QOSB_RDTOUT0 is QosBuf read command timeout configuration register 0. (offset 0x300; total reset 0x00000000; PROVEN: Hi3516E V300 data sheet (Issue 00B06, 2019-05-15), section 4.1.6.2, PDF page 246).";
        field {
            name = "reserved";
            desc = "Reserved";
            sw = r; hw = w;
            reset = 0x0;
        } reserved_31_30[31:30];
        field {
            name = "rd_tout2";
            desc = "Read command timeout period (level 2)
- 0x0: The timeout function is disabled. 0x01-0xFF: (n x 4) clock cycles

When the timeout period is set to 10 bits, the actual count value is 12 bits. That is, the lower two bits are fixed at 0.";
            sw = rw; hw = r;
            reset = 0x0;
        } rd_tout2[29:20];
        field {
            name = "rd_tout1";
            desc = "Read command timeout period (level 1)
- 0x0: The timeout function is disabled. 0x01-0xFF: (n x 4) clock cycles

When the timeout period is set to 10 bits, the actual count value is 12 bits. That is, the lower two bits are fixed at 0.";
            sw = rw; hw = r;
            reset = 0x0;
        } rd_tout1[19:10];
        field {
            name = "rd_tout0";
            desc = "Read command timeout period (level 0)
- 0x0: The timeout function is disabled. 0x01-0xFF: (n x 4) clock cycles

When the timeout period is set to 10 bits, the actual count value is 12 bits. That is, the lower two bits are fixed at 0.";
            sw = rw; hw = r;
            reset = 0x0;
        } rd_tout0[9:0];
    } QOSB_RDTOUT0 @ 0x300;
    reg {
        name = "QOSB_RDTOUT1";
        desc = "QOSB_RDTOUT1 is QosBuf read command timeout configuration register 2. (offset 0x304; total reset 0x00000000; PROVEN: Hi3516E V300 data sheet (Issue 00B06, 2019-05-15), section 4.1.6.2, PDF page 246).";
        field {
            name = "reserved";
            desc = "Reserved";
            sw = r; hw = w;
            reset = 0x0;
        } reserved_31_30[31:30];
        field {
            name = "rd_tout5";
            desc = "Read command timeout period (level 5)
- 0x0: The timeout function is disabled. 0x01-0xFF: (n x 4) clock cycles

When the timeout period is set to 10 bits, the actual count value is 12 bits. That is, the lower two bits are fixed at 0.";
            sw = rw; hw = r;
            reset = 0x0;
        } rd_tout5[29:20];
        field {
            name = "rd_tout4";
            desc = "Read command timeout period (level 4)
- 0x0: The timeout function is disabled. 0x01-0xFF: (n x 4) clock cycles

When the timeout period is set to 10 bits, the actual count value is 12 bits. That is, the lower two bits are fixed at 0.";
            sw = rw; hw = r;
            reset = 0x0;
        } rd_tout4[19:10];
        field {
            name = "rd_tout3";
            desc = "Read command timeout period (level 3)
- 0x0: The timeout function is disabled. 0x01-0xFF: (n x 4) clock cycles

When the timeout period is set to 10 bits, the actual count value is 12 bits. That is, the lower two bits are fixed at 0.";
            sw = rw; hw = r;
            reset = 0x0;
        } rd_tout3[9:0];
    } QOSB_RDTOUT1 @ 0x304;
    reg {
        name = "QOSB_RDTOUT2";
        desc = "QOSB_RDTOUT2 is QosBuf read command timeout configuration register 2. (offset 0x308; total reset 0x00000000; PROVEN: Hi3516E V300 data sheet (Issue 00B06, 2019-05-15), section 4.1.6.2, PDF page 247).";
        field {
            name = "reserved";
            desc = "Reserved";
            sw = r; hw = w;
            reset = 0x0;
        } reserved_31_30[31:30];
        field {
            name = "rd_tout8";
            desc = "Read command timeout period (level 8)
- 0x0: The timeout function is disabled. 0x01-0xFF: (n x 4) clock cycles

When the timeout period is set to 10 bits, the actual count value is 12 bits. That is, the lower two bits are fixed at 0.";
            sw = rw; hw = r;
            reset = 0x0;
        } rd_tout8[29:20];
        field {
            name = "rd_tout7";
            desc = "Read command timeout period (level 7)
- 0x0: The timeout function is disabled. 0x01-0xFF: (n x 4) clock cycles";
            sw = rw; hw = r;
            reset = 0x0;
        } rd_tout7[19:10];
        field {
            name = "rd_tout6";
            desc = "Read command timeout period (level 6)
- 0x0: The timeout function is disabled. 0x01-0xFF: (n x 4) clock cycles

When the timeout period is set to 10 bits, the actual count value is 12 bits. That is, the lower two bits are fixed at 0.";
            sw = rw; hw = r;
            reset = 0x0;
        } rd_tout6[9:0];
    } QOSB_RDTOUT2 @ 0x308;
    reg {
        name = "QOSB_RDTOUT3";
        desc = "QOSB_RDTOUT3 is QosBuf read command timeout configuration register 3. (offset 0x30C; total reset 0x00000000; PROVEN: Hi3516E V300 data sheet (Issue 00B06, 2019-05-15), section 4.1.6.2, PDF page 248).";
        field {
            name = "reserved";
            desc = "Reserved";
            sw = r; hw = w;
            reset = 0x0;
        } reserved_31_30[31:30];
        field {
            name = "rd_tout11";
            desc = "Read command timeout period (level 11)
- 0x0: The timeout function is disabled. 0x01-0xFF: (n x 4) clock cycles

When the timeout period is set to 10 bits, the actual count value is 12 bits. That is, the lower two bits are fixed at 0.";
            sw = rw; hw = r;
            reset = 0x0;
        } rd_tout11[29:20];
        field {
            name = "rd_tout10";
            desc = "Read command timeout period (level 10)
- 0x0: The timeout function is disabled. 0x01-0xFF: (n x 4) clock cycles

When the timeout period is set to 10 bits, the actual count value is 12 bits. That is, the lower two bits are fixed at 0.";
            sw = rw; hw = r;
            reset = 0x0;
        } rd_tout10[19:10];
        field {
            name = "rd_tout9";
            desc = "Read command timeout period (level 9)
- 0x0: The timeout function is disabled. 0x01-0xFF: (n x 4) clock cycles

When the timeout period is set to 10 bits, the actual count value is 12 bits. That is, the lower two bits are fixed at 0.";
            sw = rw; hw = r;
            reset = 0x0;
        } rd_tout9[9:0];
    } QOSB_RDTOUT3 @ 0x30C;
    reg {
        name = "QOSB_RDTOUT4";
        desc = "QOSB_RDTOUT3 is QosBuf read command timeout configuration register 4. (offset 0x310; total reset 0x00000000; PROVEN: Hi3516E V300 data sheet (Issue 00B06, 2019-05-15), section 4.1.6.2, PDF page 249).";
        field {
            name = "reserved";
            desc = "Reserved";
            sw = r; hw = w;
            reset = 0x0;
        } reserved_31_30[31:30];
        field {
            name = "rd_tout14";
            desc = "Read command timeout period (level 14)
- 0x0: The timeout function is disabled. 0x01-0xFF: (n x 4) clock cycles

When the timeout period is set to 10 bits, the actual count value is 12 bits. That is, the lower two bits are fixed at 0.";
            sw = rw; hw = r;
            reset = 0x0;
        } rd_tout14[29:20];
        field {
            name = "rd_tout13";
            desc = "Read command timeout period (level 13)
- 0x0: The timeout function is disabled. 0x01-0xFF: (n x 4) clock cycles

When the timeout period is set to 10 bits, the actual count value is 12 bits. That is, the lower two bits are fixed at 0.";
            sw = rw; hw = r;
            reset = 0x0;
        } rd_tout13[19:10];
        field {
            name = "rd_tout12";
            desc = "Read command timeout period (level 12)
- 0x0: The timeout function is disabled. 0x01-0xFF: (n x 4) clock cycles

When the timeout period is set to 10 bits, the actual count value is 12 bits. That is, the lower two bits are fixed at 0.";
            sw = rw; hw = r;
            reset = 0x0;
        } rd_tout12[9:0];
    } QOSB_RDTOUT4 @ 0x310;
    reg {
        name = "QOSB_RDTOUT5";
        desc = "QOSB_RDTOUT5 is QosBuf read command timeout configuration register 5. (offset 0x314; total reset 0x00000000; PROVEN: Hi3516E V300 data sheet (Issue 00B06, 2019-05-15), section 4.1.6.2, PDF page 249).";
        field {
            name = "reserved";
            desc = "Reserved";
            sw = r; hw = w;
            reset = 0x0;
        } reserved_31_10[31:10];
        field {
            name = "rd_tout15";
            desc = "Read command timeout period (level 15)
- 0x0: The timeout function is disabled. 0x01-0xFF: (n x 4) clock cycles

When the timeout period is set to 10 bits, the actual count value is 12 bits. That is, the lower two bits are";
            sw = rw; hw = r;
            reset = 0x0;
        } rd_tout15[9:0];
    } QOSB_RDTOUT5 @ 0x314;
};
`endif
