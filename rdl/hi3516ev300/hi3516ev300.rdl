`include "defines.rdl"

`include "ds_acodec.rdl"
`include "ds_aiao.rdl"
`include "ds_crg.rdl"
`include "ds_dmac.rdl"
`include "ds_ddrc_axi.rdl"
`include "ds_ddrc_dmc.rdl"
`include "ds_ddrc_phy.rdl"
`include "ds_ddrc_qosb.rdl"
`include "ds_fephy.rdl"
`include "ds_fmc.rdl"
`include "ds_klad.rdl"
`include "ds_lsadc.rdl"
`include "ds_mipi_rx.rdl"
`include "ds_mmc.rdl"
`include "ds_otp.rdl"
`include "ds_pmc.rdl"
`include "ds_rtc.rdl"
`include "ds_rtc_int.rdl"
`include "ds_spacc.rdl"
`include "ds_sys_ctrl.rdl"
`include "ds_trng.rdl"
`include "ds_usb.rdl"
`include "ds_vdp.rdl"
`include "ds_vicap.rdl"

`include "../common/HISI_ACODEC_V4.rdl"
`include "../common/HISI_DDR_V4.rdl"
`include "../common/HISI_GZIP_V4.rdl"
`include "../common/HISI_KLAD_V4.rdl"
`include "IOCFG.rdl"
`include "../common/HISI_ISP_V4.rdl"
`include "../common/HISI_VIDEO_V4.rdl"
`include "../common/HISI_VIDEO_NODE_V4.rdl"
`include "USB.rdl"
`include "../common/HISI_AIAO.rdl"
`include "../common/HISI_DMAC_V2.rdl"
`include "../common/HISI_IVE.rdl"
`include "../common/HISI_OTP_USER.rdl"
`include "../common/HISI_RSA.rdl"
`include "../common/HISI_RTC_SPI.rdl"
`include "../common/HISI_SPACC.rdl"
`include "../common/ARM_PL011.rdl"
`include "../common/ARM_PL061.rdl"
`include "../common/HISI_FEMAC.rdl"
`include "../common/HISI_FMC.rdl"
`include "../common/HISI_I2C_V2.rdl"
`include "../common/HISI_LSADC_V2.rdl"
`include "../common/HISI_PWM.rdl"
`include "../common/HISI_MIPI_RX_V4.rdl"
`include "../common/HISI_SPI.rdl"
`include "../common/HISI_TIMER_SP804.rdl"
`include "../common/HISI_TRNG.rdl"
`include "../common/HISI_WDG_SP805.rdl"

addrmap hi3516ev300 {
    name = "hi3516ev300 registers";
    desc = "
        ## Status

        Register map of the Hi3516E V300 (Cortex-A7 IP camera SoC, DDR at 0x40000000). Audited block by block on 2026-11-14 against the Hi3516E V300 data sheet, Issue 00B06 (2019-05-15, dl/Hi3516EV300-Datasheet.pdf): the blocks named ds_*.rdl were regenerated from the data sheet tables (PROVEN: offsets, names, bit ranges, access types, reset values exact; descriptions sampled only) and replaced the earlier vendor-code derived blocks (second pass 2026-11-15: array registers of the DDRC AXI, VICAP, MIPI RX and SPACC blocks now have their instance counts from the data sheet variable tables, the FE PHY MII registers (Table 5-8) are modelled in ds_fephy.rdl, USB PHY ANA_CFG0/ANA_CFG4 carry the data sheet fields, RSA MEM_EMA_CFG added, split field names and page-break losses in CRG/LSADC/FMC/MIPI RX/SPACC repaired); registers the old map knew from vendor code but the data sheet does not tabulate were kept in CRG and SYS_CTRL, marked INFERRED. Blocks the data sheet has no register chapter for (ISP, VIPROC, VGS, GZIP, IVE, VPSS, VEDU, JPGE, TDE, IO config banks, SYSCNT, DDRT; the USB PHY has only ANA_CFG0 and ANA_CFG4; the data sheet interrupt table (Table 3-6) lists no register) and the shared common blocks that match the data sheet (FEMAC, I2C, UART, SPI, PL061 GPIO, SP804 timers, SP805 watchdog, PWM, RSA, SPI RTC) keep their earlier vendor-derived or cross-checked layout; the audit results per block are in docs/rdl-campaign/audit-status.csv and docs/rdl-campaign/hi3516ev300-audit.md of the hi3520d-nvr workspace. Nothing was read from an EV300.

        ## Addresses (vendor device tree, vendor U-Boot and sys.ko; IRQ = GIC SPI number, equal to the interrupt bit of data sheet Table 3-6 minus 32: every number in this table was checked against that table on 2026-11-15)

        | Start Address | Block | IRQ | Documented Here |
        |---------------|-------|-----|-----------------|
        | 0x04010000    | on-chip SRAM 64 KB (U-Boot RAM_START_ADRS 0x04010500) | - | &#10060; |
        | 0x10000000    | FMC control (memory window 0x14000000, 16 MB) | 32 (data sheet Table 3-6, bit 64) | &#9989; |
        | 0x10010000    | eMMC / SDIO0 (SDHCI + vendor regs) | 30 | &#9989; |
        | 0x10020000    | SDIO1 (SDHCI + vendor regs) | 31 | &#9989; |
        | 0x10030000    | USB2 DWC3 (high-speed, host) | 39 | &#9989; (vendor glue registers only) |
        | 0x10040000    | FEMAC (internal FE PHY, MDIO 0x10041100, GLB 0x10041300) | 33 (FE PHY interrupt: 59) | &#9989; |
        | 0x10048000    | FE PHY MII registers (placeholder instance: reached through MDIO, not memory mapped; data sheet Table 5-8) | - | &#9989; |
        | 0x10050000    | CIPHER (SPACC layout, version register 0x308 = 0x02018121) | 34 | &#9989; |
        | 0x10060000    | KLAD | - | &#9989; |
        | 0x10070000    | RSA | - | &#9989; |
        | 0x10080000    | TRNG (registers at +0x200) | - | &#9989; |
        | 0x10090000    | OTP controller (user interface) | - | &#9989; |
        | 0x100A0000    | reserved in the data sheet (the vendor tree names it the OTP user shadow) | - | &#10060; |
        | 0x100B0000    | EDMAC hiedmacv310 (4 channels) | 38 | &#9989; |
        | 0x100C0000    | IO config bank ahb | - | &#9989; |
        | 0x100D0000    | USB2 PHY (hixvp) | - | &#9989; |
        | 0x100E0000    | AIAO | 42 | &#9989; |
        | 0x100F0000    | ACODEC | - | &#9989; |
        | 0x10301000    | GIC distributor (cpu interface 0x10302000) | - | &#10060; |
        | 0x11000000    | VI capture (2 MB) | 43 | &#9989; (subset) |
        | 0x11200000    | VI process (VIPROC) | 44 | &#9989; (subset) |
        | 0x11220000    | ISP (128 KB) | 43 | &#10060; |
        | 0x11240000    | MIPI RX (one controller) | 45 | &#9989; (EV200 block) |
        | 0x11280000    | VO | 40 / 41 (hifb) | &#9989; (heuristic map) |
        | 0x112C0000    | IO config bank vio | - | &#9989; |
        | 0x11300000    | VGS | 49 | &#10060; |
        | 0x11310000    | GZIP | 50 | &#9989; |
        | 0x11320000    | IVE | 51 | &#9989; |
        | 0x11330000    | DDRT (no register table in the data sheet; IRQ bit 85 = SPI 53, DDR_ERR SPI 54) | 53 | &#10060; |
        | 0x11400000    | VPSS | 46 | &#9989; (subset) |
        | 0x11410000    | VEDU | 47 | &#9989; (subset) |
        | 0x11420000    | JPGE | 48 | &#9989; (subset) |
        | 0x12000000    | Timers 0/1 (SP804) | 5 | &#9989; |
        | 0x12001000    | Timers 2/3 (SP804) | 6 | &#9989; |
        | 0x12010000    | CRG | - | &#9989; |
        | 0x12020000    | SYS_CTRL | - | &#9989; |
        | 0x12028000    | MISC_CTRL | - | &#9989; |
        | 0x12030000    | WDG | 2 | &#9989; |
        | 0x12040000    | UART0 / 1 / 2 (PL011, stride 0x1000) | 7 / 8 / 9 | &#9989; |
        | 0x12050000    | SYSCNT (50 MHz generic counter) | - | &#10060; |
        | 0x12060000    | I2C0 / 1 / 2 (hibvt, stride 0x1000) | 11 / 12 / 13 (data sheet bits 43-45) | &#9989; |
        | 0x12070000    | SPI0 / SPI1 (PL022) | 14 / 15 | &#9989; |
        | 0x12080000    | PWM (4 channels, stride 0x20) | - | &#9989; |
        | 0x120A0000    | LSADC (2 channels) | 4 | &#9989; |
        | 0x120B0000    | GPIO0..9 (PL061, stride 0x1000) | 16..25 | &#9989; |
        | 0x120C0000    | IO config bank core | - | &#9989; |
        | 0x120D0000    | DDR AXI (DMC at 0x120D8000, PHY at 0x120DC000) | - | &#9989; (EV200 blocks, see note) |
        | 0x120E0000    | RTC (SPI bridge) | 0 | &#9989; |
        | 0x120F0000    | PMC | - | &#9989; |

        <!-- overview:begin -->

        ### Diagrams

        ![Register blocks by function](assets/diagrams/hi3516ev300-blocks.svg)

        ### Clock-gate and reset map (generated from the CRG registers)

        | Offset | Register | Description | Gate / reset fields |
        |---|---|---|---|
        | 0x068 | PERI_CRG26_V | Motion detection | md_srst_req |
        | 0x078 | PERI_CRG30 | PERI_CRG30 | pclkdbg_cken, arm_core0_srst_req, arm_dbg0_srst_req, l2_srst_req, socdbg_srst_req, cs_srst_req |
        | 0x07C | PERI_CRG31 | PERI_CRG31 | ddr_hipack_srst_req, ddr_apb_srst_req, ddr_cfg_cken, ddr_hipack_cken, ddr_apb_cken |
        | 0x0A4 | PERI_CRG41 | PERI_CRG41 | vedu_srst_req, vedu_cken |
        | 0x0A8 | PERI_CRG42 | PERI_CRG42 | vpss_srst_req, vpss_cken |
        | 0x0AC | PERI_CRG43 | PERI_CRG43 | vgs_srst_req, vgs_cken |
        | 0x0B0 | PERI_CRG44 | PERI_CRG44 | jpge_srst_req, jpge_cken |
        | 0x0BC | PERI_CRG47 | PERI_CRG47 | ive_srst_req, ive_cken, ive_glb_cken |
        | 0x0D8 | PERI_CRG54_V | eFuse/OTP controller clock and reset | efuse_srst_req, efuse_cken |
        | 0x0F0 | PERI_CRG60 | PERI_CRG60 | sensor0_cken, sensor0_srst_req, sensor0_ctrl_cken, sensor0_ctrl_srst_req |
        | 0x0F4 | PERI_CRG61 | PERI_CRG61 | vi_p0_cken, vi_ppc_cken, vi_bus_cken, vi_p0_srst_req, vicap_srst_req |
        | 0x0F8 | PERI_CRG62 | PERI_CRG62 | cil_cken, mipi_pix0_cken, mipi_bus_cken, mipi_pix0_core_srst_req, mipi_bus_srst_req |
        | 0x0FC | PERI_CRG63 | PERI_CRG63 | viproc_cken, viproc_srst_req |
        | 0x100 | PERI_CRG64 | PERI_CRG64 | isp0_cfg_srst_req, isp1_cfg_srst_req, isp0_core_srst_req, isp1_core_srst_req |
        | 0x104 | PERI_CRG65 | PERI_CRG65 | lcd_cken |
        | 0x108 | PERI_CRG66 | PERI_CRG66 | vdp_srst_req, vdp_pcken, vdp_acken, vdp_cfg_cken, vdp_hd_ppc_cken, vdp_hd0_cken, vdp_bt_bp_cken, vdp_bt_cken |
        | 0x140 | PERI_CRG80 | PERI_CRG80 | usb2_phy_xtal_cken, usb2_vcc_srst_req, usb2_bus_cken, usb2_ref_cken, usb2_phy_apb_srst_req, usb2_phy_apb_cken, usb2_utmi_cken |
        | 0x144 | PERI_CRG81 | PERI_CRG81 | fmc_srst_req, fmc_cken |
        | 0x16C | PERI_CRG91 | PERI_CRG91 | hrst_eth_s, eth_cken, fephy_cken, fephy_srst_req |
        | 0x190 | PERI_CRG100 | PERI_CRG100 | gzip_cken, gzip_srst_req |
        | 0x194 | PERI_CRG101 | PERI_CRG101 | dmac_srst_req, dmac_apb_cken, dmac_cken |
        | 0x198 | PERI_CRG102 | PERI_CRG102 | ddrtest_srst_req, ddrtest_cken |
        | 0x19C | PERI_CRG103 | PERI_CRG103 | aiao_srst_req, aiao_cken, aiao_pll_cken, codec_dig_rst_req, codec_ana_rst_req |
        | 0x1A0 | PERI_CRG104 | PERI_CRG104 | klad_srst_req, klad_cken, trng_srst_req, trng_cken, rsa0_srst_req, rsa0_cken, spacc_srst_req_ini, spacc_cken |
        | 0x1B8 | PERI_CRG110 | PERI_CRG110 | uart0_cken, uart1_cken, uart2_cken, uart0_srst_req, uart1_srst_req, uart2_srst_req, i2c0_cken, i2c1_cken, i2c2_cken, i2c0_srst_req, ... |
        | 0x1BC | PERI_CRG111 | PERI_CRG111 | test_clk_en, otp_cken, ls_adc_srst_req, svb_pwm_srst_req, pwm_srst_req, pwm_cken, ssp0_cken, ssp1_cken, spi0_srst_req, spi1_srst_req |
        | 0x1C0 | PERI_CRG112 | PERI_CRG112 | shpm_cken, shpm_srst_req |
        | 0x1E4 | PERI_CRG_PLL121 | PERI_CRG_PLL121 | gzip_rst_ok, vicap_softrst_state, vpss_softrst_state, viproc_softrst_state, vgs_softrst_state |
        | 0x1F4 | PERI_CRG125 | PERI_CRG125 | emmc_rx_srst_req, emmc_tx_srst_req, emmc_srst_req, emmc_cken |
        | 0x22C | PERI_CRG139 | PERI_CRG139 | sdio1_rx_srst_req, sdio1_tx_srst_req, sdio1_srst_req, sdio1_cken |

        Only fields whose names contain a clock-enable or reset keyword are listed; the field descriptions in the register pages give the polarity and the clocks they gate.

        ### Register blocks (generated from this description)

        | Base | Instance | Block | Register space |
        |---|---|---|---|
        | 0x10000000 | FMC | Flash memory controller (FMC) | 224 B |
        | 0x10010000 | MMC0 | eMMC/SDIO controller | 1352 B |
        | 0x10020000 | MMC1 | eMMC/SDIO controller | 1352 B |
        | 0x10030000 | USB | USB 2.0 DRD control registers | 51232 B |
        | 0x10040000 | ETH | HiSilicon femac v2 Fast Ethernet MAC with MDIO | 5184 B |
        | 0x10048000 | FEPHY | Fast Ethernet PHY (FEPHY_BASE) MII management registers | 64 B |
        | 0x10050000 | SPACC | SPACC cipher | 2324 B |
        | 0x10060000 | KLAD | Key ladder (KLAD) | 48 B |
        | 0x10070000 | RSA | RSA (SEC_RSA modular exponentiation engine) | 152 B |
        | 0x10080000 | TRNG | TRNG | 556 B |
        | 0x10090000 | OTP | OTP controller | 80 B |
        | 0x100B0000 | DMAC | DMAC (EDMAC) | 3844 B |
        | 0x100C0000 | IOCFG_AHB | IO configuration bank ahb, Hi3516EV300 | 164 B |
        | 0x100D0000 | USB2_PHY | USB 2.0 PHY (hixvp), Hi3516EV200/EV300 generation | 24 B |
        | 0x100E0000 | AIAO | Audio input/output (AIAO) | 8368 B |
        | 0x100F0000 | ACODEC | Audio codec | 228 B |
        | 0x11000000 | VICAP | Video capture (VICAP) | 70188 B |
        | 0x11020000 | ISP_FE | ISP front end registers (Hi3516E V200 generation) | 45336 B |
        | 0x11200000 | VIPROC | VI processing (VIPROC) registers (Hi3516E V200 generation) | 1920 B |
        | 0x11220000 | ISP_BE | ISP back end registers (Hi3516E V200 generation) | 32384 B |
        | 0x11240000 | MIPI_RX | MIPI RX | 8188 B |
        | 0x11280000 | VDP | Video display processor (VDP) | 69388 B |
        | 0x112C0000 | IOCFG_VIO | IO configuration bank vio, Hi3516EV300 | 168 B |
        | 0x11300000 | VGS | VGS (graphics/scaler, also serves TDE calls) control registers, V4 | 820 B |
        | 0x11310000 | GZIP | Hardware gzip decompressor (GZIP), Hi3516E V200 / V300 generation | 16388 B |
        | 0x11320000 | IVE | HiSilicon intelligent video engine | 148 B |
        | 0x11400000 | VPSS | VPSS control and channel registers, V4 | 1796 B |
        | 0x11410000 | VEDU | VEDU (H.264/H.265 encoder) control registers, V4 | 12308 B |
        | 0x11420000 | JPGE | JPGE (JPEG encoder) control registers, V4 | 3088 B |
        | 0x12000000 | TIMER0 | Timer Registers | 28 B |
        | 0x12000020 | TIMER1 | Timer Registers | 28 B |
        | 0x12001000 | TIMER2 | Timer Registers | 28 B |
        | 0x12001020 | TIMER3 | Timer Registers | 28 B |
        | 0x12010000 | CRG | Clock and reset generator (CRG) | 560 B |
        | 0x12020000 | SYS_CTRL | System controller (SC) and peripheral control registers | 33024 B |
        | 0x12030000 | WDG | Watchdog Registers | 3076 B |
        | 0x12040000 | UART0 | UART (ARM PrimeCell PL011) | 4 KB |
        | 0x12041000 | UART1 | UART (ARM PrimeCell PL011) | 4 KB |
        | 0x12042000 | UART2 | UART (ARM PrimeCell PL011) | 4 KB |
        | 0x12060000 | I2C0 | HiSilicon I2C Master Controller V2 (command-FIFO, timing-command sequencer) | 236 B |
        | 0x12061000 | I2C1 | HiSilicon I2C Master Controller V2 (command-FIFO, timing-command sequencer) | 236 B |
        | 0x12062000 | I2C2 | HiSilicon I2C Master Controller V2 (command-FIFO, timing-command sequencer) | 236 B |
        | 0x12070000 | SPI0 | SPI Registers | 48 B |
        | 0x12071000 | SPI1 | SPI Registers | 48 B |
        | 0x12080000 | PWM | HiSilicon PWM group | 128 B |
        | 0x120A0000 | LSADC | Low-speed ADC | 96 B |
        | 0x120B0000 | GPIO0 | ARM PL061 | 1053 B |
        | 0x120B1000 | GPIO1 | ARM PL061 | 1053 B |
        | 0x120B2000 | GPIO2 | ARM PL061 | 1053 B |
        | 0x120B3000 | GPIO3 | ARM PL061 | 1053 B |
        | 0x120B4000 | GPIO4 | ARM PL061 | 1053 B |
        | 0x120B5000 | GPIO5 | ARM PL061 | 1053 B |
        | 0x120B6000 | GPIO6 | ARM PL061 | 1053 B |
        | 0x120B7000 | GPIO7 | ARM PL061 | 1053 B |
        | 0x120B8000 | GPIO8 | ARM PL061 | 1053 B |
        | 0x120B9000 | GPIO9 | ARM PL061 | 1053 B |
        | 0x120C0000 | IOCFG_CORE | IO configuration bank core, Hi3516EV300 | 44 B |
        | 0x120D0000 | DDRC_AXI | DDRC AXI interface | 1568 B |
        | 0x120D4000 | DDRC_QOSB | DDRC QoS buffer | 792 B |
        | 0x120D8000 | DDRC_DMC | DDRC DMC | 516 B |
        | 0x120DC000 | DDRC_PHY | DDR PHY | 232 B |
        | 0x120E0000 | RTC | RTC SPI interface | 8 B |
        | 0x120E0100 | RTC_INT | Internal RTC register file (device addresses reached through the RTC SPI interface, NOT memory mapped; the instance base 0x120E0100 in the SoC map is a placeholder) | 104 B |
        | 0x120F0000 | PMC | Power management controller (PMC) | 88 B |

        The table is generated from the elaborated root (instances at their absolute addresses; register space is the span of the block's registers, not the data sheet window).

        <!-- overview:end -->
    ";

    eIOCFG_AHB          IOCFG_AHB  @ 0x100C0000;
    eIOCFG_VIO          IOCFG_VIO  @ 0x112C0000;
    eIOCFG_CORE         IOCFG_CORE @ 0x120C0000;

    eVEDU_V4           VEDU       @ 0x11410000;
    eJPGE_V4           JPGE       @ 0x11420000;
    eVPSS_V4           VPSS       @ 0x11400000;
    eISP_FE_V4          ISP_FE     @ 0x11020000;
    eVIPROC_V4          VIPROC     @ 0x11200000;
    eISP_BE_V4          ISP_BE     @ 0x11220000;
    eVGS_V4             VGS        @ 0x11300000;

    eHISI_RSA           RSA        @ 0x10070000;
    eUSB2_PHY_HIXVP     USB2_PHY   @ 0x100D0000;
    eHISI_GZIP_V4      GZIP       @ 0x11310000;
    eHISI_IVE           IVE        @ 0x11320000;
    eHISI_FEMAC         ETH        @ 0x10040000;
    eHISI_TIMER_SP804   TIMER0     @ 0x12000000;
    eHISI_TIMER_SP804   TIMER1     @ 0x12000020;
    eHISI_TIMER_SP804   TIMER2     @ 0x12001000;
    eHISI_TIMER_SP804   TIMER3     @ 0x12001020;
    eHISI_WDG_SP805     WDG        @ 0x12030000;
    eARM_PL011          UART0      @ 0x12040000;
    eARM_PL011          UART1      @ 0x12041000;
    eARM_PL011          UART2      @ 0x12042000;
    eHISI_I2C_V2        I2C0       @ 0x12060000;
    eHISI_I2C_V2        I2C1       @ 0x12061000;
    eHISI_I2C_V2        I2C2       @ 0x12062000;
    eHISI_SPI           SPI0       @ 0x12070000;
    eHISI_SPI           SPI1       @ 0x12071000;
    eHISI_PWM_GRP       PWM        @ 0x12080000;
    eARM_PL061          GPIO0      @ 0x120B0000;
    eARM_PL061          GPIO1      @ 0x120B1000;
    eARM_PL061          GPIO2      @ 0x120B2000;
    eARM_PL061          GPIO3      @ 0x120B3000;
    eARM_PL061          GPIO4      @ 0x120B4000;
    eARM_PL061          GPIO5      @ 0x120B5000;
    eARM_PL061          GPIO6      @ 0x120B6000;
    eARM_PL061          GPIO7      @ 0x120B7000;
    eARM_PL061          GPIO8      @ 0x120B8000;
    eARM_PL061          GPIO9      @ 0x120B9000;
    eHI3516EV300_CRG        CRG        @ 0x12010000;
    eHI3516EV300_SYS_CTRL   SYS_CTRL   @ 0x12020000;
    eHI3516EV300_PMC        PMC        @ 0x120F0000;
    eHI3516EV300_DDRC_AXI   DDRC_AXI   @ 0x120D0000;
    eHI3516EV300_DDRC_QOSB  DDRC_QOSB  @ 0x120D4000;
    eHI3516EV300_DDRC_DMC   DDRC_DMC   @ 0x120D8000;
    eHI3516EV300_DDRC_PHY   DDRC_PHY   @ 0x120DC000;
    eHI3516EV300_FEPHY      FEPHY      @ 0x10048000;   // placeholder: MII registers reached through MDIO, not memory mapped
    eHI3516EV300_FMC        FMC        @ 0x10000000;
    eHI3516EV300_VICAP      VICAP      @ 0x11000000;
    eHI3516EV300_VDP        VDP        @ 0x11280000;
    eHI3516EV300_MIPI_RX    MIPI_RX    @ 0x11240000;
    eHI3516EV300_AIAO       AIAO       @ 0x100E0000;
    eHI3516EV300_ACODEC     ACODEC     @ 0x100F0000;
    eHI3516EV300_MMC        MMC0       @ 0x10010000;
    eHI3516EV300_MMC        MMC1       @ 0x10020000;
    eHI3516EV300_USB        USB        @ 0x10030000;
    eHI3516EV300_SPACC      SPACC      @ 0x10050000;
    eHI3516EV300_KLAD       KLAD       @ 0x10060000;
    eHI3516EV300_TRNG       TRNG       @ 0x10080000;
    eHI3516EV300_OTP        OTP        @ 0x10090000;
    eHI3516EV300_LSADC      LSADC      @ 0x120A0000;
    eHI3516EV300_DMAC       DMAC       @ 0x100B0000;
    eHI3516EV300_RTC        RTC        @ 0x120E0000;
    eHI3516EV300_RTC_INT    RTC_INT    @ 0x120E0100;
};
