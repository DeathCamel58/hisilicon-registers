`ifndef HI3516EV300_FMC_RDL
`define HI3516EV300_FMC_RDL
regfile eHI3516EV300_FMC {
    name = "Flash memory controller (FMC)";
    desc = "Flash memory controller (FMC) of the Hi3516E V300 at base 0x1000_0000. 30 registers extracted programmatically from the Hi3516E V300 data sheet (Issue 00B06, 2019-05-15) (Table 4-10 Summary of FMC registers (base address: 0x1000_0000)): register headings, offsets, total reset values, field bit ranges, access types, names, reset values and descriptions, with PDF page numbers in each register description. Field names, bit ranges, access types and offsets are exact; the free-text descriptions are taken from the cell text of the field table and were checked by sampling only. Hardware not verified.";
    reg {
        name = "FMC_CFG";
        desc = "FMC_CFG is the flash configuration register. (offset 0x0; total reset 0x00001820; PROVEN: Hi3516E V300 data sheet (Issue 00B06, 2019-05-15), section 4.2.8, PDF page 294).";
        field {
            name = "reserved";
            desc = "Reserved";
            sw = r; hw = w;
            reset = 0x0;
        } reserved_31_13[31:13];
        field {
            name = "spi_nand_plane_en";
            desc = "Plane bit function enable. The plane address bit information is sent when the address is sent, which is valid only in SPI NAND mode.
- 11: enabled

Other values: disabled";
            sw = rw; hw = r;
            reset = 0x3;
        } spi_nand_plane_en[12:11];
        field {
            name = "spi_nor_addr_mode";
            desc = "SPI address mode (valid only for the SPI NOR flash) 0 (default): 3-byte address mode
- 1: 4-byte address mode

The reset value depends on the pin.";
            sw = rw; hw = r;
            reset = 0x0;
        } spi_nor_addr_mode[10:10];
        field {
            name = "block_size";
            desc = "Block size of the SPI NAND flash
- 00: 64 pages
- 01: 128 pages

Other values: reserved";
            sw = rw; hw = r;
            reset = 0x0;
        } block_size[9:8];
        field {
            name = "ecc_type";
            desc = "ECC type of the controller
- 000: no ECC
- 001: 8-bit ECC
- 010: 16-bit ECC
- 011: 24-bit ECC

Other values: reserved";
            sw = rw; hw = r;
            reset = 0x1;
        } ecc_type[7:5];
        field {
            name = "page_size";
            desc = "Page size of the SPI NAND flash
- 00: 2 KB
- 01: 4 KB

Other values: reserved";
            sw = rw; hw = r;
            reset = 0x0;
        } page_size[4:3];
        field {
            name = "flash_sel";
            desc = "Flash type select
- 00: SPI NOR flash
- 01: SPI NAND flash

Other values: reserved The reset value depends on the pin.";
            sw = rw; hw = r;
            reset = 0x0;
        } flash_sel[2:1];
        field {
            name = "op_mode";
            desc = "FMC operation mode";
            sw = rw; hw = r;
            reset = 0x0;
        } op_mode[0:0];
    } FMC_CFG @ 0x0;
    reg {
        name = "GLOBAL_CFG";
        desc = "GLOBAL_CFG is the global configuration register. (offset 0x4; total reset 0x000000C4; PROVEN: Hi3516E V300 data sheet (Issue 00B06, 2019-05-15), section 4.2.8, PDF page 295).";
        field {
            name = "reserved";
            desc = "Reserved";
            sw = r; hw = w;
            reset = 0x0;
        } reserved_31_25[31:25];
        field {
            name = "ddr_mode_byp";
            desc = "Bypass function control for the SPI NAND DDR, ensuring the correctness of all previous functions
- 1: The bypass function is enabled.
- 0: The bypass function is disabled.

This bit field applies only to the SPI NAND DDR.";
            sw = rw; hw = r;
            reset = 0x0;
        } ddr_mode_byp[24:24];
        field {
            name = "reserved";
            desc = "Reserved";
            sw = r; hw = w;
            reset = 0x0;
        } reserved_23_16[23:16];
        field {
            name = "sample_point";
            desc = "Sampling point select based on the delay parameter of the flash memory in DDR mode. The frequency of the sampling clock is four times that of the interface read/write clock. The delay is the lowest when the field value is 0x0, and highest when the field value is 0xB.
- 0x0: The sampling point is 2 sampling clock cycles after the valid edge.
- 0x1: The sampling point is 2.5 sampling clock cycles after the valid edge.
- 0x2: The sampling point is 3 sampling clock cycles after the valid edge.
- 0x3: The sampling point is 3.5 sampling clock cycles after the valid edge.
- 0x4: The sampling point is 4 sampling clock cycles after the valid edge.
- 0x5: The sampling point is 4.5 sampling clock cycles after the valid edge.
- 0x6: The sampling point is 5 sampling clock cycles after the valid edge.
- 0x7: The sampling point is 5.5 sampling clock cycles after the valid edge.
- 0x8: The sampling point is 6 sampling clock cycles after the valid edge.
- 0x9: The sampling point is 6.5 sampling clock";
            sw = rw; hw = r;
            reset = 0x0;
        } sample_point[15:12];
        field {
            name = "ddr_mode";
            desc = "DDR mode enable
- 0: normal SDR mode
- 1: DDR mode";
            sw = rw; hw = r;
            reset = 0x0;
        } ddr_mode[11:11];
        field {
            name = "reserved";
            desc = "Reserved";
            sw = r; hw = w;
            reset = 0x1;
        } reserved_10_7[10:7];
        field {
            name = "wp_en";
            desc = "Write protection enable for the WP pin. When this bit is enabled, the chip outputs 0 to the WP pin.
- 0: disabled
- 1: enabled";
            sw = rw; hw = r;
            reset = 0x1;
        } wp_en[6:6];
        field {
            name = "rd_delay";
            desc = "Number of delayed cycles for reading data from the SPI flash (in SDR mode) 000 (default): no delay
- 001: 0.5 cycle
- 010: 1 cycle
- 011: 1.5 cycles
- 100: 2 cycles
- 101: 2.5 cycles
- 110: 3 cycles
- 111: 3.5 cycles";
            sw = rw; hw = r;
            reset = 0x0;
        } rd_delay[5:3];
        field {
            name = "reserved";
            desc = "Reserved";
            sw = r; hw = w;
            reset = 0x1;
        } reserved_2_2[2:2];
        field {
            name = "reserved";
            desc = "Reserved";
            sw = r; hw = w;
            reset = 0x0;
        } reserved_1_0[1:0];
    } GLOBAL_CFG @ 0x4;
    reg {
        name = "TIMING_SPI_CFG";
        desc = "TIMING_SPI_CFG is the SPI timing configuration register. (offset 0x8; total reset 0x0000006F; PROVEN: Hi3516E V300 data sheet (Issue 00B06, 2019-05-15), section 4.2.8, PDF page 296).";
        field {
            name = "reserved";
            desc = "Reserved";
            sw = r; hw = w;
            reset = 0x0;
        } reserved_31_8[31:8];
        field {
            name = "tcss";
            desc = "CS setup time 000-111: (n + 1) interface clock cycles (n = 0, 1, 2, …, 7)";
            sw = rw; hw = r;
            reset = 0x6;
        } tcss[7:4];
        field {
            name = "CSdeselecttime.Itisequaltotheintervalbetweentwoflashoperations.tshsl0000-1111:(n+1)interfaceclockcycles(n=0,1,2,…,15)";
            desc = "";
            sw = rw; hw = r;
            reset = 0xf;
        } CSdeselecttime_Itisequaltotheintervalbetweentwoflashoperations_tshsl0000_1111_n_1_interfaceclockcycles_n_0_1_2_15[3:0];
    } TIMING_SPI_CFG @ 0x8;
    reg {
        name = "FMC_INT";
        desc = "FMC_INT is the interrupt status register. (offset 0x18; total reset 0x00000000; PROVEN: Hi3516E V300 data sheet (Issue 00B06, 2019-05-15), section 4.2.8, PDF page 297).";
        field {
            name = "reserved";
            desc = "Reserved";
            sw = r; hw = w;
            reset = 0x0;
        } reserved_31_8[31:8];
        field {
            name = "ahb_op_int";
            desc = "CPU read/write internal buffer interrupt enable when the FMC is reading/writing data from/to the flash memory
- 0: No interrupt is generated.
- 1: An interrupt is generated.";
            sw = r; hw = w;
            reset = 0x0;
        } ahb_op_int[7:7];
        field {
            name = "reserved";
            desc = "Reserved";
            sw = r; hw = w;
            reset = 0x0;
        } reserved_6_6[6:6];
        field {
            name = "dma_err_int";
            desc = "DMA transfer bus error interrupt
- 0: No interrupt is generated.
- 1: An interrupt is generated.";
            sw = r; hw = w;
            reset = 0x0;
        } dma_err_int[5:5];
        field {
            name = "err_alarm_int";
            desc = "ECC alarm interrupt. An interrupt is generated when the number of error bits reaches the preset threshold.
- 0: No interrupt is generated.
- 1: An interrupt is generated.";
            sw = r; hw = w;
            reset = 0x0;
        } err_alarm_int[4:4];
        field {
            name = "err_inval_int";
            desc = "Uncorrectable ECC error interrupt In 8-bit ECC mode, if errors occur in eight or more bits of the checked 1024-byte data, an interrupt is generated. In 16-bit ECC mode, if errors occur in 16 or more bits of the checked 1024-byte data, an interrupt is generated. In 24-bit ECC mode, if errors occur in 24 or more bits of the checked 1024-byte data, an interrupt is generated.
- 0: No interrupt is generated.
- 1: An interrupt is generated.";
            sw = r; hw = w;
            reset = 0x0;
        } err_inval_int[3:3];
        field {
            name = "err_val_int";
            desc = "Correctable ECC error interrupt In 8-bit ECC mode, if errors occur in one to eight bits of the checked 1024-byte data, an interrupt is";
            sw = r; hw = w;
            reset = 0x0;
        } err_val_int[2:2];
        field {
            name = "Programming(timeout)failureinterruptinDMAmodeop_fail_int0:Nointerruptisgenerated.1:Aninterruptisgenerated.";
            desc = "";
            sw = r; hw = w;
            reset = 0x0;
        } Programming_timeout_failureinterruptinDMAmodeop_fail_int0_Nointerruptisgenerated_1_Aninterruptisgenerated[1:1];
        field {
            name = "Currentcontrolleroperationcompletioninterrupt.Thisbitisautomaticallyclearedwhentheoperationregisteriswritten.op_done_int0:Nointerruptisgenerated.1:Aninterruptisgenerated.";
            desc = "";
            sw = r; hw = w;
            reset = 0x0;
        } Currentcontrolleroperationcompletioninterrupt_Thisbitisautomaticallyclearedwhentheoperationregisteriswritten_op_done_int0_Nointerruptisgenerated_1_Aninterruptisgenerated[0:0];
    } FMC_INT @ 0x18;
    reg {
        name = "FMC_INT_EN";
        desc = "FMC_INT_EN is the interrupt enable register. (offset 0x1C; total reset 0x00000000; PROVEN: Hi3516E V300 data sheet (Issue 00B06, 2019-05-15), section 4.2.8, PDF page 298).";
        field {
            name = "reserved";
            desc = "Reserved";
            sw = r; hw = w;
            reset = 0x0;
        } reserved_31_8[31:8];
        field {
            name = "ahb_op_int_en";
            desc = "CPU read/write internal buffer error interrupt enable when the FMC is reading/writing data from/to the flash memory
- 0: disabled
- 1: enabled";
            sw = rw; hw = r;
            reset = 0x0;
        } ahb_op_int_en[7:7];
        field {
            name = "reserved";
            desc = "Reserved";
            sw = r; hw = w;
            reset = 0x0;
        } reserved_6_6[6:6];
        field {
            name = "dma_err_int_en";
            desc = "DMA transfer bus error interrupt enable
- 0: disabled
- 1: enabled";
            sw = rw; hw = r;
            reset = 0x0;
        } dma_err_int_en[5:5];
        field {
            name = "err_alarm_int_en";
            desc = "ECC alarm interrupt enable. An interrupt is generated when the number of error bits reaches the threshold
- 0: disabled
- 1: enabled";
            sw = rw; hw = r;
            reset = 0x0;
        } err_alarm_int_en[4:4];
        field {
            name = "err_inval_int_en";
            desc = "ECC uncorrectable error interrupt enable
- 0: disabled
- 1: enabled";
            sw = rw; hw = r;
            reset = 0x0;
        } err_inval_int_en[3:3];
        field {
            name = "err_val_int_en";
            desc = "ECC correctable error interrupt enable
- 0: disabled
- 1: enabled";
            sw = rw; hw = r;
            reset = 0x0;
        } err_val_int_en[2:2];
        field {
            name = "op_fail_int_en";
            desc = "Programming operation failure interrupt enable
- 0: disabled
- 1: enabled";
            sw = rw; hw = r;
            reset = 0x0;
        } op_fail_int_en[1:1];
        field {
            name = "op_done_int_en";
            desc = "Current operation completion interrupt enable of the FMC
- 0: disabled
- 1: enabled";
            sw = rw; hw = r;
            reset = 0x0;
        } op_done_int_en[0:0];
    } FMC_INT_EN @ 0x1C;
    reg {
        name = "FMC_INT_CLR";
        desc = "FMC_INT_CLR is the interrupt clear register. (offset 0x20; total reset 0x00000000; PROVEN: Hi3516E V300 data sheet (Issue 00B06, 2019-05-15), section 4.2.8, PDF page 299).";
        field {
            name = "reserved";
            desc = "Reserved";
            sw = r; hw = w;
            reset = 0x0;
        } reserved_31_9[31:9];
        field {
            name = "cache_page_done_int_clr";
            desc = "cache_page_done interrupt clear. Writing 1 clears the interrupt.";
            sw = w; hw = r;
            reset = 0x0;
        } cache_page_done_int_clr[8:8];
        field {
            name = "ahb_op_int_clr";
            desc = "ahb_op_err interrupt clear. Writing 1 clears the interrupt.

Access type WC in the data sheet: written 1 clears the bit.";
            sw = rw; hw = w; onwrite = woclr;
            reset = 0x0;
        } ahb_op_int_clr[7:7];
        field {
            name = "reserved";
            desc = "Reserved";
            sw = r; hw = w;
            reset = 0x0;
        } reserved_6_6[6:6];
        field {
            name = "dma_err_int_clr";
            desc = "DMA transfer bus error interrupt clear. Writing 1 clears the interrupt.

Access type WC in the data sheet: written 1 clears the bit.";
            sw = rw; hw = w; onwrite = woclr;
            reset = 0x0;
        } dma_err_int_clr[5:5];
        field {
            name = "err_alarm_int_clr";
            desc = "err_alarm interrupt clear. Writing 1 clears the interrupt.

Access type WC in the data sheet: written 1 clears the bit.";
            sw = rw; hw = w; onwrite = woclr;
            reset = 0x0;
        } err_alarm_int_clr[4:4];
        field {
            name = "err_inval_int_clr";
            desc = "err_invalid interrupt clear. Writing 1 clears the interrupt.

Access type WC in the data sheet: written 1 clears the bit.";
            sw = rw; hw = w; onwrite = woclr;
            reset = 0x0;
        } err_inval_int_clr[3:3];
        field {
            name = "err_val_int_clr";
            desc = "err_valid interrupt clear. Writing 1 clears the interrupt.

Access type WC in the data sheet: written 1 clears the bit.";
            sw = rw; hw = w; onwrite = woclr;
            reset = 0x0;
        } err_val_int_clr[2:2];
        field {
            name = "op_fail_int_clr";
            desc = "op_fail interrupt clear. Writing 1 clears the interrupt.

Access type WC in the data sheet: written 1 clears the bit.";
            sw = rw; hw = w; onwrite = woclr;
            reset = 0x0;
        } op_fail_int_clr[1:1];
        field {
            name = "op_done_int_clr";
            desc = "op_done interrupt clear. Writing 1 clears the

Access type WC in the data sheet: written 1 clears the bit.";
            sw = rw; hw = w; onwrite = woclr;
            reset = 0x0;
        } op_done_int_clr[0:0];
    } FMC_INT_CLR @ 0x20;
    reg {
        name = "FMC_CMD";
        desc = "FMC_CMD is the command word configuration register. (offset 0x24; total reset 0x00003000; PROVEN: Hi3516E V300 data sheet (Issue 00B06, 2019-05-15), section 4.2.8, PDF page 300).";
        field {
            name = "reserved";
            desc = "Reserved";
            sw = r; hw = w;
            reset = 0x0;
        } reserved_31_16[31:16];
        field {
            name = "reserved";
            desc = "Reserved";
            sw = r; hw = w;
            reset = 0x30;
        } reserved_15_8[15:8];
        field {
            name = "cmd1";
            desc = "First command sent to the SPI NOR/NAND flash by the FMC";
            sw = rw; hw = r;
            reset = 0x0;
        } cmd1[7:0];
    } FMC_CMD @ 0x24;
    reg {
        name = "FMC_ADDRH";
        desc = "FMC_ADDRH is the upper-byte flash address configuration register. (offset 0x28; total reset 0x00000000; PROVEN: Hi3516E V300 data sheet (Issue 00B06, 2019-05-15), section 4.2.8, PDF page 300).";
        field {
            name = "reserved";
            desc = "Reserved";
            sw = r; hw = w;
            reset = 0x0;
        } reserved_31_8[31:8];
        field {
            name = "addrh";
            desc = "Upper byte of the operation address for configuring the SPI NAND flash";
            sw = rw; hw = r;
            reset = 0x0;
        } addrh[7:0];
    } FMC_ADDRH @ 0x28;
    reg {
        name = "FMC_ADDRL";
        desc = "FMC_ADDRL is the lower-4-byte flash address configuration register. (offset 0x2C; total reset 0x00000000; PROVEN: Hi3516E V300 data sheet (Issue 00B06, 2019-05-15), section 4.2.8, PDF page 300).";
        field {
            name = "addrl";
            desc = "Lower 4 bytes of the operation address for configuring the flash (For the SPI NOR flash, configure the flash address.)";
            sw = rw; hw = r;
            reset = 0x0;
        } addrl[31:0];
    } FMC_ADDRL @ 0x2C;
    reg {
        name = "FMC_OP_CFG";
        desc = "FMC_OP_CFG is the operation configuration register. (offset 0x30; total reset 0x00000000; PROVEN: Hi3516E V300 data sheet (Issue 00B06, 2019-05-15), section 4.2.8, PDF page 300).";
        field {
            name = "reserved";
            desc = "Reserved";
            sw = r; hw = w;
            reset = 0x0;
        } reserved_31_14[31:14];
        field {
            name = "multi_cycle_en";
            desc = "SPI redundancy period enable
- 0: disabled
- 1: enabled

When the frequency of the output clock exceeds 50 MHz, this bit must be set to 1.";
            sw = rw; hw = r;
            reset = 0x0;
        } multi_cycle_en[13:13];
        field {
            name = "reserved";
            desc = "Reserved";
            sw = r; hw = w;
            reset = 0x0;
        } reserved_12_12[12:12];
        field {
            name = "fm_cs";
            desc = "CS corresponding to the flash to be operated
- 0: CS0
- 1: CS1";
            sw = rw; hw = r;
            reset = 0x0;
        } fm_cs[11:11];
        field {
            name = "force_cs_en";
            desc = "CS forcible pull-down enable
- 0: disabled
- 1: enabled";
            sw = rw; hw = r;
            reset = 0x0;
        } force_cs_en[10:10];
        field {
            name = "mem_if_type";
            desc = "SPI flash interface type select (read operation)
- 000: standard SPI
- 001: dual-Input/Dual-output/SPI
- 010: dual I/O SPI
- 011: quad-Input/quad-output/ SPI
- 100: quad I/O SPI 101-111: reserved";
            sw = rw; hw = r;
            reset = 0x0;
        } mem_if_type[9:7];
        field {
            name = "addr_num";
            desc = "Number of bytes of the address sent to the flash";
            sw = rw; hw = r;
            reset = 0x0;
        } addr_num[6:4];
        field {
            name = "dummy_num";
            desc = "Number of bytes to be operated for dummy_en (one byte is equivalent to two clock cycles in 4-wire mode, four clock cycles in 2-wire mode, or eight clock cycles in 1-wire mode)";
            sw = rw; hw = r;
            reset = 0x0;
        } dummy_num[3:0];
    } FMC_OP_CFG @ 0x30;
    reg {
        name = "SPI_OP_ADDR";
        desc = "SPI_OP_ADDR is the operation address configuration register. (offset 0x34; total reset 0x00000000; PROVEN: Hi3516E V300 data sheet (Issue 00B06, 2019-05-15), section 4.2.8, PDF page 301).";
        field {
            name = "spi_op_addr";
            desc = "Operation address of the SPI NOR/NAND flash. The operation address of the SPI flash is issued for each operation. This address is different from that described in FMC_ADDRL and FMC_ADDRH.";
            sw = rw; hw = r;
            reset = 0x0;
        } spi_op_addr[31:0];
    } SPI_OP_ADDR @ 0x34;
    reg {
        name = "FMC_DATA_NUM";
        desc = "FMC_DATA_NUM is the data length register. (offset 0x38; total reset 0x00000000; PROVEN: Hi3516E V300 data sheet (Issue 00B06, 2019-05-15), section 4.2.8, PDF page 302).";
        field {
            name = "reserved";
            desc = "Reserved";
            sw = r; hw = w;
            reset = 0x0;
        } reserved_31_14[31:14];
        field {
            name = "op_data_num";
            desc = "Length of data to be processed during one operation. This register needs to be configured when there is data transmission and does not need to be configured for the DMA operations and AHB direct access. This register is valid only in ECC0 mode.";
            sw = rw; hw = r;
            reset = 0x0;
        } op_data_num[13:0];
    } FMC_DATA_NUM @ 0x38;
    reg {
        name = "FMC_OP";
        desc = "FMC_OP is the operation register. (offset 0x3C; total reset 0x00000000; PROVEN: Hi3516E V300 data sheet (Issue 00B06, 2019-05-15), section 4.2.8, PDF page 302).";
        field {
            name = "reserved";
            desc = "Reserved";
            sw = r; hw = w;
            reset = 0x0;
        } reserved_31_9[31:9];
        field {
            name = "dummy_en";
            desc = "Dummy byte transfer enable after the address operation is enabled
- 0: disabled
- 1: enabled";
            sw = rw; hw = r;
            reset = 0x0;
        } dummy_en[8:8];
        field {
            name = "cmd1_en";
            desc = "Enable for transmitting command 1 to the flash
- 0: disabled
- 1: enabled";
            sw = rw; hw = r;
            reset = 0x0;
        } cmd1_en[7:7];
        field {
            name = "addr_en";
            desc = "Enable for writing the operation address to the flash
- 0: disabled
- 1: enabled";
            sw = rw; hw = r;
            reset = 0x0;
        } addr_en[6:6];
        field {
            name = "write_data_en";
            desc = "Enable for writing data to the flash
- 0: disabled
- 1: enabled read_data_en and write_data_en cannot be 1 at the same time.";
            sw = rw; hw = r;
            reset = 0x0;
        } write_data_en[5:5];
        field {
            name = "reserved";
            desc = "Reserved";
            sw = r; hw = w;
            reset = 0x0;
        } reserved_4_3[4:3];
        field {
            name = "read_data_en";
            desc = "Enable for reading data from the flash
- 0: disabled";
            sw = rw; hw = r;
            reset = 0x0;
        } read_data_en[2:2];
        field {
            name = "Enableforreadingtheflashstatusregister0:disabled1:enabledread_status_enWhenthisbitissetto1,thecomponentstatusregistervaluereadbythecontrollerisstoredinthefm_statusfieldofFMC_FLASH_INFO(notwrittentotheinternalbuffer).";
            desc = "";
            sw = rw; hw = r;
            reset = 0x0;
        } Enableforreadingtheflashstatusregister0_disabled1_enabledread_status_enWhenthisbitissetto1_thecomponentstatusregistervaluereadbythecontrollerisstoredinthefm_statusfieldofFMC_FLASH_INFO_notwrittentotheinternalbuffer[1:1];
        field {
            name = "ControllerstatuswhencommandsareissuedbyconfiguringtheFMC_OPregister0:Thecontrollerisready.Thisbitcanbesetonlyto1whensoftwareissuesthecommand,reg_op_startindicatingthatthelogicisenabled.1:Thecontrollerisbusy.Thisbitisautomaticallysetto0aftertheoperationiscomplete,indicatingthatthelogiciscomplete.";
            desc = "Access type RWSC in the data sheet (self-clearing).";
            sw = rw; hw = rw;
            reset = 0x0;
        } ControllerstatuswhencommandsareissuedbyconfiguringtheFMC_OPregister0_Thecontrollerisready_Thisbitcanbesetonlyto1whensoftwareissuesthecommand_reg_op_startindicatingthatthelogicisenabled_1_Thecontrollerisbusy_Thisbitisautomaticallysetto0aftertheoperationiscomplete_indicatingthatthelogiciscomplete[0:0];
    } FMC_OP @ 0x3C;
    reg {
        name = "FMC_DMA_LEN";
        desc = "FMC_DMA_LEN is the DMA operation length register. (offset 0x40; total reset 0x00000000; PROVEN: Hi3516E V300 data sheet (Issue 00B06, 2019-05-15), section 4.2.8, PDF page 303).";
        field {
            name = "reserved";
            desc = "Reserved";
            sw = r; hw = w;
            reset = 0x0;
        } reserved_31_28[31:28];
        field {
            name = "dma_len";
            desc = "Data transfer length during DMA operations (in byte) This field is used to configure the length of data in the spare data when the SPI NAND flash memory use the ECC0 mode. This field is used to configure the length of data required for the DMA read/write operation of the SPI NOR flash.";
            sw = rw; hw = r;
            reset = 0x0;
        } dma_len[27:0];
    } FMC_DMA_LEN @ 0x40;
    reg {
        name = "FMC_DMA_AHB_CTRL";
        desc = "FMC_DMA_AHB_CTRL is the DMA AHB control register. (offset 0x48; total reset 0x00000007; PROVEN: Hi3516E V300 data sheet (Issue 00B06, 2019-05-15), section 4.2.8, PDF page 303).";
        field {
            name = "reserved";
            desc = "Reserved";
            sw = r; hw = w;
            reset = 0x0;
        } reserved_31_3[31:3];
        field {
            name = "burst16_en";
            desc = "Burst16 enable
- 0: disabled
- 1: enabled";
            sw = rw; hw = r;
            reset = 0x1;
        } burst16_en[2:2];
        field {
            name = "burst8_en";
            desc = "Burst8 enable
- 0: disabled
- 1: enabled";
            sw = rw; hw = r;
            reset = 0x1;
        } burst8_en[1:1];
        field {
            name = "burst4_en";
            desc = "Burst4 enable
- 0: disabled
- 1: enabled";
            sw = rw; hw = r;
            reset = 0x1;
        } burst4_en[0:0];
    } FMC_DMA_AHB_CTRL @ 0x48;
    reg {
        name = "FMC_DMA_SADDR_D0";
        desc = "FMC_DMA_SADDR_D0 is DDR SDRAM start address register 0 for DMA operations. (offset 0x4C; total reset 0x00000000; PROVEN: Hi3516E V300 data sheet (Issue 00B06, 2019-05-15), section 4.2.8, PDF page 304).";
        field {
            name = "dma_mem_saddr_d0";
            desc = "For the SPI NOR flash, this register indicates the DDR SDRAM start address for DMA operations. For the SPI NAND flash, this register indicates the base address of DDR SDRAM operation data for DMA operations.";
            sw = rw; hw = r;
            reset = 0x0;
        } dma_mem_saddr_d0[31:0];
    } FMC_DMA_SADDR_D0 @ 0x4C;
    reg {
        name = "FMC_DMA_SADDR_OOB";
        desc = "FMC_DMA_SADDR_OOB is the DDR SDRAM OOB information storage start address register for DMA operations. (offset 0x5C; total reset 0x00000000; PROVEN: Hi3516E V300 data sheet (Issue 00B06, 2019-05-15), section 4.2.8, PDF page 304).";
        field {
            name = "dma_mem_saddr_oob";
            desc = "DDR SDRAM base address for the OOB area that stores the data to be read or written";
            sw = rw; hw = r;
            reset = 0x0;
        } dma_mem_saddr_oob[31:0];
    } FMC_DMA_SADDR_OOB @ 0x5C;
    reg {
        name = "FMC_OP_CTRL";
        desc = "FMC_OP_CTRL is the DMA operation control register. (offset 0x68; total reset 0x00030200; PROVEN: Hi3516E V300 data sheet (Issue 00B06, 2019-05-15), section 4.2.8, PDF page 304).";
        field {
            name = "reserved";
            desc = "Reserved";
            sw = r; hw = w;
            reset = 0x0;
        } reserved_31_24[31:24];
        field {
            name = "rd_opcode";
            desc = "SPI NAND/SPI NOR flash, DMA read command, non-bus mode (FAST_READ/READ/DUAL_READ)";
            sw = rw; hw = r;
            reset = 0x3;
        } rd_opcode[23:16];
        field {
            name = "wr_opcode";
            desc = "SPI NAND/SPI NOR flash, DMA write command";
            sw = rw; hw = r;
            reset = 0x2;
        } wr_opcode[15:8];
        field {
            name = "reserved";
            desc = "Reserved";
            sw = r; hw = w;
            reset = 0x0;
        } reserved_7_6[7:6];
        field {
            name = "rd_op_sel";
            desc = "Area of data to be read
- 00: Data on the entire page is read.
- 01: Only the OOB data is read.
- 10: reserved
- 11: reserved";
            sw = rw; hw = r;
            reset = 0x0;
        } rd_op_sel[5:4];
        field {
            name = "reserved";
            desc = "Reserved";
            sw = r; hw = w;
            reset = 0x0;
        } reserved_3_2[3:2];
        field {
            name = "rw_op";
            desc = "DMA write/read mode select
- 0: DMA read mode
- 1: DMA write mode";
            sw = rw; hw = r;
            reset = 0x0;
        } rw_op[1:1];
        field {
            name = "dma_op_ready";
            desc = "Controller status when commands are issued by configuring the FMC_OP_CTRL register
- 0: The controller is ready. This bit can be set only to 1 when software issues the command, indicating that the logic is enabled.
- 1: The controller is busy. This bit is automatically set to 0 after the operation is complete, indicating that the logic is complete.

Access type RWSC in the data sheet (self-clearing).";
            sw = rw; hw = rw;
            reset = 0x0;
        } dma_op_ready[0:0];
    } FMC_OP_CTRL @ 0x68;
    reg {
        name = "FMC_TIMEOUT_WR";
        desc = "FMC_TIMEOUT_WR is the write operation timeout register. (offset 0x6C; total reset 0x00FFFFFF; PROVEN: Hi3516E V300 data sheet (Issue 00B06, 2019-05-15), section 4.2.8, PDF page 305).";
        field {
            name = "reserved";
            desc = "Reserved";
            sw = r; hw = w;
            reset = 0x0;
        } reserved_31_24[31:24];
        field {
            name = "timeout_wr";
            desc = "Program operation busy wait time, timeout period. The timeout period is in the unit of one interface clock cycle for the SPI NAND/SPI NOR flash.";
            sw = rw; hw = r;
            reset = 0x0;
        } timeout_wr[23:0];
    } FMC_TIMEOUT_WR @ 0x6C;
    reg {
        name = "FMC_OP_PARA";
        desc = "FMC_OP_PARA is the OP operation parameter selection register. (offset 0x70; total reset 0x00000000; PROVEN: Hi3516E V300 data sheet (Issue 00B06, 2019-05-15), section 4.2.8, PDF page 306).";
        field {
            name = "reserved";
            desc = "Reserved";
            sw = r; hw = w;
            reset = 0x0;
        } reserved_31_2[31:2];
        field {
            name = "rd_oob_only";
            desc = "Only the sector that stores the OOB information is read when the flash read command is issued.
- 0: The page is read.
- 1: Only the OOB information is read.";
            sw = rw; hw = r;
            reset = 0x0;
        } rd_oob_only[1:1];
        field {
            name = "reserved";
            desc = "Reserved";
            sw = r; hw = w;
            reset = 0x0;
        } reserved_0_0[0:0];
    } FMC_OP_PARA @ 0x70;
    reg {
        name = "FMC_BOOT_SET";
        desc = "FMC_BOOT_SET is the boot setting register. (offset 0x74; total reset 0x00000005; PROVEN: Hi3516E V300 data sheet (Issue 00B06, 2019-05-15), section 4.2.8, PDF page 306).";
        field {
            name = "reserved";
            desc = "Reserved";
            sw = r; hw = w;
            reset = 0x0;
        } reserved_31_5[31:5];
        field {
            name = "boot_otp_cfg";
            desc = "Flash configuration information, that is, the mode in which the FMC_CFG register is configured
- 0: adaptive boot mode
- 1: OTP mode";
            sw = rw; hw = r;
            reset = 0x0;
        } boot_otp_cfg[4:4];
        field {
            name = "reserved";
            desc = "Reserved";
            sw = r; hw = w;
            reset = 0x0;
        } reserved_3_3[3:3];
        field {
            name = "reserved";
            desc = "Reserved";
            sw = r; hw = w;
            reset = 0x1;
        } reserved_2_2[2:2];
        field {
            name = "boot_quad_mode";
            desc = "Whether to use the 4-wire boot mode for the SPI NAND flash. The reset value depends on the pin.
- 0: No. The 1-wire boot mode is used.
- 1: Yes.";
            sw = rw; hw = r;
            reset = 0x0;
        } boot_quad_mode[1:1];
        field {
            name = "boot_page0_cfg";
            desc = "Data format conversion enable for the SPI NAND flash
- 0: The data format is not converted. The traversal operation is not performed during the boot process.
- 1: The data format is adaptively converted. The traversal operation is performed during the boot process.";
            sw = rw; hw = r;
            reset = 0x1;
        } boot_page0_cfg[0:0];
    } FMC_BOOT_SET @ 0x74;
    reg {
        name = "FMC_LP_CTRL";
        desc = "FMC_LP_CTRL is the low-power control register. (offset 0x78; total reset 0x00000000; PROVEN: Hi3516E V300 data sheet (Issue 00B06, 2019-05-15), section 4.2.8, PDF page 307).";
        field {
            name = "reserved";
            desc = "Reserved";
            sw = r; hw = w;
            reset = 0x0;
        } reserved_31_2[31:2];
        field {
            name = "mem_gate_en";
            desc = "SRAM clock enable
- 0: enabled
- 1: disabled";
            sw = rw; hw = r;
            reset = 0x0;
        } mem_gate_en[1:1];
        field {
            name = "clk_gate_en";
            desc = "Clock gating select. If the clock gating is enabled, the low-power design is used and the module working clocks are disabled by logic.
- 0: All clocks are enabled.
- 1: Clocks are disabled according to the low-power design.";
            sw = rw; hw = r;
            reset = 0x0;
        } clk_gate_en[0:0];
    } FMC_LP_CTRL @ 0x78;
    reg {
        name = "FMC_ERR_THD";
        desc = "FMC_ERR_THD is the ECC alarm threshold register. (offset 0xA8; total reset 0x000000FF; PROVEN: Hi3516E V300 data sheet (Issue 00B06, 2019-05-15), section 4.2.8, PDF page 307).";
        field {
            name = "reserved";
            desc = "Reserved";
            sw = r; hw = w;
            reset = 0x0;
        } reserved_31_8[31:8];
        field {
            name = "fmc_err_thd";
            desc = "ECC alarm threshold. When the number of error bits reaches the threshold, an ECC alarm interrupt is triggered. If an uncorrectable ECC error occurs, an uncorrectable interrupt is reported regardless of the register value. When the register value is set to 0 or 1, an alarm interrupt is reported as long as an error occurs. When the configured value exceeds the number of correctable error bits, no alarm interrupt is reported regardless of the number of error bits. Only the correctable error interrupt and uncorrectable error interrupt are generated.";
            sw = rw; hw = r;
            reset = 0xff;
        } fmc_err_thd[7:0];
    } FMC_ERR_THD @ 0xA8;
    reg {
        name = "FMC_FLASH_INFO";
        desc = "FMC_FLASH_INFO is the flash status register. (offset 0xAC; total reset 0x00000000; PROVEN: Hi3516E V300 data sheet (Issue 00B06, 2019-05-15), section 4.2.8, PDF page 307).";
        field {
            name = "exp_bb_flag";
            desc = "Uncorrected data corresponding to the bad block flag of the current page when the extended operation of reading only the OOB data or reading the page is issued";
            sw = r; hw = w;
            reset = 0x0;
        } exp_bb_flag[31:24];
        field {
            name = "bb_flag";
            desc = "Uncorrected data corresponding to the bad block flag of the current page when the only the OOB data or the page is read";
            sw = r; hw = w;
            reset = 0x0;
        } bb_flag[23:16];
        field {
            name = "exp_flash_status";
            desc = "Status register value read by the FMC from the flash during extended operations";
            sw = r; hw = w;
            reset = 0x0;
        } exp_flash_status[15:8];
        field {
            name = "flash_status";
            desc = "Status register value read by the FMC from the flash during normal operations. For details about the meanings of bits 7-0, see the flash data sheet.";
            sw = r; hw = w;
            reset = 0x0;
        } flash_status[7:0];
    } FMC_FLASH_INFO @ 0xAC;
    reg {
        name = "FMC_VERSION";
        desc = "FMC_VERSION is the version register. (offset 0xBC; total reset 0x00000100; PROVEN: Hi3516E V300 data sheet (Issue 00B06, 2019-05-15), section 4.2.8, PDF page 308).";
        field {
            name = "version";
            desc = "FMC V100";
            sw = r; hw = w;
            reset = 0x100;
        } version[31:0];
    } FMC_VERSION @ 0xBC;
    reg {
        name = "FMC_ERR_NUM0_BUF0";
        desc = "FMC_ERR_NUM0_BUF0 is the SPI NAND flash error correction information 0 statistics register for the first buffer operation. (offset 0xC0; total reset 0x00000000; PROVEN: Hi3516E V300 data sheet (Issue 00B06, 2019-05-15), section 4.2.8, PDF page 308).";
        field {
            name = "err_num0_buf0";
            desc = "Error bit count for the first 4 KB data during the first buffer operation of the NAND flash with the page size of 2 KB, 4 KB, 8 KB, or 16 KB bit[31:24]: number of error bits in the fourth 1 KB data segment bit[23:16]: number of error bits in the third 1 KB data segment bit[15:8]: number of error bits in the second 1 KB data segment bit[7:0]: number of error bits in the first 1 KB data segment";
            sw = r; hw = w;
            reset = 0x0;
        } err_num0_buf0[31:0];
    } FMC_ERR_NUM0_BUF0 @ 0xC0;
    reg {
        name = "FMC_ERR_ALARM_ADDRH";
        desc = "FMC_ERR_ALARM_ADDRH is the upper-byte ECC alarm flash address register. (offset 0xD0; total reset 0x00000000; PROVEN: Hi3516E V300 data sheet (Issue 00B06, 2019-05-15), section 4.2.8, PDF page 309).";
        field {
            name = "reserved";
            desc = "Reserved";
            sw = r; hw = w;
            reset = 0x0;
        } reserved_31_8[31:8];
        field {
            name = "fmc_err_alarm_addrh";
            desc = "Upper bytes of the operation address of the flash that triggers the last interrupt when an ECC alarm interrupt is generated";
            sw = r; hw = w;
            reset = 0x0;
        } fmc_err_alarm_addrh[7:0];
    } FMC_ERR_ALARM_ADDRH @ 0xD0;
    reg {
        name = "FMC_ERR_ALARM_ADDRL";
        desc = "FMC_ERR_ALARM_ADDRL is the lower-byte ECC alarm flash address register. (offset 0xD4; total reset 0x00000000; PROVEN: Hi3516E V300 data sheet (Issue 00B06, 2019-05-15), section 4.2.8, PDF page 309).";
        field {
            name = "Lowerfmc_err_alarm_addrthatlalarm";
            desc = "bytes of the operation address of the flash triggers the last interrupt when an ECC interrupt is generated";
            sw = r; hw = w;
            reset = 0x0;
        } Lowerfmc_err_alarm_addrthatlalarm[31:0];
    } FMC_ERR_ALARM_ADDRL @ 0xD4;
    reg {
        name = "FMC_ECC_INVALID_ADDRH";
        desc = "FMC_ECC_INVALID_ADDRH is the upper-byte ECC uncorrectable address register. (offset 0xD8; total reset 0x00000000; PROVEN: Hi3516E V300 data sheet (Issue 00B06, 2019-05-15), section 4.2.8, PDF page 309).";
        field {
            name = "reserved";
            desc = "Reserved";
            sw = r; hw = w;
            reset = 0x0;
        } reserved_31_8[31:8];
        field {
            name = "fmc_ecc_invalid_addrh";
            desc = "Upper byte of the operation address of the flash that triggers the last interrupt when an uncorrectable ECC error occurs";
            sw = r; hw = w;
            reset = 0x0;
        } fmc_ecc_invalid_addrh[7:0];
    } FMC_ECC_INVALID_ADDRH @ 0xD8;
    reg {
        name = "FMC_ECC_INVALID_ADDRL";
        desc = "FMC_ECC_INVALID_ADDRL is the lower-4-byte ECC uncorrectable address register. (offset 0xDC; total reset 0x00000000; PROVEN: Hi3516E V300 data sheet (Issue 00B06, 2019-05-15), section 4.2.8, PDF page 309).";
        field {
            name = "Lowerfmc_ecc_invalid_adflashdrluncorrectable";
            desc = "4 bytes of the operation address of the that triggers the last interrupt when an ECC error occurs Contents";
            sw = r; hw = w;
            reset = 0x0;
        } Lowerfmc_ecc_invalid_adflashdrluncorrectable[31:0];
    } FMC_ECC_INVALID_ADDRL @ 0xDC;
};
`endif
