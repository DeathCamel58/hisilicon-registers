`ifndef HI3516EV300_RTC_RDL
`define HI3516EV300_RTC_RDL
regfile eHI3516EV300_RTC {
    name = "RTC SPI interface";
    desc = "RTC SPI interface of the Hi3516E V300 at base 0x120E0000. 2 registers extracted programmatically from the Hi3516E V300 data sheet (Issue 00B06, 2019-05-15) (Table 3-14 Summary of RTC registers (base address: 0x120E_0000)): register headings, offsets, total reset values, field bit ranges, access types, names, reset values and descriptions, with PDF page numbers in each register description. Field names, bit ranges, access types and offsets are exact; the free-text descriptions are taken from the cell text of the field table and were checked by sampling only. Hardware not verified.";
    reg {
        name = "SPI_CLK_DIV";
        desc = "SPI_CLK_DIV is an SPI clock divider register. (offset 0x0; total reset 0x0000003B; PROVEN: Hi3516E V300 data sheet (Issue 00B06, 2019-05-15), section 3.9.6, PDF page 176).";
        field {
            name = "reserved";
            desc = "Reserved";
            sw = r; hw = w;
            reset = 0x0;
        } reserved_31_8[31:8];
        field {
            name = "spi_clk_div";
            desc = "Clock divider of the SPI. The SPI clock frequency cannot be higher than 5 MHz. The value 5 MHz is recommended.";
            sw = rw; hw = r;
            reset = 0x3b;
        } spi_clk_div[7:0];
    } SPI_CLK_DIV @ 0x0;
    reg {
        name = "SPI_RW";
        desc = "SPI_RW is an SPI read/write register. (offset 0x4; total reset 0x00000000; PROVEN: Hi3516E V300 data sheet (Issue 00B06, 2019-05-15), section 3.9.6, PDF page 177).";
        field {
            name = "spi_busy";
            desc = "SPI read/write status indicator
- 0: The SPI is idle, and a new read/write operation can be initiated over the SPI.
- 1: A read/write operation is being performed over the SPI, and no new operation is allowed.";
            sw = r; hw = w;
            reset = 0x0;
        } spi_busy[31:31];
        field {
            name = "reserved";
            desc = "Reserved";
            sw = r; hw = w;
            reset = 0x0;
        } reserved_30_25[30:25];
        field {
            name = "spi_start";
            desc = "SPI read/write start. Writing 1 automatically clears this field. Writing has no effect when spi_busy is 1. That is, no new SPI operation is started before the previous read/write operation is complete. If a start request is sent, hardware ignores this request.

Access type W1_PULSE in the data sheet.";
            sw = w; hw = r; singlepulse;
            reset = 0x0;
        } spi_start[24:24];
        field {
            name = "spi_rw";
            desc = "SPI operation type
- 0: write
- 1: read";
            sw = rw; hw = r;
            reset = 0x0;
        } spi_rw[23:23];
        field {
            name = "spi_add";
            desc = "SPI operation address The address range is 0-127.";
            sw = rw; hw = r;
            reset = 0x0;
        } spi_add[22:16];
        field {
            name = "spi_rdata";
            desc = "Data read from the SPI";
            sw = r; hw = w;
            reset = 0x0;
        } spi_rdata[15:8];
        field {
            name = "spi_wdata";
            desc = "Data to be written to the SPI";
            sw = rw; hw = r;
            reset = 0x0;
        } spi_wdata[7:0];
    } SPI_RW @ 0x4;
};
`endif
