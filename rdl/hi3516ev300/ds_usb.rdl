`ifndef HI3516EV300_USB_RDL
`define HI3516EV300_USB_RDL
regfile eHI3516EV300_USB {
    name = "USB 2.0 DRD control registers";
    desc = "USB 2.0 DRD control registers of the Hi3516E V300 at base 0x1003_0000. 42 registers extracted programmatically from the Hi3516E V300 data sheet (Issue 00B06, 2019-05-15) (Table 12-19 Summary of USB registers (base address: 0x1003_0000)): register headings, offsets, total reset values, field bit ranges, access types, names, reset values and descriptions, with PDF page numbers in each register description. Field names, bit ranges, access types and offsets are exact; the free-text descriptions are taken from the cell text of the field table and were checked by sampling only. Hardware not verified.";
    reg {
        name = "PERI_USB2_GSBUSCFG0";
        desc = "PERI_USB2_GSBUSCFG0 is global SoC bus configuration register 0. (offset 0xC100; total reset 0x00000000; PROVEN: Hi3516E V300 data sheet (Issue 00B06, 2019-05-15), section 12.6.8, PDF page 754).";
        field {
            name = "datrdreqinfo";
            desc = "AHB-prot/AXI-cache/OCP-ReqInfo Data read request";
            sw = rw; hw = r;
            reset = 0x0;
        } datrdreqinfo[31:28];
        field {
            name = "desrdreqinfo";
            desc = "AHB-prot/AXI-cache/OCP-ReqInfo Linked list read request";
            sw = rw; hw = r;
            reset = 0x0;
        } desrdreqinfo[27:24];
        field {
            name = "datwrreqinfo";
            desc = "AHB-prot/AXI-cache/OCP-ReqInfo Data";
            sw = rw; hw = r;
            reset = 0x0;
        } datwrreqinfo[23:20];
        field {
            name = "deswrreqinfo";
            desc = "AHB-prot/AXI-cache/OCP-ReqInfo Linked list write request";
            sw = rw; hw = r;
            reset = 0x0;
        } deswrreqinfo[19:16];
        field {
            name = "reserved";
            desc = "Reserved";
            sw = rw; hw = r;
            reset = 0x0;
        } reserved_15_12[15:12];
        field {
            name = "datbigend";
            desc = "Endian mode for accessing data
- 0: little endian
- 1: big endian";
            sw = rw; hw = r;
            reset = 0x0;
        } datbigend[11:11];
        field {
            name = "descbigend";
            desc = "Endian mode for accessing the linked list
- 0: little endian
- 1: big endian";
            sw = rw; hw = r;
            reset = 0x0;
        } descbigend[10:10];
        field {
            name = "reserved";
            desc = "Reserved";
            sw = r; hw = w;
            reset = 0x0;
        } reserved_9_8[9:8];
        field {
            name = "incr256brstena";
            desc = "256-beat burst transfer enable for the AHB master INCR
- 0: disabled
- 1: enabled";
            sw = rw; hw = r;
            reset = 0x0;
        } incr256brstena[7:7];
        field {
            name = "incr128brstena";
            desc = "128-beat burst transfer enable for the AHB master INCR
- 0: disabled
- 1: enabled";
            sw = rw; hw = r;
            reset = 0x0;
        } incr128brstena[6:6];
        field {
            name = "incr64brstena";
            desc = "64-beat burst transfer enable for the AHB master INCR
- 0: disabled
- 1: enabled";
            sw = rw; hw = r;
            reset = 0x0;
        } incr64brstena[5:5];
        field {
            name = "incr32brstena";
            desc = "32-beat burst transfer enable for the AHB master INCR
- 0: disabled
- 1: enabled";
            sw = rw; hw = r;
            reset = 0x0;
        } incr32brstena[4:4];
        field {
            name = "incr16brstena";
            desc = "16-beat burst transfer enable for the AHB master INCR
- 0: disabled
- 1: enabled";
            sw = rw; hw = r;
            reset = 0x0;
        } incr16brstena[3:3];
        field {
            name = "incr8brstena";
            desc = "8-beat burst transfer enable for the AHB master INCR
- 0: disabled
- 1: enabled";
            sw = rw; hw = r;
            reset = 0x0;
        } incr8brstena[2:2];
        field {
            name = "incr4brstena";
            desc = "4-beat burst transfer enable for the AHB master INCR";
            sw = rw; hw = r;
            reset = 0x0;
        } incr4brstena[1:1];
        field {
            name = "incrbrstena";
            desc = "1-beat burst transfer enable for the AHB master INCR
- 0: disabled
- 1: enabled";
            sw = rw; hw = r;
            reset = 0x0;
        } incrbrstena[0:0];
    } PERI_USB2_GSBUSCFG0 @ 0xC100;
    reg {
        name = "PERI_USB2_GSBUSCFG1";
        desc = "PERI_USB2_GSBUSCFG1 is global SoC bus configuration register 1. (offset 0xC104; total reset 0x00000000; PROVEN: Hi3516E V300 data sheet (Issue 00B06, 2019-05-15), section 12.6.8, PDF page 756).";
        field {
            name = "reserved";
            desc = "Reserved";
            sw = r; hw = w;
            reset = 0x0;
        } reserved_31_13[31:13];
        field {
            name = "en1kpage";
            desc = "1 KB boundary select
- 0: 4 KB boundary
- 1: 1 KB boundary";
            sw = rw; hw = r;
            reset = 0x0;
        } en1kpage[12:12];
        field {
            name = "pipetranslimit";
            desc = "Number of AXI master outstanding requests
- 0x0: 1 request
- 0x1: 2 requests
- 0x2: 3 requests
- 0x3: 4 requests ...
- 0xF: 16 requests";
            sw = rw; hw = r;
            reset = 0x0;
        } pipetranslimit[11:8];
        field {
            name = "reserved";
            desc = "Reserved";
            sw = r; hw = w;
            reset = 0x0;
        } reserved_7_0[7:0];
    } PERI_USB2_GSBUSCFG1 @ 0xC104;
    reg {
        name = "PERI_USB2_GTXTHRCFG";
        desc = "PERI_USB2_GTXTHRCFG is a global TX threshold control register. (offset 0xC108; total reset 0x00000000; PROVEN: Hi3516E V300 data sheet (Issue 00B06, 2019-05-15), section 12.6.8, PDF page 756).";
        field {
            name = "reserved";
            desc = "Reserved";
            sw = r; hw = w;
            reset = 0x0;
        } reserved_31_30[31:30];
        field {
            name = "usbtxpktcntsel";
            desc = "USB TX FIFO threshold select. This field is valid only in super-speed mode.
- 0: The USB module starts transfer only after all packets are read to the specified TX FIFO.";
            sw = rw; hw = r;
            reset = 0x0;
        } usbtxpktcntsel[29:29];
        field {
            name = "reserved";
            desc = "Reserved";
            sw = r; hw = w;
            reset = 0x0;
        } reserved_28_28[28:28];
        field {
            name = "usbtxpktcnt";
            desc = "TX FIFO threshold. The value range is 1-15.";
            sw = rw; hw = r;
            reset = 0x0;
        } usbtxpktcnt[27:24];
        field {
            name = "usbmaxtxburstsize";
            desc = "Maximum TX burst size. This field is valid only for the OUT endpoint during bulk transfer, isochronous transfer, or interrupt transfer at a super speed in host mode. The value range is 1-16.";
            sw = rw; hw = r;
            reset = 0x0;
        } usbmaxtxburstsize[23:16];
        field {
            name = "reserved";
            desc = "Reserved";
            sw = r; hw = w;
            reset = 0x0;
        } reserved_15_0[15:0];
    } PERI_USB2_GTXTHRCFG @ 0xC108;
    reg {
        name = "PERI_USB2_GRXTHRCFG";
        desc = "PERI_USB2_GRXTHRCFG is a global RX threshold control register. (offset 0xC10C; total reset 0x00000000; PROVEN: Hi3516E V300 data sheet (Issue 00B06, 2019-05-15), section 12.6.8, PDF page 757).";
        field {
            name = "reserved";
            desc = "Reserved";
            sw = r; hw = w;
            reset = 0x0;
        } reserved_31_30[31:30];
        field {
            name = "usbtxpktcntsel";
            desc = "USB RX FIFO threshold select. This field is valid only in super-speed mode.
- 0: The USB module starts transfer only after all packets are read to the specified RX FIFO.
- 1: The USB module starts transfer only after specified packets are read to the specified RX

FIFO.";
            sw = rw; hw = r;
            reset = 0x0;
        } usbtxpktcntsel[29:29];
        field {
            name = "reserved";
            desc = "Reserved";
            sw = r; hw = w;
            reset = 0x0;
        } reserved_28_28[28:28];
        field {
            name = "usbtxpktcnt";
            desc = "RX FIFO threshold. The value range is 1-15.";
            sw = rw; hw = r;
            reset = 0x0;
        } usbtxpktcnt[27:24];
        field {
            name = "usbmaxtxburstsize";
            desc = "Maximum RX burst size. This field is valid only for the IN endpoint during bulk transfer or interrupt transfer at a super speed in host mode. The value range is 1-16.";
            sw = r; hw = w;
            reset = 0x0;
        } usbmaxtxburstsize[23:19];
        field {
            name = "reserved";
            desc = "Reserved";
            sw = r; hw = w;
            reset = 0x0;
        } reserved_18_0[18:0];
    } PERI_USB2_GRXTHRCFG @ 0xC10C;
    reg {
        name = "PERI_USB2_GCTL";
        desc = "PERI_USB2_GCTL is a global core control register. (offset 0xC110; total reset 0x00000000; PROVEN: Hi3516E V300 data sheet (Issue 00B06, 2019-05-15), section 12.6.8, PDF page 757).";
        field {
            name = "pwrdnscale";
            desc = "Suspend_clk The Suspend_clk is calculated as follows: GCTL[31: 19] x 16 kHz = Suspend_clk 32 kHz < Suspend_clk < 125 MHz";
            sw = rw; hw = r;
            reset = 0x0;
        } pwrdnscale[31:19];
        field {
            name = "masterfiltbypass";
            desc = "Filtering select
- 0: Filtering is enabled when

DWC_USB2_EN_BUS_FILTERS is 1.
- 1: Filtering is disabled regardless of the value of DWC_USB2_EN_BUS_FILTERS.";
            sw = rw; hw = r;
            reset = 0x0;
        } masterfiltbypass[18:18];
        field {
            name = "bypssetaddr";
            desc = "SetAddress command in device mode
- 0: The host sends the SetAddress command to the device.
- 1: The host does not send the SetAddress command to the device. The device reads the value of DCFG[DevAddress] as the address value.

Note: This bit is configured only for simulation.";
            sw = rw; hw = r;
            reset = 0x0;
        } bypssetaddr[17:17];
        field {
            name = "u2rstecn";
            desc = "Super-speed connection
- 0: When the super-speed connection fails, the device is in high-speed mode.
- 1: When the super-speed connection fails, the device waits for more than three cycles.

Note: This bit is valid only in device mode.";
            sw = rw; hw = r;
            reset = 0x0;
        } u2rstecn[16:16];
        field {
            name = "frmscldwn";
            desc = "SOF/USOF/ITP interval in super-speed or high-speed mode
- 00: 125 µs
- 01: 62.5 µs
- 10: 31.25 µs
- 11: 15.625 µs

The corresponding value needs to be multiplied by 8 in full-speed mode. Maximum packet size of bulk in or bulk out transfer during simulation in xHCI debug mode
- 00: 1024 bytes
- 01: 512 bytes
- 10: 256 bytes
- 11: 128 bytes";
            sw = rw; hw = r;
            reset = 0x0;
        } frmscldwn[15:14];
        field {
            name = "prtcapdir";
            desc = "Port configuration type
- 00: reserved
- 01: host configuration
- 10: device configuration
- 11: OTG configuration";
            sw = rw; hw = r;
            reset = 0x0;
        } prtcapdir[13:12];
        field {
            name = "coresoftreset";
            desc = "Core soft reset select
- 0: not reset
- 1: reset

When the core is soft-reset, all interrupts excluding the interrupts of the following registers are cleared. -GCTL -GUCTL -GSTS -GSNPSID -GGPIO -GUID -GUSB2PHYCFGn -DCFG -DCTL -DEVTEN -DSTS";
            sw = rw; hw = r;
            reset = 0x0;
        } coresoftreset[11:11];
        field {
            name = "sofitpsync";
            desc = "- 0: The first port of the UTMI/ULPI PHY is not suspended no matter whether other SS ports are not in the Rx.Detect, SS.Disable, or

U3 state.
- 1: The first port of the UTMI/ULPI PHY is not suspended no matter whether other non-SS ports are not in the non-suspend state.

This field is valid only when the USB controller is in host mode.";
            sw = rw; hw = r;
            reset = 0x0;
        } sofitpsync[10:10];
        field {
            name = "u1u2timerscale";
            desc = "U1/U2 timer scale-down enable
- 0: enabled
- 1: disabled when PERI_USB2_GCTL[5: 4] (ScaleDown) is X1";
            sw = rw; hw = r;
            reset = 0x0;
        } u1u2timerscale[9:9];
        field {
            name = "debugattach";
            desc = "Debug attach signal When this field is set to 1: After the Ru/Stop bit in the DCTL register is set to 1, the SS controller enters the polling";
            sw = rw; hw = r;
            reset = 0x0;
        } debugattach[8:8];
        field {
            name = "ramclksel";
            desc = "RAM clock select
- 00: bus clock
- 01: PIPE clock
- 10: PIPE/2 clock
- 11: reserved

In host mode, hardware sets this field to 00 (the ram_clk connects to the bus_clk). Therefore, when the SS port is in P3 state, the PIPE clock is disabled, and the USB 2.0 port does not work.";
            sw = rw; hw = r;
            reset = 0x0;
        } ramclksel[7:6];
        field {
            name = "scaledown";
            desc = "Scale-down timing select In high-speed, full-speed, or low-speed mode:
- 00: All scale-down timings are disabled, and the actual timings are used for simulation.
- 01: All scale-down timings excluding the timings related to the following functions are enabled. -Speed enumeration -HNP/SRP -Suspend and resume in host mode
- 10: Only the scale-down timings related to the suspend and resume functions in device mode are enabled.
- 11: All scale-down timings are enabled.

For the SS mode: In high-speed, full-speed, or low-speed mode:
- 00: All scale-down timings are disabled, and the actual timings are used for simulation.
- 01: The SS scale-down timings are enabled, including -The number of TxEq training sequences is reduced to 8. -The LFPS polling burst time is reduced to 100 ns. -The LFPS warm reset receive is reduced to 30 μs.
- 10: TxEq training sequences are not";
            sw = rw; hw = r;
            reset = 0x0;
        } scaledown[5:4];
        field {
            name = "disscramble";
            desc = "Scrambling enable
- 1: disabled
- 0: enabled";
            sw = rw; hw = r;
            reset = 0x0;
        } disscramble[3:3];
        field {
            name = "u2exit_lfps";
            desc = "U2 state exit signal
- 0: The link layer considers the 248 ns LFPS signal as an active U2 state exit signal.
- 1: The link layer waits 8 μs after detecting an active U2 state exit signal.";
            sw = rw; hw = r;
            reset = 0x0;
        } u2exit_lfps[2:2];
        field {
            name = "gblhibernationen";
            desc = "Global hibernation enable
- 0: disabled. When the PMU accepts status switching between D0 and D3, the internal status of the core is not retained or restored.
- 1: enabled";
            sw = rw; hw = r;
            reset = 0x0;
        } gblhibernationen[1:1];
        field {
            name = "dsblclkgtng";
            desc = "Internal clock gating enable
- 0: enabled
- 1: disabled when the core is in LPM mode

This field can be set to 1 after power-on reset.";
            sw = rw; hw = r;
            reset = 0x0;
        } dsblclkgtng[0:0];
    } PERI_USB2_GCTL @ 0xC110;
    reg {
        name = "PERI_USB2_GSTS";
        desc = "PERI_USB2_GSTS is a global status register. (offset 0xC118; total reset 0x00000000; PROVEN: Hi3516E V300 data sheet (Issue 00B06, 2019-05-15), section 12.6.8, PDF page 761).";
        field {
            name = "cbelt";
            desc = "Minimum value among all received device BELT values and the BELT value configured by running the Set Latency Tolerance Value command in host mode";
            sw = r; hw = w;
            reset = 0x0;
        } cbelt[31:20];
        field {
            name = "reserved";
            desc = "Reserved";
            sw = r; hw = w;
            reset = 0x0;
        } reserved_19_11[19:11];
        field {
            name = "otg_ip";
            desc = "Indication that an OTG-related interrupt in the OEVT register is waiting for handling
- 0: There is no indication.
- 1: There is an indication.";
            sw = r; hw = w;
            reset = 0x0;
        } otg_ip[10:10];
        field {
            name = "bc_ip";
            desc = "Indication that a BC-related interrupt in the BCEVT register is waiting for handling";
            sw = r; hw = w;
            reset = 0x0;
        } bc_ip[9:9];
        field {
            name = "adp_ip";
            desc = "Indication that an ADP-related interrupt in the ADPEVT register is waiting for handling
- 0: There is no indication.
- 1: There is an indication.";
            sw = r; hw = w;
            reset = 0x0;
        } adp_ip[8:8];
        field {
            name = "host_ip";
            desc = "Indication that an xHCI-related interrupt in the host event queue is waiting for handling
- 0: There is no indication.
- 1: There is an indication.";
            sw = r; hw = w;
            reset = 0x0;
        } host_ip[7:7];
        field {
            name = "device_ip";
            desc = "Indication that an xHCI-related interrupt in the device event queue is waiting for handling
- 0: There is no indication.
- 1: There is an indication.";
            sw = r; hw = w;
            reset = 0x0;
        } device_ip[6:6];
        field {
            name = "csrtimeout";
            desc = "Indication that the duration of accessing registers by software exceeds the time defined by DWC_USB2_CSR_ACCESS_TIMEOUT
- 0: There is no indication.
- 1: There is an indication.";
            sw = r; hw = w;
            reset = 0x0;
        } csrtimeout[5:5];
        field {
            name = "buserraddrvld";
            desc = "GBUSERRADDR register validity indicator and start address for the error position
- 0: There is no indication.
- 1: There is an indication.";
            sw = r; hw = w;
            reset = 0x0;
        } buserraddrvld[4:4];
        field {
            name = "reserved";
            desc = "Reserved";
            sw = r; hw = w;
            reset = 0x0;
        } reserved_3_2[3:2];
        field {
            name = "curmod";
            desc = "Current working mode
- 00: device mode
- 01: host mode

Other values: reserved";
            sw = r; hw = w;
            reset = 0x0;
        } curmod[1:0];
    } PERI_USB2_GSTS @ 0xC118;
    reg {
        name = "PERI_USB2_GUCTL1";
        desc = "PERI_USB2_GUCTL1 is global user control register 1. (offset 0xC11C; total reset 0x00000000; PROVEN: Hi3516E V300 data sheet (Issue 00B06, 2019-05-15), section 12.6.8, PDF page 762).";
        field {
            name = "reserved";
            desc = "Reserved";
            sw = r; hw = w;
            reset = 0x0;
        } reserved_31_2[31:2];
        field {
            name = "ovrld_l1_susp_com";
            desc = "If this bit is set to 1, the utmi_l1_suspend_com_n signal will be";
            sw = rw; hw = r;
            reset = 0x0;
        } ovrld_l1_susp_com[1:1];
        field {
            name = "loa_filter_en";
            desc = "Port disable status detection. When this field is set to 1, the controller sends three consecutive cycles to detect the port status before the port is disabled.";
            sw = rw; hw = r;
            reset = 0x0;
        } loa_filter_en[0:0];
    } PERI_USB2_GUCTL1 @ 0xC11C;
    reg {
        name = "PERI_USB2_GGPIO";
        desc = "PERI_USB2_GGPIO is a global GPIO register. (offset 0xC124; total reset 0x00000000; PROVEN: Hi3516E V300 data sheet (Issue 00B06, 2019-05-15), section 12.6.8, PDF page 763).";
        field {
            name = "gpo";
            desc = "Drive value of gp_o[15: 0]";
            sw = rw; hw = r;
            reset = 0x0;
        } gpo[31:16];
        field {
            name = "gpi";
            desc = "Read value of gp_i[15: 0]";
            sw = r; hw = w;
            reset = 0x0;
        } gpi[15:0];
    } PERI_USB2_GGPIO @ 0xC124;
    reg {
        name = "PERI_USB2_GUID";
        desc = "PERI_USB2_GUID is a global user ID register. (offset 0xC128; total reset 0x00000000; PROVEN: Hi3516E V300 data sheet (Issue 00B06, 2019-05-15), section 12.6.8, PDF page 763).";
        field {
            name = "reserved";
            desc = "User information including the system version and hardware configuration";
            sw = r; hw = w;
            reset = 0x0;
        } reserved_31_0[31:0];
    } PERI_USB2_GUID @ 0xC128;
    reg {
        name = "PERI_USB2_GUCTL";
        desc = "PERI_USB2_GUCTL is a global user control register. (offset 0xC12C; total reset 0x00000000; PROVEN: Hi3516E V300 data sheet (Issue 00B06, 2019-05-15), section 12.6.8, PDF page 763).";
        field {
            name = "refclkper";
            desc = "Reference clock (ref_clk), in ns For example, if the ref_clk is 125 MHz, this field is set to 8 ns (1/125 MHz).";
            sw = rw; hw = r;
            reset = 0x0;
        } refclkper[31:22];
        field {
            name = "noextrdl_";
            desc = "Extra delay between the SOF packet and the first packet";
            sw = rw; hw = r;
            reset = 0x0;
        } noextrdl[21:21];
        field {
            name = "reserved";
            desc = "Reserved";
            sw = r; hw = w;
            reset = 0x0;
        } reserved_20_18[20:18];
        field {
            name = "sprsctrltransen";
            desc = "Disperse control transfer enable
- 0: disabled
- 1: enabled

Some devices respond to the control transfer at an extremely slow speed. The devices are abnormal if multiple transfers are performed in a frame or microframe. When this field is set to 1, the host controller disperses a control transfer in multiple frames or microframes.";
            sw = rw; hw = r;
            reset = 0x0;
        } sprsctrltransen[17:17];
        field {
            name = "resbwhseps";
            desc = "85% of the bandwidth is reserved for high-speed periodic endpoints. This field is valid only in host mode or for host operations in DRD mode.";
            sw = rw; hw = r;
            reset = 0x0;
        } resbwhseps[16:16];
        field {
            name = "cmdevaddr";
            desc = "Device address mode
- 0: The device address is the slot ID.
- 1: The device address is incremented based on the address allocation command of each device.";
            sw = rw; hw = r;
            reset = 0x0;
        } cmdevaddr[15:15];
        field {
            name = "usbhstlnautoretryen";
            desc = "Automatic retransmission enable for host inputs
- 0: disabled

If an error occurs during host input transfer, the host automatically replies an ACK indicating termination to the device (Retry = 1 and NumP = 0).
- 1: enabled

If automatic retransmission is enabled and an error occurs during host input transfer, the host automatically replies an ACK not indicating termination to the device (Retry = 1 and NumP != 0).";
            sw = rw; hw = r;
            reset = 0x0;
        } usbhstlnautoretryen[14:14];
        field {
            name = "enoverlapchk";
            desc = "LFPS overlap signal detection enable
- 0: The LFPS overlap signal is not detected.
- 1: The LFPS overlap signal is detected to avoid glitches.";
            sw = rw; hw = r;
            reset = 0x0;
        } enoverlapchk[13:13];
        field {
            name = "reserved";
            desc = "Reserved";
            sw = r; hw = w;
            reset = 0x0;
        } reserved_12_12[12:12];
        field {
            name = "csr";
            desc = "Extra delay inserted between full-speed";
            sw = rw; hw = r;
            reset = 0x0;
        } csr[11:11];
        field {
            name = "dtct";
            desc = "Rough timeout period that the device responds to the host. If this field is set to 0, the timeout period is defined by the DTFT; if this field is not 0, the timeout period is as follows:
- 00: 0 μs
- 01: 500 μs
- 10: 1.5 ms
- 11: 6.5 ms";
            sw = rw; hw = r;
            reset = 0x0;
        } dtct[10:9];
        field {
            name = "dtft";
            desc = "Exact timeout period that the device responds to the host. This field is valid when the DTCT is 0. The exact timeout period (T) is calculated as follows: T = DTFT x 256 x 8 μs";
            sw = rw; hw = r;
            reset = 0x0;
        } dtft[8:0];
    } PERI_USB2_GUCTL @ 0xC12C;
    reg {
        name = "PERI_USB2_GBUSERRADDR_HI";
        desc = "PERI_USB2_GBUSERRADDR_HI is a global bus error address upper-32-bit register. (offset 0xC130; total reset 0x00000000; PROVEN: Hi3516E V300 data sheet (Issue 00B06, 2019-05-15), section 12.6.8, PDF page 765).";
        field {
            name = "busaddrhi";
            desc = "Upper 32 bits of the error address This field is valid only when GSTS[BusErrAddrVld] is 1. This field is cleared only during reset. Only the AHB and AXI bus configurations are supported.";
            sw = r; hw = w;
            reset = 0x0;
        } busaddrhi[31:0];
    } PERI_USB2_GBUSERRADDR_HI @ 0xC130;
    reg {
        name = "PERI_USB2_GBUSERRADDR_LO";
        desc = "PERI_USB2_GBUSERRADDR_LO is a global bus error address lower-32-bit register. (offset 0xC134; total reset 0x00000000; PROVEN: Hi3516E V300 data sheet (Issue 00B06, 2019-05-15), section 12.6.8, PDF page 765).";
        field {
            name = "busaddrlo";
            desc = "Lower 32 bits of the error address This field is valid only when";
            sw = r; hw = w;
            reset = 0x0;
        } busaddrlo[31:0];
    } PERI_USB2_GBUSERRADDR_LO @ 0xC134;
    reg {
        name = "PERI_USB2_GPRTBIMAP_HI";
        desc = "PERI_USB2_GPRTBIMAP_HI is an SS port-bus mapping upper-32-bit register. (offset 0xC138; total reset 0x00000000; PROVEN: Hi3516E V300 data sheet (Issue 00B06, 2019-05-15), section 12.6.8, PDF page 766).";
        field {
            name = "reserved";
            desc = "Reserved";
            sw = r; hw = w;
            reset = 0x0;
        } reserved_31_0[31:0];
    } PERI_USB2_GPRTBIMAP_HI @ 0xC138;
    reg {
        name = "PERI_USB2_GPRTBIMAP_LO";
        desc = "PERI_USB2_GPRTBIMAP_LO is an SS port-bus mapping lower-32-bit register. (offset 0xC13C; total reset 0x00000000; PROVEN: Hi3516E V300 data sheet (Issue 00B06, 2019-05-15), section 12.6.8, PDF page 766).";
        field {
            name = "reserved";
            desc = "Reserved";
            sw = r; hw = w;
            reset = 0x0;
        } reserved_31_4[31:4];
        field {
            name = "binumn";
            desc = "ID of the currently connected SS bus";
            sw = rw; hw = r;
            reset = 0x0;
        } binumn[3:0];
    } PERI_USB2_GPRTBIMAP_LO @ 0xC13C;
    reg {
        name = "PERI_USB2_GPRTBIMAP_HS_HI";
        desc = "PERI_USB2_GPRTBIMAP_HS_HI is an HS port-bus mapping upper-32-bit register. (offset 0xC180; total reset 0x00000000; PROVEN: Hi3516E V300 data sheet (Issue 00B06, 2019-05-15), section 12.6.8, PDF page 766).";
        field {
            name = "reserved";
            desc = "Reserved";
            sw = r; hw = w;
            reset = 0x0;
        } reserved_31_0[31:0];
    } PERI_USB2_GPRTBIMAP_HS_HI @ 0xC180;
    reg {
        name = "PERI_USB2_GPRTBIMAP_HS_LO";
        desc = "PERI_USB2_GPRTBIMAP_HS_LO is an HS port-bus mapping lower-32-bit register. (offset 0xC184; total reset 0x00000000; PROVEN: Hi3516E V300 data sheet (Issue 00B06, 2019-05-15), section 12.6.8, PDF page 766).";
        field {
            name = "reserved";
            desc = "Reserved";
            sw = r; hw = w;
            reset = 0x0;
        } reserved_31_4[31:4];
        field {
            name = "binumn";
            desc = "ID of the currently connected HS bus";
            sw = rw; hw = r;
            reset = 0x0;
        } binumn[3:0];
    } PERI_USB2_GPRTBIMAP_HS_LO @ 0xC184;
    reg {
        name = "PERI_USB2_GPRTBIMAP_FS_HI";
        desc = "PERI_USB2_GPRTBIMAP_FS_HI is an FS port-bus mapping upper-32-bit register. (offset 0xC188; total reset 0x00000000; PROVEN: Hi3516E V300 data sheet (Issue 00B06, 2019-05-15), section 12.6.8, PDF page 767).";
        field {
            name = "reserved";
            desc = "Reserved";
            sw = r; hw = w;
            reset = 0x0;
        } reserved_31_0[31:0];
    } PERI_USB2_GPRTBIMAP_FS_HI @ 0xC188;
    reg {
        name = "PERI_USB2_GPRTBIMAP_FS";
        desc = "PERI_USB2_GPRTBIMAP_FS is an FS port-bus mapping lower-32-bit register. (offset 0xC18C; total reset 0x00000000; PROVEN: Hi3516E V300 data sheet (Issue 00B06, 2019-05-15), section 12.6.8, PDF page 767).";
        field {
            name = "reserved";
            desc = "Reserved";
            sw = r; hw = w;
            reset = 0x0;
        } reserved_31_4[31:4];
        field {
            name = "binumn";
            desc = "ID of the currently connected FS bus";
            sw = rw; hw = r;
            reset = 0x0;
        } binumn[3:0];
    } PERI_USB2_GPRTBIMAP_FS @ 0xC18C;
    reg {
        name = "PERI_USB2_GUSB2PHYCFGN";
        desc = "PERI_USB2_GUSB2PHYCFGN is a global USB 2.0 PHY configuration register. (offset 0xC200; total reset 0x00000000; PROVEN: Hi3516E V300 data sheet (Issue 00B06, 2019-05-15), section 12.6.8, PDF page 767).";
        field {
            name = "phy_soft_rst";
            desc = "UTMI PHY soft-reset by triggering the usb2phy_reset signal. In this case, the ULPI PHY is not reset, because it is reset by configuring the FunctionControl[Reset]. When the core is reset, the core automatically configures vcc_reset_n, xHCI_USBCMD[hcrst], DCTL[SoftReset], or GCTL[SoftReset] to implement reset.";
            sw = rw; hw = r;
            reset = 0x0;
        } phy_soft_rst[31:31];
        field {
            name = "u2_freeclk_exists";
            desc = "Whether the USB 2.0 PHY provides the free clock
- 0: no
- 1: yes";
            sw = rw; hw = r;
            reset = 0x0;
        } u2_freeclk_exists[30:30];
        field {
            name = "reserved";
            desc = "Reserved";
            sw = r; hw = w;
            reset = 0x0;
        } reserved_29_19[29:19];
        field {
            name = "ulpi_ext_vbus_indicator";
            desc = "ULPI external Vbus indicator
- 0: The PHY uses the internal Vbus as the comparison voltage.
- 1: The PHY uses the external Vbus as the comparison voltage.";
            sw = rw; hw = r;
            reset = 0x0;
        } ulpi_ext_vbus_indicator[18:18];
        field {
            name = "ulpi_ext_vbus_drv";
            desc = "ULPI external Vbus driver
- 0: The PHY uses the internal Vbus voltage driver.
- 1: The PHY uses the external Vbus voltage driver.";
            sw = rw; hw = r;
            reset = 0x0;
        } ulpi_ext_vbus_drv[17:17];
        field {
            name = "reserved";
            desc = "Reserved";
            sw = r; hw = w;
            reset = 0x0;
        } reserved_16_16[16:16];
        field {
            name = "ulpi_auto_res";
            desc = "ULPI automatic resume enable
- 0: disabled
- 1: enabled";
            sw = rw; hw = r;
            reset = 0x0;
        } ulpi_auto_res[15:15];
        field {
            name = "reserved";
            desc = "Reserved";
            sw = r; hw = w;
            reset = 0x0;
        } reserved_14_14[14:14];
        field {
            name = "usbtrdtim";
            desc = "USB 2 turnaround time, that is, response time after the MAC requests the packet FIFO controller (PFC) to fetch data from the DFIFO (SPRAM) 0x5 for the 16-bit UTMI+ interface 0x9 for the 8-bit UTMI+ or ULPI interface";
            sw = rw; hw = r;
            reset = 0x0;
        } usbtrdtim[13:10];
        field {
            name = "xcvrdly";
            desc = "TX/RX delay select. When this bit is set to 1, the delay of 2.5 μs is added between the time Transceiver Select is set to 00 (high speed) and the time TxValid is 0 to transmit the chirp-K handshake signal.";
            sw = rw; hw = r;
            reset = 0x0;
        } xcvrdly[9:9];
        field {
            name = "enblslpm";
            desc = "utmi_sleep_n/utmi_l1_suspend_n signal enable
- 0: The utmi_sleep_n and utmi_l1_suspend_n signals do not connect to the PHY.
- 1: The utmi_sleep_n and utmi_l1_suspend_n signals connect to the PHY.";
            sw = rw; hw = r;
            reset = 0x0;
        } enblslpm[8:8];
        field {
            name = "physel";
            desc = "PHY interface type
- 0: USB 2.0 high-speed UTMI+ or ULPI PHY interface
- 1: USB 1.1 full-speed serial interface

This bit is set to 1 when it is write-only.";
            sw = rw; hw = r;
            reset = 0x0;
        } physel[7:7];
        field {
            name = "susphy";
            desc = "USB 2.0 HS/FS/LS PHY suspend
- 0: not suspended
- 1: suspended";
            sw = rw; hw = r;
            reset = 0x0;
        } susphy[6:6];
        field {
            name = "fsintf";
            desc = "Type of the FS PHY serial interface
- 0: 6-pin unidirectional FS serial transfer interface
- 1: 3-pin bidirectional FS serial transfer interface

When this bit is read-only, the return value is 0.";
            sw = rw; hw = r;
            reset = 0x0;
        } fsintf[5:5];
        field {
            name = "ulpi_utmi_sel";
            desc = "Type of the HS PHY interface
- 0: UTMI+
- 1: ULPI";
            sw = rw; hw = r;
            reset = 0x0;
        } ulpi_utmi_sel[4:4];
        field {
            name = "phyif";
            desc = "Data width of the UTMI interface
- 0: 8 bits
- 1: 16 bits";
            sw = rw; hw = r;
            reset = 0x0;
        } phyif[3:3];
        field {
            name = "toutcal";
            desc = "HS/FS timeout calibration The corresponding bit time is added to each PHY clock. HS mode One 30 MHz PHY clock = 16-bit times One 60 MHz PHY clock = 8-bit times FS mode One 30 MHz PHY clock = 0.4-bit times One 60 MHz PHY clock = 0.2-bit times One 48 MHz PHY clock = 0.25-bit times";
            sw = rw; hw = r;
            reset = 0x0;
        } toutcal[2:0];
    } PERI_USB2_GUSB2PHYCFGN @ 0xC200;
    reg {
        name = "PERI_USB2_GTXFIFOSIZN";
        desc = "PERI_USB2_GTXFIFOSIZN is a global TX FIFO size register. (offset 0xC304; total reset 0x00000000; PROVEN: Hi3516E V300 data sheet (Issue 00B06, 2019-05-15), section 12.6.8, PDF page 769).";
        field {
            name = "txfstaddr_n";
            desc = "Start address for the RX FIFO n RAM in the memory";
            sw = rw; hw = r;
            reset = 0x0;
        } txfstaddr_n[31:16];
        field {
            name = "txfdep_n";
            desc = "RX FIFO depth Minimum value: 32 MDWIDTH-bit words Maximum value: 32768 MDWIDTH-bit words";
            sw = rw; hw = r;
            reset = 0x0;
        } txfdep_n[15:0];
    } PERI_USB2_GTXFIFOSIZN @ 0xC304;
    reg {
        name = "PERI_USB2_GRXFIFOSIZN";
        desc = "PERI_USB2_GRXFIFOSIZN is a global RX FIFO size register. (offset 0xC384; total reset 0x00000000; PROVEN: Hi3516E V300 data sheet (Issue 00B06, 2019-05-15), section 12.6.8, PDF page 770).";
        field {
            name = "rxfstaddr_n";
            desc = "Start address for the RX FIFO n RAM in the memory";
            sw = rw; hw = r;
            reset = 0x0;
        } rxfstaddr_n[31:16];
        field {
            name = "rxfdep_n";
            desc = "RX FIFO depth Minimum value: 32 MDWIDTH-bit words Maximum value: 32768 MDWIDTH-bit words";
            sw = rw; hw = r;
            reset = 0x0;
        } rxfdep_n[15:0];
    } PERI_USB2_GRXFIFOSIZN @ 0xC384;
    reg {
        name = "PERI_USB2_GEVNTADRN_HI";
        desc = "PERI_USB2_GEVNTADRN_HI is a global event buffer address upper-32-bit register. (offset 0xC410; total reset 0x00000000; PROVEN: Hi3516E V300 data sheet (Issue 00B06, 2019-05-15), section 12.6.8, PDF page 770).";
        field {
            name = "evntadrhi";
            desc = "Upper 32-bit address of the event buffer

Access type RWSC in the data sheet (self-clearing).";
            sw = rw; hw = rw;
            reset = 0x0;
        } evntadrhi[31:0];
    } PERI_USB2_GEVNTADRN_HI @ 0xC410;
    reg {
        name = "PERI_USB2_GEVNTADRN_LO";
        desc = "PERI_USB2_GEVNTADRN_LO is a global event buffer address lower-32-bit register. (offset 0xC414; total reset 0x00000000; PROVEN: Hi3516E V300 data sheet (Issue 00B06, 2019-05-15), section 12.6.8, PDF page 770).";
        field {
            name = "evntadrlo";
            desc = "Lower 32-bit address of the event buffer

Access type RWSC in the data sheet (self-clearing).";
            sw = rw; hw = rw;
            reset = 0x0;
        } evntadrlo[31:0];
    } PERI_USB2_GEVNTADRN_LO @ 0xC414;
    reg {
        name = "PERI_USB2_GEVNTSIZN";
        desc = "PERI_USB2_GEVNTSIZN is a global event buffer size register. (offset 0xC418; total reset 0x00000000; PROVEN: Hi3516E V300 data sheet (Issue 00B06, 2019-05-15), section 12.6.8, PDF page 770).";
        field {
            name = "evntintmask";
            desc = "Event interrupt mask";
            sw = rw; hw = r;
            reset = 0x0;
        } evntintmask[31:31];
        field {
            name = "reserved";
            desc = "Reserved";
            sw = r; hw = w;
            reset = 0x0;
        } reserved_30_16[30:16];
        field {
            name = "evntsiz";
            desc = "Event buffer size (in byte)";
            sw = rw; hw = r;
            reset = 0x0;
        } evntsiz[15:0];
    } PERI_USB2_GEVNTSIZN @ 0xC418;
    reg {
        name = "PERI_USB2_GEVNTCOUNTN";
        desc = "PERI_USB2_GEVNTCOUNTN is a global event buffer count register. (offset 0xC41C; total reset 0x00000000; PROVEN: Hi3516E V300 data sheet (Issue 00B06, 2019-05-15), section 12.6.8, PDF page 771).";
        field {
            name = "reserved";
            desc = "Reserved";
            sw = r; hw = w;
            reset = 0x0;
        } reserved_31_16[31:16];
        field {
            name = "evntcount";
            desc = "When this field is read, the number of valid events in the event buffer is returned; when it is written, the hardware automatically decreases the written count value.

Access type RWSC in the data sheet (self-clearing).";
            sw = rw; hw = rw;
            reset = 0x0;
        } evntcount[15:0];
    } PERI_USB2_GEVNTCOUNTN @ 0xC41C;
    reg {
        name = "PERI_USB2_GTXFIFOPRIDEV";
        desc = "PERI_USB2_GTXFIFOPRIDEV is a peripheral global TX FIFO DMA priority register. (offset 0xC610; total reset 0x00000000; PROVEN: Hi3516E V300 data sheet (Issue 00B06, 2019-05-15), section 12.6.8, PDF page 771).";
        field {
            name = "reserved";
            desc = "Reserved";
            sw = r; hw = w;
            reset = 0x0;
        } reserved_31_1[31:1];
        field {
            name = "device_txfifo_priority";
            desc = "Priority of the device TX FIFO
- 0: low
- 1: high";
            sw = rw; hw = r;
            reset = 0x0;
        } device_txfifo_priority[0:0];
    } PERI_USB2_GTXFIFOPRIDEV @ 0xC610;
    reg {
        name = "PERI_USB2_GTXFIFOPRIHST";
        desc = "PERI_USB2_GTXFIFOPRIHST is a host global TX FIFO DMA priority register. (offset 0xC618; total reset 0x00000000; PROVEN: Hi3516E V300 data sheet (Issue 00B06, 2019-05-15), section 12.6.8, PDF page 771).";
        field {
            name = "reserved";
            desc = "Reserved";
            sw = r; hw = w;
            reset = 0x0;
        } reserved_31_1[31:1];
        field {
            name = "host_txfifo_priority";
            desc = "Priority of the host TX FIFO
- 0: low
- 1: high";
            sw = rw; hw = r;
            reset = 0x0;
        } host_txfifo_priority[0:0];
    } PERI_USB2_GTXFIFOPRIHST @ 0xC618;
    reg {
        name = "PERI_USB2_GRXFIFOPRIHST";
        desc = "PERI_USB2_GRXFIFOPRIHST is a host global RX FIFO DMA priority register. (offset 0xC61C; total reset 0x00000000; PROVEN: Hi3516E V300 data sheet (Issue 00B06, 2019-05-15), section 12.6.8, PDF page 772).";
        field {
            name = "reserved";
            desc = "Reserved";
            sw = r; hw = w;
            reset = 0x0;
        } reserved_31_1[31:1];
        field {
            name = "host_rxfifo_priority";
            desc = "Priority of the host RX FIFO
- 0: low
- 1: high";
            sw = rw; hw = r;
            reset = 0x0;
        } host_rxfifo_priority[0:0];
    } PERI_USB2_GRXFIFOPRIHST @ 0xC61C;
    reg {
        name = "PERI_USB2_GFIFOPRIDBC";
        desc = "PERI_USB2_GFIFOPRIDBC is a host global performance debug DMA priority register. (offset 0xC620; total reset 0x00000000; PROVEN: Hi3516E V300 data sheet (Issue 00B06, 2019-05-15), section 12.6.8, PDF page 772).";
        field {
            name = "reserved";
            desc = "Reserved";
            sw = r; hw = w;
            reset = 0x0;
        } reserved_31_2[31:2];
        field {
            name = "host_dbc_dma_priority";
            desc = "Priority of the host DBC DMA
- 00: low
- 01: normal
- 10: high

Other: reserved";
            sw = rw; hw = r;
            reset = 0x0;
        } host_dbc_dma_priority[1:0];
    } PERI_USB2_GFIFOPRIDBC @ 0xC620;
    reg {
        name = "PERI_USB2_GDMAHLRATIO";
        desc = "PERI_USB2_GDMAHLRATIO is a high/low priority ratio register for the host global FIFO DMA. (offset 0xC624; total reset 0x00000000; PROVEN: Hi3516E V300 data sheet (Issue 00B06, 2019-05-15), section 12.6.8, PDF page 772).";
        field {
            name = "reserved";
            desc = "Reserved";
            sw = r; hw = w;
            reset = 0x0;
        } reserved_31_13[31:13];
        field {
            name = "hst_rxfifo_dma_hilo_priority_ratio";
            desc = "High/Low priority ratio of the host RX FIFO DMA";
            sw = rw; hw = r;
            reset = 0x0;
        } hst_rxfifo_dma_hilo_priority_ratio[12:8];
        field {
            name = "reserved";
            desc = "Reserved";
            sw = r; hw = w;
            reset = 0x0;
        } reserved_7_5[7:5];
        field {
            name = "hst_txfifo_dma_hilo_priority_ratio";
            desc = "High/Low priority ratio of the host TX FIFO DMA";
            sw = rw; hw = r;
            reset = 0x0;
        } hst_txfifo_dma_hilo_priority_ratio[4:0];
    } PERI_USB2_GDMAHLRATIO @ 0xC624;
    reg {
        name = "PERI_USB2_GFLADJ";
        desc = "PERI_USB2_GFLADJ is a global frame length adjustment register. (offset 0xC630; total reset 0x00000000; PROVEN: Hi3516E V300 data sheet (Issue 00B06, 2019-05-15), section 12.6.8, PDF page 773).";
        field {
            name = "gfladj_refclk_240mhzdecr_pls1";
            desc = "Precision of GFLADJ_REFCLK_240MHZ_DECR/ref_fre quency
- 0: The remainder is less than 0.5.
- 1: The remainder is greater than or equal to 0.5.";
            sw = rw; hw = r;
            reset = 0x0;
        } gfladj_refclk_240mhzdecr_pls1[31:31];
        field {
            name = "gfladj_refclk_240mhz_decr";
            desc = "Counter value obtained after 240 is divided by ref_clk_frequency GFLADJ_REFCLK_240MHZ_DECR = 240/ref_clk_frequency";
            sw = rw; hw = r;
            reset = 0x0;
        } gfladj_refclk_240mhz_decr[30:24];
        field {
            name = "gfladj_refclk_lpm_sel";
            desc = "SOF/ITP count clock select If this bit is set to 1, the ref_clk is the count clock.";
            sw = rw; hw = r;
            reset = 0x0;
        } gfladj_refclk_lpm_sel[23:23];
        field {
            name = "reserved";
            desc = "Reserved";
            sw = r; hw = w;
            reset = 0x0;
        } reserved_22_22[22:22];
        field {
            name = "gfladj_refclk_fladj";
            desc = "SOF/ITP calibration value when bit 23 is 1 FLADJ_REF_CLK_FLADJ = [(125000/ref_clk_period_integer) - (125000/ref_clk_period)] x ref_clk_period";
            sw = rw; hw = r;
            reset = 0x0;
        } gfladj_refclk_fladj[21:8];
        field {
            name = "gfladj_30mhz_reg_sel";
            desc = "SOF/ITP frame length tune signal select
- 0: The controller tunes the SOF/ITP frame length based on the value of input signal fladj_30mhz_reg.
- 1: The controller calibrates the SOF/ITP based on the value of

PERI_USB2_GFLADJ[gfladj_30mhz].";
            sw = rw; hw = r;
            reset = 0x0;
        } gfladj_30mhz_reg_sel[7:7];
        field {
            name = "reserved";
            desc = "Reserved";
            sw = r; hw = w;
            reset = 0x0;
        } reserved_6_6[6:6];
        field {
            name = "gfladj_30mhz";
            desc = "When bit[7] is 1 and the SOF/ITP count clock is the UTMI/ULPI clock, the controller calibrates the SOF/ITP based on this field value.";
            sw = rw; hw = r;
            reset = 0x0;
        } gfladj_30mhz[5:0];
    } PERI_USB2_GFLADJ @ 0xC630;
    reg {
        name = "PERI_USB2_DCFG";
        desc = "PERI_USB2_DCFG is a peripheral configuration register. (offset 0xC700; total reset 0x00080004; PROVEN: Hi3516E V300 data sheet (Issue 00B06, 2019-05-15), section 12.6.8, PDF page 773).";
        field {
            name = "reserved";
            desc = "Reserved";
            sw = r; hw = w;
            reset = 0x0;
        } reserved_31_24[31:24];
        field {
            name = "ignore_stream_pp";
            desc = "Packet pending bit ignore
- 0: not ignored
- 1: ignored";
            sw = rw; hw = r;
            reset = 0x0;
        } ignore_stream_pp[23:23];
        field {
            name = "lpm_capable";
            desc = "LPM function enable
- 0: enabled
- 1: disabled";
            sw = rw; hw = r;
            reset = 0x0;
        } lpm_capable[22:22];
        field {
            name = "number_of_receive_buffers";
            desc = "ID of the RX buffer that is returned in the ACK TP";
            sw = rw; hw = r;
            reset = 0x4;
        } number_of_receive_buffers[21:17];
        field {
            name = "interrupt_number";
            desc = "ID of the non-endpoint interrupt that is generated by the device";
            sw = rw; hw = r;
            reset = 0x0;
        } interrupt_number[16:12];
        field {
            name = "reserved";
            desc = "Reserved";
            sw = r; hw = w;
            reset = 0x0;
        } reserved_11_10[11:10];
        field {
            name = "device_address";
            desc = "Device address. The device address is configured each time the device receives the SetAddress command. This field is cleared after USB reset.";
            sw = rw; hw = r;
            reset = 0x0;
        } device_address[9:3];
        field {
            name = "device_speed";
            desc = "Device transfer rate select
- 000: high speed
- 001: full speed
- 100: super speed

Other values: reserved";
            sw = rw; hw = r;
            reset = 0x4;
        } device_speed[2:0];
    } PERI_USB2_DCFG @ 0xC700;
    reg {
        name = "PERI_USB2_DCTL";
        desc = "PERI_USB2_DCTL is a peripheral control register. (offset 0xC704; total reset 0x00000000; PROVEN: Hi3516E V300 data sheet (Issue 00B06, 2019-05-15), section 12.6.8, PDF page 774).";
        field {
            name = "run_stop";
            desc = "Device start/stop select The device is started after software writes 1 to this bit. To stop the device, stop all transfers and then write 0 to this bit. This bit is configured in the following cases: 1. Software must write 1 to this bit to initialize the device controller after POR; otherwise, the device controller is unaware that the host has been connected. 2. If software needs to restart the connection when a soft disconnection event occurs or a";
            sw = rw; hw = r;
            reset = 0x0;
        } run_stop[31:31];
        field {
            name = "soft_core_reset";
            desc = "Core soft reset The configuration of this bit has effect on the interrupts and registers of all clock domains. 1. All interrupts are cleared, and all registers are reset except the following ones: GCTL GUCTL GSTS GSNPSID GGPIO GUID GUSB2PHYCFGn registers GUSB2PIPECTLn registers DCFG DCTL DEVTEN DSTS 2. All state machines are restored to the idle state, and all FIFOs are cleared. 3. All transfers on the SoC bus are stopped immediately.

Access type RWSC in the data sheet (self-clearing).";
            sw = rw; hw = rw;
            reset = 0x0;
        } soft_core_reset[30:30];
        field {
            name = "reserved";
            desc = "Reserved";
            sw = r; hw = w;
            reset = 0x0;
        } reserved_29_29[29:29];
        field {
            name = "hird_threshold";
            desc = "HIRD threshold The core generates the utmi_l1_suspend_n signal or utmi_sleep_n signal when the corresponding condition is met. 1. The core generates the utmi_l1_suspend_n signal in the L1 state and switches the PHY to the deep low-power mode when the following conditions are met: The HIRD value is greater than or equal to HIRD_Thres bit[3: 0]. HIRD_Thres bit[4] is 1. 2. The core generates the utmi_sleep_n signal in the L1 state when the following conditions";
            sw = rw; hw = r;
            reset = 0x0;
        } hird_threshold[28:24];
        field {
            name = "appl1res";
            desc = "LPM response configuration When PERI_USB2_DCFG[lpm_capable] is 0, the core does not respond. When PERI_USB2_DCFG[lpm_capable] is 1, the LPM response is as follows:
- 0: The ACK is returned if the LPM reception/transmission is successful when the following conditions are met:

No check error occurs. The valid message \"bLinkState = 0001B (L1)\" is received. There is no remaining data in the TX FIFO and the OUT endpoint is not in the flow controller state (except the NYET).
- 1: The ACK is returned if the LPM reception/transmission is successful when the following conditions are met:

No check error occurs. The valid message \"bLinkState = 0001B (L1)\" is received.";
            sw = rw; hw = r;
            reset = 0x0;
        } appl1res[23:23];
        field {
            name = "reserved";
            desc = "Reserved";
            sw = r; hw = w;
            reset = 0x0;
        } reserved_22_20[22:20];
        field {
            name = "keepconnect";
            desc = "Connection status hold If this bit is set to 1 and the run_stop bit is 0, all related models are saved or restored. In addition, if the link enters the U3 or L2 state, the hibernation request event is enabled.";
            sw = rw; hw = r;
            reset = 0x0;
        } keepconnect[19:19];
        field {
            name = "l1_hibernation_en";
            desc = "When the keepconnect bit is 1 and this bit is set to 1, if L1 is enabled and the HIRD value is greater than the threshold configured in the hird_threshold bit, the device core generates a hibernation request event.";
            sw = rw; hw = r;
            reset = 0x0;
        } l1_hibernation_en[18:18];
        field {
            name = "controller_restore_state";
            desc = "Controller recovery status After software writes 1 to this bit, the controller immediately sets PERI_USB2_DSTS[rss] to 1. PERI_USB2_DSTS[rss] is set to 0 after the recovery is complete. Note: The value 0 is returned when this bit is read.";
            sw = rw; hw = r;
            reset = 0x0;
        } controller_restore_state[17:17];
        field {
            name = "controller_save_state";
            desc = "Controller save status After software writes 1 to this bit, the controller immediately sets PERI_USB2_DSTS[sss] to 1. PERI_USB2_DSTS[sss] is set to 0 after the controller is saved. Note: The value 0 is returned when this bit is read.";
            sw = rw; hw = r;
            reset = 0x0;
        } controller_save_state[16:16];
        field {
            name = "reserved";
            desc = "Reserved";
            sw = r; hw = w;
            reset = 0x0;
        } reserved_15_13[15:13];
        field {
            name = "initiate_u2_enable";
            desc = "U2 initialization enable
- 0: not initialized
- 1: initialized";
            sw = rw; hw = r;
            reset = 0x0;
        } initiate_u2_enable[12:12];
        field {
            name = "accept_u2_enable";
            desc = "U2 state enable
- 0: The core refuses to enter the U1 state unless

Force_LinkPM_Accep is 1.
- 1: If no user-end device is waiting, the core agrees to enter the U2 state.

Note: Hardware automatically clears this bit after USB reset.";
            sw = rw; hw = r;
            reset = 0x0;
        } accept_u2_enable[11:11];
        field {
            name = "initiate_u1_enable";
            desc = "U1 initialization enable
- 0: not initialized
- 1: initialized";
            sw = rw; hw = r;
            reset = 0x0;
        } initiate_u1_enable[10:10];
        field {
            name = "accept_u1_enable";
            desc = "U1 state enable
- 0: The core refuses to enter the U1 state unless

Force_LinkPM_Accep is 1.
- 1: If no user-end device is waiting, the core agrees to enter the U1 state.

Note: Hardware automatically clears this bit after USB reset.";
            sw = rw; hw = r;
            reset = 0x0;
        } accept_u1_enable[9:9];
        field {
            name = "ulstchngraq";
            desc = "USB/Link state switch request. Software initiates the corresponding state switch request by configuring this field. In SS mode:
- 0x0: no action
- 0x4: SS.Disabled
- 0x5: Rx.Detect
- 0x6: SS.Inactive
- 0x8: recovery
- 0xA: compliance

Other values: reserved";
            sw = w; hw = r;
            reset = 0x0;
        } ulstchngraq[8:5];
        field {
            name = "test_control";
            desc = "Test control
- 0x0: The test mode is disabled.
- 0x1: Test_J mode
- 0x2: Test_K mode
- 0x3: Test_SE0_NAK mode
- 0x4: Test_Packet mode
- 0x5: Test_Force_Enable

Other values: reserved";
            sw = rw; hw = r;
            reset = 0x0;
        } test_control[4:1];
        field {
            name = "reserved";
            desc = "Reserved";
            sw = r; hw = w;
            reset = 0x0;
        } reserved_0_0[0:0];
    } PERI_USB2_DCTL @ 0xC704;
    reg {
        name = "PERI_USB2_DEVTEN";
        desc = "PERI_USB2_DEVTEN is a peripheral event enable register. (offset 0xC708; total reset 0x00000000; PROVEN: Hi3516E V300 data sheet (Issue 00B06, 2019-05-15), section 12.6.8, PDF page 778).";
        field {
            name = "reserved";
            desc = "Reserved";
            sw = r; hw = w;
            reset = 0x0;
        } reserved_31_10[31:10];
        field {
            name = "erratic_error_event_enable";
            desc = "Irregular error event enable
- 0: disabled
- 1: enabled";
            sw = rw; hw = r;
            reset = 0x0;
        } erratic_error_event_enable[9:9];
        field {
            name = "reserved";
            desc = "Reserved";
            sw = r; hw = w;
            reset = 0x0;
        } reserved_8_8[8:8];
        field {
            name = "sof_en";
            desc = "SOF packet enable
- 0: disabled
- 1: enabled";
            sw = rw; hw = r;
            reset = 0x0;
        } sof_en[7:7];
        field {
            name = "u3l2l1_susp_en";
            desc = "U3/L2-L1 suspend event enable
- 0: disabled
- 1: enabled";
            sw = rw; hw = r;
            reset = 0x0;
        } u3l2l1_susp_en[6:6];
        field {
            name = "hibernation_req_evt_en";
            desc = "Hibernation request enable
- 0: disabled
- 1: enabled";
            sw = rw; hw = r;
            reset = 0x0;
        } hibernation_req_evt_en[5:5];
        field {
            name = "wkup_evt_en";
            desc = "Recovery/Remote wakeup detection event enable
- 0: disabled";
            sw = rw; hw = r;
            reset = 0x0;
        } wkup_evt_en[4:4];
        field {
            name = "ulst_cng_en";
            desc = "USB/Link state switch event enable
- 0: disabled
- 1: enabled";
            sw = rw; hw = r;
            reset = 0x0;
        } ulst_cng_en[3:3];
        field {
            name = "connect_done_en";
            desc = "Connection completion enable
- 0: disabled
- 1: enabled";
            sw = rw; hw = r;
            reset = 0x0;
        } connect_done_en[2:2];
        field {
            name = "usbrst_en";
            desc = "USB reset enable
- 0: disabled
- 1: enabled";
            sw = rw; hw = r;
            reset = 0x0;
        } usbrst_en[1:1];
        field {
            name = "disconn_evt_en";
            desc = "Disconnection detection enable
- 0: disabled
- 1: enabled";
            sw = rw; hw = r;
            reset = 0x0;
        } disconn_evt_en[0:0];
    } PERI_USB2_DEVTEN @ 0xC708;
    reg {
        name = "PERI_USB2_DSTS";
        desc = "PERI_USB2_DSTS is a peripheral status register. (offset 0xC70C; total reset 0x00120004; PROVEN: Hi3516E V300 data sheet (Issue 00B06, 2019-05-15), section 12.6.8, PDF page 779).";
        field {
            name = "reserved";
            desc = "Reserved";
            sw = r; hw = w;
            reset = 0x0;
        } reserved_31_30[31:30];
        field {
            name = "dcnrd";
            desc = "Indication that device controller is not ready. The state of the controller is being switched after the controller exits the hibernation state.";
            sw = r; hw = w;
            reset = 0x0;
        } dcnrd[29:29];
        field {
            name = "reserved";
            desc = "Reserved";
            sw = r; hw = w;
            reset = 0x0;
        } reserved_28_26[28:26];
        field {
            name = "rss";
            desc = "Recovery state This bit is set to 0 after the controller completes the recovery operation.";
            sw = r; hw = w;
            reset = 0x0;
        } rss[25:25];
        field {
            name = "sss";
            desc = "Save status This bit is set to 0 after the controller completes the save operation.";
            sw = r; hw = w;
            reset = 0x0;
        } sss[24:24];
        field {
            name = "core_idle";
            desc = "Core idle state This bit indicates that the core completes all transfers of the RX FIFO data to the system memory, all linked lists are output, and all event counters are reset to 0.";
            sw = r; hw = w;
            reset = 0x0;
        } core_idle[23:23];
        field {
            name = "devctrlhlt";
            desc = "Device controller suspend";
            sw = r; hw = w;
            reset = 0x0;
        } devctrlhlt[22:22];
        field {
            name = "usb_lnk_st";
            desc = "USB/Link status In SS mode:
- 0x0: U0
- 0x1: U1
- 0x2: U2
- 0x3: U3
- 0x4: SS_DIS
- 0x5: RX_DET
- 0x6: SS_INACT
- 0x7: POLL
- 0x8: RECOV
- 0x9: HRESET
- 0xa: CMPLY
- 0xb: LPBK
- 0xf: resume/reset

Other values: reserved In HS, FS, or LS mode:
- 0x0: on status
- 0x2: sleep (L1) status
- 0x3: suspend (L2) status
- 0x4: disconnected status (default status)
- 0x5: early suspend status (valid only when the hibernation function is disabled)
- 0xe: reset (valid only when the hibernation function is enabled)
- 0xf: resume (valid only when the hibernation function is enabled)

Other values: reserved";
            sw = r; hw = w;
            reset = 0x4;
        } usb_lnk_st[21:18];
        field {
            name = "reserved";
            desc = "Reserved";
            sw = r; hw = w;
            reset = 0x1;
        } reserved_17_17[17:17];
        field {
            name = "soffn";
            desc = "SOF frame/microframe number In HS mode: Bit[16: 6] indicate the number of frames. Bit[5: 3] indicate the number of microframes. In FS mode:";
            sw = r; hw = w;
            reset = 0x0;
        } soffn[16:3];
        field {
            name = "connect_spd";
            desc = "Connection speed indicator
- 000: high speed (the PHY clock frequency is 30 MHz or 60 MHz)
- 001: full speed (the PHY clock frequency is 30 MHz or 60 MHz)
- 010: low speed (the PHY clock frequency is 6

MHz)
- 011: low speed (the PHY clock frequency is 48 MHz)
- 100: super speed (the PHY clock frequency is 125 MHz or 250 MHz)";
            sw = r; hw = w;
            reset = 0x4;
        } connect_spd[2:0];
    } PERI_USB2_DSTS @ 0xC70C;
    reg {
        name = "PERI_USB2_DGCMDPAR";
        desc = "PERI_USB2_DGCMDPAR is a peripheral class command parameter register. (offset 0xC710; total reset 0x00000000; PROVEN: Hi3516E V300 data sheet (Issue 00B06, 2019-05-15), section 12.6.8, PDF page 781).";
        field {
            name = "parameter31_0";
            desc = "Peripheral class command parameter";
            sw = rw; hw = r;
            reset = 0x0;
        } parameter31_0[31:0];
    } PERI_USB2_DGCMDPAR @ 0xC710;
    reg {
        name = "PERI_USB2_DGCMD";
        desc = "PERI_USB2_DGCMD is a peripheral class command register. (offset 0xC714; total reset 0x00000000; PROVEN: Hi3516E V300 data sheet (Issue 00B06, 2019-05-15), section 12.6.8, PDF page 781).";
        field {
            name = "reserved";
            desc = "Reserved";
            sw = r; hw = w;
            reset = 0x0;
        } reserved_31_16[31:16];
        field {
            name = "cmd_status";
            desc = "Command status
- 0: The device controller has successfully processed the command.
- 1: An error occurs when the device controller processes the command.";
            sw = r; hw = w;
            reset = 0x0;
        } cmd_status[15:15];
        field {
            name = "reserved";
            desc = "Reserved";
            sw = r; hw = w;
            reset = 0x0;
        } reserved_14_11[14:11];
        field {
            name = "cmdact";
            desc = "Software sets this bit to 1 to enable the device controller to execute the generated command. This bit is set to 0 after the controller executes

Access type RWSC in the data sheet (self-clearing).";
            sw = rw; hw = rw;
            reset = 0x0;
        } cmdact[10:10];
        field {
            name = "reserved";
            desc = "Reserved";
            sw = r; hw = w;
            reset = 0x0;
        } reserved_9_9[9:9];
        field {
            name = "cmdloc";
            desc = "Command completion interrupt Note: This bit is set to 1 when PERI_USB2_DCTL[run_stop] is 0.";
            sw = w; hw = r;
            reset = 0x0;
        } cmdloc[8:8];
        field {
            name = "reserved";
            desc = "Reserved";
            sw = r; hw = w;
            reset = 0x0;
        } reserved_7_4[7:4];
        field {
            name = "cmdtyp";
            desc = "Command type
- 0x0: reserved
- 0x1: Configure the endpoint.
- 0x2: Configure the endpoint transfer source.
- 0x3: Obtain the endpoint status.
- 0x4: Set the suspend state.
- 0x5: Clear the suspend state.
- 0x6: Start the transfer.
- 0x7: Update the transfer.
- 0x8: End the transfer.
- 0x9: Start the new configuration.

Other values: reserved";
            sw = rw; hw = r;
            reset = 0x0;
        } cmdtyp[3:0];
    } PERI_USB2_DGCMD @ 0xC714;
    reg {
        name = "PERI_USB2_DALEPENA";
        desc = "PERI_USB2_DALEPENA is a peripheral USB endpoint enable register. (offset 0xC718; total reset 0x00000000; PROVEN: Hi3516E V300 data sheet (Issue 00B06, 2019-05-15), section 12.6.8, PDF page 782).";
        field {
            name = "usbactep";
            desc = "Whether the USB port is valid for the current configuration and interface. Each of the 32 USB endpoints (input endpoints 0-15 and output endpoints 0-15) is controlled by one bit. The even bits control the output endpoints, and the odd bits control the input endpoints. For example: Bit[0]: USB output endpoint 0 Bit[1]: USB input endpoint 0 Bit[2]: USB output endpoint 1 Bit[3]: USB input endpoint 1 Bit 0 and bit 1 must be configured so that the control endpoints in the physical endpoints can be enabled after USB reset.";
            sw = rw; hw = r;
            reset = 0x0;
        } usbactep[31:0];
    } PERI_USB2_DALEPENA @ 0xC718;
    reg {
        name = "PERI_USB2_DEPCMDPAR2N";
        desc = "PERI_USB2_DEPCMDPAR2N is peripheral endpoint command parameter register 2. (offset 0xC810; total reset 0x00000000; PROVEN: Hi3516E V300 data sheet (Issue 00B06, 2019-05-15), section 12.6.8, PDF page 783).";
        field {
            name = "parameter2";
            desc = "Peripheral physical endpoint command parameter register 2. This register must be configured before the command is executed.";
            sw = rw; hw = r;
            reset = 0x0;
        } parameter2[31:0];
    } PERI_USB2_DEPCMDPAR2N @ 0xC810;
    reg {
        name = "PERI_USB2_DEPCMDPAR1N";
        desc = "PERI_USB2_DEPCMDPAR1N is peripheral endpoint command parameter register 1. (offset 0xC814; total reset 0x00000000; PROVEN: Hi3516E V300 data sheet (Issue 00B06, 2019-05-15), section 12.6.8, PDF page 783).";
        field {
            name = "parameter1";
            desc = "Peripheral physical endpoint command parameter register 1. This register must be configured before the command is executed.";
            sw = rw; hw = r;
            reset = 0x0;
        } parameter1[31:0];
    } PERI_USB2_DEPCMDPAR1N @ 0xC814;
    reg {
        name = "PERI_USB2_DEPCMDPAR0N";
        desc = "PERI_USB2_DEPCMDPAR0N is peripheral endpoint command parameter register 0. (offset 0xC818; total reset 0x00000000; PROVEN: Hi3516E V300 data sheet (Issue 00B06, 2019-05-15), section 12.6.8, PDF page 783).";
        field {
            name = "parameter0";
            desc = "Peripheral physical endpoint command parameter register 0. This register must be configured before the command is executed or when the command is being executed. The command requires the 32-bit parameter. Therefore, this register must be configured";
            sw = rw; hw = r;
            reset = 0x0;
        } parameter0[31:0];
    } PERI_USB2_DEPCMDPAR0N @ 0xC818;
    reg {
        name = "PERI_USB2_DEPCMDN";
        desc = "PERI_USB2_DEPCMDN is peripheral physical endpoint command register. (offset 0xC81C; total reset 0x00000000; PROVEN: Hi3516E V300 data sheet (Issue 00B06, 2019-05-15), section 12.6.8, PDF page 784).";
        field {
            name = "command_parameters";
            desc = "Command parameter. The meaning of this field varies according to the command type. For the start transfer command: Bit[31: 16] indicate the USB stream ID declared by this transfer. For the start transfer command of the real-time endpoint: Bit[31: 16] indicate the number of microframes (frame) for the first TRB application. For the update transfer, end transfer, or start new configuration command: Bit[22: 16] indicate the transfer resource index (XferRscIdx). Hardware declares the transfer resource index for the transfer. The start transfer command is responded after the index is returned. The application software declares the transfer resource index for the start new configuration command.";
            sw = rw; hw = r;
            reset = 0x0;
        } command_parameters[31:16];
        field {
            name = "cmd_status";
            desc = "Command completion status. This field saves extra information about the command that is executed. The information is the same as that in bit[15: 12] of the endpoint command completion event.";
            sw = rw; hw = r;
            reset = 0x0;
        } cmd_status[15:12];
        field {
            name = "hipri_forcerm";
            desc = "HighPriority: valid only for the start transfer command ForceRM: valid only for the end transfer command";
            sw = rw; hw = r;
            reset = 0x0;
        } hipri_forcerm[11:11];
        field {
            name = "cmd_act";
            desc = "Software writes 1 to this bit to enable the peripheral endpoint controller to execute the class command. The peripheral controller sets this bit to 0 when the cmd_status bit is valid and the endpoint is ready to receive another command. However, it does not mean that all previously sent commands are executed.";
            sw = rw; hw = r;
            reset = 0x0;
        } cmd_act[10:10];
        field {
            name = "reserved";
            desc = "Reserved";
            sw = r; hw = w;
            reset = 0x0;
        } reserved_9_9[9:9];
        field {
            name = "cmdloc";
            desc = "Command completion interrupt. The value 1 indicates that the peripheral controller generates a general endpoint command completion event after executing the command. Note: This bit cannot be set to 1 when PERI_USB2_DCTL[run_stop] is 0.";
            sw = rw; hw = r;
            reset = 0x0;
        } cmdloc[8:8];
        field {
            name = "reserved";
            desc = "Reserved";
            sw = r; hw = w;
            reset = 0x0;
        } reserved_7_4[7:4];
        field {
            name = "cmdtyp";
            desc = "Type of the command that the driver requires the core to execute
- 0x0: reserved
- 0x1: Configure the endpoint (64-bit or 96-bit parameter).
- 0x2: Configure the endpoint transfer resource (32-bit parameter).
- 0x3: Obtain the endpoint status (no parameter is required).
- 0x4: Set the stall (no parameter is required).
- 0x5: Clear the stall (no parameter is required).
- 0x6: Start the transfer (64-bit parameter).
- 0x7: Update the transfer (no parameter is required).
- 0x8: End the transfer (no parameter is required).
- 0x9: Start the new configuration (no parameter is required).

Other values: reserved";
            sw = rw; hw = r;
            reset = 0x0;
        } cmdtyp[3:0];
    } PERI_USB2_DEPCMDN @ 0xC81C;
};
`endif
