`ifndef HI3516EV300_LSADC_RDL
`define HI3516EV300_LSADC_RDL
regfile eHI3516EV300_LSADC {
    name = "Low-speed ADC";
    desc = "Low-speed ADC of the Hi3516E V300 at base 0x120A_0000. 18 registers extracted programmatically from the Hi3516E V300 data sheet (Issue 00B06, 2019-05-15) (Table 12-20 Summary of LSADC registers (base address: 0x120A_0000)): register headings, offsets, total reset values, field bit ranges, access types, names, reset values and descriptions, with PDF page numbers in each register description. Field names, bit ranges, access types and offsets are exact; the free-text descriptions are taken from the cell text of the field table and were checked by sampling only. Hardware not verified.";
    reg {
        name = "LSADC_CTRL0";
        desc = "LSADC_CTRL0 is an LSDAC configuration register. (offset 0x0; total reset 0x000080FF; PROVEN: Hi3516E V300 data sheet (Issue 00B06, 2019-05-15), section 12.7.5, PDF page 789).";
        field {
            name = "reserved";
            desc = "Reserved";
            sw = r; hw = w;
            reset = 0x0;
        } reserved_31_24[31:24];
        field {
            name = "lsadc_data_delta";
            desc = "Error range of the LSADC conversion result. In continuous scanning mode, if the difference between two conversion results falls within the error range, the two results are considered as the same.";
            sw = rw; hw = r;
            reset = 0x0;
        } lsadc_data_delta[23:20];
        field {
            name = "reserved";
            desc = "Reserved";
            sw = r; hw = w;
            reset = 0x0;
        } reserved_19_18[19:18];
        field {
            name = "deglitch_bypass";
            desc = "Deglitch bypass (used in continuous scanning mode)
- 0: enabled
- 1: bypassed";
            sw = rw; hw = r;
            reset = 0x0;
        } deglitch_bypass[17:17];
        field {
            name = "reserved";
            desc = "Reserved";
            sw = r; hw = w;
            reset = 0x0;
        } reserved_16_16[16:16];
        field {
            name = "lsadc_reset";
            desc = "Whether the LSADC enters the reset status
- 0: The LSADC exits the reset status.
- 1: The LSADC enters the reset status.";
            sw = rw; hw = r;
            reset = 0x1;
        } lsadc_reset[15:15];
        field {
            name = "reserved";
            desc = "Reserved";
            sw = r; hw = w;
            reset = 0x0;
        } reserved_14_14[14:14];
        field {
            name = "model_sel";
            desc = "Scanning mode of the LSADC
- 0: single scanning mode
- 1: continuous scanning mode";
            sw = rw; hw = r;
            reset = 0x0;
        } model_sel[13:13];
        field {
            name = "equ_model_sel";
            desc = "LSADC average algorithm mode select
- 0: 16-time average algorithm
- 1: 32-time average algorithm";
            sw = rw; hw = r;
            reset = 0x0;
        } equ_model_sel[12:12];
        field {
            name = "ch_3_vld";
            desc = "LSADC channel 3 validity
- 0: invalid
- 1: valid";
            sw = rw; hw = r;
            reset = 0x0;
        } ch_3_vld[11:11];
        field {
            name = "ch_2_vld";
            desc = "LSADC channel 2 validity
- 0: invalid
- 1: valid";
            sw = rw; hw = r;
            reset = 0x0;
        } ch_2_vld[10:10];
        field {
            name = "ch_1_vld";
            desc = "LSADC channel 1 validity
- 0: invalid
- 1: valid";
            sw = rw; hw = r;
            reset = 0x0;
        } ch_1_vld[9:9];
        field {
            name = "ch_0_vld";
            desc = "LSADC channel 0 validity
- 0: invalid
- 1: valid";
            sw = rw; hw = r;
            reset = 0x0;
        } ch_0_vld[8:8];
        field {
            name = "reserved";
            desc = "Reserved";
            sw = r; hw = w;
            reset = 0xf;
        } reserved_7_4[7:4];
        field {
            name = "ch_3_eq_enable";
            desc = "Whether the average algorithm for sampling";
            sw = rw; hw = r;
            reset = 0x1;
        } ch_3_eq_enable[3:3];
        field {
            name = "ch_2_";
            desc = "Whether the average algorithm for sampling of LSADC channel 2 is valid eq_enable
- 0: invalid
- 1: valid";
            sw = rw; hw = r;
            reset = 0x1;
        } ch_2[2:2];
        field {
            name = "ch_1_";
            desc = "Whether the average algorithm for sampling of LSADC channel 1 is valid eq_enable
- 0: invalid
- 1: valid";
            sw = rw; hw = r;
            reset = 0x1;
        } ch_1[1:1];
        field {
            name = "ch_0_";
            desc = "Whether the average algorithm for sampling of LSADC channel 0 is valid eq_enable
- 0: invalid
- 1: valid";
            sw = rw; hw = r;
            reset = 0x1;
        } ch_0[0:0];
    } LSADC_CTRL0 @ 0x0;
    reg {
        name = "LSADC_CTRL1";
        desc = "LSADC_CTRL1 is a deglitch configuration register (offset 0x4; total reset 0x00000000; PROVEN: Hi3516E V300 data sheet (Issue 00B06, 2019-05-15), section 12.7.5, PDF page 791).";
        field {
            name = "glitch_sample";
            desc = "LSADC deglitch time window (in ms typically). When the LSADC conversion result is retained in the deglitch time window, the conversion result is considered as a valid value; otherwise, a glitch is considered. The deglitch time window cannot be 0 in continuous scanning mode.";
            sw = rw; hw = r;
            reset = 0x0;
        } glitch_sample[31:0];
    } LSADC_CTRL1 @ 0x4;
    reg {
        name = "LSADC_CTRL2";
        desc = "LSADC_CTRL2 is a scanning interval configuration register. (offset 0x8; total reset 0x00000000; PROVEN: Hi3516E V300 data sheet (Issue 00B06, 2019-05-15), section 12.7.5, PDF page 791).";
        field {
            name = "time_scan";
            desc = "Time interval of scanning two channels in continuous scanning mode Tscan = time_scan x 0.333 μs (The time";
            sw = rw; hw = r;
            reset = 0x0;
        } time_scan[31:0];
    } LSADC_CTRL2 @ 0x8;
    reg {
        name = "LSADC_CTRL4";
        desc = "LSADC_CTRL4 is an interrupt enable register. (offset 0x10; total reset 0x00000000; PROVEN: Hi3516E V300 data sheet (Issue 00B06, 2019-05-15), section 12.7.5, PDF page 792).";
        field {
            name = "reserved";
            desc = "Reserved";
            sw = r; hw = w;
            reset = 0x0;
        } reserved_31_1[31:1];
        field {
            name = "int_enable";
            desc = "Scanned value valid interrupt enable
- 0: disabled
- 1: enabled";
            sw = rw; hw = r;
            reset = 0x0;
        } int_enable[0:0];
    } LSADC_CTRL4 @ 0x10;
    reg {
        name = "LSADC_CTRL5";
        desc = "LSADC_CTRL5 is an interrupt status register. (offset 0x14; total reset 0x00000000; PROVEN: Hi3516E V300 data sheet (Issue 00B06, 2019-05-15), section 12.7.5, PDF page 792).";
        field {
            name = "reserved";
            desc = "Reserved Writing to this field has no effect and reading this field returns 0.";
            sw = r; hw = w;
            reset = 0x0;
        } reserved_31_5[31:5];
        field {
            name = "lsadc_auto_busy";
            desc = "LSADC busy indicator in automatic scanning mode
- 0: idle
- 1: busy";
            sw = r; hw = w;
            reset = 0x0;
        } lsadc_auto_busy[4:4];
        field {
            name = "int_flag_in3";
            desc = "Scanned value validity interrupt flag of channel 3
- 0: No interrupt is generated.
- 1: An interrupt is generated.";
            sw = r; hw = w;
            reset = 0x0;
        } int_flag_in3[3:3];
        field {
            name = "int_flag_in2";
            desc = "Scanned value validity interrupt flag of channel 2
- 0: No interrupt is generated.
- 1: An interrupt is generated.";
            sw = r; hw = w;
            reset = 0x0;
        } int_flag_in2[2:2];
        field {
            name = "int_flag_in1";
            desc = "Scanned value validity interrupt flag of channel 1
- 0: No interrupt is generated.";
            sw = r; hw = w;
            reset = 0x0;
        } int_flag_in1[1:1];
        field {
            name = "int_flag_in0";
            desc = "Scanned value validity interrupt flag of channel 0
- 0: No interrupt is generated.
- 1: An interrupt is generated.";
            sw = r; hw = w;
            reset = 0x0;
        } int_flag_in0[0:0];
    } LSADC_CTRL5 @ 0x14;
    reg {
        name = "LSADC_CTRL6";
        desc = "LSADC_CTRL6 is an interrupt clear register. (offset 0x18; total reset 0x00000000; PROVEN: Hi3516E V300 data sheet (Issue 00B06, 2019-05-15), section 12.7.5, PDF page 793).";
        field {
            name = "reserved";
            desc = "Reserved";
            sw = r; hw = w;
            reset = 0x0;
        } reserved_31_4[31:4];
        field {
            name = "clr_int_flag_in3";
            desc = "Channel 3 interrupt clear
- 0: not cleared
- 1: cleared";
            sw = w; hw = r;
            reset = 0x0;
        } clr_int_flag_in3[3:3];
        field {
            name = "clr_int_flag_in2";
            desc = "Channel 2 interrupt clear
- 0: not cleared
- 1: cleared";
            sw = w; hw = r;
            reset = 0x0;
        } clr_int_flag_in2[2:2];
        field {
            name = "clr_int_flag_in1";
            desc = "Channel 1 interrupt clear
- 0: not cleared
- 1: cleared";
            sw = w; hw = r;
            reset = 0x0;
        } clr_int_flag_in1[1:1];
        field {
            name = "clr_int_flag_in0";
            desc = "Channel 0 interrupt clear
- 0: not cleared
- 1: cleared";
            sw = w; hw = r;
            reset = 0x0;
        } clr_int_flag_in0[0:0];
    } LSADC_CTRL6 @ 0x18;
    reg {
        name = "LSADC_CTRL7";
        desc = "LSADC_CTRL7 is a start configuration register. (offset 0x1C; total reset 0x00000000; PROVEN: Hi3516E V300 data sheet (Issue 00B06, 2019-05-15), section 12.7.5, PDF page 793).";
        field {
            name = "start";
            desc = "LSADC start signal. Writing any value to this register starts the LSADC.";
            sw = w; hw = r;
            reset = 0x0;
        } start[31:0];
    } LSADC_CTRL7 @ 0x1C;
    reg {
        name = "LSADC_CTRL8";
        desc = "LSADC_CTRL8 is a stop configuration register. (offset 0x20; total reset 0x00000000; PROVEN: Hi3516E V300 data sheet (Issue 00B06, 2019-05-15), section 12.7.5, PDF page 794).";
        field {
            name = "stop";
            desc = "Automatic scanning stop. In automatic scanning mode, writing any value to this register stops automatic scanning of the LSADC. Automatic scanning is restarted only after the start bit is enabled.";
            sw = w; hw = r;
            reset = 0x0;
        } stop[31:0];
    } LSADC_CTRL8 @ 0x20;
    reg {
        name = "LSADC_CTRL9";
        desc = "LSADC_CTRL9 is a conversion result precision register. (offset 0x24; total reset 0x000003FF; PROVEN: Hi3516E V300 data sheet (Issue 00B06, 2019-05-15), section 12.7.5, PDF page 794).";
        field {
            name = "reserved";
            desc = "Reserved";
            sw = r; hw = w;
            reset = 0x0;
        } reserved_31_10[31:10];
        field {
            name = "lsadc_active_bit";
            desc = "LSADC conversion result precision. 10'b1111111111: 10-bit precision 10'b1111111110: 9-bit precision ... 10'b1000000000: 1-bit precision";
            sw = rw; hw = r;
            reset = 0x3ff;
        } lsadc_active_bit[9:0];
    } LSADC_CTRL9 @ 0x24;
    reg {
        name = "LSADC_CTRL10";
        desc = "LSADC_CTRL10 is an lsadc_zero register. (offset 0x28; total reset 0x00000000; PROVEN: Hi3516E V300 data sheet (Issue 00B06, 2019-05-15), section 12.7.5, PDF page 794).";
        field {
            name = "reserved";
            desc = "Reserved";
            sw = r; hw = w;
            reset = 0x0;
        } reserved_31_10[31:10];
        field {
            name = "lsadc_zero";
            desc = "LSADC value when no key is pressed";
            sw = rw; hw = r;
            reset = 0x0;
        } lsadc_zero[9:0];
    } LSADC_CTRL10 @ 0x28;
    reg {
        name = "LSADC_CTRL11";
        desc = "LSADC_CTRL11 is LSADC channel 0 data register. (offset 0x2C; total reset 0x00000000; PROVEN: Hi3516E V300 data sheet (Issue 00B06, 2019-05-15), section 12.7.5, PDF page 794).";
        field {
            name = "reserved";
            desc = "Reserved";
            sw = r; hw = w;
            reset = 0x0;
        } reserved_31_10[31:10];
        field {
            name = "lsadc_data_ina";
            desc = "Scanned value of LSADC channel 0";
            sw = r; hw = w;
            reset = 0x0;
        } lsadc_data_ina[9:0];
    } LSADC_CTRL11 @ 0x2C;
    reg {
        name = "LSADC_CTRL12";
        desc = "LSADC_CTRL12 is LSADC channel 1 data register. (offset 0x30; total reset 0x00000000; PROVEN: Hi3516E V300 data sheet (Issue 00B06, 2019-05-15), section 12.7.5, PDF page 795).";
        field {
            name = "reserved";
            desc = "Reserved";
            sw = r; hw = w;
            reset = 0x0;
        } reserved_31_10[31:10];
        field {
            name = "lsadc_data_in1";
            desc = "Scanned value of LSADC channel 1";
            sw = rw; hw = r;
            reset = 0x0;
        } lsadc_data_in1[9:0];
    } LSADC_CTRL12 @ 0x30;
    reg {
        name = "LSADC_CTRL13";
        desc = "LSADC_CTRL13 is LSADC channel 2 data register. (offset 0x34; total reset 0x00000000; PROVEN: Hi3516E V300 data sheet (Issue 00B06, 2019-05-15), section 12.7.5, PDF page 795).";
        field {
            name = "reserved";
            desc = "Reserved";
            sw = r; hw = w;
            reset = 0x0;
        } reserved_31_10[31:10];
        field {
            name = "lsadc_data_in2";
            desc = "Scanned value of LSADC channel 2";
            sw = r; hw = w;
            reset = 0x0;
        } lsadc_data_in2[9:0];
    } LSADC_CTRL13 @ 0x34;
    reg {
        name = "LSADC_CTRL14";
        desc = "LSADC_CTRL14 is LSADC channel 3 data register. (offset 0x38; total reset 0x00000000; PROVEN: Hi3516E V300 data sheet (Issue 00B06, 2019-05-15), section 12.7.5, PDF page 795).";
        field {
            name = "reserved";
            desc = "Reserved";
            sw = r; hw = w;
            reset = 0x0;
        } reserved_31_10[31:10];
        field {
            name = "lsadc_data_in3";
            desc = "Scanned value of LSADC channel 3";
            sw = r; hw = w;
            reset = 0x0;
        } lsadc_data_in3[9:0];
    } LSADC_CTRL14 @ 0x38;
    reg {
        name = "LSADC_CTRL20";
        desc = "LSADC_CTRL20 is the LSADC channel 0 average algorithm data register. (offset 0x50; total reset 0x00000000; PROVEN: Hi3516E V300 data sheet (Issue 00B06, 2019-05-15), section 12.7.5, PDF page 795). INFERRED: some fields could not be extracted cleanly, see the TODO file.";
        field {
            name = "reserved";
            desc = "Reserved";
            sw = r; hw = w;
            reset = 0x0;
        } reserved_31_12[31:12];
        field {
            name = "lsadc_equ_vaule_vaild_0";
            desc = "Whether the average algorithm for sampling of LSADC channel 0 is valid
- 0: invalid
- 1: valid

(INFERRED placement: the data sheet prints the reserved range overlapping this field at [11]; PDF pages 795-796.)";
            sw = r; hw = w;
            reset = 0x0;
        } lsadc_equ_vaule_vaild_0[11:11];
        field {
            name = "reserved";
            desc = "Reserved (bit 10 is not tabulated in the data sheet)";
            sw = r; hw = w;
            reset = 0x0;
        } reserved_10_10[10:10];
        field {
            name = "lsadc_equ_vaule_0";
            desc = "Result of the average algorithm for sampling of LSADC channel 0";
            sw = r; hw = w;
            reset = 0x0;
        } lsadc_equ_vaule_0[9:0];
    } LSADC_CTRL20 @ 0x50;
    reg {
        name = "LSADC_CTRL21";
        desc = "LSADC_CTRL21 is the average algorithm data register for LSADC channel 1. (offset 0x54; total reset 0x00000000; PROVEN: Hi3516E V300 data sheet (Issue 00B06, 2019-05-15), section 12.7.5, PDF page 796). INFERRED: some fields could not be extracted cleanly, see the TODO file.";
        field {
            name = "reserved";
            desc = "Reserved";
            sw = r; hw = w;
            reset = 0x0;
        } reserved_31_12[31:12];
        field {
            name = "lsadc_equ_vaule_vaild_1";
            desc = "Whether the average algorithm for sampling of LSADC channel 1 is valid
- 0: invalid
- 1: valid

(INFERRED placement: the data sheet prints the reserved range overlapping this field at [11]; PDF pages 795-796.)";
            sw = r; hw = w;
            reset = 0x0;
        } lsadc_equ_vaule_vaild_1[11:11];
        field {
            name = "reserved";
            desc = "Reserved (bit 10 is not tabulated in the data sheet)";
            sw = r; hw = w;
            reset = 0x0;
        } reserved_10_10[10:10];
        field {
            name = "lsadc_equ_vaule_1";
            desc = "Result of the average algorithm for sampling of LSADC channel 1";
            sw = r; hw = w;
            reset = 0x0;
        } lsadc_equ_vaule_1[9:0];
    } LSADC_CTRL21 @ 0x54;
    reg {
        name = "LSADC_CTRL22";
        desc = "LSADC_CTRL22 is the average algorithm data register for LSADC channel 2. (offset 0x58; total reset 0x00000000; PROVEN: Hi3516E V300 data sheet (Issue 00B06, 2019-05-15), section 12.7.5, PDF page 796). INFERRED: some fields could not be extracted cleanly, see the TODO file.";
        field {
            name = "reserved";
            desc = "Reserved";
            sw = r; hw = w;
            reset = 0x0;
        } reserved_31_12[31:12];
        field {
            name = "lsadc_equ_vaule_vaild_2";
            desc = "Whether the average algorithm for sampling of LSADC channel 2 is valid
- 0: invalid
- 1: valid

(INFERRED placement: the data sheet prints the reserved range overlapping this field at [11]; PDF pages 795-796.)";
            sw = r; hw = w;
            reset = 0x0;
        } lsadc_equ_vaule_vaild_2[11:11];
        field {
            name = "reserved";
            desc = "Reserved (bit 10 is not tabulated in the data sheet)";
            sw = r; hw = w;
            reset = 0x0;
        } reserved_10_10[10:10];
        field {
            name = "lsadc_equ_vaule_2";
            desc = "Result of the average algorithm for sampling of LSADC channel 2";
            sw = r; hw = w;
            reset = 0x0;
        } lsadc_equ_vaule_2[9:0];
    } LSADC_CTRL22 @ 0x58;
    reg {
        name = "LSADC_CTRL23";
        desc = "LSADC_CTRL23 is the average algorithm data register for LSADC channel 3. (offset 0x5C; total reset 0x00000000; PROVEN: Hi3516E V300 data sheet (Issue 00B06, 2019-05-15), section 12.7.5, PDF page 797). INFERRED: some fields could not be extracted cleanly, see the TODO file.";
        field {
            name = "reserved";
            desc = "Reserved";
            sw = r; hw = w;
            reset = 0x0;
        } reserved_31_12[31:12];
        field {
            name = "lsadc_equ_vaule_vaild_3";
            desc = "Whether the average algorithm for sampling of LSADC channel 3 is valid
- 0: invalid
- 1: valid

(INFERRED placement: the data sheet prints the reserved range overlapping this field at [11]; PDF pages 795-796.)";
            sw = r; hw = w;
            reset = 0x0;
        } lsadc_equ_vaule_vaild_3[11:11];
        field {
            name = "reserved";
            desc = "Reserved (bit 10 is not tabulated in the data sheet)";
            sw = r; hw = w;
            reset = 0x0;
        } reserved_10_10[10:10];
        field {
            name = "lsadc_equ_vaule_3";
            desc = "Result of the average algorithm for sampling of LSADC channel 3";
            sw = r; hw = w;
            reset = 0x0;
        } lsadc_equ_vaule_3[9:0];
    } LSADC_CTRL23 @ 0x5C;
};
`endif
