`ifndef HI3516EV300_KLAD_RDL
`define HI3516EV300_KLAD_RDL
regfile eHI3516EV300_KLAD {
    name = "Key ladder (KLAD)";
    desc = "Key ladder (KLAD) of the Hi3516E V300 at base 0x1006_0000. 9 registers extracted programmatically from the Hi3516E V300 data sheet (Issue 00B06, 2019-05-15) (Table 13-5 Summary of the KLAD registers (base address: 0x1006_0000)): register headings, offsets, total reset values, field bit ranges, access types, names, reset values and descriptions, with PDF page numbers in each register description. Field names, bit ranges, access types and offsets are exact; the free-text descriptions are taken from the cell text of the field table and were checked by sampling only. Hardware not verified.";
    reg {
        name = "KLAD_CTRL";
        desc = "KLAD_CTRL is the KLAD control register. (offset 0x0; total reset 0x00000000; PROVEN: Hi3516E V300 data sheet (Issue 00B06, 2019-05-15), section 13.5.5, PDF page 845).";
        field {
            name = "reserved";
            desc = "Reserved";
            sw = r; hw = w;
            reset = 0x0;
        } reserved_31_19[31:19];
        field {
            name = "klad2ci_addr";
            desc = "Address of the key sent from the KLAD to the Cipher module. This field is valid when the KLAD of the Cipher module is selected.";
            sw = rw; hw = r;
            reset = 0x0;
        } klad2ci_addr[18:16];
        field {
            name = "reserved";
            desc = "Reserved";
            sw = r; hw = w;
            reset = 0x0;
        } reserved_15_5[15:5];
        field {
            name = "high_low_128bit_flag";
            desc = "Flag for upper or lower 128 bits
- 0: lower 128 bits
- 1: upper 128 bits";
            sw = rw; hw = r;
            reset = 0x0;
        } high_low_128bit_flag[4:4];
        field {
            name = "type";
            desc = "KLAD type
- 00: the KLAD for the Cipher module
- 01: the KLAD for the RSA module

Other values: the KLAD for the RSA module";
            sw = rw; hw = r;
            reset = 0x0;
        } type_f[3:2];
        field {
            name = "decrypt";
            desc = "Encryption or decryption flag
- 0: encryption
- 1: decryption";
            sw = rw; hw = r;
            reset = 0x0;
        } decrypt[1:1];
        field {
            name = "start";
            desc = "Start flag
- 0: not started
- 1: started (busy signal)";
            sw = rw; hw = r;
            reset = 0x0;
        } start[0:0];
    } KLAD_CTRL @ 0x0;
    reg {
        name = "KLAD_DAT_IN_0";
        desc = "KLAD_DAT_IN_0 is the KLAD input data 0 register. (offset 0x10; total reset 0x00000000; PROVEN: Hi3516E V300 data sheet (Issue 00B06, 2019-05-15), section 13.5.5, PDF page 845).";
        field {
            name = "klad_dat_in_0";
            desc = "Input data 0 of the KLAD";
            sw = rw; hw = r;
            reset = 0x0;
        } klad_dat_in_0[31:0];
    } KLAD_DAT_IN_0 @ 0x10;
    reg {
        name = "KLAD_DAT_IN_1";
        desc = "KLAD_DAT_IN_1 is the KLAD input data 1 register. (offset 0x14; total reset 0x00000000; PROVEN: Hi3516E V300 data sheet (Issue 00B06, 2019-05-15), section 13.5.5, PDF page 846).";
        field {
            name = "klad_dat_in_1";
            desc = "Input data 1 of the KLAD";
            sw = rw; hw = r;
            reset = 0x0;
        } klad_dat_in_1[31:0];
    } KLAD_DAT_IN_1 @ 0x14;
    reg {
        name = "KLAD_DAT_IN_2";
        desc = "KLAD_DAT_IN_2 is the KLAD input data 2 register. (offset 0x18; total reset 0x00000000; PROVEN: Hi3516E V300 data sheet (Issue 00B06, 2019-05-15), section 13.5.5, PDF page 846).";
        field {
            name = "klad_dat_in_2";
            desc = "Input data 2 of the KLAD";
            sw = rw; hw = r;
            reset = 0x0;
        } klad_dat_in_2[31:0];
    } KLAD_DAT_IN_2 @ 0x18;
    reg {
        name = "KLAD_DAT_IN_3";
        desc = "KLAD_DAT_IN_3 is the KLAD input data 3 register. (offset 0x1C; total reset 0x00000000; PROVEN: Hi3516E V300 data sheet (Issue 00B06, 2019-05-15), section 13.5.5, PDF page 846).";
        field {
            name = "klad_dat_in_3";
            desc = "Input data 3 of the KLAD";
            sw = rw; hw = r;
            reset = 0x0;
        } klad_dat_in_3[31:0];
    } KLAD_DAT_IN_3 @ 0x1C;
    reg {
        name = "KLAD_ENC_OUT_0";
        desc = "KLAD_ENC_OUT_0 is the KLAD encryption result 0 register. (offset 0x20; total reset 0x00000000; PROVEN: Hi3516E V300 data sheet (Issue 00B06, 2019-05-15), section 13.5.5, PDF page 846).";
        field {
            name = "klad_enc_out_0";
            desc = "Output data 0 of the KLAD";
            sw = r; hw = w;
            reset = 0x0;
        } klad_enc_out_0[31:0];
    } KLAD_ENC_OUT_0 @ 0x20;
    reg {
        name = "KLAD_ENC_OUT_1";
        desc = "KLAD_ENC_OUT_1 is the KLAD encryption result 1 register. (offset 0x24; total reset 0x00000000; PROVEN: Hi3516E V300 data sheet (Issue 00B06, 2019-05-15), section 13.5.5, PDF page 847).";
        field {
            name = "klad_enc_out_1";
            desc = "Output data 1 of the KLAD";
            sw = r; hw = w;
            reset = 0x0;
        } klad_enc_out_1[31:0];
    } KLAD_ENC_OUT_1 @ 0x24;
    reg {
        name = "KLAD_ENC_OUT_2";
        desc = "KLAD_ENC_OUT_2 is the KLAD encryption result 2 register. (offset 0x28; total reset 0x00000000; PROVEN: Hi3516E V300 data sheet (Issue 00B06, 2019-05-15), section 13.5.5, PDF page 847).";
        field {
            name = "klad_enc_out_2";
            desc = "Output data 2 of the KLAD";
            sw = r; hw = w;
            reset = 0x0;
        } klad_enc_out_2[31:0];
    } KLAD_ENC_OUT_2 @ 0x28;
    reg {
        name = "KLAD_ENC_OUT_3";
        desc = "KLAD_ENC_OUT_3 is the KLAD encryption result 3 register. (offset 0x2C; total reset 0x00000000; PROVEN: Hi3516E V300 data sheet (Issue 00B06, 2019-05-15), section 13.5.5, PDF page 847).";
        field {
            name = "klad_enc_out_3";
            desc = "Output data 3 of the KLAD";
            sw = r; hw = w;
            reset = 0x0;
        } klad_enc_out_3[31:0];
    } KLAD_ENC_OUT_3 @ 0x2C;
};
`endif
