`ifndef HI3516EV300_RTC_INT_RDL
`define HI3516EV300_RTC_INT_RDL
regfile eHI3516EV300_RTC_INT {
    name = "Internal RTC register file (device addresses reached through the RTC SPI interface, NOT memory mapped; the instance base 0x120E0100 in the SoC map is a placeholder)";
    desc = "Internal RTC register file (device addresses reached through the RTC SPI interface, NOT memory mapped; the instance base 0x120E0100 in the SoC map is a placeholder) of the Hi3516E V300 at base 0x120E0000. 41 registers extracted programmatically from the Hi3516E V300 data sheet (Issue 00B06, 2019-05-15) (Table 3-15 Summary of internal RTC registers (base address: 0x00)): register headings, offsets, total reset values, field bit ranges, access types, names, reset values and descriptions, with PDF page numbers in each register description. Field names, bit ranges, access types and offsets are exact; the free-text descriptions are taken from the cell text of the field table and were checked by sampling only. Hardware not verified.";
    reg {
        name = "RTC_10MS_COUNT";
        desc = "RTC_10MS_COUNT is a count value register for the RTC 10 ms counter. (offset 0x0; total reset 0x00000000; PROVEN: Hi3516E V300 data sheet (Issue 00B06, 2019-05-15), section 3.9.7, PDF page 178).";
        regwidth = 8;
        field {
            name = "reserved";
            desc = "Reserved";
            sw = r; hw = w;
            reset = 0x0;
        } reserved_7_7[7:7];
        field {
            name = "rtc_10ms_count";
            desc = "RTC 10 ms counter value. It indicates the currently counted time. Its unit is 10 ms. The value range is 0-99.";
            sw = r; hw = w;
            reset = 0x0;
        } rtc_10ms_count[6:0];
    } RTC_10MS_COUNT @ 0x0;
    reg {
        name = "RTC_S_COUNT";
        desc = "RTC_S_COUNT is a count value register for the RTC second counter. (offset 0x1; total reset 0x00000000; PROVEN: Hi3516E V300 data sheet (Issue 00B06, 2019-05-15), section 3.9.7, PDF page 178).";
        regwidth = 8;
        field {
            name = "reserved";
            desc = "Reserved";
            sw = r; hw = w;
            reset = 0x0;
        } reserved_7_6[7:6];
        field {
            name = "rtc_s_count";
            desc = "RTC second counter value. It indicates the currently counted seconds. The value range is 0-59.";
            sw = r; hw = w;
            reset = 0x0;
        } rtc_s_count[5:0];
    } RTC_S_COUNT @ 0x1;
    reg {
        name = "RTC_M_COUNT";
        desc = "RTC_M_COUNT is a count value register for the RTC minute counter. (offset 0x2; total reset 0x00000000; PROVEN: Hi3516E V300 data sheet (Issue 00B06, 2019-05-15), section 3.9.7, PDF page 178).";
        regwidth = 8;
        field {
            name = "reserved";
            desc = "Reserved";
            sw = r; hw = w;
            reset = 0x0;
        } reserved_7_6[7:6];
        field {
            name = "rtc_m_count";
            desc = "RTC minute counter value. It indicates the currently counted minutes. The value range is 0-59.";
            sw = r; hw = w;
            reset = 0x0;
        } rtc_m_count[5:0];
    } RTC_M_COUNT @ 0x2;
    reg {
        name = "RTC_H_COUNT";
        desc = "RTC_H_COUNT is a count value register for the RTC hour counter. (offset 0x3; total reset 0x00000000; PROVEN: Hi3516E V300 data sheet (Issue 00B06, 2019-05-15), section 3.9.7, PDF page 178).";
        regwidth = 8;
        field {
            name = "reserved";
            desc = "Reserved";
            sw = r; hw = w;
            reset = 0x0;
        } reserved_7_5[7:5];
        field {
            name = "rtc_h_count";
            desc = "RTC hour counter value. It indicates the currently counted hours. The value range is 0-23.";
            sw = r; hw = w;
            reset = 0x0;
        } rtc_h_count[4:0];
    } RTC_H_COUNT @ 0x3;
    reg {
        name = "RTC_D_COUNT_L";
        desc = "RTC_D_COUNT_L is a lower-8-bit count value register for the RTC day counter. (offset 0x4; total reset 0x00000000; PROVEN: Hi3516E V300 data sheet (Issue 00B06, 2019-05-15), section 3.9.7, PDF page 179).";
        regwidth = 8;
        field {
            name = "rtc_d_count_l";
            desc = "Lower eight bits of the RTC day counter value. This field works with RTC_D_COUNT_H to indicate the currently counted days. The day range is 0-65535.";
            sw = r; hw = w;
            reset = 0x0;
        } rtc_d_count_l[7:0];
    } RTC_D_COUNT_L @ 0x4;
    reg {
        name = "RTC_D_COUNT_H";
        desc = "RTC_D_COUNT_H is an upper-8-bit count value register for the RTC day counter. (offset 0x5; total reset 0x00000000; PROVEN: Hi3516E V300 data sheet (Issue 00B06, 2019-05-15), section 3.9.7, PDF page 179).";
        regwidth = 8;
        field {
            name = "rtc_d_count_h";
            desc = "Upper eight bits of the RTC day counter value. This field works with RTC_D_COUNT_L to indicate the currently counted days. The day range is 0-65535.";
            sw = r; hw = w;
            reset = 0x0;
        } rtc_d_count_h[7:0];
    } RTC_D_COUNT_H @ 0x5;
    reg {
        name = "RTC_MR_10MS";
        desc = "RTC_MR_10MS is a match value register for the RTC 10 ms counter. (offset 0x6; total reset 0x0000007F; PROVEN: Hi3516E V300 data sheet (Issue 00B06, 2019-05-15), section 3.9.7, PDF page 179).";
        regwidth = 8;
        field {
            name = "reserved";
            desc = "Reserved";
            sw = r; hw = w;
            reset = 0x0;
        } reserved_7_7[7:7];
        field {
            name = "rtc_mr_10ms";
            desc = "Match value of the RTC 10 ms counter The value range is 0-99.";
            sw = rw; hw = r;
            reset = 0x7f;
        } rtc_mr_10ms[6:0];
    } RTC_MR_10MS @ 0x6;
    reg {
        name = "RTC_MR_S";
        desc = "RTC_MR_S is a match value register for the RTC second counter. (offset 0x7; total reset 0x0000003F; PROVEN: Hi3516E V300 data sheet (Issue 00B06, 2019-05-15), section 3.9.7, PDF page 179).";
        regwidth = 8;
        field {
            name = "reserved";
            desc = "Reserved";
            sw = r; hw = w;
            reset = 0x0;
        } reserved_7_6[7:6];
        field {
            name = "rtc_mr_s";
            desc = "Match value of the RTC second counter The value range is 0-59.";
            sw = rw; hw = r;
            reset = 0x3f;
        } rtc_mr_s[5:0];
    } RTC_MR_S @ 0x7;
    reg {
        name = "RTC_MR_M";
        desc = "RTC_MR_M is a match value register for the RTC minute counter. (offset 0x8; total reset 0x0000003F; PROVEN: Hi3516E V300 data sheet (Issue 00B06, 2019-05-15), section 3.9.7, PDF page 180).";
        regwidth = 8;
        field {
            name = "reserved";
            desc = "Reserved";
            sw = r; hw = w;
            reset = 0x0;
        } reserved_7_6[7:6];
        field {
            name = "rtc_mr_m";
            desc = "Match value of the RTC minute counter The value range is 0-59.";
            sw = rw; hw = r;
            reset = 0x3f;
        } rtc_mr_m[5:0];
    } RTC_MR_M @ 0x8;
    reg {
        name = "RTC_MR_H";
        desc = "RTC_MR_H is a match value register for the RTC hour counter. (offset 0x9; total reset 0x0000001F; PROVEN: Hi3516E V300 data sheet (Issue 00B06, 2019-05-15), section 3.9.7, PDF page 180).";
        regwidth = 8;
        field {
            name = "reserved";
            desc = "Reserved";
            sw = r; hw = w;
            reset = 0x0;
        } reserved_7_5[7:5];
        field {
            name = "rtc_mr_h";
            desc = "Match value of the RTC hour counter The value range is 0-23.";
            sw = rw; hw = r;
            reset = 0x1f;
        } rtc_mr_h[4:0];
    } RTC_MR_H @ 0x9;
    reg {
        name = "RTC_MR_D_L";
        desc = "RTC_MR_D_L is a lower-8-bit match value register for the RTC day counter. (offset 0xA; total reset 0x000000FF; PROVEN: Hi3516E V300 data sheet (Issue 00B06, 2019-05-15), section 3.9.7, PDF page 180).";
        regwidth = 8;
        field {
            name = "rtc_mr_d_l";
            desc = "Lower eight bits of the match value of the RTC day counter. This field works with RTC_MR_D_H to indicate the matched day. The day range is 0-65535.";
            sw = rw; hw = r;
            reset = 0xff;
        } rtc_mr_d_l[7:0];
    } RTC_MR_D_L @ 0xA;
    reg {
        name = "RTC_MR_D_H";
        desc = "RTC_MR_D_H is an upper-8-bit match value register for the RTC day counter. (offset 0xB; total reset 0x000000FF; PROVEN: Hi3516E V300 data sheet (Issue 00B06, 2019-05-15), section 3.9.7, PDF page 181).";
        regwidth = 8;
        field {
            name = "rtc_mr_d_h";
            desc = "Upper eight bits of the match value of the RTC day counter. This field works with RTC_MR_D_L to indicate the matched day. The day range is 0-65535.";
            sw = rw; hw = r;
            reset = 0xff;
        } rtc_mr_d_h[7:0];
    } RTC_MR_D_H @ 0xB;
    reg {
        name = "RTC_LR_10MS";
        desc = "RTC_LR_10MS is a configured value register for the RTC 10 ms counter. (offset 0xC; total reset 0x00000000; PROVEN: Hi3516E V300 data sheet (Issue 00B06, 2019-05-15), section 3.9.7, PDF page 181).";
        regwidth = 8;
        field {
            name = "reserved";
            desc = "Reserved";
            sw = r; hw = w;
            reset = 0x0;
        } reserved_7_7[7:7];
        field {
            name = "rtc_lr_10ms";
            desc = "Configured value of the RTC 10 ms counter The value range is 0-99.";
            sw = rw; hw = r;
            reset = 0x0;
        } rtc_lr_10ms[6:0];
    } RTC_LR_10MS @ 0xC;
    reg {
        name = "RTC_LR_S";
        desc = "RTC_LR_S is a configured value register for the RTC second counter. (offset 0xD; total reset 0x00000000; PROVEN: Hi3516E V300 data sheet (Issue 00B06, 2019-05-15), section 3.9.7, PDF page 181).";
        regwidth = 8;
        field {
            name = "reserved";
            desc = "Reserved";
            sw = r; hw = w;
            reset = 0x0;
        } reserved_7_6[7:6];
        field {
            name = "rtc_lr_s";
            desc = "Configured value of the RTC second counter The value range is 0-59.";
            sw = rw; hw = r;
            reset = 0x0;
        } rtc_lr_s[5:0];
    } RTC_LR_S @ 0xD;
    reg {
        name = "RTC_LR_M";
        desc = "RTC_LR_M is a configured value register for the RTC minute counter. (offset 0xE; total reset 0x00000000; PROVEN: Hi3516E V300 data sheet (Issue 00B06, 2019-05-15), section 3.9.7, PDF page 181).";
        regwidth = 8;
        field {
            name = "reserved";
            desc = "Reserved";
            sw = r; hw = w;
            reset = 0x0;
        } reserved_7_6[7:6];
        field {
            name = "rtc_lr_m";
            desc = "Configured value of the RTC minute counter";
            sw = rw; hw = r;
            reset = 0x0;
        } rtc_lr_m[5:0];
    } RTC_LR_M @ 0xE;
    reg {
        name = "RTC_LR_H";
        desc = "RTC_LR_H is a configured value register for the RTC hour counter. (offset 0xF; total reset 0x00000000; PROVEN: Hi3516E V300 data sheet (Issue 00B06, 2019-05-15), section 3.9.7, PDF page 182).";
        regwidth = 8;
        field {
            name = "reserved";
            desc = "Reserved";
            sw = r; hw = w;
            reset = 0x0;
        } reserved_7_5[7:5];
        field {
            name = "rtc_lr_h";
            desc = "Configured value of the RTC hour counter The value range is 0-23.";
            sw = rw; hw = r;
            reset = 0x0;
        } rtc_lr_h[4:0];
    } RTC_LR_H @ 0xF;
    reg {
        name = "RTC_LR_D_L";
        desc = "RTC_LR_D_L is a lower-8-bit configured value register for the RTC day counter. (offset 0x10; total reset 0x00000000; PROVEN: Hi3516E V300 data sheet (Issue 00B06, 2019-05-15), section 3.9.7, PDF page 182).";
        regwidth = 8;
        field {
            name = "rtc_lr_d_l";
            desc = "Lower eight bits of the configured value of the RTC day counter. This field works with RTC_LR_D_H to indicate the configured day. The day range is 0-65535.";
            sw = rw; hw = r;
            reset = 0x0;
        } rtc_lr_d_l[7:0];
    } RTC_LR_D_L @ 0x10;
    reg {
        name = "RTC_LR_D_H";
        desc = "RTC_LR_D_H is an upper-8-bit configured value register for the RTC day counter. (offset 0x11; total reset 0x00000000; PROVEN: Hi3516E V300 data sheet (Issue 00B06, 2019-05-15), section 3.9.7, PDF page 182).";
        regwidth = 8;
        field {
            name = "rtc_lr_d_h";
            desc = "Upper eight bits of the configured value of the RTC day counter. This field works with RTC_LR_D_L to indicate the configured day. The day range is 0-65535.";
            sw = rw; hw = r;
            reset = 0x0;
        } rtc_lr_d_h[7:0];
    } RTC_LR_D_H @ 0x11;
    reg {
        name = "RTC_LORD";
        desc = "RTC_LORD is an RTC configured value loading enable register. (offset 0x12; total reset 0x00000000; PROVEN: Hi3516E V300 data sheet (Issue 00B06, 2019-05-15), section 3.9.7, PDF page 183).";
        regwidth = 8;
        field {
            name = "reserved";
            desc = "Reserved";
            sw = r; hw = w;
            reset = 0x0;
        } reserved_7_3[7:3];
        field {
            name = "rtc_lock_bypass";
            desc = "RTC lock enable
- 0: enabled. The RTC count value (0x00-0x05) is updated only after the RTC is successfully locked.
- 1: disabled. The RTC count value (0x00-0x05) is updated in real time.";
            sw = rw; hw = r;
            reset = 0x0;
        } rtc_lock_bypass[2:2];
        field {
            name = "rtc_lock";
            desc = "RTC lock. If software writes 1, hardware is automatically cleared after the RTC is successfully locked. Note: This field is valid only when rtc_lock_bypass is 0.";
            sw = rw; hw = r;
            reset = 0x0;
        } rtc_lock[1:1];
        field {
            name = "rtc_load";
            desc = "RTC configured value loading enable. When the field is enabled, the RTC configured value will be loaded to the RTC accumulator. If software writes 1 to load the configured value, hardware will automatically set this field to 0 after successful loading.";
            sw = rw; hw = r;
            reset = 0x0;
        } rtc_load[0:0];
    } RTC_LORD @ 0x12;
    reg {
        name = "RTC_IMSC";
        desc = "RTC_IMSC is an RTC interrupt enable register. (offset 0x13; total reset 0x00000000; PROVEN: Hi3516E V300 data sheet (Issue 00B06, 2019-05-15), section 3.9.7, PDF page 183).";
        regwidth = 8;
        field {
            name = "reserved";
            desc = "Reserved";
            sw = r; hw = w;
            reset = 0x0;
        } reserved_7_3[7:3];
        field {
            name = "rtc_imsc";
            desc = "RTC global interrupt output enable
- 0: disabled
- 1: enabled";
            sw = rw; hw = r;
            reset = 0x0;
        } rtc_imsc[2:2];
        field {
            name = "rtc_imsc_uv";
            desc = "Battery low-voltage detection interrupt output enable
- 0: disabled
- 1: enabled";
            sw = rw; hw = r;
            reset = 0x0;
        } rtc_imsc_uv[1:1];
        field {
            name = "rtc_imsc_time";
            desc = "RTC timing interrupt output enable
- 0: disabled
- 1: enabled";
            sw = rw; hw = r;
            reset = 0x0;
        } rtc_imsc_time[0:0];
    } RTC_IMSC @ 0x13;
    reg {
        name = "RTC_INT_CLR";
        desc = "RTC_INT_CLR is an RTC interrupt clear register. (offset 0x14; total reset 0x00000000; PROVEN: Hi3516E V300 data sheet (Issue 00B06, 2019-05-15), section 3.9.7, PDF page 184).";
        regwidth = 8;
        field {
            name = "reserved";
            desc = "Reserved";
            sw = r; hw = w;
            reset = 0x0;
        } reserved_7_1[7:1];
        field {
            name = "rtc_int_clr";
            desc = "RTC interrupt clear register. Writing any value by software clears the interrupt. Reading back the value has no effect.";
            sw = w; hw = r;
            reset = 0x0;
        } rtc_int_clr[0:0];
    } RTC_INT_CLR @ 0x14;
    reg {
        name = "RTC_MSC_INT";
        desc = "RTC_MSC_INT is an RTC mask interrupt status register. (offset 0x15; total reset 0x00000000; PROVEN: Hi3516E V300 data sheet (Issue 00B06, 2019-05-15), section 3.9.7, PDF page 184).";
        regwidth = 8;
        field {
            name = "reserved";
            desc = "Reserved";
            sw = r; hw = w;
            reset = 0x0;
        } reserved_7_2[7:2];
        field {
            name = "mask_int_uv";
            desc = "Status of the masked battery low-voltage detection interrupt
- 0: No interrupt is generated.
- 1: An interrupt is generated.";
            sw = r; hw = w;
            reset = 0x0;
        } mask_int_uv[1:1];
        field {
            name = "mask_int_time";
            desc = "Status of the masked RTC timing interrupt
- 0: No interrupt is generated.
- 1: An interrupt is generated.";
            sw = r; hw = w;
            reset = 0x0;
        } mask_int_time[0:0];
    } RTC_MSC_INT @ 0x15;
    reg {
        name = "RTC_RAW_INT";
        desc = "RTC_RAW_INT is an RTC raw interrupt status register. (offset 0x16; total reset 0x00000000; PROVEN: Hi3516E V300 data sheet (Issue 00B06, 2019-05-15), section 3.9.7, PDF page 184).";
        regwidth = 8;
        field {
            name = "reserved";
            desc = "Reserved";
            sw = r; hw = w;
            reset = 0x0;
        } reserved_7_2[7:2];
        field {
            name = "raw_int_uv";
            desc = "Status of the raw battery low-voltage detection interrupt
- 0: No interrupt is generated.
- 1: An interrupt is generated.";
            sw = r; hw = w;
            reset = 0x0;
        } raw_int_uv[1:1];
        field {
            name = "raw_int_time";
            desc = "Status of the raw RTC timing interrupt
- 0: No interrupt is generated.
- 1: An interrupt is generated.";
            sw = r; hw = w;
            reset = 0x0;
        } raw_int_time[0:0];
    } RTC_RAW_INT @ 0x16;
    reg {
        name = "RTC_CLK";
        desc = "RTC_CLK is an RTC output clock select register. (offset 0x17; total reset 0x00000000; PROVEN: Hi3516E V300 data sheet (Issue 00B06, 2019-05-15), section 3.9.7, PDF page 185).";
        regwidth = 8;
        field {
            name = "reserved";
            desc = "Reserved";
            sw = r; hw = w;
            reset = 0x0;
        } reserved_7_2[7:2];
        field {
            name = "clk_out_sel";
            desc = "Output test clock of the RTC
- 00: crystal oscillator clock
- 01: corrected 100 Hz clock 1x: 1 Hz clock";
            sw = rw; hw = r;
            reset = 0x0;
        } clk_out_sel[1:0];
    } RTC_CLK @ 0x17;
    reg {
        name = "RTC_POR_N";
        desc = "RTC_POR_N is an RTC reset control register. (offset 0x18; total reset 0x00000001; PROVEN: Hi3516E V300 data sheet (Issue 00B06, 2019-05-15), section 3.9.7, PDF page 185).";
        regwidth = 8;
        field {
            name = "reserved";
            desc = "Reserved";
            sw = r; hw = w;
            reset = 0x0;
        } reserved_7_1[7:1];
        field {
            name = "rtc_por_n";
            desc = "RTC reset. This field is automatically set to 1 after the RTC is successfully reset.
- 0: reset";
            sw = rw; hw = r;
            reset = 0x1;
        } rtc_por_n[0:0];
    } RTC_POR_N @ 0x18;
    reg {
        name = "RTC_UV_CTRL";
        desc = "RTC_UV_CTRL is an RTC internal low-voltage detection control register. (offset 0x1A; total reset 0x00000004; PROVEN: Hi3516E V300 data sheet (Issue 00B06, 2019-05-15), section 3.9.7, PDF page 185).";
        regwidth = 8;
        field {
            name = "reserved";
            desc = "Reserved";
            sw = r; hw = w;
            reset = 0x0;
        } reserved_7_6[7:6];
        field {
            name = "bat_uv_ctrl_en";
            desc = "Low-voltage detection enable
- 0: disabled
- 1: enabled";
            sw = rw; hw = r;
            reset = 0x0;
        } bat_uv_ctrl_en[5:5];
        field {
            name = "bat_uv_ctrl_sel";
            desc = "Low-voltage detection source select
- 0: no filtering
- 1: filtering";
            sw = rw; hw = r;
            reset = 0x0;
        } bat_uv_ctrl_sel[4:4];
        field {
            name = "bat_uvp_sel";
            desc = "Voltage threshold setting for battery undervoltage detection
- 00: 1.6 V";
            sw = rw; hw = r;
            reset = 0x1;
        } bat_uvp_sel[3:2];
        field {
            name = "sample_time";
            desc = "Low-voltage detection cycle
- 00: 1s
- 01: 1 minute
- 10: 10 minutes
- 11: 30 minutes";
            sw = rw; hw = r;
            reset = 0x0;
        } sample_time[1:0];
    } RTC_UV_CTRL @ 0x1A;
    reg {
        name = "RTC_ANA_CTRL";
        desc = "RTC_ANA_CTRL is an internal low-voltage detection control register for the RTC oscillating current control. Locked by the RTC lock register, this register can be modified only when RTC_LOCK3, RTC_LOCK2, RTC_LOCK1, or RTC_LOCK0 is set to 0x5A5AABCD. (offset 0x1B; total reset 0x00000005; PROVEN: Hi3516E V300 data sheet (Issue 00B06, 2019-05-15), section 3.9.7, PDF page 186).";
        regwidth = 8;
        field {
            name = "rtc_ana_ctrl";
            desc = "RTC oscillating current control
- 0x00: 0.619 μA
- 0x01: 0.722 μA
- 0x02: 0.825 μA
- 0x03: 0.929 μA
- 0x04: 1.031 μA
- 0x05: 1.135 μA
- 0x06: 1.238 μA
- 0x07: 1.341 μA
- 0x0F: 2.166 μA
- 0x17: 2.991 μA
- 0x37: 3.817 μA

Other values: reserved";
            sw = rw; hw = r;
            reset = 0x5;
        } rtc_ana_ctrl[7:0];
    } RTC_ANA_CTRL @ 0x1B;
    reg {
        name = "SDM_COEF_OUSIDE_H";
        desc = "SDM_COEF_OUSIDE_H is an external frequency division coefficient upper four bits register. (offset 0x51; total reset 0x00000008; PROVEN: Hi3516E V300 data sheet (Issue 00B06, 2019-05-15), section 3.9.7, PDF page 186).";
        regwidth = 8;
        field {
            name = "reserved";
            desc = "Reserved";
            sw = r; hw = w;
            reset = 0x0;
        } reserved_7_4[7:4];
        field {
            name = "sdm_coef_ouside_h";
            desc = "Upper four bits of the frequency division coefficient in fixed frequency-division mode";
            sw = rw; hw = r;
            reset = 0x8;
        } sdm_coef_ouside_h[3:0];
    } SDM_COEF_OUSIDE_H @ 0x51;
    reg {
        name = "SDM_COEF_OUSIDE_L";
        desc = "SDM_COEF_OUSIDE_L is an external frequency division coefficient lower eight bits register. (offset 0x52; total reset 0x0000001B; PROVEN: Hi3516E V300 data sheet (Issue 00B06, 2019-05-15), section 3.9.7, PDF page 187).";
        regwidth = 8;
        field {
            name = "sdm_coef_ouside_l";
            desc = "Lower eight bits of the frequency division coefficient in fixed frequency-division mode Note: When clock divider registers (addresses of 0x51 and 0x52) are read or written, you need to read or write to the upper four bits and then the lower eight bits continuously. The clock divider is calculated as follows: (f - 32700) x 30.52. f indicates the oscillation frequency of the external crystal and ranges from 32700 to 32799.";
            sw = rw; hw = r;
            reset = 0x1b;
        } sdm_coef_ouside_l[7:0];
    } SDM_COEF_OUSIDE_L @ 0x52;
    reg {
        name = "USER_REGISTER1";
        desc = "USER_REGISTER1 is 64-bit user register 1. (offset 0x53; total reset 0x00000000; PROVEN: Hi3516E V300 data sheet (Issue 00B06, 2019-05-15), section 3.9.7, PDF page 187).";
        regwidth = 8;
        field {
            name = "user_register1";
            desc = "64-bit user register 1 corresponding to bit[7:0]";
            sw = rw; hw = r;
            reset = 0x0;
        } user_register1[7:0];
    } USER_REGISTER1 @ 0x53;
    reg {
        name = "USER_REGISTER2";
        desc = "USER_REGISTER2 is 64-bit user register 2. (offset 0x54; total reset 0x00000000; PROVEN: Hi3516E V300 data sheet (Issue 00B06, 2019-05-15), section 3.9.7, PDF page 187).";
        regwidth = 8;
        field {
            name = "user_register2";
            desc = "64-bit user register 2 corresponding to bit[15:8]";
            sw = rw; hw = r;
            reset = 0x0;
        } user_register2[7:0];
    } USER_REGISTER2 @ 0x54;
    reg {
        name = "USER_REGISTER3";
        desc = "USER_REGISTER3 is 64-bit user register 3. (offset 0x55; total reset 0x00000000; PROVEN: Hi3516E V300 data sheet (Issue 00B06, 2019-05-15), section 3.9.7, PDF page 188).";
        regwidth = 8;
        field {
            name = "user_register3";
            desc = "64-bit user register 3 corresponding to bit[23:16]";
            sw = rw; hw = r;
            reset = 0x0;
        } user_register3[7:0];
    } USER_REGISTER3 @ 0x55;
    reg {
        name = "USER_REGISTER4";
        desc = "USER_REGISTER4 is 64-bit user register 4. (offset 0x56; total reset 0x00000000; PROVEN: Hi3516E V300 data sheet (Issue 00B06, 2019-05-15), section 3.9.7, PDF page 188).";
        regwidth = 8;
        field {
            name = "user_register4";
            desc = "64-bit user register 4 corresponding to bit[31:24]";
            sw = rw; hw = r;
            reset = 0x0;
        } user_register4[7:0];
    } USER_REGISTER4 @ 0x56;
    reg {
        name = "USER_REGISTER5";
        desc = "USER_REGISTER5 is 64-bit user register 5. (offset 0x57; total reset 0x00000000; PROVEN: Hi3516E V300 data sheet (Issue 00B06, 2019-05-15), section 3.9.7, PDF page 188).";
        regwidth = 8;
        field {
            name = "user_register5";
            desc = "64-bit user register 5 corresponding to bit[39:32]";
            sw = rw; hw = r;
            reset = 0x0;
        } user_register5[7:0];
    } USER_REGISTER5 @ 0x57;
    reg {
        name = "USER_REGISTER6";
        desc = "USER_REGISTER6 is 64-bit user register 6. (offset 0x58; total reset 0x00000000; PROVEN: Hi3516E V300 data sheet (Issue 00B06, 2019-05-15), section 3.9.7, PDF page 188).";
        regwidth = 8;
        field {
            name = "user_register6";
            desc = "64-bit user register 6 corresponding to bit[47:40]";
            sw = rw; hw = r;
            reset = 0x0;
        } user_register6[7:0];
    } USER_REGISTER6 @ 0x58;
    reg {
        name = "USER_REGISTER7";
        desc = "USER_REGISTER7 is 64-bit user register 7. (offset 0x59; total reset 0x00000000; PROVEN: Hi3516E V300 data sheet (Issue 00B06, 2019-05-15), section 3.9.7, PDF page 188).";
        regwidth = 8;
        field {
            name = "user_register7";
            desc = "64-bit user register 7 corresponding to bit[55:48]";
            sw = rw; hw = r;
            reset = 0x0;
        } user_register7[7:0];
    } USER_REGISTER7 @ 0x59;
    reg {
        name = "USER_REGISTER8";
        desc = "USER_REGISTER8 is 64-bit user register 8. (offset 0x5A; total reset 0x00000000; PROVEN: Hi3516E V300 data sheet (Issue 00B06, 2019-05-15), section 3.9.7, PDF page 189).";
        regwidth = 8;
        field {
            name = "user_register8";
            desc = "64-bit user register 8 corresponding to bit[63:56]";
            sw = rw; hw = r;
            reset = 0x0;
        } user_register8[7:0];
    } USER_REGISTER8 @ 0x5A;
    reg {
        name = "RTC_LOCK0";
        desc = "RTC_LOCK0 is 32-bit RTC lock register 0. (offset 0x64; total reset 0x00000001; PROVEN: Hi3516E V300 data sheet (Issue 00B06, 2019-05-15), section 3.9.7, PDF page 189).";
        regwidth = 8;
        field {
            name = "rtc_lock0";
            desc = "32-bit RTC lock register 0, corresponding to bit[7:0]";
            sw = rw; hw = r;
            reset = 0x1;
        } rtc_lock0[7:0];
    } RTC_LOCK0 @ 0x64;
    reg {
        name = "RTC_LOCK1";
        desc = "RTC_LOCK1 is 32-bit RTC lock register 1. (offset 0x65; total reset 0x00000001; PROVEN: Hi3516E V300 data sheet (Issue 00B06, 2019-05-15), section 3.9.7, PDF page 189).";
        regwidth = 8;
        field {
            name = "rtc_lock1";
            desc = "32-bit RTC lock register 1, corresponding to bit[15:8]";
            sw = rw; hw = r;
            reset = 0x1;
        } rtc_lock1[7:0];
    } RTC_LOCK1 @ 0x65;
    reg {
        name = "RTC_LOCK2";
        desc = "RTC_LOCK2 is 32-bit RTC lock register 2. (offset 0x66; total reset 0x00000010; PROVEN: Hi3516E V300 data sheet (Issue 00B06, 2019-05-15), section 3.9.7, PDF page 189).";
        regwidth = 8;
        field {
            name = "rtc_lock2";
            desc = "32-bit RTC lock register 2, corresponding to bit[23:16]";
            sw = rw; hw = r;
            reset = 0x10;
        } rtc_lock2[7:0];
    } RTC_LOCK2 @ 0x66;
    reg {
        name = "RTC_LOCK3";
        desc = "RTC_LOCK3 is 32-bit RTC lock register 3. (offset 0x67; total reset 0x00000010; PROVEN: Hi3516E V300 data sheet (Issue 00B06, 2019-05-15), section 3.9.7, PDF page 190).";
        regwidth = 8;
        field {
            name = "rtc_lock3";
            desc = "32-bit RTC lock register 3, corresponding to bit[31:24]";
            sw = rw; hw = r;
            reset = 0x10;
        } rtc_lock3[7:0];
    } RTC_LOCK3 @ 0x67;
};
`endif
