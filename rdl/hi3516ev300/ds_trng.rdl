`ifndef HI3516EV300_TRNG_RDL
`define HI3516EV300_TRNG_RDL
regfile eHI3516EV300_TRNG {
    name = "TRNG";
    desc = "TRNG of the Hi3516E V300 at base 0x1008_0000. 8 registers extracted programmatically from the Hi3516E V300 data sheet (Issue 00B06, 2019-05-15) (Table 13-3 Summary of the HISEC_TRNG_CTRL registers (base address: 0x1008_0000)): register headings, offsets, total reset values, field bit ranges, access types, names, reset values and descriptions, with PDF page numbers in each register description. Field names, bit ranges, access types and offsets are exact; the free-text descriptions are taken from the cell text of the field table and were checked by sampling only. Hardware not verified.";
    reg {
        name = "HISEC_COM_TRNG_CTRL";
        desc = "HISEC_COM_TRNG_CTRL is a TRNG control register. (offset 0x200; total reset 0x0000000A; PROVEN: Hi3516E V300 data sheet (Issue 00B06, 2019-05-15), section 13.3.4, PDF page 834).";
        field {
            name = "reserved";
            desc = "Reserved";
            sw = r; hw = w;
            reset = 0x0;
        } reserved_31_20[31:20];
        field {
            name = "alarm_clr";
            desc = "Alarm clear signal";
            sw = rw; hw = r;
            reset = 0x0;
        } alarm_clr[19:19];
        field {
            name = "reserved";
            desc = "Reserved";
            sw = r; hw = w;
            reset = 0x0;
        } reserved_18_17[18:17];
        field {
            name = "trng_sel";
            desc = "TRNG output select for the entropy source
- 0: The HiSilicon OSC analog random source data is output.
- 1: The RO random source data is output.";
            sw = rw; hw = r;
            reset = 0x0;
        } trng_sel[16:16];
        field {
            name = "reserved";
            desc = "Reserved";
            sw = r; hw = w;
            reset = 0x0;
        } reserved_15_7[15:7];
        field {
            name = "mix_enable";
            desc = "Data mixing enable
- 0: disabled
- 1: enabled";
            sw = rw; hw = r;
            reset = 0x0;
        } mix_enable[6:6];
        field {
            name = "drop_enable";
            desc = "Enable for discarding data at different probabilities. If this function is enabled, the random number generation speed is decreased by 1/3.
- 0: disabled
- 1: enabled";
            sw = rw; hw = r;
            reset = 0x0;
        } drop_enable[5:5];
        field {
            name = "pre_process_enable";
            desc = "Pre-processing enable for the random number. If this function is enabled, the random number generation speed is decreased by 1/4.
- 0: disabled
- 1: enabled";
            sw = rw; hw = r;
            reset = 0x0;
        } pre_process_enable[4:4];
        field {
            name = "drbg_enable";
            desc = "DRBG post-processing enable
- 0: disabled
- 1: enabled";
            sw = rw; hw = r;
            reset = 0x1;
        } drbg_enable[3:3];
        field {
            name = "cleardata";
            desc = "Random number clear signal in the FIFO
- 0: not cleared
- 1: Writing 1 to this bit clears the random numbers in the FIFO.

Access type WC in the data sheet: written 1 clears the bit.";
            sw = rw; hw = w; onwrite = woclr;
            reset = 0x0;
        } cleardata[2:2];
        field {
            name = "osc_sel";
            desc = "Random number source select
- 00: RNG is disabled.
- 01: Random number source 1 is used.
- 10: Random number source 2 is used.
- 11: Random number source 3 is used.";
            sw = rw; hw = r;
            reset = 0x2;
        } osc_sel[1:0];
    } HISEC_COM_TRNG_CTRL @ 0x200;
    reg {
        name = "HISEC_COM_TRNG_FIFO_DATA";
        desc = "HISEC_COM_TRNG_FIFO_DATA is a TRNG FIFO data register. (offset 0x204; total reset 0x00000000; PROVEN: Hi3516E V300 data sheet (Issue 00B06, 2019-05-15), section 13.3.4, PDF page 836).";
        field {
            name = "trng_fifo_data";
            desc = "The external interface can directly read this register, and the 32-bit data in the FIFO is returned.";
            sw = r; hw = w;
            reset = 0x0;
        } trng_fifo_data[31:0];
    } HISEC_COM_TRNG_FIFO_DATA @ 0x204;
    reg {
        name = "HISEC_COM_TRNG_DATA_ST";
        desc = "HISEC_COM_TRNG_DATA_ST is a TRNG FIFO data register status register. (offset 0x208; total reset 0x00000000; PROVEN: Hi3516E V300 data sheet (Issue 00B06, 2019-05-15), section 13.3.4, PDF page 836).";
        field {
            name = "reserved";
            desc = "Reserved";
            sw = r; hw = w;
            reset = 0x0;
        } reserved_31_14[31:14];
        field {
            name = "trng_fifo_data_cnt";
            desc = "Number of random numbers in the FIFO";
            sw = r; hw = w;
            reset = 0x0;
        } trng_fifo_data_cnt[13:8];
        field {
            name = "reserved";
            desc = "Reserved";
            sw = r; hw = w;
            reset = 0x0;
        } reserved_7_4[7:4];
        field {
            name = "low_ro_st1";
            desc = "If this bit is 1, the RO ring always outputs 1. Writing this bit clears it.

Access type WC in the data sheet: written 1 clears the bit.";
            sw = rw; hw = w; onwrite = woclr;
            reset = 0x0;
        } low_ro_st1[3:3];
        field {
            name = "low_ro_st0";
            desc = "If this bit is 1, the RO ring always outputs 0. Writing this bit clears it.

Access type WC in the data sheet: written 1 clears the bit.";
            sw = rw; hw = w; onwrite = woclr;
            reset = 0x0;
        } low_ro_st0[2:2];
        field {
            name = "low_osc_st1";
            desc = "If this bit is 1, the low-frequency oscillator clock always outputs 1. Writing this bit clears it.

Access type WC in the data sheet: written 1 clears the bit.";
            sw = rw; hw = w; onwrite = woclr;
            reset = 0x0;
        } low_osc_st1[1:1];
        field {
            name = "low_osc_st0";
            desc = "If this bit is 1, the low-frequency oscillator clock always outputs 0. Writing this bit clears it.

Access type WC in the data sheet: written 1 clears the bit.";
            sw = rw; hw = w; onwrite = woclr;
            reset = 0x0;
        } low_osc_st0[0:0];
    } HISEC_COM_TRNG_DATA_ST @ 0x208;
    reg {
        name = "HISEC_COM_TRNG_ERR0_CNT";
        desc = "HISEC_COM_TRNG_ERR0_CNT is a count register for the number of times that data is detected as all 0s during RNG random number exception detection. (offset 0x20C; total reset 0x00000000; PROVEN: Hi3516E V300 data sheet (Issue 00B06, 2019-05-15), section 13.3.4, PDF page 836).";
        field {
            name = "reserved";
            desc = "Reserved";
            sw = r; hw = w;
            reset = 0x0;
        } reserved_31_16[31:16];
        field {
            name = "rng_err0_cnt";
            desc = "Number of times that data is detected as all 0s during RNG random number exception detection";
            sw = r; hw = w;
            reset = 0x0;
        } rng_err0_cnt[15:0];
    } HISEC_COM_TRNG_ERR0_CNT @ 0x20C;
    reg {
        name = "HISEC_COM_TRNG_ERR1_CNT";
        desc = "HISEC_COM_TRNG_ERR1_CNT is a count register for the number of times that data is detected as all 1s during RNG random number exception detection. (offset 0x210; total reset 0x00000000; PROVEN: Hi3516E V300 data sheet (Issue 00B06, 2019-05-15), section 13.3.4, PDF page 837).";
        field {
            name = "reserved";
            desc = "Reserved";
            sw = r; hw = w;
            reset = 0x0;
        } reserved_31_16[31:16];
        field {
            name = "rng_err1_cnt";
            desc = "Number of times that data is detected as all 1s during RNG random number exception detection";
            sw = r; hw = w;
            reset = 0x0;
        } rng_err1_cnt[15:0];
    } HISEC_COM_TRNG_ERR1_CNT @ 0x210;
    reg {
        name = "HISEC_COM_TRNG_ERR2_CNT";
        desc = "HISEC_COM_TRNG_ERR2_CNT is a count register for the number of times that the adjacent data segments are the same during RNG random number exception detection. (offset 0x214; total reset 0x00000000; PROVEN: Hi3516E V300 data sheet (Issue 00B06, 2019-05-15), section 13.3.4, PDF page 837).";
        field {
            name = "reserved";
            desc = "Reserved";
            sw = r; hw = w;
            reset = 0x0;
        } reserved_31_16[31:16];
        field {
            name = "rng_err2_cnt";
            desc = "Number of times that the adjacent data segments are the same during RNG random number exception detection";
            sw = r; hw = w;
            reset = 0x0;
        } rng_err2_cnt[15:0];
    } HISEC_COM_TRNG_ERR2_CNT @ 0x214;
    reg {
        name = "HISEC_COM_TRNG_ERR3_CNT";
        desc = "HISEC_COM_TRNG_ERR3_CNT is a count register for the number of times that the lower 32 bits of the adjacent 256-bit data are the same during RNG random number exception detection. (offset 0x218; total reset 0x00000000; PROVEN: Hi3516E V300 data sheet (Issue 00B06, 2019-05-15), section 13.3.4, PDF page 837).";
        field {
            name = "reserved";
            desc = "Reserved";
            sw = r; hw = w;
            reset = 0x0;
        } reserved_31_16[31:16];
        field {
            name = "rng_err3_cnt";
            desc = "Number of times that the lower 32 bits of the adjacent 256-bit data are the same during RNG random number exception detection";
            sw = r; hw = w;
            reset = 0x0;
        } rng_err3_cnt[15:0];
    } HISEC_COM_TRNG_ERR3_CNT @ 0x218;
    reg {
        name = "HISEC_COM_TRNG_EMA";
        desc = "HISEC_COM_TRNG_EMA is the memory EMA configuration register. (offset 0x228; total reset 0xC0019B00; PROVEN: Hi3516E V300 data sheet (Issue 00B06, 2019-05-15), section 13.3.4, PDF page 837).";
        field {
            name = "rft_cken_in_ram_a";
            desc = "RFT cken_in_ram_a signal";
            sw = rw; hw = r;
            reset = 0x1;
        } rft_cken_in_ram_a[31:31];
        field {
            name = "rft_cken_in_ram_b";
            desc = "RFT cken_in_ram_b signal";
            sw = rw; hw = r;
            reset = 0x1;
        } rft_cken_in_ram_b[30:30];
        field {
            name = "reserved";
            desc = "Reserved";
            sw = r; hw = w;
            reset = 0x0;
        } reserved_29_17[29:17];
        field {
            name = "rft_colldisn";
            desc = "RFT colldisn signal";
            sw = rw; hw = r;
            reset = 0x1;
        } rft_colldisn[16:16];
        field {
            name = "ret1n";
            desc = "RFT ret1n signal";
            sw = rw; hw = r;
            reset = 0x1;
        } ret1n[15:15];
        field {
            name = "rft_emasa";
            desc = "RFT emasa signal";
            sw = rw; hw = r;
            reset = 0x0;
        } rft_emasa[14:14];
        field {
            name = "rft_emab";
            desc = "RFT emab signal";
            sw = rw; hw = r;
            reset = 0x3;
        } rft_emab[13:11];
        field {
            name = "rft_emaa";
            desc = "RFT emaa signal";
            sw = rw; hw = r;
            reset = 0x3;
        } rft_emaa[10:8];
        field {
            name = "reserved";
            desc = "Reserved";
            sw = r; hw = w;
            reset = 0x0;
        } reserved_7_0[7:0];
    } HISEC_COM_TRNG_EMA @ 0x228;
};
`endif
