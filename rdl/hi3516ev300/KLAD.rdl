`ifndef HI3516EV300_KLAD_RDL
`define HI3516EV300_KLAD_RDL

regfile eKLAD_V4_EV300 {
    name = "Key ladder (KLAD), Hi3516EV200/EV300 generation";
    desc = "KLAD at 0x10060000 (cipher driver KLAD_REG_BASE_ADDR_PHY, size 0x100 mapped); clock/reset CRG 0x1A0 bits 1/0. Three register groups. The OTP key loading that precedes a ladder run goes through the OTP controller (HISI_OTP_USER at 0x10090000).";

    reg {
        name = "Key ladder control";
        desc = "Source: vendor cipher driver (sources/openhisilicon/kernel/cipher/hi3516ev200/src/drv/cipher_v1.0/compat/drv_klad.c, hal_cipher_klad_config / start / wait). PROVEN offsets and bits (driver source; no hardware read). Written as (chn_id << 16) | (target << 2) | (decrypt << 1), then bit 0 starts; bit 4 selects the high block when two 64-bit blocks are processed; bit 0 reads back 0 when done.";
        field {
            name = "start_busy";
            desc = "Write 1 to start; reads 1 while busy. PROVEN.";
            sw = rw;
            hw = r;
        } start_busy[0:0];
        field {
            name = "decrypt";
            desc = "1 = decrypt, 0 = encrypt. PROVEN.";
            sw = rw;
            hw = r;
        } decrypt[1:1];
        field {
            name = "target";
            desc = "Key ladder target (hi_cipher_klad_target: AES / RSA). PROVEN position, enum values UNVERIFIED.";
            sw = rw;
            hw = r;
        } target[3:2];
        field {
            name = "block_high";
            desc = "Process the high 64-bit block (block_num == 1). PROVEN.";
            sw = rw;
            hw = r;
        } block_high[4:4];
        field {
            name = "chn_id";
            desc = "Cipher channel receiving the key. PROVEN (shift 16; width GUESS).";
            sw = rw;
            hw = r;
        } chn_id[23:16];
    } KLAD_CTRL @ 0x0;

    reg {
        name = "Key ladder data input";
        desc = "Source: vendor cipher driver (sources/openhisilicon/kernel/cipher/hi3516ev200/src/drv/cipher_v1.0/compat/drv_klad.c, hal_cipher_klad_config / start / wait). Four words written by hal_cipher_set_klad_data. PROVEN.";
        field {
            name = "data";
            desc = "Input data word.";
            sw = rw;
            hw = r;
        } data[31:0];
    } KLAD_DAT_IN[4] @ 0x10 += 0x4;

    reg {
        name = "Key ladder encrypted output";
        desc = "Source: vendor cipher driver (sources/openhisilicon/kernel/cipher/hi3516ev200/src/drv/cipher_v1.0/compat/drv_klad.c, hal_cipher_klad_config / start / wait). Four words read by hal_cipher_get_klad_data. PROVEN.";
        field {
            name = "data";
            desc = "Output data word.";
            sw = r;
            hw = w;
        } data[31:0];
    } KLAD_ENC_OUT[4] @ 0x20 += 0x4;

};

`endif
