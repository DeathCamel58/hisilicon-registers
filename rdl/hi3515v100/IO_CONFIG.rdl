`ifndef HI3515V100_IO_CONFIG_RDL
`define HI3515V100_IO_CONFIG_RDL

regfile eIO_CONFIG {
    name = "IO configuration (pin multiplexing control), Hi3515 V100";
    desc = "
    0x200F0000..: `regN` pin multiplexing control registers (48 registers, one per pin, offsets 0x000..0x0BC; the field value selects the pin function, 0 is the reset default = the pin's primary function; the upper bits are reserved and read 0).
    Source: Hi3515 data sheet issue 02 (2010-04-20), English edition (no Chinese original is available in the tree; the register names `reg0`..`reg47` are the data sheet's own): 2.4 Summary of the IO Config registers (Table 2-30, `hi3515v100--Hi3515-Datasheet.txt` line 3060) and the register descriptions that follow it in the same section (lines 3100-4683). Memory map Table 1-1 lists the IO config window at 0x200F0000.
    No vendor Hi3515 pin-multiplexing code is in the tree (the vendor U-Boot/kernel trees carry no Hi3515 V100 port), so the encodings are data-sheet only.
    ";

    reg {
        name = "Multiplexing control register of the VI0HS pin";
        desc = "Multiplexing control register of the VI0HS pin.

Data sheet 2.4 reg0 (offset 0x0, printed page 2-38, `hi3515v100--Hi3515-Datasheet.txt` line 3214).";

        enum reg0_reg0_enum {
            VI0HS = 0 { name = "Vi0Hs"; desc = "VI0HS"; };
            URXD2 = 1 { name = "Urxd2"; desc = "URXD2"; };
            GPIO1_3 = 2 { name = "Gpio1 3"; desc = "GPIO1_3"; };
        };

        field {
            name = "reg0";
            desc = "Multiplexing of the VI0HS pin. Other values: reserved.";
            sw = rw;
            hw = r;
            encode = reg0_reg0_enum;
            reset = 0x0;
        } reg0[1:0];
    } reg0 @ 0x0;

    reg {
        name = "Multiplexing control register of the VI0VS pin";
        desc = "Multiplexing control register of the VI0VS pin.

Data sheet 2.4 reg1 (offset 0x4, printed page 2-38, `hi3515v100--Hi3515-Datasheet.txt` line 3241).";

        enum reg1_reg1_enum {
            VI0VS = 0 { name = "Vi0Vs"; desc = "VI0VS"; };
            UTXD2 = 1 { name = "Utxd2"; desc = "UTXD2"; };
            GPIO1_4 = 2 { name = "Gpio1 4"; desc = "GPIO1_4"; };
        };

        field {
            name = "reg1";
            desc = "Multiplexing of the VI0VS pin. Other values: reserved.";
            sw = rw;
            hw = r;
            encode = reg1_reg1_enum;
            reset = 0x0;
        } reg1[1:0];
    } reg1 @ 0x4;

    reg {
        name = "Multiplexing control register of the VI1DAT0 pin";
        desc = "Multiplexing control register of the VI1DAT0 pin.

Data sheet 2.4 reg2 (offset 0x8, printed page 2-39, `hi3515v100--Hi3515-Datasheet.txt` line 3278).";

        enum reg2_reg2_enum {
            VI1DAT0 = 0 { name = "Vi1Dat0"; desc = "VI1DAT0"; };
            GPIO3_0 = 1 { name = "Gpio3 0"; desc = "GPIO3_0"; };
        };

        field {
            name = "reg2";
            desc = "Multiplexing of the VI1DAT0 pin.";
            sw = rw;
            hw = r;
            encode = reg2_reg2_enum;
            reset = 0x0;
        } reg2[0:0];
    } reg2 @ 0x8;

    reg {
        name = "Multiplexing control register of the VI1DAT1 pin";
        desc = "Multiplexing control register of the VI1DAT1 pin.

Data sheet 2.4 reg3 (offset 0xC, printed page 2-39, `hi3515v100--Hi3515-Datasheet.txt` line 3303).";

        field {
            name = "reg3";
            desc = "Multiplexing of the VI1DAT1 pin.";
            sw = rw;
            hw = r;
            reset = 0x0;
        } reg3[0:0];
    } reg3 @ 0xC;

    reg {
        name = "Multiplexing control register of the VI1DAT2 pin";
        desc = "Multiplexing control register of the VI1DAT2 pin.

Data sheet 2.4 reg4 (offset 0x10, printed page 2-40, `hi3515v100--Hi3515-Datasheet.txt` line 3339).";

        enum reg4_reg4_enum {
            VI1DAT2 = 0 { name = "Vi1Dat2"; desc = "VI1DAT2"; };
            GPIO3_2 = 1 { name = "Gpio3 2"; desc = "GPIO3_2"; };
        };

        field {
            name = "reg4";
            desc = "Multiplexing of the VI1DAT2 pin.";
            sw = rw;
            hw = r;
            encode = reg4_reg4_enum;
            reset = 0x0;
        } reg4[0:0];
    } reg4 @ 0x10;

    reg {
        name = "Multiplexing control register of the VI1DAT3 pin";
        desc = "Multiplexing control register of the VI1DAT3 pin.

Data sheet 2.4 reg5 (offset 0x14, printed page 2-40, `hi3515v100--Hi3515-Datasheet.txt` line 3363).";

        enum reg5_reg5_enum {
            VI1DAT3 = 0 { name = "Vi1Dat3"; desc = "VI1DAT3"; };
            GPIO3_3 = 1 { name = "Gpio3 3"; desc = "GPIO3_3"; };
        };

        field {
            name = "reg5";
            desc = "Multiplexing of the VI1DAT3 pin.";
            sw = rw;
            hw = r;
            encode = reg5_reg5_enum;
            reset = 0x0;
        } reg5[0:0];
    } reg5 @ 0x14;

    reg {
        name = "Multiplexing control register of the VI1DAT4 pin";
        desc = "Multiplexing control register of the VI1DAT4 pin.

Data sheet 2.4 reg6 (offset 0x18, printed page 2-41, `hi3515v100--Hi3515-Datasheet.txt` line 3396).";

        enum reg6_reg6_enum {
            VI1DAT4 = 0 { name = "Vi1Dat4"; desc = "VI1DAT4"; };
            GPIO3_4 = 1 { name = "Gpio3 4"; desc = "GPIO3_4"; };
        };

        field {
            name = "reg6";
            desc = "Multiplexing of the VI1DAT4 pin.";
            sw = rw;
            hw = r;
            encode = reg6_reg6_enum;
            reset = 0x0;
        } reg6[0:0];
    } reg6 @ 0x18;

    reg {
        name = "Multiplexing control register of the VI1DAT5 pin";
        desc = "Multiplexing control register of the VI1DAT5 pin.

Data sheet 2.4 reg7 (offset 0x1C, printed page 2-41, `hi3515v100--Hi3515-Datasheet.txt` line 3421).";

        enum reg7_reg7_enum {
            VI1DAT5 = 0 { name = "Vi1Dat5"; desc = "VI1DAT5"; };
            GPIO3_5 = 1 { name = "Gpio3 5"; desc = "GPIO3_5"; };
        };

        field {
            name = "reg7";
            desc = "Multiplexing of the VI1DAT5 pin.";
            sw = rw;
            hw = r;
            encode = reg7_reg7_enum;
            reset = 0x0;
        } reg7[0:0];
    } reg7 @ 0x1C;

    reg {
        name = "Multiplexing control register of the VI1DAT6 pin";
        desc = "Multiplexing control register of the VI1DAT6 pin.

Data sheet 2.4 reg8 (offset 0x20, printed page 2-42, `hi3515v100--Hi3515-Datasheet.txt` line 3458).";

        enum reg8_reg8_enum {
            VI1DAT6 = 0 { name = "Vi1Dat6"; desc = "VI1DAT6"; };
            GPIO3_6 = 1 { name = "Gpio3 6"; desc = "GPIO3_6"; };
        };

        field {
            name = "reg8";
            desc = "Multiplexing of the VI1DAT6 pin.";
            sw = rw;
            hw = r;
            encode = reg8_reg8_enum;
            reset = 0x0;
        } reg8[0:0];
    } reg8 @ 0x20;

    reg {
        name = "Multiplexing control register of the VI1DAT7 pin";
        desc = "Multiplexing control register of the VI1DAT7 pin.

Data sheet 2.4 reg9 (offset 0x24, printed page 2-42, `hi3515v100--Hi3515-Datasheet.txt` line 3482).";

        enum reg9_reg9_enum {
            VI1DAT7 = 0 { name = "Vi1Dat7"; desc = "VI1DAT7"; };
            GPIO3_7 = 1 { name = "Gpio3 7"; desc = "GPIO3_7"; };
        };

        field {
            name = "reg9";
            desc = "Multiplexing of the VI1DAT7 pin.";
            sw = rw;
            hw = r;
            encode = reg9_reg9_enum;
            reset = 0x0;
        } reg9[0:0];
    } reg9 @ 0x24;

    reg {
        name = "Multiplexing control register of the VI2HS pin";
        desc = "Multiplexing control register of the VI2HS pin.

Data sheet 2.4 reg10 (offset 0x28, printed page 2-43, `hi3515v100--Hi3515-Datasheet.txt` line 3518).";

        enum reg10_reg10_enum {
            VI2HS = 0 { name = "Vi2Hs"; desc = "VI2HS"; };
            URXD3 = 1 { name = "Urxd3"; desc = "URXD3"; };
            GPIO1_5 = 2 { name = "Gpio1 5"; desc = "GPIO1_5"; };
        };

        field {
            name = "reg10";
            desc = "Multiplexing of the VI2HS pin. Other values: reserved.";
            sw = rw;
            hw = r;
            encode = reg10_reg10_enum;
            reset = 0x0;
        } reg10[1:0];
    } reg10 @ 0x28;

    reg {
        name = "Multiplexing control register of the VI2VS pin";
        desc = "Multiplexing control register of the VI2VS pin.

Data sheet 2.4 reg11 (offset 0x2C, printed page 2-43, `hi3515v100--Hi3515-Datasheet.txt` line 3545).";

        enum reg11_reg11_enum {
            VI2VS = 0 { name = "Vi2Vs"; desc = "VI2VS"; };
            UTXD3 = 1 { name = "Utxd3"; desc = "UTXD3"; };
            GPIO1_6 = 2 { name = "Gpio1 6"; desc = "GPIO1_6"; };
        };

        field {
            name = "reg11";
            desc = "Multiplexing of the VI2VS pin. Other values: reserved.";
            sw = rw;
            hw = r;
            encode = reg11_reg11_enum;
            reset = 0x0;
        } reg11[1:0];
    } reg11 @ 0x2C;

    reg {
        name = "Multiplexing control register of the VI2DAT0 pin";
        desc = "Multiplexing control register of the VI2DAT0 pin.

Data sheet 2.4 reg12 (offset 0x30, printed page 2-44, `hi3515v100--Hi3515-Datasheet.txt` line 3584).";

        enum reg12_reg12_enum {
            VI2DAT0 = 0 { name = "Vi2Dat0"; desc = "VI2DAT0"; };
            GPIO4_0 = 1 { name = "Gpio4 0"; desc = "GPIO4_0"; };
        };

        field {
            name = "reg12";
            desc = "Multiplexing of the VI2DAT0 pin.";
            sw = rw;
            hw = r;
            encode = reg12_reg12_enum;
            reset = 0x0;
        } reg12[0:0];
    } reg12 @ 0x30;

    reg {
        name = "Multiplexing control register of the VI2DAT1 pin";
        desc = "Multiplexing control register of the VI2DAT1 pin.

Data sheet 2.4 reg13 (offset 0x34, printed page 2-44, `hi3515v100--Hi3515-Datasheet.txt` line 3608).";

        enum reg13_reg13_enum {
            VI2DAT1 = 0 { name = "Vi2Dat1"; desc = "VI2DAT1"; };
            GPIO4_1 = 1 { name = "Gpio4 1"; desc = "GPIO4_1"; };
        };

        field {
            name = "reg13";
            desc = "Multiplexing of the VI2DAT1 pin.";
            sw = rw;
            hw = r;
            encode = reg13_reg13_enum;
            reset = 0x0;
        } reg13[0:0];
    } reg13 @ 0x34;

    reg {
        name = "Multiplexing control register of the VI2DAT2 pin";
        desc = "Multiplexing control register of the VI2DAT2 pin.

Data sheet 2.4 reg14 (offset 0x38, printed page 2-45, `hi3515v100--Hi3515-Datasheet.txt` line 3644).";

        enum reg14_reg14_enum {
            VI2DAT2 = 0 { name = "Vi2Dat2"; desc = "VI2DAT2"; };
            GPIO4_2 = 1 { name = "Gpio4 2"; desc = "GPIO4_2"; };
        };

        field {
            name = "reg14";
            desc = "Multiplexing of the VI2DAT2 pin.";
            sw = rw;
            hw = r;
            encode = reg14_reg14_enum;
            reset = 0x0;
        } reg14[0:0];
    } reg14 @ 0x38;

    reg {
        name = "Multiplexing control register of the VI2DAT3 pin";
        desc = "Multiplexing control register of the VI2DAT3 pin.

Data sheet 2.4 reg15 (offset 0x3C, printed page 2-45, `hi3515v100--Hi3515-Datasheet.txt` line 3669).";

        enum reg15_reg15_enum {
            VI2DAT3 = 0 { name = "Vi2Dat3"; desc = "VI2DAT3"; };
            GPIO4_3 = 1 { name = "Gpio4 3"; desc = "GPIO4_3"; };
        };

        field {
            name = "reg15";
            desc = "Multiplexing of the VI2DAT3 pin.";
            sw = rw;
            hw = r;
            encode = reg15_reg15_enum;
            reset = 0x0;
        } reg15[0:0];
    } reg15 @ 0x3C;

    reg {
        name = "Multiplexing control register of the VI2DAT4 pin";
        desc = "Multiplexing control register of the VI2DAT4 pin.

Data sheet 2.4 reg16 (offset 0x40, printed page 2-46, `hi3515v100--Hi3515-Datasheet.txt` line 3706).";

        enum reg16_reg16_enum {
            VI2DAT4 = 0 { name = "Vi2Dat4"; desc = "VI2DAT4"; };
            GPIO4_4 = 1 { name = "Gpio4 4"; desc = "GPIO4_4"; };
        };

        field {
            name = "reg16";
            desc = "Multiplexing of the VI2DAT4 pin.";
            sw = rw;
            hw = r;
            encode = reg16_reg16_enum;
            reset = 0x0;
        } reg16[0:0];
    } reg16 @ 0x40;

    reg {
        name = "Multiplexing control register of the VI2DAT5 pin";
        desc = "Multiplexing control register of the VI2DAT5 pin.

Data sheet 2.4 reg17 (offset 0x44, printed page 2-46, `hi3515v100--Hi3515-Datasheet.txt` line 3730).";

        enum reg17_reg17_enum {
            VI2DAT5 = 0 { name = "Vi2Dat5"; desc = "VI2DAT5"; };
            GPIO4_5 = 1 { name = "Gpio4 5"; desc = "GPIO4_5"; };
        };

        field {
            name = "reg17";
            desc = "Multiplexing of the VI2DAT5 pin.";
            sw = rw;
            hw = r;
            encode = reg17_reg17_enum;
            reset = 0x0;
        } reg17[0:0];
    } reg17 @ 0x44;

    reg {
        name = "Multiplexing control register of the VI2DAT6 pin";
        desc = "Multiplexing control register of the VI2DAT6 pin.

Data sheet 2.4 reg18 (offset 0x48, printed page 2-47, `hi3515v100--Hi3515-Datasheet.txt` line 3766).";

        enum reg18_reg18_enum {
            VI2DAT6 = 0 { name = "Vi2Dat6"; desc = "VI2DAT6"; };
            GPIO4_6 = 1 { name = "Gpio4 6"; desc = "GPIO4_6"; };
        };

        field {
            name = "reg18";
            desc = "Multiplexing of the VI2DAT6 pin.";
            sw = rw;
            hw = r;
            encode = reg18_reg18_enum;
            reset = 0x0;
        } reg18[0:0];
    } reg18 @ 0x48;

    reg {
        name = "Multiplexing control register of the VI2DAT7 pin";
        desc = "Multiplexing control register of the VI2DAT7 pin.

Data sheet 2.4 reg19 (offset 0x4C, printed page 2-47, `hi3515v100--Hi3515-Datasheet.txt` line 3791).";

        enum reg19_reg19_enum {
            VI2DAT7 = 0 { name = "Vi2Dat7"; desc = "VI2DAT7"; };
            GPIO4_7 = 1 { name = "Gpio4 7"; desc = "GPIO4_7"; };
        };

        field {
            name = "reg19";
            desc = "Multiplexing of the VI2DAT7 pin.";
            sw = rw;
            hw = r;
            encode = reg19_reg19_enum;
            reset = 0x0;
        } reg19[0:0];
    } reg19 @ 0x4C;

    reg {
        name = "Multiplexing control register of the VI3DAT0 pin";
        desc = "Multiplexing control register of the VI3DAT0 pin.

Data sheet 2.4 reg20 (offset 0x50, printed page 2-48, `hi3515v100--Hi3515-Datasheet.txt` line 3828).";

        enum reg20_reg20_enum {
            VI3DAT0 = 0 { name = "Vi3Dat0"; desc = "VI3DAT0"; };
            GPIO5_0 = 1 { name = "Gpio5 0"; desc = "GPIO5_0"; };
        };

        field {
            name = "reg20";
            desc = "Multiplexing of the VI3DAT0 pin.";
            sw = rw;
            hw = r;
            encode = reg20_reg20_enum;
            reset = 0x0;
        } reg20[0:0];
    } reg20 @ 0x50;

    reg {
        name = "Multiplexing control register of the VI3DAT1 pin";
        desc = "Multiplexing control register of the VI3DAT1 pin.

Data sheet 2.4 reg21 (offset 0x54, printed page 2-48, `hi3515v100--Hi3515-Datasheet.txt` line 3852).";

        enum reg21_reg21_enum {
            VI3DAT1 = 0 { name = "Vi3Dat1"; desc = "VI3DAT1"; };
            GPIO5_1 = 1 { name = "Gpio5 1"; desc = "GPIO5_1"; };
        };

        field {
            name = "reg21";
            desc = "Multiplexing of the VI3DAT1 pin.";
            sw = rw;
            hw = r;
            encode = reg21_reg21_enum;
            reset = 0x0;
        } reg21[0:0];
    } reg21 @ 0x54;

    reg {
        name = "Multiplexing control register of the VI3DAT2 pin";
        desc = "Multiplexing control register of the VI3DAT2 pin.

Data sheet 2.4 reg22 (offset 0x58, printed page 2-49, `hi3515v100--Hi3515-Datasheet.txt` line 3888).";

        enum reg22_reg22_enum {
            VI3DAT2 = 0 { name = "Vi3Dat2"; desc = "VI3DAT2"; };
            GPIO5_2 = 1 { name = "Gpio5 2"; desc = "GPIO5_2"; };
        };

        field {
            name = "reg22";
            desc = "Multiplexing of the VI3DAT2 pin.";
            sw = rw;
            hw = r;
            encode = reg22_reg22_enum;
            reset = 0x0;
        } reg22[0:0];
    } reg22 @ 0x58;

    reg {
        name = "Multiplexing control register of the VI3DAT3 pin";
        desc = "Multiplexing control register of the VI3DAT3 pin.

Data sheet 2.4 reg23 (offset 0x5C, printed page 2-49, `hi3515v100--Hi3515-Datasheet.txt` line 3913).";

        enum reg23_reg23_enum {
            VI3DAT3 = 0 { name = "Vi3Dat3"; desc = "VI3DAT3"; };
            GPIO5_3 = 1 { name = "Gpio5 3"; desc = "GPIO5_3"; };
        };

        field {
            name = "reg23";
            desc = "Multiplexing of the VI3DAT3 pin.";
            sw = rw;
            hw = r;
            encode = reg23_reg23_enum;
            reset = 0x0;
        } reg23[0:0];
    } reg23 @ 0x5C;

    reg {
        name = "Multiplexing control register of the VI3DAT4 pin";
        desc = "Multiplexing control register of the VI3DAT4 pin.

Data sheet 2.4 reg24 (offset 0x60, printed page 2-50, `hi3515v100--Hi3515-Datasheet.txt` line 3950).";

        enum reg24_reg24_enum {
            VI3DAT4 = 0 { name = "Vi3Dat4"; desc = "VI3DAT4"; };
            GPIO5_4 = 1 { name = "Gpio5 4"; desc = "GPIO5_4"; };
        };

        field {
            name = "reg24";
            desc = "Multiplexing of the VI3DAT4 pin.";
            sw = rw;
            hw = r;
            encode = reg24_reg24_enum;
            reset = 0x0;
        } reg24[0:0];
    } reg24 @ 0x60;

    reg {
        name = "Multiplexing control register of the VI3DAT5 pin";
        desc = "Multiplexing control register of the VI3DAT5 pin.

Data sheet 2.4 reg25 (offset 0x64, printed page 2-50, `hi3515v100--Hi3515-Datasheet.txt` line 3974).";

        enum reg25_reg25_enum {
            VI3DAT5 = 0 { name = "Vi3Dat5"; desc = "VI3DAT5"; };
            GPIO5_5 = 1 { name = "Gpio5 5"; desc = "GPIO5_5"; };
        };

        field {
            name = "reg25";
            desc = "Multiplexing of the VI3DAT5 pin.";
            sw = rw;
            hw = r;
            encode = reg25_reg25_enum;
            reset = 0x0;
        } reg25[0:0];
    } reg25 @ 0x64;

    reg {
        name = "Multiplexing control register of the VI3DAT6 pin";
        desc = "Multiplexing control register of the VI3DAT6 pin.

Data sheet 2.4 reg26 (offset 0x68, printed page 2-51, `hi3515v100--Hi3515-Datasheet.txt` line 4010).";

        enum reg26_reg26_enum {
            VI3DAT6 = 0 { name = "Vi3Dat6"; desc = "VI3DAT6"; };
            GPIO5_6 = 1 { name = "Gpio5 6"; desc = "GPIO5_6"; };
        };

        field {
            name = "reg26";
            desc = "Multiplexing of the VI3DAT6 pin.";
            sw = rw;
            hw = r;
            encode = reg26_reg26_enum;
            reset = 0x0;
        } reg26[0:0];
    } reg26 @ 0x68;

    reg {
        name = "Multiplexing control register of the VI3DAT7 pin";
        desc = "Multiplexing control register of the VI3DAT7 pin.

Data sheet 2.4 reg27 (offset 0x6C, printed page 2-51, `hi3515v100--Hi3515-Datasheet.txt` line 4035).";

        enum reg27_reg27_enum {
            VI3DAT7 = 0 { name = "Vi3Dat7"; desc = "VI3DAT7"; };
            GPIO5_7 = 1 { name = "Gpio5 7"; desc = "GPIO5_7"; };
        };

        field {
            name = "reg27";
            desc = "Multiplexing of the VI3DAT7 pin.";
            sw = rw;
            hw = r;
            encode = reg27_reg27_enum;
            reset = 0x0;
        } reg27[0:0];
    } reg27 @ 0x6C;

    reg {
        name = "Multiplexing control register of the VOCK pin";
        desc = "Multiplexing control register of the VOCK pin.

Data sheet 2.4 reg28 (offset 0x70, printed page 2-52, `hi3515v100--Hi3515-Datasheet.txt` line 4072).";

        enum reg28_reg28_enum {
            GPIO1_7 = 0 { name = "Gpio1 7"; desc = "GPIO1_7"; };
            VOCK = 1 { name = "Vock"; desc = "VOCK"; };
            SDIOCK = 2 { name = "Sdiock"; desc = "SDIOCK"; };
            SPICK = 3 { name = "Spick"; desc = "SPICK"; };
        };

        field {
            name = "reg28";
            desc = "Multiplexing of the VOCK pin.";
            sw = rw;
            hw = r;
            encode = reg28_reg28_enum;
            reset = 0x0;
        } reg28[1:0];
    } reg28 @ 0x70;

    reg {
        name = "Multiplexing control register of the VODAT0 pin";
        desc = "Multiplexing control register of the VODAT0 pin.

Data sheet 2.4 reg29 (offset 0x74, printed page 2-52, `hi3515v100--Hi3515-Datasheet.txt` line 4098).";

        enum reg29_reg29_enum {
            GPIO2_0 = 0 { name = "Gpio2 0"; desc = "GPIO2_0"; };
            VODAT0 = 1 { name = "Vodat0"; desc = "VODAT0"; };
            SDIOCMD = 2 { name = "Sdiocmd"; desc = "SDIOCMD"; };
            SPIDI = 3 { name = "Spidi"; desc = "SPIDI"; };
        };

        field {
            name = "reg29";
            desc = "Multiplexing of the VODAT0 pin.";
            sw = rw;
            hw = r;
            encode = reg29_reg29_enum;
            reset = 0x0;
        } reg29[1:0];
    } reg29 @ 0x74;

    reg {
        name = "Multiplexing control register of the VODAT1 pin";
        desc = "Multiplexing control register of the VODAT1 pin.

Data sheet 2.4 reg30 (offset 0x78, printed page 2-53, `hi3515v100--Hi3515-Datasheet.txt` line 4137).";

        enum reg30_reg30_enum {
            GPIO2_1 = 0 { name = "Gpio2 1"; desc = "GPIO2_1"; };
            VODAT1 = 1 { name = "Vodat1"; desc = "VODAT1"; };
            SDIODAT0 = 2 { name = "Sdiodat0"; desc = "SDIODAT0"; };
            SPIDO = 3 { name = "Spido"; desc = "SPIDO"; };
        };

        field {
            name = "reg30";
            desc = "Multiplexing of the VODAT1 pin.";
            sw = rw;
            hw = r;
            encode = reg30_reg30_enum;
            reset = 0x0;
        } reg30[1:0];
    } reg30 @ 0x78;

    reg {
        name = "Multiplexing control register of the VODAT2 pin";
        desc = "Multiplexing control register of the VODAT2 pin.

Data sheet 2.4 reg31 (offset 0x7C, printed page 2-53, `hi3515v100--Hi3515-Datasheet.txt` line 4164).";

        enum reg31_reg31_enum {
            GPIO2_2 = 0 { name = "Gpio2 2"; desc = "GPIO2_2"; };
            VODAT2 = 1 { name = "Vodat2"; desc = "VODAT2"; };
            SDIODAT1 = 2 { name = "Sdiodat1"; desc = "SDIODAT1"; };
            SPICSN0 = 3 { name = "Spicsn0"; desc = "SPICSN0"; };
        };

        field {
            name = "reg31";
            desc = "Multiplexing of the VODAT2 pin.";
            sw = rw;
            hw = r;
            encode = reg31_reg31_enum;
            reset = 0x0;
        } reg31[1:0];
    } reg31 @ 0x7C;

    reg {
        name = "Multiplexing control register of the VODAT3 pin";
        desc = "Multiplexing control register of the VODAT3 pin.

Data sheet 2.4 reg32 (offset 0x80, printed page 2-54, `hi3515v100--Hi3515-Datasheet.txt` line 4203).";

        enum reg32_reg32_enum {
            GPIO2_3 = 0 { name = "Gpio2 3"; desc = "GPIO2_3"; };
            VODAT3 = 1 { name = "Vodat3"; desc = "VODAT3"; };
            SDIODAT2 = 2 { name = "Sdiodat2"; desc = "SDIODAT2"; };
            SPICSN1 = 3 { name = "Spicsn1"; desc = "SPICSN1"; };
        };

        field {
            name = "reg32";
            desc = "Multiplexing of the VODAT3 pin.";
            sw = rw;
            hw = r;
            encode = reg32_reg32_enum;
            reset = 0x0;
        } reg32[1:0];
    } reg32 @ 0x80;

    reg {
        name = "Multiplexing control register of the VODAT4 pin";
        desc = "Multiplexing control register of the VODAT4 pin.

Data sheet 2.4 reg33 (offset 0x84, printed page 2-54, `hi3515v100--Hi3515-Datasheet.txt` line 4229).";

        enum reg33_reg33_enum {
            GPIO2_4 = 0 { name = "Gpio2 4"; desc = "GPIO2_4"; };
            VODAT4 = 1 { name = "Vodat4"; desc = "VODAT4"; };
            SDIODAT3 = 2 { name = "Sdiodat3"; desc = "SDIODAT3"; };
        };

        field {
            name = "reg33";
            desc = "Multiplexing of the VODAT4 pin. Other values: reserved.";
            sw = rw;
            hw = r;
            encode = reg33_reg33_enum;
            reset = 0x0;
        } reg33[1:0];
    } reg33 @ 0x84;

    reg {
        name = "Multiplexing control register of the VODAT5 pin";
        desc = "Multiplexing control register of the VODAT5 pin.

Data sheet 2.4 reg34 (offset 0x88, printed page 2-55, `hi3515v100--Hi3515-Datasheet.txt` line 4268).";

        enum reg34_reg34_enum {
            GPIO2_5 = 0 { name = "Gpio2 5"; desc = "GPIO2_5"; };
            VODAT5 = 1 { name = "Vodat5"; desc = "VODAT5"; };
            SDIODETC = 2 { name = "Sdiodetc"; desc = "SDIODETC"; };
        };

        field {
            name = "reg34";
            desc = "Multiplexing of the VODAT5 pin. Other values: reserved.";
            sw = rw;
            hw = r;
            encode = reg34_reg34_enum;
            reset = 0x0;
        } reg34[1:0];
    } reg34 @ 0x88;

    reg {
        name = "Multiplexing control register of the VODAT6 pin";
        desc = "Multiplexing control register of the VODAT6 pin.

Data sheet 2.4 reg35 (offset 0x8C, printed page 2-55, `hi3515v100--Hi3515-Datasheet.txt` line 4295).";

        enum reg35_reg35_enum {
            SATALEDN0 = 0 { name = "Sataledn0"; desc = "SATALEDN0"; };
            VODAT6 = 1 { name = "Vodat6"; desc = "VODAT6"; };
        };

        field {
            name = "reg35";
            desc = "Multiplexing of the VODAT6 pin.";
            sw = rw;
            hw = r;
            encode = reg35_reg35_enum;
            reset = 0x0;
        } reg35[0:0];
    } reg35 @ 0x8C;

    reg {
        name = "Multiplexing control register of the VODAT7 pin";
        desc = "Multiplexing control register of the VODAT7 pin.

Data sheet 2.4 reg36 (offset 0x90, printed page 2-56, `hi3515v100--Hi3515-Datasheet.txt` line 4332).";

        enum reg36_reg36_enum {
            SATALEDN1 = 0 { name = "Sataledn1"; desc = "SATALEDN1"; };
            VODAT7 = 1 { name = "Vodat7"; desc = "VODAT7"; };
        };

        field {
            name = "reg36";
            desc = "Multiplexing of the VODAT7 pin.";
            sw = rw;
            hw = r;
            encode = reg36_reg36_enum;
            reset = 0x0;
        } reg36[0:0];
    } reg36 @ 0x90;

    reg {
        name = "Multiplexing control register of the serial data (SDA) pin";
        desc = "Multiplexing control register of the SDA pin.

Data sheet 2.4 reg37 (offset 0x94, printed page 2-56, `hi3515v100--Hi3515-Datasheet.txt` line 4356).";

        enum reg37_reg37_enum {
            SDA = 0 { name = "Sda"; desc = "SDA"; };
            GPIO0_0 = 1 { name = "Gpio0 0"; desc = "GPIO0_0"; };
        };

        field {
            name = "reg37";
            desc = "Multiplexing of the SDA pin.";
            sw = rw;
            hw = r;
            encode = reg37_reg37_enum;
            reset = 0x0;
        } reg37[0:0];
    } reg37 @ 0x94;

    reg {
        name = "Multiplexing control register of the serial clock (SCL) pin";
        desc = "Multiplexing control register of the serial clock (SCL) pin.

Data sheet 2.4 reg38 (offset 0x98, printed page 2-57, `hi3515v100--Hi3515-Datasheet.txt` line 4392).";

        enum reg38_reg38_enum {
            SCL = 0 { name = "Scl"; desc = "SCL"; };
            GPIO0_1 = 1 { name = "Gpio0 1"; desc = "GPIO0_1"; };
        };

        field {
            name = "reg38";
            desc = "Multiplexing of the SCL pin.";
            sw = rw;
            hw = r;
            encode = reg38_reg38_enum;
            reset = 0x0;
        } reg38[0:0];
    } reg38 @ 0x98;

    reg {
        name = "Multiplexing control register of the SIO0XFS pin";
        desc = "Multiplexing control register of the SIO0XFS pin.

Data sheet 2.4 reg39 (offset 0x9C, printed page 2-57, `hi3515v100--Hi3515-Datasheet.txt` line 4417).";

        enum reg39_reg39_enum {
            SIO0XFS = 0 { name = "Sio0Xfs"; desc = "SIO0XFS"; };
            GPIO0_2 = 1 { name = "Gpio0 2"; desc = "GPIO0_2"; };
        };

        field {
            name = "reg39";
            desc = "Multiplexing of the SIO0XFS pin.";
            sw = rw;
            hw = r;
            encode = reg39_reg39_enum;
            reset = 0x0;
        } reg39[0:0];
    } reg39 @ 0x9C;

    reg {
        name = "Multiplexing control register of the SIO0XCK pin";
        desc = "Multiplexing control register of the SIO0XCK pin.

Data sheet 2.4 reg40 (offset 0xA0, printed page 2-58, `hi3515v100--Hi3515-Datasheet.txt` line 4454).";

        enum reg40_reg40_enum {
            SIO0XCK = 0 { name = "Sio0Xck"; desc = "SIO0XCK"; };
            GPIO0_3 = 1 { name = "Gpio0 3"; desc = "GPIO0_3"; };
        };

        field {
            name = "reg40";
            desc = "Multiplexing of the SIO0XCK pin.";
            sw = rw;
            hw = r;
            encode = reg40_reg40_enum;
            reset = 0x0;
        } reg40[0:0];
    } reg40 @ 0xA0;

    reg {
        name = "Multiplexing control register of the ACKOUT pin";
        desc = "Multiplexing control register of the ACKOUT pin.

Data sheet 2.4 reg41 (offset 0xA4, printed page 2-58, `hi3515v100--Hi3515-Datasheet.txt` line 4478).";

        enum reg41_reg41_enum {
            GPIO0_4 = 0 { name = "Gpio0 4"; desc = "GPIO0_4"; };
            ACKOUT = 1 { name = "Ackout"; desc = "ACKOUT"; };
        };

        field {
            name = "reg41";
            desc = "Multiplexing of the ACKOUT pin.";
            sw = rw;
            hw = r;
            encode = reg41_reg41_enum;
            reset = 0x0;
        } reg41[0:0];
    } reg41 @ 0xA4;

    reg {
        name = "Multiplexing control register of the SMICS1N pin";
        desc = "Multiplexing control register of the SMICS1N pin.

Data sheet 2.4 reg42 (offset 0xA8, printed page 2-59, `hi3515v100--Hi3515-Datasheet.txt` line 4514).";

        enum reg42_reg42_enum {
            GPIO0_5 = 0 { name = "Gpio0 5"; desc = "GPIO0_5"; };
            SMICS1N = 1 { name = "Smics1N"; desc = "SMICS1N"; };
        };

        field {
            name = "reg42";
            desc = "Multiplexing of the SMICS1N pin.";
            sw = rw;
            hw = r;
            encode = reg42_reg42_enum;
            reset = 0x0;
        } reg42[0:0];
    } reg42 @ 0xA8;

    reg {
        name = "Multiplexing control register of the NFCS1N pin";
        desc = "Multiplexing control register of the NFCS1N pin.

Data sheet 2.4 reg43 (offset 0xAC, printed page 2-59, `hi3515v100--Hi3515-Datasheet.txt` line 4539).";

        enum reg43_reg43_enum {
            GPIO0_6 = 0 { name = "Gpio0 6"; desc = "GPIO0_6"; };
            NFCS1N = 1 { name = "Nfcs1N"; desc = "NFCS1N"; };
        };

        field {
            name = "reg43";
            desc = "Multiplexing of the NFCS1N pin.";
            sw = rw;
            hw = r;
            encode = reg43_reg43_enum;
            reset = 0x0;
        } reg43[0:0];
    } reg43 @ 0xAC;

    reg {
        name = "Multiplexing control register of the NFRB pin";
        desc = "Multiplexing control register of the NFRB pin.

Data sheet 2.4 reg44 (offset 0xB0, printed page 2-60, `hi3515v100--Hi3515-Datasheet.txt` line 4576).";

        enum reg44_reg44_enum {
            NFRB = 0 { name = "Nfrb"; desc = "NFRB"; };
            GPIO0_7 = 1 { name = "Gpio0 7"; desc = "GPIO0_7"; };
        };

        field {
            name = "reg44";
            desc = "Multiplexing of the NFRB pin.";
            sw = rw;
            hw = r;
            encode = reg44_reg44_enum;
            reset = 0x0;
        } reg44[0:0];
    } reg44 @ 0xB0;

    reg {
        name = "Multiplexing control register of the EBIRDYN pin";
        desc = "Multiplexing control register of the EBIRDYN pin.

Data sheet 2.4 reg45 (offset 0xB4, printed page 2-60, `hi3515v100--Hi3515-Datasheet.txt` line 4600).";

        enum reg45_reg45_enum {
            EBIRDYN = 0 { name = "Ebirdyn"; desc = "EBIRDYN"; };
            IRRCV = 1 { name = "Irrcv"; desc = "IRRCV"; };
            GPIO1_0 = 2 { name = "Gpio1 0"; desc = "GPIO1_0"; };
        };

        field {
            name = "reg45";
            desc = "Multiplexing of the EBIRDYN pin. Other values: reserved.";
            sw = rw;
            hw = r;
            encode = reg45_reg45_enum;
            reset = 0x0;
        } reg45[1:0];
    } reg45 @ 0xB4;

    reg {
        name = "Multiplexing control register of the ECOL pin";
        desc = "Multiplexing control register of the ECOL pin.

Data sheet 2.4 reg46 (offset 0xB8, printed page 2-61, `hi3515v100--Hi3515-Datasheet.txt` line 4638).";

        enum reg46_reg46_enum {
            ECOL = 0 { name = "Ecol"; desc = "ECOL"; };
            GPIO1_1 = 1 { name = "Gpio1 1"; desc = "GPIO1_1"; };
        };

        field {
            name = "reg46";
            desc = "Multiplexing of the ECOL pin.";
            sw = rw;
            hw = r;
            encode = reg46_reg46_enum;
            reset = 0x0;
        } reg46[0:0];
    } reg46 @ 0xB8;

    reg {
        name = "Multiplexing control register of the ECRS pin";
        desc = "Multiplexing control register of the ECRS pin.

Data sheet 2.4 reg47 (offset 0xBC, printed page 2-61, `hi3515v100--Hi3515-Datasheet.txt` line 4663).";

        enum reg47_reg47_enum {
            ECRS = 0 { name = "Ecrs"; desc = "ECRS"; };
            GPIO1_2 = 1 { name = "Gpio1 2"; desc = "GPIO1_2"; };
        };

        field {
            name = "reg47";
            desc = "Multiplexing of the ECRS pin.";
            sw = rw;
            hw = r;
            encode = reg47_reg47_enum;
            reset = 0x0;
        } reg47[0:0];
    } reg47 @ 0xBC;

};

`endif
