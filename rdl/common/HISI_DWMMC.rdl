`ifndef HISI_DWMMC_RDL
`define HISI_DWMMC_RDL

// Chip generation macros (set in the chip's defines.rdl). Without any macro the block is the
// Hi3518E V20X / Hi3516C V200 edition (himciv200, data sheet 12.4). Generation macros:
//   DWMMC_GEN1  dw_mmc 1.x: Hi3511/Hi3512, Hi3515, Hi3520 V100 (no IDMAC, PWREN, CLKSRC, WRTPRT, boot
//               bits; FIFO at 0x100; MMC_CARDSTATUS instead of MMC_CDETECT on the Hi3515: DWMMC_CARDSTATUS)
//   DWMMC_GEN2  Hi3516C V100, Hi3518A/C V100, Hi3518E V100, Hi3516 V100: IDMAC, FIFO still at 0x100, no
//               DEBNCE/UHS/CARDTHRCTL/phase registers (Hi3516 V100 adds DWMMC_OD_PULLUP)
//   DWMMC_GEN3  Hi3516A/D V100: GEN2 + DEBNCE, UHS_REG, CARDTHRCTL, UHS_REG_EXT, DDR_REG, ENABLE_SHIFT,
//               FIFO at 0x200 (= the default edition without CARD_RSTN / use_hold_reg / volt_switch)
//   DWMMC_GEN4  Hi3516C V300 / Hi3516E V100, Hi3516A V300: default edition without CLKSRC, with CARD_RSTN
//               (Hi3516A V300 adds DWMMC_FIFOTH_MSIZE0 and DWMMC_NO_WRTPRT)
//   DWMMC_GEN5  Hi3516A V200, Hi3519 V101: GEN4 + WRTPRT + ADMA3 (ADMA_* registers, IDSTS/IDINTEN[29:17],
//               4-bit clock phase fields)
// Feature macros derived below (a chip may also set them directly): DWMMC_SINGLE_SLOT_BITS (one card per
// controller: the eMMC/SDIO bit pairs of the Hi3518E V20X data sheet are single bits), DWMMC_FIFO_0x100,
// DWMMC_NO_CLKSRC, DWMMC_NO_WRTPRT, DWMMC_NO_CARD_RSTN, DWMMC_NO_HOLD_REG (MMC_CMD without use_hold_reg /
// volt_switch, reset 0), DWMMC_FIFOTH_MSIZE0 (MMC_FIFOTH reset 0x00FF0000), DWMMC_CDETECT_RESET0,
// DWMMC_CTRL_DMA_ENABLE (MMC_CTRL[5] dma_enable for the external DMAC), DWMMC_ADMA3.
`ifdef DWMMC_GEN1
`define DWMMC_SINGLE_SLOT_BITS
`define DWMMC_FIFO_0x100
`define DWMMC_NO_CLKSRC
`define DWMMC_NO_WRTPRT
`define DWMMC_NO_CARD_RSTN
`define DWMMC_NO_HOLD_REG
`define DWMMC_FIFOTH_MSIZE0
`define DWMMC_CTRL_DMA_ENABLE
`endif
`ifdef DWMMC_GEN2
`define DWMMC_SINGLE_SLOT_BITS
`define DWMMC_FIFO_0x100
`define DWMMC_NO_CARD_RSTN
`define DWMMC_NO_HOLD_REG
`define DWMMC_FIFOTH_MSIZE0
`define DWMMC_CDETECT_RESET0
`define DWMMC_CTRL_DMA_ENABLE
`endif
`ifdef DWMMC_GEN3
`define DWMMC_SINGLE_SLOT_BITS
`define DWMMC_NO_CARD_RSTN
`define DWMMC_NO_HOLD_REG
`define DWMMC_CTRL_DMA_ENABLE
`endif
`ifdef DWMMC_GEN4
`define DWMMC_SINGLE_SLOT_BITS
`define DWMMC_NO_CLKSRC
`endif
`ifdef DWMMC_GEN5
`define DWMMC_SINGLE_SLOT_BITS
`define DWMMC_NO_CLKSRC
`define DWMMC_ADMA3
`endif


regfile eHISI_DWMMC {
    name = "HiSilicon MMC/SD/SDIO controller (DesignWare-MMC based, himciv200)";
    desc = "
    HiSilicon MMC/SD/SDIO host controller \"himciv200\", a Synopsys DesignWare Mobile Storage Host (dw_mmc) core with HiSilicon additions (PHASE/tuning register MMC_UHS_REG_EXT, MMC_ENABLE_SHIFT, MMC_DDR_REG (HS400), card threshold control, 256-word FIFO at 0x200). Hi3518E V20X / Hi3516C V200: two instances, MMC0 / SDIO0 at 0x10020000 (SD 3.0, SDIO 3.0, eMMC 5.0 with 8-bit bus; GIC/VIC interrupt 18) and MMC1 / SDIO1 at 0x10030000 (SD 2.0 and SDIO 2.0 only, 4-bit bus; interrupt 8, shared with GZIP). Data moves through the built-in IDMAC (descriptor list, MMC_DBADDR) or the CPU through the FIFO window.
    Registers are from the Hi3518E V20X/Hi3516C V200 data sheet issue 02 (2017-06-12), section 12.4.4 (`datasheet` text lines 82110-84358). The DS describes eMMC/SDIO bit pairs in several registers (copied from a two-slot variant of the IP); on this SoC each controller drives a single slot and the vendor driver (and the Linux dw_mmc based `himci` driver) only uses bit 0 / bits 7:0 / bit 16 for the 8-bit mode. The vendor U-Boot register header (include/himciv200_reg.h) additionally names MMC_GPIO (0x58), MMC_USRID (0x68), MMC_VERID (0x6C) and MMC_HCON (0x70); they are modelled as vendor-only registers.
    Clock and reset (PERI_CRG49, 0x20030000 + 0xC4): MMC0 srst bit 8, clock enable bit 9, clock select bits 11:10 (0 = 99 MHz, 1 = 74.25 MHz, 2 = 49.5 MHz, 3 = 148.5 MHz); MMC1 srst bit 0, clock enable bit 1, clock select bits 3:2 (the vendor driver programs 0 = 49.5 MHz for MMC1; compare the MMC0 encoding, where 2 = 49.5 MHz). The card clock is CCLK_IN / (2 x MMC_CLKDIV).
    Not hardware verified.

    The same dw_mmc core, in five generations, is the SD/SDIO/eMMC host of every HiSilicon SoC in this repository (chip macros DWMMC_GEN1..GEN5 in the file header select the generation; every data sheet other than the Hi3518E V20X one shows the slot fields as single bits):
    - GEN1 (dw_mmc 1.x, registers 0x00-0x60 and the FIFO at 0x100; no IDMAC: data moves through the external PL080 DMAC or the CPU; MMC_CTRL[0] and the card-detect interrupt bit 0 are reserved; no PWREN, CLKSRC, WRTPRT, boot or hold-register bits; MMC_FIFOTH reset 0): Hi3511/Hi3512 MMC at 0x90020000 (Hi3511 data sheet chapter 8, Chinese), Hi3515 MMC at 0x10030000 (chapter 8; adds MMC_CARDSTATUS at 0x50, reset 1), Hi3520 V100 MMC at 0x10030000 (chapter 8, Chinese).
    - GEN2 (adds PWREN, CLKSRC[0], CDETECT (reset 0), WRTPRT, MMC_CTRL[25] use_internal_dmac and the IDMAC registers 0x80-0x98; FIFO still at 0x100; MMC_CMD without use_hold_reg / volt_switch; MMC_FIFOTH reset 0x00FF0000): Hi3516C V100 SDIO at 0x10020000 (DS 13.7), Hi3518A/C V100 SDIO at 0x10020000 (DS 13.7), Hi3518E V100 (DS 13.7), Hi3516 V100 SDIO0 at 0x10020000 and SDIO1 at 0x10030000 (Chinese DS; MMC_CTRL[24] enable_od_pullup).
    - GEN3 (adds DEBNCE 0x64, UHS_REG 0x74, CLKSRC[1:0], CARDTHRCTL 0x100, UHS_REG_EXT 0x108, DDR_REG 0x10C, ENABLE_SHIFT 0x110, FIFO at 0x200, MMC_FIFOTH reset 0x60FF0000; no CARD_RSTN): Hi3516A/D V100 SDIO0 at 0x206E0000 and SDIO1 at 0x206F0000 (DS 13.4).
    - Hi3518E V20X / Hi3516C V200 (default): GEN3 + CLKSRC[3:0], MMC_CMD use_hold_reg (reset 1) / volt_switch, CARD_RSTN 0x78, CARDTHRCTL cardwrthr_en.
    - GEN4 (default without CLKSRC; MMC_STATUS[8] data_3_status reserved): Hi3516C V300 / Hi3516E V100 MMC0..MMC3 at 0x100C0000, 0x100D0000, 0x100E0000, 0x100F0000 (DS 12.5; the Hi3516CV300-only edition lists MMC_WRTPRT, the Hi3516CV300/EV100 edition does not), Hi3516A V300 SDIO1 at 0x10020000, SDIO0 at 0x100F0000 and eMMC at 0x10100000 (Chinese DS; MMC_FIFOTH reset 0x00FF0000, no WRTPRT).
    - GEN5 (GEN4 + WRTPRT + ADMA3 command-queue engine: ADMA_CONTROL..ADMA_TIMEOUT at 0xB0-0xC4, MMC_IDSTS/MMC_IDINTEN bits 29:17, 4-bit clock phase fields in MMC_UHS_REG_EXT): Hi3516A V200 and Hi3519 V101 MMC0..MMC2 at 0x100C0000, 0x100D0000, 0x100E0000 (DS 12.5).
    Vendor drivers: himci (Hi3515/Hi3520/Hi3516C/Hi3518 V100 generations, FIFO at 0x100), himciv200 (Hi3516A V100 on), himciv300 (Hi3516A V200/Hi3519); mainline Linux dw_mmc-hi3798cv200 / dw_mmc-pltfm are the closest in-tree drivers.
";

    reg {
        name = "MMC control register";
        desc = "MMC_CTRL is a MMC control register.

Vendor driver (himciv200.c): sets `USE_INTERNAL_DMA` (bit 25), `INTR_EN` (bit 4) and resets controller/FIFO/DMA with `CTRL_RESET | FIFO_RESET | DMA_RESET` (bits 0-2) during init; the DS marks bit 25 as use_internal_dmac. The reset bits clear themselves.

Data sheet 12.4.4 MMC_CTRL (offset 0x0, printed page 12-88, `Hi3518EV20X-Hi3516CV200-Datasheet.txt` line 82115).";

        enum MMC_CTRL_Use_internal_dmac_enum {
            CPU_TRANSFERS_DATA = 0 { name = "Cpu Transfers Data"; desc = "The CPU transfers data by using the slave interface."; };
            CPU_TRANSFERS_DATA_2 = 1 { name = "Cpu Transfers Data 2"; desc = "The CPU transfers data by using the IDMAC."; };
        };

`ifndef DWMMC_GEN1
        field {
            name = "Use_internal_dmac";
            desc = "Whether to transfer data by using the IDMAC";
            sw = rw;
            hw = r;
            encode = MMC_CTRL_Use_internal_dmac_enum;
            reset = 0x0;
        } Use_internal_dmac[25:25];
`endif

`ifdef DWMMC_OD_PULLUP
        field {
            name = "Enable_OD_pullup";
            desc = "External open-drain pull-up enable (Hi3516 V100 only): 0 = disabled, 1 = enabled. The inverted value drives the SDIOn_CCMD_ODPULLUP_EN_N pin (n = 0, 1). Hi3516 V100 Chinese data sheet MMC_CTRL bit 24.";
            sw = rw;
            hw = r;
            reset = 0x0;
        } Enable_OD_pullup[24:24];
`endif

        enum MMC_CTRL_Abort_read_data_enum {
            INVALID = 0 { name = "Invalid"; desc = "invalid"; };
            AFTER_TRANSMITTING_SUSPEND = 1 { name = "After Transmitting Suspend"; desc = "After transmitting a suspend command during data read, the software polls the card to check when suspend occurs. After the suspend occurs, the software sets the bit to 1. This enables the data transfer state machine to be restored to idle state for the next block transfer. After the state machine restores to the idle status, this bit is cleared automatically."; };
        };

        field {
            name = "Abort_read_data";
            desc = "Whether to abort the data transfer during data read";
            sw = rw;
            hw = r;
            encode = MMC_CTRL_Abort_read_data_enum;
            reset = 0x0;
        } Abort_read_data[8:8];

        enum MMC_CTRL_Send_irq_response_enum {
            INVALID = 0 { name = "Invalid"; desc = "invalid"; };
            INTERRUPT_REQUEST_RESPONSE = 1 { name = "Interrupt Request Response"; desc = "An interrupt request (IRQ) response is transmitted automatically. After the response is transmitted, this bit is cleared automatically. To wait for the interrupt generated by the MMC controller, the host transmits the CMD40 command and waits for the interrupt response from the MMC controller. If you do not want the host to keep in the interrupt wait state, set this bit to 1 and transmit the CMD40 command to restore the host to the idle state."; };
        };

        field {
            name = "Send_irq_response";
            desc = "TX interrupt response control";
            sw = rw;
            hw = w;
            encode = MMC_CTRL_Send_irq_response_enum;
            reset = 0x0;
        } Send_irq_response[7:7];

        enum MMC_CTRL_Read_wait_enum {
            DISABLED = 0 { name = "Disabled"; desc = "disabled"; };
            ENABLED_THIS_BIT = 1 { name = "Enabled This Bit"; desc = "enabled This bit is valid only for the SDIO card that supports the read wait function."; };
        };

        field {
            name = "Read_wait";
            desc = "Read wait control";
            sw = rw;
            hw = r;
            encode = MMC_CTRL_Read_wait_enum;
            reset = 0x0;
        } Read_wait[6:6];

`ifdef DWMMC_CTRL_DMA_ENABLE
        field {
            name = "Dma_enable";
            desc = "DMA request enable for the external DMAC (dw_mmc dma_enable): 0 = the CPU moves data through MMC_DATA, 1 = the controller raises DMA requests at the FIFO thresholds. Listed in the Hi3515/Hi3520 V100, Hi3516C/Hi3518 V100 and Hi3516A/D V100 data sheets; reserved from the Hi3518E V20X on (IDMAC only).";
            sw = rw;
            hw = r;
            reset = 0x0;
        } Dma_enable[5:5];
`endif

        enum MMC_CTRL_Int_enable_enum {
            DISABLED = 0 { name = "Disabled"; desc = "disabled"; };
            ENABLED_INTERRUPT_OUTPUT = 1 { name = "Enabled Interrupt Output"; desc = "enabled The interrupt output is valid only when this bit is valid and the interrupt source is enabled."; };
        };

        field {
            name = "Int_enable";
            desc = "Global interrupt enable";
            sw = rw;
            hw = r;
            encode = MMC_CTRL_Int_enable_enum;
            reset = 0x0;
        } Int_enable[4:4];

        enum MMC_CTRL_Dma_reset_enum {
            INVALID = 0 { name = "Invalid"; desc = "invalid"; };
            RESET_INTERNAL_DMA = 1 { name = "Reset Internal Dma"; desc = "reset the internal DMA interface This bit is automatically reset after two AHB clock cycles."; };
        };

        field {
            name = "Dma_reset";
            desc = "Soft reset control for the IDMAC";
            sw = rw;
            hw = w;
            encode = MMC_CTRL_Dma_reset_enum;
            reset = 0x0;
        } Dma_reset[2:2];

        enum MMC_CTRL_Fifo_reset_enum {
            INVALID = 0 { name = "Invalid"; desc = "invalid"; };
            RESET_FIFO_POINTER = 1 { name = "Reset Fifo Pointer"; desc = "reset the FIFO pointer This bit is reset automatically after the reset operation is complete."; };
        };

        field {
            name = "Fifo_reset";
            desc = "Soft reset control for the internal FIFO";
            sw = rw;
            hw = w;
            encode = MMC_CTRL_Fifo_reset_enum;
            reset = 0x0;
        } Fifo_reset[1:1];

        enum MMC_CTRL_Controller_reset_enum {
            INVALID = 0 { name = "Invalid"; desc = "invalid"; };
            RESET_MMC_SD = 1 { name = "Reset Mmc Sd"; desc = "reset the MMC/SD/SDIO host module"; };
        };

`ifndef DWMMC_GEN1
        field {
            name = "Controller_reset";
            desc = "Soft reset control for the controller";
            sw = rw;
            hw = w;
            encode = MMC_CTRL_Controller_reset_enum;
            reset = 0x0;
        } Controller_reset[0:0];
`endif
    } MMC_CTRL @ 0x0;

`ifndef DWMMC_GEN1
    reg {
        name = "Power_en control register";
        desc = "MMC_PWREN is a Power_en control register.

Bit 0 drives the card-power output of this controller (SDIOn_CARD_POWER_EN). The DS describes a two-bit eMMC/SDIO pair; on this SoC each controller (MMC0 at 0x10020000, MMC1 at 0x10030000) is a separate instance and only bit 0 is meaningful to the vendor driver.

Data sheet 12.4.4 MMC_PWREN (offset 0x4, printed page 12-90, `Hi3518EV20X-Hi3516CV200-Datasheet.txt` line 82211).";

        enum MMC_PWREN_Power_enable_enum {
            POWER_OFF = 0 { name = "Power Off"; desc = "power off"; };
            POWER_THIS_VALUE = 1 { name = "Power This Value"; desc = "power on This value is used to drive the SDIOn_CARD_POWER_EN (n = 0 or 1) pin."; };
        };

        field {
            name = "Power_enable";
            desc = "Power control Bit 1 and bit 0 control the eMMC power and SDIO power respectively. The following takes bit 0 as an example:";
            sw = rw;
            hw = r;
            encode = MMC_PWREN_Power_enable_enum;
            reset = 0x0;
`ifdef DWMMC_SINGLE_SLOT_BITS
        } Power_enable[0:0];
`else
        } Power_enable[1:0];
`endif
    } MMC_PWREN @ 0x4;
`endif

    reg {
        name = "Clock divider register";
        desc = "Clock divider register.

Interface clock = CCLK_IN / (2 x clk_divider) (DS 12.4.2); CCLK_IN is selected in PERI_CRG49 (MMC0 bits 11:10, MMC1 bits 3:2) and the maximum interface clock is 100 MHz. The vendor driver programs clk_divider0 for card 0. After a change, update the clock registers with MMC_CMD[update_clock_registers_only] as in DS 12.4.2.

Data sheet 12.4.4 MMC_CLKDIV (offset 0x8, printed page 12-91, `Hi3518EV20X-Hi3516CV200-Datasheet.txt` line 82258).";

`ifndef DWMMC_SINGLE_SLOT_BITS
        field {
            name = "clk_divider1";
            desc = "eMMC clock divider. The clock divider is 2 x n. If the value of n is 0, it indicates no frequency division; if the value of n is 1, the frequency is divided by 2; if the value of is 0xFF, the frequency is divided by 510.";
            sw = rw;
            hw = r;
            reset = 0x0;
        } clk_divider1[15:8];
`endif

        field {
            name = "clk_divider0";
            desc = "SDIO clock divider. The clock divider is 2 x n. If the value of n is 0, it indicates no frequency division; if the value of n is 1, the frequency is divided by 2; if the value of n is 0xFF, the frequency is divided by 510.";
            sw = rw;
            hw = r;
            reset = 0x0;
        } clk_divider0[7:0];
    } MMC_CLKDIV @ 0x8;

`ifndef DWMMC_NO_CLKSRC
    reg {
        name = "Clock source select register of the SD card";
        desc = "MMC_CLKSRC is a clock source select register of the SD card.

Must stay 0 on this SoC in practice; the DS text for clk_source says \"must be set to 4\" for the bit pair of two cards but the vendor driver never writes this register. (DS wording kept verbatim in the field description.) The Hi3516C/Hi3518 V100 and Hi3516 V100 data sheets show a single bit [0], the Hi3516A/D V100 one bits [1:0] (\"must be 0\"); the register is absent (reserved) on Hi3511/Hi3515/Hi3520 V100, Hi3516C V300, Hi3516A V300, Hi3516A V200 and Hi3519.

Data sheet 12.4.4 MMC_CLKSRC (offset 0xC, printed page 12-91, `Hi3518EV20X-Hi3516CV200-Datasheet.txt` line 82286).";

        field {
            name = "clk_source";
            desc = "This bit must be set to 4.";
            sw = rw;
            hw = r;
            reset = 0x0;
        } clk_source[3:0];
    } MMC_CLKSRC @ 0xC;
`endif

    reg {
        name = "Clock enable register";
        desc = "MMC_CLKENA is a clock enable register.

Data sheet 12.4.4 MMC_CLKENA (offset 0x10, printed page 12-92, `Hi3518EV20X-Hi3516CV200-Datasheet.txt` line 82320).";

        enum MMC_CLKENA_cclk_low_power_enum {
            NON_LOWER_POWER = 0 { name = "Non Lower Power"; desc = "non lower-power mode"; };
            LOW_POWER_MODE = 1 { name = "Low Power Mode"; desc = "low-power mode When the card is idle, the card clock is disabled. This function is used only for the MMC and SD card, because the card clock of the SDIO card must be retained for detecting interrupts."; };
        };

        field {
            name = "cclk_low_power";
            desc = "Card low-power control for disabling the card clock Bit 17 and bit 16 indicate the low-power control for eMMC and SDIO respectively. The following takes bit 16 as an example:";
            sw = rw;
            hw = r;
            encode = MMC_CLKENA_cclk_low_power_enum;
            reset = 0x0;
`ifdef DWMMC_SINGLE_SLOT_BITS
        } cclk_low_power[16:16];
`else
        } cclk_low_power[17:16];
`endif

        enum MMC_CLKENA_cclk_enable_enum {
            DISABLED = 0 { name = "Disabled"; desc = "disabled"; };
            ENABLED = 1 { name = "Enabled"; desc = "enabled"; };
        };

        field {
            name = "cclk_enable";
            desc = "Card clock enable Bit 1 and bit 0 indicate the clock enable for eMMC and SDIO respectively. The following takes bit 0 as an example:";
            sw = rw;
            hw = r;
            encode = MMC_CLKENA_cclk_enable_enum;
            reset = 0x0;
`ifdef DWMMC_SINGLE_SLOT_BITS
        } cclk_enable[0:0];
`else
        } cclk_enable[1:0];
`endif
    } MMC_CLKENA @ 0x10;

    reg {
        name = "Timeout register";
        desc = "MMC_TMOUT is a timeout register.

Data sheet 12.4.4 MMC_TMOUT (offset 0x14, printed page 12-92, `Hi3518EV20X-Hi3516CV200-Datasheet.txt` line 82362).";

        field {
            name = "data_timeout";
            desc = "Timeout during the data transfer of the card, in unit of the mmc_clk cycle of the card. The timeout is also the data starvation timeout of the CPU";
            sw = rw;
            hw = r;
            reset = 0x00FFFFFF;
        } data_timeout[31:8];

        field {
            name = "response_timeout";
            desc = "Response timeout, in unit of the mmc_clk cycle of the card.";
            sw = rw;
            hw = r;
            reset = 0x40;
        } response_timeout[7:0];
    } MMC_TMOUT @ 0x14;

    reg {
        name = "Card type register";
        desc = "MMC_CTYPE is a card type register.

DS inconsistency: the field names are swapped against their bit positions (`card_width_0` is bits 17:16 and `card_width_1` is bits 1:0). Vendor header: `CARD_WIDTH_4BIT` = bit 0, `CARD_WIDTH_8BIT` = bit 16 (`CARD_WIDTH_MASK` = 0x10001); the DS text for bits 17:16 says the field must be 0 (non-8-bit mode), which contradicts the 8-bit mode the MMC0 (eMMC) controller supports and the vendor driver uses (`bus-width = <8>` in the device tree). MMC1 has no 8-bit mode.

Data sheet 12.4.4 MMC_CTYPE (offset 0x18, printed page 12-93, `Hi3518EV20X-Hi3516CV200-Datasheet.txt` line 82393).";

`ifndef DWMMC_GEN1
        field {
            name = "card_width_0";
            desc = "Bus width of the card Bit 17 and bit 16 indicate the eMMC bus width and SDIO bus width respectively. The following takes bit 16 as an example: This field must be set to 0 (non 8-bit mode). The bus width of the card is set to 1-bit mode or 4-bit mode, which depends on the value of bit[0]. (Other data sheets: bit 16 = 8-bit mode enable; absent on Hi3511/Hi3515/Hi3520 V100, which have no 8-bit bus.)";
            sw = rw;
            hw = r;
            reset = 0x0;
`ifdef DWMMC_SINGLE_SLOT_BITS
        } card_width_0[16:16];
`else
        } card_width_0[17:16];
`endif
`endif

        enum MMC_CTYPE_card_width_1_enum {
            V_1_BIT_MODE = 0 { name = "V 1 Bit Mode"; desc = "1-bit mode"; };
            V_4_BIT_MODE = 1 { name = "V 4 Bit Mode"; desc = "4-bit mode"; };
        };

        field {
            name = "card_width_1";
            desc = "Bus width of the card Bit 1 and bit 0 indicate the eMMC bus width and SDIO bus width respectively. The following takes bit 0 as an example:";
            sw = rw;
            hw = r;
            encode = MMC_CTYPE_card_width_1_enum;
            reset = 0x0;
`ifdef DWMMC_SINGLE_SLOT_BITS
        } card_width_1[0:0];
`else
        } card_width_1[1:0];
`endif
    } MMC_CTYPE @ 0x18;

    reg {
        name = "Block size configuration register";
        desc = "MMC_BLKSIZ is a block size configuration register.

Data sheet 12.4.4 MMC_BLKSIZ (offset 0x1C, printed page 12-93, `Hi3518EV20X-Hi3516CV200-Datasheet.txt` line 82431).";

        field {
            name = "block_size";
            desc = "Block size. The initial size of each block is 512 bytes.";
            sw = rw;
            hw = r;
            reset = 0x200;
        } block_size[15:0];
    } MMC_BLKSIZ @ 0x1C;

    reg {
        name = "Block transfer count register";
        desc = "MMC_BYTCNT is a block transfer count register.

Data sheet 12.4.4 MMC_BYTCNT (offset 0x20, printed page 12-94, `Hi3518EV20X-Hi3516CV200-Datasheet.txt` line 82460).";

        field {
            name = "Byte_count";
            desc = "Number of transferred bytes. The number must be an integral multiple of the block size. If the data transfer is not block transfer, this register must be set to 0. In this case, the software needs to transmit a stop or an abort command to control the data transfer.";
            sw = rw;
            hw = r;
            reset = 0x200;
        } Byte_count[31:0];
    } MMC_BYTCNT @ 0x20;

    reg {
        name = "Interrupt mask register";
        desc = "MMC_INTMASK is an interrupt mask register.

Interrupt bit meanings (same in MMC_MINTSTS/MMC_RINTSTS): bit 0 card detect, bit 1 response error (RE), 2 command done (CD), 3 data transfer over (DTO), 4 TX FIFO data request (TXDR), 5 RX FIFO data request (RXDR), 6 response CRC error (RCRC), 7 data CRC error (DCRC), 8 response timeout (RTO), 9 data read timeout (DRTO; also boot data start, vendor `BDS_INT_STATUS`), 10 data starvation by host timeout (HTO), 11 FIFO underrun/overrun (FRUN), 12 hardware locked write error (HLE), 13 start-bit error (SBE), 14 auto command done (ACD), 15 end-bit error (EBE); bits 17:16 are the SDIO card interrupt. The vendor header `ALL_INT_MASK` = 0x1FFFE and `ALL_INT_CLR` = 0x1AFFE.

Data sheet 12.4.4 MMC_INTMASK (offset 0x24, printed page 12-94, `Hi3518EV20X-Hi3516CV200-Datasheet.txt` line 82483).";

        enum MMC_INTMASK_sdio_int_mask_enum {
            MASKED = 0 { name = "Masked"; desc = "masked"; };
            ENABLED = 1 { name = "Enabled"; desc = "enabled"; };
        };

        field {
            name = "sdio_int_mask";
            desc = "Interrupt mask control Bit 17 and bit 16 indicate the interrupt mask control for eMMC and SDIO respectively. The following takes bit 16 as an example:";
            sw = rw;
            hw = r;
            encode = MMC_INTMASK_sdio_int_mask_enum;
            reset = 0x0;
`ifdef DWMMC_SINGLE_SLOT_BITS
        } sdio_int_mask[16:16];
`else
        } sdio_int_mask[17:16];
`endif

        enum MMC_INTMASK_int_mask_enum {
            MASKED = 0x0 { name = "Masked"; desc = "masked"; };
            ENABLED_BIT_15 = 0x1 { name = "Enabled Bit 15"; desc = "enabled Bit[15]: end-bit error (read)/write no CRC (EBE) Bit[14]: auto command done (ACD) Bit[13]: start-bit error (SBE) Bit[12]: hardware locked write error (HLE) Bit[11]: FIFO underrun/overrun error (FRUN) Bit[10]: data starvation-by-host timeout (HTO) Bit[9]: data read timeout (DTO) Bit[8]: response timeout (RTO) Bit[7]: data CRC error (DCRC) Bit[6]: response CRC error (RCRC) Bit[5]: RX FIFO data request (RXDR) Bit[4]: TX FIFO data request (TXDR) Bit[3]: data transfer over (DTO) Bit[2]: command done (CD) Bit[1]: response error (RE) Bit[0]: card detect (CD)"; };
        };

        field {
            name = "int_mask";
            desc = "Interrupt mask (bit 0, the card-detect interrupt, is reserved on Hi3511/Hi3515/Hi3520 V100; there the Hi3515 data sheet names the bits ebe/acd/sbe/hle/frun/hto/drto/rto/dcrc/rcrc/rxdr/txdr/dto/cd/re_int_mask in the same positions)";
            sw = rw;
            hw = r;
            encode = MMC_INTMASK_int_mask_enum;
            reset = 0x0;
`ifdef DWMMC_GEN1
        } int_mask[15:1];
`else
        } int_mask[15:0];
`endif
    } MMC_INTMASK @ 0x24;

    reg {
        name = "Command parameter register";
        desc = "MMC_CMDARG is a command parameter register.

Data sheet 12.4.4 MMC_CMDARG (offset 0x28, printed page 12-95, `Hi3518EV20X-Hi3516CV200-Datasheet.txt` line 82543).";

        field {
            name = "cmd_arg";
            desc = "Command parameter that is transferred to the card. The command parameter is related to the protocol, and each command corresponds to a command parameter.";
            sw = rw;
            hw = r;
            reset = 0x0;
        } cmd_arg[31:0];
    } MMC_CMDARG @ 0x28;

    reg {
        name = "Command register";
        desc = "MMC_CMD is a command register.

Vendor flags (`MCI_CMD_MASK` 0x803FFFFF): START_CMD bit 31, USE_HOLD_REG bit 29 (set in every command by the vendor driver; reset value 1 per the DS Total Reset Value, the bit diagram of the DS shows 0 for it), UP_CLK_ONLY bit 21, CARD_NUM bit 16 (card number field is [20:16]), SEND_INIT, WT_PD_CPT, SEND_AUTO_STOP, DATA_EXPECT, CHECK_RESP_CRC, RESP_LENGTH, RESP_EXPECT bits as in the table.

Other chips: use_hold_reg / volt_switch (bits 29:28) exist from the Hi3518E V20X on (Hi3516C V300, Hi3516A V300, Hi3516A V200, Hi3519: reset 0x20000000); the Hi3516C/Hi3518 V100, Hi3516 V100 and Hi3516A/D V100 data sheets call them reserved (register reset 0); the boot bits 27:24 are additionally reserved on Hi3511/Hi3515/Hi3520 V100.

Data sheet 12.4.4 MMC_CMD (offset 0x2C, printed page 12-96, `Hi3518EV20X-Hi3516CV200-Datasheet.txt` line 82569).";

        enum MMC_CMD_start_cmd_enum {
            DO_NOT_START = 0 { name = "Do Not Start"; desc = "do not start"; };
            START_COMMAND_AFTER = 1 { name = "Start Command After"; desc = "start a command After the command is transferred to the card interface unit (CIU), this bit is cleared. The CPU does not allow modifications to this register. Otherwise, an HLE interrupt is generated. After transmitting a command, the CPU queries this bit, and transmits the next command when the value of this bit changes to 0."; };
        };

        field {
            name = "start_cmd";
            desc = "Start control";
            sw = rw;
            hw = w;
            encode = MMC_CMD_start_cmd_enum;
            reset = 0x0;
        } start_cmd[31:31];

`ifndef DWMMC_NO_HOLD_REG
        enum MMC_CMD_use_hold_reg_enum {
            CMD_DATA_SIGNALS = 0 { name = "Cmd Data Signals"; desc = "The CMD and DATA signals transmitted to the MMC do not pass through the hold register."; };
            CMD_DATA_SIGNALS_2 = 1 { name = "Cmd Data Signals 2"; desc = "The CMD and DATA signals transmitted to the MMC pass through the hold register."; };
        };

        field {
            name = "use_hold_reg";
            desc = "Whether to use the hold register";
            sw = rw;
            hw = r;
            encode = MMC_CMD_use_hold_reg_enum;
            reset = 0x1;
        } use_hold_reg[29:29];

        enum MMC_CMD_volt_switch_enum {
            DISABLED = 0 { name = "Disabled"; desc = "disabled"; };
            ENABLED = 1 { name = "Enabled"; desc = "enabled"; };
        };

        field {
            name = "volt_switch";
            desc = "Voltage switching enable";
            sw = rw;
            hw = r;
            encode = MMC_CMD_volt_switch_enum;
            reset = 0x0;
        } volt_switch[28:28];
`endif

`ifndef DWMMC_GEN1
        enum MMC_CMD_boot_mode_enum {
            BOOT_MODE = 0 { name = "Boot Mode"; desc = "boot mode"; };
            ALTERNATIVE_BOOT_MODE = 1 { name = "Alternative Boot Mode"; desc = "alternative boot mode"; };
        };

        field {
            name = "boot_mode";
            desc = "Boot mode";
            sw = rw;
            hw = r;
            encode = MMC_CMD_boot_mode_enum;
            reset = 0x0;
        } boot_mode[27:27];

        field {
            name = "disable_boot";
            desc = "Boot disable If the software enables this bit and the Start_cmd bit at the same time, the controller aborts the boot operation. The Enable_boot and Disable_boot bits cannot be enabled at the same time.";
            sw = rw;
            hw = r;
            reset = 0x0;
        } disable_boot[26:26];

        field {
            name = "expect_boot_ack";
            desc = "Boot response enable If the software enables this bit and the Enable_boot bit at the same time, the controller detects the boot response signal in \"0-1-0\" sequence.";
            sw = rw;
            hw = r;
            reset = 0x0;
        } expect_boot_ack[25:25];

        field {
            name = "enable_boot";
            desc = "Boot enable This bit is available when the boot mode is mandatory. If the software enables this bit and the Start_cmd bit, the controller pulls down the CMD signal to start the boot process. The Enable_boot and Disable_boot bits cannot be enabled at the same time.";
            sw = rw;
            hw = r;
            reset = 0x0;
        } enable_boot[24:24];
`endif

        enum MMC_CMD_update_clock_registers_only_enum {
            NORMAL_COMMAND_SEQUENCE = 0 { name = "Normal Command Sequence"; desc = "The normal command sequence is used. That is, the values of MMC_CMD, MMC_CMDARG, MMC_TMOUT, MMC_CTYPE, MMC_BLKSIZ, and MMC_BYTCNT are transferred from the BIU to the CIU. The CIU uses the new values of registers when running new commands."; };
            NO_COMMAND_TRANSMITTED = 1 { name = "No Command Transmitted"; desc = "No command is transmitted, and only the clock register values in the card clock domain are updated. The values of MMC_CLKDIV, MMC_CLKSRC, and MMC_CLKENA are transferred to the card clock domain. The card clock can be changed (frequency change and clock enable) even no command is transmitted. Each time the card clock is changed; this bit must be set to 1. In this case, no command is transmitted to the card, and no command done interrupt is generated."; };
        };

        field {
            name = "update_clock_registers_only";
            desc = "Automatic update";
            sw = rw;
            hw = r;
            encode = MMC_CMD_update_clock_registers_only_enum;
            reset = 0x0;
        } update_clock_registers_only[21:21];

        field {
            name = "card_number";
            desc = "Serial number of the card that is being used";
            sw = rw;
            hw = r;
            reset = 0x0;
        } card_number[20:16];

        enum MMC_CMD_send_initialization_enum {
            DO_NOT_TRANSMIT = 0 { name = "Do Not Transmit"; desc = "do not transmit the initialization sequence before transmitting the Send_initialization command (high level in 80 clock cycles)"; };
            TRANSMIT_INITIALIZATION_SEQUEN = 1 { name = "Transmit Initialization Sequen"; desc = "transmit the initialization sequence before transmitting the Send_initialization command When a card is powered on, the initialization sequence must be transmitted for initialization before any command is transmitted. That is, this bit must be set to 1."; };
        };

        field {
            name = "send_initialization";
            desc = "Whether to transmit the initialization sequence";
            sw = rw;
            hw = r;
            encode = MMC_CMD_send_initialization_enum;
            reset = 0x0;
        } send_initialization[15:15];

        enum MMC_CMD_stop_abort_cmd_enum {
            DO_NOT_TRANSMIT = 0 { name = "Do Not Transmit"; desc = "do not transmit the stop/abort command"; };
            TRANSMIT_STOP_ABORT = 1 { name = "Transmit Stop Abort"; desc = "transmit the stop/abort command for stopping the current data transfer"; };
        };

        field {
            name = "stop_abort_cmd";
            desc = "Whether to transmit the stop/abort command when data is being transferred in open-ended mode or in fixed length mode.";
            sw = rw;
            hw = r;
            encode = MMC_CMD_stop_abort_cmd_enum;
            reset = 0x0;
        } stop_abort_cmd[14:14];

        enum MMC_CMD_wait_prvdata_complete_enum {
            TRANSMIT_COMMAND_IMMEDIATELY = 0 { name = "Transmit Command Immediately"; desc = "transmit a command immediately even though the previous data transfer is not complete"; };
            TRANSMIT_COMMAND_ONLY = 1 { name = "Transmit Command Only"; desc = "transmit a command only when the previous data transfer is complete The typical value is 0. If this bit is set to 0, the transfer status can be read during data transfer, and the interrupt transfer is supported."; };
        };

        field {
            name = "wait_prvdata_complete";
            desc = "Whether to transmit a command immediately";
            sw = rw;
            hw = r;
            encode = MMC_CMD_wait_prvdata_complete_enum;
            reset = 0x0;
        } wait_prvdata_complete[13:13];

        enum MMC_CMD_send_auto_stop_enum {
            DO_NOT_TRANSMIT = 0 { name = "Do Not Transmit"; desc = "do not transmit the stop command after data transfer"; };
            TRANSMIT_STOP_COMMAND = 1 { name = "Transmit Stop Command"; desc = "transmit the stop command after data transfer In non-data transfer mode, this bit is ignored."; };
        };

        field {
            name = "send_auto_stop";
            desc = "Whether to transmit the stop command";
            sw = rw;
            hw = r;
            encode = MMC_CMD_send_auto_stop_enum;
            reset = 0x0;
        } send_auto_stop[12:12];

        enum MMC_CMD_transfer_mode_enum {
            BLOCK_TRANSFER_MODE = 0 { name = "Block Transfer Mode"; desc = "block transfer mode"; };
            STREAM_TRANSFER_MODE = 1 { name = "Stream Transfer Mode"; desc = "stream transfer mode In non-data transfer mode, this bit is ignored."; };
        };

        field {
            name = "transfer_mode";
            desc = "Transfer mode";
            sw = rw;
            hw = r;
            encode = MMC_CMD_transfer_mode_enum;
            reset = 0x0;
        } transfer_mode[11:11];

        enum MMC_CMD_read_write_enum {
            READ_DATA_FROM = 0 { name = "Read Data From"; desc = "read data from the card"; };
            WRITE_DATA_CARD = 1 { name = "Write Data Card"; desc = "write data to the card In non-data transfer mode, this bit is ignored."; };
        };

        field {
            name = "read_write";
            desc = "Read/write control";
            sw = rw;
            hw = r;
            encode = MMC_CMD_read_write_enum;
            reset = 0x0;
        } read_write[10:10];

        enum MMC_CMD_data_transfer_expected_enum {
            NO_DATA_OUTPUT = 0 { name = "No Data Output"; desc = "No data is output from the card."; };
            DATA_OUTPUT_FROM = 1 { name = "Data Output From"; desc = "Data is output from the card."; };
        };

        field {
            name = "data_transfer_expected";
            desc = "Data transfer indicator";
            sw = rw;
            hw = r;
            encode = MMC_CMD_data_transfer_expected_enum;
            reset = 0x0;
        } data_transfer_expected[9:9];

        enum MMC_CMD_check_response_crc_enum {
            DO_NOT_CHECK = 0 { name = "Do Not Check"; desc = "Do not check the CRC response."; };
            CHECK_CRC_RESPONSE = 1 { name = "Check Crc Response"; desc = "Check the CRC response. No valid CRC is returned when some commands are responded. To prevent the host from performing CRC, the software needs to disable this function based on related commands."; };
        };

        field {
            name = "check_response_crc_";
            desc = "Whether to perform the CRC check";
            sw = rw;
            hw = r;
            encode = MMC_CMD_check_response_crc_enum;
            reset = 0x0;
        } check_response_crc[8:8];

        enum MMC_CMD_response_length_enum {
            SHORT_RESPONSES_OUTPUT = 0 { name = "Short Responses Output"; desc = "Short responses are output from the card"; };
            LONG_RESPONSES_OUTPUT = 1 { name = "Long Responses Output"; desc = "Long responses are output from the card The length of a long response is 128 bits, whereas the length of a short response is 32 bits."; };
        };

        field {
            name = "response_length";
            desc = "Response length";
            sw = rw;
            hw = r;
            encode = MMC_CMD_response_length_enum;
            reset = 0x0;
        } response_length[7:7];

        enum MMC_CMD_response_expect_enum {
            NO_RESPONSE_OUTPUT = 0 { name = "No Response Output"; desc = "No response is output from the card."; };
            RESPONSES_OUTPUT_FROM = 1 { name = "Responses Output From"; desc = "Responses are output from the card."; };
        };

        field {
            name = "response_expect";
            desc = "Whether to output response";
            sw = rw;
            hw = r;
            encode = MMC_CMD_response_expect_enum;
            reset = 0x0;
        } response_expect[6:6];

        field {
            name = "cmd_index";
            desc = "Command index";
            sw = rw;
            hw = r;
            reset = 0x0;
        } cmd_index[5:0];
    } MMC_CMD @ 0x2C;

    reg {
        name = "Response register 0";
        desc = "MMC_RESP0 is response register 0.

Data sheet 12.4.4 MMC_RESP0 (offset 0x30, printed page 12-99, `Hi3518EV20X-Hi3516CV200-Datasheet.txt` line 82738).";

        field {
            name = "response0";
            desc = "Bit[31:0] of a response";
            sw = r;
            hw = w;
            reset = 0x0;
        } response0[31:0];
    } MMC_RESP0 @ 0x30;

    reg {
        name = "Response register 1";
        desc = "MMC_RESP1 is response register 1.

Data sheet 12.4.4 MMC_RESP1 (offset 0x34, printed page 12-99, `Hi3518EV20X-Hi3516CV200-Datasheet.txt` line 82757).";

        field {
            name = "response1";
            desc = "Bit[63:32] of a long response After the CIU transmits an auto-stop command, the corresponding response is stored in this register, and the response to the previous command is still stored in MMC_RESP0. The auto-stop command is available only during data transfer, and the corresponding response is always a short response.";
            sw = r;
            hw = w;
            reset = 0x0;
        } response1[31:0];
    } MMC_RESP1 @ 0x34;

    reg {
        name = "Response register 2";
        desc = "MMC_RESP2 is response register 2.

Data sheet 12.4.4 MMC_RESP2 (offset 0x38, printed page 12-99, `Hi3518EV20X-Hi3516CV200-Datasheet.txt` line 82782).";

        field {
            name = "response2";
            desc = "Bit[95:64] of a long response";
            sw = r;
            hw = w;
            reset = 0x0;
        } response2[31:0];
    } MMC_RESP2 @ 0x38;

    reg {
        name = "Response register 3";
        desc = "MMC_RESP3 is response register 3.

Data sheet 12.4.4 MMC_RESP3 (offset 0x3C, printed page 12-100, `Hi3518EV20X-Hi3516CV200-Datasheet.txt` line 82810).";

        field {
            name = "response3";
            desc = "Bit[127:96] of a long response";
            sw = r;
            hw = w;
            reset = 0x0;
        } response3[31:0];
    } MMC_RESP3 @ 0x3C;

    reg {
        name = "Masked interrupt status register";
        desc = "MMC_MINTSTS is a masked interrupt status register.

Data sheet 12.4.4 MMC_MINTSTS (offset 0x40, printed page 12-100, `Hi3518EV20X-Hi3516CV200-Datasheet.txt` line 82829).";

        enum MMC_MINTSTS_sdio_interrupt_enum {
            NO_SDIO_INTERRUPT = 0 { name = "No Sdio Interrupt"; desc = "No SDIO interrupt is output from the card."; };
            SDIO_INTERRUPT_OUTPUT = 1 { name = "Sdio Interrupt Output"; desc = "An SDIO interrupt is output from the card."; };
        };

        field {
            name = "sdio_interrupt";
            desc = "Interrupt mask status The SDIO interrupt is valid only when MMC_INTMASK [sdio_int_mask] is enabled. Bit 17 and bit 16 indicate the interrupt mask control for eMMC and SDIO respectively. The following takes bit 16 as an example:";
            sw = r;
            hw = w;
            encode = MMC_MINTSTS_sdio_interrupt_enum;
            reset = 0x0;
`ifdef DWMMC_SINGLE_SLOT_BITS
        } sdio_interrupt[16:16];
`else
        } sdio_interrupt[17:16];
`endif

        field {
            name = "int_status";
            desc = "Status of each interrupt Bit[15]: end-bit error (read)/write no CRC (EBE) Bit[14]: auto command done (ACD) Bit[13]: start-bit error (SBE) Bit[12]: hardware locked write error (HLE) Bit[11]: FIFO underrun/overrun error (FRUN) Bit[10]: data starvation by the host timeout (HTO) Bit[9]: data read timeout (DTO) Bit[8]: response timeout (RTO) Bit[7]: data CRC error (DCRC) Bit[6]: response CRC error (RCRC) Bit[5]: RX FIFO data request (RXDR) Bit[4]: TX FIFO data request (TXDR) Bit[3]: data transfer over (DTO) Bit[2]: command done (CD) Bit[1]: response error (RE) Bit[0]: card detect (CD)";
            sw = r;
            hw = w;
            reset = 0x0;
`ifdef DWMMC_GEN1
        } int_status[15:1];
`else
        } int_status[15:0];
`endif
    } MMC_MINTSTS @ 0x40;

    reg {
        name = "Raw interrupt status register";
        desc = "MMC_RINTSTS is a raw interrupt status register.

Data sheet 12.4.4 MMC_RINTSTS (offset 0x44, printed page 12-101, `Hi3518EV20X-Hi3516CV200-Datasheet.txt` line 82889).";

        enum MMC_RINTSTS_sdio_interrupt_enum {
            NO_SDIO_INTERRUPT = 0 { name = "No Sdio Interrupt"; desc = "No SDIO interrupt is output from the card."; };
            SDIO_INTERRUPT_OUTPUT = 1 { name = "Sdio Interrupt Output"; desc = "An SDIO interrupt is output from the card. The value of the interrupt status bit is independent of the interrupt mask status."; };
        };

        field {
            name = "sdio_interrupt";
            desc = "Raw status of an interrupt Bit 17 and bit 16 control the eMMC interrupts and SDIO interrupts respectively. The following takes bit 16 as an example:";
            sw = rw;
            hw = w;
            onwrite = woclr;
            encode = MMC_RINTSTS_sdio_interrupt_enum;
            reset = 0x0;
`ifdef DWMMC_SINGLE_SLOT_BITS
        } sdio_interrupt[16:16];
`else
        } sdio_interrupt[17:16];
`endif

        field {
            name = "int_status";
            desc = "Raw status of each interrupt. Writing 1 clears the bits, and writing 0 has no effect. The value of the interrupt status bit is independent of the interrupt mask status. Bit[15]: end-bit error (read)/write no CRC (EBE) Bit[14]: auto command done (ACD) Bit[13]: start-bit error (SBE) Bit[12]: hardware locked write error (HLE) Bit[11]: FIFO underrun/overrun error (FRUN) Bit[10]: data starvation by the host timeout (HTO) Bit[9]: data read timeout (DRTO)/Boot Data Start (BDS) Bit[8]: response timeout (RTO)/Boot Ack Received (BAR) Bit[7]: data CRC error (DCRC) Bit[6]: response CRC error (RCRC) Bit[5]: RX FIFO data request (RXDR) Bit[4]: TX FIFO data request (TXDR) Bit[3]: data transfer over (DTO) Bit[2]: command done (CD) Bit[1]: response error (RE) Bit[0]: card detect (CD)";
            sw = rw;
            hw = w;
            onwrite = woclr;
            reset = 0x0;
`ifdef DWMMC_GEN1
        } int_status[15:1];
`else
        } int_status[15:0];
`endif
    } MMC_RINTSTS @ 0x44;

    reg {
        name = "Status register";
        desc = "MMC_STATUS is a status register.

FIFO_COUNT lives in bits 29:17 (vendor `FIFO_COUNT_MASK` 0x1FFF, shift 17). Reset 0x106 = data_3_status (card present) 1, fifo_empty 1, fifo_tx_watermark 1.

Other chips: Hi3511/Hi3515/Hi3520 V100 add the external-DMAC handshake bits dma_req [31] and dma_ack [30] and print the total reset as 0 (the FIFO-empty/TX-watermark bits are nevertheless 1 after reset in every dw_mmc). The Hi3516C V300 / Hi3516A V300 / Hi3516A V200 / Hi3519 data sheets call bit 8 data_3_status reserved (reset still 0x106).

Data sheet 12.4.4 MMC_STATUS (offset 0x48, printed page 12-102, `Hi3518EV20X-Hi3516CV200-Datasheet.txt` line 82951).";

`ifdef DWMMC_GEN1
        field {
            name = "dma_req";
            desc = "DMA request status (external DMAC handshake): 0 = the controller is not requesting a DMA transfer, 1 = the controller is requesting a DMA transfer.";
            sw = r;
            hw = w;
            reset = 0x0;
        } dma_req[31:31];

        field {
            name = "dma_ack";
            desc = "DMA acknowledge status: 0 = the DMAC has not cleared the request, 1 = the DMAC has cleared the request.";
            sw = r;
            hw = w;
            reset = 0x0;
        } dma_ack[30:30];
`endif

        field {
            name = "fifo_count";
            desc = "FIFO count";
            sw = r;
            hw = w;
            reset = 0x0;
        } fifo_count[29:17];

        field {
            name = "response_index";
            desc = "Serial number of the previous response, including the response to the auto-stop command";
            sw = r;
            hw = w;
            reset = 0x0;
        } response_index[16:11];

        enum MMC_STATUS_data_state_mc_busy_enum {
            DATA_TX_RX = 0 { name = "Data Tx Rx"; desc = "The data TX/RX state machine is idle."; };
            DATA_TX_RX_2 = 1 { name = "Data Tx Rx 2"; desc = "The data TX/RX state machine is busy."; };
        };

        field {
            name = "data_state_mc_busy";
            desc = "data_state_mc_busy";
            sw = r;
            hw = w;
            encode = MMC_STATUS_data_state_mc_busy_enum;
            reset = 0x0;
        } data_state_mc_busy[10:10];

        enum MMC_STATUS_data_busy_enum {
            IDLE = 0 { name = "Idle"; desc = "idle (DATA0 is high level)"; };
            BUSY = 1 { name = "Busy"; desc = "busy (DATA0 is low level)"; };
        };

        field {
            name = "data_busy";
            desc = "This field value depends on the reverse level of DATA0.";
            sw = r;
            hw = w;
            encode = MMC_STATUS_data_busy_enum;
            reset = 0x0;
        } data_busy[9:9];

        enum MMC_STATUS_data_3_status_enum {
            NO_CARD_INSERTED = 0 { name = "No Card Inserted"; desc = "No card is inserted (DATA3 is low level)."; };
            CARD_INSERTED = 1 { name = "Card Inserted"; desc = "A card is inserted (DATA3 is high level)."; };
        };

        field {
            name = "data_3_status";
            desc = "Card detection signal. This field value depends on the level of DATA3.";
            sw = r;
            hw = w;
            encode = MMC_STATUS_data_3_status_enum;
            reset = 0x1;
        } data_3_status[8:8];

        enum MMC_STATUS_commandfsm_states_enum {
            IDLE = 0 { name = "Idle"; desc = "idle"; };
            SEND_INIT_SEQUENCE = 1 { name = "Send Init Sequence"; desc = "send init sequence"; };
            TX_CMD_START = 2 { name = "Tx Cmd Start"; desc = "Tx cmd start bit"; };
            TX_CMD_TX = 3 { name = "Tx Cmd Tx"; desc = "Tx cmd tx bit"; };
            TX_CMD_INDEX = 4 { name = "Tx Cmd Index"; desc = "Tx cmd index + arg"; };
            TX_CMD_CRC7 = 5 { name = "Tx Cmd Crc7"; desc = "Tx cmd crc7"; };
            TX_CMD_END = 6 { name = "Tx Cmd End"; desc = "Tx cmd end bit"; };
            RX_RESP_START = 7 { name = "Rx Resp Start"; desc = "Rx resp start bit"; };
            RX_RESP_IRQ = 8 { name = "Rx Resp Irq"; desc = "Rx resp IRQ response"; };
            RX_RESP_TX = 9 { name = "Rx Resp Tx"; desc = "Rx resp tx bit"; };
            RX_RESP_CMD = 10 { name = "Rx Resp Cmd"; desc = "Rx resp cmd idx"; };
            RX_RESP_DATA = 11 { name = "Rx Resp Data"; desc = "Rx resp data"; };
            RX_RESP_CRC7 = 12 { name = "Rx Resp Crc7"; desc = "Rx resp crc7"; };
            RX_RESP_END = 13 { name = "Rx Resp End"; desc = "Rx resp end bit"; };
            CMD_PATH_WAIT = 14 { name = "Cmd Path Wait"; desc = "Cmd path wait NCC"; };
            WAIT_CMD_RESPONSE = 15 { name = "Wait Cmd Response"; desc = "wait, CMD-to-response turnaround"; };
        };

        field {
            name = "commandfsm_states";
            desc = "Status of the command state machine";
            sw = r;
            hw = w;
            encode = MMC_STATUS_commandfsm_states_enum;
            reset = 0x0;
        } commandfsm_states[7:4];

        enum MMC_STATUS_fifo_full_enum {
            EMPTY = 0 { name = "Empty"; desc = "empty"; };
            FULL = 1 { name = "Full"; desc = "full"; };
        };

        field {
            name = "fifo_full";
            desc = "FIFO full flag";
            sw = r;
            hw = w;
            encode = MMC_STATUS_fifo_full_enum;
            reset = 0x0;
        } fifo_full[3:3];

        enum MMC_STATUS_fifo_empty_enum {
            NOT_EMPTY = 0 { name = "Not Empty"; desc = "not empty"; };
            EMPTY = 1 { name = "Empty"; desc = "empty"; };
        };

        field {
            name = "fifo_empty";
            desc = "FIFO empty flag";
            sw = r;
            hw = w;
            encode = MMC_STATUS_fifo_empty_enum;
            reset = 0x1;
        } fifo_empty[2:2];

        enum MMC_STATUS_fifo_tx_watermark_enum {
            NO = 0 { name = "No"; desc = "no"; };
            YES = 1 { name = "Yes"; desc = "yes"; };
        };

        field {
            name = "fifo_tx_watermark";
            desc = "Whether the FIFO reaches the TX threshold";
            sw = r;
            hw = w;
            encode = MMC_STATUS_fifo_tx_watermark_enum;
            reset = 0x1;
        } fifo_tx_watermark[1:1];

        enum MMC_STATUS_fifo_rx_watermark_enum {
            NO = 0 { name = "No"; desc = "no"; };
            YES = 1 { name = "Yes"; desc = "yes"; };
        };

        field {
            name = "fifo_rx_watermark";
            desc = "Whether the FIFO reaches the RX threshold";
            sw = r;
            hw = w;
            encode = MMC_STATUS_fifo_rx_watermark_enum;
            reset = 0x0;
        } fifo_rx_watermark[0:0];
    } MMC_STATUS @ 0x48;

    reg {
        name = "FIFO threshold register";
        desc = "MMC_FIFOTH is a FIFO threshold register.

The DS Total Reset Value is 0x60FF0000 (Multiple_Transaction_Size 6 = 128-transfer burst, rx_wmark 0xFF, tx_wmark 0); the bit diagram of the DS shows 0 for the burst field, the header value is used. The vendor driver programs burst 8 (`BURST_SIZE` = 0x2 << 28 -> 8 transfers), rx_wmark 7 and tx_wmark 8 (`RX_WMARK`, `TX_WMARK`).

Other chips: reset 0x00FF0000 on Hi3516C/Hi3518 V100, Hi3516 V100 (bits 30:28 reserved there) and Hi3516A V300 (DWMMC_FIFOTH_MSIZE0); reset 0 with the burst field named burst_size on Hi3511/Hi3515/Hi3520 V100 (same encoding, 1/4/8/16/32/64/128/256 words per external-DMAC burst).

Data sheet 12.4.4 MMC_FIFOTH (offset 0x4C, printed page 12-104, `Hi3518EV20X-Hi3516CV200-Datasheet.txt` line 83041).";

        enum MMC_FIFOTH_Multiple_Transaction_Size_enum {
            V_1 = 0 { name = "V 1"; desc = "1"; };
            V_4 = 1 { name = "V 4"; desc = "4"; };
            V_8 = 2 { name = "V 8"; desc = "8"; };
            V_16 = 3 { name = "V 16"; desc = "16"; };
            V_32 = 4 { name = "V 32"; desc = "32"; };
            V_64 = 5 { name = "V 64"; desc = "64"; };
            V_128 = 6 { name = "V 128"; desc = "128"; };
            V_256 = 7 { name = "V 256"; desc = "256"; };
        };

        field {
            name = "Multiple_Transaction_Size";
            desc = "Transferred burst length";
            sw = rw;
            hw = r;
            encode = MMC_FIFOTH_Multiple_Transaction_Size_enum;
`ifdef DWMMC_FIFOTH_MSIZE0
            reset = 0x0;
`else
            reset = 0x6;
`endif
        } Multiple_Transaction_Size[30:28];

        field {
            name = "rx_wmark";
            desc = "FIFO threshold during data read. If the data amount in the FIFO is above the threshold, a DMA request is enabled. After a data transfer, a DMA request is raised for transferring the remaining data no matter whether the threshold is reached. In non-DMA mode, the RXDR interrupt is enabled. If the data amount in the FIFO is not above the threshold after a data transfer, no interrupt is generated. In this case, the software needs to read the remaining data by querying the DTD interrupt. If a data transfer is complete in DMA mode, the DMA raises a single transfer request to read data until the DTD interrupt is generated even though the remaining data amount is below the threshold. Restriction: RX_WMark <= FIFO_DEPTH - 2 Recommendation: A request is raised when the value of [(FIFO_DEPTH/2) - 1] is above the threshold.";
            sw = rw;
            hw = r;
`ifdef DWMMC_GEN1
            reset = 0x0;
`else
            reset = 0xFF;
`endif
        } rx_wmark[27:16];

        field {
            name = "tx_wmark";
            desc = "FIFO threshold during data transmission. If the data amount in the FIFO is below the threshold, a DMA request is enabled. After a data transfer, a DMA request is raised for transferring the remaining data no matter whether the threshold is reached. In non-DMA mode, the RXDR interrupt is enabled. If the data amount in the FIFO is not above the threshold after a data transfer, no interrupt is generated. In this case, the software needs to read the remaining data by querying the DTD interrupt. If a data transfer is complete in DMA mode, the DMA raises a single transfer request to read data until the DTD interrupt is generated even though the remaining data amount is below the threshold. Restriction: TX_WMark <= FIFO_DEPTH - 2 Recommendation: This field must be less than or equal to FIFO_DEPTH/2.";
            sw = rw;
            hw = r;
            reset = 0x0;
        } tx_wmark[11:0];
    } MMC_FIFOTH @ 0x4C;

`ifdef DWMMC_GEN1
`ifdef DWMMC_CARDSTATUS
    reg {
        name = "Card detection status register";
        desc = "MMC_CARDSTATUS is the card detection status register (Hi3515 data sheet 8.7, offset 0x050, reset 0x1). The same bit as MMC_CDETECT[card_detect_n] of the later generations; the Hi3511 and Hi3520 V100 data sheets list 0x50 as reserved.";

        field {
            name = "card_detctor";
            desc = "Card detection status of the MMC interface (data sheet spelling): 0 = a card is inserted, 1 = no card is inserted.";
            sw = r;
            hw = w;
            reset = 0x1;
        } card_detctor[0:0];
    } MMC_CARDSTATUS @ 0x50;
`endif
`else
    reg {
        name = "Card detection register";
        desc = "MMC_CDETECT is a card detection register.

Reset: 1 (no card) in the Hi3518E V20X, Hi3516A/D V100, Hi3516C V300, Hi3516A V300, Hi3516A V200 and Hi3519 data sheets; the Hi3516C/Hi3518 V100 and Hi3516 V100 data sheets print 0 (DWMMC_CDETECT_RESET0).

Data sheet 12.4.4 MMC_CDETECT (offset 0x50, printed page 12-105, `Hi3518EV20X-Hi3516CV200-Datasheet.txt` line 83117).";

        field {
            name = "card_detect_n";
            desc = "Card detection signal The value depends on the SDIO_CARD_DETECT pin.";
            sw = r;
            hw = w;
`ifdef DWMMC_CDETECT_RESET0
            reset = 0x0;
`else
            reset = 0x1;
`endif
        } card_detect_n[0:0];
    } MMC_CDETECT @ 0x50;
`endif

`ifndef DWMMC_NO_WRTPRT
    reg {
        name = "Card write protection register";
        desc = "MMC_WRTPRT is a card write protection register.

Data sheet 12.4.4 MMC_WRTPRT (offset 0x54, printed page 12-106, `Hi3518EV20X-Hi3516CV200-Datasheet.txt` line 83155).";

        field {
            name = "write_protect";
            desc = "Card write protection signal The value depends on the SDIO_CWPR pin.";
            sw = r;
            hw = w;
            reset = 0x0;
        } write_protect[0:0];
    } MMC_WRTPRT @ 0x54;
`endif

    reg {
        name = "Count of bytes transmitted to the card register";
        desc = "MMC_TCBCNT is a count of bytes transmitted to the card register.

Data sheet 12.4.4 MMC_TCBCNT (offset 0x5C, printed page 12-106, `Hi3518EV20X-Hi3516CV200-Datasheet.txt` line 83184).";

        field {
            name = "trans_card_byte_count";
            desc = "Count of bytes transmitted from the CIU to the card When this register is accessed through a 32-bit AHB, the 32-bit data needs to be read at a time. This avoids the read-coherency error.";
            sw = r;
            hw = w;
            reset = 0x0;
        } trans_card_byte_count[31:0];
    } MMC_TCBCNT @ 0x5C;

    reg {
        name = "Count of bytes transmitted from the bus interface unit (BIU) FIFO register";
        desc = "MMC_TBBCNT is a count of bytes transmitted from the BIU FIFO register.

Data sheet 12.4.4 MMC_TBBCNT (offset 0x60, printed page 12-106, `Hi3518EV20X-Hi3516CV200-Datasheet.txt` line 83206).";

        field {
            name = "trans_fifo_byte_count";
            desc = "Count of bytes transferred between the CPU/DMA and BIU FIFO When this register is accessed through a 32-bit AHB, the 32-bit data needs to be read at a time. This avoids the read-coherency error.";
            sw = r;
            hw = w;
            reset = 0x0;
        } trans_fifo_byte_count[31:0];
    } MMC_TBBCNT @ 0x60;

`ifndef DWMMC_FIFO_0x100
    reg {
        name = "Dejitter count register";
        desc = "MMC_DEBNCE is a dejitter count register.

Data sheet 12.4.4 MMC_DEBNCE (offset 0x64, printed page 12-107, `Hi3518EV20X-Hi3516CV200-Datasheet.txt` line 83238).";

        field {
            name = "debounce_count";
            desc = "Number of bus clock cycles used by the dejitter filter logic. Generally, the dejitter duration ranges from 5 ms to 25 ms.";
            sw = rw;
            hw = r;
            reset = 0x00FFFFFF;
        } debounce_count[23:0];
    } MMC_DEBNCE @ 0x64;

    reg {
        name = "UHS-1 register";
        desc = "MMC_UHS_REG is a UHS-1 register.

Bit 0 selects 1.8 V signalling for the pins of this controller, bit 16 DDR mode.

Data sheet 12.4.4 MMC_UHS_REG (offset 0x74, printed page 12-107, `Hi3518EV20X-Hi3516CV200-Datasheet.txt` line 83260).";

        enum MMC_UHS_REG_ddr_reg_enum {
            NON_DDR_MODE = 0 { name = "Non Ddr Mode"; desc = "non-DDR mode"; };
            DDR_MODE = 1 { name = "Ddr Mode"; desc = "DDR mode"; };
        };

        field {
            name = "ddr_reg";
            desc = "DDR mode control Bit 17 and bit 16 control the DDR modes of eMMC and SDIO respectively. The following takes bit 16 as an example:";
            sw = rw;
            hw = r;
            encode = MMC_UHS_REG_ddr_reg_enum;
            reset = 0x0;
`ifdef DWMMC_SINGLE_SLOT_BITS
        } ddr_reg[16:16];
`else
        } ddr_reg[17:16];
`endif

        enum MMC_UHS_REG_volt_reg_enum {
            V_3_3_V = 0 { name = "V 3 3 V"; desc = "3.3 V"; };
            V_1_8_V = 1 { name = "V 1 8 V"; desc = "1.8 V"; };
        };

        field {
            name = "volt_reg";
            desc = "Voltage mode control Bit 1 and bit 0 control the voltage modes of eMMC and SDIO respectively. The following takes bit 0 as an example:";
            sw = rw;
            hw = r;
            encode = MMC_UHS_REG_volt_reg_enum;
            reset = 0x0;
`ifdef DWMMC_SINGLE_SLOT_BITS
        } volt_reg[0:0];
`else
        } volt_reg[1:0];
`endif
    } MMC_UHS_REG @ 0x74;
`endif

`ifndef DWMMC_NO_CARD_RSTN
    reg {
        name = "EMMC reset control register";
        desc = "MMC_CARD_RSTN is an eMMC reset control register.

Data sheet 12.4.4 MMC_CARD_RSTN (offset 0x78, printed page 12-108, `Hi3518EV20X-Hi3516CV200-Datasheet.txt` line 83304).";

        enum MMC_CARD_RSTN_card_reset_enum {
            RESET_F = 0 { name = "Reset F"; desc = "reset"; };
            DEASSERT_RESET = 1 { name = "Deassert Reset"; desc = "deassert reset"; };
        };

`ifdef DWMMC_SINGLE_SLOT_BITS
        field {
            name = "card_reset";
            desc = "eMMC hardware reset (RST_n pin CARD_RESET): 0 = reset asserted, 1 = reset deasserted. Reset value 1 (Hi3516C V300, Hi3516A V300, Hi3516A V200, Hi3519 data sheets: bit 0).";
            sw = rw;
            hw = r;
            encode = MMC_CARD_RSTN_card_reset_enum;
            reset = 0x1;
        } card_reset[0:0];
`else
        field {
            name = "card_reset";
            desc = "eMMC reset. The control pin is CARD_RESET.";
            sw = rw;
            hw = r;
            encode = MMC_CARD_RSTN_card_reset_enum;
            reset = 0x0;
        } card_reset[1:1];

        field {
            name = "card_reset_slot0";
            desc = "Not in the data sheet (listed there as a reserved RW bit); the data sheet's Total Reset Value 0x1 has bit 0 set. Standard DesignWare-MMC RST_n bit for card 0: 0 = hardware reset asserted, 1 = reset deasserted (the vendor header names the register `MCI_RESET_N`).";
            sw = rw;
            hw = r;
            reset = 0x1;
        } card_reset_slot0[0:0];
`endif
    } MMC_CARD_RSTN @ 0x78;
`endif

`ifndef DWMMC_GEN1
    reg {
        name = "Bus mode register";
        desc = "MMC_BMOD is a bus mode register.

Vendor values: `BMOD_SWR` bit 0, `BURST_INCR` bit 1, `BMOD_DMA_EN` bit 7, `BURST_8` = pbl 2, `BURST_16` = pbl 3. Descriptor flags in memory (`DMA_DES_OWN` bit 31, NEXT_DES bit 4, FIRST_DES bit 3, LAST_DES bit 2) are memory structures, not registers.

Data sheet 12.4.4 MMC_BMOD (offset 0x80, printed page 12-108, `Hi3518EV20X-Hi3516CV200-Datasheet.txt` line 83333).";

        enum MMC_BMOD_pbl_enum {
            V_1 = 0 { name = "V 1"; desc = "1"; };
            V_4 = 1 { name = "V 4"; desc = "4"; };
            V_8 = 2 { name = "V 8"; desc = "8"; };
            V_16 = 3 { name = "V 16"; desc = "16"; };
            V_32 = 4 { name = "V 32"; desc = "32"; };
            V_64 = 5 { name = "V 64"; desc = "64"; };
            V_128 = 6 { name = "V 128"; desc = "128"; };
            V_256 = 7 { name = "V 256"; desc = "256"; };
        };

        field {
            name = "pbl";
            desc = "Length of the IDMAC burst transfer";
            sw = rw;
            hw = r;
            encode = MMC_BMOD_pbl_enum;
            reset = 0x0;
        } pbl[10:8];

        enum MMC_BMOD_de_enum {
            DISABLED = 0 { name = "Disabled"; desc = "disabled"; };
            ENABLED = 1 { name = "Enabled"; desc = "enabled"; };
        };

        field {
            name = "de";
            desc = "IDMAC enable";
            sw = rw;
            hw = r;
            encode = MMC_BMOD_de_enum;
            reset = 0x0;
        } de[7:7];

        field {
            name = "dsl";
            desc = "Span between two descriptors, that is, number of words between two non-linked descriptors. This bit is valid only for the dual-buffer descriptor.";
            sw = rw;
            hw = r;
            reset = 0x0;
        } dsl[6:2];

        enum MMC_BMOD_fb_enum {
            SINGLE_INCR_BURST = 0 { name = "Single Incr Burst"; desc = "single and INCR burst types"; };
            SINGLE_INCR4_INCR8 = 1 { name = "Single Incr4 Incr8"; desc = "single, INCR4, INCR8, and INCR16 burst types"; };
        };

        field {
            name = "fb";
            desc = "Fixed burst length type";
            sw = rw;
            hw = r;
            encode = MMC_BMOD_fb_enum;
            reset = 0x0;
        } fb[1:1];

        enum MMC_BMOD_swr_enum {
            NOT_RESET = 0 { name = "Not Reset"; desc = "not reset"; };
            RESET_AFTER_RESET = 1 { name = "Reset After Reset"; desc = "reset After reset, this bit is automatically cleared one clock cycle later."; };
        };

        field {
            name = "swr";
            desc = "Soft reset control for the internal register of the IDMAC";
            sw = rw;
            hw = w;
            encode = MMC_BMOD_swr_enum;
            reset = 0x0;
        } swr[0:0];
    } MMC_BMOD @ 0x80;

    reg {
        name = "Poll demand register";
        desc = "MMC_PLDMND is a poll demand register.

Data sheet 12.4.4 MMC_PLDMND (offset 0x84, printed page 12-109, `Hi3518EV20X-Hi3516CV200-Datasheet.txt` line 83385).";

        field {
            name = "pd";
            desc = "If DES0[OWN] is 0, the IDMAC enters the suspend state. The";
            sw = w;
            hw = r;
            reset = 0x0;
        } pd[31:0];
    } MMC_PLDMND @ 0x84;

    reg {
        name = "Base address register of the descriptor linked list";
        desc = "MMC_DBADDR is a base address register of the descriptor linked list.

Data sheet 12.4.4 MMC_DBADDR (offset 0x88, printed page 12-110, `Hi3518EV20X-Hi3516CV200-Datasheet.txt` line 83414).";

        field {
            name = "sdl";
            desc = "Start address of the descriptor linked list, that is, the base address of the first descriptor";
            sw = rw;
            hw = r;
            reset = 0x0;
        } sdl[31:0];
    } MMC_DBADDR @ 0x88;

    reg {
        name = "IDMAC status register";
        desc = "MMC_IDSTS is an IDMAC status register.

Data sheet 12.4.4 MMC_IDSTS (offset 0x8C, printed page 12-110, `Hi3518EV20X-Hi3516CV200-Datasheet.txt` line 83435). Bits 29:17 (DWMMC_ADMA3) are the ADMA3 command-queue status of the Hi3516A V200 / Hi3519 V101 (data sheet 12.5, MMC_IDSTS).";

`ifdef DWMMC_ADMA3
        field { name = "cmd_lock_err"; desc = "Command conflict: 1 = command conflicts occurred. Write 1 to clear."; sw = rw; hw = w; onwrite = woclr; reset = 0x0; } cmd_lock_err[29:29];
        field { name = "ids_ownbit_err"; desc = "Integrated-descriptor own-bit error. Write 1 to clear."; sw = rw; hw = w; onwrite = woclr; reset = 0x0; } ids_ownbit_err[28:28];
        field { name = "ids_queue_overflow"; desc = "Integrated-descriptor queue overflow. Write 1 to clear."; sw = rw; hw = w; onwrite = woclr; reset = 0x0; } ids_queue_overflow[27:27];
        field { name = "resp_check_err"; desc = "Response error detected by the ADMA3 response check. Write 1 to clear."; sw = rw; hw = w; onwrite = woclr; reset = 0x0; } resp_check_err[26:26];
        field { name = "packet_int"; desc = "Multi-packet interrupt. Write 1 to clear."; sw = rw; hw = w; onwrite = woclr; reset = 0x0; } packet_int[25:25];
        field { name = "packet_timeout_int"; desc = "Multi-packet timeout interrupt (ADMA_TIMEOUT). Write 1 to clear."; sw = rw; hw = w; onwrite = woclr; reset = 0x0; } packet_timeout_int[24:24];
        field { name = "auto_stop_err"; desc = "Hardware auto-stop error. Write 1 to clear."; sw = rw; hw = w; onwrite = woclr; reset = 0x0; } auto_stop_err[23:23];
        field { name = "ids_queue_full"; desc = "Integrated-descriptor queue full. Write 1 to clear."; sw = rw; hw = w; onwrite = woclr; reset = 0x0; } ids_queue_full[22:22];
        field { name = "ids_queue_empty"; desc = "Integrated-descriptor queue empty. Write 1 to clear."; sw = rw; hw = w; onwrite = woclr; reset = 0x0; } ids_queue_empty[21:21];

        enum MMC_IDSTS_adma3_fsm_enum {
            ADMA3_IDLE = 0 { name = "Adma3 Idle"; desc = "ADMA3_IDLE"; };
            ADMA3_FIDS = 1 { name = "Adma3 Fids"; desc = "ADMA3_FIDS (fetch integrated descriptor)"; };
            ADMA3_SREG = 2 { name = "Adma3 Sreg"; desc = "ADMA3_SREG (set registers)"; };
            ADMA3_CMD = 3 { name = "Adma3 Cmd"; desc = "ADMA3_CMD"; };
            ADMA3_TRANS = 4 { name = "Adma3 Trans"; desc = "ADMA3_TRANS"; };
            ADMA3_DESC_CLOSE = 5 { name = "Adma3 Desc Close"; desc = "ADMA3_DESC_CLOSE"; };
            ADMA3_AUTO_STOP = 6 { name = "Adma3 Auto Stop"; desc = "ADMA3_AUTO_STOP"; };
            ADMA3_WAIT = 7 { name = "Adma3 Wait"; desc = "ADMA3_WAIT; other values reserved"; };
        };

        field {
            name = "adma3_fsm";
            desc = "Current state of the ADMA3 state machine";
            sw = r;
            hw = w;
            encode = MMC_IDSTS_adma3_fsm_enum;
            reset = 0x0;
        } adma3_fsm[20:17];
`endif

        enum MMC_IDSTS_fsm_enum {
            DMA_IDLE = 0 { name = "Dma Idle"; desc = "DMA_IDLE"; };
            DMA_SUSPEND = 1 { name = "Dma Suspend"; desc = "DMA_SUSPEND"; };
            DESC_RD = 2 { name = "Desc Rd"; desc = "DESC_RD"; };
            DESC_CHK = 3 { name = "Desc Chk"; desc = "DESC_CHK"; };
            DMA_RD_REQ = 4 { name = "Dma Rd Req"; desc = "DMA_RD_REQ_WAIT"; };
            DMA_WR_REQ = 5 { name = "Dma Wr Req"; desc = "DMA_WR_REQ_WAIT"; };
            DMA_RD = 6 { name = "Dma Rd"; desc = "DMA_RD"; };
            DMA_WR = 7 { name = "Dma Wr"; desc = "DMA_WR"; };
            DESC_CLOSE_OTHER = 8 { name = "Desc Close Other"; desc = "DESC_CLOSE Other values: reserved"; };
        };

        field {
            name = "fsm";
            desc = "Current state of the IDMAC state machine";
            sw = r;
            hw = w;
            encode = MMC_IDSTS_fsm_enum;
            reset = 0x0;
        } fsm[16:13];

        enum MMC_IDSTS_eb_enum {
            TRANSMIT_OPERATION_ABORTED = 1 { name = "Transmit Operation Aborted"; desc = "The transmit operation is aborted."; };
            RECEIVE_OPERATION_ABORTED = 2 { name = "Receive Operation Aborted"; desc = "The receive operation is aborted. Other values: reserved"; };
        };

        field {
            name = "eb";
            desc = "Bus error type";
            sw = rw;
            hw = w;
            encode = MMC_IDSTS_eb_enum;
            reset = 0x0;
        } eb[12:10];

        field {
            name = "ais";
            desc = "Abnormal total interrupt. The value of this bit is obtained after the values of FBE, DU, and CES bits are ORed. Writing 1 clears this bit.";
            sw = rw;
            hw = w;
            onwrite = woclr;
            reset = 0x0;
        } ais[9:9];

        field {
            name = "nis";
            desc = "Normal total interrupt. The value of this bit is obtained after the values of the TI and RI bits are ORed. Writing 1 clears this bit.";
            sw = rw;
            hw = w;
            onwrite = woclr;
            reset = 0x0;
        } nis[8:8];

        field {
            name = "ces";
            desc = "Card error indicator. This bit indicates the card status when data is being received.";
            sw = rw;
            hw = w;
            onwrite = woclr;
            reset = 0x0;
        } ces[5:5];

        field {
            name = "du";
            desc = "Descriptor invalid interrupt. When DES0[OWN] is 0, this bit is set to 1. Writing 1 clears this bit.";
            sw = rw;
            hw = w;
            onwrite = woclr;
            reset = 0x0;
        } du[4:4];

        field {
            name = "fbe";
            desc = "Fatal bus error interrupt. If this bit is set to 1, the IDMAC stops all accesses through the bus. Writing 1 clears this bit.";
            sw = rw;
            hw = w;
            onwrite = woclr;
            reset = 0x0;
        } fbe[2:2];

        field {
            name = "ri";
            desc = "Receive done interrupt. This bit indicates that the data of a descriptor is received. Writing 1 clears this bit.";
            sw = rw;
            hw = w;
            onwrite = woclr;
            reset = 0x0;
        } ri[1:1];

        field {
            name = "ti";
            desc = "Transmit done interrupt. This bit indicates that a descriptor finishes transmitting data. Writing 1 clears this bit.";
            sw = rw;
            hw = w;
            onwrite = woclr;
            reset = 0x0;
        } ti[0:0];
    } MMC_IDSTS @ 0x8C;

    reg {
        name = "IDMAC interrupt enable register";
        desc = "MMC_IDINTEN is an IDMAC interrupt enable register.

Data sheet 12.4.4 MMC_IDINTEN (offset 0x90, printed page 12-112, `Hi3518EV20X-Hi3516CV200-Datasheet.txt` line 83520). Bits 29:21 (DWMMC_ADMA3) enable the ADMA3 interrupts of the Hi3516A V200 / Hi3519 V101 (data sheet 12.5, MMC_IDINTEN; bits 20:10 reserved RO there).";

`ifdef DWMMC_ADMA3
        field { name = "cmd_lock_err"; desc = "Command conflict interrupt enable"; sw = rw; hw = r; reset = 0x0; } cmd_lock_err[29:29];
        field { name = "ids_ownbit_err"; desc = "Own-bit error interrupt enable"; sw = rw; hw = r; reset = 0x0; } ids_ownbit_err[28:28];
        field { name = "ids_queue_overflow"; desc = "Queue overflow interrupt enable"; sw = rw; hw = r; reset = 0x0; } ids_queue_overflow[27:27];
        field { name = "resp_check_err"; desc = "Response error detection interrupt enable"; sw = rw; hw = r; reset = 0x0; } resp_check_err[26:26];
        field { name = "packet_int"; desc = "Multi-packet interrupt enable"; sw = rw; hw = r; reset = 0x0; } packet_int[25:25];
        field { name = "packet_timeout_int"; desc = "Timeout interrupt enable"; sw = rw; hw = r; reset = 0x0; } packet_timeout_int[24:24];
        field { name = "auto_stop_err"; desc = "Hardware stop error detection interrupt enable"; sw = rw; hw = r; reset = 0x0; } auto_stop_err[23:23];
        field { name = "ids_queue_full"; desc = "Queue full interrupt enable"; sw = rw; hw = r; reset = 0x0; } ids_queue_full[22:22];
        field { name = "ids_queue_empty"; desc = "Queue empty interrupt enable"; sw = rw; hw = r; reset = 0x0; } ids_queue_empty[21:21];
`endif

        enum MMC_IDINTEN_ai_enum {
            DISABLED = 0 { name = "Disabled"; desc = "disabled"; };
            FBE_DU_CES = 1 { name = "Fbe Du Ces"; desc = "The FBE, DU, and CES interrupts are enabled."; };
        };

        field {
            name = "ai";
            desc = "Abnormal interrupt enable";
            sw = rw;
            hw = r;
            encode = MMC_IDINTEN_ai_enum;
            reset = 0x0;
        } ai[9:9];

        enum MMC_IDINTEN_ni_enum {
            DISABLED = 0 { name = "Disabled"; desc = "disabled"; };
            TI_RI_INTERRUPTS = 1 { name = "Ti Ri Interrupts"; desc = "The TI and RI interrupts are enabled."; };
        };

        field {
            name = "ni";
            desc = "Normal interrupt enable";
            sw = rw;
            hw = r;
            encode = MMC_IDINTEN_ni_enum;
            reset = 0x0;
        } ni[8:8];

        enum MMC_IDINTEN_ces_enum {
            DISABLED = 0 { name = "Disabled"; desc = "disabled"; };
            ENABLED = 1 { name = "Enabled"; desc = "enabled"; };
        };

        field {
            name = "ces";
            desc = "Card error interrupt enable";
            sw = rw;
            hw = r;
            encode = MMC_IDINTEN_ces_enum;
            reset = 0x0;
        } ces[5:5];

        enum MMC_IDINTEN_du_enum {
            DISABLED = 0 { name = "Disabled"; desc = "disabled"; };
            ENABLED = 1 { name = "Enabled"; desc = "enabled"; };
        };

        field {
            name = "du";
            desc = "Descriptor invalid interrupt enable";
            sw = rw;
            hw = r;
            encode = MMC_IDINTEN_du_enum;
            reset = 0x0;
        } du[4:4];

        enum MMC_IDINTEN_fbe_enum {
            DISABLED = 0 { name = "Disabled"; desc = "disabled"; };
            ENABLED = 1 { name = "Enabled"; desc = "enabled"; };
        };

        field {
            name = "fbe";
            desc = "Fatal bus error interrupt enable";
            sw = rw;
            hw = r;
            encode = MMC_IDINTEN_fbe_enum;
            reset = 0x0;
        } fbe[2:2];

        enum MMC_IDINTEN_ri_enum {
            DISABLED = 0 { name = "Disabled"; desc = "disabled"; };
            ENABLED = 1 { name = "Enabled"; desc = "enabled"; };
        };

        field {
            name = "ri";
            desc = "RX interrupt enable";
            sw = rw;
            hw = r;
            encode = MMC_IDINTEN_ri_enum;
            reset = 0x0;
        } ri[1:1];

        enum MMC_IDINTEN_ti_enum {
            DISABLED = 0 { name = "Disabled"; desc = "disabled"; };
            ENABLED = 1 { name = "Enabled"; desc = "enabled"; };
        };

        field {
            name = "ti";
            desc = "TX interrupt enable";
            sw = rw;
            hw = r;
            encode = MMC_IDINTEN_ti_enum;
            reset = 0x0;
        } ti[0:0];
    } MMC_IDINTEN @ 0x90;

    reg {
        name = "Address register of the current descriptor";
        desc = "MMC_DSCADDR is an address register of the current descriptor.

Data sheet 12.4.4 MMC_DSCADDR (offset 0x94, printed page 12-113, `Hi3518EV20X-Hi3516CV200-Datasheet.txt` line 83574).";

        field {
            name = "had";
            desc = "Descriptor pointer. The value is automatically refreshed during data transfer. The register points to the start address of the descriptor that will be used by the IDMAC.";
            sw = r;
            hw = w;
            reset = 0x0;
        } had[31:0];
    } MMC_DSCADDR @ 0x94;

    reg {
        name = "Address register of the current data buffer";
        desc = "MMC_BUFADDR is an address register of the current data buffer.

Data sheet 12.4.4 MMC_BUFADDR (offset 0x98, printed page 12-113, `Hi3518EV20X-Hi3516CV200-Datasheet.txt` line 83594).";

        field {
            name = "hba";
            desc = "Data buffer pointer. The value is automatically refreshed during data transfer. The register points to the start address of the data buffer that is being used by the IDMAC.";
            sw = r;
            hw = w;
            reset = 0x0;
        } hba[31:0];
    } MMC_BUFADDR @ 0x98;
`endif

`ifdef DWMMC_ADMA3
    reg {
        name = "ADMA3 control register";
        desc = "ADMA_CONTROL is the ADMA3 (command queue / integrated descriptor) control register of the Hi3516A V200 / Hi3519 V101 (data sheet 12.5, offset 0xB0, reset 0). The ADMA3 engine fetches integrated descriptors (command + data descriptor pairs) from the queue at ADMA_IDS_ADDR and issues the commands without CPU intervention.";
        field { name = "resp_check_en"; desc = "Response error detection enable"; sw = rw; hw = r; reset = 0x0; } resp_check_en[4:4];
        field { name = "soft_change_rdptr_en"; desc = "Software rewrite of the logic read pointer (ADMA_ID_RDPTR) enable"; sw = rw; hw = r; reset = 0x0; } soft_change_rdptr_en[3:3];
        field { name = "packet_int_en"; desc = "Multi-packet interrupt enable"; sw = rw; hw = r; reset = 0x0; } packet_int_en[2:2];
        field { name = "adma3_restart"; desc = "ADMA3 restart"; sw = rw; hw = r; reset = 0x0; } adma3_restart[1:1];
        field { name = "adma3_enable"; desc = "ADMA3 enable"; sw = rw; hw = r; reset = 0x0; } adma3_enable[0:0];
    } ADMA_CONTROL @ 0xB0;

    reg {
        name = "ADMA3 queue start address register";
        desc = "ADMA_IDS_ADDR: start address of the integrated descriptor queue (Hi3516A V200 / Hi3519 V101 data sheet 12.5, offset 0xB4).";
        field { name = "ids_start_addr"; desc = "Start address of the integrated descriptors"; sw = rw; hw = r; reset = 0x0; } ids_start_addr[31:0];
    } ADMA_IDS_ADDR @ 0xB4;

    reg {
        name = "ADMA3 queue depth register";
        desc = "ADMA_DEEPTH (data sheet spelling): depth of the integrated descriptor queue (offset 0xB8).";
        field { name = "ids_deepth"; desc = "Depth of the integrated descriptor queue"; sw = rw; hw = r; reset = 0x0; } ids_deepth[31:0];
    } ADMA_DEEPTH @ 0xB8;

    reg {
        name = "ADMA3 queue read pointer register";
        desc = "ADMA_ID_RDPTR: read pointer of the integrated descriptor queue (offset 0xBC); software may rewrite it when ADMA_CONTROL[soft_change_rdptr_en] is set.";
        field { name = "ids_rdptr"; desc = "Read pointer of the integrated descriptors"; sw = rw; hw = r; reset = 0x0; } ids_rdptr[31:0];
    } ADMA_ID_RDPTR @ 0xBC;

    reg {
        name = "ADMA3 queue write pointer register";
        desc = "ADMA_ID_WRPTR: write pointer of the integrated descriptor queue (offset 0xC0).";
        field { name = "ids_wrptr"; desc = "Write pointer of the integrated descriptors"; sw = rw; hw = r; reset = 0x0; } ids_wrptr[31:0];
    } ADMA_ID_WRPTR @ 0xC0;

    reg {
        name = "ADMA3 timeout configuration register";
        desc = "ADMA_TIMEOUT: timeout count for the multi-packet timeout interrupt MMC_IDSTS[packet_timeout_int] (offset 0xC4).";
        field { name = "timeout_count"; desc = "Timeout count for the multi-packet timeout interrupt"; sw = rw; hw = r; reset = 0x0; } timeout_count[31:0];
    } ADMA_TIMEOUT @ 0xC4;
`endif

`ifndef DWMMC_FIFO_0x100
    reg {
        name = "Threshold control register";
        desc = "MMC_CARDTHRCTL is a threshold control register.

Vendor driver value `RW_THRESHOLD_SIZE` = 0x02000005 (cardrdthreshold 0x200, cardrdthr_en and cardwrthr_en set; bit 1 BsyClrIntEn clear).

Data sheet 12.4.4 MMC_CARDTHRCTL (offset 0x100, printed page 12-114, `Hi3518EV20X-Hi3516CV200-Datasheet.txt` line 83620).";

        field {
            name = "cardrdthreshold";
            desc = "Read threshold The maximum value is 512.";
            sw = rw;
            hw = r;
            reset = 0x0;
        } cardrdthreshold[27:16];

        enum MMC_CARDTHRCTL_cardwrthr_en_enum {
            DISABLED = 0 { name = "Disabled"; desc = "disabled"; };
            ENABLED = 1 { name = "Enabled"; desc = "enabled"; };
        };

        field {
            name = "cardwrthr_en";
            desc = "Write threshold enable";
            sw = rw;
            hw = r;
            encode = MMC_CARDTHRCTL_cardwrthr_en_enum;
            reset = 0x0;
        } cardwrthr_en[2:2];

        enum MMC_CARDTHRCTL_BsyClrIntEn_enum {
            DISABLED = 0 { name = "Disabled"; desc = "disabled"; };
            ENABLED = 1 { name = "Enabled"; desc = "enabled"; };
        };

        field {
            name = "BsyClrIntEn";
            desc = "Busy clear interrupt enable";
            sw = rw;
            hw = r;
            encode = MMC_CARDTHRCTL_BsyClrIntEn_enum;
            reset = 0x0;
        } BsyClrIntEn[1:1];

        enum MMC_CARDTHRCTL_cardrdthr_en_enum {
            DISABLED = 0 { name = "Disabled"; desc = "disabled"; };
            ENABLED = 1 { name = "Enabled"; desc = "enabled"; };
        };

        field {
            name = "cardrdthr_en";
            desc = "Read threshold enable";
            sw = rw;
            hw = r;
            encode = MMC_CARDTHRCTL_cardrdthr_en_enum;
            reset = 0x0;
        } cardrdthr_en[0:0];
    } MMC_CARDTHRCTL @ 0x100;

    reg {
        name = "UHS extension register";
        desc = "MMC_UHS_REG_EXT is a UHS extension register.

Vendor driver tuning: clk_drv_phase_ctrl (bits 25:23, `DRV_PHASE_MASK` 0x7 << 23) and clk_smpl_phase_ctrl (bits 18:16, `SMPL_PHASE_MASK` 0x7 << 16); the driver writes drive phase 2 (90 degrees) and sample phase 2 on Hi3518EV200 (sample phase 0 on Hi3516CV300 / Hi3519 / Hi3516AV200), then tunes the sample phase for HS200.

Hi3516A V200 / Hi3519 V101 (DWMMC_ADMA3): both fields are 4 bits wide, [26:23] and [19:16], in 22.5-degree steps (drive phase 0x4 = 90, 0x5 = 112.5, 0x6 = 135 degrees, other values reserved; sample phase 0x0 = 0 .. 0xF = 337.5 degrees). Hi3516A/D V100 and Hi3516C V300: 3-bit fields as here.

Data sheet 12.4.4 MMC_UHS_REG_EXT (offset 0x108, printed page 12-115, `Hi3518EV20X-Hi3516CV200-Datasheet.txt` line 83665).";

        enum MMC_UHS_REG_EXT_clk_drv_phase_ctrl_enum {
            V_0 = 0 { name = "V 0"; desc = "0°"; };
            V_45 = 1 { name = "V 45"; desc = "45°"; };
            V_90 = 2 { name = "V 90"; desc = "90°"; };
            V_135 = 3 { name = "V 135"; desc = "135°"; };
            V_180 = 4 { name = "V 180"; desc = "180°"; };
            V_225 = 5 { name = "V 225"; desc = "225°"; };
            V_270 = 6 { name = "V 270"; desc = "270°"; };
            V_315 = 7 { name = "V 315"; desc = "315°"; };
        };

`ifdef DWMMC_ADMA3
        field {
            name = "clk_drv_phase_ctrl";
            desc = "clk_in_drv clock phase control: 0x4 = 90 degrees, 0x5 = 112.5 degrees, 0x6 = 135 degrees; other values reserved.";
            sw = rw;
            hw = r;
            reset = 0x0;
        } clk_drv_phase_ctrl[26:23];
`else
        field {
            name = "clk_drv_phase_ctrl";
            desc = "clk_in_drv clock phase control";
            sw = rw;
            hw = r;
            encode = MMC_UHS_REG_EXT_clk_drv_phase_ctrl_enum;
            reset = 0x0;
        } clk_drv_phase_ctrl[25:23];
`endif

        enum MMC_UHS_REG_EXT_clk_smpl_phase_ctrl_enum {
            V_0 = 0 { name = "V 0"; desc = "0°"; };
            V_45 = 1 { name = "V 45"; desc = "45°"; };
            V_90 = 2 { name = "V 90"; desc = "90°"; };
            V_135 = 3 { name = "V 135"; desc = "135°"; };
            V_180 = 4 { name = "V 180"; desc = "180°"; };
            V_225 = 5 { name = "V 225"; desc = "225°"; };
            V_270 = 6 { name = "V 270"; desc = "270°"; };
            V_315 = 7 { name = "V 315"; desc = "315°"; };
        };

`ifdef DWMMC_ADMA3
        field {
            name = "clk_smpl_phase_ctrl";
            desc = "clk_in_sample clock phase control in 22.5-degree steps: 0x0 = 0, 0x1 = 22.5, 0x2 = 45, ... 0x8 = 180, ... 0xF = 337.5 degrees.";
            sw = rw;
            hw = r;
            reset = 0x0;
        } clk_smpl_phase_ctrl[19:16];
`else
        field {
            name = "clk_smpl_phase_ctrl";
            desc = "clk_in_sample clock phase control";
            sw = rw;
            hw = r;
            encode = MMC_UHS_REG_EXT_clk_smpl_phase_ctrl_enum;
            reset = 0x0;
        } clk_smpl_phase_ctrl[18:16];
`endif
    } MMC_UHS_REG_EXT @ 0x108;

    reg {
        name = "EMMC 4.5 DDR start bit detection control register";
        desc = "MMC_DDR_REG is an eMMC 4.5 DDR start bit detection control register.

Data sheet 12.4.4 MMC_DDR_REG (offset 0x10C, printed page 12-116, `Hi3518EV20X-Hi3516CV200-Datasheet.txt` line 83718).";

        enum MMC_DDR_REG_hs400_mode_enum {
            NON_HS400_MODE = 0 { name = "Non Hs400 Mode"; desc = "non-HS400 mode"; };
            HS400_MODE = 1 { name = "Hs400 Mode"; desc = "HS400 mode"; };
        };

        field {
            name = "hs400_mode";
            desc = "HS400 mode control";
            sw = rw;
            hw = r;
            encode = MMC_DDR_REG_hs400_mode_enum;
            reset = 0x0;
        } hs400_mode[31:31];

        field {
            name = "half_start_bit";
            desc = "For the eMMC4.5 component, when this bit is set to 1'b1, RINTSTS[15] is set to 1 when CMD12 is received in DDR mode.";
            sw = rw;
            hw = r;
            reset = 0x0;
        } half_start_bit[1:1];
    } MMC_DDR_REG @ 0x10C;

    reg {
        name = "Phase shift register";
        desc = "MMC_ENABLE_SHIFT is a phase shift register.

Data sheet 12.4.4 MMC_ENABLE_SHIFT (offset 0x110, printed page 12-117, `Hi3518EV20X-Hi3516CV200-Datasheet.txt` line 83757).";

        enum MMC_ENABLE_SHIFT_Register_1_enum {
            DEFAULT_PHASE_SHIFT = 0 { name = "Default Phase Shift"; desc = "default phase shift"; };
            PHASE_SHIFT_NEXT = 1 { name = "Phase Shift Next"; desc = "Phase shift on the next rising edge"; };
            PHASE_SHIFT_NEXT_2 = 2 { name = "Phase Shift Next 2"; desc = "Phase shift on the next falling edge"; };
            RESERVED = 3 { name = "Reserved"; desc = "Reserved"; };
        };

        field {
            name = "Register_1";
            desc = "eMMC phase shift control";
            sw = rw;
            hw = r;
            encode = MMC_ENABLE_SHIFT_Register_1_enum;
            reset = 0x0;
        } Register_1[3:2];

        enum MMC_ENABLE_SHIFT_Register_0_enum {
            DEFAULT_PHASE_SHIFT = 0 { name = "Default Phase Shift"; desc = "default phase shift"; };
            PHASE_SHIFT_NEXT = 1 { name = "Phase Shift Next"; desc = "Phase shift on the next rising edge"; };
            PHASE_SHIFT_NEXT_2 = 2 { name = "Phase Shift Next 2"; desc = "Phase shift on the next falling edge"; };
            RESERVED = 3 { name = "Reserved"; desc = "Reserved"; };
        };

        field {
            name = "Register_0";
            desc = "SDIO phase shift control";
            sw = rw;
            hw = r;
            encode = MMC_ENABLE_SHIFT_Register_0_enum;
            reset = 0x0;
        } Register_0[1:0];
    } MMC_ENABLE_SHIFT @ 0x110;
`endif

    reg {
        name = "Data register (entrance address of the FIFO)";
        desc = "MMC_DATA is a data register (entrance address of the FIFO). The FIFO overflow must be read first before the data is read from or written to the FIFO.

FIFO window: the whole range 0x200 .. 0x200 + FIFO depth (256 words) addresses the FIFO (vendor `MCI_FIFO_START` 0x200 for HIMCI_V200). On the Hi3511/Hi3515/Hi3520 V100, Hi3516C/Hi3518 V100 and Hi3516 V100 generations (DWMMC_FIFO_0x100) the FIFO window starts at 0x100 instead (vendor `MCI_FIFO_START` 0x100; the Hi3515 data sheet names the field fifo_entrance).

Data sheet 12.4.4 MMC_DATA (offset 0x200, printed page 12-118, `Hi3518EV20X-Hi3516CV200-Datasheet.txt` line 83808).";

        field {
            name = "data";
            desc = "Address for reading/writing to the FIFO. If the address ranges from 0x200 to 0x200 + FIFO_DEPTH, the FIFO is selected.";
            sw = rw;
            hw = r;
            reset = 0x0;
        } data[31:0];
`ifdef DWMMC_FIFO_0x100
    } MMC_DATA @ 0x100;
`else
    } MMC_DATA @ 0x200;
`endif

`ifndef DWMMC_GEN1
    reg {
        name = "General purpose input/output register (vendor)";
        desc = "DesignWare-MMC GPIO register at 0x58.

NOT IN THE DATA SHEET: register defined only in the vendor U-Boot 'include/himciv200_reg.h` / `drivers/mmc/himciv200.c` (sources/u-boot-vendor-2010.06). Standard DesignWare-MMC register; no reset documented.";

        field {
            name = "gpio";
            desc = "General-purpose I/O register of the DesignWare-MMC (vendor `MCI_GPIO`); not used by the vendor driver.";
            sw = rw;
            hw = r;
        } gpio[31:0];
    } MMC_GPIO @ 0x58;

    reg {
        name = "User identification register (vendor)";
        desc = "DesignWare-MMC USRID register at 0x68.

NOT IN THE DATA SHEET: register defined only in the vendor U-Boot 'include/himciv200_reg.h` / `drivers/mmc/himciv200.c` (sources/u-boot-vendor-2010.06). Standard DesignWare-MMC register; no reset documented.";

        field {
            name = "usrid";
            desc = "User-defined ID (vendor `MCI_USRID`).";
            sw = rw;
            hw = r;
        } usrid[31:0];
    } MMC_USRID @ 0x68;

    reg {
        name = "Version identification register (vendor)";
        desc = "DesignWare-MMC VERID register at 0x6C.

NOT IN THE DATA SHEET: register defined only in the vendor U-Boot 'include/himciv200_reg.h` / `drivers/mmc/himciv200.c` (sources/u-boot-vendor-2010.06). Standard DesignWare-MMC register; no reset documented.";

        field {
            name = "verid";
            desc = "IP version ID. The vendor driver (`MCI_VERID`) accepts 0x5342250A, 0x5342270A or 0x5342290A for HIMCI_V200 (DesignWare-MMC 2.50a / 2.70a / 2.90a); 0x5342210A is the older HIMCI_V100.";
            sw = r;
            hw = w;
        } verid[31:0];
    } MMC_VERID @ 0x6C;

    reg {
        name = "Hardware configuration register (vendor)";
        desc = "DesignWare-MMC HCON register at 0x70.

NOT IN THE DATA SHEET: register defined only in the vendor U-Boot 'include/himciv200_reg.h` / `drivers/mmc/himciv200.c` (sources/u-boot-vendor-2010.06). Standard DesignWare-MMC register; no reset documented.";

        field {
            name = "hcon";
            desc = "Hardware configuration of the DesignWare-MMC (vendor `MCI_HCON`); read-only.";
            sw = r;
            hw = w;
        } hcon[31:0];
    } MMC_HCON @ 0x70;
`endif

};

`endif
