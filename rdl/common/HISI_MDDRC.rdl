`ifndef HISI_MDDRC_RDL
`define HISI_MDDRC_RDL

// Generated from the Hi3516A V200 data sheet chapter 4.1 (DDRC) with build/rdl-audit/cpu-ddr-io-scratch/ddr2/gen_mddrc.py
// (ds_extract2 + dsdesc geometry extraction + hand fix-ups for the INT / INT_WC rows the extractor drops); the Hi3519 V101
// data sheet chapter 4.1 is register-for-register identical (147 of 147, dsdiff 2026-11-10).

regfile eHISI_MDDRC_AXI {
    name = "MDDRC AXI registers";
    desc = "AXI-side registers of the MDDRC (data sheet 4.1.5, Table 4-8, base 0x1206_0000, 18 registers): configuration lock, clock gating, AXI operating mode, eight address regions (mapping / attributes / scrambling), per-port QoS mapping and priority tables, per-port and per-group outstanding-command (OSTD) restriction and statistics, status and interrupt status. Variables (Table 4-9): regions 0-7, ports 0-7, groups 0-3.";

    reg {
        name = "Lock control register";
        desc = "AXI_CFG_LOCK is a lock control register.

Data sheet 4.1.5 AXI_CFG_LOCK (offset 0x4, printed page 4-16, `hi3516av200--Hi3516AV200-Datasheet.txt` line 19357).";

        enum AXI_CFG_LOCK_apb_cfg_lock_enum {
            UNLOCKED = 0 { name = "Unlocked"; desc = "unlocked"; };
            LOCKED = 1 { name = "Locked"; desc = "locked (None of the AXI_IF configuration registers can be accessed except this register. Therefore, the power consumption is reduced.)"; };
        };

        field {
            name = "apb_cfg_lock";
            desc = "Lock control of all the register configuration modules (AXI_IF/SEC/DMC/PUB) in the MDDRC";
            sw = rw;
            hw = r;
            encode = AXI_CFG_LOCK_apb_cfg_lock_enum;
            reset = 0x0;
        } apb_cfg_lock[0:0];
    } AXI_CFG_LOCK @ 0x4;

    reg {
        name = "Module clock gating register";
        desc = "AXI_CKG is a module clock gating register. Hi3516A V200 Professional HD IP Camera SoC

Data sheet 4.1.5 AXI_CKG (offset 0x8, printed page 4-17, `hi3516av200--Hi3516AV200-Datasheet.txt` line 19399).";

        field {
            name = "sta_ckg_dmc";
            desc = "Static clock gating for each DMC When sta_ckg_dmc[n] is 0, the clocks for the DMCn and the corresponding PHY utility block (PUB) are disabled. When sta_ckg_dmc[n] is 1, the clocks for the DMCn and the corresponding PUB are enabled. n = 1, 2, or 3: reserved";
            sw = rw;
            hw = r;
            reset = 0xF;
        } sta_ckg_dmc[19:16];

        enum AXI_CKG_dyn_ckg_rdr_enum {
            CLOCK_ALWAYS_ENABLED = 0 { name = "Clock Always Enabled"; desc = "The clock is always enabled."; };
            CLOCK_AUTOMATICALLY_DISABLED = 1 { name = "Clock Automatically Disabled"; desc = "The clock is automatically disabled when the module is idle."; };
        };

        field {
            name = "dyn_ckg_rdr";
            desc = "Dynamic clock gating for the reorder module";
            sw = rw;
            hw = r;
            encode = AXI_CKG_dyn_ckg_rdr_enum;
            reset = 0x1;
        } dyn_ckg_rdr[12:12];

        field {
            name = "dyn_ckg_axi";
            desc = "Dynamic clock gating for each AXI port When dyn_ckg_axi[n] is 0, the clock for AXI port n is always enabled. When dyn_ckg_axi[n] is 1, the clock is automatically disabled when modules in AXI port n are idle.";
            sw = rw;
            hw = r;
            reset = 0xFFF;
        } dyn_ckg_axi[11:0];
    } AXI_CKG @ 0x8;

    reg {
        name = "AXI operating mode register";
        desc = "AXI_ACTION is an AXI operating mode register. Hi3516A V200 Professional HD IP Camera SoC

Data sheet 4.1.5 AXI_ACTION (offset 0x20, printed page 4-18, `hi3516av200--Hi3516AV200-Datasheet.txt` line 19451).";

        field {
            name = "wr_rcv_mode";
            desc = "Anti-deadlock mode enable When wr_rcv_mode[n] is 0, the anti-deadlock mode for port n is disabled. When wr_rcv_mode[n] is 1, the anti-deadlock mode for port n is enabled.";
            sw = rw;
            hw = r;
            reset = 0x0;
        } wr_rcv_mode[19:8];

        enum AXI_ACTION_rd_wrap_split_en_enum {
            NO_SPLIT_ADDRESS = 0 { name = "No Split Address"; desc = "no split. The address is wrapped by the DMC."; };
            SPLIT = 1 { name = "Split"; desc = "split"; };
        };

        field {
            name = "rd_wrap_split_en";
            desc = "Wrap read command split enable";
            sw = rw;
            hw = r;
            encode = AXI_ACTION_rd_wrap_split_en_enum;
            reset = 0x1;
        } rd_wrap_split_en[1:1];

        enum AXI_ACTION_exclusive_en_enum {
            DISABLED = 0 { name = "Disabled"; desc = "disabled"; };
            ENABLED = 1 { name = "Enabled"; desc = "enabled"; };
        };

        field {
            name = "exclusive_en";
            desc = "Exclusive command enable";
            sw = rw;
            hw = r;
            encode = AXI_ACTION_exclusive_en_enum;
            reset = 0x1;
        } exclusive_en[0:0];
    } AXI_ACTION @ 0x20;

    reg {
        name = "Port operating mode register";
        desc = "AXI_STATUS is a port operating mode register. Hi3516A V200 Professional HD IP Camera SoC

Data sheet 4.1.5 AXI_STATUS (offset 0x600, printed page 4-36, `hi3516av200--Hi3516AV200-Datasheet.txt` line 20501).";

        field {
            name = "axi_if_busy";
            desc = "Operating mode of each AXI port When axi_prt_busy[n] is 0, AXI port n is idle. When axi_prt_busy[n] is 1, AXI port n is processing commands or data.";
            sw = r;
            hw = w;
            reset = 0x0;
        } axi_if_busy[11:0];
    } AXI_STATUS @ 0x600;

    reg {
        name = "Interrupt status register S";
        desc = "AXI_INT_STATUS is an interrupt status register.

Data sheet 4.1.5 AXI_INT_STATUS (offset 0x610, printed page 4-36, `hi3516av200--Hi3516AV200-Datasheet.txt` line 20524).";

        field {
            name = "int_ports";
            desc = "Interrupt source indicator When interrupt_ports[n] is 1, the interrupt source is port n.";
            sw = r;
            hw = w;
            reset = 0x0;
        } int_ports[11:0];
    } AXI_INT_STATUS @ 0x610;

    regfile {
        name = "AXI REGION[n]";
        desc = "Address region n (regions = 0..7): mapping, attribute and scrambling registers at 0x100 + 0x10 x n.";

        reg {
            name = "Address area mapping register";
            desc = "AXI_REGION_MAP is an address area mapping register. Hi3516A V200 Professional HD IP Camera SoC

Data sheet 4.1.5 AXI_REGION_MAP (offset 0x100, printed page 4-19, `hi3516av200--Hi3516AV200-Datasheet.txt` line 19507).";

            enum AXI_REGION_MAP_rgn_en_enum {
                DISABLED = 0 { name = "Disabled"; desc = "disabled"; };
                ENABLED = 1 { name = "Enabled"; desc = "enabled"; };
            };

            field {
                name = "rgn_en";
                desc = "Current address area enable";
                sw = rw;
                hw = r;
                encode = AXI_REGION_MAP_rgn_en_enum;
                reset = 0x0;
            } rgn_en[12:12];

            enum AXI_REGION_MAP_rgn_size_enum {
                V_16_MB = 0 { name = "V 16 Mb"; desc = "16 MB"; };
                V_32_MB_THIS = 1 { name = "V 32 Mb This"; desc = "32 MB. In this case, rgn_base_addr/ch_offset[0] must be set to 0."; };
                V_64_MB_THIS = 2 { name = "V 64 Mb This"; desc = "64 MB. In this case, rgn_base_addr/ch_offset[1:0] must be set to 0."; };
                V_128_MB_THIS = 3 { name = "V 128 Mb This"; desc = "128 MB. In this case, rgn_base_addr/ ch _offset[2:0] must be set to 0."; };
                V_256_MB_THIS = 4 { name = "V 256 Mb This"; desc = "256 MB. In this case, rgn_base_addr/ ch _offset[3:0] must be set to 0."; };
                V_512_MB_THIS = 5 { name = "V 512 Mb This"; desc = "512 MB. In this case, rgn_base_addr/ ch _offset[4:0] must be set to 0."; };
                V_1_GB_THIS = 6 { name = "V 1 Gb This"; desc = "1 GB. In this case, rgn_base_addr/ ch _offset[5:0] must be set to 0."; };
                V_2_GB_THIS = 7 { name = "V 2 Gb This"; desc = "2 GB. In this case, rgn_base_addr/ ch _offset[6:0] must be set to 0."; };
            };

            field {
                name = "rgn_size";
                desc = "Size of the current address area";
                sw = rw;
                hw = r;
                encode = AXI_REGION_MAP_rgn_size_enum;
                reset = 0x0;
            } rgn_size[10:8];

            field {
                name = "rgn_base_addr";
                desc = "Base address of the current address area (upper eight bits)";
                sw = rw;
                hw = r;
                reset = 0x0;
            } rgn_base_addr[7:0];
        } AXI_REGION_MAP @ 0x0;

        reg {
            name = "Address area attribute register";
            desc = "AXI_REGION_ATTRIB is an address area attribute register.

Data sheet 4.1.5 AXI_REGION_ATTRIB (offset 0x104, printed page 4-20, `hi3516av200--Hi3516AV200-Datasheet.txt` line 19583).";

            field {
                name = "bnk_mod";
                desc = "Bank interleaving granularity in the channel of the current address area (the interleaving granularity varies according to the component) 8 bytes*2^n (8-bit components) 16 bytes*2^n (16-bit components) 32 bytes*2^n (32-bit components) 64 bytes*2^n (64-bit components) n=0-7";
                sw = rw;
                hw = r;
                reset = 0x0;
            } bnk_mod[30:28];

            enum AXI_REGION_ATTRIB_rnk_mod_enum {
                CONFIGURATION_DMC_USED = 0 { name = "Configuration Dmc Used"; desc = "The configuration in the DMC is used."; };
                SINGLE_INDEPENDENT_RANK = 1 { name = "Single Independent Rank"; desc = "a single independent rank address"; };
                TWO_RANK_ADDRESSES = 2 { name = "Two Rank Addresses"; desc = "Two rank addresses are interleaved."; };
                FOUR_RANK_ADDRESSES = 3 { name = "Four Rank Addresses"; desc = "Four rank addresses are interleaved. Only one channel is supported in this version and the channel supports only one rank."; };
            };

            field {
                name = "rnk_mod";
                desc = "Rank interleaving mode of the channel of the current address area";
                sw = rw;
                hw = r;
                encode = AXI_REGION_ATTRIB_rnk_mod_enum;
                reset = 0x0;
            } rnk_mod[25:24];

            enum AXI_REGION_ATTRIB_addr_aligned_enum {
                V_8_BYTES = 0 { name = "V 8 Bytes"; desc = "8 bytes (valid only when the DMC data bit width is 64 bits)"; };
                V_16_BYTES = 1 { name = "V 16 Bytes"; desc = "16 bytes"; };
                V_32_BYTES = 2 { name = "V 32 Bytes"; desc = "32 bytes"; };
                V_64_BYTES = 3 { name = "V 64 Bytes"; desc = "64 bytes"; };
                V_128_BYTES = 4 { name = "V 128 Bytes"; desc = "128 bytes"; };
                V_256_BYTES = 5 { name = "V 256 Bytes"; desc = "256 bytes"; };
                V_512_BYTES = 6 { name = "V 512 Bytes"; desc = "512 bytes"; };
                V_1_KB = 7 { name = "V 1 Kb"; desc = "1 KB"; };
            };

            field {
                name = "addr_aligned";
                desc = "Address boundary alignment granularity of the current address area";
                sw = rw;
                hw = r;
                encode = AXI_REGION_ATTRIB_addr_aligned_enum;
                reset = 0x1;
            } addr_aligned[18:16];

            field {
                name = "ch_offset";
                desc = "Channel offset address: replaces the upper eight bits of the address in the channel to offset the mapped address within the channel. The replaced bits depend on the address width: bits [31:24] of a 32-bit address after channel mapping, bits [39:32] of a 40-bit address. Only the 32-bit address width is supported in this version.";
                sw = rw;
                hw = r;
                reset = 0x0;
            } ch_offset[15:8];

            enum AXI_REGION_ATTRIB_ch_intlv_enum {
                V_128_BYTES = 0 { name = "V 128 Bytes"; desc = "128 bytes"; };
                V_256_BYTES = 1 { name = "V 256 Bytes"; desc = "256 bytes"; };
                V_512_BYTES = 2 { name = "V 512 Bytes"; desc = "512 bytes"; };
                V_1_KB = 3 { name = "V 1 Kb"; desc = "1 KB"; };
            };

            field {
                name = "ch_intlv";
                desc = "Address interleaving granularity of the current address area (invalid in single independent channel address mode)";
                sw = rw;
                hw = r;
                encode = AXI_REGION_ATTRIB_ch_intlv_enum;
                reset = 0x0;
            } ch_intlv[5:4];

            enum AXI_REGION_ATTRIB_ch_mode_enum {
                NO_MAPPING = 0 { name = "No Mapping"; desc = "no mapping"; };
                ADDRESS_SINGLE_CHANNEL = 1 { name = "Address Single Channel"; desc = "The address of a single channel is mapped to the channel, and the address is independent"; };
                ADDRESSES_TWO_CHANNELS = 2 { name = "Addresses Two Channels"; desc = "The addresses of two channels are mapped to the channel, and the addresses are interleaved."; };
                ADDRESSES_FOUR_CHANNELS = 3 { name = "Addresses Four Channels"; desc = "The addresses of four channels are mapped to the channel, and the addresses are interleaved."; };
            };

            field {
                name = "ch_mode";
                desc = "Channel mapping mode of the current address area";
                sw = rw;
                hw = r;
                encode = AXI_REGION_ATTRIB_ch_mode_enum;
                reset = 0x1;
            } ch_mode[3:2];

            enum AXI_REGION_ATTRIB_ch_start_enum {
                CHANNEL_0 = 0 { name = "Channel 0"; desc = "channel 0"; };
                CHANNEL_1 = 1 { name = "Channel 1"; desc = "channel 1"; };
                CHANNEL_2 = 2 { name = "Channel 2"; desc = "channel 2"; };
                CHANNEL_3 = 3 { name = "Channel 3"; desc = "channel 3"; };
            };

            field {
                name = "ch_start";
                desc = "Mapping start channel of the current address area";
                sw = rw;
                hw = r;
                encode = AXI_REGION_ATTRIB_ch_start_enum;
                reset = 0x0;
            } ch_start[1:0];
        } AXI_REGION_ATTRIB @ 0x4;

        reg {
            name = "Address scrambling code mode register for address areas";
            desc = "AXI_REGION_SCRMBL is an address scrambling code mode register for address areas. Hi3516A V200 Professional HD IP Camera SoC

Data sheet 4.1.5 AXI_REGION_SCRMBL (offset 0x108, printed page 4-23, `hi3516av200--Hi3516AV200-Datasheet.txt` line 19746).";

            field {
                name = "bnk_scrmbl";
                desc = "Bank address scrambling code mode. Other values: reserved. 0x0: no scrambling code In single-channel mode 0x1: addr[14:12] = addr[14:12] XOR addr[19:17] 0x2: addr[14:12] = addr[14:12] XOR addr[20:18] 0x3: addr[14:12] = addr[14:12] XOR addr[21:19] 0x4: addr[14:12] = addr[14:12] XOR addr[22:20] 0x5: addr[14:12] = addr[14:12] XOR addr[23:21] 0x6: addr[14:12] = addr[14:12] XOR addr[24:22] 0x7: addr[14:12] = addr[14:12] XOR addr[25:23] In dual-channel mode (bnk_scrmbl based on the address exchange of ch_scrmbl) 0x1: addr[15:13] = addr[15:13] XOR addr[20:18] 0x2: addr[15:13] = addr[15:13] XOR addr[21:19] 0x3: addr[15:13] = addr[15:13] XOR addr[22:20] 0x4: addr[15:13] = addr[15:13] XOR addr[23:21] 0x5: addr[15:13] = addr[15:13] XOR addr[24:22] 0x6: addr[15:13] = addr[15:13] XOR addr[25:23] 0x7: addr[15:13] = addr[15:13] XOR addr[26:24]";
                sw = rw;
                hw = r;
                reset = 0x0;
            } bnk_scrmbl[3:0];
        } AXI_REGION_SCRMBL @ 0x8;

    } REGION[8] @ 0x100 += 0x10;

    regfile {
        name = "AXI QOS_PORT[n]";
        desc = "QoS of AXI port n (ports = 0..7): priority mapping mode, write/read priority mapping tables and adaptation cycles at 0x200 + 0x10 x n.";

        reg {
            name = "Command priority mapping mode register";
            desc = "AXI_QOS_MAP is a command priority mapping mode register. Hi3516A V200 Professional HD IP Camera SoC

Data sheet 4.1.5 AXI_QOS_MAP (offset 0x200, printed page 4-24, `hi3516av200--Hi3516AV200-Datasheet.txt` line 19801).";

            enum AXI_QOS_MAP_qos_rever_enum {
                PRIORITY_0_LOWEST = 0 { name = "Priority 0 Lowest"; desc = "Priority 0 (axqos = 0) is the lowest priority."; };
                PRIORITY_0_HIGHEST = 1 { name = "Priority 0 Highest"; desc = "Priority 0 (axqos = 0) is the highest priority."; };
            };

            field {
                name = "qos_rever";
                desc = "QoS inversion enable (for the priority arbitration of the read and write commands from the same port)";
                sw = rw;
                hw = r;
                encode = AXI_QOS_MAP_qos_rever_enum;
                reset = 0x0;
            } qos_rever[21:21];

            enum AXI_QOS_MAP_rw_arb_mode_enum {
                ARBITRATION_BASED_COMMAND = 0 { name = "Arbitration Based Command"; desc = "The arbitration is based on the command read/write type.  The command that arrives first is arbitrated first.  When the read and write commands arrive simultaneously (or"; };
                ARBITRATION_BASED_COMMAND_2 = 1 { name = "Arbitration Based Command 2"; desc = "The arbitration is based on the command priority.  The command that arrives first is arbitrated first.  When the read and write commands arrive simultaneously (or"; };
            };

            field {
                name = "rw_arb_mode";
                desc = "Arbitration mode for the read and write commands from the same port";
                sw = rw;
                hw = r;
                encode = AXI_QOS_MAP_rw_arb_mode_enum;
                reset = 0x0;
            } rw_arb_mode[20:20];

            enum AXI_QOS_MAP_pri_map_mode_enum {
                ANY_THREE_BITS = 0 { name = "Any Three Bits"; desc = "Any three bits in the command ID or associated signal are used as the mapping index."; };
                ANY_THREE_BITS_2 = 1 { name = "Any Three Bits 2"; desc = "Any three bits in the lower 16 bits of the command ID are used as the mapping index."; };
            };

            field {
                name = "pri_map_mode";
                desc = "Priority mapping mode of the read/write command";
                sw = rw;
                hw = r;
                encode = AXI_QOS_MAP_pri_map_mode_enum;
                reset = 0x0;
            } pri_map_mode[12:12];

            field {
                name = "id_map_idx";
                desc = "Three methods for selecting bits in the command ID as the mapping index when the command ID is used to map the priority id_map_idx[11:8]: Any one bit in the lower 16 bits of the command ID is selected as idx[2]. id_map_idx[7:4]: Any one bit in the lower 16 bits of the command ID is selected as idx[1]. id_map_idx[3:0]: Any one bit in the lower 16 bits of the command ID is selected as idx[0]. For example, if id_map_idx is set to 0x3A0, ID[3], ID[10], and ID[0] of the command form idx[2:0], which is used to map the command priority from the priority lookup table. The lookup table indicates the description of AXI_QOS_WRPRI or AXI_QOS_RDPRI.";
                sw = rw;
                hw = r;
                reset = 0x0;
            } id_map_idx[11:0];
        } AXI_QOS_MAP @ 0x0;

        reg {
            name = "Write command priority mapping table register";
            desc = "AXI_QOS_WRPRIn is a write command priority mapping table register.

Data sheet 4.1.5 AXI_QOS_WRPRIn (offset 0x204, printed page 4-25, `hi3516av200--Hi3516AV200-Datasheet.txt` line 19894).";

            enum AXI_QOS_WRPRI_wr_pri7_enum {
                HIGHEST_PRIORITY = 0 { name = "Highest Priority"; desc = "highest priority …"; };
                LOWEST_PRIORITY = 7 { name = "Lowest Priority"; desc = "lowest priority"; };
            };

            field {
                name = "wr_pri7";
                desc = "Priority of the write command when the mapping index is 7";
                sw = rw;
                hw = r;
                encode = AXI_QOS_WRPRI_wr_pri7_enum;
                reset = 0x0;
            } wr_pri7[30:28];

            enum AXI_QOS_WRPRI_wr_pri6_enum {
                HIGHEST_PRIORITY = 0 { name = "Highest Priority"; desc = "highest priority …"; };
                LOWEST_PRIORITY = 7 { name = "Lowest Priority"; desc = "lowest priority"; };
            };

            field {
                name = "wr_pri6";
                desc = "Priority of the write command when the mapping index is 6";
                sw = rw;
                hw = r;
                encode = AXI_QOS_WRPRI_wr_pri6_enum;
                reset = 0x0;
            } wr_pri6[26:24];

            enum AXI_QOS_WRPRI_wr_pri5_enum {
                HIGHEST_PRIORITY = 0 { name = "Highest Priority"; desc = "highest priority …"; };
                LOWEST_PRIORITY = 7 { name = "Lowest Priority"; desc = "lowest priority"; };
            };

            field {
                name = "wr_pri5";
                desc = "Priority of the write command when the mapping index is 5";
                sw = rw;
                hw = r;
                encode = AXI_QOS_WRPRI_wr_pri5_enum;
                reset = 0x0;
            } wr_pri5[22:20];

            enum AXI_QOS_WRPRI_wr_pri4_enum {
                HIGHEST_PRIORITY = 0 { name = "Highest Priority"; desc = "highest priority …"; };
                LOWEST_PRIORITY = 7 { name = "Lowest Priority"; desc = "lowest priority"; };
            };

            field {
                name = "wr_pri4";
                desc = "Priority of the write command when the mapping index is 4";
                sw = rw;
                hw = r;
                encode = AXI_QOS_WRPRI_wr_pri4_enum;
                reset = 0x0;
            } wr_pri4[18:16];

            enum AXI_QOS_WRPRI_wr_pri3_enum {
                HIGHEST_PRIORITY = 0 { name = "Highest Priority"; desc = "highest priority …"; };
                LOWEST_PRIORITY = 7 { name = "Lowest Priority"; desc = "lowest priority"; };
            };

            field {
                name = "wr_pri3";
                desc = "Priority of the write command when the mapping index is 3";
                sw = rw;
                hw = r;
                encode = AXI_QOS_WRPRI_wr_pri3_enum;
                reset = 0x0;
            } wr_pri3[14:12];

            enum AXI_QOS_WRPRI_wr_pri2_enum {
                HIGHEST_PRIORITY = 0 { name = "Highest Priority"; desc = "highest priority …"; };
                LOWEST_PRIORITY = 7 { name = "Lowest Priority"; desc = "lowest priority"; };
            };

            field {
                name = "wr_pri2";
                desc = "Priority of the write command when the mapping index is 2";
                sw = rw;
                hw = r;
                encode = AXI_QOS_WRPRI_wr_pri2_enum;
                reset = 0x0;
            } wr_pri2[10:8];

            enum AXI_QOS_WRPRI_wr_pri1_enum {
                HIGHEST_PRIORITY = 0 { name = "Highest Priority"; desc = "highest priority …"; };
                LOWEST_PRIORITY = 7 { name = "Lowest Priority"; desc = "lowest priority"; };
            };

            field {
                name = "wr_pri1";
                desc = "Priority of the write command when the mapping index is 1";
                sw = rw;
                hw = r;
                encode = AXI_QOS_WRPRI_wr_pri1_enum;
                reset = 0x0;
            } wr_pri1[6:4];

            enum AXI_QOS_WRPRI_wr_pri0_enum {
                HIGHEST_PRIORITY = 0 { name = "Highest Priority"; desc = "highest priority …"; };
                LOWEST_PRIORITY = 7 { name = "Lowest Priority"; desc = "lowest priority"; };
            };

            field {
                name = "wr_pri0";
                desc = "Priority of the write command when the mapping index is 0";
                sw = rw;
                hw = r;
                encode = AXI_QOS_WRPRI_wr_pri0_enum;
                reset = 0x0;
            } wr_pri0[2:0];
        } AXI_QOS_WRPRI @ 0x4;

        reg {
            name = "Read command priority mapping table register";
            desc = "AXI_QOS_RDPRIn is a read command priority mapping table register.

Data sheet 4.1.5 AXI_QOS_RDPRIn (offset 0x208, printed page 4-27, `hi3516av200--Hi3516AV200-Datasheet.txt` line 19989).";

            enum AXI_QOS_RDPRI_rd_pri7_enum {
                HIGHEST_PRIORITY = 0 { name = "Highest Priority"; desc = "highest priority …"; };
                LOWEST_PRIORITY = 7 { name = "Lowest Priority"; desc = "lowest priority"; };
            };

            field {
                name = "rd_pri7";
                desc = "Priority of the read command when the mapping index is 7";
                sw = rw;
                hw = r;
                encode = AXI_QOS_RDPRI_rd_pri7_enum;
                reset = 0x0;
            } rd_pri7[30:28];

            enum AXI_QOS_RDPRI_rd_pri6_enum {
                HIGHEST_PRIORITY = 0 { name = "Highest Priority"; desc = "highest priority …"; };
                LOWEST_PRIORITY = 7 { name = "Lowest Priority"; desc = "lowest priority"; };
            };

            field {
                name = "rd_pri6";
                desc = "Priority of the read command when the mapping index is 6";
                sw = rw;
                hw = r;
                encode = AXI_QOS_RDPRI_rd_pri6_enum;
                reset = 0x0;
            } rd_pri6[26:24];

            enum AXI_QOS_RDPRI_rd_pri5_enum {
                HIGHEST_PRIORITY = 0 { name = "Highest Priority"; desc = "highest priority …"; };
                LOWEST_PRIORITY = 7 { name = "Lowest Priority"; desc = "lowest priority"; };
            };

            field {
                name = "rd_pri5";
                desc = "Priority of the read command when the mapping index is 5";
                sw = rw;
                hw = r;
                encode = AXI_QOS_RDPRI_rd_pri5_enum;
                reset = 0x0;
            } rd_pri5[22:20];

            enum AXI_QOS_RDPRI_rd_pri4_enum {
                HIGHEST_PRIORITY = 0 { name = "Highest Priority"; desc = "highest priority …"; };
                LOWEST_PRIORITY = 7 { name = "Lowest Priority"; desc = "lowest priority"; };
            };

            field {
                name = "rd_pri4";
                desc = "Priority of the read command when the mapping index is 4";
                sw = rw;
                hw = r;
                encode = AXI_QOS_RDPRI_rd_pri4_enum;
                reset = 0x0;
            } rd_pri4[18:16];

            enum AXI_QOS_RDPRI_rd_pri3_enum {
                HIGHEST_PRIORITY = 0 { name = "Highest Priority"; desc = "highest priority …"; };
                LOWEST_PRIORITY = 7 { name = "Lowest Priority"; desc = "lowest priority"; };
            };

            field {
                name = "rd_pri3";
                desc = "Priority of the read command when the mapping index is 3";
                sw = rw;
                hw = r;
                encode = AXI_QOS_RDPRI_rd_pri3_enum;
                reset = 0x0;
            } rd_pri3[14:12];

            enum AXI_QOS_RDPRI_rd_pri2_enum {
                HIGHEST_PRIORITY = 0 { name = "Highest Priority"; desc = "highest priority …"; };
                LOWEST_PRIORITY = 7 { name = "Lowest Priority"; desc = "lowest priority"; };
            };

            field {
                name = "rd_pri2";
                desc = "Priority of the read command when the mapping index is 2";
                sw = rw;
                hw = r;
                encode = AXI_QOS_RDPRI_rd_pri2_enum;
                reset = 0x0;
            } rd_pri2[10:8];

            enum AXI_QOS_RDPRI_rd_pri1_enum {
                HIGHEST_PRIORITY = 0 { name = "Highest Priority"; desc = "highest priority …"; };
                LOWEST_PRIORITY = 7 { name = "Lowest Priority"; desc = "lowest priority"; };
            };

            field {
                name = "rd_pri1";
                desc = "Priority of the read command when the mapping index is 1";
                sw = rw;
                hw = r;
                encode = AXI_QOS_RDPRI_rd_pri1_enum;
                reset = 0x0;
            } rd_pri1[6:4];

            enum AXI_QOS_RDPRI_rd_pri0_enum {
                HIGHEST_PRIORITY = 0 { name = "Highest Priority"; desc = "highest priority …"; };
                LOWEST_PRIORITY = 7 { name = "Lowest Priority"; desc = "lowest priority"; };
            };

            field {
                name = "rd_pri0";
                desc = "Priority of the read command when the mapping index is 0";
                sw = rw;
                hw = r;
                encode = AXI_QOS_RDPRI_rd_pri0_enum;
                reset = 0x0;
            } rd_pri0[2:0];
        } AXI_QOS_RDPRI @ 0x8;

        reg {
            name = "Priority adaptation cycle mapping table register";
            desc = "AXI_QOS_ADPTn is a priority adaptation cycle mapping table register. Hi3516A V200 Professional HD IP Camera SoC

Data sheet 4.1.5 AXI_QOS_ADPTn (offset 0x20C, printed page 4-29, `hi3516av200--Hi3516AV200-Datasheet.txt` line 20083).";

            field {
                name = "wr_adpt_high";
                desc = "Write command priority adaptation cycle (high-level) 0x0: The priority adaptation function is disabled. 0x1-0xF: (n x 16) clock cycles";
                sw = rw;
                hw = r;
                reset = 0x0;
            } wr_adpt_high[27:24];

            field {
                name = "wr_adpt_lvl";
                desc = "Write command priority adaptation cycle threshold 0x0-0x1: reserved 0x2-0x7: When the priority of a command is greater than or equal to the threshold, the command is mapped to the high-level cycle. Otherwise, the command is mapped to the low-level cycle. For example: 0x5: The priority adaptation cycle of write commands with priorities 2-5 is configured in wr_adpt_high, and that of write commands with priorities 6-7 is configured in wr_adpt_low.";
                sw = rw;
                hw = r;
                reset = 0x0;
            } wr_adpt_lvl[22:20];

            field {
                name = "wr_adpt_low";
                desc = "Write command priority adaptation cycle (low-level) 0x0: The priority adaptation function is disabled. 0x1-0xF: (n x 16) clock cycles";
                sw = rw;
                hw = r;
                reset = 0x0;
            } wr_adpt_low[19:16];

            field {
                name = "rd_adpt_high";
                desc = "Read command priority adaptation cycle (high-level) 0x0: The priority adaptation function is disabled. 0x1-0xF: (n x 16) clock cycles";
                sw = rw;
                hw = r;
                reset = 0x0;
            } rd_adpt_high[11:8];

            field {
                name = "rd_adpt_lvl";
                desc = "Read command priority adaptation cycle threshold 0x0-0x1: reserved 0x2-0x7: When the priority of a command is greater than or equal to the threshold, the command is mapped to the high-level cycle. Otherwise, the command is mapped to the low-level cycle. For example: 0x5: The priority adaptation cycle of read commands with priorities 2-5 is configured in rd_adpt_high, and that of read commands with priorities 6-7 is configured in rd_adpt_low.";
                sw = rw;
                hw = r;
                reset = 0x0;
            } rd_adpt_lvl[6:4];

            field {
                name = "rd_adpt_low";
                desc = "Read command priority adaptation cycle (low-level) 0x0: The priority adaptation function is disabled. 0x1-0xF: (n x 16) clock cycles";
                sw = rw;
                hw = r;
                reset = 0x0;
            } rd_adpt_low[3:0];
        } AXI_QOS_ADPT @ 0xC;

    } QOS_PORT[8] @ 0x200 += 0x10;

    regfile {
        name = "AXI OSTD_PORT[n]";
        desc = "Outstanding-command restriction and statistics of AXI port n (ports = 0..7) at 0x300 + 0x10 x n.";

        reg {
            name = "Port command OSTD restriction register";
            desc = "AXI_OSTD_PRTn is a port command OSTD restriction register.

Data sheet 4.1.5 AXI_OSTD_PRTn (offset 0x300, printed page 4-30, `hi3516av200--Hi3516AV200-Datasheet.txt` line 20178).";

            field {
                name = "prt_ostd_lvl";
                desc = "Command OSTD threshold of a port 0x00: The number of command OSTDs of a port is not limited. 0x01-0x7F: maximum number of command OSTDs allowed by the port";
                sw = rw;
                hw = r;
                reset = 0x0;
            } prt_ostd_lvl[6:0];
        } AXI_OSTD_PRT @ 0x0;

        reg {
            name = "Port command OSTD statistics register";
            desc = "AXI_OSTD_PRT_STn is a port command OSTD statistics register.

Data sheet 4.1.5 AXI_OSTD_PRT_STn (offset 0x304, printed page 4-31, `hi3516av200--Hi3516AV200-Datasheet.txt` line 20220).";

            field {
                name = "prt_ostd_st";
                desc = "Command OSTD statistics of a port";
                sw = r;
                hw = w;
                reset = 0x0;
            } prt_ostd_st[6:0];
        } AXI_OSTD_PRT_ST @ 0x4;

    } OSTD_PORT[8] @ 0x300 += 0x10;

    regfile {
        name = "AXI OSTD_GROUP[n]";
        desc = "Outstanding-command restriction and statistics of port group n (groups = 0..3) at 0x400 + 0x10 x n.";

        reg {
            name = "Command OSTD register for the port group";
            desc = "AXI_OSTD_GROUPn is a command OSTD register for the port group.

Data sheet 4.1.5 AXI_OSTD_GROUPn (offset 0x400, printed page 4-31, `hi3516av200--Hi3516AV200-Datasheet.txt` line 20242).";

            field {
                name = "group_ostd_sel";
                desc = "Port select of a group When group_ostd_sel[n] is 0, port n is not selected. When group_ostd_sel[n] is 1, port n is selected.";
                sw = rw;
                hw = r;
                reset = 0x0;
            } group_ostd_sel[27:16];

            field {
                name = "group_ostd_lvl";
                desc = "Command OSTD threshold of a port group 0x00: The number of command OSTDs of the port group is not limited. 0x01-0x7F: maximum number of accumulated command OSTDs allowed by the port group";
                sw = rw;
                hw = r;
                reset = 0x0;
            } group_ostd_lvl[6:0];
        } AXI_OSTD_GROUP @ 0x0;

        reg {
            name = "Priority-based port group command OSTD restriction register 0";
            desc = "AXI_OSTD_PRI0 is priority-based port group command OSTD restriction register 0.

Data sheet 4.1.5 AXI_OSTD_PRI0 (offset 0x404, printed page 4-32, `hi3516av200--Hi3516AV200-Datasheet.txt` line 20294).";

            field {
                name = "pri3_ostd_lvl";
                desc = "Priority 3 command OSTD threshold 0x00: The number of accumulated command OSTDs of the selected port group is not limited. 0x01-0x7F: When the number of accumulated command OSTDs of the selected port group reaches the threshold, only the commands whose priorities are higher than 1 are allowed.";
                sw = rw;
                hw = r;
                reset = 0x0;
            } pri3_ostd_lvl[30:24];

            field {
                name = "pri2_ostd_lvl";
                desc = "Priority 2 command OSTD threshold 0x00: The number of accumulated command OSTDs of the selected port group is not limited. 0x01-0x7F: When the number of accumulated command OSTDs of the selected port group reaches the threshold, only the commands whose priorities are higher than 1 are allowed.";
                sw = rw;
                hw = r;
                reset = 0x0;
            } pri2_ostd_lvl[22:16];

            field {
                name = "pri1_ostd_lvl";
                desc = "Priority 1 command OSTD threshold 0x00: The number of accumulated command OSTDs of the selected port group is not limited. 0x01-0x7F: When the number of accumulated command OSTDs of the selected port group reaches the threshold, only the commands whose priorities are higher than 1 are allowed.";
                sw = rw;
                hw = r;
                reset = 0x0;
            } pri1_ostd_lvl[14:8];
        } AXI_OSTD_PRI0 @ 0x4;

        reg {
            name = "Priority-based port group command OSTD restriction register 1";
            desc = "AXI_OSTD_PRI1 is priority-based port group command OSTD restriction register 1. Hi3516A V200 Professional HD IP Camera SoC

Data sheet 4.1.5 AXI_OSTD_PRI1 (offset 0x408, printed page 4-34, `hi3516av200--Hi3516AV200-Datasheet.txt` line 20382).";

            field {
                name = "pri7_ostd_lvl";
                desc = "Priority 7 command OSTD threshold 0x00: The number of accumulated command OSTDs of the selected port group is not limited. 0x01-0x7F: When the number of accumulated command OSTDs of the selected port group reaches the threshold, only the commands whose priorities are higher than 1 are allowed.";
                sw = rw;
                hw = r;
                reset = 0x0;
            } pri7_ostd_lvl[30:24];

            field {
                name = "pri6_ostd_lvl";
                desc = "Priority 6 command OSTD threshold 0x00: The number of accumulated command OSTDs of the selected port group is not limited. 0x01-0x7F: When the number of accumulated command OSTDs of the selected port group reaches the threshold, only the commands whose priorities are higher than 1 are allowed.";
                sw = rw;
                hw = r;
                reset = 0x0;
            } pri6_ostd_lvl[22:16];

            field {
                name = "pri5_ostd_lvl";
                desc = "Priority 5 command OSTD threshold 0x00: The number of accumulated command OSTDs of the selected port group is not limited. 0x01-0x7F: When the number of accumulated command OSTDs of the selected port group reaches the threshold, only the commands whose priorities are higher than 1 are allowed.";
                sw = rw;
                hw = r;
                reset = 0x0;
            } pri5_ostd_lvl[14:8];

            field {
                name = "pri4_ostd_lvl";
                desc = "Priority 4 command OSTD threshold 0x00: The number of accumulated command OSTDs of the selected port group is not limited. 0x01-0x7F: When the number of accumulated command OSTDs of the selected port group reaches the threshold, only the commands whose priorities are higher than 1 are allowed.";
                sw = rw;
                hw = r;
                reset = 0x0;
            } pri4_ostd_lvl[6:0];
        } AXI_OSTD_PRI1 @ 0x8;

        reg {
            name = "Command OSTD statistics register for the port group";
            desc = "AXI_OSTD_GROUP_STn is a command OSTD statistics register for the port group.

Data sheet 4.1.5 AXI_OSTD_GROUP_STn (offset 0x40C, printed page 4-35, `hi3516av200--Hi3516AV200-Datasheet.txt` line 20472).";

            field {
                name = "group_ostd_st";
                desc = "Command OSTD statistics of a port group";
                sw = r;
                hw = w;
                reset = 0x0;
            } group_ostd_st[6:0];
        } AXI_OSTD_GROUP_ST @ 0xC;

    } OSTD_GROUP[4] @ 0x400 += 0x10;

};

regfile eHISI_MDDRC_QOSB {
    name = "MDDRC QoSBuf registers";
    desc = "QoS buffer (QoSBuf) registers of the MDDRC (data sheet 4.1.6, Table 4-10, base 0x1206_4000, 56 registers): push / adaptation control, traffic statistics (matched IDs fids = 0..6, groups fgps = 0..7), bank rotation and green channel, write buffer, write/read timeout and ageing tables, row-hit priority, clock gating, DMC entry threshold, performance statistics, slot / buffer status, interrupts and command / rank / bank counters. The chans variable is 0 only (one channel), so the per-channel registers are single registers.";

    reg {
        name = "QosBuf push configuration register";
        desc = "QOSB_PUSH_CTRL is a QosBuf push configuration register.

Data sheet 4.1.6 QOSB_PUSH_CTRL (offset 0x0, printed page 4-40, `hi3516av200--Hi3516AV200-Datasheet.txt` line 20727).";

        enum QOSB_PUSH_CTRL_mid_push_en_enum {
            DISABLED = 0 { name = "Disabled"; desc = "disabled"; };
            ENABLED = 1 { name = "Enabled"; desc = "enabled"; };
        };

        field {
            name = "mid_push_en";
            desc = "Push enable for commands with the same MID";
            sw = rw;
            hw = r;
            encode = QOSB_PUSH_CTRL_mid_push_en_enum;
            reset = 0x0;
        } mid_push_en[2:2];

        enum QOSB_PUSH_CTRL_addr_push_en_enum {
            DISABLED = 0 { name = "Disabled"; desc = "disabled"; };
            ENABLED = 1 { name = "Enabled"; desc = "enabled"; };
        };

        field {
            name = "addr_push_en";
            desc = "Push enable for commands with the same address";
            sw = rw;
            hw = r;
            encode = QOSB_PUSH_CTRL_addr_push_en_enum;
            reset = 0x0;
        } addr_push_en[1:1];

        enum QOSB_PUSH_CTRL_id_push_en_enum {
            DISABLED = 0 { name = "Disabled"; desc = "disabled"; };
            ENABLED = 1 { name = "Enabled"; desc = "enabled"; };
        };

        field {
            name = "id_push_en";
            desc = "Push enable for commands with the same ID";
            sw = rw;
            hw = r;
            encode = QOSB_PUSH_CTRL_id_push_en_enum;
            reset = 0x0;
        } id_push_en[0:0];
    } QOSB_PUSH_CTRL @ 0x0;

    reg {
        name = "Lock control register";
        desc = "QOSB_ADPT_CTRL is a QoSBuf adaptation configuration register. Hi3516A V200 Professional HD IP Camera SoC

Data sheet 4.1.6 QOSB_ADPT_CTRL (offset 0x4, printed page 4-41, `hi3516av200--Hi3516AV200-Datasheet.txt` line 20771).";

        field {
            name = "adpt_share_cnt";
            desc = "Adapt counter for lower bits. When the value of this counter decreases to 0, the counter for upper bits corresponding to each CMD decreases by 1.";
            sw = rw;
            hw = r;
            reset = 0xFF;
        } adpt_share_cnt[19:4];

        enum QOSB_ADPT_CTRL_adpt_en_enum {
            DISABLED = 0 { name = "Disabled"; desc = "disabled"; };
            ENABLED = 1 { name = "Enabled"; desc = "enabled"; };
        };

        field {
            name = "adpt_en";
            desc = "Adapt enable";
            sw = rw;
            hw = r;
            encode = QOSB_ADPT_CTRL_adpt_en_enum;
            reset = 0x0;
        } adpt_en[0:0];
    } QOSB_ADPT_CTRL @ 0x4;

    reg {
        name = "Module clock gating register";
        desc = "QOSB_FLUX_ID is a QoSBuf matched ID register for traffic statistics.

Data sheet 4.1.6 QOSB_FLUX_ID (offset 0x8, printed page 4-41, `hi3516av200--Hi3516AV200-Datasheet.txt` line 20803).";

        field {
            name = "flux_id";
            desc = "Matched ID for traffic statistics. The ID ranges from 0 to 6, and each ID corresponds to a statistics group. If the traffic ID matches none of the seven IDs, the traffic is included in the default group.";
            sw = rw;
            hw = r;
            reset = 0x0;
        } flux_id[31:0];
    } QOSB_FLUX_ID[7] @ 0x8 += 0x4;

    reg {
        name = "QoSBuf traffic statistics ID mask register";
        desc = "QOSB_FLUX_ID_MASK is a QoSBuf traffic statistics ID mask register. Hi3516A V200 Professional HD IP Camera SoC

Data sheet 4.1.6 QOSB_FLUX_ID_MASK (offset 0x24, printed page 4-42, `hi3516av200--Hi3516AV200-Datasheet.txt` line 20836).";

        enum QOSB_FLUX_ID_MASK_flux_id_mask_enum {
            BITS_CORRESPONDING_ID = 0x0 { name = "Bits Corresponding Id"; desc = "Bits of the corresponding ID are ignored."; };
            BITS_CORRESPONDING_ID_2 = 0x1 { name = "Bits Corresponding Id 2"; desc = "Bits of the corresponding ID are compared."; };
        };

        field {
            name = "flux_id_mask";
            desc = "QoSBuf traffic statistics ID mask, corresponding to QOSB_FLUX_ID";
            sw = rw;
            hw = r;
            encode = QOSB_FLUX_ID_MASK_flux_id_mask_enum;
            reset = 0x0;
        } flux_id_mask[31:0];
    } QOSB_FLUX_ID_MASK[7] @ 0x24 += 0x4;

    reg {
        name = "QoSBuf traffic statistical period register";
        desc = "QOSB_FLUX_PRD is a QoSBuf traffic statistical period register.

Data sheet 4.1.6 QOSB_FLUX_PRD (offset 0x40, printed page 4-42, `hi3516av200--Hi3516AV200-Datasheet.txt` line 20859).";

        field {
            name = "flux_prd";
            desc = "Traffic statistical period";
            sw = rw;
            hw = r;
            reset = 0x0;
        } flux_prd[15:0];
    } QOSB_FLUX_PRD @ 0x40;

    reg {
        name = "QoSBuf traffic statistical threshold register";
        desc = "QOSB_FLUX_LVL is a QoSBuf traffic statistical threshold register. Hi3516A V200 Professional HD IP Camera SoC

Data sheet 4.1.6 QOSB_FLUX_LVL (offset 0x44, printed page 4-43, `hi3516av200--Hi3516AV200-Datasheet.txt` line 20891).";

        field {
            name = "flux_lvl";
            desc = "Traffic statistical threshold. During the statistical period, the priority of the command is decreased to the lowest one when the traffic exceeds the threshold.";
            sw = rw;
            hw = r;
            reset = 0x0;
        } flux_lvl[19:0];
    } QOSB_FLUX_LVL[8] @ 0x44 += 0x4;

    reg {
        name = "QoSBuf traffic statistics enable register";
        desc = "QOSB_FLUX_EN is a QoSBuf traffic statistics enable register.

Data sheet 4.1.6 QOSB_FLUX_EN (offset 0x64, printed page 4-43, `hi3516av200--Hi3516AV200-Datasheet.txt` line 20913).";

        enum QOSB_FLUX_EN_flux_en_enum {
            DISABLED = 0 { name = "Disabled"; desc = "disabled"; };
            ENABLED = 1 { name = "Enabled"; desc = "enabled"; };
        };

        field {
            name = "flux_en";
            desc = "Traffic statistics enable";
            sw = rw;
            hw = r;
            encode = QOSB_FLUX_EN_flux_en_enum;
            reset = 0x0;
        } flux_en[0:0];
    } QOSB_FLUX_EN @ 0x64;

    reg {
        name = "QoSBuf bank rotating control register";
        desc = "QOSB_BANK_CTRL is a QoSBuf bank rotating control register. Hi3516A V200 Professional HD IP Camera SoC

Data sheet 4.1.6 QOSB_BANK_CTRL (offset 0x68, printed page 4-44, `hi3516av200--Hi3516AV200-Datasheet.txt` line 20949).";

        field {
            name = "ba_cnt_lvl";
            desc = "Bank conflict threshold. When the number of commands with the same bank address exceeds the threshold, bank conflict occurs. Otherwise, there is no bank conflict.";
            sw = rw;
            hw = r;
            reset = 0x0;
        } ba_cnt_lvl[7:4];

        enum QOSB_BANK_CTRL_ba_intleav_en_enum {
            DISABLED = 0 { name = "Disabled"; desc = "disabled"; };
            ENABLED = 1 { name = "Enabled"; desc = "enabled"; };
        };

        field {
            name = "ba_intleav_en";
            desc = "QoSBuf bank rotating enable";
            sw = rw;
            hw = r;
            encode = QOSB_BANK_CTRL_ba_intleav_en_enum;
            reset = 0x0;
        } ba_intleav_en[0:0];
    } QOSB_BANK_CTRL @ 0x68;

    reg {
        name = "QoSBuf green channel control register";
        desc = "QOSB_GREEN_CTRL is a QoSBuf green channel control register.

Data sheet 4.1.6 QOSB_GREEN_CTRL (offset 0x78, printed page 4-44, `hi3516av200--Hi3516AV200-Datasheet.txt` line 20984).";

        field {
            name = "green_lvl";
            desc = "Green channel threshold. That is, the empty locations above this threshold are reserved for green channels. For example, if there are 12 DMC queues (queues 0-11) and the threshold is 9, queues 10 and 11 are reserved for green channels.";
            sw = rw;
            hw = r;
            reset = 0x0;
        } green_lvl[7:4];

        enum QOSB_GREEN_CTRL_green_en_enum {
            DISABLED = 0 { name = "Disabled"; desc = "disabled"; };
            ENABLED = 1 { name = "Enabled"; desc = "enabled"; };
        };

        field {
            name = "green_en";
            desc = "Green channel enable (channels are not controlled separately, which needs to be optimized later)";
            sw = rw;
            hw = r;
            encode = QOSB_GREEN_CTRL_green_en_enum;
            reset = 0x0;
        } green_en[0:0];
    } QOSB_GREEN_CTRL @ 0x78;

    reg {
        name = "QoSBuf bypass control register";
        desc = "QOSB_BUF_BYP is a QoSBuf bypass control register.

Data sheet 4.1.6 QOSB_BUF_BYP (offset 0x88, printed page 4-45, `hi3516av200--Hi3516AV200-Datasheet.txt` line 21036).";

        enum QOSB_BUF_BYP_qos_buf_byp_enum {
            WHETHER_BYPASS_DEPENDS = 1 { name = "Whether Bypass Depends"; desc = "whether to bypass depends on the queue status in the DMC"; };
            FORCIBLE_BYPASS_MODE = 3 { name = "Forcible Bypass Mode"; desc = "forcible bypass mode. None of the commands enters the QoSBuf module."; };
        };

        field {
            name = "qos_buf_byp";
            desc = "QoSBuf bypass control x0: forcible non-bypass mode. That is, all the commands enter the QoSBuf module when the value is set to 00 or 10.";
            sw = rw;
            hw = r;
            encode = QOSB_BUF_BYP_qos_buf_byp_enum;
            reset = 0x0;
        } qos_buf_byp[1:0];
    } QOSB_BUF_BYP @ 0x88;

    reg {
        name = "QoSBuf write command priority adjustment control register";
        desc = "QOSB_WBUF_CTRL is a QoSBuf write command priority adjustment control register.

Data sheet 4.1.6 QOSB_WBUF_CTRL (offset 0x8C, printed page 4-46, `hi3516av200--Hi3516AV200-Datasheet.txt` line 21080).";

        enum QOSB_WBUF_CTRL_wbuf_ptun_en_enum {
            DISABLED = 0 { name = "Disabled"; desc = "disabled"; };
            ENABLED = 1 { name = "Enabled"; desc = "enabled"; };
        };

        field {
            name = "wbuf_ptun_en";
            desc = "Write command priority adjustment enable";
            sw = rw;
            hw = r;
            encode = QOSB_WBUF_CTRL_wbuf_ptun_en_enum;
            reset = 0x0;
        } wbuf_ptun_en[31:31];

        field {
            name = "wbuf_pri2";
            desc = "Priority of write buffer threshold 2";
            sw = rw;
            hw = r;
            reset = 0x0;
        } wbuf_pri2[30:28];

        field {
            name = "wbuf_lvl2";
            desc = "Write buffer threshold 2. When the number of commands increasingly reaches the threshold, if the priorities of the write commands are lower than wbuf_pri2, the priorities of the write commands are set to wbuf_pri2. If the priorities of the write commands are higher than wbuf_pri2, the priorities of the write commands are restored to their previous priorities. Note that the threshold cannot be dynamically configured. Otherwise, the write buffer adaptation function becomes invalid.";
            sw = rw;
            hw = r;
            reset = 0x0;
        } wbuf_lvl2[27:20];

        field {
            name = "wbuf_pri1";
            desc = "Priority of write buffer threshold 1 priority";
            sw = rw;
            hw = r;
            reset = 0x0;
        } wbuf_pri1[18:16];

        field {
            name = "wbuf_lvl1";
            desc = "Write buffer threshold 1. When the number of commands increasingly or decreasingly reaches the threshold, if the priorities of the write commands are lower than wbuf_pri1, the priorities of the write commands are set to wbuf_pri1. If the priorities of the write commands are higher than wbuf_pri1, the priorities of the write commands are restored to their previous priorities. Note that the threshold cannot be dynamically configured. Otherwise, the write buffer adaptation function becomes invalid.";
            sw = rw;
            hw = r;
            reset = 0x0;
        } wbuf_lvl1[15:8];

        field {
            name = "wbuf_lvl0";
            desc = "Write buffer threshold 0. When the number of commands decreasingly reaches the threshold, the priorities of the write commands are decreased to the lowest priority. Note that the threshold cannot be dynamically configured. Otherwise, the write buffer adaptation function becomes invalid.";
            sw = rw;
            hw = r;
            reset = 0x0;
        } wbuf_lvl0[7:0];
    } QOSB_WBUF_CTRL @ 0x8C;

    reg {
        name = "QoSBuf write command timeout period register 0";
        desc = "QOSB_WRTOUT0 is QoSBuf write command timeout period register 0.

Data sheet 4.1.6 QOSB_WRTOUT0 (offset 0x9C, printed page 4-47, `hi3516av200--Hi3516AV200-Datasheet.txt` line 21142).";

        field {
            name = "wr_tout3";
            desc = "Write command timeout period (level 3) The configuration mode is the same as that of wr_tout0.";
            sw = rw;
            hw = r;
            reset = 0x0;
        } wr_tout3[31:24];

        field {
            name = "wr_tout2";
            desc = "Write command timeout period (level 2) The configuration mode is the same as that of wr_tout0.";
            sw = rw;
            hw = r;
            reset = 0x0;
        } wr_tout2[23:16];

        field {
            name = "wr_tout1";
            desc = "Write command timeout period (level 1) The configuration mode is the same as that of wr_tout0.";
            sw = rw;
            hw = r;
            reset = 0x0;
        } wr_tout1[15:8];

        field {
            name = "wr_tout0";
            desc = "Write command timeout period (level 0) 0x0: The timeout function is disabled. 0x1-0xFF: n x 4 clock cycles";
            sw = rw;
            hw = r;
            reset = 0x0;
        } wr_tout0[7:0];
    } QOSB_WRTOUT0 @ 0x9C;

    reg {
        name = "QoSBuf write command timeout period register 1";
        desc = "QOSB_WRTOUT1 is QoSBuf write command timeout period register 1.

Data sheet 4.1.6 QOSB_WRTOUT1 (offset 0xA0, printed page 4-47, `hi3516av200--Hi3516AV200-Datasheet.txt` line 21176).";

        field {
            name = "wr_tout7";
            desc = "Write command timeout period (level 7) The configuration mode is the same as that of wr_tout0.";
            sw = rw;
            hw = r;
            reset = 0x0;
        } wr_tout7[31:24];

        field {
            name = "wr_tout6";
            desc = "Write command timeout period (level 6) The configuration mode is the same as that of wr_tout0.";
            sw = rw;
            hw = r;
            reset = 0x0;
        } wr_tout6[23:16];

        field {
            name = "wr_tout5";
            desc = "Write command timeout period (level 5) The configuration mode is the same as that of wr_tout0.";
            sw = rw;
            hw = r;
            reset = 0x0;
        } wr_tout5[15:8];

        field {
            name = "wr_tout4";
            desc = "Write command timeout period (level 4) The configuration mode is the same as that of wr_tout0.";
            sw = rw;
            hw = r;
            reset = 0x0;
        } wr_tout4[7:0];
    } QOSB_WRTOUT1 @ 0xA0;

    reg {
        name = "QoSBuf write command timeout period register 2";
        desc = "QOSB_WRTOUT2 is QoSBuf write command timeout period register 2.

Data sheet 4.1.6 QOSB_WRTOUT2 (offset 0xA4, printed page 4-48, `hi3516av200--Hi3516AV200-Datasheet.txt` line 21215).";

        field {
            name = "wr_tout11";
            desc = "Write command timeout period (level 11) The configuration mode is the same as that of wr_tout0.";
            sw = rw;
            hw = r;
            reset = 0x0;
        } wr_tout11[31:24];

        field {
            name = "wr_tout10";
            desc = "Write command timeout period (level 10) The configuration mode is the same as that of wr_tout0.";
            sw = rw;
            hw = r;
            reset = 0x0;
        } wr_tout10[23:16];

        field {
            name = "wr_tout9";
            desc = "Write command timeout period (level 9) The configuration mode is the same as that of wr_tout0.";
            sw = rw;
            hw = r;
            reset = 0x0;
        } wr_tout9[15:8];

        field {
            name = "wr_tout8";
            desc = "Write command timeout period (level 8) The configuration mode is the same as that of wr_tout0.";
            sw = rw;
            hw = r;
            reset = 0x0;
        } wr_tout8[7:0];
    } QOSB_WRTOUT2 @ 0xA4;

    reg {
        name = "QoSBuf write command timeout period register 3";
        desc = "QOSB_WRTOUT3 is QoSBuf write command timeout period register 3.

Data sheet 4.1.6 QOSB_WRTOUT3 (offset 0xA8, printed page 4-48, `hi3516av200--Hi3516AV200-Datasheet.txt` line 21245).";

        field {
            name = "wr_tout15";
            desc = "Write command timeout period (level 15) The configuration mode is the same as that of wr_tout0.";
            sw = rw;
            hw = r;
            reset = 0x0;
        } wr_tout15[31:24];

        field {
            name = "wr_tout14";
            desc = "Write command timeout period (level 14) The configuration mode is the same as that of wr_tout0.";
            sw = rw;
            hw = r;
            reset = 0x0;
        } wr_tout14[23:16];

        field {
            name = "wr_tout13";
            desc = "Write command timeout period (level 13) The configuration mode is the same as that of wr_tout0.";
            sw = rw;
            hw = r;
            reset = 0x0;
        } wr_tout13[15:8];

        field {
            name = "wr_tout12";
            desc = "Write command timeout period (level 12) The configuration mode is the same as that of wr_tout0.";
            sw = rw;
            hw = r;
            reset = 0x0;
        } wr_tout12[7:0];
    } QOSB_WRTOUT3 @ 0xA8;

    reg {
        name = "QoSBuf read command timeout period register 0";
        desc = "QOSB_RDTOUT0 is QoSBuf read command timeout period register 0.

Data sheet 4.1.6 QOSB_RDTOUT0 (offset 0xAC, printed page 4-49, `hi3516av200--Hi3516AV200-Datasheet.txt` line 21286).";

        field {
            name = "rd_tout3";
            desc = "Read command timeout period (level 3) The configuration mode is the same as that of rd_tout0.";
            sw = rw;
            hw = r;
            reset = 0x0;
        } rd_tout3[31:24];

        field {
            name = "rd_tout2";
            desc = "Read command timeout period (level 2) The configuration mode is the same as that of rd_tout0.";
            sw = rw;
            hw = r;
            reset = 0x0;
        } rd_tout2[23:16];

        field {
            name = "rd_tout1";
            desc = "Read command timeout period (level 1) The configuration mode is the same as that of rd_tout0.";
            sw = rw;
            hw = r;
            reset = 0x0;
        } rd_tout1[15:8];

        field {
            name = "rd_tout0";
            desc = "Read command timeout period (level 0) 0x0: The timeout function is disabled. 0x1-0xFF: n x 4 clock cycles";
            sw = rw;
            hw = r;
            reset = 0x0;
        } rd_tout0[7:0];
    } QOSB_RDTOUT0 @ 0xAC;

    reg {
        name = "QoSBuf read command timeout period register 1";
        desc = "QOSB_RDTOUT1 is QoSBuf read command timeout period register 1. Hi3516A V200 Professional HD IP Camera SoC

Data sheet 4.1.6 QOSB_RDTOUT1 (offset 0xB0, printed page 4-50, `hi3516av200--Hi3516AV200-Datasheet.txt` line 21330).";

        field {
            name = "rd_tout7";
            desc = "Read command timeout period (level 7) The configuration mode is the same as that of rd_tout0.";
            sw = rw;
            hw = r;
            reset = 0x0;
        } rd_tout7[31:24];

        field {
            name = "rd_tout6";
            desc = "Read command timeout period (level 6) The configuration mode is the same as that of rd_tout0.";
            sw = rw;
            hw = r;
            reset = 0x0;
        } rd_tout6[23:16];

        field {
            name = "rd_tout5";
            desc = "Read command timeout period (level 5) The configuration mode is the same as that of rd_tout0.";
            sw = rw;
            hw = r;
            reset = 0x0;
        } rd_tout5[15:8];

        field {
            name = "rd_tout4";
            desc = "Read command timeout period (level 4) The configuration mode is the same as that of rd_tout0.";
            sw = rw;
            hw = r;
            reset = 0x0;
        } rd_tout4[7:0];
    } QOSB_RDTOUT1 @ 0xB0;

    reg {
        name = "QoSBuf read command timeout period register 2";
        desc = "QOSB_RDTOUT2 is QoSBuf read command timeout period register 2.

Data sheet 4.1.6 QOSB_RDTOUT2 (offset 0xB4, printed page 4-50, `hi3516av200--Hi3516AV200-Datasheet.txt` line 21359).";

        field {
            name = "rd_tout11";
            desc = "Read command timeout period (level 11) The configuration mode is the same as that of rd_tout0.";
            sw = rw;
            hw = r;
            reset = 0x0;
        } rd_tout11[31:24];

        field {
            name = "rd_tout10";
            desc = "Read command timeout period (level 10) The configuration mode is the same as that of rd_tout0.";
            sw = rw;
            hw = r;
            reset = 0x0;
        } rd_tout10[23:16];

        field {
            name = "rd_tout9";
            desc = "Read command timeout period (level 9) The configuration mode is the same as that of rd_tout0.";
            sw = rw;
            hw = r;
            reset = 0x0;
        } rd_tout9[15:8];

        field {
            name = "rd_tout8";
            desc = "Read command timeout period (level 8) The configuration mode is the same as that of rd_tout0.";
            sw = rw;
            hw = r;
            reset = 0x0;
        } rd_tout8[7:0];
    } QOSB_RDTOUT2 @ 0xB4;

    reg {
        name = "QoSBuf read command timeout period register 3";
        desc = "QOSB_RDTOUT3 is QoSBuf read command timeout period register 3.

Data sheet 4.1.6 QOSB_RDTOUT3 (offset 0xB8, printed page 4-51, `hi3516av200--Hi3516AV200-Datasheet.txt` line 21394).";

        field {
            name = "rd_tout15";
            desc = "Read command timeout period (level 15) The configuration mode is the same as that ofrd_tout0.";
            sw = rw;
            hw = r;
            reset = 0x0;
        } rd_tout15[31:24];

        field {
            name = "rd_tout14";
            desc = "Read command timeout period (level 14) The configuration mode is the same as that ofrd_tout0.";
            sw = rw;
            hw = r;
            reset = 0x0;
        } rd_tout14[23:16];

        field {
            name = "rd_tout13";
            desc = "Read command timeout period (level 13) The configuration mode is the same as that ofrd_tout0.";
            sw = rw;
            hw = r;
            reset = 0x0;
        } rd_tout13[15:8];

        field {
            name = "rd_tout12";
            desc = "Read command timeout period (level 12) The configuration mode is the same as that ofrd_tout0.";
            sw = rw;
            hw = r;
            reset = 0x0;
        } rd_tout12[7:0];
    } QOSB_RDTOUT3 @ 0xB8;

    reg {
        name = "QoSBuf write command timeout mapping mode control register";
        desc = "QOSB_WRTOUT_MAP is a QoSBuf write command timeout mapping mode control register.

Data sheet 4.1.6 QOSB_WRTOUT_MAP (offset 0xBC, printed page 4-51, `hi3516av200--Hi3516AV200-Datasheet.txt` line 21424).";

        field {
            name = "wrtout_map3";
            desc = "There are 16 levels of timeout periods. Four bits are selected from the ID and the level is determined based on the four bits. wrtout_map3 indicates the position of bit 3 in the ID.";
            sw = rw;
            hw = r;
            reset = 0x0;
        } wrtout_map3[28:24];

        field {
            name = "wrtout_map2";
            desc = "There are 16 levels of timeout periods. Four bits are selected from the ID and the level is determined based on the four bits. wrtout_map2 indicates the position of bit 2 in the ID.";
            sw = rw;
            hw = r;
            reset = 0x0;
        } wrtout_map2[20:16];

        field {
            name = "wrtout_map1";
            desc = "There are 16 levels of timeout periods. Four bits are selected from the ID and the level is determined based on the four bits. wrtout_map1 indicates the position of bit 1 in the ID.";
            sw = rw;
            hw = r;
            reset = 0x0;
        } wrtout_map1[12:8];

        field {
            name = "wrtout_map0";
            desc = "There are 16 levels of timeout periods. Four bits are selected from the ID and the level is determined based on the four bits. wrtout_map0 indicates the position of bit 0 in the ID.";
            sw = rw;
            hw = r;
            reset = 0x0;
        } wrtout_map0[4:0];
    } QOSB_WRTOUT_MAP @ 0xBC;

    reg {
        name = "QoSBuf read command timeout mapping mode control register";
        desc = "QOSB_RDTOUT_MAP is a QoSBuf read command timeout mapping mode control register.

Data sheet 4.1.6 QOSB_RDTOUT_MAP (offset 0xD0, printed page 4-52, `hi3516av200--Hi3516AV200-Datasheet.txt` line 21473).";

        field {
            name = "rdtout_map3";
            desc = "There are 16 levels of timeout periods. Four bits are selected from the ID and the level is determined based on the four bits. rdtout_map3 indicates the position of bit 3 in the ID.";
            sw = rw;
            hw = r;
            reset = 0x0;
        } rdtout_map3[28:24];

        field {
            name = "rdtout_map2";
            desc = "There are 16 levels of timeout periods. Four bits are selected from the ID and the level is determined based on the four bits. rdtout_map2 indicates the position of bit 2 in the ID.";
            sw = rw;
            hw = r;
            reset = 0x0;
        } rdtout_map2[20:16];

        field {
            name = "rdtout_map1";
            desc = "There are 16 levels of timeout periods. Four bits are selected from the ID and the level is determined based on the four bits. rdtout_map1 indicates the position of bit 1 in the ID.";
            sw = rw;
            hw = r;
            reset = 0x0;
        } rdtout_map1[12:8];

        field {
            name = "rdtout_map0";
            desc = "There are 16 levels of timeout periods. Four bits are selected from the ID and the level is determined based on the four bits. rdtout_map0 indicates the position of bit 0 in the ID.";
            sw = rw;
            hw = r;
            reset = 0x0;
        } rdtout_map0[4:0];
    } QOSB_RDTOUT_MAP @ 0xD0;

    reg {
        name = "QoSBuf write command aging configuration register 0";
        desc = "QOSB_WRAGE0 is QoSBuf write command aging configuration register 0.

Data sheet 4.1.6 QOSB_WRAGE0 (offset 0xD4, printed page 4-53, `hi3516av200--Hi3516AV200-Datasheet.txt` line 21521).";

        field {
            name = "wr_age_prd7";
            desc = "Write command aging cycle (level 7) For details, see wr_age_prd0.";
            sw = rw;
            hw = r;
            reset = 0x0;
        } wr_age_prd7[31:28];

        field {
            name = "wr_age_prd6";
            desc = "Write command aging cycle (level 6) For details, see wr_age_prd0.";
            sw = rw;
            hw = r;
            reset = 0x0;
        } wr_age_prd6[27:24];

        field {
            name = "wr_age_prd5";
            desc = "Write command aging cycle (level 5) For details, see wr_age_prd0.";
            sw = rw;
            hw = r;
            reset = 0x0;
        } wr_age_prd5[23:20];

        field {
            name = "wr_age_prd4";
            desc = "Write command aging cycle (level 4) For details, see wr_age_prd0.";
            sw = rw;
            hw = r;
            reset = 0x0;
        } wr_age_prd4[19:16];

        field {
            name = "wr_age_prd3";
            desc = "Write command aging cycle (level 3) For details, see wr_age_prd0.";
            sw = rw;
            hw = r;
            reset = 0x0;
        } wr_age_prd3[15:12];

        field {
            name = "wr_age_prd2";
            desc = "Write command aging cycle (level 2) For details, see wr_age_prd0.";
            sw = rw;
            hw = r;
            reset = 0x0;
        } wr_age_prd2[11:8];

        field {
            name = "wr_age_prd1";
            desc = "Write command aging cycle (level 1) For details, see wr_age_prd0.";
            sw = rw;
            hw = r;
            reset = 0x0;
        } wr_age_prd1[7:4];

        field {
            name = "wr_age_prd0";
            desc = "Write command aging cycle (level 0) 0x0: The aging function is disabled. 0x1-0xF: (n x 16) clock cycles";
            sw = rw;
            hw = r;
            reset = 0x0;
        } wr_age_prd0[3:0];
    } QOSB_WRAGE0 @ 0xD4;

    reg {
        name = "QoSBuf write command aging configuration register 1";
        desc = "QOSB_WRAGE1 is QoSBuf write command aging configuration register 1. Hi3516A V200 Professional HD IP Camera SoC

Data sheet 4.1.6 QOSB_WRAGE1 (offset 0xD8, printed page 4-54, `hi3516av200--Hi3516AV200-Datasheet.txt` line 21573).";

        field {
            name = "wr_age_prd15";
            desc = "Write command aging cycle (level 15) For details, see wr_age_prd0.";
            sw = rw;
            hw = r;
            reset = 0x0;
        } wr_age_prd15[31:28];

        field {
            name = "wr_age_prd14";
            desc = "Write command aging cycle (level 14) For details, see wr_age_prd0.";
            sw = rw;
            hw = r;
            reset = 0x0;
        } wr_age_prd14[27:24];

        field {
            name = "wr_age_prd13";
            desc = "Write command aging cycle (level 13) For details, see wr_age_prd0.";
            sw = rw;
            hw = r;
            reset = 0x0;
        } wr_age_prd13[23:20];

        field {
            name = "wr_age_prd12";
            desc = "Write command aging cycle (level 12) For details, see wr_age_prd0.";
            sw = rw;
            hw = r;
            reset = 0x0;
        } wr_age_prd12[19:16];

        field {
            name = "wr_age_prd11";
            desc = "Write command aging cycle (level 11) For details, see wr_age_prd0.";
            sw = rw;
            hw = r;
            reset = 0x0;
        } wr_age_prd11[15:12];

        field {
            name = "wr_age_prd10";
            desc = "Write command aging cycle (level 10) For details, see wr_age_prd0.";
            sw = rw;
            hw = r;
            reset = 0x0;
        } wr_age_prd10[11:8];

        field {
            name = "wr_age_prd9";
            desc = "Write command aging cycle (level 9) For details, see wr_age_prd0.";
            sw = rw;
            hw = r;
            reset = 0x0;
        } wr_age_prd9[7:4];

        field {
            name = "wr_age_prd8";
            desc = "Write command aging cycle (level 8) For details, see wr_age_prd0.";
            sw = rw;
            hw = r;
            reset = 0x0;
        } wr_age_prd8[3:0];
    } QOSB_WRAGE1 @ 0xD8;

    reg {
        name = "QoSBuf read command aging configuration register 0";
        desc = "QOSB_RDAGE0 is QoSBuf read command aging configuration register 0.

Data sheet 4.1.6 QOSB_RDAGE0 (offset 0xDC, printed page 4-54, `hi3516av200--Hi3516AV200-Datasheet.txt` line 21614).";

        field {
            name = "rd_age_prd7";
            desc = "Read command aging cycle (level 7) For details, see rd_age_prd0.";
            sw = rw;
            hw = r;
            reset = 0x0;
        } rd_age_prd7[31:28];

        field {
            name = "rd_age_prd6";
            desc = "Read command aging cycle (level 6) For details, see rd_age_prd0.";
            sw = rw;
            hw = r;
            reset = 0x0;
        } rd_age_prd6[27:24];

        field {
            name = "rd_age_prd5";
            desc = "Read command aging cycle (level 5) For details, see rd_age_prd0.";
            sw = rw;
            hw = r;
            reset = 0x0;
        } rd_age_prd5[23:20];

        field {
            name = "rd_age_prd4";
            desc = "Read command aging cycle (level 4) For details, see rd_age_prd0.";
            sw = rw;
            hw = r;
            reset = 0x0;
        } rd_age_prd4[19:16];

        field {
            name = "rd_age_prd3";
            desc = "Read command aging cycle (level 3) For details, see rd_age_prd0.";
            sw = rw;
            hw = r;
            reset = 0x0;
        } rd_age_prd3[15:12];

        field {
            name = "rd_age_prd2";
            desc = "Read command aging cycle (level 2) For details, see rd_age_prd0.";
            sw = rw;
            hw = r;
            reset = 0x0;
        } rd_age_prd2[11:8];

        field {
            name = "rd_age_prd1";
            desc = "Read command aging cycle (level 1) For details, see rd_age_prd0.";
            sw = rw;
            hw = r;
            reset = 0x0;
        } rd_age_prd1[7:4];

        field {
            name = "rd_age_prd0";
            desc = "Read command aging cycle (level 0) 0x0: The aging function is disabled. 0x1-0xF: (n x 16) clock cycles";
            sw = rw;
            hw = r;
            reset = 0x0;
        } rd_age_prd0[3:0];
    } QOSB_RDAGE0 @ 0xDC;

    reg {
        name = "QoSBuf read command aging configuration register 1";
        desc = "QOSB_RDAGE1 is QoSBuf read command aging configuration register 1.

Data sheet 4.1.6 QOSB_RDAGE1 (offset 0xE0, printed page 4-55, `hi3516av200--Hi3516AV200-Datasheet.txt` line 21667).";

        field {
            name = "rd_age_prd15";
            desc = "Read command aging cycle (level 15) For details, see rd_age_prd0.";
            sw = rw;
            hw = r;
            reset = 0x0;
        } rd_age_prd15[31:28];

        field {
            name = "rd_age_prd14";
            desc = "Read command aging cycle (level 14) For details, see rd_age_prd0.";
            sw = rw;
            hw = r;
            reset = 0x0;
        } rd_age_prd14[27:24];

        field {
            name = "rd_age_prd13";
            desc = "Read command aging cycle (level 13) For details, see rd_age_prd0.";
            sw = rw;
            hw = r;
            reset = 0x0;
        } rd_age_prd13[23:20];

        field {
            name = "rd_age_prd12";
            desc = "Read command aging cycle (level 12) For details, see rd_age_prd0.";
            sw = rw;
            hw = r;
            reset = 0x0;
        } rd_age_prd12[19:16];

        field {
            name = "rd_age_prd11";
            desc = "Read command aging cycle (level 11) For details, see rd_age_prd0.";
            sw = rw;
            hw = r;
            reset = 0x0;
        } rd_age_prd11[15:12];

        field {
            name = "rd_age_prd10";
            desc = "Read command aging cycle (level 10) For details, see rd_age_prd0.";
            sw = rw;
            hw = r;
            reset = 0x0;
        } rd_age_prd10[11:8];

        field {
            name = "rd_age_prd9";
            desc = "Read command aging cycle (level 9) For details, see rd_age_prd0.";
            sw = rw;
            hw = r;
            reset = 0x0;
        } rd_age_prd9[7:4];

        field {
            name = "rd_age_prd8";
            desc = "Read command aging cycle (level 8) For details, see rd_age_prd0.";
            sw = rw;
            hw = r;
            reset = 0x0;
        } rd_age_prd8[3:0];
    } QOSB_RDAGE1 @ 0xE0;

    reg {
        name = "QoSBuf write command aging mapping mode control register";
        desc = "QOSB_WRAGE_MAP is a QoSBuf write command aging mapping mode control register.

Data sheet 4.1.6 QOSB_WRAGE_MAP (offset 0xE4, printed page 4-56, `hi3516av200--Hi3516AV200-Datasheet.txt` line 21720).";

        field {
            name = "wrage_map3";
            desc = "There are 16 levels of aging cycles. Four bits are selected from the ID and the level is determined based on the four bits. wrage_map3 indicates the position of bit 3 in the ID.";
            sw = rw;
            hw = r;
            reset = 0x0;
        } wrage_map3[28:24];

        field {
            name = "wrage_map2";
            desc = "There are 16 levels of aging cycles. Four bits are selected from the ID and the level is determined based on the four bits. wrage_map2 indicates the position of bit 2 in the ID.";
            sw = rw;
            hw = r;
            reset = 0x0;
        } wrage_map2[20:16];

        field {
            name = "wrage_map1";
            desc = "There are 16 levels of aging cycles. Four bits are selected from the ID and the level is determined based on the four bits. wrage_map1 indicates the position of bit 1 in the ID.";
            sw = rw;
            hw = r;
            reset = 0x0;
        } wrage_map1[12:8];

        field {
            name = "wrage_map0";
            desc = "There are 16 levels of aging cycles. Four bits are selected from the ID and the level is determined based on the four bits. wrage_map0 indicates the position of bit 0 in the ID.";
            sw = rw;
            hw = r;
            reset = 0x0;
        } wrage_map0[4:0];
    } QOSB_WRAGE_MAP @ 0xE4;

    reg {
        name = "QoSBuf read command aging mapping mode control register";
        desc = "QOSB_RDAGE_MAP is a QoSBuf read command aging mapping mode control register.

Data sheet 4.1.6 QOSB_RDAGE_MAP (offset 0xE8, printed page 4-57, `hi3516av200--Hi3516AV200-Datasheet.txt` line 21763).";

        field {
            name = "rdage_map3";
            desc = "There are 16 levels of aging cycles. Four bits are selected from the ID and the level is determined based on the four bits. rdage_map3 indicates the position of bit 3 in the ID.";
            sw = rw;
            hw = r;
            reset = 0x0;
        } rdage_map3[28:24];

        field {
            name = "rdage_map2";
            desc = "There are 16 levels of aging cycles. Four bits are selected from the ID and the level is determined based on the four bits. rdage_map2 indicates the position of bit 2 in the ID.";
            sw = rw;
            hw = r;
            reset = 0x0;
        } rdage_map2[20:16];

        field {
            name = "rdage_map1";
            desc = "There are 16 levels of aging cycles. Four bits are selected from the ID and the level is determined based on the four bits. rdage_map1 indicates the position of bit 1 in the ID.";
            sw = rw;
            hw = r;
            reset = 0x0;
        } rdage_map1[12:8];

        field {
            name = "rdage_map0";
            desc = "There are 16 levels of aging cycles. Four bits are selected from the ID and the level is determined based on the four bits. rdage_map0 indicates the position of bit 0 in the ID.";
            sw = rw;
            hw = r;
            reset = 0x0;
        } rdage_map0[4:0];
    } QOSB_RDAGE_MAP @ 0xE8;

    reg {
        name = "QoSBuf row-hit priority threshold register";
        desc = "QOSB_ROWHIT_PRILVL is a QoSBuf row-hit priority threshold register. Hi3516A V200 Professional HD IP Camera SoC

Data sheet 4.1.6 QOSB_ROWHIT_PRILVL (offset 0xEC, printed page 4-58, `hi3516av200--Hi3516AV200-Datasheet.txt` line 21811).";

        field {
            name = "ch3_rowhit_pri_lvl";
            desc = "Channel 3 priority threshold If the current priority is lower than ch3_rohit_pri_lvl, the priority is changed to ch3_rowhit_pri1. If the current priority is higher than ch3_rohit_pri_lvl, the priority is changed to ch3_rowhit_pri0.";
            sw = rw;
            hw = r;
            reset = 0x0;
        } ch3_rowhit_pri_lvl[14:12];

        field {
            name = "ch2_rowhit_pri_lvl";
            desc = "Channel 2 priority threshold If the current priority is lower than ch2_rohit_pri_lvl, the priority is changed to ch2_rowhit_pri1. If the current priority is higher than ch2_rohit_pri_lvl, the priority is changed to ch2_rowhit_pri0.";
            sw = rw;
            hw = r;
            reset = 0x0;
        } ch2_rowhit_pri_lvl[10:8];

        field {
            name = "ch1_rowhit_pri_lvl";
            desc = "Channel 1 priority threshold If the current priority is lower than ch1_rohit_pri_lvl, the priority is changed to ch1_rowhit_pri1. If the current priority is higher than ch1_rohit_pri_lvl, the priority is changed to ch1_rowhit_pri0.";
            sw = rw;
            hw = r;
            reset = 0x0;
        } ch1_rowhit_pri_lvl[6:4];

        field {
            name = "ch0_rowhit_pri_lvl";
            desc = "Channel 0 priority threshold If the current priority is lower than ch0_rohit_pri_lvl, the priority is changed to ch0_rowhit_pri1. If the current priority is higher than ch0_rohit_pri_lvl, the priority is changed to ch0_rowhit_pri0.";
            sw = rw;
            hw = r;
            reset = 0x0;
        } ch0_rowhit_pri_lvl[2:0];
    } QOSB_ROWHIT_PRILVL @ 0xEC;

    reg {
        name = "QoSBuf row-hit priority control register";
        desc = "QOSB_ROWHIT_PRI is a QoSBuf row-hit priority control register.

Data sheet 4.1.6 QOSB_ROWHIT_PRI (offset 0xF0, printed page 4-59, `hi3516av200--Hi3516AV200-Datasheet.txt` line 21866).";

        field {
            name = "ch3_rowhit_pri1";
            desc = "See ch3_rowhit_pri_lvl.";
            sw = rw;
            hw = r;
            reset = 0x0;
        } ch3_rowhit_pri1[30:28];

        field {
            name = "ch3_rowhit_pri0";
            desc = "See ch3_rowhit_pri_lvl.";
            sw = rw;
            hw = r;
            reset = 0x0;
        } ch3_rowhit_pri0[26:24];

        field {
            name = "ch2_rowhit_pri1";
            desc = "See ch2_rowhit_pri_lvl.";
            sw = rw;
            hw = r;
            reset = 0x0;
        } ch2_rowhit_pri1[22:20];

        field {
            name = "ch2_rowhit_pri0";
            desc = "See ch2_rowhit_pri_lvl.";
            sw = rw;
            hw = r;
            reset = 0x0;
        } ch2_rowhit_pri0[18:16];

        field {
            name = "ch1_rowhit_pri1";
            desc = "See ch1_rowhit_pri_lvl.";
            sw = rw;
            hw = r;
            reset = 0x0;
        } ch1_rowhit_pri1[14:12];

        field {
            name = "ch1_rowhit_pri0";
            desc = "See ch1_rowhit_pri_lvl.";
            sw = rw;
            hw = r;
            reset = 0x0;
        } ch1_rowhit_pri0[10:8];

        field {
            name = "ch0_rowhit_pri1";
            desc = "See ch0_rowhit_pri_lvl.";
            sw = rw;
            hw = r;
            reset = 0x0;
        } ch0_rowhit_pri1[6:4];

        field {
            name = "ch0_rowhit_pri0";
            desc = "See ch0_rowhit_pri_lvl.";
            sw = rw;
            hw = r;
            reset = 0x0;
        } ch0_rowhit_pri0[2:0];
    } QOSB_ROWHIT_PRI @ 0xF0;

    reg {
        name = "QoSBuf row-hit enable register";
        desc = "QOSB_ROWHIT_CTRL is a QoSBuf row-hit enable register. Hi3516A V200 Professional HD IP Camera SoC

Data sheet 4.1.6 QOSB_ROWHIT_CTRL (offset 0xF4, printed page 4-60, `hi3516av200--Hi3516AV200-Datasheet.txt` line 21916).";

        enum QOSB_ROWHIT_CTRL_ch3_dual_flow_en_enum {
            DISABLED = 0 { name = "Disabled"; desc = "disabled"; };
            ENABLED = 1 { name = "Enabled"; desc = "enabled"; };
        };

        field {
            name = "ch3_dual_flow_en";
            desc = "Channel 3 row-hit dual-stream enable";
            sw = rw;
            hw = r;
            encode = QOSB_ROWHIT_CTRL_ch3_dual_flow_en_enum;
            reset = 0x0;
        } ch3_dual_flow_en[7:7];

        enum QOSB_ROWHIT_CTRL_ch2_dual_flow_en_enum {
            DISABLED = 0 { name = "Disabled"; desc = "disabled"; };
            ENABLED = 1 { name = "Enabled"; desc = "enabled"; };
        };

        field {
            name = "ch2_dual_flow_en";
            desc = "Channel 2 row-hit dual-stream enable";
            sw = rw;
            hw = r;
            encode = QOSB_ROWHIT_CTRL_ch2_dual_flow_en_enum;
            reset = 0x0;
        } ch2_dual_flow_en[6:6];

        enum QOSB_ROWHIT_CTRL_ch1_dual_flow_en_enum {
            DISABLED = 0 { name = "Disabled"; desc = "disabled"; };
            ENABLED = 1 { name = "Enabled"; desc = "enabled"; };
        };

        field {
            name = "ch1_dual_flow_en";
            desc = "Channel 1 row-hit dual-stream enable";
            sw = rw;
            hw = r;
            encode = QOSB_ROWHIT_CTRL_ch1_dual_flow_en_enum;
            reset = 0x0;
        } ch1_dual_flow_en[5:5];

        enum QOSB_ROWHIT_CTRL_ch0_dual_flow_en_enum {
            DISABLED = 0 { name = "Disabled"; desc = "disabled"; };
            ENABLED = 1 { name = "Enabled"; desc = "enabled"; };
        };

        field {
            name = "ch0_dual_flow_en";
            desc = "Channel 0 row-hit dual-stream enable";
            sw = rw;
            hw = r;
            encode = QOSB_ROWHIT_CTRL_ch0_dual_flow_en_enum;
            reset = 0x0;
        } ch0_dual_flow_en[4:4];

        enum QOSB_ROWHIT_CTRL_ch3_row_hit_en_enum {
            DISABLED = 0 { name = "Disabled"; desc = "disabled"; };
            ENABLED = 1 { name = "Enabled"; desc = "enabled"; };
        };

        field {
            name = "ch3_row_hit_en";
            desc = "Channel 3 row-hit enable";
            sw = rw;
            hw = r;
            encode = QOSB_ROWHIT_CTRL_ch3_row_hit_en_enum;
            reset = 0x0;
        } ch3_row_hit_en[3:3];

        enum QOSB_ROWHIT_CTRL_ch2_row_hit_en_enum {
            DISABLED = 0 { name = "Disabled"; desc = "disabled"; };
            ENABLED = 1 { name = "Enabled"; desc = "enabled"; };
        };

        field {
            name = "ch2_row_hit_en";
            desc = "Channel 2 row-hit enable";
            sw = rw;
            hw = r;
            encode = QOSB_ROWHIT_CTRL_ch2_row_hit_en_enum;
            reset = 0x0;
        } ch2_row_hit_en[2:2];

        enum QOSB_ROWHIT_CTRL_ch1_row_hit_en_enum {
            DISABLED = 0 { name = "Disabled"; desc = "disabled"; };
            ENABLED = 1 { name = "Enabled"; desc = "enabled"; };
        };

        field {
            name = "ch1_row_hit_en";
            desc = "Channel 1 row-hit enable";
            sw = rw;
            hw = r;
            encode = QOSB_ROWHIT_CTRL_ch1_row_hit_en_enum;
            reset = 0x0;
        } ch1_row_hit_en[1:1];

        enum QOSB_ROWHIT_CTRL_ch0_row_hit_en_enum {
            DISABLED = 0 { name = "Disabled"; desc = "disabled"; };
            ENABLED = 1 { name = "Enabled"; desc = "enabled"; };
        };

        field {
            name = "ch0_row_hit_en";
            desc = "Channel 0 row-hit enable";
            sw = rw;
            hw = r;
            encode = QOSB_ROWHIT_CTRL_ch0_row_hit_en_enum;
            reset = 0x0;
        } ch0_row_hit_en[0:0];
    } QOSB_ROWHIT_CTRL @ 0xF4;

    reg {
        name = "QoSBuf clock control register";
        desc = "QOSB_CKG_CFG is a QoSBuf clock control register.

Data sheet 4.1.6 QOSB_CKG_CFG (offset 0x108, printed page 4-61, `hi3516av200--Hi3516AV200-Datasheet.txt` line 21971).";

        enum QOSB_CKG_CFG_dyn_ck_gate_enum {
            CLOCK_ALWAYS_ENABLED = 0 { name = "Clock Always Enabled"; desc = "The clock is always enabled."; };
            CLOCK_GATING_AUTOMATIC = 1 { name = "Clock Gating Automatic"; desc = "The clock gating is automatic when the module is idle."; };
        };

        field {
            name = "dyn_ck_gate";
            desc = "Dynamic clock gating for the QoSBuf module";
            sw = rw;
            hw = r;
            encode = QOSB_CKG_CFG_dyn_ck_gate_enum;
            reset = 0x1;
        } dyn_ck_gate[0:0];
    } QOSB_CKG_CFG @ 0x108;

    reg {
        name = "QoSBuf threshold control register for commands";
        desc = "QOSB_DMC_LVL is a QoSBuf threshold control register for commands that enter the DMC module.

Data sheet 4.1.6 QOSB_DMC_LVL (offset 0x10C, printed page 4-61, `hi3516av200--Hi3516AV200-Datasheet.txt` line 22003).";

        field {
            name = "dmc_cmd_full_lvl";
            desc = "Number of QoSBuf commands that enter the DMC module. When this threshold is reached, the DMC queue is full.";
            sw = rw;
            hw = r;
            reset = 0xF;
        } dmc_cmd_full_lvl[4:0];
    } QOSB_DMC_LVL @ 0x10C;

    reg {
        name = "QoSBuf performance statistics mode register";
        desc = "QOSB_CFG_PERF is a QoSBuf performance statistics mode register.

Data sheet 4.1.6 QOSB_CFG_PERF (offset 0x120, printed page 4-62, `hi3516av200--Hi3516AV200-Datasheet.txt` line 22036).";

        enum QOSB_CFG_PERF_perf_en_enum {
            ENABLED = 1 { name = "Enabled"; desc = "enabled"; };
            DISABLED = 0 { name = "Disabled"; desc = "disabled"; };
        };

        field {
            name = "perf_en";
            desc = "Performance statistics enable";
            sw = rw;
            hw = r;
            encode = QOSB_CFG_PERF_perf_en_enum;
            reset = 0x0;
        } perf_en[29:29];

        enum QOSB_CFG_PERF_perf_mode_enum {
            CONTINUOUS_TRIGGER_MODE = 0 { name = "Continuous Trigger Mode"; desc = "continuous trigger mode. Counters related to performance statistics keep counting to ensure that no data overflows within 1s."; };
            SINGLE_TRIGGER_MODE = 1 { name = "Single Trigger Mode"; desc = "single trigger mode. When the performance statistical period reaches the value of perf_prd, the statistical result retains and the counting stops."; };
        };

        field {
            name = "perf_mode";
            desc = "Performance statistical mode";
            sw = rw;
            hw = r;
            encode = QOSB_CFG_PERF_perf_mode_enum;
            reset = 0x0;
        } perf_mode[28:28];

        field {
            name = "perf_prd";
            desc = "Performance statistical cycle 0x0: invalid 0x1-0xFFFFFFF: statistical cycle The actual statistical cycle is (perf_prd x 16 x tclk). tclk is the bus clock cycle of the DDRC.";
            sw = rw;
            hw = r;
            reset = 0x0;
        } perf_prd[27:0];
    } QOSB_CFG_PERF @ 0x120;

    reg {
        name = "QoSBuf accumulated command count register";
        desc = "QOSB_CMD_SUM is a QoSBuf accumulated command count register. Hi3516A V200 Professional HD IP Camera SoC

Data sheet 4.1.6 QOSB_CMD_SUM (offset 0x124, printed page 4-63, `hi3516av200--Hi3516AV200-Datasheet.txt` line 22099).";

        field {
            name = "qos_cmd_sum";
            desc = "Accumulated value of the commands that are temporarily stored in the QoSBuf in the cycle. The value is wrapped if an overflow occurs.";
            sw = r;
            hw = w;
            reset = 0x0;
        } qos_cmd_sum[31:0];
    } QOSB_CMD_SUM @ 0x124;

    reg {
        name = "QoSBuf queue status register 0";
        desc = "QOSB_SLOT_STAT0 is QoSBuf queue status register 0.

Data sheet 4.1.6 QOSB_SLOT_STAT0 (offset 0x128, printed page 4-63, `hi3516av200--Hi3516AV200-Datasheet.txt` line 22119).";

        field {
            name = "grp_cmd_valid_l";
            desc = "Status of bits 0-31 in the QoSBuf cmd queue. If a bit is set to 1, there are commands stored in the corresponding slot; otherwise, the slot is empty.";
            sw = r;
            hw = w;
            reset = 0x0;
        } grp_cmd_valid_l[31:0];
    } QOSB_SLOT_STAT0 @ 0x128;

    reg {
        name = "QoSBuf queue status register 1";
        desc = "QOSB_SLOT_STAT1 is QoSBuf queue status register 1.

Data sheet 4.1.6 QOSB_SLOT_STAT1 (offset 0x12C, printed page 4-63, `hi3516av200--Hi3516AV200-Datasheet.txt` line 22139).";

        field {
            name = "grp_cmd_valid_m0";
            desc = "Status of bits 32-63 in the QoSBuf cmd queue. If a bit is set to 1, there are commands stored in the corresponding slot; otherwise, the slot is empty.";
            sw = r;
            hw = w;
            reset = 0x0;
        } grp_cmd_valid_m0[31:0];
    } QOSB_SLOT_STAT1 @ 0x12C;

    reg {
        name = "QoSBuf queue status register 2";
        desc = "QOSB_SLOT_STAT2 is QoSBuf queue status register 2.

Data sheet 4.1.6 QOSB_SLOT_STAT2 (offset 0x130, printed page 4-64, `hi3516av200--Hi3516AV200-Datasheet.txt` line 22165).";

        field {
            name = "grp_cmd_valid_m1";
            desc = "Status of bits 64-95 in the QoSBuf cmd queue. If a bit is set to 1, there are commands stored in the corresponding slot; otherwise, the slot is empty.";
            sw = r;
            hw = w;
            reset = 0x0;
        } grp_cmd_valid_m1[31:0];
    } QOSB_SLOT_STAT2 @ 0x130;

    reg {
        name = "QoSBuf queue status register 3";
        desc = "QOSB_SLOT_STAT3 is QoSBuf queue status register 3.

Data sheet 4.1.6 QOSB_SLOT_STAT3 (offset 0x134, printed page 4-64, `hi3516av200--Hi3516AV200-Datasheet.txt` line 22185).";

        field {
            name = "grp_cmd_valid_h";
            desc = "Status of bits 96-127 in the QoSBuf cmd queue. If a bit is set to 1, there are commands stored in the corresponding slot; otherwise, the slot is empty.";
            sw = r;
            hw = w;
            reset = 0x0;
        } grp_cmd_valid_h[31:0];
    } QOSB_SLOT_STAT3 @ 0x134;

    reg {
        name = "QoSBuf write buffer status register 0";
        desc = "QOSB_WBUF_STAT0 is QoSBuf write buffer status register 0. Hi3516A V200 Professional HD IP Camera SoC

Data sheet 4.1.6 QOSB_WBUF_STAT0 (offset 0x140, printed page 4-65, `hi3516av200--Hi3516AV200-Datasheet.txt` line 22217).";

        field {
            name = "buf_ldata_valid_l";
            desc = "Status of write buffers 0-31 in the QoSBuf. If a bit is set to 1, a burst is stored in the corresponding buffer; otherwise, the data amount is less than a burst or the buffer is empty.";
            sw = r;
            hw = w;
            reset = 0x0;
        } buf_ldata_valid_l[31:0];
    } QOSB_WBUF_STAT0 @ 0x140;

    reg {
        name = "QoSBuf write buffer status register 1";
        desc = "QOSB_WBUF_STAT1 is QoSBuf write buffer status register 1.

Data sheet 4.1.6 QOSB_WBUF_STAT1 (offset 0x150, printed page 4-65, `hi3516av200--Hi3516AV200-Datasheet.txt` line 22240).";

        field {
            name = "buf_ldata_valid_h";
            desc = "Status of write buffers 32-63 in the QoSBuf. If a bit is set to 1, a burst is stored in the corresponding buffer; otherwise, the data amount is less than a burst or the buffer is empty.";
            sw = r;
            hw = w;
            reset = 0x0;
        } buf_ldata_valid_h[31:0];
    } QOSB_WBUF_STAT1 @ 0x150;

    reg {
        name = "Buffer status register for the Reorder module";
        desc = "QOSB_RDRBUF_STAT is a buffer status register for the Reorder module. Hi3516A V200 Professional HD IP Camera SoC

Data sheet 4.1.6 QOSB_RDRBUF_STAT (offset 0x160, printed page 4-66, `hi3516av200--Hi3516AV200-Datasheet.txt` line 22273).";

        field {
            name = "e_vld";
            desc = "Status of reorder buffers 0-31 in the Reorder. If a bit is set to 1, a burst is stored in the corresponding buffer; otherwise, the data amount is less than a burst or the buffer is empty.";
            sw = r;
            hw = w;
            reset = 0x0;
        } e_vld[31:0];
    } QOSB_RDRBUF_STAT @ 0x160;

    reg {
        name = "QoSBuf interrupt mask register";
        desc = "QOSB_INTMSK is a QoSBuf interrupt mask register.

Data sheet 4.1.6 QOSB_INTMSK (offset 0x170, printed page 4-66, `hi3516av200--Hi3516AV200-Datasheet.txt` line 22294).";

        enum QOSB_INTMSK_qos_stat_int_mask_enum {
            MASKED = 1 { name = "Masked"; desc = "masked"; };
            ENABLED = 0 { name = "Enabled"; desc = "enabled"; };
        };

        field {
            name = "qos_stat_int_mask";
            desc = "QoSBuf command statistics interrupt mask enable";
            sw = rw;
            hw = r;
            encode = QOSB_INTMSK_qos_stat_int_mask_enum;
            reset = 0x0;
        } qos_stat_int_mask[0:0];
    } QOSB_INTMSK @ 0x170;

    reg {
        name = "QoSBuf raw interrupt register";
        desc = "QOSB_RINT is a QoSBuf raw interrupt register. Hi3516A V200 Professional HD IP Camera SoC The data sheet lists no bit fields for it.

Data sheet 4.1.6 QOSB_RINT (offset 0x174, printed page 4-67, `hi3516av200--Hi3516AV200-Datasheet.txt` line 22332).";

        field {
            name = "qos_stat_rint";
            desc = "QoSBuf command statistics raw interrupt. Writing 1 clears the interrupt.";
            sw = rw;
            hw = w;
            onwrite = woclr;
            reset = 0x0;
        } qos_stat_rint[0:0];
    } QOSB_RINT @ 0x174;

    reg {
        name = "QoSBuf interrupt status register";
        desc = "QOSB_INTSTS is a QoSBuf interrupt status register. The data sheet lists no bit fields for it.

Data sheet 4.1.6 QOSB_INTSTS (offset 0x178, printed page 4-67, `hi3516av200--Hi3516AV200-Datasheet.txt` line 22360).";

        field {
            name = "qos_stat_intsts";
            desc = "QoSBuf command statistics interrupt (raw interrupt AND NOT mask).";
            sw = r;
            hw = w;
            reset = 0x0;
        } qos_stat_intsts[0:0];
    } QOSB_INTSTS @ 0x178;

    reg {
        name = "QoSBuf command statistics register";
        desc = "QOSB_CMD_CNT is a QoSBuf command statistics register. Hi3516A V200 Professional HD IP Camera SoC The data sheet lists no bit fields for it.

Data sheet 4.1.6 QOSB_CMD_CNT (offset 0x180, printed page 4-68, `hi3516av200--Hi3516AV200-Datasheet.txt` line 22395).";

        field {
            name = "qos_cmd_cnt";
            desc = "Number of commands in the QoSBuf, including those on the pipeline.";
            sw = r;
            hw = w;
            reset = 0x0;
        } qos_cmd_cnt[7:0];
    } QOSB_CMD_CNT @ 0x180;

    reg {
        name = "QoSBuf command (in each rank) statistics register";
        desc = "QOSB_RNK_CNT is a QoSBuf command (in each rank) statistics register.

Data sheet 4.1.6 QOSB_RNK_CNT (offset 0x190, printed page 4-68, `hi3516av200--Hi3516AV200-Datasheet.txt` line 22418).";

        field {
            name = "rnk0_cmd_cnt";
            desc = "Number of rank 0 commands in the current channel in the QoSBuf";
            sw = r;
            hw = w;
            reset = 0x0;
        } rnk0_cmd_cnt[7:0];
    } QOSB_RNK_CNT @ 0x190;

    reg {
        name = "QoSBuf command (in each bank) statistics register";
        desc = "QOSB_BNK_CNT0 is a QoSBuf command (in each bank) statistics register.

Data sheet 4.1.6 QOSB_BNK_CNT0 (offset 0x1A0, printed page 4-68, `hi3516av200--Hi3516AV200-Datasheet.txt` line 22441).";

        field {
            name = "bnk3_cmd_cnt";
            desc = "Number of bank 3 commands in the current channel in the DMC";
            sw = r;
            hw = w;
            reset = 0x0;
        } bnk3_cmd_cnt[31:24];

        field {
            name = "bnk2_cmd_cnt";
            desc = "Number of bank 2 commands in the current channel in the DMC";
            sw = r;
            hw = w;
            reset = 0x0;
        } bnk2_cmd_cnt[23:16];

        field {
            name = "bnk1_cmd_cnt";
            desc = "Number of bank 1 commands in the current channel in the DMC";
            sw = r;
            hw = w;
            reset = 0x0;
        } bnk1_cmd_cnt[15:8];

        field {
            name = "bnk0_cmd_cnt";
            desc = "Number of bank 0 commands in the current channel in the DMC";
            sw = r;
            hw = w;
            reset = 0x0;
        } bnk0_cmd_cnt[7:0];
    } QOSB_BNK_CNT0 @ 0x1A0;

    reg {
        name = "QoSBuf command (in each bank) statistics register";
        desc = "QOSB_BNK_CNT1 is a QoSBuf command (in each bank) statistics register.

Data sheet 4.1.6 QOSB_BNK_CNT1 (offset 0x1B0, printed page 4-69, `hi3516av200--Hi3516AV200-Datasheet.txt` line 22476).";

        field {
            name = "bnk7_cmd_cnt";
            desc = "Number of bank 7 commands in the current channel in the DMC";
            sw = r;
            hw = w;
            reset = 0x0;
        } bnk7_cmd_cnt[31:24];

        field {
            name = "bnk6_cmd_cnt";
            desc = "Number of bank 6 commands in the current channel in the DMC";
            sw = r;
            hw = w;
            reset = 0x0;
        } bnk6_cmd_cnt[23:16];

        field {
            name = "bnk5_cmd_cnt";
            desc = "Number of bank 5 commands in the current channel in the DMC";
            sw = r;
            hw = w;
            reset = 0x0;
        } bnk5_cmd_cnt[15:8];

        field {
            name = "bnk4_cmd_cnt";
            desc = "Number of bank 4 commands in the current channel in the DMC";
            sw = r;
            hw = w;
            reset = 0x0;
        } bnk4_cmd_cnt[7:0];
    } QOSB_BNK_CNT1 @ 0x1B0;

    reg {
        name = "QoSBuf command (in each bank) statistics register";
        desc = "QOSB_BNK_CNT2 is a QoSBuf command (in each bank) statistics register.

Data sheet 4.1.6 QOSB_BNK_CNT2 (offset 0x1C0, printed page 4-69, `hi3516av200--Hi3516AV200-Datasheet.txt` line 22501).";

        field {
            name = "bnk11_cmd_cnt";
            desc = "Number of bank 11 commands in the current channel in the DMC";
            sw = r;
            hw = w;
            reset = 0x0;
        } bnk11_cmd_cnt[31:24];

        field {
            name = "bnk10_cmd_cnt";
            desc = "Number of bank 10 commands in the current channel in the DMC";
            sw = r;
            hw = w;
            reset = 0x0;
        } bnk10_cmd_cnt[23:16];

        field {
            name = "bnk9_cmd_cnt";
            desc = "Number of bank 9 commands in the current channel in the DMC";
            sw = r;
            hw = w;
            reset = 0x0;
        } bnk9_cmd_cnt[15:8];

        field {
            name = "bnk8_cmd_cnt";
            desc = "Number of bank 8 commands in the current channel in the DMC";
            sw = r;
            hw = w;
            reset = 0x0;
        } bnk8_cmd_cnt[7:0];
    } QOSB_BNK_CNT2 @ 0x1C0;

    reg {
        name = "QoSBuf command (in each bank) statistics register";
        desc = "QOSB_BNK_CNT3 is a QoSBuf command (in each bank) statistics register.

Data sheet 4.1.6 QOSB_BNK_CNT3 (offset 0x1D0, printed page 4-70, `hi3516av200--Hi3516AV200-Datasheet.txt` line 22535).";

        field {
            name = "bnk15_cmd_cnt";
            desc = "Number of bank 15 commands in the current channel in the DMC";
            sw = r;
            hw = w;
            reset = 0x0;
        } bnk15_cmd_cnt[31:24];

        field {
            name = "bnk14_cmd_cnt";
            desc = "Number of bank 14 commands in the current channel in the DMC";
            sw = r;
            hw = w;
            reset = 0x0;
        } bnk14_cmd_cnt[23:16];

        field {
            name = "bnk13_cmd_cnt";
            desc = "Number of bank 13 commands in the current channel in the DMC";
            sw = r;
            hw = w;
            reset = 0x0;
        } bnk13_cmd_cnt[15:8];

        field {
            name = "bnk12_cmd_cnt";
            desc = "Number of bank 12 commands in the current channel in the DMC";
            sw = r;
            hw = w;
            reset = 0x0;
        } bnk12_cmd_cnt[7:0];
    } QOSB_BNK_CNT3 @ 0x1D0;

    reg {
        name = "QoSBuf OSTD command (in each channel) statistics register";
        desc = "QOSB_OSTD_CNT is a QoSBuf OSTD command (in each channel) statistics register.

Data sheet 4.1.6 QOSB_OSTD_CNT (offset 0x1E0, printed page 4-70, `hi3516av200--Hi3516AV200-Datasheet.txt` line 22557).";

        field {
            name = "ch1_cmd_ostd";
            desc = "Number of OSTD commands in channel 1 in the QoSBuf";
            sw = r;
            hw = w;
            reset = 0x0;
        } ch1_cmd_ostd[15:8];

        field {
            name = "ch0_cmd_ostd";
            desc = "Number of OSTD commands in channel 0 in the QoSBuf";
            sw = r;
            hw = w;
            reset = 0x0;
        } ch0_cmd_ostd[7:0];
    } QOSB_OSTD_CNT @ 0x1E0;

    reg {
        name = "QoSBuf accumulated write command count register";
        desc = "QOSB_WR_CMD_SUM is a QoSBuf accumulated write command count register. Hi3516A V200 Professional HD IP Camera SoC

Data sheet 4.1.6 QOSB_WR_CMD_SUM (offset 0x1E4, printed page 4-71, `hi3516av200--Hi3516AV200-Datasheet.txt` line 22588).";

        field {
            name = "qos_wr_cmd_sum";
            desc = "Accumulated value of the write commands that are temporarily stored in the QoSBuf in the cycle. The value is wrapped if an overflow occurs.";
            sw = r;
            hw = w;
            reset = 0x0;
        } qos_wr_cmd_sum[31:0];
    } QOSB_WR_CMD_SUM @ 0x1E4;

    reg {
        name = "QoSBuf accumulated read command count register";
        desc = "QOSB_RD_CMD_SUM is a QoSBuf accumulated read command count register.

Data sheet 4.1.6 QOSB_RD_CMD_SUM (offset 0x1E8, printed page 4-71, `hi3516av200--Hi3516AV200-Datasheet.txt` line 22608).";

        field {
            name = "qos_rd_cmd_sum";
            desc = "Accumulated value of the read commands that are temporarily stored in the QoSBuf in the cycle. The value is wrapped if an overflow occurs.";
            sw = r;
            hw = w;
            reset = 0x0;
        } qos_rd_cmd_sum[31:0];
    } QOSB_RD_CMD_SUM @ 0x1E8;

    reg {
        name = "QoSBuf timeout mode selection register";
        desc = "QOSB_TIMEOUT_MODE is a QoSBuf timeout mode selection register. Hi3516A V200 Professional HD IP Camera SoC

Data sheet 4.1.6 QOSB_TIMEOUT_MODE (offset 0x1F0, printed page 4-72, `hi3516av200--Hi3516AV200-Datasheet.txt` line 22638).";

        enum QOSB_TIMEOUT_MODE_timeout_mode_enum {
            TIMEOUT_MODE_MAPPED = 0 { name = "Timeout Mode Mapped"; desc = "The timeout mode is mapped by using the ID and there are 16 levels of timeout periods. For details about the definition of each level, see QOSB_WRTOUT0 to QOSB_WRTOUT3 or QOSB_RDTOUT0 to QOSB_RDTOUT3."; };
            TIMEOUT_MODE_MAPPED_2 = 1 { name = "Timeout Mode Mapped 2"; desc = "The timeout mode is mapped by using the priority and there are eight levels of timeout periods. The levels in the priority mapping table are the same as the lower eight levels in the ID mapping table."; };
        };

        field {
            name = "timeout_mode";
            desc = "Read/Write command timeout mapping mode select";
            sw = rw;
            hw = r;
            encode = QOSB_TIMEOUT_MODE_timeout_mode_enum;
            reset = 0x0;
        } timeout_mode[0:0];
    } QOSB_TIMEOUT_MODE @ 0x1F0;

    reg {
        name = "QoSBuf write buffer priority adjustment control register";
        desc = "QOSB_WBUF_PRI_CTRL is a QoSBuf write buffer priority adjustment control register.

Data sheet 4.1.6 QOSB_WBUF_PRI_CTRL (offset 0x1F4, printed page 4-72, `hi3516av200--Hi3516AV200-Datasheet.txt` line 22673).";

        field {
            name = "wbuf_hcnt";
            desc = "The value of this field is used by the internal counter only when the number of write commands reaches the value of QOSB_WBUF_CTRL[wbuf_lvl2] (write buffer threshold 2). When the number reaches wbuf_lvl2, the internal counter starts counting. The priorities of the write commands in the write buffer are increased to pri2 until the count value reaches wbuf_hcnt. Note: pri2 indicates the priority of the write buffer threshold 2. For details, see QOSB_WBUF_CTRL[wbuf_pri2].";
            sw = rw;
            hw = r;
            reset = 0x20;
        } wbuf_hcnt[31:16];

        field {
            name = "wbuf_lcnt";
            desc = "The value of this field is used by the internal counter only when the number of write commands reaches the value of QOSB_WBUF_CTRL[wbuf_lvl2] (write buffer threshold 2) and the count value has already reached wbuf_hcnt. When the count value reaches wbuf_hcnt, the internal counter starts counting again. The priorities of the write commands are increased to pril1 until the count value reaches wbuf_lcnt. If the count value is 0, the priorities of the write commands are always pri2. Note: pri1 indicates the priority of the write buffer threshold 1. For details, see QOSB_WBUF_CTRL[wbuf_pri1].";
            sw = rw;
            hw = r;
            reset = 0x0;
        } wbuf_lcnt[15:0];
    } QOSB_WBUF_PRI_CTRL @ 0x1F4;

    reg {
        name = "QoSBuf row-hit priority adjustment control register";
        desc = "QOSB_RHIT_CTRL is a QoSBuf row-hit priority adjustment control register.

Data sheet 4.1.6 QOSB_RHIT_CTRL (offset 0x1F8, printed page 4-73, `hi3516av200--Hi3516AV200-Datasheet.txt` line 22719).";

        field {
            name = "rhit_hcnt";
            desc = "Time allowed to maintain the row-hit command stream Note: The row-hit command stream is forcibly disconnected when the time for maintaining the row-hit command stream reaches rhit_hcnt. Then the internal counter starts counting again, and the row-hit command stream is allowed to raise the arbitration request until the count value reaches rhit_lcnt.";
            sw = rw;
            hw = r;
            reset = 0xFF;
        } rhit_hcnt[31:16];

        field {
            name = "rhit_lcnt";
            desc = "Duration that the row-hit command stream is disconnected Note: The row-hit command stream is forcibly disconnected when the time for maintaining the row-hit command stream reaches rhit_hcnt. Then the internal counter starts counting again, and the row-hit command stream is allowed to raise the arbitration request until the count value reaches rhit_lcnt.";
            sw = rw;
            hw = r;
            reset = 0xF;
        } rhit_lcnt[15:0];
    } QOSB_RHIT_CTRL @ 0x1F8;

};

regfile eHISI_MDDRC_DMC {
    name = "MDDRC DMC registers";
    desc = "DMC (DDR memory controller) registers of the MDDRC (data sheet 4.1.7, Table 4-12, DMC0 base 0x1206_8000, 73 registers): self-refresh / SFC / performance control, SDRAM configuration (self-refresh, initialisation, power-down, auto-refresh, work mode, DDR mode, scrambling, rank volume, ODT, EMRS01..67, TIMING0-7), bulk data, DMC level, DDR PHY interface, software-configuration (SFC) command interface, data / command statistics thresholds, interrupts, current status and history (flux / latency / command) counters, SFC read data. The rnks variable is 0 only (one rank). Compared with eHISI_DDRC_V2 the registers were renumbered (CFG_TIMING1 at 0x84 but TIMING0/2-7 at 0x100-0x11C, EMRS at 0xF0-0xFC, CFG_ODT at 0xA0) and CFG_INIT / CFG_WORKMODE2 / CFG_SCRAMB / STADAT-CMDMAX / STAT_RPT / HIS_DAT_SUM / CURR_FUNC2 added.";

    reg {
        name = "DDR self-refresh control register";
        desc = "DDRC_CTRL_SREF is a DDR self-refresh control register.

Data sheet 4.1.7 DDRC_CTRL_SREF (offset 0x0, printed page 4-78, `hi3516av200--Hi3516AV200-Datasheet.txt` line 22986).";

        enum DDRC_CTRL_SREF_sref_done_enum {
            NORMAL_OPERATING_MODE = 0 { name = "Normal Operating Mode"; desc = "normal operating mode"; };
            TRANSITION_FROM_0 = 1 { name = "Transition From 0"; desc = "The transition from 0 to 1 indicates that the DDR PHY completes all required operations after exiting the self-refresh status and the DMC can accept new requests."; };
        };

        field {
            name = "sref_done";
            desc = "DDR PHY self-refresh done";
            sw = rw;
            hw = r;
            encode = DDRC_CTRL_SREF_sref_done_enum;
            reset = 0x0;
        } sref_done[1:1];

        enum DDRC_CTRL_SREF_sref_req_enum {
            EXIT_SELF_REFRESH = 0 { name = "Exit Self Refresh"; desc = "exit the self-refresh status"; };
            ENTER_SELF_REFRESH = 1 { name = "Enter Self Refresh"; desc = "enter the self-refresh status"; };
        };

        field {
            name = "sref_req";
            desc = "SDRAM self-refresh request";
            sw = rw;
            hw = r;
            encode = DDRC_CTRL_SREF_sref_req_enum;
            reset = 0x1;
        } sref_req[0:0];
    } DDRC_CTRL_SREF @ 0x0;

    reg {
        name = "DDRC software configuration command start register";
        desc = "DDRC_CTRL_SFC is a DDRC software configuration command start register.

Data sheet 4.1.7 DDRC_CTRL_SFC (offset 0xC, printed page 4-79, `hi3516av200--Hi3516AV200-Datasheet.txt` line 23024).";

        enum DDRC_CTRL_SFC_cmd_req_enum {
            COMMAND_NOT_EXECUTED = 0 { name = "Command Not Executed"; desc = "The command is not executed or the parameter is automatically cleared after the command is executed."; };
            COMMAND_REQUESTED_EXECUTED = 1 { name = "Command Requested Executed"; desc = "The command is requested to be executed."; };
        };

        field {
            name = "cmd_req";
            desc = "Request of executing the configuration command of the DDRC";
            sw = rw;
            hw = r;
            encode = DDRC_CTRL_SFC_cmd_req_enum;
            reset = 0x0;
        } cmd_req[0:0];
    } DDRC_CTRL_SFC @ 0xC;

    reg {
        name = "DDRC performance statistics enable register";
        desc = "DDRC_CTRL_PERF is a DDRC performance statistics enable register.

Data sheet 4.1.7 DDRC_CTRL_PERF (offset 0x10, printed page 4-79, `hi3516av200--Hi3516AV200-Datasheet.txt` line 23053).";

        field {
            name = "reserved_nz_31_1";
            desc = "Reserved in the bit table, but the data sheet total reset value of this register has these bits set (reset 0xA7800).";
            sw = r;
            hw = w;
            reset = 0x000A7800;
        } reserved_nz_31_1[31:1];

        enum DDRC_CTRL_PERF_perf_en_enum {
            DISABLED = 0 { name = "Disabled"; desc = "disabled"; };
            ENABLED = 1 { name = "Enabled"; desc = "enabled"; };
        };

        field {
            name = "perf_en";
            desc = "Performance statistics mode";
            sw = rw;
            hw = r;
            encode = DDRC_CTRL_PERF_perf_en_enum;
            reset = 0x0;
        } perf_en[0:0];
    } DDRC_CTRL_PERF @ 0x10;

    reg {
        name = "AXI operating mode register";
        desc = "DDRC_CFG_SREF is a DDRC self-refresh configuration register.

Data sheet 4.1.7 DDRC_CFG_SREF (offset 0x20, printed page 4-80, `hi3516av200--Hi3516AV200-Datasheet.txt` line 23089).";

        enum DDRC_CFG_SREF_asref_en_enum {
            DISABLED = 0x0 { name = "Disabled"; desc = "disabled"; };
            ENABLED = 0x1 { name = "Enabled"; desc = "enabled"; };
        };

        field {
            name = "asref_en";
            desc = "SDRAM automatic self-refresh enable";
            sw = r;
            hw = w;
            encode = DDRC_CFG_SREF_asref_en_enum;
            reset = 0x0;
        } asref_en[31:16];

        field {
            name = "sref_arefnum";
            desc = "This function is not supported in this version. Number of self-refresh operations initiated after DDR3/DDR4/LPDDR3 SDRAM exits the self-refresh status during the DFS process 0x0: No self-refresh operation is initiated. 0x1-0xF: n";
            sw = rw;
            hw = r;
            reset = 0x0;
        } sref_arefnum[15:12];

        enum DDRC_CFG_SREF_clk_switch_enum {
            INTERFACE_COMMANDS_NOT = 0 { name = "Interface Commands Not"; desc = "The interface commands are not back pressed, and an error is returned directly."; };
            INTERFACE_COMMANDS_BACK = 1 { name = "Interface Commands Back"; desc = "The interface commands are back pressed, and the original command is executed after the clock is switched."; };
        };

        field {
            name = "clk_switch";
            desc = "DDRC low-power clock switch. Whether to back press AXI interface command when the DDRC enters the low-power status (DDR self-refresh)";
            sw = rw;
            hw = r;
            encode = DDRC_CFG_SREF_clk_switch_enum;
            reset = 0x0;
        } clk_switch[8:8];

        enum DDRC_CFG_SREF_sref_odis_enum {
            ENABLED = 0 { name = "Enabled"; desc = "enabled"; };
            DISABLED = 1 { name = "Disabled"; desc = "disabled"; };
        };

        field {
            name = "sref_odis";
            desc = "Output disable for the DDR command and data I/O in self-refresh mode";
            sw = rw;
            hw = r;
            encode = DDRC_CFG_SREF_sref_odis_enum;
            reset = 0x0;
        } sref_odis[4:4];

        enum DDRC_CFG_SREF_asref_fast_wakeup_enum {
            ENABLED = 0 { name = "Enabled"; desc = "enabled"; };
            DISABLED = 1 { name = "Disabled"; desc = "disabled"; };
        };

        field {
            name = "asref_fast_wakeup";
            desc = "Enable/disable of the AUTO SELFREFRESH fast wakeup";
            sw = rw;
            hw = r;
            encode = DDRC_CFG_SREF_asref_fast_wakeup_enum;
            reset = 0x0;
        } asref_fast_wakeup[1:1];

        enum DDRC_CFG_SREF_sref_cc_enum {
            SDRAM_CLOCK_ENABLED = 0 { name = "Sdram Clock Enabled"; desc = "The SDRAM clock is enabled."; };
            SDRAM_CLOCK_DISABLED = 1 { name = "Sdram Clock Disabled"; desc = "The SDRAM clock is disabled."; };
        };

        field {
            name = "sref_cc";
            desc = "SDRAM clock control in self-refresh mode";
            sw = rw;
            hw = r;
            encode = DDRC_CFG_SREF_sref_cc_enum;
            reset = 0x0;
        } sref_cc[0:0];
    } DDRC_CFG_SREF @ 0x20;

    reg {
        name = "DDR initialization configuration register";
        desc = "DDRC_CFG_INIT is a DDR initialization configuration register.

Data sheet 4.1.7 DDRC_CFG_INIT (offset 0x24, printed page 4-81, `hi3516av200--Hi3516AV200-Datasheet.txt` line 23164).";

        field {
            name = "init_arefnum";
            desc = "Number of auto-refresh operations when the DDR3/DDR4 SDRAM is being initialized 0x0-0x2: two 0x3-0xF: n";
            sw = rw;
            hw = r;
            reset = 0x0;
        } init_arefnum[7:0];
    } DDRC_CFG_INIT @ 0x24;

    reg {
        name = "DDR power-down status register";
        desc = "DDRC_CFG_PD is a DDR power-down status register. Hi3516A V200 Professional HD IP Camera SoC

Data sheet 4.1.7 DDRC_CFG_PD (offset 0x28, printed page 4-82, `hi3516av200--Hi3516AV200-Datasheet.txt` line 23202).";

        field {
            name = "asref_prd";
            desc = "SDRAM self-refresh cycle. When the DDRC does not receive any command in consecutive asref_prd cycles, it forces the SDRAM to enter the self-refresh status. When a command is received, the DDRC forces the SDRAM to exit the self-refresh status. 0x0-0xFFF: (n x 16) clock cycles";
            sw = r;
            hw = w;
            reset = 0x0;
        } asref_prd[31:20];

        field {
            name = "t_clk_cke";
            desc = "Relationship between CLK and CKE 0x0-0x7: Delay relative to CKE when the DDR PHY disables the DDR clock. The delay is related to the DDR PHY.";
            sw = rw;
            hw = r;
            reset = 0x0;
        } t_clk_cke[19:16];

        field {
            name = "pd_prd";
            desc = "SDRAM power-down cycle. When the DDRC does not receive any command in consecutive pd_prd cycles, it forces the SDRAM to enter the power-down status. When a command is received, the DDRC forces the SDRAM to exit the power-down status. 0x00: not enter the power-down status 0x01-0xFFF: n clock cycles";
            sw = rw;
            hw = r;
            reset = 0x0;
        } pd_prd[15:4];

        enum DDRC_CFG_PD_pd_cc_enum {
            SDRAM_CLOCK_ENABLED = 0 { name = "Sdram Clock Enabled"; desc = "The SDRAM clock is enabled."; };
            SDRAM_CLOCK_DISABLED = 1 { name = "Sdram Clock Disabled"; desc = "The SDRAM clock is disabled."; };
        };

        field {
            name = "pd_cc";
            desc = "SDRAM clock control in power-down mode";
            sw = rw;
            hw = r;
            encode = DDRC_CFG_PD_pd_cc_enum;
            reset = 0x0;
        } pd_cc[2:2];

        enum DDRC_CFG_PD_pd_ac_enum {
            ENABLE_PIN_OUTPUT = 0 { name = "Enable Pin Output"; desc = "enable the pin output"; };
            DISABLE_PIN_OUTPUT = 1 { name = "Disable Pin Output"; desc = "disable the pin output"; };
        };

        field {
            name = "pd_ac";
            desc = "SDRAM address command dynamic disable in power-down mode";
            sw = rw;
            hw = r;
            encode = DDRC_CFG_PD_pd_ac_enum;
            reset = 0x0;
        } pd_ac[1:1];

        enum DDRC_CFG_PD_pd_en_enum {
            ENABLED = 1 { name = "Enabled"; desc = "enabled"; };
            DISABLED = 0 { name = "Disabled"; desc = "disabled"; };
        };

        field {
            name = "pd_en";
            desc = "Automatic power-down enable for the SDRAM";
            sw = rw;
            hw = r;
            encode = DDRC_CFG_PD_pd_en_enum;
            reset = 0x0;
        } pd_en[0:0];
    } DDRC_CFG_PD @ 0x28;

    reg {
        name = "DDRC auto-refresh mode register";
        desc = "DDRC_CFG_AREF is a DDRC auto-refresh mode register.

Data sheet 4.1.7 DDRC_CFG_AREF (offset 0x2C, printed page 4-83, `hi3516av200--Hi3516AV200-Datasheet.txt` line 23281).";

        field {
            name = "aref_alarm_num";
            desc = "The auto-refresh command is forced to be transmitted if a specific number of auto-refresh commands cannot be transmitted. 0x0-0xFF: lack of (n + 1) auto-refresh commands";
            sw = rw;
            hw = r;
            reset = 0x0;
        } aref_alarm_num[15:8];

        enum DDRC_CFG_AREF_pstpnd_level_enum {
            V_8 = 3 { name = "V 8"; desc = "8"; };
            V_4 = 2 { name = "V 4"; desc = "4"; };
            V_2 = 1 { name = "V 2"; desc = "2"; };
            V_1 = 0 { name = "V 1"; desc = "1"; };
        };

        field {
            name = "pstpnd_level";
            desc = "Threshold for the number of postponed commands in optimized auto-refresh mode";
            sw = rw;
            hw = r;
            encode = DDRC_CFG_AREF_pstpnd_level_enum;
            reset = 0x0;
        } pstpnd_level[6:5];

        enum DDRC_CFG_AREF_aref_alarm_en_enum {
            DISABLED = 0 { name = "Disabled"; desc = "disabled"; };
            ENABLED = 1 { name = "Enabled"; desc = "enabled"; };
        };

        field {
            name = "aref_alarm_en";
            desc = "Auto-refresh loss alarm enable (AREF function)";
            sw = rw;
            hw = r;
            encode = DDRC_CFG_AREF_aref_alarm_en_enum;
            reset = 0x0;
        } aref_alarm_en[4:4];

        enum DDRC_CFG_AREF_aref_dual_rank_enum {
            REF_COMMANDS_TRANSMITTED = 0 { name = "Ref Commands Transmitted"; desc = "The REF commands are transmitted to only one rank each time."; };
            REF_COMMANDS_TRANSMITTED_2 = 1 { name = "Ref Commands Transmitted 2"; desc = "The REF commands are transmitted to two ranks each time."; };
        };

        field {
            name = "aref_dual_rank";
            desc = "REF command transmit mode select";
            sw = rw;
            hw = r;
            encode = DDRC_CFG_AREF_aref_dual_rank_enum;
            reset = 0x0;
        } aref_dual_rank[3:3];

        enum DDRC_CFG_AREF_aref_opt_enum {
            DISABLED = 0 { name = "Disabled"; desc = "disabled"; };
            ENABLED_WHEN_THIS = 1 { name = "Enabled When This"; desc = "enabled When this function is enabled, it is recommended that aref_mode be set to 00. The DMC dynamically detects whether the DDR is idle during each auto-refresh. If the DDR is idle, the AREF commands are transmitted; otherwise, the DMC waits until nine AREF cycles are reached. Then the DMC forcibly terminates the DDR access and inserts AREF commands."; };
        };

        field {
            name = "aref_opt";
            desc = "Auto-refresh optimization enable";
            sw = rw;
            hw = r;
            encode = DDRC_CFG_AREF_aref_opt_enum;
            reset = 0x0;
        } aref_opt[2:2];

        field {
            name = "aref_mode";
            desc = "Auto-refresh mode 00: An auto-refresh operation is performed every one tREFI cycle. 01: Three auto-refresh operations are performed every four tREFI cycles. 10: Four auto-refresh operations are performed every five tREFI cycles. 11: Eight auto-refresh operations are performed every nine tREFI cycles. Optimized auto-refresh mode 00: The maximum number of postponed commands is 1. 01: The maximum number of postponed commands is 2. 10: The maximum number of postponed commands is 4. 11: The maximum number of postponed commands is 8.";
            sw = rw;
            hw = r;
            reset = 0x0;
        } aref_mode[1:0];
    } DDRC_CFG_AREF @ 0x2C;

    reg {
        name = "DDRC operating mode register";
        desc = "DDRC_CFG_WORKMODE is a DDRC operating mode register. Hi3516A V200 Professional HD IP Camera SoC

Data sheet 4.1.7 DDRC_CFG_WORKMODE (offset 0x40, printed page 4-85, `hi3516av200--Hi3516AV200-Datasheet.txt` line 23378).";

        enum DDRC_CFG_WORKMODE_hdr_mode_enum {
            SDR_MODE = 0 { name = "Sdr Mode"; desc = "SDR mode"; };
            HDR_MODE_HI3519 = 1 { name = "Hdr Mode Hi3519"; desc = "HDR mode The Hi3519 V101 supports only the HDR mode."; };
        };

        field {
            name = "hdr_mode";
            desc = "DFI interface mode select";
            sw = rw;
            hw = r;
            encode = DDRC_CFG_WORKMODE_hdr_mode_enum;
            reset = 0x0;
        } hdr_mode[13:13];

        enum DDRC_CFG_WORKMODE_read_mode_enum {
            ASSOCIATED_READ_MODE = 0 { name = "Associated Read Mode"; desc = "associated read mode"; };
            DELAY_READ_MODE = 1 { name = "Delay Read Mode"; desc = "delay read mode The associated read mode is a mode in which the DDRC samples data based on the data valid signal from the PHY. The delay read mode is a mode in which the DDRC samples the data from the PHY after the internal delay of the DDRC."; };
        };

        field {
            name = "read_mode";
            desc = "DDRC read mode";
            sw = rw;
            hw = r;
            encode = DDRC_CFG_WORKMODE_read_mode_enum;
            reset = 0x0;
        } read_mode[12:12];

        enum DDRC_CFG_WORKMODE_addr_mode_enum {
            ADDRESS_SET_ALL = 0 { name = "Address Set All"; desc = "The address is set to all 1s when the DDR is idle."; };
            STATUS_PREVIOUS_COMMAND = 1 { name = "Status Previous Command"; desc = "The status of the previous command is retained when the DDR is idle."; };
            STATUS_OPPOSITE_PREVIOUS = 2 { name = "Status Opposite Previous"; desc = "The status opposite to the previous status is restored when the DDR is idle."; };
            RESERVED = 3 { name = "Reserved"; desc = "reserved"; };
        };

        field {
            name = "addr_mode";
            desc = "DDR address line reverse mode select";
            sw = rw;
            hw = r;
            encode = DDRC_CFG_WORKMODE_addr_mode_enum;
            reset = 0x0;
        } addr_mode[11:10];

        enum DDRC_CFG_WORKMODE_intlv_en_enum {
            DISABLED = 0 { name = "Disabled"; desc = "disabled"; };
            ENABLED_DDR4_MODE = 1 { name = "Enabled Ddr4 Mode"; desc = "enabled In DDR4 mode, the performance is best when this field is set to 1. In other modes, it is recommended that this field be set to 0."; };
        };

        field {
            name = "intlv_en";
            desc = "DMC burst interleave enable";
            sw = rw;
            hw = r;
            encode = DDRC_CFG_WORKMODE_intlv_en_enum;
            reset = 0x0;
        } intlv_en[9:9];

        enum DDRC_CFG_WORKMODE_wrap_en_enum {
            DISABLED = 0 { name = "Disabled"; desc = "disabled"; };
            ENABLED = 1 { name = "Enabled"; desc = "enabled"; };
        };

        field {
            name = "wrap_en";
            desc = "Wrap command optimization enable";
            sw = rw;
            hw = r;
            encode = DDRC_CFG_WORKMODE_wrap_en_enum;
            reset = 0x0;
        } wrap_en[8:8];

        enum DDRC_CFG_WORKMODE_apre_en_enum {
            DISABLED = 0 { name = "Disabled"; desc = "disabled"; };
            ENABLED = 1 { name = "Enabled"; desc = "enabled"; };
        };

        field {
            name = "apre_en";
            desc = "Auto-precharge enable";
            sw = rw;
            hw = r;
            encode = DDRC_CFG_WORKMODE_apre_en_enum;
            reset = 0x0;
        } apre_en[4:4];

        enum DDRC_CFG_WORKMODE_func_clkon_enum {
            CLOCK_INTERNALLY_CONTROLLED = 0 { name = "Clock Internally Controlled"; desc = "The clock is internally controlled."; };
            CLOCK_FORCIBLY_ENABLED = 1 { name = "Clock Forcibly Enabled"; desc = "The clock is forcibly enabled."; };
        };

        field {
            name = "func_clkon";
            desc = "Functional module clock enable";
            sw = rw;
            hw = r;
            encode = DDRC_CFG_WORKMODE_func_clkon_enum;
            reset = 0x0;
        } func_clkon[3:3];

        enum DDRC_CFG_WORKMODE_data_clkon_enum {
            CLOCK_INTERNALLY_CONTROLLED = 0 { name = "Clock Internally Controlled"; desc = "The clock is internally controlled."; };
            CLOCK_FORCIBLY_ENABLED = 1 { name = "Clock Forcibly Enabled"; desc = "The clock is forcibly enabled."; };
        };

        field {
            name = "data_clkon";
            desc = "Data channel clock enable";
            sw = rw;
            hw = r;
            encode = DDRC_CFG_WORKMODE_data_clkon_enum;
            reset = 0x0;
        } data_clkon[2:2];

        enum DDRC_CFG_WORKMODE_cmd_clkon_enum {
            CLOCK_INTERNALLY_CONTROLLED = 0 { name = "Clock Internally Controlled"; desc = "The clock is internally controlled."; };
            CLOCK_FORCIBLY_ENABLED = 1 { name = "Clock Forcibly Enabled"; desc = "The clock is forcibly enabled."; };
        };

        field {
            name = "cmd_clkon";
            desc = "Command channel clock enable";
            sw = rw;
            hw = r;
            encode = DDRC_CFG_WORKMODE_cmd_clkon_enum;
            reset = 0x0;
        } cmd_clkon[1:1];

        enum DDRC_CFG_WORKMODE_clk_ratio_enum {
            RATIO_DDRC_FREQUENCY = 0 { name = "Ratio Ddrc Frequency"; desc = "The ratio of the DDRC frequency to the PHY frequency is 1:1."; };
            RATIO_FREQUENCY_DDRC = 1 { name = "Ratio Frequency Ddrc"; desc = "The ratio of the frequency of the DDRC to the frequency of the PHY is 1:2."; };
        };

        field {
            name = "clk_ratio";
            desc = "Operating mode of the DDRC";
            sw = rw;
            hw = r;
            encode = DDRC_CFG_WORKMODE_clk_ratio_enum;
            reset = 0x0;
        } clk_ratio[0:0];
    } DDRC_CFG_WORKMODE @ 0x40;

    reg {
        name = "DDRC operating mode register";
        desc = "DDRC_CFG_WORKMODE2 is a DDRC operating mode register.

Data sheet 4.1.7 DDRC_CFG_WORKMODE2 (offset 0x44, printed page 4-86, `hi3516av200--Hi3516AV200-Datasheet.txt` line 23463).";

        field {
            name = "openpage_time";
            desc = "Open page delay control 0x0-0x1: The open page function is disabled. 0x2-0x3fff: open page delay";
            sw = rw;
            hw = r;
            reset = 0x0;
        } openpage_time[29:16];

        enum DDRC_CFG_WORKMODE2_rank_disable_enum {
            NORMAL_OPERATING_MODE = 0x0 { name = "Normal Operating Mode"; desc = "normal operating mode"; };
            AUTO_REFRESH_POWER = 0x1 { name = "Auto Refresh Power"; desc = "The auto-refresh/power-down/self-refresh function of a rank is disabled."; };
        };

        field {
            name = "rank_disable";
            desc = "Rank disable";
            sw = rw;
            hw = r;
            encode = DDRC_CFG_WORKMODE2_rank_disable_enum;
            reset = 0x0;
        } rank_disable[15:0];
    } DDRC_CFG_WORKMODE2 @ 0x44;

    reg {
        name = "DDRC operating mode register";
        desc = "DDRC_CFG_DDRMODE is a DDRC operating mode register. The data sheet bit table prints a stale second row set for bits [7:4] ('[7:5] reserved, [4] apre_en'); the Name row and the vendor U-Boot ddr_ddrc_v510.h (DMC_MEM_WIDTH_BIT 4, mask 0x3) give brstlen2 [7] and mem_width [5:4], kept here. The Name row also prints cmd_2t_en at bit 11, which the bit table lists as reserved ('must be fixed at 1'b0').

Data sheet 4.1.7 DDRC_CFG_DDRMODE (offset 0x50, printed page 4-87, `hi3516av200--Hi3516AV200-Datasheet.txt` line 23509).";

        field {
            name = "bank_mode";
            desc = "Bank interleaving mode For 8-bit bus width: 000: 8-byte banks are interleaved. 001: 16-byte banks are interleaved. … 111: 1 KB banks are interleaved. For 16-bit bus width: 000: 16-byte banks are interleaved. 001: 32-byte banks are interleaved. … 111: 2 KB banks are interleaved. For 32-bit bus width: 000: 32-byte banks are interleaved. 001: 64-byte banks are interleaved. … 111: 4 KB banks are interleaved. For 64-bit bus width: 000: 64-byte banks are interleaved. 001: 128-byte banks are interleaved. … 111: 8 KB banks are interleaved.";
            sw = rw;
            hw = r;
            reset = 0x0;
        } bank_mode[30:28];

        enum DDRC_CFG_DDRMODE_bank_xor_enum {
            DISABLED = 0 { name = "Disabled"; desc = "disabled"; };
            BANK_ADDRESS_OFFSET = 1 { name = "Bank Address Offset"; desc = "The bank address and offset address 0 are scrambled."; };
            BANK_ADDRESS_OFFSET_2 = 2 { name = "Bank Address Offset 2"; desc = "The bank address and offset address 1 are scrambled."; };
            BANK_ADDRESS_OFFSET_3 = 3 { name = "Bank Address Offset 3"; desc = "The bank address and offset address 2 are scrambled."; };
        };

        field {
            name = "bank_xor";
            desc = "Scrambling enable for the bank address and row address";
            sw = rw;
            hw = r;
            encode = DDRC_CFG_DDRMODE_bank_xor_enum;
            reset = 0x0;
        } bank_xor[25:24];

        enum DDRC_CFG_DDRMODE_asref_zqc_en_enum {
            DISABLED = 0 { name = "Disabled"; desc = "disabled"; };
            ENABLED = 1 { name = "Enabled"; desc = "enabled"; };
        };

        field {
            name = "asref_zqc_en";
            desc = "SDRAM ZQ enable when the ASREF exits.";
            sw = rw;
            hw = r;
            encode = DDRC_CFG_DDRMODE_asref_zqc_en_enum;
            reset = 0x0;
        } asref_zqc_en[23:23];

        enum DDRC_CFG_DDRMODE_sref_zqc_en_enum {
            DISABLED = 0 { name = "Disabled"; desc = "disabled"; };
            ENABLED = 1 { name = "Enabled"; desc = "enabled"; };
        };

        field {
            name = "sref_zqc_en";
            desc = "SDRAM ZQ enable when the SREF exits.";
            sw = rw;
            hw = r;
            encode = DDRC_CFG_DDRMODE_sref_zqc_en_enum;
            reset = 0x0;
        } sref_zqc_en[22:22];

        enum DDRC_CFG_DDRMODE_rank_enum {
            V_1 = 0 { name = "V 1"; desc = "1"; };
            V_2 = 1 { name = "V 2"; desc = "2"; };
            V_3 = 2 { name = "V 3"; desc = "3"; };
            V_4 = 3 { name = "V 4"; desc = "4"; };
        };

        field {
            name = "rank";
            desc = "Number of DDRC ranks";
            sw = rw;
            hw = r;
            encode = DDRC_CFG_DDRMODE_rank_enum;
            reset = 0x0;
        } rank[21:20];

        enum DDRC_CFG_DDRMODE_rank_mode_enum {
            SINGLE_RANK_MODE = 0 { name = "Single Rank Mode"; desc = "single rank mode"; };
            SINGLE_RANK_MODE_2 = 1 { name = "Single Rank Mode 2"; desc = "single rank mode"; };
            TWO_RANKS_INTERLEAVED = 2 { name = "Two Ranks Interleaved"; desc = "Two ranks are interleaved."; };
            FOUR_RANKS_INTERLEAVED = 3 { name = "Four Ranks Interleaved"; desc = "Four ranks are interleaved."; };
        };

        field {
            name = "rank_mode";
            desc = "Rank interleaving mode";
            sw = rw;
            hw = r;
            encode = DDRC_CFG_DDRMODE_rank_mode_enum;
            reset = 0x0;
        } rank_mode[19:18];

        enum DDRC_CFG_DDRMODE_odt_on_enum {
            SIGNAL_AUTOMATICALLY_CONTROLLE = 0 { name = "Signal Automatically Controlle"; desc = "The signal is automatically controlled by the DDRC."; };
            OUTPUT_FIXED_AT = 1 { name = "Output Fixed At"; desc = "The output is fixed at the wodt configuration of rank 0."; };
        };

        field {
            name = "odt_on";
            desc = "Whether the ODT signal output to the SDRAM is fixed";
            sw = rw;
            hw = r;
            encode = DDRC_CFG_DDRMODE_odt_on_enum;
            reset = 0x0;
        } odt_on[17:17];

        enum DDRC_CFG_DDRMODE_zqc_en_enum {
            DISABLED = 0 { name = "Disabled"; desc = "disabled"; };
            ENABLED = 1 { name = "Enabled"; desc = "enabled"; };
        };

        field {
            name = "zqc_en";
            desc = "AREF ZQ command enable";
            sw = rw;
            hw = r;
            encode = DDRC_CFG_DDRMODE_zqc_en_enum;
            reset = 0x0;
        } zqc_en[16:16];

        enum DDRC_CFG_DDRMODE_scramb_en_enum {
            DISABLED = 0 { name = "Disabled"; desc = "disabled"; };
            ENABLED = 1 { name = "Enabled"; desc = "enabled"; };
        };

        field {
            name = "scramb_en";
            desc = "Data scrambling enable (The scrambling code is generated by using the address, and exclusive ORed with the data to reduce synchronous inversion).";
            sw = rw;
            hw = r;
            encode = DDRC_CFG_DDRMODE_scramb_en_enum;
            reset = 0x0;
        } scramb_en[14:14];

        enum DDRC_CFG_DDRMODE_dbi_en_enum {
            DISABLED = 0 { name = "Disabled"; desc = "disabled"; };
            ENABLED = 1 { name = "Enabled"; desc = "enabled"; };
        };

        field {
            name = "dbi_en";
            desc = "DDR4 DBI enable";
            sw = rw;
            hw = r;
            encode = DDRC_CFG_DDRMODE_dbi_en_enum;
            reset = 0x0;
        } dbi_en[13:13];

        enum DDRC_CFG_DDRMODE_bc_en_enum {
            DISABLED = 0 { name = "Disabled"; desc = "disabled"; };
            ENABLED = 1 { name = "Enabled"; desc = "enabled"; };
        };

        field {
            name = "bc_en";
            desc = "DDR3 burst chop mode";
            sw = rw;
            hw = r;
            encode = DDRC_CFG_DDRMODE_bc_en_enum;
            reset = 0x0;
        } bc_en[12:12];

        enum DDRC_CFG_DDRMODE_rd_2t_pre_enum {
            DISABLED = 0 { name = "Disabled"; desc = "disabled"; };
            ENABLED = 1 { name = "Enabled"; desc = "enabled"; };
        };

        field {
            name = "rd_2t_pre";
            desc = "DDR4 read 2T preamble enable";
            sw = rw;
            hw = r;
            encode = DDRC_CFG_DDRMODE_rd_2t_pre_enum;
            reset = 0x0;
        } rd_2t_pre[10:10];

        enum DDRC_CFG_DDRMODE_wr_2t_pre_enum {
            DISABLED = 0 { name = "Disabled"; desc = "disabled"; };
            ENABLED = 1 { name = "Enabled"; desc = "enabled"; };
        };

        field {
            name = "wr_2t_pre";
            desc = "DDR4 write 2T preamble enable";
            sw = rw;
            hw = r;
            encode = DDRC_CFG_DDRMODE_wr_2t_pre_enum;
            reset = 0x0;
        } wr_2t_pre[9:9];

        field {
            name = "brstlen";
            desc = "Burst length of the DDRC When brstlen2 is set to 0: 0: BL4 1: BL8 When brstlen2 is set to 1: 0: BL16 1: BL32 The burst length of the DDR3/DDR4 SDRAM can be set to only burst 8.";
            sw = rw;
            hw = r;
            reset = 0x0;
        } brstlen[8:8];

        enum DDRC_CFG_DDRMODE_brstlen2_enum {
            BASIC_MODE = 0 { name = "Basic Mode"; desc = "basic mode"; };
            EXTENDED_MODE_THIS = 1 { name = "Extended Mode This"; desc = "extended mode This field works with brstlen."; };
        };

        field {
            name = "brstlen2";
            desc = "Burst length 2 of the DDRC";
            sw = rw;
            hw = r;
            encode = DDRC_CFG_DDRMODE_brstlen2_enum;
            reset = 0x0;
        } brstlen2[7:7];

        enum DDRC_CFG_DDRMODE_mem_width_enum {
            V_8_BITS = 0 { name = "V 8 Bits"; desc = "8 bits"; };
            V_16_BITS = 1 { name = "V 16 Bits"; desc = "16 bits"; };
            V_32_BITS = 2 { name = "V 32 Bits"; desc = "32 bits"; };
            V_64_BITS = 3 { name = "V 64 Bits"; desc = "64 bits"; };
        };

        field {
            name = "mem_width";
            desc = "Bit width of the storage data bus";
            sw = rw;
            hw = r;
            encode = DDRC_CFG_DDRMODE_mem_width_enum;
            reset = 0x0;
        } mem_width[5:4];

        enum DDRC_CFG_DDRMODE_dram_type_enum {
            LPDDR3 = 3 { name = "Lpddr3"; desc = "LPDDR3"; };
            DDR3 = 6 { name = "Ddr3"; desc = "DDR3"; };
            DDR4 = 7 { name = "Ddr4"; desc = "DDR4"; };
        };

        field {
            name = "dram_type";
            desc = "External memory type. Other values: reserved.";
            sw = rw;
            hw = r;
            encode = DDRC_CFG_DDRMODE_dram_type_enum;
            reset = 0x0;
        } dram_type[3:0];
    } DDRC_CFG_DDRMODE @ 0x50;

    reg {
        name = "DDR data scrambling configuration register";
        desc = "DDRC_CFG_SCRAMB is a DDR data scrambling configuration register.

Data sheet 4.1.7 DDRC_CFG_SCRAMB (offset 0x58, printed page 4-91, `hi3516av200--Hi3516AV200-Datasheet.txt` line 23700).";

        enum DDRC_CFG_SCRAMB_dbi_low_act_enum {
            ACTIVE_HIGH = 0 { name = "Active High"; desc = "active high"; };
            ACTIVE_LOW = 1 { name = "Active Low"; desc = "active low"; };
        };

        field {
            name = "dbi_low_act";
            desc = "DBI active level";
            sw = rw;
            hw = r;
            encode = DDRC_CFG_SCRAMB_dbi_low_act_enum;
            reset = 0x0;
        } dbi_low_act[18:18];

        enum DDRC_CFG_SCRAMB_rd_dbi_en_enum {
            DISABLED = 0 { name = "Disabled"; desc = "disabled"; };
            ENABLED = 1 { name = "Enabled"; desc = "enabled"; };
        };

        field {
            name = "rd_dbi_en";
            desc = "Read DBI enable";
            sw = rw;
            hw = r;
            encode = DDRC_CFG_SCRAMB_rd_dbi_en_enum;
            reset = 0x0;
        } rd_dbi_en[17:17];

        enum DDRC_CFG_SCRAMB_wr_dbi_en_enum {
            DISABLED = 0 { name = "Disabled"; desc = "disabled"; };
            ENABLED = 1 { name = "Enabled"; desc = "enabled"; };
        };

        field {
            name = "wr_dbi_en";
            desc = "Read DBI enable";
            sw = rw;
            hw = r;
            encode = DDRC_CFG_SCRAMB_wr_dbi_en_enum;
            reset = 0x0;
        } wr_dbi_en[16:16];

        enum DDRC_CFG_SCRAMB_scramb_seed_type_enum {
            USE_CS_BA = 0 { name = "Use Cs Ba"; desc = "Use the CS and BA for scrambling."; };
            USE_CS_BA_2 = 1 { name = "Use Cs Ba 2"; desc = "Use the CS, BA, and low bits of the row address for scrambling."; };
        };

        field {
            name = "scramb_seed_type";
            desc = "Address mode for scrambling";
            sw = rw;
            hw = r;
            encode = DDRC_CFG_SCRAMB_scramb_seed_type_enum;
            reset = 0x0;
        } scramb_seed_type[4:4];

        enum DDRC_CFG_SCRAMB_scramb_seed_sort_enum {
            CS_BA_COL = 0 { name = "Cs Ba Col"; desc = "CS_BA_COL arrangement"; };
            CS_COL_BA = 1 { name = "Cs Col Ba"; desc = "CS_COL_BA arrangement"; };
            COL_CS_BA = 2 { name = "Col Cs Ba"; desc = "COL_CS_BA arrangement"; };
            COL_BA_CS = 3 { name = "Col Ba Cs"; desc = "COL_BA_CS arrangement"; };
            BA_CS_COL = 4 { name = "Ba Cs Col"; desc = "BA_CS_COL arrangement"; };
            BA_COL_CS = 5 { name = "Ba Col Cs"; desc = "BA_COL_CS arrangement"; };
        };

        field {
            name = "scramb_seed_sort";
            desc = "Address arrangement mode for scrambling. Other values: reserved.";
            sw = rw;
            hw = r;
            encode = DDRC_CFG_SCRAMB_scramb_seed_sort_enum;
            reset = 0x0;
        } scramb_seed_sort[2:0];
    } DDRC_CFG_SCRAMB @ 0x58;

    reg {
        name = "DDRC-controlled DDR capacity configuration register";
        desc = "DDRC_CFG_RNKVOLn is a DDRC-controlled DDR capacity configuration register.

Data sheet 4.1.7 DDRC_CFG_RNKVOLn (offset 0x60, printed page 4-92, `hi3516av200--Hi3516AV200-Datasheet.txt` line 23760).";

        enum DDRC_CFG_RNKVOL_mem_x4_enum {
            V_8_16_32 = 0 { name = "V 8 16 32"; desc = "8-/16-/32-bit external components are combined."; };
            V_4_BIT_EXTERNAL = 1 { name = "V 4 Bit External"; desc = "4-bit external components are combined."; };
        };

        field {
            name = "mem_x4";
            desc = "4-bit external component combination mode";
            sw = rw;
            hw = r;
            encode = DDRC_CFG_RNKVOL_mem_x4_enum;
            reset = 0x0;
        } mem_x4[16:16];

        enum DDRC_CFG_RNKVOL_mem_map_enum {
            RANK_ROW_BA = 0 { name = "Rank Row Ba"; desc = "{Rank, Row, Ba, Col, DW} = AXI_Address"; };
            RANK_BA_ROW = 1 { name = "Rank Ba Row"; desc = "{Rank, Ba, Row, Col, DW}= AXI_Address"; };
            RANK_ROW_BA_2 = 2 { name = "Rank Row Ba 2"; desc = "{Rank, Row, Ba, Col, cs, Col, DW}= AXI_Address"; };
            RANK_BA_ROW_2 = 3 { name = "Rank Ba Row 2"; desc = "{Rank, Ba, Row, Col, cs, Col, DW}= AXI_Address This parameter can be set to 10 or 11 only when DDRC_CONFIG1[dual_ch] is valid. When there are multiple ranks, the configuration must be the same for each rank. This field must be set to 00 in the current version."; };
        };

        field {
            name = "mem_map";
            desc = "Address translation mode of the SDRAM";
            sw = rw;
            hw = r;
            encode = DDRC_CFG_RNKVOL_mem_map_enum;
            reset = 0x0;
        } mem_map[13:12];

        enum DDRC_CFG_RNKVOL_mem_bankgroup_enum {
            V_1_BANK_GROUP = 0 { name = "V 1 Bank Group"; desc = "1 bank group"; };
            V_2_BANK_GROUPS = 1 { name = "V 2 Bank Groups"; desc = "2 bank groups"; };
            V_4_BANK_GROUPS = 2 { name = "V 4 Bank Groups"; desc = "4 bank groups"; };
            RESERVED = 3 { name = "Reserved"; desc = "reserved"; };
        };

        field {
            name = "mem_bankgroup";
            desc = "Number of bank groups in a single SDRAM";
            sw = rw;
            hw = r;
            encode = DDRC_CFG_RNKVOL_mem_bankgroup_enum;
            reset = 0x0;
        } mem_bankgroup[11:10];

        enum DDRC_CFG_RNKVOL_mem_bank_enum {
            V_4_BANKS = 0 { name = "V 4 Banks"; desc = "4 banks"; };
            V_8_BANKS = 1 { name = "V 8 Banks"; desc = "8 banks"; };
            V_16_BANKS = 2 { name = "V 16 Banks"; desc = "16 banks"; };
            RESERVED = 3 { name = "Reserved"; desc = "reserved"; };
        };

        field {
            name = "mem_bank";
            desc = "Number of banks of a single SDRAM";
            sw = rw;
            hw = r;
            encode = DDRC_CFG_RNKVOL_mem_bank_enum;
            reset = 0x0;
        } mem_bank[9:8];

        enum DDRC_CFG_RNKVOL_mem_row_enum {
            V_11_BITS = 0 { name = "V 11 Bits"; desc = "11 bits"; };
            V_12_BITS = 1 { name = "V 12 Bits"; desc = "12 bits"; };
            V_13_BITS = 2 { name = "V 13 Bits"; desc = "13 bits"; };
            V_14_BITS = 3 { name = "V 14 Bits"; desc = "14 bits"; };
            V_15_BITS = 4 { name = "V 15 Bits"; desc = "15 bits"; };
            V_16_BITS = 5 { name = "V 16 Bits"; desc = "16 bits"; };
        };

        field {
            name = "mem_row";
            desc = "Bit width of the row address of a single SDRAM. Other values: reserved.";
            sw = rw;
            hw = r;
            encode = DDRC_CFG_RNKVOL_mem_row_enum;
            reset = 0x2;
        } mem_row[6:4];

        enum DDRC_CFG_RNKVOL_mem_col_enum {
            V_8_BITS = 0 { name = "V 8 Bits"; desc = "8 bits"; };
            V_9_BITS = 1 { name = "V 9 Bits"; desc = "9 bits"; };
            V_10_BITS = 2 { name = "V 10 Bits"; desc = "10 bits"; };
            V_11_BITS = 3 { name = "V 11 Bits"; desc = "11 bits"; };
            V_12_BITS = 4 { name = "V 12 Bits"; desc = "12 bits"; };
        };

        field {
            name = "mem_col";
            desc = "Bit width of the column address of a single SDRAM. Other values: reserved.";
            sw = rw;
            hw = r;
            encode = DDRC_CFG_RNKVOL_mem_col_enum;
            reset = 0x2;
        } mem_col[2:0];
    } DDRC_CFG_RNKVOL @ 0x60;

    reg {
        name = "DDR ODT configuration register";
        desc = "DDRC_CFG_ODT is a DDR ODT configuration register.

Data sheet 4.1.7 DDRC_CFG_ODT (offset 0xA0, printed page 4-93, `hi3516av200--Hi3516AV200-Datasheet.txt` line 23846).";

        enum DDRC_CFG_ODT_rodt_enum {
            DISABLED = 0x0 { name = "Disabled"; desc = "disabled"; };
            ENABLED = 0x1 { name = "Enabled"; desc = "enabled"; };
        };

        field {
            name = "rodt";
            desc = "ODT read enable for other RANKs when the current RANK transmits the read command";
            sw = rw;
            hw = r;
            encode = DDRC_CFG_ODT_rodt_enum;
            reset = 0x0;
        } rodt[31:16];

        enum DDRC_CFG_ODT_wodt_enum {
            DISABLED = 0x0 { name = "Disabled"; desc = "disabled"; };
            ENABLED = 0x1 { name = "Enabled"; desc = "enabled"; };
        };

        field {
            name = "wodt";
            desc = "ODT write enable for other RANKs when the current RANK transmits the write command";
            sw = rw;
            hw = r;
            encode = DDRC_CFG_ODT_wodt_enum;
            reset = 0x0;
        } wodt[15:0];
    } DDRC_CFG_ODT @ 0xA0;

    reg {
        name = "Configuration register for DDR mode register 0 and mode register 1";
        desc = "DDRC_CFG_EMRS01 is a configuration register for DDR mode register 0 and mode register 1.

Data sheet 4.1.7 DDRC_CFG_EMRS01 (offset 0xF0, printed page 4-94, `hi3516av200--Hi3516AV200-Datasheet.txt` line 23886).";

        field {
            name = "emrs1";
            desc = "DDR3/DDR4 SDRAM extended mode register 1 This field corresponds to valid bits 13-0 of mode register 1 (MR1) in the DDR3/DDR4 SDRAM manual. MR1[15:14] of most DDR SDRAMs are not used. DDRC_CFG_EMRS01 bit[31:30] are reserved and set to 2'b00. LPDDR3 SDRAM mode register 1. The lower 8 bits are valid for this register. For details about MR1, see the DDR3/DDR4 SDRAM manual.";
            sw = rw;
            hw = r;
            reset = 0x0;
        } emrs1[31:16];

        field {
            name = "mrs";
            desc = "DDR3/DDR4 SDRAM mode register This field corresponds to valid bits 13-0 of mode register 0 (MR0) in the DDR3/DDR4 SDRAM manual. MR0[15:14] of most DDR SDRAMs are not used. DDRC_CFG_EMRS01 bit[15:14] are reserved and set to 2'b00. For details about MR0, see the DDR3/DDR4 SDRAM manual.";
            sw = rw;
            hw = r;
            reset = 0x0;
        } mrs[15:0];
    } DDRC_CFG_EMRS01 @ 0xF0;

    reg {
        name = "Configuration register for DDR mode register 2 and mode register 3";
        desc = "DDRC_CFG_EMRS23 is a configuration register for DDR mode register 2 and mode register 3. Hi3516A V200 Professional HD IP Camera SoC

Data sheet 4.1.7 DDRC_CFG_EMRS23 (offset 0xF4, printed page 4-95, `hi3516av200--Hi3516AV200-Datasheet.txt` line 23929).";

        field {
            name = "emrs3";
            desc = "DDR3/DDR4 SDRAM extended mode register 3 This field corresponds to valid bits 13-0 of mode register 3 (MR3) in the DDR3/DDR4 SDRAM manual. MR3[15:14] of most DDR SDRAMs are not used. DDRC_CFG_EMRS23 bit[31:30] are reserved and set to 2'b00. LPDDR3 SDRAM mode register 3. The lower eight bits are valid for this register. For details about MR3, see the DDR3/DDR4 SDRAM manual.";
            sw = rw;
            hw = r;
            reset = 0x0;
        } emrs3[31:16];

        field {
            name = "emrs2";
            desc = "DDR3/DDR4 SDRAM extended mode register 2 This field corresponds to valid bits 13-0 of mode register 2 (MR2) in the DDR3/DDR4 SDRAM manual. MR2[15:14] of most DDR SDRAMs are not used. DDRC_CFG_EMRS23 bit[15:14] are reserved and set to 2'b00. LPDDR3 SDRAM mode register 4. The lower eight bits are valid for this register. For details about MR2, see the DDR3/DDR4 SDRAM manual.";
            sw = rw;
            hw = r;
            reset = 0x0;
        } emrs2[15:0];
    } DDRC_CFG_EMRS23 @ 0xF4;

    reg {
        name = "Configuration register for DDR mode register 4 and mode register 5";
        desc = "DDRC_CFG_EMRS45 is a configuration register for DDR mode register 4 and mode register 5.

Data sheet 4.1.7 DDRC_CFG_EMRS45 (offset 0xF8, printed page 4-95, `hi3516av200--Hi3516AV200-Datasheet.txt` line 23963).";

        field {
            name = "emrs5";
            desc = "DDR4 SDRAM extended mode register 5 This field corresponds to valid bits 13-0 of mode register 5 (MR5) in the DDR4 SDRAM manual. MR5[15:14] of most DDR SDRAMs are not used. DDRC_CFG_EMRS45 bit[31:30] are reserved and set to 2'b00. For details about MR5, see the DDR4 SDRAM manual.";
            sw = rw;
            hw = r;
            reset = 0x0;
        } emrs5[31:16];

        field {
            name = "emrs4";
            desc = "DDR4 SDRAM extended mode register 4 This field corresponds to valid bits 13-0 of mode register 4 (MR4) in the DDR4 SDRAM manual. MR4[15:14] of most DDR SDRAMs are not used. DDRC_CFG_EMRS45 bit[15:14] are reserved and set to 2'b00. For details about MR4, see the DDR4 SDRAM manual.";
            sw = rw;
            hw = r;
            reset = 0x0;
        } emrs4[15:0];
    } DDRC_CFG_EMRS45 @ 0xF8;

    reg {
        name = "Configuration register for DDR mode register 6 and mode register 7";
        desc = "DDRC_CFG_EMRS67 is a configuration register for DDR mode register 6 and mode register 7.

Data sheet 4.1.7 DDRC_CFG_EMRS67 (offset 0xFC, printed page 4-96, `hi3516av200--Hi3516AV200-Datasheet.txt` line 24003).";

        field {
            name = "emrs7";
            desc = "DDR4 SDRAM extended mode register 7 This field corresponds to valid bits 13-0 of mode register 7 (MR7) in the DDR4 SDRAM manual. MR7[15:14] of most DDRs are not used. DDRC_CFG_EMRS67 bit[31:30] are reserved and set to 2'b00. For details about MR7, see the DDR4 SDRAM manual.";
            sw = rw;
            hw = r;
            reset = 0x0;
        } emrs7[31:16];

        field {
            name = "emrs6";
            desc = "DDR4 SDRAM extended mode register 6 This field corresponds to valid bits 13-0 of mode register 6 (MR6) in the DDR4 SDRAM manual. MR6[15:14] of most DDR SDRAMs are not used. DDRC_CFG_EMRS67 bit[15:14] are reserved and set to 2'b00. For details about MR6, see the DDR4 SDRAM manual.";
            sw = rw;
            hw = r;
            reset = 0x0;
        } emrs6[15:0];
    } DDRC_CFG_EMRS67 @ 0xFC;

    reg {
        name = "DDRC timing parameter register 0";
        desc = "DDRC_CFG_TIMING0 is DDRC timing parameter register 0.

Data sheet 4.1.7 DDRC_CFG_TIMING0 (offset 0x100, printed page 4-96, `hi3516av200--Hi3516AV200-Datasheet.txt` line 24035).";

        field {
            name = "tmrd";
            desc = "Number of wait cycles for the load mode register (LMR) command. The value is tMRD for the DDR3 and DDR4. 0x0-0x1: 1 clock cycle 0x2-0xF: n clock cycles";
            sw = rw;
            hw = r;
            reset = 0xF;
        } tmrd[31:28];

        field {
            name = "trrd";
            desc = "Number of wait cycles from ACT bank A to ACT bank B 0x0-0x1: 1 clock cycle 0x2-0xF: n clock cycles";
            sw = rw;
            hw = r;
            reset = 0xF;
        } trrd[27:24];

        field {
            name = "trp";
            desc = "Number of wait cycles for the disable command (PRE period) 0x0-0x1: 1 clock cycle 0x2-0xF: n clock cycles";
            sw = rw;
            hw = r;
            reset = 0x1F;
        } trp[23:19];

        field {
            name = "trcd";
            desc = "Number of wait cycles from the ACT bank command to the read or write command 0x0-0x3: 3 clock cycles 0x4-0xF: n clock cycles";
            sw = rw;
            hw = r;
            reset = 0x1F;
        } trcd[18:14];

        field {
            name = "trc";
            desc = "Number of wait cycles from an ACT bank command to the next ACT bank command 0x00-0x01: 1 clock cycle 0x02-0x3F: n clock cycles";
            sw = rw;
            hw = r;
            reset = 0x3F;
        } trc[13:8];

        field {
            name = "tras";
            desc = "Number of wait cycles from the ACT bank command to the. Other values: reserved. disable command (PRE) 0x0-0x1: 1 clock cycle 0x2-0xF: n clock cycles";
            sw = rw;
            hw = r;
            reset = 0x3F;
        } tras[5:0];
    } DDRC_CFG_TIMING0 @ 0x100;

    reg {
        name = "DDRC timing parameter register 1";
        desc = "DDRC_CFG_TIMING1 is DDRC timing parameter register 1.

Data sheet 4.1.7 DDRC_CFG_TIMING1 (offset 0x84, printed page 4-97, `hi3516av200--Hi3516AV200-Datasheet.txt` line 24090).";

        field {
            name = "tsre";
            desc = "Number of wait cycles from the self-refresh exit command to the read command 0x0: reserved 0x01-0xFF: (n x 4) clock cycles This field is set to the larger value between tXSDLL and tXS for the DDR3/DDR4 SDRAM.";
            sw = rw;
            hw = r;
            reset = 0xFF;
        } tsre[31:24];

        field {
            name = "trtw";
            desc = "Delay from the last read data command to the first write data command 0x0-0x1: 1 clock cycle 0x2-0xF: (n + 1) clock cycles";
            sw = rw;
            hw = r;
            reset = 0x2;
        } trtw[23:20];

        field {
            name = "twl";
            desc = "Number of wait cycles from the write command to the write data command 0x0-0x1: 1 clock cycle 0x2-0xF: n clock cycles For example, 0x3 indicates three clock cycles.";
            sw = rw;
            hw = r;
            reset = 0x4;
        } twl[19:15];

        field {
            name = "tcl";
            desc = "Column address strobe (CAS) latency from the read command to the read data operation 0x0-0x1: 1 clock cycle 0x2-0xF: n clock cycles";
            sw = rw;
            hw = r;
            reset = 0x5;
        } tcl[14:10];

        field {
            name = "trfc";
            desc = "Number of wait cycles for the AREF period or AREF to the ACT command. The field value is set to the maximum value of max{trfc, tzqcs}. 0x00: reserved 0x01-0x1FF: n clock cycles";
            sw = rw;
            hw = r;
            reset = 0x1FF;
        } trfc[8:0];
    } DDRC_CFG_TIMING1 @ 0x84;

    reg {
        name = "DDRC timing parameter register 2";
        desc = "DDRC_CFG_TIMING2 is DDRC timing parameter register 2. Hi3516A V200 Professional HD IP Camera SoC

Data sheet 4.1.7 DDRC_CFG_TIMING2 (offset 0x108, printed page 4-99, `hi3516av200--Hi3516AV200-Datasheet.txt` line 24172).";

        field {
            name = "tcke";
            desc = "Minimum cycle of retaining the self-refresh mode 0x0: reserved 0x1-0xF: n clock cycles The field value must be the maximum value among tCKESR, tCKSRE, tCKSRX, and tCKE.";
            sw = rw;
            hw = r;
            reset = 0xF;
        } tcke[31:28];

        field {
            name = "twtr";
            desc = "Number of wait cycles for the last write data to the write-to-read command 0x0-0x1: 1 clock cycle 0x2-0xF: n clock cycles For example, 0x3 indicates three clock cycles.";
            sw = rw;
            hw = r;
            reset = 0x3;
        } twtr[27:24];

        field {
            name = "tfaw";
            desc = "Number of clock cycles for four consecutive activation commands 0x00-0x3F: n clock cycles For example, 0x14 indicates 20 clock cycles.";
            sw = rw;
            hw = r;
            reset = 0x3F;
        } tfaw[17:12];

        field {
            name = "taref";
            desc = "Number of auto-refresh cycles 0x000: forbidden 0x001-0x7FF: The auto-refresh cycle of the SDRAM is (16 x n) clock cycles. For example, 0x008 indicates 128 (16 x 8) clock cycles. The interval tREFI is 7800/16/tclk. Tclk is twice the running cycle of the DDR.";
            sw = rw;
            hw = r;
            reset = 0x0;
        } taref[10:0];
    } DDRC_CFG_TIMING2 @ 0x108;

    reg {
        name = "DDRC timing parameter register 3";
        desc = "DDRC_CFG_TIMING3 is DDRC timing parameter register 3. Hi3516A V200 Professional HD IP Camera SoC

Data sheet 4.1.7 DDRC_CFG_TIMING3 (offset 0x10C, printed page 4-100, `hi3516av200--Hi3516AV200-Datasheet.txt` line 24225).";

        field {
            name = "tzq_prd";
            desc = "Number of ZQCS command cycles 0x000: The ZQCS command is forbidden. 0x001-0x3FF: (n x 128) AREF cycles The number of ZQCS command cycles is equal to (n x 128) taref clock cycles.";
            sw = rw;
            hw = r;
            reset = 0x3FF;
        } tzq_prd[31:22];

        field {
            name = "tzqinit";
            desc = "Number of ZQ initialization delay cycles 0x0-0x1FF: (n x 4) clock cycles The value needs to be set to the larger value between tZQINIT and tDLLK.";
            sw = rw;
            hw = r;
            reset = 0x1FF;
        } tzqinit[21:13];

        field {
            name = "taond";
            desc = "Number of ODT enable/disable cycles In DDR3/DDR4 mode, this value is set to tWL - 2 (tWL is DDRC_CFG_TIMING1[twl]). In LPDDR3 mode, this value is set to tODTon (max)/tCK.";
            sw = rw;
            hw = r;
            reset = 0x0;
        } taond[12:8];

        field {
            name = "txard";
            desc = "Number of wait cycles of exiting the DDR low-power mode 0x0-0xF: n clock cycles (in decimal) For example, 0x7 indicates seven clock cycles. The field value is the maximum value among tXP, tXARD, tXARDS, and tXS. In DDR3/DDR4 mode, the field value is the larger value between tXP and tCKE.";
            sw = rw;
            hw = r;
            reset = 0xF;
        } txard[7:4];

        field {
            name = "trtp";
            desc = "Wait delay from the read command to the disable command 0x0-0x2: 2 clock cycles 0x3-0xF: n clock cycles Trtp is calculated as follows: Trtp = AL + BL/2 + Max (trtp, 2) - 2";
            sw = rw;
            hw = r;
            reset = 0x2;
        } trtp[3:0];
    } DDRC_CFG_TIMING3 @ 0x10C;

    reg {
        name = "DDRC timing parameter register 4";
        desc = "DDRC_CFG_TIMING4 is DDRC timing parameter register 4. Hi3516A V200 Professional HD IP Camera SoC

Data sheet 4.1.7 DDRC_CFG_TIMING4 (offset 0x110, printed page 4-101, `hi3516av200--Hi3516AV200-Datasheet.txt` line 24278).";

        field {
            name = "trodt_ext";
            desc = "In LPDDR3 mode, the configuration of trodt_ext is the same as that of twodt_ext.";
            sw = rw;
            hw = r;
            reset = 0x0;
        } trodt_ext[30:28];

        field {
            name = "tmod";
            desc = "Delay from the MRS command to ODT and ZQCL validity 0x0-0x1: 1 clock cycle 0x2-0x1F: n clock cycles";
            sw = rw;
            hw = r;
            reset = 0x1F;
        } tmod[24:20];

        field {
            name = "twlo";
            desc = "DDR3 write-leveling output delay: 0x0 and 0x1: one clock cycle; 0x2-0xF: n clock cycles. The parameter equals twlo + twloe. (The bit table lists [19:0] as reserved, but the Name and Reset rows show twlo at [19:16] with reset 0xF, the same field as on the Hi3518E V20X; bit 13 is reserved and also resets to 1.)";
            sw = rw;
            hw = r;
            reset = 0xF;
        } twlo[19:16];

        field {
            name = "reserved_nz_15_0";
            desc = "Reserved in the bit table, but the data sheet total reset value of this register has these bits set (reset 0x2000).";
            sw = r;
            hw = w;
            reset = 0x2000;
        } reserved_nz_15_0[15:0];
    } DDRC_CFG_TIMING4 @ 0x110;

    reg {
        name = "DDRC timing parameter register 5";
        desc = "DDRC_CFG_TIMING5 is DDRC timing parameter register 5.

Data sheet 4.1.7 DDRC_CFG_TIMING5 (offset 0x114, printed page 4-101, `hi3516av200--Hi3516AV200-Datasheet.txt` line 24309).";

        field {
            name = "twodt_ext";
            desc = "This parameter is valid only for LPDDR3. The LPDDR3 is an asynchronous ODT, and therefore the ODT signal needs to be broadened. The broadened length is calculated as follows: [tODTon/off (max) - tODTon/off (min)]/tCK.";
            sw = rw;
            hw = r;
            reset = 0x1;
        } twodt_ext[30:28];

        field {
            name = "tdqsckmax";
            desc = "Maximum output access time of DQS relative to CK. This parameter is valid only for LPDDR3. This parameter is automatically attached to parameters for all other read commands in LPDDR3 mode.";
            sw = rw;
            hw = r;
            reset = 0x1;
        } tdqsckmax[26:24];

        field {
            name = "tdqsck";
            desc = "Output access time of DQS relative to CK. This parameter is valid only for LPDDR3. This value is used to calculate the read latency and is automatically attached to RL in LPDDR3 mode. This field can be ignored and retains the default value in DDR3/DDR4 mode.";
            sw = rw;
            hw = r;
            reset = 0x1;
        } tdqsck[22:20];

        field {
            name = "reserved_nz_19_16";
            desc = "Reserved in the bit table, but the data sheet total reset value of this register has these bits set (reset 0x3).";
            sw = r;
            hw = w;
            reset = 0x3;
        } reserved_nz_19_16[19:16];

        field {
            name = "tzqcs";
            desc = "ZQCS calibration delay cycle 0x0-0xFF: (n x 2) clock cycles The field value must be greater than or equal to 10 because of the DMC design.";
            sw = rw;
            hw = r;
            reset = 0xFF;
        } tzqcs[15:8];

        field {
            name = "twr";
            desc = "Number of wait cycles of write recovery 0x0-0x1: one clock cycle 0x2-0x1F: n clock cycles";
            sw = rw;
            hw = r;
            reset = 0x1F;
        } twr[4:0];
    } DDRC_CFG_TIMING5 @ 0x114;

    reg {
        name = "DDRC timing parameter register 6";
        desc = "DDRC_CFG_TIMING6 is DDRC timing parameter register 6.

Data sheet 4.1.7 DDRC_CFG_TIMING6 (offset 0x118, printed page 4-102, `hi3516av200--Hi3516AV200-Datasheet.txt` line 24373).";

        field {
            name = "trrd_l";
            desc = "Number of trrd wait cycles between bank groups 0x0-0x1: one clock cycle 0x2-0xF: n clock cycles";
            sw = rw;
            hw = r;
            reset = 0x0;
        } trrd_l[23:20];

        field {
            name = "twtr_l";
            desc = "Number of twtr wait cycles between bank groups 0x0-0x1: one clock cycle 0x2-0xF: n clock cycles";
            sw = rw;
            hw = r;
            reset = 0x0;
        } twtr_l[19:16];

        field {
            name = "tccd_l";
            desc = "Number of tccd wait cycles between bank groups 0x0-0x1: one clock cycle 0x2-0xF: n clock cycles";
            sw = rw;
            hw = r;
            reset = 0x0;
        } tccd_l[15:12];

        field {
            name = "todt_sft";
            desc = "ODT delay control in LPDDR3 mode, for compensating the delay of the DDR PHY for ODT IO of POP LPDDR3";
            sw = rw;
            hw = r;
            reset = 0x0;
        } todt_sft[11:8];

        field {
            name = "tcksrx";
            desc = "tCKSRX for the DDR3 or DDR4. Number of advanced valid beats before the DDR exits the self-refresh status 0x0-0x1: one clock cycle 0x2-0xF: n clock cycles";
            sw = rw;
            hw = r;
            reset = 0xF;
        } tcksrx[7:4];

        field {
            name = "tcksre";
            desc = "tCKSRE for the DDR3 or DDR4. Number of beats to be retained after the DDR enters the self-refresh status 0x0-0x1: one clock cycle 0x2-0xF: n clock cycles";
            sw = rw;
            hw = r;
            reset = 0xF;
        } tcksre[3:0];
    } DDRC_CFG_TIMING6 @ 0x118;

    reg {
        name = "DDRC timing parameter register 7";
        desc = "DDRC_CFG_TIMING7 is DDRC timing parameter register 7.

Data sheet 4.1.7 DDRC_CFG_TIMING7 (offset 0x11C, printed page 4-103, `hi3516av200--Hi3516AV200-Datasheet.txt` line 24424).";

        field {
            name = "dimm_trtr";
            desc = "Extra delay of read-to-read switching between DIMMs based on rnk_trtr, for matching the maximum skew between DIMMs";
            sw = rw;
            hw = r;
            reset = 0x0;
        } dimm_trtr[23:20];

        field {
            name = "dimm_twtw";
            desc = "Extra delay of write-to-write switching between DIMMs based on rnk_twtw, for matching the maximum skew between DIMMs";
            sw = rw;
            hw = r;
            reset = 0x0;
        } dimm_twtw[19:16];

        field {
            name = "rnk_trtr";
            desc = "Read-to-read delay between ranks";
            sw = rw;
            hw = r;
            reset = 0x0;
        } rnk_trtr[15:12];

        field {
            name = "rnk_twtw";
            desc = "Write-to-write delay between ranks";
            sw = rw;
            hw = r;
            reset = 0x0;
        } rnk_twtw[11:8];

        field {
            name = "rnk_trtw";
            desc = "Read-to-write delay between ranks";
            sw = rw;
            hw = r;
            reset = 0x0;
        } rnk_trtw[7:4];

        field {
            name = "rnk_twtr";
            desc = "Write-to-read delay between ranks";
            sw = rw;
            hw = r;
            reset = 0x0;
        } rnk_twtr[3:0];
    } DDRC_CFG_TIMING7 @ 0x11C;

    reg {
        name = "DDRC pre-received write data configuration register";
        desc = "DDRC_CFG_BLDATA is a DDRC pre-received write data configuration register.

Data sheet 4.1.7 DDRC_CFG_BLDATA (offset 0x140, printed page 4-104, `hi3516av200--Hi3516AV200-Datasheet.txt` line 24459).";

        field {
            name = "bl_data";
            desc = "Number of DMC data segments corresponding to each DDR command in the current mode 0x0-0xF: n data segments";
            sw = rw;
            hw = r;
            reset = 0x2;
        } bl_data[3:0];
    } DDRC_CFG_BLDATA @ 0x140;

    reg {
        name = "DDRC command queue depth threshold configuration register";
        desc = "DDRC_CFG_DMCLVL is a DDRC command queue depth threshold configuration register.

Data sheet 4.1.7 DDRC_CFG_DMCLVL (offset 0x144, printed page 4-104, `hi3516av200--Hi3516AV200-Datasheet.txt` line 24481).";

        field {
            name = "mbist_que_level";
            desc = "Number of command buffers started by the DMC when the MTEST or MCLR function is used 0x0: 1 0x1-0x10: 1-16. The maximum value is related to the code.";
            sw = rw;
            hw = r;
            reset = 0x0;
        } mbist_que_level[12:8];

        field {
            name = "que_level";
            desc = "Depth of the command register FIFO in the DMC. Other values: reserved. 0x1-0x10: depth of n commands";
            sw = rw;
            hw = r;
            reset = 0x8;
        } que_level[4:0];
    } DDRC_CFG_DMCLVL @ 0x144;

    reg {
        name = "DDR I/O configuration register";
        desc = "DDRC_CFG_DDRPHY is a DDR I/O configuration register.

Data sheet 4.1.7 DDRC_CFG_DDRPHY (offset 0x200, printed page 4-105, `hi3516av200--Hi3516AV200-Datasheet.txt` line 24518).";

        field {
            name = "wr_busy_dly";
            desc = "Gating enable for the data beat in the PHY The value of this field must be greater than (WL + 2). This field can be set to 0x1F in scenarios that do not have high requirements on power consumption.";
            sw = rw;
            hw = r;
            reset = 0x1F;
        } wr_busy_dly[20:16];

        enum DDRC_CFG_DDRPHY_phy_upden_enum {
            DISABLED = 0 { name = "Disabled"; desc = "disabled"; };
            ENABLED = 1 { name = "Enabled"; desc = "enabled"; };
        };

        field {
            name = "phy_upden";
            desc = "Enable of the DDRC response to dfi_phyupd_en of the DDR PHY";
            sw = rw;
            hw = r;
            encode = DDRC_CFG_DDRPHY_phy_upden_enum;
            reset = 0x1;
        } phy_upden[12:12];

        field {
            name = "trdlat";
            desc = "Inherent delay of the DDR PHY 0x0-0xF: (n + 1) clock cycles This field needs to be set to 8 when synopsys3/2phy is used.";
            sw = rw;
            hw = r;
            reset = 0x0;
        } trdlat[11:8];
    } DDRC_CFG_DDRPHY @ 0x200;

    reg {
        name = "DDRC software DDR configuration command timing register";
        desc = "DDRC_CFG_SFC_TIM is a DDRC software DDR configuration command timing register.

Data sheet 4.1.7 DDRC_CFG_SFC_TIM (offset 0x20C, printed page 4-105, `hi3516av200--Hi3516AV200-Datasheet.txt` line 24556).";

        field {
            name = "wait_time";
            desc = "Wait period after the DDR command configured by the SFC is executed. This field is valid only when DDRC_CFG_SFC[wait_en] is 1.";
            sw = rw;
            hw = r;
            reset = 0x0;
        } wait_time[15:0];
    } DDRC_CFG_SFC_TIM @ 0x20C;

    reg {
        name = "DDRC software DDR command attribute register";
        desc = "DDRC_CFG_SFC is a DDRC software DDR command attribute register.

Data sheet 4.1.7 DDRC_CFG_SFC (offset 0x210, printed page 4-106, `hi3516av200--Hi3516AV200-Datasheet.txt` line 24588).";

        enum DDRC_CFG_SFC_wait_en_enum {
            DISABLED = 0 { name = "Disabled"; desc = "disabled"; };
            ENABLED_WAIT_PERIOD = 1 { name = "Enabled Wait Period"; desc = "enabled The wait period is configured in DDRC_CFG_SFC_TIM."; };
        };

        field {
            name = "wait_en";
            desc = "Enable for exiting a period after the command execution is complete";
            sw = rw;
            hw = r;
            encode = DDRC_CFG_SFC_wait_en_enum;
            reset = 0x0;
        } wait_en[31:31];

        enum DDRC_CFG_SFC_pre_dis_enum {
            PRECHARGE_COMMAND_TRANSMITTED = 0 { name = "Precharge Command Transmitted"; desc = "The precharge command is transmitted before the SFC command."; };
            PRECHARGE_COMMAND_NOT = 1 { name = "Precharge Command Not"; desc = "The precharge command is not transmitted before the SFC command, and the corresponding command is transmitted directly."; };
        };

        field {
            name = "pre_dis";
            desc = "Precharge command transmit disable";
            sw = rw;
            hw = r;
            encode = DDRC_CFG_SFC_pre_dis_enum;
            reset = 0x0;
        } pre_dis[30:30];

        field {
            name = "cmd_mrs";
            desc = "Value of the DDR mode register when the LMR command is configured. The lower 8 bits are valid in LPDDR mode. This field is used to select a beat as the valid data during the RDMRS or RD operation.";
            sw = rw;
            hw = r;
            reset = 0x0;
        } cmd_mrs[29:12];

        field {
            name = "cmd_ma";
            desc = "Address for the mode register to be configured when configuring the LMR command in LPDDR mode";
            sw = r;
            hw = w;
            reset = 0x0;
        } cmd_ma[11:4];

        enum DDRC_CFG_SFC_cmd_type_enum {
            ENTER_DEEP_POWER = 0 { name = "Enter Deep Power"; desc = "enter the deep power-down status"; };
            EXIT_DEEP_POWER = 1 { name = "Exit Deep Power"; desc = "exit the deep power down mode"; };
            LMR_COMMAND = 2 { name = "Lmr Command"; desc = "LMR command"; };
            ZQCL_COMMAND_LPDDRX = 3 { name = "Zqcl Command Lpddrx"; desc = "ZQCL command. In LPDDRX mode, the ZQ type is controlled by setting cmd_mrs. When cmd_mrs is 0xFF, 0x56, and 0xC3, the ZQ type is ZQINIT, ZQCS, and ZQRESET respectively. When cmd_mrs is set to other values, the ZQ type is ZQCL."; };
            WRITE_COMMAND = 4 { name = "Write Command"; desc = "write command"; };
            READ_COMMAND = 5 { name = "Read Command"; desc = "read command"; };
            PRECHARGE_ALL_COMMAND = 6 { name = "Precharge All Command"; desc = "precharge all command"; };
            READ_MRS_COMMAND = 7 { name = "Read Mrs Command"; desc = "read MRS command"; };
            AREF_COMMAND = 8 { name = "Aref Command"; desc = "AREF command"; };
            ENTER_SELF_REFRESH = 9 { name = "Enter Self Refresh"; desc = "enter the self-refresh status"; };
            EXIT_SELF_REFRESH = 10 { name = "Exit Self Refresh"; desc = "exit the self-refresh status"; };
            DDR4_PDA_COMMAND = 11 { name = "Ddr4 Pda Command"; desc = "DDR4 PDA command. The data scrambling function must be disabled during the transmission of this command."; };
            DFI_CTRL_UPD = 15 { name = "Dfi Ctrl Upd"; desc = "DFI_CTRL_UPD_REQ/DFI_CTRL_UPD_ACK handshake for requesting the PHY to enter the refresh mode (this operation is not supported in this version)"; };
        };

        field {
            name = "cmd_type";
            desc = "DDR command configuration";
            sw = rw;
            hw = r;
            encode = DDRC_CFG_SFC_cmd_type_enum;
            reset = 0x0;
        } cmd_type[3:0];
    } DDRC_CFG_SFC @ 0x210;

    reg {
        name = "Read/write memory address register 0 for the software configuration module";
        desc = "DDRC_CFG_SFC_ADDR0 is read/write memory address register 0 for the software configuration module.

Data sheet 4.1.7 DDRC_CFG_SFC_ADDR0 (offset 0x214, printed page 4-107, `hi3516av200--Hi3516AV200-Datasheet.txt` line 24660).";

        field {
            name = "sfc_row";
            desc = "Row address for the memory that is read or written by the software configuration module The maximum address bit width is related to the specifications of the connected component.";
            sw = rw;
            hw = r;
            reset = 0x0;
        } sfc_row[31:12];

        field {
            name = "sfc_col";
            desc = "Column address for the memory that is read or written by the software configuration module";
            sw = rw;
            hw = r;
            reset = 0x0;
        } sfc_col[11:0];
    } DDRC_CFG_SFC_ADDR0 @ 0x214;

    reg {
        name = "Read/write memory address register 1 for the software configuration module";
        desc = "DDRC_CFG_SFC_ADDR1 is read/write memory address register 1 for the software configuration module.

Data sheet 4.1.7 DDRC_CFG_SFC_ADDR1 (offset 0x218, printed page 4-108, `hi3516av200--Hi3516AV200-Datasheet.txt` line 24700).";

        enum DDRC_CFG_SFC_ADDR1_sfc_rank_enum {
            NOT_EXECUTE = 0x0 { name = "Not Execute"; desc = "not execute"; };
            EXECUTE = 0x1 { name = "Execute"; desc = "execute"; };
        };

        field {
            name = "sfc_rank";
            desc = "ddr_rank for executing commands";
            sw = rw;
            hw = r;
            encode = DDRC_CFG_SFC_ADDR1_sfc_rank_enum;
            reset = 0x0;
        } sfc_rank[31:16];

        field {
            name = "sfc_bank";
            desc = "Bank address for the memory that is read or written by the software configuration module";
            sw = rw;
            hw = r;
            reset = 0x0;
        } sfc_bank[3:0];
    } DDRC_CFG_SFC_ADDR1 @ 0x218;

    reg {
        name = "Write data configuration register 0 for the software configuration module";
        desc = "DDRC_CFG_SFC_WDATA0 is write data configuration register 0 for the software configuration module.

Data sheet 4.1.7 DDRC_CFG_SFC_WDATA0 (offset 0x21C, printed page 4-108, `hi3516av200--Hi3516AV200-Datasheet.txt` line 24737).";

        field {
            name = "wdata0";
            desc = "Bits 31-0 of the written data of the software configuration module";
            sw = rw;
            hw = r;
            reset = 0x0;
        } wdata0[31:0];
    } DDRC_CFG_SFC_WDATA0 @ 0x21C;

    reg {
        name = "Write data configuration register 1 for the software configuration module";
        desc = "DDRC_CFG_SFC_WDATA1 is write data configuration register 1 for the software configuration module.

Data sheet 4.1.7 DDRC_CFG_SFC_WDATA1 (offset 0x220, printed page 4-109, `hi3516av200--Hi3516AV200-Datasheet.txt` line 24766).";

        field {
            name = "wdata1";
            desc = "Bits 63-32 of the written data of the software configuration module";
            sw = rw;
            hw = r;
            reset = 0x0;
        } wdata1[31:0];
    } DDRC_CFG_SFC_WDATA1 @ 0x220;

    reg {
        name = "Write data configuration register 2 for the software configuration module";
        desc = "DDRC_CFG_SFC_WDATA2 is write data configuration register 2 for the software configuration module.

Data sheet 4.1.7 DDRC_CFG_SFC_WDATA2 (offset 0x224, printed page 4-109, `hi3516av200--Hi3516AV200-Datasheet.txt` line 24788).";

        field {
            name = "wdata2";
            desc = "Bits 95-64 of the written data of the software configuration module";
            sw = rw;
            hw = r;
            reset = 0x0;
        } wdata2[31:0];
    } DDRC_CFG_SFC_WDATA2 @ 0x224;

    reg {
        name = "Write data configuration register 3 for the software configuration module";
        desc = "DDRC_CFG_SFC_WDATA3 is write data configuration register 3 for the software configuration module. Hi3516A V200 Professional HD IP Camera SoC

Data sheet 4.1.7 DDRC_CFG_SFC_WDATA3 (offset 0x228, printed page 4-110, `hi3516av200--Hi3516AV200-Datasheet.txt` line 24820).";

        field {
            name = "wdata3";
            desc = "Bits 127-96 of the written data of the software configuration module";
            sw = rw;
            hw = r;
            reset = 0x0;
        } wdata3[31:0];
    } DDRC_CFG_SFC_WDATA3 @ 0x228;

    reg {
        name = "DDRC_CFG_ STADAT is a DDRC data statistics control register";
        desc = "DDRC_CFG_ STADAT is a DDRC data statistics control register.

Data sheet 4.1.7 DDRC_CFG_STADAT (offset 0x254, printed page 4-110, `hi3516av200--Hi3516AV200-Datasheet.txt` line 24840).";

        field {
            name = "dat_stat_en";
            desc = "DDR data statistics enable: 0: disabled; 1: enabled. When dat_stat_mode is 0 and this bit is set the performance statistics registers count cyclically; when dat_stat_mode is 1 the bit clears automatically once the counting completes.";
            sw = rw;
            hw = r;
            reset = 0x0;
        } dat_stat_en[30:30];

        field {
            name = "dat_stat_mode";
            desc = "Data statistics mode: 2'b00: continuous trigger mode (the counters keep counting; no overflow within 1 s); 2'b01: single trigger mode (when the statistical period reaches perf_prd the result is retained, counting stops and an interrupt is reported); 2'b10: threshold-based trigger mode (when the period is reached and the count is within the thresholds no interrupt is reported and a new count starts, otherwise an interrupt is reported); 2'b11: reserved.";
            sw = rw;
            hw = r;
            reset = 0x0;
        } dat_stat_mode[29:28];

        field {
            name = "dat_stat_prd";
            desc = "IP Camera SoC";
            sw = rw;
            hw = r;
            reset = 0x0;
        } dat_stat_prd[27:0];
    } DDRC_CFG_STADAT @ 0x254;

    reg {
        name = "DMC data counting minimum threshold register";
        desc = "DDRC_CFG_DATMIN is a DMC data counting minimum threshold register.

Data sheet 4.1.7 DDRC_CFG_DATMIN (offset 0x258, printed page 4-111, `hi3516av200--Hi3516AV200-Datasheet.txt` line 24911).";

        field {
            name = "dmc_dat_min";
            desc = "IP Camera SoC";
            sw = rw;
            hw = r;
            reset = 0x0;
        } dmc_dat_min[27:0];
    } DDRC_CFG_DATMIN @ 0x258;

    reg {
        name = "DMC data counting maximum threshold register";
        desc = "DDRC_CFG_DATMAX is a DMC data counting maximum threshold register. Hi3516A V200 Professional HD IP Camera SoC

Data sheet 4.1.7 DDRC_CFG_DATMAX (offset 0x25C, printed page 4-112, `hi3516av200--Hi3516AV200-Datasheet.txt` line 24945).";

        field {
            name = "dmc_dat_max";
            desc = "IP Camera SoC";
            sw = rw;
            hw = r;
            reset = 0x0;
        } dmc_dat_max[27:0];
    } DDRC_CFG_DATMAX @ 0x25C;

    reg {
        name = "DDR performance statistics mode register";
        desc = "DDRC_CFG_STACMD is a DDR performance statistics mode register.

Data sheet 4.1.7 DDRC_CFG_STACMD (offset 0x260, printed page 4-112, `hi3516av200--Hi3516AV200-Datasheet.txt` line 24970).";

        field {
            name = "load_stat_en";
            desc = "DDR load statistics enable: 0: disabled; 1: enabled. When load_stat_mode is 0 and this bit is set the performance statistics registers count cyclically; when load_stat_mode is 1 the bit clears automatically once the counting completes (the data sheet text says dat_stat_mode here).";
            sw = rw;
            hw = r;
            reset = 0x0;
        } load_stat_en[30:30];

        field {
            name = "load_stat_mode";
            desc = "Load statistics mode (the data sheet prints the name as 'load_stat _mode'): 2'b00: continuous trigger mode (the counters keep counting; no overflow within 1 s); 2'b01: single trigger mode (when the statistical period reaches perf_prd the result is retained, counting stops and an interrupt is reported); 2'b10: threshold-based trigger mode; 2'b11: reserved.";
            sw = rw;
            hw = r;
            reset = 0x0;
        } load_stat_mode[29:28];

        field {
            name = "load_stat_prd";
            desc = "IP Camera SoC";
            sw = rw;
            hw = r;
            reset = 0x0;
        } load_stat_prd[27:0];
    } DDRC_CFG_STACMD @ 0x260;

    reg {
        name = "DMC command counting minimum threshold register";
        desc = "DDRC_CFG_CMDMIN is a DMC command counting minimum threshold register.

Data sheet 4.1.7 DDRC_CFG_CMDMIN (offset 0x264, printed page 4-113, `hi3516av200--Hi3516AV200-Datasheet.txt` line 25039).";

        field {
            name = "dmc_cmd_min";
            desc = "IP Camera SoC";
            sw = rw;
            hw = r;
            reset = 0x0;
        } dmc_cmd_min[27:0];
    } DDRC_CFG_CMDMIN @ 0x264;

    reg {
        name = "DMC command counting maximum threshold register";
        desc = "DDRC_CFG_CMDMAX is a DMC command counting maximum threshold register. Hi3516A V200 Professional HD IP Camera SoC

Data sheet 4.1.7 DDRC_CFG_CMDMAX (offset 0x268, printed page 4-114, `hi3516av200--Hi3516AV200-Datasheet.txt` line 25073).";

        field {
            name = "dmc_cmd_max";
            desc = "IP Camera SoC";
            sw = rw;
            hw = r;
            reset = 0x0;
        } dmc_cmd_max[27:0];
    } DDRC_CFG_CMDMAX @ 0x268;

    reg {
        name = "DDRC performance statistics mode register";
        desc = "DDRC_CFG_PERF is a DDRC performance statistics mode register.

Data sheet 4.1.7 DDRC_CFG_PERF (offset 0x270, printed page 4-114, `hi3516av200--Hi3516AV200-Datasheet.txt` line 25098).";

        enum DDRC_CFG_PERF_flux_en_enum {
            DISABLED = 0 { name = "Disabled"; desc = "disabled"; };
            ENABLED_WHEN_TRAFFIC = 1 { name = "Enabled When Traffic"; desc = "enabled When traffic monitoring is enabled, the statistics module provides the number of cycles occupied by the DDR interface by ID to each request port. The traffic can be controlled by using this field and the port traffic setting function."; };
        };

        field {
            name = "flux_en";
            desc = "DMC traffic monitoring enable";
            sw = rw;
            hw = r;
            encode = DDRC_CFG_PERF_flux_en_enum;
            reset = 0x0;
        } flux_en[29:29];

        enum DDRC_CFG_PERF_perf_mode_enum {
            CONTINUOUS_TRIGGER_MODE = 0 { name = "Continuous Trigger Mode"; desc = "continuous trigger mode. The performance counter continues to count. This ensures no overflow within 1s in continuous count mode."; };
            SINGLE_TRIGGER_MODE = 1 { name = "Single Trigger Mode"; desc = "single trigger mode. When the performance statistics time"; };
        };

        field {
            name = "perf_mode";
            desc = "Performance statistical mode";
            sw = rw;
            hw = r;
            encode = DDRC_CFG_PERF_perf_mode_enum;
            reset = 0x0;
        } perf_mode[28:28];

        field {
            name = "perf_prd";
            desc = "reaches perf_prd, the count value is retained and counting stops. Performance statistics cycle 0x0-0x1: invalid 0x2-0xFFFFFFF: statistical cycles The actual statistics cycle is (perf_prd x 16 x tclk). tclk is the bus clock cycle of the DDRC.";
            sw = rw;
            hw = r;
            reset = 0x0;
        } perf_prd[27:0];
    } DDRC_CFG_PERF @ 0x270;

    reg {
        name = "DDRC performance statistics command ID register";
        desc = "DDRC_CFG_STAID is a DDRC performance statistics command ID register.

Data sheet 4.1.7 DDRC_CFG_STAID (offset 0x274, printed page 4-115, `hi3516av200--Hi3516AV200-Datasheet.txt` line 25157).";

        field {
            name = "sta_id";
            desc = "Performance statistics by a specified ID. This field works with sta_idmask.";
            sw = rw;
            hw = r;
            reset = 0x0;
        } sta_id[15:0];
    } DDRC_CFG_STAID @ 0x274;

    reg {
        name = "DDR performance statistics command ID mask register";
        desc = "DDRC_CFG_STAIDMSK is a DDR performance statistics command ID mask register.

Data sheet 4.1.7 DDRC_CFG_STAIDMSK (offset 0x278, printed page 4-115, `hi3516av200--Hi3516AV200-Datasheet.txt` line 25178).";

        field {
            name = "sta_idmask";
            desc = "Specified ID mask";
            sw = rw;
            hw = r;
            reset = 0xFFFF;
        } sta_idmask[15:0];
    } DDRC_CFG_STAIDMSK @ 0x278;

    reg {
        name = "DDRC interrupt mask register";
        desc = "DDRC_INTMSK is a DDRC interrupt mask register.

Data sheet 4.1.7 DDRC_INTMSK (offset 0x280, printed page 4-116, `hi3516av200--Hi3516AV200-Datasheet.txt` line 25210).";

        enum DDRC_INTMSK_aref_alarm_int_mask_enum {
            ENABLED = 0 { name = "Enabled"; desc = "enabled"; };
            MASKED = 1 { name = "Masked"; desc = "masked"; };
        };

        field {
            name = "aref_alarm_int_mask";
            desc = "DDR AREF command interrupt mask";
            sw = rw;
            hw = r;
            encode = DDRC_INTMSK_aref_alarm_int_mask_enum;
            reset = 0x0;
        } aref_alarm_int_mask[16:16];

        enum DDRC_INTMSK_stadat_max_int_mask_enum {
            ENABLED = 0 { name = "Enabled"; desc = "enabled"; };
            MASKED = 1 { name = "Masked"; desc = "masked"; };
        };

        field {
            name = "stadat_max_int_mask";
            desc = "DDR data counting overflow interrupt mask";
            sw = rw;
            hw = r;
            encode = DDRC_INTMSK_stadat_max_int_mask_enum;
            reset = 0x0;
        } stadat_max_int_mask[14:14];

        enum DDRC_INTMSK_stadat_min_int_mask_enum {
            ENABLED = 0 { name = "Enabled"; desc = "enabled"; };
            MASKED = 1 { name = "Masked"; desc = "masked"; };
        };

        field {
            name = "stadat_min_int_mask";
            desc = "DDR data counting period expire or underflow interrupt mask";
            sw = rw;
            hw = r;
            encode = DDRC_INTMSK_stadat_min_int_mask_enum;
            reset = 0x0;
        } stadat_min_int_mask[13:13];

        enum DDRC_INTMSK_rdtimeout_int_mask_enum {
            ENABLED = 0 { name = "Enabled"; desc = "enabled"; };
            MASKED = 1 { name = "Masked"; desc = "masked"; };
        };

        field {
            name = "rdtimeout_int_mask";
            desc = "DDR PHY read data timeout interrupt mask";
            sw = rw;
            hw = r;
            encode = DDRC_INTMSK_rdtimeout_int_mask_enum;
            reset = 0x0;
        } rdtimeout_int_mask[12:12];

        enum DDRC_INTMSK_stacmd_max_int_mask_enum {
            MASKED = 1 { name = "Masked"; desc = "masked"; };
            ENABLED = 0 { name = "Enabled"; desc = "enabled"; };
        };

        field {
            name = "stacmd_max_int_mask";
            desc = "DDR load counting overflow interrupt mask";
            sw = rw;
            hw = r;
            encode = DDRC_INTMSK_stacmd_max_int_mask_enum;
            reset = 0x0;
        } stacmd_max_int_mask[10:10];

        enum DDRC_INTMSK_stacmd_min_int_mask_enum {
            ENABLED = 0 { name = "Enabled"; desc = "enabled"; };
            MASKED = 1 { name = "Masked"; desc = "masked"; };
        };

        field {
            name = "stacmd_min_int_mask";
            desc = "DDR load counting period expire or underflow interrupt mask";
            sw = rw;
            hw = r;
            encode = DDRC_INTMSK_stacmd_min_int_mask_enum;
            reset = 0x0;
        } stacmd_min_int_mask[9:9];

        enum DDRC_INTMSK_sref_err_int_mask_enum {
            ENABLED = 0 { name = "Enabled"; desc = "enabled"; };
            MASKED = 1 { name = "Masked"; desc = "masked"; };
        };

        field {
            name = "sref_err_int_mask";
            desc = "Command interface access error interrupt mask in DDR self-refresh mode";
            sw = rw;
            hw = r;
            encode = DDRC_INTMSK_sref_err_int_mask_enum;
            reset = 0x0;
        } sref_err_int_mask[5:5];

        enum DDRC_INTMSK_flux_int_mask_enum {
            ENABLED = 0 { name = "Enabled"; desc = "enabled"; };
            MASKED = 1 { name = "Masked"; desc = "masked"; };
        };

        field {
            name = "flux_int_mask";
            desc = "DDR FLUX statistical period reach interrupt mask";
            sw = rw;
            hw = r;
            encode = DDRC_INTMSK_flux_int_mask_enum;
            reset = 0x0;
        } flux_int_mask[1:1];
    } DDRC_INTMSK @ 0x280;

    reg {
        name = "DDRC raw interrupt register";
        desc = "DDRC_RINT is a DDRC raw interrupt register.

Data sheet 4.1.7 DDRC_RINT (offset 0x284, printed page 4-117, `hi3516av200--Hi3516AV200-Datasheet.txt` line 25289).";

        field {
            name = "aref_alarm_rint";
            desc = "DDR AREF command error raw interrupt. Writing 1 clears the interrupt.";
            sw = rw;
            hw = w;
            onwrite = woclr;
            reset = 0x0;
        } aref_alarm_rint[16:16];

        field {
            name = "stadat_max_rint";
            desc = "DDR data counting above the upper threshold raw interrupt. Writing 1 clears the interrupt.";
            sw = rw;
            hw = w;
            onwrite = woclr;
            reset = 0x0;
        } stadat_max_rint[14:14];

        field {
            name = "stadat_min_rint";
            desc = "DDR data counting period expired or below the lower threshold raw interrupt. Writing 1 clears the interrupt.";
            sw = rw;
            hw = w;
            onwrite = woclr;
            reset = 0x0;
        } stadat_min_rint[13:13];

        field {
            name = "rdtimeout_rint";
            desc = "DDR PHY read data timeout raw interrupt. Writing 1 clears the interrupt.";
            sw = rw;
            hw = w;
            onwrite = woclr;
            reset = 0x0;
        } rdtimeout_rint[12:12];

        field {
            name = "stacmd_max_rint";
            desc = "DDR load counting above the upper threshold raw interrupt. Writing 1 clears the interrupt.";
            sw = rw;
            hw = w;
            onwrite = woclr;
            reset = 0x0;
        } stacmd_max_rint[10:10];

        field {
            name = "stacmd_min_rint";
            desc = "DDR load counting period expired or below the lower threshold raw interrupt. Writing 1 clears the interrupt.";
            sw = rw;
            hw = w;
            onwrite = woclr;
            reset = 0x0;
        } stacmd_min_rint[9:9];

        field {
            name = "sref_err_rint";
            desc = "Self-refresh interface command access raw interrupt. Writing 1 clears the interrupt.";
            sw = rw;
            hw = w;
            onwrite = woclr;
            reset = 0x0;
        } sref_err_rint[5:5];

        field {
            name = "flux_rint";
            desc = "DDR FLUX statistical period reach interrupt. Writing 1 clears the interrupt.";
            sw = rw;
            hw = r;
            reset = 0x0;
        } flux_rint[1:1];
    } DDRC_RINT @ 0x284;

    reg {
        name = "DDRC interrupt status register";
        desc = "DDRC_INTSTS is a DDRC interrupt status register.

Data sheet 4.1.7 DDRC_INTSTS (offset 0x288, printed page 4-118, `hi3516av200--Hi3516AV200-Datasheet.txt` line 25356).";

        field {
            name = "aref_alarm_intsts";
            desc = "DDR AREF command error interrupt: 0: no interrupt; 1: interrupt generated.";
            sw = r;
            hw = w;
            reset = 0x0;
        } aref_alarm_intsts[16:16];

        field {
            name = "stadat_max_intsts";
            desc = "DDR data counting overflow (above the upper threshold) interrupt: 0: no interrupt; 1: interrupt generated.";
            sw = r;
            hw = w;
            reset = 0x0;
        } stadat_max_intsts[14:14];

        field {
            name = "stadat_min_intsts";
            desc = "DDR data counting period expired or underflow interrupt: 0: no interrupt; 1: interrupt generated.";
            sw = r;
            hw = w;
            reset = 0x0;
        } stadat_min_intsts[13:13];

        field {
            name = "rdtimeout_intsts";
            desc = "DDR PHY read data timeout interrupt: 0: no interrupt; 1: interrupt generated.";
            sw = r;
            hw = w;
            reset = 0x0;
        } rdtimeout_intsts[12:12];

        field {
            name = "stacmd_max_intsts";
            desc = "DDR load counting overflow (above the upper threshold) interrupt: 0: no interrupt; 1: interrupt generated.";
            sw = r;
            hw = w;
            reset = 0x0;
        } stacmd_max_intsts[10:10];

        field {
            name = "stacmd_min_intsts";
            desc = "DDR load counting period expired or underflow interrupt: 0: no interrupt; 1: interrupt generated.";
            sw = r;
            hw = w;
            reset = 0x0;
        } stacmd_min_intsts[9:9];

        field {
            name = "sref_err_intsts";
            desc = "Self-refresh interface command access interrupt: 0: no interrupt; 1: interrupt generated.";
            sw = r;
            hw = w;
            reset = 0x0;
        } sref_err_intsts[5:5];

        enum DDRC_INTSTS_flux_intsts_enum {
            NO_INTERRUPT_GENERATED = 0 { name = "No Interrupt Generated"; desc = "No interrupt is generated."; };
            INTERRUPT_GENERATED = 1 { name = "Interrupt Generated"; desc = "An interrupt is generated."; };
        };

        field {
            name = "flux_intsts";
            desc = "DDR FLUX statistical period reach interrupt";
            sw = rw;
            hw = r;
            encode = DDRC_INTSTS_flux_intsts_enum;
            reset = 0x0;
        } flux_intsts[1:1];
    } DDRC_INTSTS @ 0x288;

    reg {
        name = "DDRC status register";
        desc = "DDRC_CURR_STATUS is a DDRC status register.

Data sheet 4.1.7 DDRC_CURR_STATUS (offset 0x290, printed page 4-119, `hi3516av200--Hi3516AV200-Datasheet.txt` line 25422).";

        enum DDRC_CURR_STATUS_busy_func_enum {
            IDLE = 0 { name = "Idle"; desc = "idle"; };
            COMMAND_BEING_PROCESSED = 1 { name = "Command Being Processed"; desc = "A command is being processed."; };
        };

        field {
            name = "busy_func";
            desc = "Status of the DDRC FUNC module. This field is in the SREF status during reset.";
            sw = r;
            hw = w;
            encode = DDRC_CURR_STATUS_busy_func_enum;
            reset = 0x1;
        } busy_func[8:8];

        enum DDRC_CURR_STATUS_busy_dmc_enum {
            IDLE = 0 { name = "Idle"; desc = "idle"; };
            COMMAND_BEING_PROCESSED = 1 { name = "Command Being Processed"; desc = "A command is being processed."; };
        };

        field {
            name = "busy_dmc";
            desc = "Status of the DDRC DMC";
            sw = r;
            hw = w;
            encode = DDRC_CURR_STATUS_busy_dmc_enum;
            reset = 0x0;
        } busy_dmc[4:4];

        enum DDRC_CURR_STATUS_busy_enum {
            IDLE = 0 { name = "Idle"; desc = "idle"; };
            COMMAND_BEING_PROCESSED = 1 { name = "Command Being Processed"; desc = "A command is being processed."; };
        };

        field {
            name = "busy";
            desc = "Overall status of the DDRC";
            sw = r;
            hw = w;
            encode = DDRC_CURR_STATUS_busy_enum;
            reset = 0x1;
        } busy[0:0];
    } DDRC_CURR_STATUS @ 0x290;

    reg {
        name = "DDRC FUNC module status register";
        desc = "DDRC_CURR_FUNC is a DDRC FUNC module status register.

Data sheet 4.1.7 DDRC_CURR_FUNC (offset 0x294, printed page 4-120, `hi3516av200--Hi3516AV200-Datasheet.txt` line 25467).";

        enum DDRC_CURR_FUNC_in_sfc_enum {
            IDLE = 0 { name = "Idle"; desc = "idle"; };
            SFC_COMMAND_BEING = 1 { name = "Sfc Command Being"; desc = "An SFC command is being processed."; };
        };

        field {
            name = "in_sfc";
            desc = "DDRC SFC status";
            sw = r;
            hw = w;
            encode = DDRC_CURR_FUNC_in_sfc_enum;
            reset = 0x0;
        } in_sfc[12:12];

        enum DDRC_CURR_FUNC_aref_opt_stat_enum {
            DDR_EXITS_OPTIMIZATION = 0 { name = "Ddr Exits Optimization"; desc = "The DDR exits the optimization mode"; };
            DDR_OPTIMIZATION_MODE = 1 { name = "Ddr Optimization Mode"; desc = "The DDR is in optimization mode."; };
        };

        field {
            name = "aref_opt_stat";
            desc = "Auto-refresh optimization mode status";
            sw = r;
            hw = w;
            encode = DDRC_CURR_FUNC_aref_opt_stat_enum;
            reset = 0x0;
        } aref_opt_stat[8:8];

        enum DDRC_CURR_FUNC_in_sref_enum {
            NORMAL = 0 { name = "Normal"; desc = "normal"; };
            SELF_REFRESH = 1 { name = "Self Refresh"; desc = "self-refresh."; };
        };

        field {
            name = "in_sref";
            desc = "DDR self-refresh status";
            sw = r;
            hw = w;
            encode = DDRC_CURR_FUNC_in_sref_enum;
            reset = 0x1;
        } in_sref[0:0];
    } DDRC_CURR_FUNC @ 0x294;

    reg {
        name = "DDRC FUNC2 module status register";
        desc = "DDRC_CURR_FUNC2 is a DDRC FUNC2 module status register.

Data sheet 4.1.7 DDRC_CURR_FUNC2 (offset 0x298, printed page 4-121, `hi3516av200--Hi3516AV200-Datasheet.txt` line 25523).";

        enum DDRC_CURR_FUNC2_in_asref_enum {
            NORMAL_STATUS = 0x0 { name = "Normal Status"; desc = "normal status"; };
            AUTOMATIC_SELF_REFRESH = 0x1 { name = "Automatic Self Refresh"; desc = "automatic self-refresh status Each bit represents a rank. (The data sheet prints in_asref as [31:15], overlapping in_pd [15:0]; modelled [31:16]. The Name row of this bit table reads 'dmc_ct dmc_cv', which matches neither field: low confidence.)"; };
        };

        field {
            name = "in_asref";
            desc = "DDRC automatic self-refresh status";
            sw = r;
            hw = w;
            encode = DDRC_CURR_FUNC2_in_asref_enum;
            reset = 0x0;
        } in_asref[31:16];

        enum DDRC_CURR_FUNC2_in_pd_enum {
            NORMAL_STATUS = 0x0 { name = "Normal Status"; desc = "normal status"; };
            POWER_DOWN_STATUS = 0x1 { name = "Power Down Status"; desc = "power-down status Each bit represents a rank."; };
        };

        field {
            name = "in_pd";
            desc = "DDRC power-down status";
            sw = r;
            hw = w;
            encode = DDRC_CURR_FUNC2_in_pd_enum;
            reset = 0x0;
        } in_pd[15:0];
    } DDRC_CURR_FUNC2 @ 0x298;

    reg {
        name = "DDRC command state machine status register";
        desc = "DDRC_CURR_EXECST is a DDRC command state machine status register. Hi3516A V200 Professional HD IP Camera SoC

Data sheet 4.1.7 DDRC_CURR_EXECST (offset 0x2A0, printed page 4-122, `hi3516av200--Hi3516AV200-Datasheet.txt` line 25561).";

        enum DDRC_CURR_EXECST_dmc_ct_enum {
            READ_COMMAND = 0x0 { name = "Read Command"; desc = "read command"; };
            WRITE_COMMAND = 0x1 { name = "Write Command"; desc = "write command"; };
        };

        field {
            name = "dmc_ct";
            desc = "Controller command type";
            sw = r;
            hw = w;
            encode = DDRC_CURR_EXECST_dmc_ct_enum;
            reset = 0x0;
        } dmc_ct[31:16];

        enum DDRC_CURR_EXECST_dmc_cv_enum {
            INVALID = 0x0 { name = "Invalid"; desc = "invalid"; };
            VALID = 0x1 { name = "Valid"; desc = "valid"; };
        };

        field {
            name = "dmc_cv";
            desc = "Controller command validity flag";
            sw = r;
            hw = w;
            encode = DDRC_CURR_EXECST_dmc_cv_enum;
            reset = 0x0;
        } dmc_cv[15:0];
    } DDRC_CURR_EXECST @ 0x2A0;

    reg {
        name = "DDRC write data FIFO status register";
        desc = "DDRC_CURR_WGFIFOST is a DDRC write data FIFO status register.

Data sheet 4.1.7 DDRC_CURR_WGFIFOST (offset 0x2A4, printed page 4-122, `hi3516av200--Hi3516AV200-Datasheet.txt` line 25584).";

        enum DDRC_CURR_WGFIFOST_wgntfifo_e_enum {
            NOT_EMPTY = 0 { name = "Not Empty"; desc = "not empty"; };
            EMPTY = 1 { name = "Empty"; desc = "empty"; };
        };

        field {
            name = "wgntfifo_e";
            desc = "WGNT_FIFO empty or full status. The empty status indicates that all written data is received, and the non-empty status indicates that the written data is not completely received.";
            sw = r;
            hw = w;
            encode = DDRC_CURR_WGFIFOST_wgntfifo_e_enum;
            reset = 0x1;
        } wgntfifo_e[0:0];
    } DDRC_CURR_WGFIFOST @ 0x2A4;

    reg {
        name = "DDRC all write command traffic statistics register";
        desc = "DDRC_HIS_FLUX_WR is a DDRC all write command traffic statistics register. Hi3516A V200 Professional HD IP Camera SoC

Data sheet 4.1.7 DDRC_HIS_FLUX_WR (offset 0x380, printed page 4-123, `hi3516av200--Hi3516AV200-Datasheet.txt` line 25625).";

        field {
            name = "flux_wr";
            desc = "Write traffic statistics of all masters with the IDs of the DDRC. The counting is performed in the valid statistics cycle. The unit is the DMC bit width. When perf_mode is 0, the value is wrapped when an overflow occurs. When perf_mode is 1, the value is retained when an overflow occurs. This field is cleared when the next statistics start.";
            sw = r;
            hw = w;
            reset = 0x0;
        } flux_wr[31:0];
    } DDRC_HIS_FLUX_WR @ 0x380;

    reg {
        name = "DDRC all read command traffic statistics register";
        desc = "DDRC_HIS_FLUX_RD is a DDRC all read command traffic statistics register.

Data sheet 4.1.7 DDRC_HIS_FLUX_RD (offset 0x384, printed page 4-123, `hi3516av200--Hi3516AV200-Datasheet.txt` line 25651).";

        field {
            name = "flux_rd";
            desc = "Read traffic statistics of all masters with the IDs of the DDRC. The counting is performed in the valid statistics cycle. The unit is the DMC bit width. When perf_mode is 0, the value is wrapped when an overflow occurs. When perf_mode is 1, the value is retained when an overflow occurs. This field is cleared when the next statistics start.";
            sw = r;
            hw = w;
            reset = 0x0;
        } flux_rd[31:0];
    } DDRC_HIS_FLUX_RD @ 0x384;

    reg {
        name = "DDRC all write command count register";
        desc = "DDRC_HIS_FLUX_WCMD is a DDRC all write command count register. Hi3516A V200 Professional HD IP Camera SoC

Data sheet 4.1.7 DDRC_HIS_FLUX_WCMD (offset 0x388, printed page 4-124, `hi3516av200--Hi3516AV200-Datasheet.txt` line 25687).";

        field {
            name = "flux_wr_cmd";
            desc = "Write command count of the masters with all IDs of the DDRC. The counting is performed in the valid statistics cycle. When perf_mode is 0, the value is wrapped when an overflow occurs. When perf_mode is 1, the value is retained when an overflow occurs. This field is cleared when the next statistics start.";
            sw = r;
            hw = w;
            reset = 0x0;
        } flux_wr_cmd[31:0];
    } DDRC_HIS_FLUX_WCMD @ 0x388;

    reg {
        name = "DDRC all read command count register";
        desc = "DDRC_HIS_FLUX_RCMD is a DDRC all read command count register.

Data sheet 4.1.7 DDRC_HIS_FLUX_RCMD (offset 0x38C, printed page 4-124, `hi3516av200--Hi3516AV200-Datasheet.txt` line 25711).";

        field {
            name = "flux_rd_cmd";
            desc = "Read command count of the masters with all IDs of the DDRC. The counting is performed in the valid statistics cycle. When perf_mode is 0, the value is wrapped when an overflow occurs. When perf_mode is 1, the value is retained when an overflow occurs. This field is cleared when the next statistics start.";
            sw = r;
            hw = w;
            reset = 0x0;
        } flux_rd_cmd[31:0];
    } DDRC_HIS_FLUX_RCMD @ 0x38C;

    reg {
        name = "DDRC specified ID write traffic statistics registers";
        desc = "DDRC_HIS_FLUXID_WR is a DDRC specified ID write traffic statistics registers. Hi3516A V200 Professional HD IP Camera SoC

Data sheet 4.1.7 DDRC_HIS_FLUXID_WR (offset 0x390, printed page 4-125, `hi3516av200--Hi3516AV200-Datasheet.txt` line 25745).";

        field {
            name = "fluxid_wr";
            desc = "Write traffic statistics of the master with the specified ID of the DDRC. The counting is performed in the valid statistics cycle. When perf_mode is 0, the value is wrapped when an overflow occurs. When perf_mode is 1, the value is retained when an overflow occurs. This field is cleared when the next statistics start.";
            sw = r;
            hw = w;
            reset = 0x0;
        } fluxid_wr[31:0];
    } DDRC_HIS_FLUXID_WR @ 0x390;

    reg {
        name = "DDRC specified ID read traffic statistics registers";
        desc = "DDRC_HIS_FLUXID_RD is a DDRC specified ID read traffic statistics registers.

Data sheet 4.1.7 DDRC_HIS_FLUXID_RD (offset 0x394, printed page 4-125, `hi3516av200--Hi3516AV200-Datasheet.txt` line 25772).";

        field {
            name = "fluxid_rd";
            desc = "Read traffic statistics of the master with the specified ID of the DDRC. The counting is performed in the valid statistics cycle. When perf_mode is 0, the value is wrapped when an overflow occurs. When perf_mode is 1, the value is retained when an overflow occurs. This field is cleared when the next statistics start.";
            sw = r;
            hw = w;
            reset = 0x0;
        } fluxid_rd[31:0];
    } DDRC_HIS_FLUXID_RD @ 0x394;

    reg {
        name = "DDRC all ID write command count register";
        desc = "DDRC_HIS_FLUXID_WCMD is a DDRC all ID write command count register. Hi3516A V200 Professional HD IP Camera SoC

Data sheet 4.1.7 DDRC_HIS_FLUXID_WCMD (offset 0x398, printed page 4-126, `hi3516av200--Hi3516AV200-Datasheet.txt` line 25808).";

        field {
            name = "fluxid_wr_cmd";
            desc = "Read traffic statistics of the master based on specified IDs. The counting is performed in the valid statistics cycle. When perf_mode is 0, the value is wrapped when an overflow occurs. When perf_mode is 1, the value is retained when an overflow occurs. This field is cleared when the next statistics start.";
            sw = r;
            hw = w;
            reset = 0x0;
        } fluxid_wr_cmd[31:0];
    } DDRC_HIS_FLUXID_WCMD @ 0x398;

    reg {
        name = "DDRC all ID read command count register";
        desc = "DDRC_HIS_FLUXID_RCMD is a DDRC all ID read command count register.

Data sheet 4.1.7 DDRC_HIS_FLUXID_RCMD (offset 0x39C, printed page 4-126, `hi3516av200--Hi3516AV200-Datasheet.txt` line 25832).";

        field {
            name = "fluxid_rd_cmd";
            desc = "Read command count of the master based on specified IDs. The counting is performed in the valid statistics cycle. When perf_mode is 0, the value is wrapped when an overflow occurs. When perf_mode is 1, the value is retained when an overflow occurs. This field is cleared when the next statistics start.";
            sw = r;
            hw = w;
            reset = 0x0;
        } fluxid_rd_cmd[31:0];
    } DDRC_HIS_FLUXID_RCMD @ 0x39C;

    reg {
        name = "DDRC specified ID write command latency statistics register 0";
        desc = "DDRC_HIS_WLATCNT0 is DDRC specified ID write command latency statistics register 0. Hi3516A V200 Professional HD IP Camera SoC

Data sheet 4.1.7 DDRC_HIS_WLATCNT0 (offset 0x3A0, printed page 4-127, `hi3516av200--Hi3516AV200-Datasheet.txt` line 25866).";

        field {
            name = "wlatcnt_max";
            desc = "Maximum latency of the write command with the specified ID of the DDRC This field is cleared when the next statistics start.";
            sw = r;
            hw = w;
            reset = 0x0;
        } wlatcnt_max[31:16];

        field {
            name = "wlatcnt_min";
            desc = "Minimum latency of the write command with the specified ID of the DDRC. The maximum value is retained if an overflow occurs. This field is cleared when the next statistics start.";
            sw = r;
            hw = w;
            reset = 0xFFFF;
        } wlatcnt_min[15:0];
    } DDRC_HIS_WLATCNT0 @ 0x3A0;

    reg {
        name = "DDRC specified ID write command latency statistics register 1";
        desc = "DDRC_HIS_WLATCNT1 is DDRC specified ID write command latency statistics register 1.

Data sheet 4.1.7 DDRC_HIS_WLATCNT1 (offset 0x3A4, printed page 4-127, `hi3516av200--Hi3516AV200-Datasheet.txt` line 25889).";

        field {
            name = "wlatcnt_all";
            desc = "Accumulated latency of the write command with the specified ID in the statistics cycle (the results of the lower four bits are ignored) When perf_mode is 0, the value is wrapped when an overflow occurs. When perf_mode is 1, the value is retained when an overflow occurs. This field is cleared when the next statistics start.";
            sw = r;
            hw = w;
            reset = 0x0;
        } wlatcnt_all[31:0];
    } DDRC_HIS_WLATCNT1 @ 0x3A4;

    reg {
        name = "DDRC specified ID read command latency statistics register 0";
        desc = "DDRC_HIS_RLATCNT0 is a DDRC specified ID read command latency statistics register 0. Hi3516A V200 Professional HD IP Camera SoC

Data sheet 4.1.7 DDRC_HIS_RLATCNT0 (offset 0x3A8, printed page 4-128, `hi3516av200--Hi3516AV200-Datasheet.txt` line 25927).";

        field {
            name = "rlatcnt_max";
            desc = "Maximum latency of the read command with the specified ID of the DDRC The actual maximum read latency is rlatcnt_max plus inhere_rlatcnt. The maximum value is retained if an overflow occurs. This field is cleared when the next statistics start.";
            sw = r;
            hw = w;
            reset = 0x0;
        } rlatcnt_max[31:16];

        field {
            name = "rlatcnt_min";
            desc = "Minimum latency of the read command with the specified ID of the DDRC Note that the actual minimum read latency is rlatcnt_min plus inhere_rlatcnt. The maximum value is retained if an overflow occurs. This field is cleared when the next statistics start.";
            sw = r;
            hw = w;
            reset = 0xFFFF;
        } rlatcnt_min[15:0];
    } DDRC_HIS_RLATCNT0 @ 0x3A8;

    reg {
        name = "DDRC specified ID read command latency statistics register 1";
        desc = "DDRC_HIS_RLATCNT1 is DDRC specified ID read command latency statistics register 1.

Data sheet 4.1.7 DDRC_HIS_RLATCNT1 (offset 0x3AC, printed page 4-128, `hi3516av200--Hi3516AV200-Datasheet.txt` line 25956).";

        field {
            name = "rlatcnt_all";
            desc = "Accumulated latency of the read command with the specified ID in the statistics cycle (the results of the lower four bits are ignored) When perf_mode is 0, the value is wrapped when an overflow occurs. When perf_mode is 1, the value is retained when an overflow occurs. This field is cleared when the next statistics start.";
            sw = r;
            hw = w;
            reset = 0x0;
        } rlatcnt_all[31:0];
    } DDRC_HIS_RLATCNT1 @ 0x3AC;

    reg {
        name = "Read channel inherent latency register";
        desc = "DDRC_HIS_INHERE_RLAT_CNT is a read channel inherent latency register.

Data sheet 4.1.7 DDRC_HIS_INHERE_RLAT_CNT (offset 0x3B0, printed page 4-129, `hi3516av200--Hi3516AV200-Datasheet.txt` line 25990).";

        field {
            name = "inhere_rlatcnt";
            desc = "Inherent latency of the read data channel for the DDRC and PHY. The actual latency can be obtained only by using this register and rlatcnt_min, rlatcnt_max, rlatcnt_all, and fluxid_rd_cmd.";
            sw = r;
            hw = w;
            reset = 0x0;
        } inhere_rlatcnt[15:0];
    } DDRC_HIS_INHERE_RLAT_CNT @ 0x3B0;

    reg {
        name = "Read pointer to the DMC accumulated command count register";
        desc = "DDRC_STAT_RPT is a read pointer to the DMC accumulated command count register.

Data sheet 4.1.7 DDRC_STAT_RPT (offset 0x3B4, printed page 4-129, `hi3516av200--Hi3516AV200-Datasheet.txt` line 26012).";

        enum DDRC_STAT_RPT_stacmd_rpt_enum {
            LATEST_STATISTICAL_RESULT = 0 { name = "Latest Statistical Result"; desc = "latest statistical result"; };
            SECOND_LATEST_STATISTICAL = 1 { name = "Second Latest Statistical"; desc = "second latest statistical result …"; };
            SEVENTH_LATEST_STATISTICAL = 7 { name = "Seventh Latest Statistical"; desc = "seventh latest statistical result"; };
        };

        field {
            name = "stacmd_rpt";
            desc = "In threshold-based statistical mode, the latest eight statistical results are stored. This pointer is used to indicate the statistical result that the DDRC_HIS_CMD_SUM or DDRC_HIS_DAT_SUM reading result points to.";
            sw = rw;
            hw = r;
            encode = DDRC_STAT_RPT_stacmd_rpt_enum;
            reset = 0x0;
        } stacmd_rpt[2:0];
    } DDRC_STAT_RPT @ 0x3B4;

    reg {
        name = "DDRC accumulated command count register";
        desc = "DDRC_HIS_CMD_SUM is a DDRC accumulated command count register.

Data sheet 4.1.7 DDRC_HIS_CMD_SUM (offset 0x3B8, printed page 4-130, `hi3516av200--Hi3516AV200-Datasheet.txt` line 26052).";

        field {
            name = "dmc_cmd_sum";
            desc = "Accumulated value of the commands that are temporarily stored in the DMC in the cycle. The value is wrapped if an overflow occurs.";
            sw = r;
            hw = w;
            reset = 0x0;
        } dmc_cmd_sum[31:0];
    } DDRC_HIS_CMD_SUM @ 0x3B8;

    reg {
        name = "DDRC accumulated data count register";
        desc = "DDRC_HIS_CMD_SUM is a DDRC accumulated data count register.

Data sheet 4.1.7 DDRC_HIS_DAT_SUM (offset 0x3BC, printed page 4-130, `hi3516av200--Hi3516AV200-Datasheet.txt` line 26073).";

        field {
            name = "dmc_dat_sum";
            desc = "Accumulated value of data that are temporarily stored in the DMC in the cycle. The value is wrapped if an overflow occurs.";
            sw = r;
            hw = w;
            reset = 0x0;
        } dmc_dat_sum[31:0];
    } DDRC_HIS_DAT_SUM @ 0x3BC;

    reg {
        name = "SFC read data register 0";
        desc = "DDRC_HIS_SFC_RDATA0 is SFC read data register 0.

Data sheet 4.1.7 DDRC_HIS_SFC_RDATA0 (offset 0x4A8, printed page 4-130, `hi3516av200--Hi3516AV200-Datasheet.txt` line 26093).";

        field {
            name = "rdata0";
            desc = "Bits 31-0 of the data read by the SFC";
            sw = r;
            hw = w;
            reset = 0x0;
        } rdata0[31:0];
    } DDRC_HIS_SFC_RDATA0 @ 0x4A8;

    reg {
        name = "SFC read data register";
        desc = "DDRC_HIS_SFC_RDATA1 is an SFC read data register.

Data sheet 4.1.7 DDRC_HIS_SFC_RDATA1 (offset 0x4AC, printed page 4-131, `hi3516av200--Hi3516AV200-Datasheet.txt` line 26118).";

        field {
            name = "rdata1";
            desc = "Bits 63-32 of the data read by the SFC";
            sw = r;
            hw = w;
            reset = 0x0;
        } rdata1[31:0];
    } DDRC_HIS_SFC_RDATA1 @ 0x4AC;

    reg {
        name = "SFC read data register";
        desc = "DDRC_HIS_SFC_RDATA2 is an SFC read data register.

Data sheet 4.1.7 DDRC_HIS_SFC_RDATA2 (offset 0x4B0, printed page 4-131, `hi3516av200--Hi3516AV200-Datasheet.txt` line 26137).";

        field {
            name = "rdata2";
            desc = "Bits 95-64 of the data read by the SFC";
            sw = r;
            hw = w;
            reset = 0x0;
        } rdata2[31:0];
    } DDRC_HIS_SFC_RDATA2 @ 0x4B0;

    reg {
        name = "Software configuration read data register 3";
        desc = "DDRC_HIS_SFC_RDATA3 is software configuration read data register 3.

Data sheet 4.1.7 DDRC_HIS_SFC_RDATA3 (offset 0x4B4, printed page 4-131, `hi3516av200--Hi3516AV200-Datasheet.txt` line 26156).";

        field {
            name = "rdata3";
            desc = "Bits 127-96 of the data read by the SFC";
            sw = rw;
            hw = r;
            reset = 0x0;
        } rdata3[31:0];
    } DDRC_HIS_SFC_RDATA3 @ 0x4B4;

};

regfile eHISI_MDDRC {
    name = "HiSilicon MDDRC (DDR3/DDR4/LPDDR3 controller, Hi3516A V200 / Hi3519 V101)";
    desc = "
    Multi-port DDR controller of the Hi3516A V200 and Hi3519 V101 (data sheet chapter 4.1): AXI front end at +0x0000 (0x1206_0000), QoS buffer at +0x4000 (0x1206_4000) and DMC0 at +0x8000 (0x1206_8000), as printed in the data sheet summary tables (Tables 4-8, 4-10, 4-12). The address map calls the 64 KB window 'MDDRC/DDR PHY register'; the data sheets have no DDR PHY chapter. The vendor U-Boot (`arch/arm/cpu/hi3516av200/ddr_training_custom.h`, `hi3519v101/...`) selects the DDRC V510 DMC driver (`drivers/ddr/ddr_ddrc_v510.h`) with the 28 nm T28 DDR PHY (`ddr_phy_t28.h`, base DDRC + 0xC000 on the Hi3516A V300 which documents it at 0x1206_C000) and the T28 DDRT.

    Not the eHISI_DDRC_V2 layout (Hi3518E V20X / Hi3516A V100 / Hi3516C V300: AXI_CONFIG at 0x0, DMC CFG_TIMING0.. at 0x80): this generation adds a lock register, address regions with scrambling, per-port QoS priority tables, a separate QoSBuf block and DDR4 / LPDDR3 mode fields. The Hi3516A V300 (original Chinese data sheet) is a further variant with a TZASC at +0x1000 and a different QoSBuf timeout / DMC timing layout (not modelled here).

    Both data sheets are English-only HiSilicon editions; no hardware verification.
    ";

    eHISI_MDDRC_AXI   AXI  @ 0x0000;
    eHISI_MDDRC_QOSB  QOSB @ 0x4000;
    eHISI_MDDRC_DMC   DMC  @ 0x8000;
};

`endif
