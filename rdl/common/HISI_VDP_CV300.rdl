`ifndef HISI_VDP_CV300_RDL
`define HISI_VDP_CV300_RDL


regfile eHISI_VDP_CV300 {
    name = "VDP (video display processor, Hi3516C V300 / Hi3516E V100)";
    desc = "
    Video display processor of the Hi3516C V300 / Hi3516E V100 at 0x11400000 (data sheet Table 1-1, 64 KB; CVBS/BT output). 59 registers of the V2 family (shares 59 names with the Hi3516A V200 VDP, see docs/rdl-campaign/common-driver-candidacy.md). The data sheet does not state an interrupt number in the register chapter. The vendor module hi3516cv300_vou.ko (OpenIPC package) is the matching driver; it was not disassembled in this pass.
    
    PROVENANCE: PROVEN = register offsets, names, bit fields, access and reset values transcribed from the Hi3516C V300/Hi3516E V100 data sheet issue 05 (9.2.6); the description of every register and field is the data sheet text.  Nothing here is hardware verified (no CV300 board in the lab).


    Register sources: 59 registers from the data sheet (hi3516cv300--Hi3516CV300-Hi3516EV100-Datasheet.txt, section 9.2.6); 0 registers and 0 fields from - (-), each marked `[inferred]` in its desc (names from the header, meanings inferred from the names, reset/access unknown). ";

    reg {
        name = "VO control register";
        desc = "VOCTRL is a VO control register. It is used to configure the arbitration mode of surface bus requests.

Data sheet 9.2.6 VOCTRL (offset 0x0, printed page 9-71, `hi3516cv300--Hi3516CV300-Hi3516EV100-Datasheet.txt` line 31593).";

        enum VOCTRL_vo_ck_gt_en_enum {
            DISABLED = 0 { name = "Disabled"; desc = "disabled"; };
            ENABLED = 1 { name = "Enabled"; desc = "enabled"; };
        };

        field {
            name = "vo_ck_gt_en";
            desc = "VDP clock gating enable";
            sw = rw;
            hw = r;
            encode = VOCTRL_vo_ck_gt_en_enum;
            reset = 0x0;
        } vo_ck_gt_en[31:31];

        field {
            name = "m0_arb_mode";
            desc = "Arbitration mode of data requests of internal surface buses of VO MAC0 0x0: polling Other values: reserved";
            sw = rw;
            hw = r;
            reset = 0x0;
        } m0_arb_mode[3:0];
    } VOCTRL @ 0x0;

    reg {
        name = "VO interrupt status register (read-only)";
        desc = "VOINTSTA is a VO interrupt status register (read-only).

Data sheet 9.2.6 VOINTSTA (offset 0x4, printed page 9-72, `hi3516cv300--Hi3516CV300-Hi3516EV100-Datasheet.txt` line 31633).";

        enum VOINTSTA_dhd1uf_int_enum {
            INTERRUPT_REPORTED = 0 { name = "Interrupt Reported"; desc = "An interrupt is reported."; };
            NO_INTERRUPT_REPORTED = 1 { name = "No Interrupt Reported"; desc = "No interrupt is reported."; };
        };

        field {
            name = "dhd1uf_int";
            desc = "DHD1 low-bandwidth alarm interrupt";
            sw = r;
            hw = w;
            encode = VOINTSTA_dhd1uf_int_enum;
            reset = 0x0;
        } dhd1uf_int[7:7];

        enum VOINTSTA_dhd1vtthd1_int_enum {
            INTERRUPT_REPORTED = 0 { name = "Interrupt Reported"; desc = "An interrupt is reported."; };
            NO_INTERRUPT_REPORTED = 1 { name = "No Interrupt Reported"; desc = "No interrupt is reported."; };
        };

        field {
            name = "dhd1vtthd1_int";
            desc = "DHD1 vertical timing interrupt 1";
            sw = r;
            hw = w;
            encode = VOINTSTA_dhd1vtthd1_int_enum;
            reset = 0x0;
        } dhd1vtthd1_int[4:4];
    } VOINTSTA @ 0x4;

    reg {
        name = "VO masked interrupt status register";
        desc = "VOMSKINTSTA is a VO masked interrupt status register. Writing 1 clears this register. Hi3516C V300/Hi3516E V100 Professional HD IP Camera SoC

Data sheet 9.2.6 VOMSKINTSTA (offset 0x8, printed page 9-73, `hi3516cv300--Hi3516CV300-Hi3516EV100-Datasheet.txt` line 31680).";

        enum VOMSKINTSTA_vdac0_unload_int_enum {
            INTERRUPT_REPORTED = 0 { name = "Interrupt Reported"; desc = "An interrupt is reported."; };
            NO_INTERRUPT_REPORTED = 1 { name = "No Interrupt Reported"; desc = "No interrupt is reported. Not supported for the Hi3516E V100."; };
        };

        field {
            name = "vdac0_unload_int";
            desc = "DAC0 offload interrupt";
            sw = rw;
            hw = w;
            onwrite = woclr;
            encode = VOMSKINTSTA_vdac0_unload_int_enum;
            reset = 0x0;
        } vdac0_unload_int[12:12];

        enum VOMSKINTSTA_dhd1uf_clr_enum {
            INTERRUPT_REPORTED = 0 { name = "Interrupt Reported"; desc = "An interrupt is reported."; };
            NO_INTERRUPT_REPORTED = 1 { name = "No Interrupt Reported"; desc = "No interrupt is reported."; };
        };

        field {
            name = "dhd1uf_clr";
            desc = "DHD1 low-bandwidth alarm interrupt";
            sw = rw;
            hw = w;
            onwrite = woclr;
            encode = VOMSKINTSTA_dhd1uf_clr_enum;
            reset = 0x0;
        } dhd1uf_clr[7:7];

        enum VOMSKINTSTA_dhd1vtthd1_clr_enum {
            INTERRUPT_REPORTED = 0 { name = "Interrupt Reported"; desc = "An interrupt is reported."; };
            NO_INTERRUPT_REPORTED = 1 { name = "No Interrupt Reported"; desc = "No interrupt is reported."; };
        };

        field {
            name = "dhd1vtthd1_clr";
            desc = "DHD1 vertical timing interrupt 1";
            sw = rw;
            hw = w;
            onwrite = woclr;
            encode = VOMSKINTSTA_dhd1vtthd1_clr_enum;
            reset = 0x0;
        } dhd1vtthd1_clr[4:4];
    } VOMSKINTSTA @ 0x8;

    reg {
        name = "VDP interrupt mask register";
        desc = "VOINTMSK corresponds to VOINTSTA. If a bit is 1, the corresponding interrupt is enabled; if a bit is 0, the corresponding interrupt is masked. Hi3516C V300/Hi3516E V100 Professional HD IP Camera SoC

Data sheet 9.2.6 VOINTMSK (offset 0xC, printed page 9-74, `hi3516cv300--Hi3516CV300-Hi3516EV100-Datasheet.txt` line 31737).";

        enum VOINTMSK_dhd1uf_intmsk_enum {
            MASKED = 0 { name = "Masked"; desc = "masked"; };
            ENABLED = 1 { name = "Enabled"; desc = "enabled"; };
        };

        field {
            name = "dhd1uf_intmsk";
            desc = "Mask for the DHD1 low-bandwidth alarm interrupt";
            sw = rw;
            hw = r;
            encode = VOINTMSK_dhd1uf_intmsk_enum;
            reset = 0x0;
        } dhd1uf_intmsk[7:7];

        enum VOINTMSK_dhd1vtthd1_intmsk_enum {
            MASKED = 0 { name = "Masked"; desc = "masked"; };
            ENABLED = 1 { name = "Enabled"; desc = "enabled"; };
        };

        field {
            name = "dhd1vtthd1_intmsk";
            desc = "Mask for DHD1 vertical timing interrupt 1";
            sw = rw;
            hw = r;
            encode = VOINTMSK_dhd1vtthd1_intmsk_enum;
            reset = 0x0;
        } dhd1vtthd1_intmsk[4:4];
    } VOINTMSK @ 0xC;

    reg {
        name = "VO AXI bus configuration register";
        desc = "VOAXICTRL is a VO AXI bus configuration register.

Data sheet 9.2.6 VOAXICTRL (offset 0x34, printed page 9-74, `hi3516cv300--Hi3516CV300-Hi3516EV100-Datasheet.txt` line 31772).";

        field {
            name = "m0_outstd_rid0";
            desc = "Read ID0 outstanding of AXI master 0. The value ranges from 1 to 7.";
            sw = rw;
            hw = r;
            reset = 0x1;
        } m0_outstd_rid0[3:0];
    } VOAXICTRL @ 0x34;

    reg {
        name = "VO interface multiplexing register";
        desc = "VO_MUX is a VO interface multiplexing register.

Data sheet 9.2.6 VO_MUX (offset 0x100, printed page 9-75, `hi3516cv300--Hi3516CV300-Hi3516EV100-Datasheet.txt` line 31801).";

        enum VO_MUX_digital_sel_enum {
            BT_656 = 1 { name = "Bt 656"; desc = "BT.656"; };
            LCD_OTHER_VALUES = 2 { name = "Lcd Other Values"; desc = "LCD Other values: reserved"; };
        };

        field {
            name = "digital_sel";
            desc = "Digital interface data select";
            sw = rw;
            hw = r;
            encode = VO_MUX_digital_sel_enum;
            reset = 0x0;
        } digital_sel[31:28];
    } VO_MUX @ 0x100;

    reg {
        name = "VO DAC control register";
        desc = "VO_DAC_CTRL is a VO DAC control register.

Data sheet 9.2.6 VO_DAC_CTRL (offset 0x120, printed page 9-75, `hi3516cv300--Hi3516CV300-Hi3516EV100-Datasheet.txt` line 31829).";

        enum VO_DAC_CTRL_envbg_enum {
            DISABLED = 0 { name = "Disabled"; desc = "disabled"; };
            ENABLED = 1 { name = "Enabled"; desc = "enabled"; };
        };

        field {
            name = "envbg";
            desc = "VBG reference voltage enable";
            sw = rw;
            hw = r;
            encode = VO_DAC_CTRL_envbg_enum;
            reset = 0x0;
        } envbg[22:22];

        enum VO_DAC_CTRL_pdchopper_enum {
            ENABLED = 0 { name = "Enabled"; desc = "enabled"; };
            DISABLED = 1 { name = "Disabled"; desc = "disabled"; };
        };

        field {
            name = "pdchopper";
            desc = "VBG Chopper enable";
            sw = rw;
            hw = r;
            encode = VO_DAC_CTRL_pdchopper_enum;
            reset = 0x0;
        } pdchopper[21:21];

        enum VO_DAC_CTRL_enextref_enum {
            INTERVAL_VBG_USED = 0 { name = "Interval Vbg Used"; desc = "The interval VBG is used, and the VBG is not output to the test pin."; };
            VBG_OUTPUT_TESTING = 1 { name = "Vbg Output Testing"; desc = "The VBG is output for testing."; };
        };

        field {
            name = "enextref";
            desc = "VBG output test enable";
            sw = rw;
            hw = r;
            encode = VO_DAC_CTRL_enextref_enum;
            reset = 0x0;
        } enextref[20:20];

        enum VO_DAC_CTRL_enctr_enum {
            INTERVAL_VBG_USED = 0 { name = "Interval Vbg Used"; desc = "The interval VBG is used, and the VBG is not output to the test pin."; };
            VBG_OUTPUT_TESTING = 1 { name = "Vbg Output Testing"; desc = "The VBG is output for testing."; };
        };

        field {
            name = "enctr";
            desc = "VBG output test enable";
            sw = rw;
            hw = r;
            encode = VO_DAC_CTRL_enctr_enum;
            reset = 0x0;
        } enctr[19:16];

        field {
            name = "dac_reg_rev";
            desc = "Reserved";
            sw = rw;
            hw = r;
            reset = 0x4000;
        } dac_reg_rev[15:0];
    } VO_DAC_CTRL @ 0x120;

    reg {
        name = "VO DAC channel 0 control register";
        desc = "VO_DAC_0_CTRL is a VO DAC 0 channel control register.

Data sheet 9.2.6 VO_DAC_0_CTRL (offset 0x134, printed page 9-76, `hi3516cv300--Hi3516CV300-Hi3516EV100-Datasheet.txt` line 31882).";

        enum VO_DAC_0_CTRL_dac0en_enum {
            DISABLED = 0 { name = "Disabled"; desc = "disabled"; };
            ENABLED = 1 { name = "Enabled"; desc = "enabled"; };
        };

        field {
            name = "dac0en";
            desc = "DAC enable";
            sw = rw;
            hw = r;
            encode = VO_DAC_0_CTRL_dac0en_enum;
            reset = 0x0;
        } dac0en[31:31];

        enum VO_DAC_0_CTRL_dac0gc_enum {
            V_0_52_V = 0x0 { name = "V 0 52 V"; desc = "0.52 V ..."; };
            V_1_37_V = 0x3F { name = "V 1 37 V"; desc = "1.37 V"; };
        };

        field {
            name = "dac0gc";
            desc = "DAC output amplitude control The full-scale output voltage ranges from 0.52 V to 1.37 V. The output amplitude is divided into 64 orders for adjustment. The adjustment precision is 1%. The formula is as follows: Ifs = 13.9 + GAIN x 0.358 (m A)";
            sw = rw;
            hw = r;
            encode = VO_DAC_0_CTRL_dac0gc_enum;
            reset = 0x0;
        } dac0gc[9:4];

        enum VO_DAC_0_CTRL_cablectr0_enum {
            NORMAL = 0 { name = "Normal"; desc = "normal (default)"; };
            V_10 = 1 { name = "V 10"; desc = "-10%"; };
            V_20 = 2 { name = "V 20"; desc = "-20%"; };
            V_10_2 = 3 { name = "V 10 2"; desc = "+10%"; };
        };

        field {
            name = "cablectr0";
            desc = "VREF_CABLE reference voltage adjustment of the DAC";
            sw = rw;
            hw = r;
            encode = VO_DAC_0_CTRL_cablectr0_enum;
            reset = 0x0;
        } cablectr0[1:0];
    } VO_DAC_0_CTRL @ 0x134;

    reg {
        name = "VO DAC status 0 register";
        desc = "VO_DAC_STAT0 is a VO DAC status 0 register.

Data sheet 9.2.6 VO_DAC_STAT0 (offset 0x140, printed page 9-77, `hi3516cv300--Hi3516CV300-Hi3516EV100-Datasheet.txt` line 31932).";

        field {
            name = "cableout0";
            desc = "cableout0 feedback signal";
            sw = r;
            hw = w;
            reset = 0x0;
        } cableout0[16:16];
    } VO_DAC_STAT0 @ 0x140;

    reg {
        name = "V1 configuration register (non-instant register)";
        desc = "V1_CTRL is a V1 configuration register (non-instant register). Hi3516C V300/Hi3516E V100 Professional HD IP Camera SoC

Data sheet 9.2.6 V1_CTRL (offset 0x1000, printed page 9-78, `hi3516cv300--Hi3516CV300-Hi3516EV100-Datasheet.txt` line 31968).";

        enum V1_CTRL_surface_en_enum {
            DISABLED = 0 { name = "Disabled"; desc = "disabled"; };
            ENABLED = 1 { name = "Enabled"; desc = "enabled"; };
        };

        field {
            name = "surface_en";
            desc = "Surface enable (non-instant)";
            sw = rw;
            hw = r;
            encode = V1_CTRL_surface_en_enum;
            reset = 0x0;
        } surface_en[31:31];

        enum V1_CTRL_precharge_en_enum {
            DISABLED = 0 { name = "Disabled"; desc = "disabled"; };
            ENABLED = 1 { name = "Enabled"; desc = "enabled"; };
        };

        field {
            name = "precharge_en";
            desc = "Pre-charge enable. This field is valid when the precharge_mode field is 1 (software mode).";
            sw = rw;
            hw = r;
            encode = V1_CTRL_precharge_en_enum;
            reset = 0x0;
        } precharge_en[21:21];

        enum V1_CTRL_precharge_mode_enum {
            HARDWARE_MODE_HARDWARE = 0 { name = "Hardware Mode Hardware"; desc = "hardware mode. Hardware automatically enters the pre-charge status on the frame trailer."; };
            SOFTWARE_MODE_SOFTWARE = 1 { name = "Software Mode Software"; desc = "software mode. Software determines whether to enter or exit the pre-charge status."; };
        };

        field {
            name = "precharge_mode";
            desc = "Pre-charge mode of the FDR FIFO";
            sw = rw;
            hw = r;
            encode = V1_CTRL_precharge_mode_enum;
            reset = 0x0;
        } precharge_mode[20:20];

        enum V1_CTRL_lm_rmode_enum {
            READ_MODE_BOUND = 0 { name = "Read Mode Bound"; desc = "The read mode is bound to the interface."; };
            FRAME_BUFFER_DATA = 1 { name = "Frame Buffer Data"; desc = "The frame buffer data is read in progressive mode."; };
            TOP_FIELD_READ = 2 { name = "Top Field Read"; desc = "The top field is read in interlaced mode."; };
            BOTTOM_FIELD_READ = 3 { name = "Bottom Field Read"; desc = "The bottom field is read in interlaced mode."; };
        };

        field {
            name = "lm_rmode";
            desc = "Luminance read mode";
            sw = rw;
            hw = r;
            encode = V1_CTRL_lm_rmode_enum;
            reset = 0x0;
        } lm_rmode[15:14];

        enum V1_CTRL_chm_rmode_enum {
            READ_MODE_BOUND = 0 { name = "Read Mode Bound"; desc = "The read mode is bound to the interface."; };
            FRAME_BUFFER_DATA = 1 { name = "Frame Buffer Data"; desc = "The frame buffer data is read in progressive mode."; };
            TOP_FIELD_READ = 2 { name = "Top Field Read"; desc = "The top field is read in interlaced mode."; };
            BOTTOM_FIELD_READ = 3 { name = "Bottom Field Read"; desc = "The bottom field is read in interlaced mode."; };
        };

        field {
            name = "chm_rmode";
            desc = "Chrominance read mode";
            sw = rw;
            hw = r;
            encode = V1_CTRL_chm_rmode_enum;
            reset = 0x0;
        } chm_rmode[13:12];

        enum V1_CTRL_ifmt_enum {
            SEMI_PLANAR_YCBCR400 = 1 { name = "Semi Planar Ycbcr400"; desc = "Semi-planar YCbCr400"; };
            SEMI_PLANAR_YCBCR420 = 3 { name = "Semi Planar Ycbcr420"; desc = "Semi-planar YCbCr420"; };
            SEMI_PLANAR_YCBCR422 = 4 { name = "Semi Planar Ycbcr422"; desc = "Semi-planar YCbCr422 Other values: reserved"; };
        };

        field {
            name = "ifmt";
            desc = "Format of the input data";
            sw = rw;
            hw = r;
            encode = V1_CTRL_ifmt_enum;
            reset = 0x0;
        } ifmt[3:0];
    } V1_CTRL @ 0x1000;

    reg {
        name = "V1 channel update enable register";
        desc = "V1_UPD is a V1 channel update enable register.

Data sheet 9.2.6 V1_UPD (offset 0x1004, printed page 9-79, `hi3516cv300--Hi3516CV300-Hi3516EV100-Datasheet.txt` line 32035).";

        field {
            name = "regup";
            desc = "Surface register update. After the registers at this layer are configured, the registers are updated when the value 1 is written to this bit. After the registers are updated, this bit is automatically cleared by the hardware.";
            sw = rw;
            hw = w;
            onwrite = woclr;
            reset = 0x0;
        } regup[0:0];
    } V1_UPD @ 0x1004;

    reg {
        name = "V1 input resolution register (non-instant register)";
        desc = "V1_IRESO is a V1 input resolution register (non-instant register).

Data sheet 9.2.6 V1_IRESO (offset 0x1028, printed page 9-79, `hi3516cv300--Hi3516CV300-Hi3516EV100-Datasheet.txt` line 32061).";

        field {
            name = "ih";
            desc = "Height (in line). The configured value is the actual height minus 1. The frame height is referenced and its unit is line.";
            sw = rw;
            hw = r;
            reset = 0x0;
        } ih[23:12];

        field {
            name = "iw";
            desc = "Width (in pixel). The configured value is the actual width minus 1.";
            sw = rw;
            hw = r;
            reset = 0x0;
        } iw[11:0];
    } V1_IRESO @ 0x1028;

    reg {
        name = "V1 output resolution register (non-instant register)";
        desc = "V1_ORESO is a V1 output resolution register (non-instant register).

Data sheet 9.2.6 V1_ORESO (offset 0x102C, printed page 9-80, `hi3516cv300--Hi3516CV300-Hi3516EV100-Datasheet.txt` line 32089).";

        field {
            name = "oh";
            desc = "Height (in line). The configured value is the actual height minus 1. The frame height is referenced and its unit is line.";
            sw = rw;
            hw = r;
            reset = 0x0;
        } oh[23:12];

        field {
            name = "ow";
            desc = "Width (in pixel). The configured value is the actual width minus 1.";
            sw = rw;
            hw = r;
            reset = 0x0;
        } ow[11:0];
    } V1_ORESO @ 0x102C;

    reg {
        name = "V1 overlay parameter register (non-instant register)";
        desc = "V1_CBMPARA is a V1 overlay parameter register (non-instant register).

Data sheet 9.2.6 V1_CBMPARA (offset 0x1038, printed page 9-80, `hi3516cv300--Hi3516CV300-Hi3516EV100-Datasheet.txt` line 32112).";

        field {
            name = "galpha";
            desc = "Overlay global alpha value. The value ranges from 0 to 255. The value 255 indicates opaque, and the value 0 indicates completely transparent.";
            sw = rw;
            hw = r;
            reset = 0x0;
        } galpha[7:0];
    } V1_CBMPARA @ 0x1038;

    reg {
        name = "V1 surface start position (in the display window) register (non-instant register)";
        desc = "V1_DFPOS is a V1 surface start position (in the display window) register (non-instant register). Hi3516C V300/Hi3516E V100 Professional HD IP Camera SoC

Data sheet 9.2.6 V1_DFPOS (offset 0x1060, printed page 9-81, `hi3516cv300--Hi3516CV300-Hi3516EV100-Datasheet.txt` line 32145).";

        field {
            name = "disp_yfpos";
            desc = "Start coordinates of the display column The frame height is referenced and its unit is line.";
            sw = rw;
            hw = r;
            reset = 0x0;
        } disp_yfpos[23:12];

        field {
            name = "disp_xfpos";
            desc = "Start coordinates of the display row";
            sw = rw;
            hw = r;
            reset = 0x0;
        } disp_xfpos[11:0];
    } V1_DFPOS @ 0x1060;

    reg {
        name = "V1 surface end position (in the display window) register (non-instant register)";
        desc = "V1_DLPOS is a V1 surface end position (in the display window) register (non-instant register).

Data sheet 9.2.6 V1_DLPOS (offset 0x1064, printed page 9-81, `hi3516cv300--Hi3516CV300-Hi3516EV100-Datasheet.txt` line 32168).";

        field {
            name = "disp_ylpos";
            desc = "End coordinates of the display column The frame height is referenced and its unit is line.";
            sw = rw;
            hw = r;
            reset = 0x0;
        } disp_ylpos[23:12];

        field {
            name = "disp_xlpos";
            desc = "End coordinates of the display row";
            sw = rw;
            hw = r;
            reset = 0x0;
        } disp_xlpos[11:0];
    } V1_DLPOS @ 0x1064;

    reg {
        name = "V1 CSC input DC component register (instant register)";
        desc = "V1_CSC_IDC is a V1 CSC input DC component register (instant register). Hi3516C V300/Hi3516E V100 Professional HD IP Camera SoC

Data sheet 9.2.6 V1_CSC_IDC (offset 0x1080, printed page 9-82, `hi3516cv300--Hi3516CV300-Hi3516EV100-Datasheet.txt` line 32201).";

        enum V1_CSC_IDC_csc_en_enum {
            DISABLED = 0 { name = "Disabled"; desc = "disabled"; };
            ENABLED = 1 { name = "Enabled"; desc = "enabled"; };
        };

        field {
            name = "csc_en";
            desc = "CSC enable";
            sw = rw;
            hw = r;
            encode = V1_CSC_IDC_csc_en_enum;
            reset = 0x0;
        } csc_en[22:22];

        field {
            name = "cscidc1";
            desc = "DC parameter of the input U/G component. The MSB is the signed bit. The value is expressed as a two's complement.";
            sw = rw;
            hw = r;
            reset = 0x0;
        } cscidc1[21:11];

        field {
            name = "cscidc0";
            desc = "DC parameter of the input V/B component. The MSB is the signed bit. The value is expressed as a two's complement.";
            sw = rw;
            hw = r;
            reset = 0x0;
        } cscidc0[10:0];
    } V1_CSC_IDC @ 0x1080;

    reg {
        name = "V1 CSC output DC component register (instant register)";
        desc = "V1_CSC_ODC is a V1 CSC output DC component register (instant register).

Data sheet 9.2.6 V1_CSC_ODC (offset 0x1084, printed page 9-82, `hi3516cv300--Hi3516CV300-Hi3516EV100-Datasheet.txt` line 32231).";

        enum V1_CSC_ODC_csc_sign_mode_enum {
            CSC_OUTPUT_10 = 0 { name = "Csc Output 10"; desc = "The CSC output is a 10-bit unsigned number."; };
            CSC_OUTPUT_12 = 1 { name = "Csc Output 12"; desc = "The CSC output is a 12-bit signed number."; };
        };

        field {
            name = "csc_sign_mode";
            desc = "CSC output mode";
            sw = rw;
            hw = r;
            encode = V1_CSC_ODC_csc_sign_mode_enum;
            reset = 0x0;
        } csc_sign_mode[22:22];

        field {
            name = "cscodc1";
            desc = "DC parameter of the output U/G component. The MSB is the signed bit. The value is expressed as a two's complement.";
            sw = rw;
            hw = r;
            reset = 0x0;
        } cscodc1[21:11];

        field {
            name = "cscodc0";
            desc = "DC parameter of the output Y/R component. The MSB is the signed bit. The value is expressed as a two's complement.";
            sw = rw;
            hw = r;
            reset = 0x0;
        } cscodc0[10:0];
    } V1_CSC_ODC @ 0x1084;

    reg {
        name = "V1 CSC input/output DC component register (instant register)";
        desc = "V1_CSC_IODC is a V1 CSC input/output DC component register (instant register).

Data sheet 9.2.6 V1_CSC_IODC (offset 0x1088, printed page 9-83, `hi3516cv300--Hi3516CV300-Hi3516EV100-Datasheet.txt` line 32277).";

        field {
            name = "cscodc2";
            desc = "DC parameter of the output V/B component. The MSB is the signed bit. The value is expressed as a two's complement.";
            sw = rw;
            hw = r;
            reset = 0x0;
        } cscodc2[21:11];

        field {
            name = "cscidc2";
            desc = "DC parameter of the input Y/R component. The MSB is the signed bit. The value is expressed as a two's complement.";
            sw = rw;
            hw = r;
            reset = 0x0;
        } cscidc2[10:0];
    } V1_CSC_IODC @ 0x1088;

    reg {
        name = "V1 CSC parameter register 0 (instant register)";
        desc = "V1_CSC_P0 is the V1 CSC parameter register 0 (instant register).

Data sheet 9.2.6 V1_CSC_P0 (offset 0x108C, printed page 9-83, `hi3516cv300--Hi3516CV300-Hi3516EV100-Datasheet.txt` line 32302).";

        field {
            name = "cscp01";
            desc = "Data format: a 1-bit sign part, a 4-bit integer part, and an 8-bit decimal part. The value is expressed as a two's complement.";
            sw = rw;
            hw = r;
            reset = 0x0;
        } cscp01[30:16];

        field {
            name = "cscp00";
            desc = "Data format: a 1-bit sign part, a 4-bit integer part, and an 8-bit decimal part. The value is expressed as a two's complement.";
            sw = rw;
            hw = r;
            reset = 0x0;
        } cscp00[14:0];
    } V1_CSC_P0 @ 0x108C;

    reg {
        name = "V1 CSC parameter register 1 (instant register)";
        desc = "V1_CSC_P1 is the V1 CSC parameter register 1 (instant register).

Data sheet 9.2.6 V1_CSC_P1 (offset 0x1090, printed page 9-84, `hi3516cv300--Hi3516CV300-Hi3516EV100-Datasheet.txt` line 32337).";

        field {
            name = "cscp10";
            desc = "Data format: a 1-bit sign part, a 4-bit integer part, and an 8-bit decimal part. The value is expressed as a two's complement.";
            sw = rw;
            hw = r;
            reset = 0x0;
        } cscp10[30:16];

        field {
            name = "cscp02";
            desc = "Data format: a 1-bit sign part, a 4-bit integer part, and an 8-bit decimal part. The value is expressed as a two's complement.";
            sw = rw;
            hw = r;
            reset = 0x0;
        } cscp02[14:0];
    } V1_CSC_P1 @ 0x1090;

    reg {
        name = "V1 CSC parameter register 2 (instant register)";
        desc = "V1_CSC_P2 is the V1 CSC parameter register 2 (instant register).

Data sheet 9.2.6 V1_CSC_P2 (offset 0x1094, printed page 9-84, `hi3516cv300--Hi3516CV300-Hi3516EV100-Datasheet.txt` line 32365).";

        field {
            name = "cscp12";
            desc = "Data format: a 1-bit sign part, a 4-bit integer part, and an 8-bit decimal part. The value is expressed as a two's complement.";
            sw = rw;
            hw = r;
            reset = 0x0;
        } cscp12[30:16];

        field {
            name = "cscp11";
            desc = "Data format: a 1-bit sign part, a 4-bit integer part, and an 8-bit decimal part. The value is expressed as a two's complement.";
            sw = rw;
            hw = r;
            reset = 0x0;
        } cscp11[14:0];
    } V1_CSC_P2 @ 0x1094;

    reg {
        name = "V1 CSC parameter register 3 (instant register)";
        desc = "V1_CSC_P3 is the V1 CSC parameter register 3 (instant register).

Data sheet 9.2.6 V1_CSC_P3 (offset 0x1098, printed page 9-85, `hi3516cv300--Hi3516CV300-Hi3516EV100-Datasheet.txt` line 32401).";

        field {
            name = "cscp21";
            desc = "Data format: a 1-bit sign part, a 4-bit integer part, and an 8-bit decimal part. The value is expressed as a two's complement.";
            sw = rw;
            hw = r;
            reset = 0x0;
        } cscp21[30:16];

        field {
            name = "cscp20";
            desc = "Data format: a 1-bit sign part, a 4-bit integer part, and an 8-bit decimal part. The value is expressed as a two's complement.";
            sw = rw;
            hw = r;
            reset = 0x0;
        } cscp20[14:0];
    } V1_CSC_P3 @ 0x1098;

    reg {
        name = "V1 CSC parameter register 4 (instant register)";
        desc = "V1_CSC_P4 is a V1 CSC parameter 4 register (instant register).

Data sheet 9.2.6 V1_CSC_P4 (offset 0x109C, printed page 9-85, `hi3516cv300--Hi3516CV300-Hi3516EV100-Datasheet.txt` line 32431).";

        field {
            name = "cscp22";
            desc = "Data format: a 1-bit sign part, a 4-bit integer part, and an 8-bit decimal part. The value is expressed as a two's complement.";
            sw = rw;
            hw = r;
            reset = 0x0;
        } cscp22[14:0];
    } V1_CSC_P4 @ 0x109C;

    reg {
        name = "V1 luminance address register";
        desc = "V1_P0LADDR is a V1 luminance address register. Hi3516C V300/Hi3516E V100 Professional HD IP Camera SoC

Data sheet 9.2.6 V1_P0LADDR (offset 0x1204, printed page 9-86, `hi3516cv300--Hi3516CV300-Hi3516EV100-Datasheet.txt` line 32463).";

        field {
            name = "surface_addr";
            desc = "Luminance start address for the video layer";
            sw = rw;
            hw = r;
            reset = 0x0;
        } surface_addr[31:0];
    } V1_P0LADDR @ 0x1204;

    reg {
        name = "V1 chrominance address register";
        desc = "V1_P0CADDR is a V1 chrominance address register.

Data sheet 9.2.6 V1_P0CADDR (offset 0x1208, printed page 9-86, `hi3516cv300--Hi3516CV300-Hi3516EV100-Datasheet.txt` line 32481).";

        field {
            name = "surface_addr";
            desc = "Chrominance start address for the video layer";
            sw = rw;
            hw = r;
            reset = 0x0;
        } surface_addr[31:0];
    } V1_P0CADDR @ 0x1208;

    reg {
        name = "V1 stride register";
        desc = "V1_P0STRIDE is a V1 stride register.

Data sheet 9.2.6 V1_P0STRIDE (offset 0x120C, printed page 9-86, `hi3516cv300--Hi3516CV300-Hi3516EV100-Datasheet.txt` line 32500).";

        field {
            name = "surface_cstride";
            desc = "Stride of the chrominance buffer of the video layer (valid in semi- planar format), 128-bit alignment";
            sw = rw;
            hw = r;
            reset = 0x0;
        } surface_cstride[31:16];

        field {
            name = "surface_stride";
            desc = "Stride of the video layer buffer (luminance stride in semi-planar format), 128-bit alignment";
            sw = rw;
            hw = r;
            reset = 0x0;
        } surface_stride[15:0];
    } V1_P0STRIDE @ 0x120C;

    reg {
        name = "DSD1 global control register";
        desc = "DHD1_CTRL is a DHD1 global control register. All bits of this register must be configured before or when DHD0_CTRL.intf_en is configured; otherwise, the configurations do not take effect.

Data sheet 9.2.6 DHD1_CTRL (offset 0xC400, printed page 9-87, `hi3516cv300--Hi3516CV300-Hi3516EV100-Datasheet.txt` line 32536).";

        enum DHD1_CTRL_intf_en_enum {
            DISABLED = 0 { name = "Disabled"; desc = "disabled"; };
            ENABLED = 1 { name = "Enabled"; desc = "enabled"; };
        };

        field {
            name = "intf_en";
            desc = "Display interface enable (instant). Data is output over the interface only when this field is enabled.";
            sw = rw;
            hw = r;
            encode = DHD1_CTRL_intf_en_enum;
            reset = 0x0;
        } intf_en[31:31];

        enum DHD1_CTRL_cbar_en_enum {
            DISABLED = 0 { name = "Disabled"; desc = "disabled"; };
            ENABLED = 1 { name = "Enabled"; desc = "enabled"; };
        };

        field {
            name = "cbar_en";
            desc = "Color bar enable. The color bar is output over the interface when this field is enabled.";
            sw = rw;
            hw = r;
            encode = DHD1_CTRL_cbar_en_enum;
            reset = 0x0;
        } cbar_en[30:30];

        enum DHD1_CTRL_cbar_sel_enum {
            VGA = 0 { name = "Vga"; desc = "VGA"; };
            YPBPR = 1 { name = "Ypbpr"; desc = "YPbPr"; };
        };

        field {
            name = "cbar_sel";
            desc = "Color space select for the output color bar (instant)";
            sw = rw;
            hw = r;
            encode = DHD1_CTRL_cbar_sel_enum;
            reset = 0x0;
        } cbar_sel[29:29];

        enum DHD1_CTRL_precharge_en_enum {
            DISABLED = 0 { name = "Disabled"; desc = "disabled"; };
            ENABLED = 1 { name = "Enabled"; desc = "enabled"; };
        };

        field {
            name = "precharge_en";
            desc = "Pre-charge enable. This field is valid when the precharge_mode field is 1 (software mode).";
            sw = rw;
            hw = r;
            encode = DHD1_CTRL_precharge_en_enum;
            reset = 0x0;
        } precharge_en[10:10];

        enum DHD1_CTRL_precharge_mode_enum {
            HARDWARE_MODE_HARDWARE = 0 { name = "Hardware Mode Hardware"; desc = "hardware mode. Hardware automatically enters the pre-charge status in the vertical blanking region."; };
            SOFTWARE_MODE_SOFTWARE = 1 { name = "Software Mode Software"; desc = "software mode. Software determines whether to enter or exit the pre-charge status."; };
        };

        field {
            name = "precharge_mode";
            desc = "Pre-charge mode of AFIFO";
            sw = rw;
            hw = r;
            encode = DHD1_CTRL_precharge_mode_enum;
            reset = 0x0;
        } precharge_mode[9:9];

        enum DHD1_CTRL_iop_enum {
            INTERLACED_DISPLAY = 0 { name = "Interlaced Display"; desc = "interlaced display"; };
            PROGRESSIVE_DISPLAY = 1 { name = "Progressive Display"; desc = "progressive display"; };
        };

        field {
            name = "iop";
            desc = "Display mode (non-instant)";
            sw = rw;
            hw = r;
            encode = DHD1_CTRL_iop_enum;
            reset = 0x0;
        } iop[4:4];

        field {
            name = "regup";
            desc = "Surface register update. After the registers at this layer are configured, the registers are updated when the value 1 is written to this bit. After the registers are updated, this bit is automatically cleared by the hardware.";
            sw = rw;
            hw = w;
            onwrite = woclr;
            reset = 0x0;
        } regup[0:0];
    } DHD1_CTRL @ 0xC400;

    reg {
        name = "Top field vertical sync timing register in interlaced output mode or frame vertical sync timing register in progressive output mode";
        desc = "DHD1_VSYNC is a top field vertical sync timing register in interlaced output mode or frame vertical sync timing register in progressive output mode. This register is a non-instant register.

Data sheet 9.2.6 DHD1_VSYNC (offset 0xC404, printed page 9-88, `hi3516cv300--Hi3516CV300-Hi3516EV100-Datasheet.txt` line 32608).";

        field {
            name = "vfb";
            desc = "In interlaced output mode: top vertical front blanking (TVFB) In progressive output mode: vertical front blanking (VFB) The configured value is the actual value minus 1.";
            sw = rw;
            hw = r;
            reset = 0x1;
        } vfb[27:20];

        field {
            name = "vbb";
            desc = "In interlaced output mode: top vertical back blanking (TVBB) In progressive output mode: vertical back blanking (VBB)+vertical pulse width (VPW) The configured value is the actual value minus 1.";
            sw = rw;
            hw = r;
            reset = 0x13;
        } vbb[19:12];

        field {
            name = "vact";
            desc = "In interlaced output mode: height of an active picture on the top field In progressive output mode: height of an active picture in a frame. The configured value is the actual value minus 1.";
            sw = rw;
            hw = r;
            reset = 0x21B;
        } vact[11:0];
    } DHD1_VSYNC @ 0xC404;

    reg {
        name = "Horizontal sync configuration register in interlaced or progressive output mode";
        desc = "DHD1_HSYNC1 is a horizontal sync configuration register in interlaced or progressive output mode (non-instant register).

Data sheet 9.2.6 DHD1_HSYNC1 (offset 0xC408, printed page 9-89, `hi3516cv300--Hi3516CV300-Hi3516EV100-Datasheet.txt` line 32647).";

        field {
            name = "hbb";
            desc = "Horizontal back blanking (HBB), in pixel The configured value is the actual value minus 1.";
            sw = rw;
            hw = r;
            reset = 0xBF;
        } hbb[31:16];

        field {
            name = "hact";
            desc = "Number of horizontal pixels in an active region The configured value is the actual value minus 1.";
            sw = rw;
            hw = r;
            reset = 0x77F;
        } hact[15:0];
    } DHD1_HSYNC1 @ 0xC408;

    reg {
        name = "Horizontal sync configuration register in interlaced or progressive output mode (non-instant register)";
        desc = "DHD1_HSYNC2 is a horizontal sync configuration register in interlaced or progressive output mode (non-instant register).

Data sheet 9.2.6 DHD1_HSYNC2 (offset 0xC40C, printed page 9-89, `hi3516cv300--Hi3516CV300-Hi3516EV100-Datasheet.txt` line 32672).";

        field {
            name = "hmid";
            desc = "Bottom vertical sync active pixel (active region) The configured value is the actual value minus 1.";
            sw = rw;
            hw = r;
            reset = 0x0;
        } hmid[31:16];

        field {
            name = "hfb";
            desc = "HFB, in pixel The configured value is the actual value minus 1.";
            sw = rw;
            hw = r;
            reset = 0x20F;
        } hfb[15:0];
    } DHD1_HSYNC2 @ 0xC40C;

    reg {
        name = "Bottom field vertical sync timing register in interlaced output mode (non-instant register)";
        desc = "DHD1_VPLUS is a bottom field vertical sync timing in interlaced output mode (non-instant register). Hi3516C V300/Hi3516E V100 Professional HD IP Camera SoC

Data sheet 9.2.6 DHD1_VPLUS (offset 0xC410, printed page 9-90, `hi3516cv300--Hi3516CV300-Hi3516EV100-Datasheet.txt` line 32706).";

        field {
            name = "bvfb";
            desc = "Bottom vertical front blanking (BVFB) in interlaced output mode The configured value is the actual value minus 1.";
            sw = rw;
            hw = r;
            reset = 0x2;
        } bvfb[27:20];

        field {
            name = "bvbb";
            desc = "Bottom vertical back blanking (BVBB)+VPW in interlaced output mode The configured value is the actual value minus 1.";
            sw = rw;
            hw = r;
            reset = 0x13;
        } bvbb[19:12];

        field {
            name = "bvact";
            desc = "Height of an active picture in the bottom field in interlaced output mode The configured value is the actual value minus 1.";
            sw = rw;
            hw = r;
            reset = 0x21B;
        } bvact[11:0];
    } DHD1_VPLUS @ 0xC410;

    reg {
        name = "Sync signal pulse width register (non- instant register)";
        desc = "DHD1_PWR is a sync signal pulse width register (non-instant register).

Data sheet 9.2.6 DHD1_PWR (offset 0xC414, printed page 9-90, `hi3516cv300--Hi3516CV300-Hi3516EV100-Datasheet.txt` line 32733).";

        field {
            name = "vpw";
            desc = "VPW. The configured value is the actual value minus 1.";
            sw = rw;
            hw = r;
            reset = 0x0;
        } vpw[23:16];

        field {
            name = "hpw";
            desc = "Horizontal pulse width (HPW). The configured value is the actual value minus 1.";
            sw = rw;
            hw = r;
            reset = 0x0;
        } hpw[15:0];
    } DHD1_PWR @ 0xC414;

    reg {
        name = "Vertical timing threshold register (instant register)";
        desc = "Vertical timing threshold register (instant register).

Data sheet 9.2.6 DHD1_VTTHD (offset 0xC41C, printed page 9-91, `hi3516cv300--Hi3516CV300-Hi3516EV100-Datasheet.txt` line 32770).";

        enum DHD1_VTTHD_thd1_mode_enum {
            FRAME_MODE_THRESHOLD = 0 { name = "Frame Mode Threshold"; desc = "frame mode. The threshold count is by frame."; };
            FIELD_MODE_THRESHOLD = 1 { name = "Field Mode Threshold"; desc = "field mode. The threshold count is by field during interlaced displaying."; };
        };

        field {
            name = "thd1_mode";
            desc = "Mode of generating threshold 1";
            sw = rw;
            hw = r;
            encode = DHD1_VTTHD_thd1_mode_enum;
            reset = 0x0;
        } thd1_mode[15:15];

        field {
            name = "vtmgthd1";
            desc = "Vertical timing threshold 1. When the vertical timing counter reaches this threshold, the VOINTSTA[dhdvtthd_int1] interrupt is triggered.";
            sw = rw;
            hw = r;
            reset = 0x1;
        } vtmgthd1[12:0];
    } DHD1_VTTHD @ 0xC41C;

    reg {
        name = "DHD1 status register";
        desc = "DHD1_STATE is a DHD1 status register.

Data sheet 9.2.6 DHD1_STATE (offset 0xC4F0, printed page 9-91, `hi3516cv300--Hi3516CV300-Hi3516EV100-Datasheet.txt` line 32804).";

        field {
            name = "count_int";
            desc = "DHD1 interrupt count. The count value is increased by 1 each time a vertical timing interrupt is reported.";
            sw = r;
            hw = w;
            reset = 0x0;
        } count_int[23:16];

        field {
            name = "vcnt";
            desc = "Active display line count of DHD1";
            sw = r;
            hw = w;
            reset = 0x0;
        } vcnt[15:3];

        enum DHD1_STATE_bottom_field_enum {
            TOP_FIELD = 0 { name = "Top Field"; desc = "top field"; };
            BOTTOM_FIELD = 1 { name = "Bottom Field"; desc = "bottom field"; };
        };

        field {
            name = "bottom_field";
            desc = "DHD1 top/bottom field indicator";
            sw = r;
            hw = w;
            encode = DHD1_STATE_bottom_field_enum;
            reset = 0x1;
        } bottom_field[2:2];

        enum DHD1_STATE_vblank_enum {
            ACTIVE_REGION = 0 { name = "Active Region"; desc = "active region"; };
            BLANKING_REGION = 1 { name = "Blanking Region"; desc = "blanking region"; };
        };

        field {
            name = "vblank";
            desc = "DHD1 blanking region indicator";
            sw = r;
            hw = w;
            encode = DHD1_STATE_vblank_enum;
            reset = 0x1;
        } vblank[1:1];

        enum DHD1_STATE_vback_blank_enum {
            NON_BACK_BLANKING = 0 { name = "Non Back Blanking"; desc = "non-back blanking region"; };
            BLANKING_REGION = 1 { name = "Blanking Region"; desc = "blanking region"; };
        };

        field {
            name = "vback_blank";
            desc = "DHD1 back blanking region indicator";
            sw = r;
            hw = w;
            encode = DHD1_STATE_vback_blank_enum;
            reset = 0x0;
        } vback_blank[0:0];
    } DHD1_STATE @ 0xC4F0;

    reg {
        name = "BT.656 clip lowest threshold register (instant register)";
        desc = "BT_CLIP0_L is a BT.656 clip lowest threshold register (instant register).

Data sheet 9.2.6 BT_CLIP0_L (offset 0xD210, printed page 9-92, `hi3516cv300--Hi3516CV300-Hi3516EV100-Datasheet.txt` line 32853).";

        field {
            name = "clip_cl2";
            desc = "Lowest threshold Y/R of component 2, unsigned integer";
            sw = rw;
            hw = r;
            reset = 0x10;
        } clip_cl2[29:20];

        field {
            name = "clip_cl1";
            desc = "Lowest threshold Cb/G of component 1, unsigned integer";
            sw = rw;
            hw = r;
            reset = 0x10;
        } clip_cl1[19:10];

        field {
            name = "clip_cl0";
            desc = "Lowest threshold Cr/B of component 0, unsigned integer";
            sw = rw;
            hw = r;
            reset = 0x10;
        } clip_cl0[9:0];
    } BT_CLIP0_L @ 0xD210;

    reg {
        name = "BT.656 clip highest threshold register (instant register)";
        desc = "BT_CLIP0_H is a BT.656 clip highest threshold register (instant register). For example, the output data needs to be clipped in BT.656 output mode. Hi3516C V300/Hi3516E V100 Professional HD IP Camera SoC

Data sheet 9.2.6 BT_CLIP0_H (offset 0xD214, printed page 9-93, `hi3516cv300--Hi3516CV300-Hi3516EV100-Datasheet.txt` line 32890).";

        field {
            name = "clip_ch2";
            desc = "Highest threshold Y/R of component 2, unsigned integer";
            sw = rw;
            hw = r;
            reset = 0xEB;
        } clip_ch2[29:20];

        field {
            name = "clip_ch1";
            desc = "Highest threshold Cb/G of component 1, unsigned integer";
            sw = rw;
            hw = r;
            reset = 0xF0;
        } clip_ch1[19:10];

        field {
            name = "clip_ch0";
            desc = "Highest threshold Cr/B of component 0, unsigned integer";
            sw = rw;
            hw = r;
            reset = 0xF0;
        } clip_ch0[9:0];
    } BT_CLIP0_H @ 0xD214;

    reg {
        name = "BT.656 dither control register";
        desc = "BT_DITHER0_CTRL is a BT.656 dither control register.

Data sheet 9.2.6 BT_DITHER0_CTRL (offset 0xD280, printed page 9-93, `hi3516cv300--Hi3516CV300-Hi3516EV100-Datasheet.txt` line 32913).";

        enum BT_DITHER0_CTRL_dither_md_enum {
            V_12_BIT_INPUTS = 0 { name = "V 12 Bit Inputs"; desc = "12-bit inputs, 10-bit outputs, no dithering, and direct bit truncation"; };
            V_12_BIT_INPUTS_2 = 1 { name = "V 12 Bit Inputs 2"; desc = "12-bit inputs, 10-bit outputs, and time-domain dithering"; };
            V_12_BIT_INPUTS_3 = 2 { name = "V 12 Bit Inputs 3"; desc = "12-bit inputs, 10-bit outputs, and spatial-domain dithering"; };
            V_12_BIT_INPUTS_4 = 3 { name = "V 12 Bit Inputs 4"; desc = "12-bit inputs, 8-bit outputs, and time-domain and spatial- domain dithering"; };
            V_12_BIT_INPUTS_5 = 4 { name = "V 12 Bit Inputs 5"; desc = "12-bit inputs, 10-bit outputs, and round off"; };
            V_12_BIT_INPUTS_6 = 5 { name = "V 12 Bit Inputs 6"; desc = "12-bit inputs, 8-bit outputs, and round off Other values: reserved"; };
        };

        field {
            name = "dither_md";
            desc = "Dither mode select";
            sw = rw;
            hw = r;
            encode = BT_DITHER0_CTRL_dither_md_enum;
            reset = 0x1;
        } dither_md[31:29];
    } BT_DITHER0_CTRL @ 0xD280;

    reg {
        name = "BT.656 dither coefficient 0 register 0";
        desc = "BT_DITHER0_COEF0 is BT.656 dither coefficient register 0.

Data sheet 9.2.6 BT_DITHER0_COEF0 (offset 0xD284, printed page 9-94, `hi3516cv300--Hi3516CV300-Hi3516EV100-Datasheet.txt` line 32954).";

        field {
            name = "dither_coef3";
            desc = "Coefficient 3 for time-domain dithering";
            sw = rw;
            hw = r;
            reset = 0xDD;
        } dither_coef3[31:24];

        field {
            name = "dither_coef2";
            desc = "Coefficient 2 for time-domain dithering";
            sw = rw;
            hw = r;
            reset = 0x66;
        } dither_coef2[23:16];

        field {
            name = "dither_coef1";
            desc = "Coefficient 1 for time-domain dithering";
            sw = rw;
            hw = r;
            reset = 0x44;
        } dither_coef1[15:8];

        field {
            name = "dither_coef0";
            desc = "Coefficient 0 for time-domain dithering";
            sw = rw;
            hw = r;
            reset = 0x0;
        } dither_coef0[7:0];
    } BT_DITHER0_COEF0 @ 0xD284;

    reg {
        name = "BT.656 dither coefficient 1 register 1";
        desc = "BT_DITHER0_COEF1 is BT.656 dither coefficient register 1.

Data sheet 9.2.6 BT_DITHER0_COEF1 (offset 0xD288, printed page 9-94, `hi3516cv300--Hi3516CV300-Hi3516EV100-Datasheet.txt` line 32976).";

        field {
            name = "dither_coef7";
            desc = "Coefficient 7 for time-domain dithering";
            sw = rw;
            hw = r;
            reset = 0xDD;
        } dither_coef7[31:24];

        field {
            name = "dither_coef6";
            desc = "Coefficient 6 for time-domain dithering";
            sw = rw;
            hw = r;
            reset = 0x66;
        } dither_coef6[23:16];

        field {
            name = "dither_coef5";
            desc = "Coefficient 5 for time-domain dithering";
            sw = rw;
            hw = r;
            reset = 0x44;
        } dither_coef5[15:8];

        field {
            name = "dither_coef4";
            desc = "Coefficient 4 for time-domain dithering";
            sw = rw;
            hw = r;
            reset = 0x0;
        } dither_coef4[7:0];
    } BT_DITHER0_COEF1 @ 0xD288;

    reg {
        name = "LCD control register";
        desc = "LCD_CTRL is an LCD control register. Hi3516C V300/Hi3516E V100 Professional HD IP Camera SoC

Data sheet 9.2.6 LCD_CTRL (offset 0xD400, printed page 9-95, `hi3516cv300--Hi3516CV300-Hi3516EV100-Datasheet.txt` line 33008).";

        enum LCD_CTRL_lcd_serial_mode_enum {
            RESERVED = 0 { name = "Reserved"; desc = "reserved"; };
            SERIAL_MODE = 1 { name = "Serial Mode"; desc = "serial mode"; };
        };

        field {
            name = "lcd_serial_mode";
            desc = "LCD serial mode";
            sw = rw;
            hw = r;
            encode = LCD_CTRL_lcd_serial_mode_enum;
            reset = 0x0;
        } lcd_serial_mode[29:29];

        enum LCD_CTRL_lcd_serial_perd_enum {
            THREE_CYCLES = 0 { name = "Three Cycles"; desc = "three cycles"; };
            FOUR_CYCLES = 1 { name = "Four Cycles"; desc = "four cycles"; };
        };

        field {
            name = "lcd_serial_perd";
            desc = "Number of cycles of the LCD serial output single-pixel clock";
            sw = rw;
            hw = r;
            encode = LCD_CTRL_lcd_serial_perd_enum;
            reset = 0x0;
        } lcd_serial_perd[28:28];

        enum LCD_CTRL_lcd_data_inv_enum {
            FROM_UPPER_BITS = 0 { name = "From Upper Bits"; desc = "from upper bits to lower bits (bit 15 to bit 0)"; };
            FROM_LOWER_BITS = 1 { name = "From Lower Bits"; desc = "from lower bits to upper bits (bit 0 to bit 15)"; };
        };

        field {
            name = "lcd_data_inv";
            desc = "LCD output line sequence";
            sw = rw;
            hw = r;
            encode = LCD_CTRL_lcd_data_inv_enum;
            reset = 0x0;
        } lcd_data_inv[26:26];
    } LCD_CTRL @ 0xD400;

    reg {
        name = "Sync signal polarity configuration register when the LCD external sync timing is input";
        desc = "Sync signal polarity configuration register when the LCD external sync timing is input.

Data sheet 9.2.6 LCD_SYNC_INV (offset 0xD408, printed page 9-96, `hi3516cv300--Hi3516CV300-Hi3516EV100-Datasheet.txt` line 33062).";

        enum LCD_SYNC_INV_f_inv_enum {
            DISABLED = 0 { name = "Disabled"; desc = "disabled"; };
            ENABLED = 1 { name = "Enabled"; desc = "enabled"; };
        };

        field {
            name = "f_inv";
            desc = "Parity field indicator signal output reverse-phase enable (instant register)";
            sw = rw;
            hw = r;
            encode = LCD_SYNC_INV_f_inv_enum;
            reset = 0x0;
        } f_inv[3:3];

        enum LCD_SYNC_INV_vs_inv_enum {
            DISABLED = 0 { name = "Disabled"; desc = "disabled"; };
            ENABLED = 1 { name = "Enabled"; desc = "enabled"; };
        };

        field {
            name = "vs_inv";
            desc = "Vertical sync pulse output reverse-phase enable (instant register)";
            sw = rw;
            hw = r;
            encode = LCD_SYNC_INV_vs_inv_enum;
            reset = 0x0;
        } vs_inv[2:2];

        enum LCD_SYNC_INV_hs_inv_enum {
            DISABLED = 0 { name = "Disabled"; desc = "disabled"; };
            ENABLED = 1 { name = "Enabled"; desc = "enabled"; };
        };

        field {
            name = "hs_inv";
            desc = "Horizontal sync pulse output reverse-phase enable (instant register)";
            sw = rw;
            hw = r;
            encode = LCD_SYNC_INV_hs_inv_enum;
            reset = 0x0;
        } hs_inv[1:1];

        enum LCD_SYNC_INV_dv_inv_enum {
            DISABLED = 0 { name = "Disabled"; desc = "disabled"; };
            ENABLED = 1 { name = "Enabled"; desc = "enabled"; };
        };

        field {
            name = "dv_inv";
            desc = "Data validity signal output reverse-phase enable (instant register)";
            sw = rw;
            hw = r;
            encode = LCD_SYNC_INV_dv_inv_enum;
            reset = 0x0;
        } dv_inv[0:0];
    } LCD_SYNC_INV @ 0xD408;

    reg {
        name = "Standard parameter configuration register";
        desc = "DATE_COEFF0 is a standard parameter configuration register. Hi3516C V300/Hi3516E V100 Professional HD IP Camera SoC

Data sheet 9.2.6 DATE_COEFF0 (offset 0xF200, printed page 9-97, `hi3516cv300--Hi3516CV300-Hi3516EV100-Datasheet.txt` line 33109).";

        enum DATE_COEFF0_clpf_sel_enum {
            V_1_1_MHZ = 0 { name = "V 1 1 Mhz"; desc = "1.1 MHz (NTSC)"; };
            V_1_3_MHZ = 1 { name = "V 1 3 Mhz"; desc = "1.3 MHz (PAL)"; };
            V_1_6_MHZ = 2 { name = "V 1 6 Mhz"; desc = "1.6 MHz (for test)"; };
            RESERVED = 3 { name = "Reserved"; desc = "reserved"; };
        };

        field {
            name = "clpf_sel";
            desc = "Bandwidth of the chrominance low-pass filter";
            sw = rw;
            hw = r;
            encode = DATE_COEFF0_clpf_sel_enum;
            reset = 0x1;
        } clpf_sel[31:30];

        enum DATE_COEFF0_dis_ire_enum {
            BLACK_LEVEL_7 = 0 { name = "Black Level 7"; desc = "The black level is 7.5 IRE higher than the blanking level."; };
            BLACK_LEVEL_EQUAL = 1 { name = "Black Level Equal"; desc = "The black level is equal to the blanking level."; };
        };

        field {
            name = "dis_ire";
            desc = "For the (M) NTSC and (M, N) PAL standards, the black level is 7.5 IRE higher than the blanking level; for other standards, the black level is equal to the blanking level. This bit controls whether the black level is 7.5 IRE higher than the blanking level.";
            sw = rw;
            hw = r;
            encode = DATE_COEFF0_dis_ire_enum;
            reset = 0x0;
        } dis_ire[29:29];

        enum DATE_COEFF0_pal_half_en_enum {
            DISABLED = 0 { name = "Disabled"; desc = "disabled"; };
            ENABLED = 1 { name = "Enabled"; desc = "enabled"; };
        };

        field {
            name = "pal_half_en";
            desc = "PAL half line reduction enable";
            sw = rw;
            hw = r;
            encode = DATE_COEFF0_pal_half_en_enum;
            reset = 0x0;
        } pal_half_en[27:27];

        enum DATE_COEFF0_pbpr_lpf_en_enum {
            DISABLED = 0 { name = "Disabled"; desc = "disabled"; };
            ENABLED = 1 { name = "Enabled"; desc = "enabled"; };
        };

        field {
            name = "pbpr_lpf_en";
            desc = "Component chrominance low-pass filtering enable";
            sw = rw;
            hw = r;
            encode = DATE_COEFF0_pbpr_lpf_en_enum;
            reset = 0x0;
        } pbpr_lpf_en[26:26];

        enum DATE_COEFF0_scanline_enum {
            V_525_LINES_FRAME = 0 { name = "V 525 Lines Frame"; desc = "525 lines in a frame"; };
            V_625_LINES_FRAME = 1 { name = "V 625 Lines Frame"; desc = "625 lines in a frame"; };
        };

        field {
            name = "scanline";
            desc = "Number of scanned lines in each frame based on standards. For the (M) NTSC, NTSC-J, and (M) PAL standards, each line contains 525 lines; for the (B, D, J, H, I) PAL, (N) PAL, and (Nc) PAL standards, each frame contains 625 lines.";
            sw = rw;
            hw = r;
            encode = DATE_COEFF0_scanline_enum;
            reset = 0x1;
        } scanline[25:25];

        enum DATE_COEFF0_rgb_en_enum {
            YPBPR = 0 { name = "Ypbpr"; desc = "YPbPr"; };
            RGB = 1 { name = "Rgb"; desc = "RGB"; };
        };

        field {
            name = "rgb_en";
            desc = "When intf_sel is set to 100, this bit determines whether the component signal is RGB or YPbPr.";
            sw = rw;
            hw = r;
            encode = DATE_COEFF0_rgb_en_enum;
            reset = 0x0;
        } rgb_en[24:24];

        enum DATE_COEFF0_vbi_lpf_en_enum {
            NO_FILTERING = 0 { name = "No Filtering"; desc = "no filtering"; };
            FILTERING = 1 { name = "Filtering"; desc = "filtering"; };
        };

        field {
            name = "vbi_lpf_en";
            desc = "VBI data low-pass filtering enable";
            sw = rw;
            hw = r;
            encode = DATE_COEFF0_vbi_lpf_en_enum;
            reset = 0x1;
        } vbi_lpf_en[23:23];

        field {
            name = "style_sel";
            desc = "CVBS/S-Video output signal standard when this bit works with the scanline bit When the scanline bit is 0 (525 scanned lines in a frame), the definition of the style_sel bit is as follows: 0x1: (M) NTSC standard 0x2: NTSC-J standard 0x4: (M) PAL standard When the scanline bit is 1 (625 scanned lines in a frame), the definition of the style_sel bit is as follows: 0x1: (B, D, G, H, I) PAL standard 0x2: (N) PAL standard 0x4: (Nc) PAL standard Other values: reserved";
            sw = rw;
            hw = r;
            reset = 0x1;
        } style_sel[21:18];

        field {
            name = "sync_mode_sel";
            desc = "bit[17]: specifies whether there are sync signals in three channels during component output. This bit takes effect only when the sync_mode_scart bit is set to 0. bit[17] is valid only when intf_sel is set to 100 (component output enabled). The definition of bit[17] is as follows: 0: Only one channel contains sync signals during component output. 1: Three channels contain sync signals during component output. When bit[17] is set to 0, the sync channel must be the Y channel for YPbPr output or G channel for RGB output. bit[16]: specifies whether there are blanking radixes during RGB output. bit[16] is valid only when intf_sel is set to 100 and rgb_en is set to 1. The definition of bit[16] is as follows: 0: There are no blanking radixes during RGB output. 1: There are blanking radixes during RGB output.";
            sw = rw;
            hw = r;
            reset = 0x0;
        } sync_mode_sel[17:16];

        enum DATE_COEFF0_sync_mode_scart_enum {
            COMPONENT_SYNC_OUTPUT = 0 { name = "Component Sync Output"; desc = "Component sync output is configured based on sync_mode_sel bit[1]."; };
            COMPONENTS_THREE_CHANNELS = 1 { name = "Components Three Channels"; desc = "The components of the three channels are not overlaid and synchronized. In this case, sync_mode_sel bit[1] must be set to 0."; };
        };

        field {
            name = "sync_mode_scart";
            desc = "Overlay sync control for the components of three channels";
            sw = rw;
            hw = r;
            encode = DATE_COEFF0_sync_mode_scart_enum;
            reset = 0x0;
        } sync_mode_scart[15:15];

        enum DATE_COEFF0_length_sel_enum {
            OUTPUT_ACCORDING_LINE = 0 { name = "Output According Line"; desc = "output according to the line active pixel width in BT.601 mode."; };
            OUTPUT_ACCORDING_LINE_2 = 1 { name = "Output According Line 2"; desc = "output according to the line active pixel width in BT.470 mode When this bit is set to 0, the active width of the line is 720 pixels. When this bit is set to 1, the active width of the line is 704 pixels for the 625-line standard or 712 pixels for the 525-line standard. Currently, the BT.601 mode and BT.470 mode cannot be dynamically switched. You can change the mode only after reset. The BT.601 mode is recommended, and this mode is the default mode after power-on reset."; };
        };

        field {
            name = "length_sel";
            desc = "Active width of each video line (in pixel)";
            sw = rw;
            hw = r;
            encode = DATE_COEFF0_length_sel_enum;
            reset = 0x0;
        } length_sel[14:14];

        enum DATE_COEFF0_agc_amp_sel_enum {
            AGC_PULSE_GENERATED = 0 { name = "Agc Pulse Generated"; desc = "The AGC pulse is generated based on the on-chip default value (recommended)."; };
            AGC_PULSE_GENERATED_2 = 1 { name = "Agc Pulse Generated 2"; desc = "The AGC pulse is generated based on the off-chip configuration."; };
        };

        field {
            name = "agc_amp_sel";
            desc = "AGC pulse select";
            sw = rw;
            hw = r;
            encode = DATE_COEFF0_agc_amp_sel_enum;
            reset = 0x0;
        } agc_amp_sel[13:13];

        field {
            name = "luma_dl";
            desc = "Lead or lag-behind offset of the chrominance signal relative to the luminance signal, in the unit of half a pixel width bit[12]: offset direction of the chrominance signal relative to the luminance signal. 0: The chrominance signal lags behind the luminance signal. 1: The chrominance signal leads the luminance signal. bit[11:9]: absolute offset of the chrominance signal relative to the luminance signal. The value is in binary format and ranges from 0 to 7. 000: The chrominance signal is aligned with the luminance signal. No adjustment is required. 001-111: The chrominance signal leads or lags behind the luminance signal by one to seven units.";
            sw = rw;
            hw = r;
            reset = 0xA;
        } luma_dl[12:9];

        field {
            name = "oversam_en";
            desc = "Level-1 over-sampling enable. Both luminance over-sampling and chrominance over-sampling are controlled. bit[7]: luminance over-sampling enable 0: disabled 1: enabled bit[6]: chrominance over-sampling enable 0: disabled 1: enabled";
            sw = rw;
            hw = r;
            reset = 0x3;
        } oversam_en[7:6];

        enum DATE_COEFF0_lunt_en_enum {
            DISABLED = 0 { name = "Disabled"; desc = "disabled"; };
            ENABLED = 1 { name = "Enabled"; desc = "enabled"; };
        };

        field {
            name = "lunt_en";
            desc = "Luminance notch enable";
            sw = rw;
            hw = r;
            encode = DATE_COEFF0_lunt_en_enum;
            reset = 0x1;
        } lunt_en[5:5];

        enum DATE_COEFF0_oversam2_en_enum {
            DISABLED = 0 { name = "Disabled"; desc = "disabled"; };
            ENABLED = 1 { name = "Enabled"; desc = "enabled"; };
        };

        field {
            name = "oversam2_en";
            desc = "Level-2 over-sampling enable. Both the luminance channel and chrominance channel are controlled.";
            sw = rw;
            hw = r;
            encode = DATE_COEFF0_oversam2_en_enum;
            reset = 0x1;
        } oversam2_en[4:4];

        enum DATE_COEFF0_chlp_en_enum {
            DISABLED = 0 { name = "Disabled"; desc = "disabled"; };
            ENABLED = 1 { name = "Enabled"; desc = "enabled"; };
        };

        field {
            name = "chlp_en";
            desc = "Chrominance low-pass filtering enable";
            sw = rw;
            hw = r;
            encode = DATE_COEFF0_chlp_en_enum;
            reset = 0x1;
        } chlp_en[3:3];

        enum DATE_COEFF0_sylp_en_enum {
            DISABLED = 0 { name = "Disabled"; desc = "disabled"; };
            ENABLED = 1 { name = "Enabled"; desc = "enabled"; };
        };

        field {
            name = "sylp_en";
            desc = "Sync low-pass filtering enable";
            sw = rw;
            hw = r;
            encode = DATE_COEFF0_sylp_en_enum;
            reset = 0x1;
        } sylp_en[2:2];

        enum DATE_COEFF0_chgain_en_enum {
            DISABLED = 0 { name = "Disabled"; desc = "disabled"; };
            ENABLED = 1 { name = "Enabled"; desc = "enabled"; };
        };

        field {
            name = "chgain_en";
            desc = "Chrominance gain enable";
            sw = rw;
            hw = r;
            encode = DATE_COEFF0_chgain_en_enum;
            reset = 0x0;
        } chgain_en[1:1];
    } DATE_COEFF0 @ 0xF200;

    reg {
        name = "Output matrix control register";
        desc = "DATE_COEFF21 is an output matrix control register.

Data sheet 9.2.6 DATE_COEFF21 (offset 0xF254, printed page 9-100, `hi3516cv300--Hi3516CV300-Hi3516EV100-Datasheet.txt` line 33288).";

        field {
            name = "dac0_in_sel";
            desc = "DAC0 output mode 001: CVBS Other values: reserved";
            sw = rw;
            hw = r;
            reset = 0x2;
        } dac0_in_sel[2:0];
    } DATE_COEFF21 @ 0xF254;

    reg {
        name = "Discrete time oscillator (DTO) initial phase configuration register";
        desc = "DATE_COEFF22 is a DTO initial phase configuration register. Hi3516C V300/Hi3516E V100 Professional HD IP Camera SoC

Data sheet 9.2.6 DATE_COEFF22 (offset 0xF258, printed page 9-101, `hi3516cv300--Hi3516CV300-Hi3516EV100-Datasheet.txt` line 33327).";

        field {
            name = "video_phase_delta";
            desc = "DTO initial phase";
            sw = rw;
            hw = r;
            reset = 0x0;
        } video_phase_delta[10:0];
    } DATE_COEFF22 @ 0xF258;

    reg {
        name = "VIDEO_OUT delay configuration register";
        desc = "DATE_COEFF23 is a VIDEO_OUT delay configuration register.

Data sheet 9.2.6 DATE_COEFF23 (offset 0xF25C, printed page 9-101, `hi3516cv300--Hi3516CV300-Hi3516EV100-Datasheet.txt` line 33346).";

        field {
            name = "dac0_out_dly";
            desc = "DAC0 output delay cycle The value is measured by a 54 MHz clock cycle, and the value indicates delay cycles.";
            sw = rw;
            hw = r;
            reset = 0x0;
        } dac0_out_dly[2:0];
    } DATE_COEFF23 @ 0xF25C;

    reg {
        name = "Color burst start position register";
        desc = "DATE_COEFF24 is a color burst start position register. Hi3516C V300/Hi3516E V100 Professional HD IP Camera SoC

Data sheet 9.2.6 DATE_COEFF24 (offset 0xF260, printed page 9-102, `hi3516cv300--Hi3516CV300-Hi3516EV100-Datasheet.txt` line 33384).";

        field {
            name = "burst_start";
            desc = "Color burst start position";
            sw = rw;
            hw = r;
            reset = 0x00012C99;
        } burst_start[31:0];
    } DATE_COEFF24 @ 0xF260;

    reg {
        name = "Up-sampling filtering coefficient register 1";
        desc = "DATE_COEFF37 is the up-sampling filtering coefficient register 1.

Data sheet 9.2.6 DATE_COEFF37 (offset 0xF294, printed page 9-102, `hi3516cv300--Hi3516CV300-Hi3516EV100-Datasheet.txt` line 33402).";

        field {
            name = "fir_y1_coeff3";
            desc = "Coefficient 13 for luminance up-sampling and filtering";
            sw = rw;
            hw = r;
            reset = 0x19;
        } fir_y1_coeff3[31:24];

        field {
            name = "fir_y1_coeff2";
            desc = "Coefficient 12 for luminance up-sampling and filtering";
            sw = rw;
            hw = r;
            reset = 0xEF;
        } fir_y1_coeff2[23:16];

        field {
            name = "fir_y1_coeff1";
            desc = "Coefficient 11 for luminance up-sampling and filtering";
            sw = rw;
            hw = r;
            reset = 0xC;
        } fir_y1_coeff1[15:8];

        field {
            name = "fir_y1_coeff0";
            desc = "Coefficient 10 for luminance up-sampling and filtering";
            sw = rw;
            hw = r;
            reset = 0xF9;
        } fir_y1_coeff0[7:0];
    } DATE_COEFF37 @ 0xF294;

    reg {
        name = "Up-sampling filtering coefficient register 2";
        desc = "DATE_COEFF38 is the up-sampling filtering coefficient register 2.

Data sheet 9.2.6 DATE_COEFF38 (offset 0xF298, printed page 9-102, `hi3516cv300--Hi3516CV300-Hi3516EV100-Datasheet.txt` line 33424).";

        field {
            name = "fir_y2_coeff1";
            desc = "Coefficient 21 for luminance up-sampling and filtering";
            sw = rw;
            hw = r;
            reset = 0x3A;
        } fir_y2_coeff1[31:16];

        field {
            name = "fir_y2_coeff0";
            desc = "Coefficient 20 for luminance up-sampling and filtering";
            sw = rw;
            hw = r;
            reset = 0xFFDA;
        } fir_y2_coeff0[15:0];
    } DATE_COEFF38 @ 0xF298;

    reg {
        name = "Up-sampling filtering coefficient register 3";
        desc = "DATE_COEFF39 is the up-sampling filtering coefficient register 3.

Data sheet 9.2.6 DATE_COEFF39 (offset 0xF29C, printed page 9-103, `hi3516cv300--Hi3516CV300-Hi3516EV100-Datasheet.txt` line 33448).";

        field {
            name = "fir_y2_coeff3";
            desc = "Coefficient 23 for luminance up-sampling and filtering";
            sw = rw;
            hw = r;
            reset = 0x148;
        } fir_y2_coeff3[31:16];

        field {
            name = "fir_y2_coeff2";
            desc = "Coefficient 22 for luminance up-sampling and filtering";
            sw = rw;
            hw = r;
            reset = 0xFF97;
        } fir_y2_coeff2[15:0];
    } DATE_COEFF39 @ 0xF29C;

    reg {
        name = "Up-sampling filtering coefficient register 4";
        desc = "DATE_COEFF40 is the up-sampling filtering coefficient register 4.

Data sheet 9.2.6 DATE_COEFF40 (offset 0xF2A0, printed page 9-103, `hi3516cv300--Hi3516CV300-Hi3516EV100-Datasheet.txt` line 33468).";

        field {
            name = "fir_c1_coeff3";
            desc = "Coefficient 13 for chrominance up-sampling and filtering";
            sw = rw;
            hw = r;
            reset = 0x19;
        } fir_c1_coeff3[31:24];

        field {
            name = "fir_c1_coeff2";
            desc = "Coefficient 12 for chrominance up-sampling and filtering";
            sw = rw;
            hw = r;
            reset = 0xEF;
        } fir_c1_coeff2[23:16];

        field {
            name = "fir_c1_coeff1";
            desc = "Coefficient 11 for chrominance up-sampling and filtering";
            sw = rw;
            hw = r;
            reset = 0xC;
        } fir_c1_coeff1[15:8];

        field {
            name = "fir_c1_coeff0";
            desc = "Coefficient 10 for chrominance up-sampling and filtering";
            sw = rw;
            hw = r;
            reset = 0xF9;
        } fir_c1_coeff0[7:0];
    } DATE_COEFF40 @ 0xF2A0;

    reg {
        name = "Up-sampling filtering coefficient register 5";
        desc = "DATE_COEFF41 is the up-sampling filtering coefficient register 5. Hi3516C V300/Hi3516E V100 Professional HD IP Camera SoC

Data sheet 9.2.6 DATE_COEFF41 (offset 0xF2A4, printed page 9-104, `hi3516cv300--Hi3516CV300-Hi3516EV100-Datasheet.txt` line 33499).";

        field {
            name = "fir_c2_coeff1";
            desc = "Coefficient 21 for chrominance up-sampling and filtering";
            sw = rw;
            hw = r;
            reset = 0x3A;
        } fir_c2_coeff1[31:16];

        field {
            name = "fir_c2_coeff0";
            desc = "Coefficient 20 for chrominance up-sampling and filtering";
            sw = rw;
            hw = r;
            reset = 0xFFDA;
        } fir_c2_coeff0[15:0];
    } DATE_COEFF41 @ 0xF2A4;

    reg {
        name = "Up-sampling filtering coefficient register 6";
        desc = "DATE_COEFF42 is the up-sampling filtering coefficient register 6.

Data sheet 9.2.6 DATE_COEFF42 (offset 0xF2A8, printed page 9-104, `hi3516cv300--Hi3516CV300-Hi3516EV100-Datasheet.txt` line 33518).";

        field {
            name = "fir_c2_coeff3";
            desc = "Coefficient 23 for chrominance up-sampling and filtering";
            sw = rw;
            hw = r;
            reset = 0x148;
        } fir_c2_coeff3[31:16];

        field {
            name = "fir_c2_coeff2";
            desc = "Coefficient 22 for chrominance up-sampling and filtering";
            sw = rw;
            hw = r;
            reset = 0xFF97;
        } fir_c2_coeff2[15:0];
    } DATE_COEFF42 @ 0xF2A8;

    reg {
        name = "DAC automatic detection register 1";
        desc = "DATE_DACDET1 is the DAC automatic detection register 1.

Data sheet 9.2.6 DATE_DACDET1 (offset 0xF2C0, printed page 9-104, `hi3516cv300--Hi3516CV300-Hi3516EV100-Datasheet.txt` line 33538).";

        field {
            name = "det_line";
            desc = "Line of the detected level";
            sw = rw;
            hw = r;
            reset = 0xD;
        } det_line[25:16];

        field {
            name = "vdac_det_high";
            desc = "Detected level";
            sw = rw;
            hw = r;
            reset = 0x303;
        } vdac_det_high[9:0];
    } DATE_DACDET1 @ 0xF2C0;

    reg {
        name = "DAC automatic detection register 2";
        desc = "DATE_DACDET2 is the DAC automatic detection register 2.

Data sheet 9.2.6 DATE_DACDET2 (offset 0xF2C4, printed page 9-105, `hi3516cv300--Hi3516CV300-Hi3516EV100-Datasheet.txt` line 33569).";

        enum DATE_DACDET2_vdac_det_en_enum {
            DISABLED = 0 { name = "Disabled"; desc = "disabled"; };
            ENABLED = 1 { name = "Enabled"; desc = "enabled"; };
        };

        field {
            name = "vdac_det_en";
            desc = "DAC automatic detection enable";
            sw = rw;
            hw = r;
            encode = DATE_DACDET2_vdac_det_en_enum;
            reset = 0x0;
        } vdac_det_en[31:31];

        field {
            name = "det_pixel_wid";
            desc = "Level width";
            sw = rw;
            hw = r;
            reset = 0x30;
        } det_pixel_wid[26:16];

        field {
            name = "det_pixel_sta";
            desc = "Start position of a line";
            sw = rw;
            hw = r;
            reset = 0x118;
        } det_pixel_sta[10:0];
    } DATE_DACDET2 @ 0xF2C4;

    reg {
        name = "Over-sampling round-off register";
        desc = "DATE_COEFF56 is an over-sampling round-off register. Hi3516C V300/Hi3516E V100 Professional HD IP Camera SoC

Data sheet 9.2.6 DATE_COEFF56 (offset 0xF2E0, printed page 9-106, `hi3516cv300--Hi3516CV300-Hi3516EV100-Datasheet.txt` line 33611).";

        enum DATE_COEFF56_oversam2_round_en_enum {
            DISABLED = 0 { name = "Disabled"; desc = "disabled"; };
            ENABLED = 1 { name = "Enabled"; desc = "enabled"; };
        };

        field {
            name = "oversam2_round_en";
            desc = "Round-off enable during 2x up-sampling";
            sw = rw;
            hw = r;
            encode = DATE_COEFF56_oversam2_round_en_enum;
            reset = 0x0;
        } oversam2_round_en[0:0];
    } DATE_COEFF56 @ 0xF2E0;

    reg {
        name = "CVBS gain control register";
        desc = "DATE_COEFF57 is a CVBS gain control register.

Data sheet 9.2.6 DATE_COEFF57 (offset 0xF2E4, printed page 9-106, `hi3516cv300--Hi3516CV300-Hi3516EV100-Datasheet.txt` line 33641).";

        enum DATE_COEFF57_cvbs_gain_en_enum {
            DISABLED = 0 { name = "Disabled"; desc = "disabled"; };
            ENABLED = 1 { name = "Enabled"; desc = "enabled"; };
        };

        field {
            name = "cvbs_gain_en";
            desc = "CVBS gain enable";
            sw = rw;
            hw = r;
            encode = DATE_COEFF57_cvbs_gain_en_enum;
            reset = 0x0;
        } cvbs_gain_en[31:31];

        field {
            name = "ycvbs_gain";
            desc = "Gain control of the luminance component Y";
            sw = rw;
            hw = r;
            reset = 0x0;
        } ycvbs_gain[23:16];

        field {
            name = "u_gain";
            desc = "Gain control of the chrominance component U";
            sw = rw;
            hw = r;
            reset = 0x0;
        } u_gain[15:8];

        field {
            name = "v_gain";
            desc = "Gain control of the chrominance component V";
            sw = rw;
            hw = r;
            reset = 0x0;
        } v_gain[7:0];
    } DATE_COEFF57 @ 0xF2E4;

    reg {
        name = "Component gain control register";
        desc = "DATE_COEFF58 is a component gain control register.

Data sheet 9.2.6 DATE_COEFF58 (offset 0xF2E8, printed page 9-107, `hi3516cv300--Hi3516CV300-Hi3516EV100-Datasheet.txt` line 33678).";

        enum DATE_COEFF58_comp_gain_en_enum {
            DISABLED = 0 { name = "Disabled"; desc = "disabled"; };
            ENABLED = 1 { name = "Enabled"; desc = "enabled"; };
        };

        field {
            name = "comp_gain_en";
            desc = "Component gain enable";
            sw = rw;
            hw = r;
            encode = DATE_COEFF58_comp_gain_en_enum;
            reset = 0x0;
        } comp_gain_en[31:31];

        field {
            name = "ycomp_gain";
            desc = "Gain control of the luminance component Y";
            sw = rw;
            hw = r;
            reset = 0x0;
        } ycomp_gain[23:16];

        field {
            name = "pb_gain";
            desc = "Gain control of the chrominance component U";
            sw = rw;
            hw = r;
            reset = 0x0;
        } pb_gain[15:8];

        field {
            name = "pr_gain";
            desc = "Gain control of the chrominance component V";
            sw = rw;
            hw = r;
            reset = 0x0;
        } pr_gain[7:0];
    } DATE_COEFF58 @ 0xF2E8;

    reg {
        name = "Clip control bit register";
        desc = "DATE_COEFF59 is a clip control bit register.

Data sheet 9.2.6 DATE_COEFF59 (offset 0xF2EC, printed page 9-107, `hi3516cv300--Hi3516CV300-Hi3516EV100-Datasheet.txt` line 33710).";

        enum DATE_COEFF59_cb_gain_polar_enum {
            NEGATIVE_GAIN = 0 { name = "Negative Gain"; desc = "negative gain"; };
            POSITIVE_GAIN = 1 { name = "Positive Gain"; desc = "positive gain"; };
        };

        field {
            name = "cb_gain_polar";
            desc = "Chrominance subcarrier polarity control";
            sw = rw;
            hw = r;
            encode = DATE_COEFF59_cb_gain_polar_enum;
            reset = 0x0;
        } cb_gain_polar[16:16];

        enum DATE_COEFF59_cr_os_clip_fullrange_enum {
            DISABLED = 0 { name = "Disabled"; desc = "disabled"; };
            ENABLED = 1 { name = "Enabled"; desc = "enabled"; };
        };

        field {
            name = "cr_os_clip_fullrange";
            desc = "Cr component clip enable on the up-sampling module";
            sw = rw;
            hw = r;
            encode = DATE_COEFF59_cr_os_clip_fullrange_enum;
            reset = 0x0;
        } cr_os_clip_fullrange[13:13];

        enum DATE_COEFF59_cb_os_clip_fullrange_enum {
            DISABLED = 0 { name = "Disabled"; desc = "disabled"; };
            ENABLED = 1 { name = "Enabled"; desc = "enabled"; };
        };

        field {
            name = "cb_os_clip_fullrange";
            desc = "Cb component clip enable on the up-sampling module";
            sw = rw;
            hw = r;
            encode = DATE_COEFF59_cb_os_clip_fullrange_enum;
            reset = 0x0;
        } cb_os_clip_fullrange[12:12];

        enum DATE_COEFF59_v_os_clip_fullrange_enum {
            DISABLED = 0 { name = "Disabled"; desc = "disabled"; };
            ENABLED = 1 { name = "Enabled"; desc = "enabled"; };
        };

        field {
            name = "v_os_clip_fullrange";
            desc = "V component clip enable on the up-sampling module";
            sw = rw;
            hw = r;
            encode = DATE_COEFF59_v_os_clip_fullrange_enum;
            reset = 0x0;
        } v_os_clip_fullrange[9:9];

        enum DATE_COEFF59_u_os_clip_fullrange_enum {
            DISABLED = 0 { name = "Disabled"; desc = "disabled"; };
            ENABLED = 1 { name = "Enabled"; desc = "enabled"; };
        };

        field {
            name = "u_os_clip_fullrange";
            desc = "U component clip enable on the up-sampling module";
            sw = rw;
            hw = r;
            encode = DATE_COEFF59_u_os_clip_fullrange_enum;
            reset = 0x0;
        } u_os_clip_fullrange[8:8];

        enum DATE_COEFF59_y_os_clip_fullrange_enum {
            DISABLED = 0 { name = "Disabled"; desc = "disabled"; };
            ENABLED = 1 { name = "Enabled"; desc = "enabled"; };
        };

        field {
            name = "y_os_clip_fullrange";
            desc = "Y component clip enable on the up-sampling module";
            sw = rw;
            hw = r;
            encode = DATE_COEFF59_y_os_clip_fullrange_enum;
            reset = 0x0;
        } y_os_clip_fullrange[4:4];

        enum DATE_COEFF59_clpf_clip_fullrange_enum {
            DISABLED = 0 { name = "Disabled"; desc = "disabled"; };
            ENABLED = 1 { name = "Enabled"; desc = "enabled"; };
        };

        field {
            name = "clpf_clip_fullrange";
            desc = "Chrominance low-pass module clip enable";
            sw = rw;
            hw = r;
            encode = DATE_COEFF59_clpf_clip_fullrange_enum;
            reset = 0x0;
        } clpf_clip_fullrange[1:1];

        enum DATE_COEFF59_ynotch_clip_fullrange_enum {
            DISABLED = 0 { name = "Disabled"; desc = "disabled"; };
            ENABLED = 1 { name = "Enabled"; desc = "enabled"; };
        };

        field {
            name = "ynotch_clip_fullrange";
            desc = "Luminance notch module clip enable";
            sw = rw;
            hw = r;
            encode = DATE_COEFF59_ynotch_clip_fullrange_enum;
            reset = 0x0;
        } ynotch_clip_fullrange[0:0];
    } DATE_COEFF59 @ 0xF2EC;
};

`endif
