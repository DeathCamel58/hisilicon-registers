`ifndef HISI_VGS_V2_NODE_RDL
`define HISI_VGS_V2_NODE_RDL

regfile eHISI_VGS_V2_NODE {
    name = "VGS job node image (NOT A REGISTER FILE), Hi3516C V300 / E V100";
    desc = "NOT A REGISTER FILE and NOT INSTANTIATED: layout of one VGS job node as written by the VGS_DRV_Set*Reg functions of hi3516cv300_vgs.ko (Xiongmai V4.02.R12). Same scanner limits as eHISI_VPSS_V2_NODE (bit extents are lower bounds). Control words 0x004/0x008/0x00C come from VGS_DRV_SetCtrlReg, OSD from SetOsdReg (0x078, 0x130-0x140, 0x24C, 0x330/0x334), crop 0x028/0x02C, current image 0x020/0x100-0x114, luma statistics 0x1C0/0x268/0x26C, CSC 0x3B0-0x3C0 and further words (see below). Not hardware verified.";

    reg {
        name = "Node word at offset 0x4";
        desc = "Word 0x4 of the node image. PROVENANCE: PROVEN offset and the listed bit extents (read from the load/store/bic/orr sequence of the named vendor function, hi3516cv300 Xiongmai module); INFERRED that a function name describes the content; UNKNOWN field meaning. Written by: VGS_DRV_SetCtrlReg.";
        field {
            name = "word";
            desc = "32-bit word (layout see the register description).";
            sw = rw;
            hw = r;
        } word[31:0];
    } NODE_W_004 @ 0x4;

    reg {
        name = "Node word at offset 0x8";
        desc = "Word 0x8 of the node image. PROVENANCE: PROVEN offset and the listed bit extents (read from the load/store/bic/orr sequence of the named vendor function, hi3516cv300 Xiongmai module); INFERRED that a function name describes the content; UNKNOWN field meaning. Written by: VGS_DRV_SetCtrlReg.";
        field {
            name = "word";
            desc = "32-bit word (layout see the register description).";
            sw = rw;
            hw = r;
        } word[31:0];
    } NODE_W_008 @ 0x8;

    reg {
        name = "Node word at offset 0xC";
        desc = "Word 0xC of the node image. PROVENANCE: PROVEN offset and the listed bit extents (read from the load/store/bic/orr sequence of the named vendor function, hi3516cv300 Xiongmai module); INFERRED that a function name describes the content; UNKNOWN field meaning. Written by: VGS_DRV_SetCtrlReg.";
        field {
            name = "word";
            desc = "32-bit word (layout see the register description).";
            sw = rw;
            hw = r;
        } word[31:0];
    } NODE_W_00C @ 0xC;

    reg {
        name = "Node word at offset 0x20";
        desc = "Word 0x20 of the node image. PROVENANCE: PROVEN offset and the listed bit extents (read from the load/store/bic/orr sequence of the named vendor function, hi3516cv300 Xiongmai module); INFERRED that a function name describes the content; UNKNOWN field meaning. Written by: VGS_DRV_SetCurImgReg.";
        field {
            name = "word";
            desc = "32-bit word (layout see the register description).";
            sw = rw;
            hw = r;
        } word[31:0];
    } NODE_W_020 @ 0x20;

    reg {
        name = "Node word at offset 0x28";
        desc = "Word 0x28 of the node image. PROVENANCE: PROVEN offset and the listed bit extents (read from the load/store/bic/orr sequence of the named vendor function, hi3516cv300 Xiongmai module); INFERRED that a function name describes the content; UNKNOWN field meaning. Written by: VGS_DRV_SetCropReg.";
        field {
            name = "word";
            desc = "32-bit word (layout see the register description).";
            sw = rw;
            hw = r;
        } word[31:0];
    } NODE_W_028 @ 0x28;

    reg {
        name = "Node word at offset 0x2C";
        desc = "Word 0x2C of the node image. PROVENANCE: PROVEN offset and the listed bit extents (read from the load/store/bic/orr sequence of the named vendor function, hi3516cv300 Xiongmai module); INFERRED that a function name describes the content; UNKNOWN field meaning. Written by: VGS_DRV_SetCropReg.";
        field {
            name = "word";
            desc = "32-bit word (layout see the register description).";
            sw = rw;
            hw = r;
        } word[31:0];
    } NODE_W_02C @ 0x2C;

    reg {
        name = "Node word at offset 0x64";
        desc = "Word 0x64 of the node image. PROVENANCE: PROVEN offset and the listed bit extents (read from the load/store/bic/orr sequence of the named vendor function, hi3516cv300 Xiongmai module); INFERRED that a function name describes the content; UNKNOWN field meaning. Written by: VGS_DRV_SetDstImgReg.";
        field {
            name = "word";
            desc = "32-bit word (layout see the register description).";
            sw = rw;
            hw = r;
        } word[31:0];
    } NODE_W_064 @ 0x64;

    reg {
        name = "Node word at offset 0x78";
        desc = "Word 0x78 of the node image. PROVENANCE: PROVEN offset and the listed bit extents (read from the load/store/bic/orr sequence of the named vendor function, hi3516cv300 Xiongmai module); INFERRED that a function name describes the content; UNKNOWN field meaning. Written by: VGS_DRV_SetOsdReg.";
        field {
            name = "word";
            desc = "32-bit word (layout see the register description).";
            sw = rw;
            hw = r;
        } word[31:0];
    } NODE_W_078 @ 0x78;

    reg {
        name = "Node word at offset 0x100";
        desc = "Word 0x100 of the node image. PROVENANCE: PROVEN offset and the listed bit extents (read from the load/store/bic/orr sequence of the named vendor function, hi3516cv300 Xiongmai module); INFERRED that a function name describes the content; UNKNOWN field meaning. Written by: VGS_DRV_SetCurImgReg.";
        field {
            name = "word";
            desc = "32-bit word (layout see the register description).";
            sw = rw;
            hw = r;
        } word[31:0];
    } NODE_W_100 @ 0x100;

    reg {
        name = "Node word at offset 0x104";
        desc = "Word 0x104 of the node image. PROVENANCE: PROVEN offset and the listed bit extents (read from the load/store/bic/orr sequence of the named vendor function, hi3516cv300 Xiongmai module); INFERRED that a function name describes the content; UNKNOWN field meaning. Written by: VGS_DRV_SetCurImgReg.";
        field {
            name = "word";
            desc = "32-bit word (layout see the register description).";
            sw = rw;
            hw = r;
        } word[31:0];
    } NODE_W_104 @ 0x104;

    reg {
        name = "Node word at offset 0x108";
        desc = "Word 0x108 of the node image. PROVENANCE: PROVEN offset and the listed bit extents (read from the load/store/bic/orr sequence of the named vendor function, hi3516cv300 Xiongmai module); INFERRED that a function name describes the content; UNKNOWN field meaning. Written by: VGS_DRV_SetCurImgReg.";
        field {
            name = "word";
            desc = "32-bit word (layout see the register description).";
            sw = rw;
            hw = r;
        } word[31:0];
    } NODE_W_108 @ 0x108;

    reg {
        name = "Node word at offset 0x10C";
        desc = "Word 0x10C of the node image. PROVENANCE: PROVEN offset and the listed bit extents (read from the load/store/bic/orr sequence of the named vendor function, hi3516cv300 Xiongmai module); INFERRED that a function name describes the content; UNKNOWN field meaning. Written by: VGS_DRV_SetCurImgReg.";
        field {
            name = "word";
            desc = "32-bit word (layout see the register description).";
            sw = rw;
            hw = r;
        } word[31:0];
    } NODE_W_10C @ 0x10C;

    reg {
        name = "Node word at offset 0x110";
        desc = "Word 0x110 of the node image. PROVENANCE: PROVEN offset and the listed bit extents (read from the load/store/bic/orr sequence of the named vendor function, hi3516cv300 Xiongmai module); INFERRED that a function name describes the content; UNKNOWN field meaning. Written by: VGS_DRV_SetCurImgReg.";
        field {
            name = "word";
            desc = "32-bit word (layout see the register description).";
            sw = rw;
            hw = r;
        } word[31:0];
    } NODE_W_110 @ 0x110;

    reg {
        name = "Node word at offset 0x114";
        desc = "Word 0x114 of the node image. PROVENANCE: PROVEN offset and the listed bit extents (read from the load/store/bic/orr sequence of the named vendor function, hi3516cv300 Xiongmai module); INFERRED that a function name describes the content; UNKNOWN field meaning. Written by: VGS_DRV_SetCurImgReg.";
        field {
            name = "word";
            desc = "32-bit word (layout see the register description).";
            sw = rw;
            hw = r;
        } word[31:0];
    } NODE_W_114 @ 0x114;

    reg {
        name = "Node word at offset 0x130";
        desc = "Word 0x130 of the node image. PROVENANCE: PROVEN offset and the listed bit extents (read from the load/store/bic/orr sequence of the named vendor function, hi3516cv300 Xiongmai module); INFERRED that a function name describes the content; UNKNOWN field meaning. Written by: VGS_DRV_SetOsdReg.";
        field {
            name = "word";
            desc = "32-bit word (layout see the register description).";
            sw = rw;
            hw = r;
        } word[31:0];
    } NODE_W_130 @ 0x130;

    reg {
        name = "Node word at offset 0x134";
        desc = "Word 0x134 of the node image. PROVENANCE: PROVEN offset and the listed bit extents (read from the load/store/bic/orr sequence of the named vendor function, hi3516cv300 Xiongmai module); INFERRED that a function name describes the content; UNKNOWN field meaning. Written by: VGS_DRV_SetOsdReg.";
        field {
            name = "word";
            desc = "32-bit word (layout see the register description).";
            sw = rw;
            hw = r;
        } word[31:0];
    } NODE_W_134 @ 0x134;

    reg {
        name = "Node word at offset 0x138";
        desc = "Word 0x138 of the node image. PROVENANCE: PROVEN offset and the listed bit extents (read from the load/store/bic/orr sequence of the named vendor function, hi3516cv300 Xiongmai module); INFERRED that a function name describes the content; UNKNOWN field meaning. Written by: VGS_DRV_SetOsdReg.";
        field {
            name = "word";
            desc = "32-bit word (layout see the register description).";
            sw = rw;
            hw = r;
        } word[31:0];
    } NODE_W_138 @ 0x138;

    reg {
        name = "Node word at offset 0x140";
        desc = "Word 0x140 of the node image. PROVENANCE: PROVEN offset and the listed bit extents (read from the load/store/bic/orr sequence of the named vendor function, hi3516cv300 Xiongmai module); INFERRED that a function name describes the content; UNKNOWN field meaning. Written by: VGS_DRV_SetOsdReg modifies bits [9:8] (sets constants 0xFF).";
        field {
            name = "word";
            desc = "32-bit word (layout see the register description).";
            sw = rw;
            hw = r;
        } word[31:0];
    } NODE_W_140 @ 0x140;

    reg {
        name = "Node word at offset 0x144";
        desc = "Word 0x144 of the node image. PROVENANCE: PROVEN offset and the listed bit extents (read from the load/store/bic/orr sequence of the named vendor function, hi3516cv300 Xiongmai module); INFERRED that a function name describes the content; UNKNOWN field meaning. Written by: VGS_DRV_SetDstImgReg.";
        field {
            name = "word";
            desc = "32-bit word (layout see the register description).";
            sw = rw;
            hw = r;
        } word[31:0];
    } NODE_W_144 @ 0x144;

    reg {
        name = "Node word at offset 0x148";
        desc = "Word 0x148 of the node image. PROVENANCE: PROVEN offset and the listed bit extents (read from the load/store/bic/orr sequence of the named vendor function, hi3516cv300 Xiongmai module); INFERRED that a function name describes the content; UNKNOWN field meaning. Written by: VGS_DRV_SetDstImgReg.";
        field {
            name = "word";
            desc = "32-bit word (layout see the register description).";
            sw = rw;
            hw = r;
        } word[31:0];
    } NODE_W_148 @ 0x148;

    reg {
        name = "Node word at offset 0x14C";
        desc = "Word 0x14C of the node image. PROVENANCE: PROVEN offset and the listed bit extents (read from the load/store/bic/orr sequence of the named vendor function, hi3516cv300 Xiongmai module); INFERRED that a function name describes the content; UNKNOWN field meaning. Written by: VGS_DRV_SetDstImgReg.";
        field {
            name = "word";
            desc = "32-bit word (layout see the register description).";
            sw = rw;
            hw = r;
        } word[31:0];
    } NODE_W_14C @ 0x14C;

    reg {
        name = "Node word at offset 0x150";
        desc = "Word 0x150 of the node image. PROVENANCE: PROVEN offset and the listed bit extents (read from the load/store/bic/orr sequence of the named vendor function, hi3516cv300 Xiongmai module); INFERRED that a function name describes the content; UNKNOWN field meaning. Written by: VGS_DRV_SetDstImgReg.";
        field {
            name = "word";
            desc = "32-bit word (layout see the register description).";
            sw = rw;
            hw = r;
        } word[31:0];
    } NODE_W_150 @ 0x150;

    reg {
        name = "Node word at offset 0x154";
        desc = "Word 0x154 of the node image. PROVENANCE: PROVEN offset and the listed bit extents (read from the load/store/bic/orr sequence of the named vendor function, hi3516cv300 Xiongmai module); INFERRED that a function name describes the content; UNKNOWN field meaning. Written by: VGS_DRV_SetDstImgReg.";
        field {
            name = "word";
            desc = "32-bit word (layout see the register description).";
            sw = rw;
            hw = r;
        } word[31:0];
    } NODE_W_154 @ 0x154;

    reg {
        name = "Node word at offset 0x158";
        desc = "Word 0x158 of the node image. PROVENANCE: PROVEN offset and the listed bit extents (read from the load/store/bic/orr sequence of the named vendor function, hi3516cv300 Xiongmai module); INFERRED that a function name describes the content; UNKNOWN field meaning. Written by: VGS_DRV_SetDstImgReg.";
        field {
            name = "word";
            desc = "32-bit word (layout see the register description).";
            sw = rw;
            hw = r;
        } word[31:0];
    } NODE_W_158 @ 0x158;

    reg {
        name = "Node word at offset 0x1C0";
        desc = "Word 0x1C0 of the node image. PROVENANCE: PROVEN offset and the listed bit extents (read from the load/store/bic/orr sequence of the named vendor function, hi3516cv300 Xiongmai module); INFERRED that a function name describes the content; UNKNOWN field meaning. Written by: VGS_DRV_SetLumaReg.";
        field {
            name = "word";
            desc = "32-bit word (layout see the register description).";
            sw = rw;
            hw = r;
        } word[31:0];
    } NODE_W_1C0 @ 0x1C0;

    reg {
        name = "Node word at offset 0x200";
        desc = "Word 0x200 of the node image. PROVENANCE: PROVEN offset and the listed bit extents (read from the load/store/bic/orr sequence of the named vendor function, hi3516cv300 Xiongmai module); INFERRED that a function name describes the content; UNKNOWN field meaning. Written by: VGS_DRV_SetReg.";
        field {
            name = "word";
            desc = "32-bit word (layout see the register description).";
            sw = rw;
            hw = r;
        } word[31:0];
    } NODE_W_200 @ 0x200;

    reg {
        name = "Node word at offset 0x204";
        desc = "Word 0x204 of the node image. PROVENANCE: PROVEN offset and the listed bit extents (read from the load/store/bic/orr sequence of the named vendor function, hi3516cv300 Xiongmai module); INFERRED that a function name describes the content; UNKNOWN field meaning. Written by: VGS_DRV_SetReg.";
        field {
            name = "word";
            desc = "32-bit word (layout see the register description).";
            sw = rw;
            hw = r;
        } word[31:0];
    } NODE_W_204 @ 0x204;

    reg {
        name = "Node word at offset 0x208";
        desc = "Word 0x208 of the node image. PROVENANCE: PROVEN offset and the listed bit extents (read from the load/store/bic/orr sequence of the named vendor function, hi3516cv300 Xiongmai module); INFERRED that a function name describes the content; UNKNOWN field meaning. Written by: VGS_DRV_SetReg.";
        field {
            name = "word";
            desc = "32-bit word (layout see the register description).";
            sw = rw;
            hw = r;
        } word[31:0];
    } NODE_W_208 @ 0x208;

    reg {
        name = "Node word at offset 0x20C";
        desc = "Word 0x20C of the node image. PROVENANCE: PROVEN offset and the listed bit extents (read from the load/store/bic/orr sequence of the named vendor function, hi3516cv300 Xiongmai module); INFERRED that a function name describes the content; UNKNOWN field meaning. Written by: VGS_DRV_SetReg.";
        field {
            name = "word";
            desc = "32-bit word (layout see the register description).";
            sw = rw;
            hw = r;
        } word[31:0];
    } NODE_W_20C @ 0x20C;

    reg {
        name = "Node word at offset 0x240";
        desc = "Word 0x240 of the node image. PROVENANCE: PROVEN offset and the listed bit extents (read from the load/store/bic/orr sequence of the named vendor function, hi3516cv300 Xiongmai module); INFERRED that a function name describes the content; UNKNOWN field meaning. Written by: VGS_DRV_SetReg.";
        field {
            name = "word";
            desc = "32-bit word (layout see the register description).";
            sw = rw;
            hw = r;
        } word[31:0];
    } NODE_W_240 @ 0x240;

    reg {
        name = "Node word at offset 0x24C";
        desc = "Word 0x24C of the node image. PROVENANCE: PROVEN offset and the listed bit extents (read from the load/store/bic/orr sequence of the named vendor function, hi3516cv300 Xiongmai module); INFERRED that a function name describes the content; UNKNOWN field meaning. Written by: VGS_DRV_SetOsdReg.";
        field {
            name = "word";
            desc = "32-bit word (layout see the register description).";
            sw = rw;
            hw = r;
        } word[31:0];
    } NODE_W_24C @ 0x24C;

    reg {
        name = "Node word at offset 0x250";
        desc = "Word 0x250 of the node image. PROVENANCE: PROVEN offset and the listed bit extents (read from the load/store/bic/orr sequence of the named vendor function, hi3516cv300 Xiongmai module); INFERRED that a function name describes the content; UNKNOWN field meaning. Written by: VGS_DRV_SetCoverReg.";
        field {
            name = "word";
            desc = "32-bit word (layout see the register description).";
            sw = rw;
            hw = r;
        } word[31:0];
    } NODE_W_250 @ 0x250;

    reg {
        name = "Node word at offset 0x260";
        desc = "Word 0x260 of the node image. PROVENANCE: PROVEN offset and the listed bit extents (read from the load/store/bic/orr sequence of the named vendor function, hi3516cv300 Xiongmai module); INFERRED that a function name describes the content; UNKNOWN field meaning. Written by: VGS_DRV_SetLdcReg.";
        field {
            name = "word";
            desc = "32-bit word (layout see the register description).";
            sw = rw;
            hw = r;
        } word[31:0];
    } NODE_W_260 @ 0x260;

    reg {
        name = "Node word at offset 0x264";
        desc = "Word 0x264 of the node image. PROVENANCE: PROVEN offset and the listed bit extents (read from the load/store/bic/orr sequence of the named vendor function, hi3516cv300 Xiongmai module); INFERRED that a function name describes the content; UNKNOWN field meaning. Written by: VGS_DRV_SetLdcReg.";
        field {
            name = "word";
            desc = "32-bit word (layout see the register description).";
            sw = rw;
            hw = r;
        } word[31:0];
    } NODE_W_264 @ 0x264;

    reg {
        name = "Node word at offset 0x268";
        desc = "Word 0x268 of the node image. PROVENANCE: PROVEN offset and the listed bit extents (read from the load/store/bic/orr sequence of the named vendor function, hi3516cv300 Xiongmai module); INFERRED that a function name describes the content; UNKNOWN field meaning. Written by: VGS_DRV_SetLumaReg.";
        field {
            name = "word";
            desc = "32-bit word (layout see the register description).";
            sw = rw;
            hw = r;
        } word[31:0];
    } NODE_W_268 @ 0x268;

    reg {
        name = "Node word at offset 0x26C";
        desc = "Word 0x26C of the node image. PROVENANCE: PROVEN offset and the listed bit extents (read from the load/store/bic/orr sequence of the named vendor function, hi3516cv300 Xiongmai module); INFERRED that a function name describes the content; UNKNOWN field meaning. Written by: VGS_DRV_SetLumaReg.";
        field {
            name = "word";
            desc = "32-bit word (layout see the register description).";
            sw = rw;
            hw = r;
        } word[31:0];
    } NODE_W_26C @ 0x26C;

    reg {
        name = "Node word at offset 0x330";
        desc = "Word 0x330 of the node image. PROVENANCE: PROVEN offset and the listed bit extents (read from the load/store/bic/orr sequence of the named vendor function, hi3516cv300 Xiongmai module); INFERRED that a function name describes the content; UNKNOWN field meaning. Written by: VGS_DRV_SetOsdReg.";
        field {
            name = "word";
            desc = "32-bit word (layout see the register description).";
            sw = rw;
            hw = r;
        } word[31:0];
    } NODE_W_330 @ 0x330;

    reg {
        name = "Node word at offset 0x334";
        desc = "Word 0x334 of the node image. PROVENANCE: PROVEN offset and the listed bit extents (read from the load/store/bic/orr sequence of the named vendor function, hi3516cv300 Xiongmai module); INFERRED that a function name describes the content; UNKNOWN field meaning. Written by: VGS_DRV_SetOsdReg.";
        field {
            name = "word";
            desc = "32-bit word (layout see the register description).";
            sw = rw;
            hw = r;
        } word[31:0];
    } NODE_W_334 @ 0x334;

    reg {
        name = "Node word at offset 0x3B0";
        desc = "Word 0x3B0 of the node image. PROVENANCE: PROVEN offset and the listed bit extents (read from the load/store/bic/orr sequence of the named vendor function, hi3516cv300 Xiongmai module); INFERRED that a function name describes the content; UNKNOWN field meaning. Written by: VGS_DRV_SetCscReg (inserts a value at shift 27).";
        field {
            name = "word";
            desc = "32-bit word (layout see the register description).";
            sw = rw;
            hw = r;
        } word[31:0];
    } NODE_W_3B0 @ 0x3B0;

    reg {
        name = "Node word at offset 0x3B4";
        desc = "Word 0x3B4 of the node image. PROVENANCE: PROVEN offset and the listed bit extents (read from the load/store/bic/orr sequence of the named vendor function, hi3516cv300 Xiongmai module); INFERRED that a function name describes the content; UNKNOWN field meaning. Written by: VGS_DRV_SetCscReg (sets constants 0x80 0x410000).";
        field {
            name = "word";
            desc = "32-bit word (layout see the register description).";
            sw = rw;
            hw = r;
        } word[31:0];
    } NODE_W_3B4 @ 0x3B4;

    reg {
        name = "Node word at offset 0x3B8";
        desc = "Word 0x3B8 of the node image. PROVENANCE: PROVEN offset and the listed bit extents (read from the load/store/bic/orr sequence of the named vendor function, hi3516cv300 Xiongmai module); INFERRED that a function name describes the content; UNKNOWN field meaning. Written by: VGS_DRV_SetCscReg modifies bits [0:0] [3:2] [7:6] [14:9] [18:17] [21:21] [24:23] [30:26] (sets constants 0x2 0x130 0x10000 0x2580000).";
        field {
            name = "word";
            desc = "32-bit word (layout see the register description).";
            sw = rw;
            hw = r;
        } word[31:0];
    } NODE_W_3B8 @ 0x3B8;

    reg {
        name = "Node word at offset 0x3BC";
        desc = "Word 0x3BC of the node image. PROVENANCE: PROVEN offset and the listed bit extents (read from the load/store/bic/orr sequence of the named vendor function, hi3516cv300 Xiongmai module); INFERRED that a function name describes the content; UNKNOWN field meaning. Written by: VGS_DRV_SetCscReg modifies bits [1:0] [3:3] [14:7] [19:16] [21:21] [23:23] (sets constants 0x74 0x500000 0x7F000000).";
        field {
            name = "word";
            desc = "32-bit word (layout see the register description).";
            sw = rw;
            hw = r;
        } word[31:0];
    } NODE_W_3BC @ 0x3BC;

    reg {
        name = "Node word at offset 0x3C0";
        desc = "Word 0x3C0 of the node image. PROVENANCE: PROVEN offset and the listed bit extents (read from the load/store/bic/orr sequence of the named vendor function, hi3516cv300 Xiongmai module); INFERRED that a function name describes the content; UNKNOWN field meaning. Written by: VGS_DRV_SetCscReg modifies bits [1:1] [4:3] [6:6] [8:8] [18:18] [24:20] [30:26] (sets constants 0xA5 0x7E00 0x30000 0x2080000).";
        field {
            name = "word";
            desc = "32-bit word (layout see the register description).";
            sw = rw;
            hw = r;
        } word[31:0];
    } NODE_W_3C0 @ 0x3C0;

    reg {
        name = "Node word at offset 0x3C4";
        desc = "Word 0x3C4 of the node image. PROVENANCE: PROVEN offset and the listed bit extents (read from the load/store/bic/orr sequence of the named vendor function, hi3516cv300 Xiongmai module); INFERRED that a function name describes the content; UNKNOWN field meaning. Written by: VGS_DRV_SetCscReg modifies bits [2:2] [8:4] [14:10] [16:16] [18:18] [21:20] [24:23] (sets constants 0x3 0x208 0x4A0000 0x7E000000).";
        field {
            name = "word";
            desc = "32-bit word (layout see the register description).";
            sw = rw;
            hw = r;
        } word[31:0];
    } NODE_W_3C4 @ 0x3C4;

    reg {
        name = "Node word at offset 0x3C8";
        desc = "Word 0x3C8 of the node image. PROVENANCE: PROVEN offset and the listed bit extents (read from the load/store/bic/orr sequence of the named vendor function, hi3516cv300 Xiongmai module); INFERRED that a function name describes the content; UNKNOWN field meaning. Written by: VGS_DRV_SetCscReg modifies bits [1:0] [4:4] [6:6] (sets constants 0xAC 0x7F00).";
        field {
            name = "word";
            desc = "32-bit word (layout see the register description).";
            sw = rw;
            hw = r;
        } word[31:0];
    } NODE_W_3C8 @ 0x3C8;

    reg {
        name = "Node word at offset 0x3D0";
        desc = "Word 0x3D0 of the node image. PROVENANCE: PROVEN offset and the listed bit extents (read from the load/store/bic/orr sequence of the named vendor function, hi3516cv300 Xiongmai module); INFERRED that a function name describes the content; UNKNOWN field meaning. Written by: VGS_DRV_SetSclReg.";
        field {
            name = "word";
            desc = "32-bit word (layout see the register description).";
            sw = rw;
            hw = r;
        } word[31:0];
    } NODE_W_3D0 @ 0x3D0;

    reg {
        name = "Node word at offset 0x3D4";
        desc = "Word 0x3D4 of the node image. PROVENANCE: PROVEN offset and the listed bit extents (read from the load/store/bic/orr sequence of the named vendor function, hi3516cv300 Xiongmai module); INFERRED that a function name describes the content; UNKNOWN field meaning. Written by: VGS_DRV_SetSclReg.";
        field {
            name = "word";
            desc = "32-bit word (layout see the register description).";
            sw = rw;
            hw = r;
        } word[31:0];
    } NODE_W_3D4 @ 0x3D4;

    reg {
        name = "Node word at offset 0x3D8";
        desc = "Word 0x3D8 of the node image. PROVENANCE: PROVEN offset and the listed bit extents (read from the load/store/bic/orr sequence of the named vendor function, hi3516cv300 Xiongmai module); INFERRED that a function name describes the content; UNKNOWN field meaning. Written by: VGS_DRV_SetSclReg.";
        field {
            name = "word";
            desc = "32-bit word (layout see the register description).";
            sw = rw;
            hw = r;
        } word[31:0];
    } NODE_W_3D8 @ 0x3D8;

    reg {
        name = "Node word at offset 0x3DC";
        desc = "Word 0x3DC of the node image. PROVENANCE: PROVEN offset and the listed bit extents (read from the load/store/bic/orr sequence of the named vendor function, hi3516cv300 Xiongmai module); INFERRED that a function name describes the content; UNKNOWN field meaning. Written by: VGS_DRV_SetSclReg modifies bits [22:19] [26:26] [31:28] (inserts a value at shift 19, 21, 30, 31) (sets constants 0x1800000).";
        field {
            name = "word";
            desc = "32-bit word (layout see the register description).";
            sw = rw;
            hw = r;
        } word[31:0];
    } NODE_W_3DC @ 0x3DC;

    reg {
        name = "Node word at offset 0x3E0";
        desc = "Word 0x3E0 of the node image. PROVENANCE: PROVEN offset and the listed bit extents (read from the load/store/bic/orr sequence of the named vendor function, hi3516cv300 Xiongmai module); INFERRED that a function name describes the content; UNKNOWN field meaning. Written by: VGS_DRV_SetSclReg.";
        field {
            name = "word";
            desc = "32-bit word (layout see the register description).";
            sw = rw;
            hw = r;
        } word[31:0];
    } NODE_W_3E0 @ 0x3E0;

    reg {
        name = "Node word at offset 0x3E4";
        desc = "Word 0x3E4 of the node image. PROVENANCE: PROVEN offset and the listed bit extents (read from the load/store/bic/orr sequence of the named vendor function, hi3516cv300 Xiongmai module); INFERRED that a function name describes the content; UNKNOWN field meaning. Written by: VGS_DRV_SetSclReg.";
        field {
            name = "word";
            desc = "32-bit word (layout see the register description).";
            sw = rw;
            hw = r;
        } word[31:0];
    } NODE_W_3E4 @ 0x3E4;

    reg {
        name = "Node word at offset 0x3E8";
        desc = "Word 0x3E8 of the node image. PROVENANCE: PROVEN offset and the listed bit extents (read from the load/store/bic/orr sequence of the named vendor function, hi3516cv300 Xiongmai module); INFERRED that a function name describes the content; UNKNOWN field meaning. Written by: VGS_DRV_SetSclReg.";
        field {
            name = "word";
            desc = "32-bit word (layout see the register description).";
            sw = rw;
            hw = r;
        } word[31:0];
    } NODE_W_3E8 @ 0x3E8;

    reg {
        name = "Node word at offset 0x3EC";
        desc = "Word 0x3EC of the node image. PROVENANCE: PROVEN offset and the listed bit extents (read from the load/store/bic/orr sequence of the named vendor function, hi3516cv300 Xiongmai module); INFERRED that a function name describes the content; UNKNOWN field meaning. Written by: VGS_DRV_SetSclReg.";
        field {
            name = "word";
            desc = "32-bit word (layout see the register description).";
            sw = rw;
            hw = r;
        } word[31:0];
    } NODE_W_3EC @ 0x3EC;

    reg {
        name = "Node word at offset 0x3F0";
        desc = "Word 0x3F0 of the node image. PROVENANCE: PROVEN offset and the listed bit extents (read from the load/store/bic/orr sequence of the named vendor function, hi3516cv300 Xiongmai module); INFERRED that a function name describes the content; UNKNOWN field meaning. Written by: VGS_DRV_SetCoverReg.";
        field {
            name = "word";
            desc = "32-bit word (layout see the register description).";
            sw = rw;
            hw = r;
        } word[31:0];
    } NODE_W_3F0 @ 0x3F0;

    reg {
        name = "Node word at offset 0x3F4";
        desc = "Word 0x3F4 of the node image. PROVENANCE: PROVEN offset and the listed bit extents (read from the load/store/bic/orr sequence of the named vendor function, hi3516cv300 Xiongmai module); INFERRED that a function name describes the content; UNKNOWN field meaning. Written by: VGS_DRV_SetCoverReg.";
        field {
            name = "word";
            desc = "32-bit word (layout see the register description).";
            sw = rw;
            hw = r;
        } word[31:0];
    } NODE_W_3F4 @ 0x3F4;

    reg {
        name = "Node word at offset 0x3F8";
        desc = "Word 0x3F8 of the node image. PROVENANCE: PROVEN offset and the listed bit extents (read from the load/store/bic/orr sequence of the named vendor function, hi3516cv300 Xiongmai module); INFERRED that a function name describes the content; UNKNOWN field meaning. Written by: VGS_DRV_SetCoverReg (sets constants 0x1).";
        field {
            name = "word";
            desc = "32-bit word (layout see the register description).";
            sw = rw;
            hw = r;
        } word[31:0];
    } NODE_W_3F8 @ 0x3F8;

    reg {
        name = "Node word at offset 0x3FC";
        desc = "Word 0x3FC of the node image. PROVENANCE: PROVEN offset and the listed bit extents (read from the load/store/bic/orr sequence of the named vendor function, hi3516cv300 Xiongmai module); INFERRED that a function name describes the content; UNKNOWN field meaning. Written by: VGS_DRV_SetCoverReg.";
        field {
            name = "word";
            desc = "32-bit word (layout see the register description).";
            sw = rw;
            hw = r;
        } word[31:0];
    } NODE_W_3FC @ 0x3FC;

};

`endif
