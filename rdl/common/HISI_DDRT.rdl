`ifndef HISI_DDRT_RDL
`define HISI_DDRT_RDL

regfile eHISI_DDRT {
    name = "HiSilicon DDR test module";
    desc = "Partly described: the offsets (0x00-0x4C, DQ_ERR_CNT[8] at 0x60, DQ_ERR_OVFL at 0x80) and the few bit uses (OP, STATUS) come from the Hi3535 U-Boot DDR data-eye training code, which uses the same base address, clock/reset bits and SYS_CTRL enable bit; they are NOT verified on a Hi3520D (no Hi3520D DDRT code or data sheet text exists in the tree). No reset values are known, bits not used by that code are plain fields. All registers in this block have unverified meaning on this SoC. DDR test module (DDRT) at 0x206D0000 (data sheet Table 1-1 lists the window only; no register description). Used by the vendor DDR training: clock enable PERI_CRG 0x200300D8 bit 3, reset bit 2 and SYS_CTRL 0x2005003C bit 15 (U-Boot `DDRT_CLK`, `DDRT_RESET`, `DDRT_ENABLE_SYS`). The registers below are the Hi3535 U-Boot (`ddr_dataeye_training.h`) set, which uses the same base address; the Hi3520D U-Boot tree has no DDRT register definitions (its training code is not in the tree). Treat as sibling-chip information, not Hi3520D data. Note: the tree also has a Hi3520D V200 U-Boot DDR training (`sources/openipc-u-boot-hi3520dv200/product/hiddrtv200/ddrtv200.h`, same base 0x206D0000) whose register list agrees with the offsets below and additionally has ERR_NUM 0x50, INTS 0x54, INTEN 0x58, INTCLR 0x5C, BIT_ERR_CNT0/1 0x90/0x94, BIT_ERR_OVFL 0xA0 and SEED 0x38, WADDR_OFFSET1 0x28, REVERSED_BIT_HIGHER 0x34 (only SEED modelled here; it is a V200 chip, so still not a V100 confirmation).

Cross-chip (vendor U-Boot 2010.06 `drivers/ddr/ddr_ddrt_s40.h` and `ddr_ddrt_t28.h`, 2026-11-10): the generic DDR training driver uses one identical DDRT register list for every chip it supports (Hi3518E V20X, Hi3516C V300, Hi3516A V200, Hi3519 V101, Hi3521A/D, Hi3531A/D, Hi3536): OP 0x0, STATUS 0x4, BURST_CONFIG 0x8 (= DDRT_BURST_TRANSFER here), MEM_CONFIG 0xC, BURST_NUM 0x10, ADDR_NUM 0x14, LOOP_NUM 0x18, DDR_BASE_ADDR 0x1C (= DDRT_START_ADDR here), ADDR 0x20, REVERSED_DQ 0x30, SEED 0x38, KDATA 0x3C, DATA0-3 0x40-0x4C, DQ_ERR_CNT(n) 0x60 + 4n, DQ_ERR_OVFL 0x80; it does not use 0x24 (ADDR_OFFSET0, Hi3535 only). The Hi3516A V100 `cpu/hi3516a/ddr_dataeye_training.h` has the same names as the Hi3535 set at 0x206D0000. Bases: 0x206D0000 (Hi3520D, Hi3516A/D V100, Hi3518E V20X), 0x11200000 (Hi3516C V300 / E V100), 0x12050000 (Hi3516A V200, Hi3519 V101); the SYS_CTRL DDRT pattern/scratch register is SC 0x94 on all of them (`SYSCTRL_DDRT_PATTERN`; the Hi3516A V200 / Hi3519 add a secure copy at 0x130). Vendor constants for MEM_CONFIG: `DDRT_DDR_MEM_WIDTH 12` (bit position of the SDRAM total-width field, value 0 = 16-bit / 1 = 32-bit as the generic code shifts the DMC mem_width into it), `DDRT_DDR_COL_WIDTH 0x2`, `DDRT_DDR_ROW_WIDTH 0x50`, `DDRT_DDR_BANK_WIDTH 0x100` (ORed together: column width field at [3:0], row width at [7:4], bank width at [9:8]; the Hi3535 code writes the sum 0x1142). OP: `DDRT_TEST_MODE_MASK 0x300`, `DDRT_CFG_START 0x1`; STATUS: `DDRT_TEST_DONE_MASK 0x1`, `DDRT_TEST_PASS_MASK 0x2`; BURST_CONFIG values 0x4F (data eye) / 0x43 (gate training). No data sheet documents the block.";

    reg {
        name = "DDRT operation register";
        desc = "Operation mode, data pattern and start (`DDRT_OP`): the training code writes `mode | pattern | 1`.

Vendor U-Boot `arch/arm/cpu/hi3535/ddr_dataeye_training.[ch]` (Hi3535 DDR training, `SSN_DDRT`; the DDRT module is at the same address 0x206D0000 and uses the same CRG/SYS_CTRL bits as the Hi3520D, see `arch-hi3520d/platform.h` DDRT_*). Not in the Hi3520D data sheet; offsets and the few bit uses are from the Hi3535 code, not verified on a Hi3520D. No reset values known.";

        field {
            name = "pattern";
            desc = "Data pattern: 0 PRBS9, 1 PRBS7, 2 PRBS11, 3 K28.5 (`DDRT_PATTERM_*`).";
            sw = rw;
            hw = r;
        } pattern[13:12];

        field {
            name = "mode";
            desc = "0 write+read+compare, 1 write only, 2 read only, 3 random read/write (`*_MODE`).";
            sw = rw;
            hw = r;
        } mode[9:8];

        field {
            name = "start";
            desc = "Write 1 to start the test.";
            sw = rw;
            hw = r;
        } start[0:0];
    } DDRT_OP @ 0x0;

    reg {
        name = "DDRT status register";
        desc = "Polled by the training code until bit 0 is set, then bit 1 says pass (`DDRT_STATUS`).

Vendor U-Boot `arch/arm/cpu/hi3535/ddr_dataeye_training.[ch]` (Hi3535 DDR training, `SSN_DDRT`; the DDRT module is at the same address 0x206D0000 and uses the same CRG/SYS_CTRL bits as the Hi3520D, see `arch-hi3520d/platform.h` DDRT_*). Not in the Hi3520D data sheet; offsets and the few bit uses are from the Hi3535 code, not verified on a Hi3520D. No reset values known.";

        field {
            name = "pass";
            desc = "1 = test passed (training code: `(status & 2) ? OK : fail`).";
            sw = r;
            hw = w;
        } pass[1:1];

        field {
            name = "done";
            desc = "1 = test finished.";
            sw = r;
            hw = w;
        } done[0:0];
    } DDRT_STATUS @ 0x4;

    reg {
        name = "Ddrt Burst Transfer";
        desc = "Burst transfer configuration (training writes 0x4F).

Vendor U-Boot `arch/arm/cpu/hi3535/ddr_dataeye_training.[ch]` (Hi3535 DDR training, `SSN_DDRT`; the DDRT module is at the same address 0x206D0000 and uses the same CRG/SYS_CTRL bits as the Hi3520D, see `arch-hi3520d/platform.h` DDRT_*). Not in the Hi3520D data sheet; offsets and the few bit uses are from the Hi3535 code, not verified on a Hi3520D. No reset values known.";

        field {
            name = "value";
            desc = "Register value (layout not documented).";
            sw = rw;
            hw = r;
        } value[31:0];
    } DDRT_BURST_TRANSFER @ 0x8;

    reg {
        name = "Ddrt Mem Config";
        desc = "Memory configuration (training writes 0x01142).

Vendor U-Boot `arch/arm/cpu/hi3535/ddr_dataeye_training.[ch]` (Hi3535 DDR training, `SSN_DDRT`; the DDRT module is at the same address 0x206D0000 and uses the same CRG/SYS_CTRL bits as the Hi3520D, see `arch-hi3520d/platform.h` DDRT_*). Not in the Hi3520D data sheet; offsets and the few bit uses are from the Hi3535 code, not verified on a Hi3520D. No reset values known.";

        field {
            name = "value";
            desc = "Register value (layout not documented).";
            sw = rw;
            hw = r;
        } value[31:0];
    } DDRT_MEM_CONFIG @ 0xC;

    reg {
        name = "Ddrt Burst Num";
        desc = "Number of bursts (training writes 0xFF).

Vendor U-Boot `arch/arm/cpu/hi3535/ddr_dataeye_training.[ch]` (Hi3535 DDR training, `SSN_DDRT`; the DDRT module is at the same address 0x206D0000 and uses the same CRG/SYS_CTRL bits as the Hi3520D, see `arch-hi3520d/platform.h` DDRT_*). Not in the Hi3520D data sheet; offsets and the few bit uses are from the Hi3535 code, not verified on a Hi3520D. No reset values known.";

        field {
            name = "value";
            desc = "Register value (layout not documented).";
            sw = rw;
            hw = r;
        } value[31:0];
    } DDRT_BURST_NUM @ 0x10;

    reg {
        name = "Ddrt Addr Num";
        desc = "Address count (training writes 0xFFFFFFFF).

Vendor U-Boot `arch/arm/cpu/hi3535/ddr_dataeye_training.[ch]` (Hi3535 DDR training, `SSN_DDRT`; the DDRT module is at the same address 0x206D0000 and uses the same CRG/SYS_CTRL bits as the Hi3520D, see `arch-hi3520d/platform.h` DDRT_*). Not in the Hi3520D data sheet; offsets and the few bit uses are from the Hi3535 code, not verified on a Hi3520D. No reset values known.";

        field {
            name = "value";
            desc = "Register value (layout not documented).";
            sw = rw;
            hw = r;
        } value[31:0];
    } DDRT_ADDR_NUM @ 0x14;

    reg {
        name = "Ddrt Loop Num";
        desc = "Loop count (training writes 0).

Vendor U-Boot `arch/arm/cpu/hi3535/ddr_dataeye_training.[ch]` (Hi3535 DDR training, `SSN_DDRT`; the DDRT module is at the same address 0x206D0000 and uses the same CRG/SYS_CTRL bits as the Hi3520D, see `arch-hi3520d/platform.h` DDRT_*). Not in the Hi3520D data sheet; offsets and the few bit uses are from the Hi3535 code, not verified on a Hi3520D. No reset values known.";

        field {
            name = "value";
            desc = "Register value (layout not documented).";
            sw = rw;
            hw = r;
        } value[31:0];
    } DDRT_LOOP_NUM @ 0x18;

    reg {
        name = "Ddrt Start Addr";
        desc = "Start address (training writes 0x80000000).

Vendor U-Boot `arch/arm/cpu/hi3535/ddr_dataeye_training.[ch]` (Hi3535 DDR training, `SSN_DDRT`; the DDRT module is at the same address 0x206D0000 and uses the same CRG/SYS_CTRL bits as the Hi3520D, see `arch-hi3520d/platform.h` DDRT_*). Not in the Hi3520D data sheet; offsets and the few bit uses are from the Hi3535 code, not verified on a Hi3520D. No reset values known.";

        field {
            name = "value";
            desc = "Register value (layout not documented).";
            sw = rw;
            hw = r;
        } value[31:0];
    } DDRT_START_ADDR @ 0x1C;

    reg {
        name = "Ddrt Addr";
        desc = "Test address (training writes 0x80000000).

Vendor U-Boot `arch/arm/cpu/hi3535/ddr_dataeye_training.[ch]` (Hi3535 DDR training, `SSN_DDRT`; the DDRT module is at the same address 0x206D0000 and uses the same CRG/SYS_CTRL bits as the Hi3520D, see `arch-hi3520d/platform.h` DDRT_*). Not in the Hi3520D data sheet; offsets and the few bit uses are from the Hi3535 code, not verified on a Hi3520D. No reset values known.";

        field {
            name = "value";
            desc = "Register value (layout not documented).";
            sw = rw;
            hw = r;
        } value[31:0];
    } DDRT_ADDR @ 0x20;

    reg {
        name = "Ddrt Addr Offset0";
        desc = "Address offset 0 (defined, not used by the training code).

Vendor U-Boot `arch/arm/cpu/hi3535/ddr_dataeye_training.[ch]` (Hi3535 DDR training, `SSN_DDRT`; the DDRT module is at the same address 0x206D0000 and uses the same CRG/SYS_CTRL bits as the Hi3520D, see `arch-hi3520d/platform.h` DDRT_*). Not in the Hi3520D data sheet; offsets and the few bit uses are from the Hi3535 code, not verified on a Hi3520D. No reset values known.";

        field {
            name = "value";
            desc = "Register value (layout not documented).";
            sw = rw;
            hw = r;
        } value[31:0];
    } DDRT_ADDR_OFFSET0 @ 0x24;

    reg {
        name = "Ddrt Reversed Dq";
        desc = "Per-bit data reversal mask (training writes 0 or 0xB49C863C).

Vendor U-Boot `arch/arm/cpu/hi3535/ddr_dataeye_training.[ch]` (Hi3535 DDR training, `SSN_DDRT`; the DDRT module is at the same address 0x206D0000 and uses the same CRG/SYS_CTRL bits as the Hi3520D, see `arch-hi3520d/platform.h` DDRT_*). Not in the Hi3520D data sheet; offsets and the few bit uses are from the Hi3535 code, not verified on a Hi3520D. No reset values known.";

        field {
            name = "value";
            desc = "Register value (layout not documented).";
            sw = rw;
            hw = r;
        } value[31:0];
    } DDRT_REVERSED_DQ @ 0x30;

    reg {
        name = "DDRT PRBS seed";
        desc = "Starting random seed of the PRBS pattern generator (`DDRT_SEED`, vendor `ddr_ddrt_s40.h` / `ddr_ddrt_t28.h`; the generic training code writes `DDRT_CFG_SEED` 0x6D6D6D6D). Also in the Hi3520D V200 `ddrtv200.h` list. Not in the Hi3535 training code, unverified on the Hi3520D.";

        field {
            name = "seed";
            desc = "PRBS seed (layout not documented).";
            sw = rw;
            hw = r;
        } seed[31:0];
    } DDRT_SEED @ 0x38;

    reg {
        name = "Ddrt Kdata";
        desc = "K-code data (training writes 0xBC3EB053).

Vendor U-Boot `arch/arm/cpu/hi3535/ddr_dataeye_training.[ch]` (Hi3535 DDR training, `SSN_DDRT`; the DDRT module is at the same address 0x206D0000 and uses the same CRG/SYS_CTRL bits as the Hi3520D, see `arch-hi3520d/platform.h` DDRT_*). Not in the Hi3520D data sheet; offsets and the few bit uses are from the Hi3535 code, not verified on a Hi3520D. No reset values known.";

        field {
            name = "value";
            desc = "Register value (layout not documented).";
            sw = rw;
            hw = r;
        } value[31:0];
    } DDRT_KDATA @ 0x3C;

    reg {
        name = "Ddrt Data0";
        desc = "Data word 0 (0x8A18207F).

Vendor U-Boot `arch/arm/cpu/hi3535/ddr_dataeye_training.[ch]` (Hi3535 DDR training, `SSN_DDRT`; the DDRT module is at the same address 0x206D0000 and uses the same CRG/SYS_CTRL bits as the Hi3520D, see `arch-hi3520d/platform.h` DDRT_*). Not in the Hi3520D data sheet; offsets and the few bit uses are from the Hi3535 code, not verified on a Hi3520D. No reset values known.";

        field {
            name = "value";
            desc = "Register value (layout not documented).";
            sw = rw;
            hw = r;
        } value[31:0];
    } DDRT_DATA0 @ 0x40;

    reg {
        name = "Ddrt Data1";
        desc = "Data word 1 (0x5F2B9A27).

Vendor U-Boot `arch/arm/cpu/hi3535/ddr_dataeye_training.[ch]` (Hi3535 DDR training, `SSN_DDRT`; the DDRT module is at the same address 0x206D0000 and uses the same CRG/SYS_CTRL bits as the Hi3520D, see `arch-hi3520d/platform.h` DDRT_*). Not in the Hi3520D data sheet; offsets and the few bit uses are from the Hi3535 code, not verified on a Hi3520D. No reset values known.";

        field {
            name = "value";
            desc = "Register value (layout not documented).";
            sw = rw;
            hw = r;
        } value[31:0];
    } DDRT_DATA1 @ 0x44;

    reg {
        name = "Ddrt Data2";
        desc = "Data word 2 (0xBDAD9238).

Vendor U-Boot `arch/arm/cpu/hi3535/ddr_dataeye_training.[ch]` (Hi3535 DDR training, `SSN_DDRT`; the DDRT module is at the same address 0x206D0000 and uses the same CRG/SYS_CTRL bits as the Hi3520D, see `arch-hi3520d/platform.h` DDRT_*). Not in the Hi3520D data sheet; offsets and the few bit uses are from the Hi3535 code, not verified on a Hi3520D. No reset values known.";

        field {
            name = "value";
            desc = "Register value (layout not documented).";
            sw = rw;
            hw = r;
        } value[31:0];
    } DDRT_DATA2 @ 0x48;

    reg {
        name = "Ddrt Data3";
        desc = "Data word 3 (0xAA6774B1).

Vendor U-Boot `arch/arm/cpu/hi3535/ddr_dataeye_training.[ch]` (Hi3535 DDR training, `SSN_DDRT`; the DDRT module is at the same address 0x206D0000 and uses the same CRG/SYS_CTRL bits as the Hi3520D, see `arch-hi3520d/platform.h` DDRT_*). Not in the Hi3520D data sheet; offsets and the few bit uses are from the Hi3535 code, not verified on a Hi3520D. No reset values known.";

        field {
            name = "value";
            desc = "Register value (layout not documented).";
            sw = rw;
            hw = r;
        } value[31:0];
    } DDRT_DATA3 @ 0x4C;

    reg {
        name = "DQ error counter";
        desc = "`DDRT_DQ_ERR_CNT(n)` = 0x60 + 4n, n = 0..7.

Vendor U-Boot `arch/arm/cpu/hi3535/ddr_dataeye_training.[ch]` (Hi3535 DDR training, `SSN_DDRT`; the DDRT module is at the same address 0x206D0000 and uses the same CRG/SYS_CTRL bits as the Hi3520D, see `arch-hi3520d/platform.h` DDRT_*). Not in the Hi3520D data sheet; offsets and the few bit uses are from the Hi3535 code, not verified on a Hi3520D. No reset values known.";

        field {
            name = "count";
            desc = "Error count of DQ group n.";
            sw = r;
            hw = w;
        } count[31:0];
    } DDRT_DQ_ERR_CNT[8] @ 0x60 += 0x4;

    reg {
        name = "DQ error overflow";
        desc = "`DDRT_DQ_ERR_OVFL`.

Vendor U-Boot `arch/arm/cpu/hi3535/ddr_dataeye_training.[ch]` (Hi3535 DDR training, `SSN_DDRT`; the DDRT module is at the same address 0x206D0000 and uses the same CRG/SYS_CTRL bits as the Hi3520D, see `arch-hi3520d/platform.h` DDRT_*). Not in the Hi3520D data sheet; offsets and the few bit uses are from the Hi3535 code, not verified on a Hi3520D. No reset values known.";

        field {
            name = "value";
            desc = "Overflow flags (layout not documented).";
            sw = r;
            hw = w;
        } value[31:0];
    } DDRT_DQ_ERR_OVFL @ 0x80;
};

`endif
