`ifndef HISI_DDRT_RDL
`define HISI_DDRT_RDL

regfile eHISI_DDRT {
    name = "HiSilicon DDR test module";
    desc = "Partly described: the offsets (0x00-0x4C, DQ_ERR_CNT[8] at 0x60, DQ_ERR_OVFL at 0x80) and the few bit uses (OP, STATUS) come from the Hi3535 U-Boot DDR data-eye training code, which uses the same base address, clock/reset bits and SYS_CTRL enable bit; they are NOT verified on a Hi3520D (no Hi3520D DDRT code or data sheet text exists in the tree). No reset values are known, bits not used by that code are plain fields. All registers in this block have unverified meaning on this SoC. DDR test module (DDRT) at 0x206D0000 (data sheet Table 1-1 lists the window only; no register description). Used by the vendor DDR training: clock enable PERI_CRG 0x200300D8 bit 3, reset bit 2 and SYS_CTRL 0x2005003C bit 15 (U-Boot `DDRT_CLK`, `DDRT_RESET`, `DDRT_ENABLE_SYS`). The registers below are the Hi3535 U-Boot (`ddr_dataeye_training.h`) set, which uses the same base address; the Hi3520D U-Boot tree has no DDRT register definitions (its training code is not in the tree). Treat as sibling-chip information, not Hi3520D data. Note: the tree also has a Hi3520D V200 U-Boot DDR training (`sources/openipc-u-boot-hi3520dv200/product/hiddrtv200/ddrtv200.h`, same base 0x206D0000) whose register list agrees with the offsets below and additionally has ERR_NUM 0x50, INTS 0x54, INTEN 0x58, INTCLR 0x5C, BIT_ERR_CNT0/1 0x90/0x94, BIT_ERR_OVFL 0xA0 and SEED 0x38, WADDR_OFFSET1 0x28, REVERSED_BIT_HIGHER 0x34 (only SEED modelled here; it is a V200 chip, so still not a V100 confirmation).

Cross-chip (vendor U-Boot 2010.06 `drivers/ddr/ddr_ddrt_s40.h` and `ddr_ddrt_t28.h`, 2026-11-10): the generic DDR training driver uses one identical DDRT register list for every chip it supports (Hi3518E V20X, Hi3516C V300, Hi3516A V200, Hi3519 V101, Hi3521A/D, Hi3531A/D, Hi3536): OP 0x0, STATUS 0x4, BURST_CONFIG 0x8 (= DDRT_BURST_TRANSFER here), MEM_CONFIG 0xC, BURST_NUM 0x10, ADDR_NUM 0x14, LOOP_NUM 0x18, DDR_BASE_ADDR 0x1C (= DDRT_START_ADDR here), ADDR 0x20, REVERSED_DQ 0x30, SEED 0x38, KDATA 0x3C, DATA0-3 0x40-0x4C, DQ_ERR_CNT(n) 0x60 + 4n, DQ_ERR_OVFL 0x80; it does not use 0x24 (ADDR_OFFSET0, Hi3535 only). The Hi3516A V100 `cpu/hi3516a/ddr_dataeye_training.h` has the same names as the Hi3535 set at 0x206D0000. Bases: 0x206D0000 (Hi3520D, Hi3516A/D V100, Hi3518E V20X), 0x11200000 (Hi3516C V300 / E V100), 0x12050000 (Hi3516A V200, Hi3519 V101); the SYS_CTRL DDRT pattern/scratch register is SC 0x94 on all of them (`SYSCTRL_DDRT_PATTERN`; the Hi3516A V200 / Hi3519 add a secure copy at 0x130). Vendor constants for MEM_CONFIG: `DDRT_DDR_MEM_WIDTH 12` (bit position of the SDRAM total-width field, value 0 = 16-bit / 1 = 32-bit as the generic code shifts the DMC mem_width into it), `DDRT_DDR_COL_WIDTH 0x2`, `DDRT_DDR_ROW_WIDTH 0x50`, `DDRT_DDR_BANK_WIDTH 0x100` (ORed together: column width field at [3:0], row width at [7:4], bank width at [9:8]; the Hi3535 code writes the sum 0x1142). OP: `DDRT_TEST_MODE_MASK 0x300`, `DDRT_CFG_START 0x1`; STATUS: `DDRT_TEST_DONE_MASK 0x1`, `DDRT_TEST_PASS_MASK 0x2`; BURST_CONFIG values 0x4F (data eye) / 0x43 (gate training). No data sheet documents the block.

    VENDOR SOURCE AND BINARY PASS (2026-11-11, docs/rdl-campaign/ddrt-vendor.md): no vendor kernel module touches the DDRT (the MPP modules, ddr*.ko from other vendors and the stock Hi3520D U-Boot contain no DDRT access; the only users are the vendor U-Boot DDR training sources and the shipped U-Boots of the newer IPC chips). Four layouts of the vendor source were compared: (1) the generic `ddr_ddrt_s40.h`/`ddr_ddrt_t28.h` driver (identical files; S40 chips Hi3518E V200/Hi3521A/Hi3531A/Hi3536D, T28 chips Hi3516C V300/Hi3516A V200/Hi3519/Hi3536/Hi3521D/Hi3531D); (2) the Hi3535 / Hi3516A V100 `ddr_dataeye_training.h` set (this file's base set plus ADDR_OFFSET0 0x24); (3) the Hi3520D `product/hiddrtv200/ddrtv200.h`, which is this register file plus the registers under DDRT_V200_REGS below; (4) an older, different DDRT layout in `product/ddrtraining.h` (INTSTAT 0x0, INTEN 0x4, RAWINT 0x8, INTCLR 0xC, START 0x10, MODE 0x14, BLKSIZE 0x18, LOOP_NUM 0x1C, WADDR 0x20, RADDR 0x24, STRIDE 0x28, DATABUF 0x130+4n) used by an old SSN/DMA pressure test whose chip is unidentified (DMAC at 0x100D0000, two DDRCs: a Hi3531-V100-era source); it is NOT modelled and is not the layout of any chip in this repository. Shipped U-Boot binaries of the Xiongmai Hi3518E V200 and Hi3516C V300 IPC firmware (static analysis, nothing executed) write exactly the generic-driver registers (MEM_CONFIG 0xC, DDR_BASE 0x1C, ADDR 0x20, SEED 0x38, BURST_CONFIG 0x8, BURST_NUM 0x10, ADDR_NUM 0x14, LOOP_NUM 0x18, REVERSED_DQ 0x30) and read DQ_ERR_OVFL 0x80, so the generic layout is in use on those chips. The Hi3516C V300 shares a window with the GZIP engine: MISC_CTRL0 bit 19 selects DDRT (0) or GZIP (1).";

    reg {
        name = "DDRT operation register";
        desc = "Operation mode, data pattern and start (`DDRT_OP`): the training code writes `mode | pattern | 1`.

Vendor U-Boot `arch/arm/cpu/hi3535/ddr_dataeye_training.[ch]` (Hi3535 DDR training, `SSN_DDRT`; the DDRT module is at the same address 0x206D0000 and uses the same CRG/SYS_CTRL bits as the Hi3520D, see `arch-hi3520d/platform.h` DDRT_*). Not in the Hi3520D data sheet; offsets and the few bit uses are from the Hi3535 code, not verified on a Hi3520D. No reset values known.";

        field {
            name = "pattern";
            desc = "Data pattern: 0 PRBS9, 1 PRBS7, 2 PRBS11, 3 K28.5 (`DDRT_PATTERM_*`).";
            sw = rw;
            hw = r;
        } pattern[13:12];

        field {
            name = "mode";
            desc = "0 write+read+compare, 1 write only, 2 read only, 3 random read/write (`*_MODE`).";
            sw = rw;
            hw = r;
        } mode[9:8];

        field {
            name = "start";
            desc = "Write 1 to start the test.";
            sw = rw;
            hw = r;
        } start[0:0];
    } DDRT_OP @ 0x0;

    reg {
        name = "DDRT status register";
        desc = "Polled by the training code until bit 0 is set, then bit 1 says pass (`DDRT_STATUS`).

Vendor U-Boot `arch/arm/cpu/hi3535/ddr_dataeye_training.[ch]` (Hi3535 DDR training, `SSN_DDRT`; the DDRT module is at the same address 0x206D0000 and uses the same CRG/SYS_CTRL bits as the Hi3520D, see `arch-hi3520d/platform.h` DDRT_*). Not in the Hi3520D data sheet; offsets and the few bit uses are from the Hi3535 code, not verified on a Hi3520D. No reset values known.";

        field {
            name = "pass";
            desc = "1 = test passed (training code: `(status & 2) ? OK : fail`).";
            sw = r;
            hw = w;
        } pass[1:1];

        field {
            name = "done";
            desc = "1 = test finished.";
            sw = r;
            hw = w;
        } done[0:0];
    } DDRT_STATUS @ 0x4;

    reg {
        name = "Ddrt Burst Transfer";
        desc = "Burst transfer configuration (training writes 0x4F for data-eye training, 0x43 for gate training in the generic driver `DDRT_CFG_BURST_CFG_DATAEYE` / `_GATE`; the Hi3520D training never writes it).

Vendor U-Boot `arch/arm/cpu/hi3535/ddr_dataeye_training.[ch]` (Hi3535 DDR training, `SSN_DDRT`; the DDRT module is at the same address 0x206D0000 and uses the same CRG/SYS_CTRL bits as the Hi3520D, see `arch-hi3520d/platform.h` DDRT_*). Not in the Hi3520D data sheet; offsets and the few bit uses are from the Hi3535 code, not verified on a Hi3520D. No reset values known.";

        field {
            name = "value";
            desc = "Register value (layout not documented).";
            sw = rw;
            hw = r;
        } value[31:0];
    } DDRT_BURST_TRANSFER @ 0x8;

    reg {
        name = "Ddrt Mem Config";
        desc = "Memory configuration (training writes 0x01142).

Vendor U-Boot `arch/arm/cpu/hi3535/ddr_dataeye_training.[ch]` (Hi3535 DDR training, `SSN_DDRT`; the DDRT module is at the same address 0x206D0000 and uses the same CRG/SYS_CTRL bits as the Hi3520D, see `arch-hi3520d/platform.h` DDRT_*). Not in the Hi3520D data sheet; offsets and the few bit uses are from the Hi3535 code, not verified on a Hi3520D. No reset values known.

Vendor generic U-Boot DDR training (`drivers/ddr/ddr_ddrt_s40.h`, `ddr_training_impl.c` ddr_ddrt_init, 2026-11-11): the register is built from the DMC memory-width field and three constants: column width [2:0] (000 = 8 bit .. 100 = 12 bit; the vendor writes 2), row width [6:4] (000 = 11 bit .. 101 = 16 bit; the vendor constant is 0x50, i.e. 5), bank [8] (0 = 4 banks, 1 = 8 banks; the vendor writes 1) and the SDRAM total width at bit 12 written as (DMC mem_width - 1) (value 0 = 16 bit, 1 = 32 bit, field width not stated by the code). The Hi3535 code writes 0x1142 (col 2, row 4, 8 banks, width bit 1), the Hi3520D training writes the constant 0x0132 (col 2, row 3, 8 banks, width 0). Source: vendor U-Boot headers and code, confidence HIGH for the quoted constants and the field positions, MEDIUM for the meanings of the field encodings; not verified on hardware.";

        field {
            name = "col_width";
            desc = "Single SDRAM column address width: 0 = 8 bit, 1 = 9, 2 = 10, 3 = 11, 4 = 12 bit (vendor header comment). Vendor writes 2.";
            sw = rw;
            hw = r;
        } col_width[2:0];

        field {
            name = "row_width";
            desc = "Single SDRAM row address width: 0 = 11 bit .. 5 = 16 bit (vendor header comment). Vendor writes 5 (generic), 4 (Hi3535), 3 (Hi3520D).";
            sw = rw;
            hw = r;
        } row_width[6:4];

        field {
            name = "bank_width";
            desc = "Bank count: 0 = 4 banks, 1 = 8 banks (vendor header comment). Vendor writes 1.";
            sw = rw;
            hw = r;
        } bank_width[8:8];

        field {
            name = "mem_width";
            desc = "SDRAM total width, bit 12 = DMC mem_width - 1 (0 = 16 bit, 1 = 32 bit as written by the generic code); the field width above bit 12 is not stated by the vendor code, so only this one bit is modelled.";
            sw = rw;
            hw = r;
        } mem_width[12:12];
    } DDRT_MEM_CONFIG @ 0xC;

    reg {
        name = "Ddrt Burst Num";
        desc = "Number of bursts (training writes 0xFF).

Vendor U-Boot `arch/arm/cpu/hi3535/ddr_dataeye_training.[ch]` (Hi3535 DDR training, `SSN_DDRT`; the DDRT module is at the same address 0x206D0000 and uses the same CRG/SYS_CTRL bits as the Hi3520D, see `arch-hi3520d/platform.h` DDRT_*). Not in the Hi3520D data sheet; offsets and the few bit uses are from the Hi3535 code, not verified on a Hi3520D. No reset values known.";

        field {
            name = "value";
            desc = "Register value (layout not documented).";
            sw = rw;
            hw = r;
        } value[31:0];
    } DDRT_BURST_NUM @ 0x10;

    reg {
        name = "Ddrt Addr Num";
        desc = "Address count (training writes 0xFFFFFFFF).

Vendor U-Boot `arch/arm/cpu/hi3535/ddr_dataeye_training.[ch]` (Hi3535 DDR training, `SSN_DDRT`; the DDRT module is at the same address 0x206D0000 and uses the same CRG/SYS_CTRL bits as the Hi3520D, see `arch-hi3520d/platform.h` DDRT_*). Not in the Hi3520D data sheet; offsets and the few bit uses are from the Hi3535 code, not verified on a Hi3520D. No reset values known.";

        field {
            name = "value";
            desc = "Register value (layout not documented).";
            sw = rw;
            hw = r;
        } value[31:0];
    } DDRT_ADDR_NUM @ 0x14;

    reg {
        name = "Ddrt Loop Num";
        desc = "Loop count (training writes 0).

Vendor U-Boot `arch/arm/cpu/hi3535/ddr_dataeye_training.[ch]` (Hi3535 DDR training, `SSN_DDRT`; the DDRT module is at the same address 0x206D0000 and uses the same CRG/SYS_CTRL bits as the Hi3520D, see `arch-hi3520d/platform.h` DDRT_*). Not in the Hi3520D data sheet; offsets and the few bit uses are from the Hi3535 code, not verified on a Hi3520D. No reset values known.";

        field {
            name = "value";
            desc = "Register value (layout not documented).";
            sw = rw;
            hw = r;
        } value[31:0];
    } DDRT_LOOP_NUM @ 0x18;

    reg {
        name = "Ddrt Start Addr";
        desc = "Start address (training writes 0x80000000).

Vendor U-Boot `arch/arm/cpu/hi3535/ddr_dataeye_training.[ch]` (Hi3535 DDR training, `SSN_DDRT`; the DDRT module is at the same address 0x206D0000 and uses the same CRG/SYS_CTRL bits as the Hi3520D, see `arch-hi3520d/platform.h` DDRT_*). Not in the Hi3520D data sheet; offsets and the few bit uses are from the Hi3535 code, not verified on a Hi3520D. No reset values known.";

        field {
            name = "value";
            desc = "Register value (layout not documented).";
            sw = rw;
            hw = r;
        } value[31:0];
    } DDRT_START_ADDR @ 0x1C;

    reg {
        name = "Ddrt Addr";
        desc = "Test address (training writes 0x80000000).

Vendor U-Boot `arch/arm/cpu/hi3535/ddr_dataeye_training.[ch]` (Hi3535 DDR training, `SSN_DDRT`; the DDRT module is at the same address 0x206D0000 and uses the same CRG/SYS_CTRL bits as the Hi3520D, see `arch-hi3520d/platform.h` DDRT_*). Not in the Hi3520D data sheet; offsets and the few bit uses are from the Hi3535 code, not verified on a Hi3520D. No reset values known.";

        field {
            name = "value";
            desc = "Register value (layout not documented).";
            sw = rw;
            hw = r;
        } value[31:0];
    } DDRT_ADDR @ 0x20;

    reg {
        name = "Ddrt Addr Offset0";
        desc = "Address offset 0 (defined, not used by the training code).

Vendor U-Boot `arch/arm/cpu/hi3535/ddr_dataeye_training.[ch]` (Hi3535 DDR training, `SSN_DDRT`; the DDRT module is at the same address 0x206D0000 and uses the same CRG/SYS_CTRL bits as the Hi3520D, see `arch-hi3520d/platform.h` DDRT_*). Not in the Hi3520D data sheet; offsets and the few bit uses are from the Hi3535 code, not verified on a Hi3520D. No reset values known.";

        field {
            name = "value";
            desc = "Register value (layout not documented).";
            sw = rw;
            hw = r;
        } value[31:0];
    } DDRT_ADDR_OFFSET0 @ 0x24;

    reg {
        name = "Ddrt Reversed Dq";
        desc = "Per-bit data reversal mask (training writes 0 or 0xB49C863C; the generic driver writes 0x55AA55AA and 0 and takes a second value from the SYS_CTRL DDRT pattern register 0x94; the Hi3520D header names this register REVERSED_BIT_LOWER and the next one, 0x34, REVERSED_BIT_HIGHER: a 64 bit mask pair, both written by the Hi3520D training with test-pattern constants such as 0x4B2C and 0xB4D3).

Vendor U-Boot `arch/arm/cpu/hi3535/ddr_dataeye_training.[ch]` (Hi3535 DDR training, `SSN_DDRT`; the DDRT module is at the same address 0x206D0000 and uses the same CRG/SYS_CTRL bits as the Hi3520D, see `arch-hi3520d/platform.h` DDRT_*). Not in the Hi3520D data sheet; offsets and the few bit uses are from the Hi3535 code, not verified on a Hi3520D. No reset values known.";

        field {
            name = "value";
            desc = "Register value (layout not documented).";
            sw = rw;
            hw = r;
        } value[31:0];
    } DDRT_REVERSED_DQ @ 0x30;

    reg {
        name = "DDRT PRBS seed";
        desc = "Starting random seed of the PRBS pattern generator (`DDRT_SEED`, vendor `ddr_ddrt_s40.h` / `ddr_ddrt_t28.h`; the generic training code writes `DDRT_CFG_SEED` 0x6D6D6D6D). Also in the Hi3520D V200 `ddrtv200.h` list. Not in the Hi3535 training code, unverified on the Hi3520D.";

        field {
            name = "seed";
            desc = "PRBS seed (layout not documented).";
            sw = rw;
            hw = r;
        } seed[31:0];
    } DDRT_SEED @ 0x38;

    reg {
        name = "Ddrt Kdata";
        desc = "K-code data (training writes 0xBC3EB053).

Vendor U-Boot `arch/arm/cpu/hi3535/ddr_dataeye_training.[ch]` (Hi3535 DDR training, `SSN_DDRT`; the DDRT module is at the same address 0x206D0000 and uses the same CRG/SYS_CTRL bits as the Hi3520D, see `arch-hi3520d/platform.h` DDRT_*). Not in the Hi3520D data sheet; offsets and the few bit uses are from the Hi3535 code, not verified on a Hi3520D. No reset values known.";

        field {
            name = "value";
            desc = "Register value (layout not documented).";
            sw = rw;
            hw = r;
        } value[31:0];
    } DDRT_KDATA @ 0x3C;

    reg {
        name = "Ddrt Data0";
        desc = "Data word 0 (0x8A18207F).

Vendor U-Boot `arch/arm/cpu/hi3535/ddr_dataeye_training.[ch]` (Hi3535 DDR training, `SSN_DDRT`; the DDRT module is at the same address 0x206D0000 and uses the same CRG/SYS_CTRL bits as the Hi3520D, see `arch-hi3520d/platform.h` DDRT_*). Not in the Hi3520D data sheet; offsets and the few bit uses are from the Hi3535 code, not verified on a Hi3520D. No reset values known.";

        field {
            name = "value";
            desc = "Register value (layout not documented).";
            sw = rw;
            hw = r;
        } value[31:0];
    } DDRT_DATA0 @ 0x40;

    reg {
        name = "Ddrt Data1";
        desc = "Data word 1 (0x5F2B9A27).

Vendor U-Boot `arch/arm/cpu/hi3535/ddr_dataeye_training.[ch]` (Hi3535 DDR training, `SSN_DDRT`; the DDRT module is at the same address 0x206D0000 and uses the same CRG/SYS_CTRL bits as the Hi3520D, see `arch-hi3520d/platform.h` DDRT_*). Not in the Hi3520D data sheet; offsets and the few bit uses are from the Hi3535 code, not verified on a Hi3520D. No reset values known.";

        field {
            name = "value";
            desc = "Register value (layout not documented).";
            sw = rw;
            hw = r;
        } value[31:0];
    } DDRT_DATA1 @ 0x44;

    reg {
        name = "Ddrt Data2";
        desc = "Data word 2 (0xBDAD9238).

Vendor U-Boot `arch/arm/cpu/hi3535/ddr_dataeye_training.[ch]` (Hi3535 DDR training, `SSN_DDRT`; the DDRT module is at the same address 0x206D0000 and uses the same CRG/SYS_CTRL bits as the Hi3520D, see `arch-hi3520d/platform.h` DDRT_*). Not in the Hi3520D data sheet; offsets and the few bit uses are from the Hi3535 code, not verified on a Hi3520D. No reset values known.";

        field {
            name = "value";
            desc = "Register value (layout not documented).";
            sw = rw;
            hw = r;
        } value[31:0];
    } DDRT_DATA2 @ 0x48;

    reg {
        name = "Ddrt Data3";
        desc = "Data word 3 (0xAA6774B1).

Vendor U-Boot `arch/arm/cpu/hi3535/ddr_dataeye_training.[ch]` (Hi3535 DDR training, `SSN_DDRT`; the DDRT module is at the same address 0x206D0000 and uses the same CRG/SYS_CTRL bits as the Hi3520D, see `arch-hi3520d/platform.h` DDRT_*). Not in the Hi3520D data sheet; offsets and the few bit uses are from the Hi3535 code, not verified on a Hi3520D. No reset values known.";

        field {
            name = "value";
            desc = "Register value (layout not documented).";
            sw = rw;
            hw = r;
        } value[31:0];
    } DDRT_DATA3 @ 0x4C;

    reg {
        name = "DQ error counter";
        desc = "`DDRT_DQ_ERR_CNT(n)` = 0x60 + 4n, n = 0..7.

Vendor U-Boot `arch/arm/cpu/hi3535/ddr_dataeye_training.[ch]` (Hi3535 DDR training, `SSN_DDRT`; the DDRT module is at the same address 0x206D0000 and uses the same CRG/SYS_CTRL bits as the Hi3520D, see `arch-hi3520d/platform.h` DDRT_*). Not in the Hi3520D data sheet; offsets and the few bit uses are from the Hi3535 code, not verified on a Hi3520D. No reset values known.";

        field {
            name = "count";
            desc = "Error count of DQ group n.";
            sw = r;
            hw = w;
        } count[31:0];
    } DDRT_DQ_ERR_CNT[8] @ 0x60 += 0x4;

    reg {
        name = "DQ error overflow";
        desc = "`DDRT_DQ_ERR_OVFL`.

Vendor U-Boot `arch/arm/cpu/hi3535/ddr_dataeye_training.[ch]` (Hi3535 DDR training, `SSN_DDRT`; the DDRT module is at the same address 0x206D0000 and uses the same CRG/SYS_CTRL bits as the Hi3520D, see `arch-hi3520d/platform.h` DDRT_*). Not in the Hi3520D data sheet; offsets and the few bit uses are from the Hi3535 code, not verified on a Hi3520D. No reset values known.";

        field {
            name = "value";
            desc = "Overflow flags (layout not documented).";
            sw = r;
            hw = w;
        } value[31:0];
    } DDRT_DQ_ERR_OVFL @ 0x80;

`ifdef DDRT_V200_REGS

    reg {
        name = "Ddrt Waddr Offset1";
        desc = "Second write-address offset (vendor name DDRT_WADDR_OFFSET1). Defined in the Hi3520D training header, never accessed by its code. Source: vendor U-Boot `product/hiddrtv200/ddrtv200.h` (Hi3520D DDR training), confidence LOW, not verified on hardware.";

        field {
            name = "value";
            desc = "32 bit value, single field (bit layout not observed). Not verified on hardware.";
            sw = rw;
            hw = r;
        } value[31:0];
    } DDRT_WADDR_OFFSET1 @ 0x28;

    reg {
        name = "Ddrt Reversed Bit Higher";
        desc = "Upper 32 bits of the data-reversal indicator (the lower half is DDRT_REVERSED_DQ at 0x30). Written by the Hi3520D training (ddrt_config_ddrt) from the test configuration (value 0 in all calls seen). Source: vendor U-Boot `product/hiddrtv200/ddrtv200.h` (Hi3520D DDR training), confidence MEDIUM, not verified on hardware.";

        field {
            name = "value";
            desc = "32 bit value, single field (bit layout not observed). Not verified on hardware.";
            sw = rw;
            hw = r;
        } value[31:0];
    } DDRT_REVERSED_BIT_HIGHER @ 0x34;

    reg {
        name = "Ddrt Err Num";
        desc = "Error number (vendor name DDRT_ERR_NUM). Defined, never accessed by the Hi3520D training code. Source: vendor U-Boot `product/hiddrtv200/ddrtv200.h` (Hi3520D DDR training), confidence LOW, not verified on hardware.";

        field {
            name = "value";
            desc = "32 bit value, single field (bit layout not observed). Not verified on hardware.";
            sw = r;
            hw = w;
        } value[31:0];
    } DDRT_ERR_NUM @ 0x50;

    reg {
        name = "Ddrt Ints";
        desc = "Interrupt status (vendor name DDRT_INTS). Defined, never accessed. Source: vendor U-Boot `product/hiddrtv200/ddrtv200.h` (Hi3520D DDR training), confidence LOW, not verified on hardware.";

        field {
            name = "value";
            desc = "32 bit value, single field (bit layout not observed). Not verified on hardware.";
            sw = r;
            hw = w;
        } value[31:0];
    } DDRT_INTS @ 0x54;

    reg {
        name = "Ddrt Inten";
        desc = "Interrupt enable (vendor name DDRT_INTEN). Defined, never accessed. Source: vendor U-Boot `product/hiddrtv200/ddrtv200.h` (Hi3520D DDR training), confidence LOW, not verified on hardware.";

        field {
            name = "value";
            desc = "32 bit value, single field (bit layout not observed). Not verified on hardware.";
            sw = rw;
            hw = r;
        } value[31:0];
    } DDRT_INTEN @ 0x58;

    reg {
        name = "Ddrt Intclr";
        desc = "Interrupt clear (vendor name DDRT_INTCLR). Defined, never accessed. Source: vendor U-Boot `product/hiddrtv200/ddrtv200.h` (Hi3520D DDR training), confidence LOW, not verified on hardware.";

        field {
            name = "value";
            desc = "32 bit value, single field (bit layout not observed). Not verified on hardware.";
            sw = w;
            hw = r;
        } value[31:0];
    } DDRT_INTCLR @ 0x5C;

    reg {
        name = "Ddrt Bit Err Cnt0";
        desc = "Bit error count 0 (vendor name DDRT_BIT_ERR_CNT0). Defined, never accessed. Source: vendor U-Boot `product/hiddrtv200/ddrtv200.h` (Hi3520D DDR training), confidence LOW, not verified on hardware.";

        field {
            name = "value";
            desc = "32 bit value, single field (bit layout not observed). Not verified on hardware.";
            sw = r;
            hw = w;
        } value[31:0];
    } DDRT_BIT_ERR_CNT0 @ 0x90;

    reg {
        name = "Ddrt Bit Err Cnt1";
        desc = "Bit error count 1 (vendor name DDRT_BIT_ERR_CNT1). Defined, never accessed. Source: vendor U-Boot `product/hiddrtv200/ddrtv200.h` (Hi3520D DDR training), confidence LOW, not verified on hardware.";

        field {
            name = "value";
            desc = "32 bit value, single field (bit layout not observed). Not verified on hardware.";
            sw = r;
            hw = w;
        } value[31:0];
    } DDRT_BIT_ERR_CNT1 @ 0x94;

    reg {
        name = "Ddrt Bit Err Ovfl";
        desc = "Bit error overflow flags (vendor name DDRT_BIT_ERR_OVFL). Defined, never accessed. Source: vendor U-Boot `product/hiddrtv200/ddrtv200.h` (Hi3520D DDR training), confidence LOW, not verified on hardware.";

        field {
            name = "value";
            desc = "32 bit value, single field (bit layout not observed). Not verified on hardware.";
            sw = r;
            hw = w;
        } value[31:0];
    } DDRT_BIT_ERR_OVFL @ 0xA0;
`endif
};

`endif
