`ifndef HISI_LSADC_V2_RDL
`define HISI_LSADC_V2_RDL

regfile eHISI_LSADC_V2 {
    name = "HiSilicon LSADC controller, 10-bit generation (2-3 channels)";
    desc = "
    Low-speed ADC (LSADC) of the second generation: 10-bit sampling depth, 3.3 V / 1.8 V supply, up to 200000 scans per second, single and continuous scanning mode with deglitch, scanned value valid interrupt
    (single `int_enable` bit, one `int_flag_in*` / `clr_int_flag_in*` bit per channel). Compared with the first generation (HISI_LSADC.rdl, 6-bit result, 8-bit result fields, LSADC_CTRL3 data hold, separate key-change
    interrupt bits) the controller has an explicit sampling-depth register LSADC_CTRL9 (reset 0x3FF, 10 bits), per-channel 10-bit data registers and no LSADC_CTRL3. Instance base 0x120E0000 in all chips below;
    the soft reset / clock gate is in PERI_CRG31 (`lsadc_srst_req` ...). The block is the same IP but the three data sheets differ in the channel count and naming, selected by macros defined BEFORE including this file:

    - default (no macro): Hi3516A V200 (Hi3516AV200 data sheet 12.11, issue of 2016-2017) and Hi3519 V101 (data sheet 12.11): three channels numbered 1-3 (`ch_1_vld`..`ch_3_vld` at LSADC_CTRL0 [9..11], data registers
      LSADC_CTRL12/13/14 at 0x30/0x34/0x38, `lsadc_data_in1..3`), `power_down_model` at LSADC_CTRL0 [14], total reset of LSADC_CTRL0 0x80FF. The two data sheets are identical for this block. IRQ 48.
    - HISI_LSADC_V2_CV300: Hi3516C V300 / Hi3516E V100 (data sheet 12.9, 10-bit, three channels A-C = channel 0-2, `Hi3516CV300-Hi3516EV100` edition issue 05; the older 2016 draft edition lists only two data registers and is
      superseded): `ch_a_vld`..`ch_c_vld` at LSADC_CTRL0 [8..10], per-channel sampling equalization enable `ch_a_eq_enable`..`ch_c_eq_enable` at [0..2] (reset 1), data registers LSADC_CTRL11/12/13 at 0x2C/0x30/0x34
      (`lsadc_data_ina..c`), maximum scan rate stated as 16000 scans/s in the features list, total reset of LSADC_CTRL0 0x807F. IRQ 19 shared with the IR receiver (\"IR/LSADC\").
    - HISI_LSADC_V2_AV300: Hi3516A V300 (Chinese data sheet 12.9, original user guide, watermarked: rows read by eye): two channels 0-1 (`ch_0_vld` [8], `ch_1_vld` [9]; the features list contradicts itself with \"4 independent
      channels\", the register tables only have two), no power-down mode bit ([14] is reserved), data registers LSADC_CTRL11/12 at 0x2C/0x30 (`lsadc_data_in0/in1`), the minimum `time_scan` is 20 (not 14), total reset of LSADC_CTRL0 0x80FF. IRQ 97.

    Data sheet typos that the model corrects (all other chips and the Hi3516A/D first-generation block use the same access types): the scanned value registers (`lsadc_data_in*`) are listed RW in some tables but are read-only status results (modelled sw = r);
    `clr_int_flag_in0` of the Hi3516A V300 is listed RO (modelled WO like every other clear bit); the scan interval / deglitch unit is printed as \"0.333 us\" here and as \"0.333 ms\" in the Hi3518E V20X data sheet (the 3 MHz
    LSADC clock and a 200 kHz scan limit make 0.333 us the consistent value). Hi3516C V300: sources are `hi3516cv300--Hi3516CV300-Hi3516EV100-Datasheet.txt` lines 82167-82700;
    Hi3516A V200 `hi3516av200--Hi3516AV200-Datasheet.txt` lines 109763-110350; Hi3519 V101 `hi3519v101--Hi3519V101-Datasheet.txt` lines 109711-110300; Hi3516A V300 `hi3516av300--Hi3516AV300-Datasheet.txt` lines 68596-69120.
    No vendor driver for these SoCs is in the source trees; data-sheet only, not hardware verified.
    ";


    reg {
        name = "LSADC configuration register";
        desc = "LSADC_CTRL0 is an LSDAC configuration register.

The layout of the channel bits depends on the chip (see the block description); `lsadc_reset` is set out of reset: clear it before use.

Data sheet 12.11 LSADC_CTRL0 (offset 0x0, printed page 12-370, `hi3516av200--Hi3516AV200-Datasheet.txt` line 109938); the other editions (12.9 in the Hi3516C V300 and Hi3516A V300 data sheets) print the same register.";

        field {
            name = "lsadc_data_delta";
            desc = "Error range of the LSADC conversion result. In continuous scanning mode, if the difference between two conversion results falls within the error range, the two results are considered as the same.";
            sw = rw;
            hw = r;
            reset = 0x0;
        } lsadc_data_delta[23:20];

        enum LSADC_CTRL0_deglitch_bypass_enum {
            ENABLED = 0 { name = "Enabled"; desc = "enabled"; };
            BYPASSED = 1 { name = "Bypassed"; desc = "bypassed"; };
        };

        field {
            name = "deglitch_bypass";
            desc = "Deglitch bypass (used in continuous scanning mode)";
            sw = rw;
            hw = r;
            encode = LSADC_CTRL0_deglitch_bypass_enum;
            reset = 0x0;
        } deglitch_bypass[17:17];

        enum LSADC_CTRL0_lsadc_reset_enum {
            LSADC_EXITS_RESET = 0 { name = "Lsadc Exits Reset"; desc = "The LSADC exits the reset status."; };
            LSADC_ENTERS_RESET = 1 { name = "Lsadc Enters Reset"; desc = "The LSADC enters the reset status."; };
        };

        field {
            name = "lsadc_reset";
            desc = "Whether the LSADC enters the reset status";
            sw = rw;
            hw = r;
            encode = LSADC_CTRL0_lsadc_reset_enum;
            reset = 0x1;
        } lsadc_reset[15:15];

        enum LSADC_CTRL0_model_sel_enum {
            SINGLE_SCANNING_MODE = 0 { name = "Single Scanning Mode"; desc = "single scanning mode"; };
            CONTINUOUS_SCANNING_MODE = 1 { name = "Continuous Scanning Mode"; desc = "continuous scanning mode"; };
        };

        field {
            name = "model_sel";
            desc = "Scanning mode of the LSADC";
            sw = rw;
            hw = r;
            encode = LSADC_CTRL0_model_sel_enum;
            reset = 0x0;
        } model_sel[13:13];

`ifdef HISI_LSADC_V2_CV300
        enum LSADC_CTRL0_power_down_model_enum {
            NOT_SUPPORTED = 0 { name = "Not Supported"; desc = "The power down operation is not supported."; };
            AUTO_POWER_DOWN = 1 { name = "Auto Power Down"; desc = "The LSADC is automatically powered down after scanning is complete."; };
        };

        field {
            name = "power_down_model";
            desc = "Whether the power down operation is supported. 0: not supported; 1: the LSADC is automatically powered down after scanning is complete (the Hi3516C V300 / Hi3516E V100 data sheet words it as supported / not supported).";
            sw = rw;
            hw = r;
            encode = LSADC_CTRL0_power_down_model_enum;
            reset = 0x0;
        } power_down_model[14:14];

        enum LSADC_CTRL0_ch_c_vld_enum {
            INVALID = 0 { name = "Invalid"; desc = "invalid"; };
            VALID = 1 { name = "Valid"; desc = "valid"; };
        };

        field {
            name = "ch_c_vld";
            desc = "LSADC channel C (2) validity";
            sw = rw;
            hw = r;
            encode = LSADC_CTRL0_ch_c_vld_enum;
            reset = 0x0;
        } ch_c_vld[10:10];

        enum LSADC_CTRL0_ch_b_vld_enum {
            INVALID = 0 { name = "Invalid"; desc = "invalid"; };
            VALID = 1 { name = "Valid"; desc = "valid"; };
        };

        field {
            name = "ch_b_vld";
            desc = "LSADC channel B (1) validity";
            sw = rw;
            hw = r;
            encode = LSADC_CTRL0_ch_b_vld_enum;
            reset = 0x0;
        } ch_b_vld[9:9];

        enum LSADC_CTRL0_ch_a_vld_enum {
            INVALID = 0 { name = "Invalid"; desc = "invalid"; };
            VALID = 1 { name = "Valid"; desc = "valid"; };
        };

        field {
            name = "ch_a_vld";
            desc = "LSADC channel A (0) validity";
            sw = rw;
            hw = r;
            encode = LSADC_CTRL0_ch_a_vld_enum;
            reset = 0x0;
        } ch_a_vld[8:8];

        field {
            name = "reserved_7_3";
            desc = "Reserved; resets to 0x0F: the data sheet total reset value is 0x0000_807F and lists bits [7:3] as reserved (RW) (not read on hardware).";
            sw = rw;
            hw = r;
            reset = 0xF;
        } reserved_7_3[7:3];

        enum LSADC_CTRL0_ch_c_eq_enable_enum {
            INVALID = 0 { name = "Invalid"; desc = "invalid"; };
            VALID = 1 { name = "Valid"; desc = "valid"; };
        };

        field {
            name = "ch_c_eq_enable";
            desc = "LSADC channel 2 sampling equalization algorithm validity";
            sw = rw;
            hw = r;
            encode = LSADC_CTRL0_ch_c_eq_enable_enum;
            reset = 0x1;
        } ch_c_eq_enable[2:2];

        enum LSADC_CTRL0_ch_b_eq_enable_enum {
            INVALID = 0 { name = "Invalid"; desc = "invalid"; };
            VALID = 1 { name = "Valid"; desc = "valid"; };
        };

        field {
            name = "ch_b_eq_enable";
            desc = "LSADC channel 1 sampling equalization algorithm validity";
            sw = rw;
            hw = r;
            encode = LSADC_CTRL0_ch_b_eq_enable_enum;
            reset = 0x1;
        } ch_b_eq_enable[1:1];

        enum LSADC_CTRL0_ch_a_eq_enable_enum {
            INVALID = 0 { name = "Invalid"; desc = "invalid"; };
            VALID = 1 { name = "Valid"; desc = "valid"; };
        };

        field {
            name = "ch_a_eq_enable";
            desc = "LSADC channel 0 sampling equalization algorithm validity";
            sw = rw;
            hw = r;
            encode = LSADC_CTRL0_ch_a_eq_enable_enum;
            reset = 0x1;
        } ch_a_eq_enable[0:0];

`else
`ifdef HISI_LSADC_V2_AV300
        enum LSADC_CTRL0_ch_1_vld_enum {
            INVALID = 0 { name = "Invalid"; desc = "invalid"; };
            VALID = 1 { name = "Valid"; desc = "valid"; };
        };

        field {
            name = "ch_1_vld";
            desc = "LSADC channel 1 validity";
            sw = rw;
            hw = r;
            encode = LSADC_CTRL0_ch_1_vld_enum;
            reset = 0x0;
        } ch_1_vld[9:9];

        enum LSADC_CTRL0_ch_0_vld_enum {
            INVALID = 0 { name = "Invalid"; desc = "invalid"; };
            VALID = 1 { name = "Valid"; desc = "valid"; };
        };

        field {
            name = "ch_0_vld";
            desc = "LSADC channel 0 validity";
            sw = rw;
            hw = r;
            encode = LSADC_CTRL0_ch_0_vld_enum;
            reset = 0x0;
        } ch_0_vld[8:8];

        field {
            name = "reserved_7_0";
            desc = "Reserved (RO); reads 0xFF: the data sheet total reset value is 0x0000_80FF (not read on hardware).";
            sw = r;
            hw = w;
            reset = 0xFF;
        } reserved_7_0[7:0];

`else
        enum LSADC_CTRL0_power_down_model_enum {
            NOT_SUPPORTED = 0 { name = "Not Supported"; desc = "The power down operation is not supported."; };
            AUTO_POWER_DOWN = 1 { name = "Auto Power Down"; desc = "The LSADC is automatically powered down after scanning is complete."; };
        };

        field {
            name = "power_down_model";
            desc = "Whether the power down operation is supported. 0: not supported; 1: the LSADC is automatically powered down after scanning is complete (the Hi3516C V300 / Hi3516E V100 data sheet words it as supported / not supported).";
            sw = rw;
            hw = r;
            encode = LSADC_CTRL0_power_down_model_enum;
            reset = 0x0;
        } power_down_model[14:14];

        enum LSADC_CTRL0_ch_3_vld_enum {
            INVALID = 0 { name = "Invalid"; desc = "invalid"; };
            VALID = 1 { name = "Valid"; desc = "valid"; };
        };

        field {
            name = "ch_3_vld";
            desc = "LSADC channel 3 validity";
            sw = rw;
            hw = r;
            encode = LSADC_CTRL0_ch_3_vld_enum;
            reset = 0x0;
        } ch_3_vld[11:11];

        enum LSADC_CTRL0_ch_2_vld_enum {
            INVALID = 0 { name = "Invalid"; desc = "invalid"; };
            VALID = 1 { name = "Valid"; desc = "valid"; };
        };

        field {
            name = "ch_2_vld";
            desc = "LSADC channel 2 validity";
            sw = rw;
            hw = r;
            encode = LSADC_CTRL0_ch_2_vld_enum;
            reset = 0x0;
        } ch_2_vld[10:10];

        enum LSADC_CTRL0_ch_1_vld_enum {
            INVALID = 0 { name = "Invalid"; desc = "invalid"; };
            VALID = 1 { name = "Valid"; desc = "valid"; };
        };

        field {
            name = "ch_1_vld";
            desc = "LSADC channel 1 validity";
            sw = rw;
            hw = r;
            encode = LSADC_CTRL0_ch_1_vld_enum;
            reset = 0x0;
        } ch_1_vld[9:9];

        field {
            name = "reserved_8_0";
            desc = "Reserved (RO); reads 0xFF: the data sheet total reset value is 0x0000_80FF (not read on hardware).";
            sw = r;
            hw = w;
            reset = 0xFF;
        } reserved_8_0[8:0];

`endif
`endif
    } LSADC_CTRL0 @ 0x0;

    reg {
        name = "Deglitch configuration register";
        desc = "LSADC_CTRL1 is a deglitch configuration register.

Data sheet 12.11 LSADC_CTRL1 (offset 0x4, printed page 12-372, `hi3516av200--Hi3516AV200-Datasheet.txt` line 110018); the other editions (12.9 in the Hi3516C V300 and Hi3516A V300 data sheets) print the same register.";

        field {
            name = "glitch_sample";
            desc = "LSADC deglitch time window (in ms typically). When the LSADC conversion result is retained in the deglitch time window, the conversion result is considered as a valid value; otherwise, a glitch is considered. The deglitch time window cannot be 0 in continuous scanning mode. Tglitch = glitch_sample x 0.333 us (Hi3516A V200 / Hi3519 V101 data sheets).";
            sw = rw;
            hw = r;
            reset = 0x0;
        } glitch_sample[31:0];

    } LSADC_CTRL1 @ 0x4;

    reg {
        name = "Scanning interval configuration register";
        desc = "LSADC_CTRL2 is a scanning interval configuration register.

Data sheet 12.11 LSADC_CTRL2 (offset 0x8, printed page 12-372, `hi3516av200--Hi3516AV200-Datasheet.txt` line 110042); the other editions (12.9 in the Hi3516C V300 and Hi3516A V300 data sheets) print the same register.";

        field {
            name = "time_scan";
            desc = "Interval of scanning two channels in continuous scanning mode: Tscan = time_scan x 0.333 us. The interval must be greater than the LSADC conversion time, that is, the configured value must be greater than or equal to 14 (20 in the Hi3516A V300 data sheet).";
            sw = rw;
            hw = r;
            reset = 0x0;
        } time_scan[31:0];

    } LSADC_CTRL2 @ 0x8;

    reg {
        name = "Interrupt enable register";
        desc = "LSADC_CTRL4 is an interrupt enable register.

Data sheet 12.11 LSADC_CTRL4 (offset 0x10, printed page 12-373, `hi3516av200--Hi3516AV200-Datasheet.txt` line 110074); the other editions (12.9 in the Hi3516C V300 and Hi3516A V300 data sheets) print the same register.";

        enum LSADC_CTRL4_int_enable_enum {
            DISABLED = 0 { name = "Disabled"; desc = "disabled"; };
            ENABLED = 1 { name = "Enabled"; desc = "enabled"; };
        };

        field {
            name = "int_enable";
            desc = "Scanned value valid interrupt enable";
            sw = rw;
            hw = r;
            encode = LSADC_CTRL4_int_enable_enum;
            reset = 0x0;
        } int_enable[0:0];

    } LSADC_CTRL4 @ 0x10;

    reg {
        name = "Interrupt status register";
        desc = "LSADC_CTRL5 is an interrupt status register.

Data sheet 12.11 LSADC_CTRL5 (offset 0x14, printed page 12-373, `hi3516av200--Hi3516AV200-Datasheet.txt` line 110103); the other editions (12.9 in the Hi3516C V300 and Hi3516A V300 data sheets) print the same register.";

        enum LSADC_CTRL5_lsadc_auto_busy_enum {
            IDLE = 0 { name = "Idle"; desc = "idle"; };
            BUSY = 1 { name = "Busy"; desc = "busy"; };
        };

        field {
            name = "lsadc_auto_busy";
            desc = "LSADC busy indicator in automatic scanning mode";
            sw = r;
            hw = w;
            encode = LSADC_CTRL5_lsadc_auto_busy_enum;
            reset = 0x0;
        } lsadc_auto_busy[4:4];

`ifdef HISI_LSADC_V2_CV300
        field {
            name = "int_flag_inc";
            desc = "Scanned value valid interrupt flag of channel 2 (C). 0: no interrupt is generated; 1: an interrupt is generated.";
            sw = r;
            hw = w;
            reset = 0x0;
        } int_flag_inc[2:2];

        field {
            name = "int_flag_inb";
            desc = "Scanned value valid interrupt flag of channel 1 (B). 0: no interrupt is generated; 1: an interrupt is generated.";
            sw = r;
            hw = w;
            reset = 0x0;
        } int_flag_inb[1:1];

        field {
            name = "int_flag_ina";
            desc = "Scanned value valid interrupt flag of channel 0 (A). 0: no interrupt is generated; 1: an interrupt is generated.";
            sw = r;
            hw = w;
            reset = 0x0;
        } int_flag_ina[0:0];

`else
`ifdef HISI_LSADC_V2_AV300
        field {
            name = "int_flag_in1";
            desc = "Scanned value valid interrupt flag of channel 1. 0: no interrupt is generated; 1: an interrupt is generated.";
            sw = r;
            hw = w;
            reset = 0x0;
        } int_flag_in1[1:1];

        field {
            name = "int_flag_in0";
            desc = "Scanned value valid interrupt flag of channel 0. 0: no interrupt is generated; 1: an interrupt is generated.";
            sw = r;
            hw = w;
            reset = 0x0;
        } int_flag_in0[0:0];

`else
        field {
            name = "int_flag_in3";
            desc = "Scanned value valid interrupt flag of channel 3. 0: no interrupt is generated; 1: an interrupt is generated.";
            sw = r;
            hw = w;
            reset = 0x0;
        } int_flag_in3[3:3];

        field {
            name = "int_flag_in2";
            desc = "Scanned value valid interrupt flag of channel 2. 0: no interrupt is generated; 1: an interrupt is generated.";
            sw = r;
            hw = w;
            reset = 0x0;
        } int_flag_in2[2:2];

        field {
            name = "int_flag_in1";
            desc = "Scanned value valid interrupt flag of channel 1. 0: no interrupt is generated; 1: an interrupt is generated.";
            sw = r;
            hw = w;
            reset = 0x0;
        } int_flag_in1[1:1];

`endif
`endif
    } LSADC_CTRL5 @ 0x14;

    reg {
        name = "Interrupt clear register";
        desc = "LSADC_CTRL6 is an interrupt clear register.

Data sheet 12.11 LSADC_CTRL6 (offset 0x18, printed page 12-374, `hi3516av200--Hi3516AV200-Datasheet.txt` line 110155); the other editions (12.9 in the Hi3516C V300 and Hi3516A V300 data sheets) print the same register.";

`ifdef HISI_LSADC_V2_CV300
        enum LSADC_CTRL6_clr_int_flag_inc_enum {
            NOT_CLEARED = 0 { name = "Not Cleared"; desc = "not cleared"; };
            CLEARED = 1 { name = "Cleared"; desc = "cleared"; };
        };

        field {
            name = "clr_int_flag_inc";
            desc = "Channel 2 (C) interrupt clear";
            sw = w;
            hw = r;
            encode = LSADC_CTRL6_clr_int_flag_inc_enum;
            reset = 0x0;
        } clr_int_flag_inc[2:2];

        enum LSADC_CTRL6_clr_int_flag_inb_enum {
            NOT_CLEARED = 0 { name = "Not Cleared"; desc = "not cleared"; };
            CLEARED = 1 { name = "Cleared"; desc = "cleared"; };
        };

        field {
            name = "clr_int_flag_inb";
            desc = "Channel 1 (B) interrupt clear";
            sw = w;
            hw = r;
            encode = LSADC_CTRL6_clr_int_flag_inb_enum;
            reset = 0x0;
        } clr_int_flag_inb[1:1];

        enum LSADC_CTRL6_clr_int_flag_ina_enum {
            NOT_CLEARED = 0 { name = "Not Cleared"; desc = "not cleared"; };
            CLEARED = 1 { name = "Cleared"; desc = "cleared"; };
        };

        field {
            name = "clr_int_flag_ina";
            desc = "Channel 0 (A) interrupt clear";
            sw = w;
            hw = r;
            encode = LSADC_CTRL6_clr_int_flag_ina_enum;
            reset = 0x0;
        } clr_int_flag_ina[0:0];

`else
`ifdef HISI_LSADC_V2_AV300
        enum LSADC_CTRL6_clr_int_flag_in1_enum {
            NOT_CLEARED = 0 { name = "Not Cleared"; desc = "not cleared"; };
            CLEARED = 1 { name = "Cleared"; desc = "cleared"; };
        };

        field {
            name = "clr_int_flag_in1";
            desc = "Channel 1 interrupt clear";
            sw = w;
            hw = r;
            encode = LSADC_CTRL6_clr_int_flag_in1_enum;
            reset = 0x0;
        } clr_int_flag_in1[1:1];

        enum LSADC_CTRL6_clr_int_flag_in0_enum {
            NOT_CLEARED = 0 { name = "Not Cleared"; desc = "not cleared"; };
            CLEARED = 1 { name = "Cleared"; desc = "cleared"; };
        };

        field {
            name = "clr_int_flag_in0";
            desc = "Channel 0 interrupt clear";
            sw = w;
            hw = r;
            encode = LSADC_CTRL6_clr_int_flag_in0_enum;
            reset = 0x0;
        } clr_int_flag_in0[0:0];

`else
        enum LSADC_CTRL6_clr_int_flag_in3_enum {
            NOT_CLEARED = 0 { name = "Not Cleared"; desc = "not cleared"; };
            CLEARED = 1 { name = "Cleared"; desc = "cleared"; };
        };

        field {
            name = "clr_int_flag_in3";
            desc = "Channel 3 interrupt clear";
            sw = w;
            hw = r;
            encode = LSADC_CTRL6_clr_int_flag_in3_enum;
            reset = 0x0;
        } clr_int_flag_in3[3:3];

        enum LSADC_CTRL6_clr_int_flag_in2_enum {
            NOT_CLEARED = 0 { name = "Not Cleared"; desc = "not cleared"; };
            CLEARED = 1 { name = "Cleared"; desc = "cleared"; };
        };

        field {
            name = "clr_int_flag_in2";
            desc = "Channel 2 interrupt clear";
            sw = w;
            hw = r;
            encode = LSADC_CTRL6_clr_int_flag_in2_enum;
            reset = 0x0;
        } clr_int_flag_in2[2:2];

        enum LSADC_CTRL6_clr_int_flag_in1_enum {
            NOT_CLEARED = 0 { name = "Not Cleared"; desc = "not cleared"; };
            CLEARED = 1 { name = "Cleared"; desc = "cleared"; };
        };

        field {
            name = "clr_int_flag_in1";
            desc = "Channel 1 interrupt clear";
            sw = w;
            hw = r;
            encode = LSADC_CTRL6_clr_int_flag_in1_enum;
            reset = 0x0;
        } clr_int_flag_in1[1:1];

`endif
`endif
    } LSADC_CTRL6 @ 0x18;

    reg {
        name = "Start configuration register";
        desc = "LSADC_CTRL7 is a start configuration register.

Data sheet 12.11 LSADC_CTRL7 (offset 0x1C, printed page 12-375, `hi3516av200--Hi3516AV200-Datasheet.txt` line 110197); the other editions (12.9 in the Hi3516C V300 and Hi3516A V300 data sheets) print the same register.";

        field {
            name = "start";
            desc = "LSADC start signal. Writing any value to this register starts the LSADC.";
            sw = w;
            hw = r;
            reset = 0x0;
        } start[31:0];

    } LSADC_CTRL7 @ 0x1C;

    reg {
        name = "Stop configuration register";
        desc = "LSADC_CTRL8 is a stop configuration register.

Data sheet 12.11 LSADC_CTRL8 (offset 0x20, printed page 12-375, `hi3516av200--Hi3516AV200-Datasheet.txt` line 110218); the other editions (12.9 in the Hi3516C V300 and Hi3516A V300 data sheets) print the same register.";

        field {
            name = "stop";
            desc = "Automatic scanning stop. In automatic scanning mode, writing any value to this register stops automatic scanning of the LSADC. Automatic scanning is restarted only after the start bit is enabled.";
            sw = w;
            hw = r;
            reset = 0x0;
        } stop[31:0];

    } LSADC_CTRL8 @ 0x20;

    reg {
        name = "Conversion result precision register";
        desc = "LSADC_CTRL9 is a conversion result precision register.

Total reset 0x3FF (10-bit precision). When the precision is below 10 bits the corresponding upper bits of the sampling result are valid (for 8 bits the upper 8 bits).

Data sheet 12.11 LSADC_CTRL9 (offset 0x24, printed page 12-375, `hi3516av200--Hi3516AV200-Datasheet.txt` line 110238); the other editions (12.9 in the Hi3516C V300 and Hi3516A V300 data sheets) print the same register.";

        field {
            name = "lsadc_active_bit";
            desc = "LSADC conversion result precision. 10'b1111111111: 10-bit precision; 10'b1111111110: 9-bit precision; ...; 10'b1000000000: 1-bit precision.";
            sw = rw;
            hw = r;
            reset = 0x3FF;
        } lsadc_active_bit[9:0];

    } LSADC_CTRL9 @ 0x24;

    reg {
        name = "lsadc_zero register";
        desc = "LSADC_CTRL10 is an lsadc_zero register.

Data sheet 12.11 LSADC_CTRL10 (offset 0x28, printed page 12-376, `hi3516av200--Hi3516AV200-Datasheet.txt` line 110271); the other editions (12.9 in the Hi3516C V300 and Hi3516A V300 data sheets) print the same register.";

        field {
            name = "lsadc_zero";
            desc = "LSADC value when no key is pressed.";
            sw = rw;
            hw = r;
            reset = 0x0;
        } lsadc_zero[9:0];

    } LSADC_CTRL10 @ 0x28;

`ifdef HISI_LSADC_V2_CV300
    reg {
        name = "LSADC data hold register 1";
        desc = "LSADC_CTRL11 is LSADC data hold register 1.

Data sheet 12.9 LSADC_CTRL11 (offset 0x2C, printed page 12-256, `hi3516cv300--Hi3516CV300-Hi3516EV100-Datasheet.txt` line 82633).";

        field {
            name = "lsadc_data_ina";
            desc = "Scanned value of LSADC channel 0 (A). Listed RW by some data sheets; modelled read-only (scan result).";
            sw = r;
            hw = w;
            reset = 0x0;
        } lsadc_data_ina[9:0];

    } LSADC_CTRL11 @ 0x2C;

    reg {
        name = "LSADC data hold register 2";
        desc = "LSADC_CTRL12 is LSADC data hold register 2.

Data sheet 12.9 LSADC_CTRL12 (offset 0x30, printed page 12-257, `hi3516cv300--Hi3516CV300-Hi3516EV100-Datasheet.txt` line 82662).";

        field {
            name = "lsadc_data_inb";
            desc = "Scanned value of LSADC channel 1 (B). Listed RW by some data sheets; modelled read-only (scan result).";
            sw = r;
            hw = w;
            reset = 0x0;
        } lsadc_data_inb[9:0];

    } LSADC_CTRL12 @ 0x30;

    reg {
        name = "LSADC data hold register 3";
        desc = "LSADC_CTRL13 is LSADC data hold register 3.

Data sheet 12.9 LSADC_CTRL13 (offset 0x34, printed page 12-257, `hi3516cv300--Hi3516CV300-Hi3516EV100-Datasheet.txt` line 82681).";

        field {
            name = "lsadc_data_inc";
            desc = "Scanned value of LSADC channel 2 (C). Listed RW by some data sheets; modelled read-only (scan result).";
            sw = r;
            hw = w;
            reset = 0x0;
        } lsadc_data_inc[9:0];

    } LSADC_CTRL13 @ 0x34;

`else
`ifdef HISI_LSADC_V2_AV300
    reg {
        name = "LSADC channel 0 data register";
        desc = "LSADC_CTRL11 is the LSADC channel 0 data register.

Data sheet 12.9 LSADC_CTRL11 (offset 0x2C, printed page 12-184, `hi3516av300--Hi3516AV300-Datasheet.txt` line 69081, Chinese).";

        field {
            name = "lsadc_data_in0";
            desc = "Scanned value of LSADC channel 0. Listed RW by some data sheets; modelled read-only (scan result).";
            sw = r;
            hw = w;
            reset = 0x0;
        } lsadc_data_in0[9:0];

    } LSADC_CTRL11 @ 0x2C;

    reg {
        name = "LSADC channel 1 data register";
        desc = "LSADC_CTRL12 is the LSADC channel 1 data register.

Data sheet 12.9 LSADC_CTRL12 (offset 0x30, printed page 12-185, `hi3516av300--Hi3516AV300-Datasheet.txt` line 69102, Chinese).";

        field {
            name = "lsadc_data_in1";
            desc = "Scanned value of LSADC channel 1. Listed RW by some data sheets; modelled read-only (scan result).";
            sw = r;
            hw = w;
            reset = 0x0;
        } lsadc_data_in1[9:0];

    } LSADC_CTRL12 @ 0x30;

`else
    reg {
        name = "LSADC channel 1 data register";
        desc = "LSADC_CTRL12 is the LSADC channel 1 data register.

Data sheet 12.11 LSADC_CTRL12 (offset 0x30, printed page 12-376, `hi3516av200--Hi3516AV200-Datasheet.txt` line 110291).";

        field {
            name = "lsadc_data_in1";
            desc = "Scanned value of LSADC channel 1. Listed RW by some data sheets; modelled read-only (scan result).";
            sw = r;
            hw = w;
            reset = 0x0;
        } lsadc_data_in1[9:0];

    } LSADC_CTRL12 @ 0x30;

    reg {
        name = "LSADC channel 2 data register";
        desc = "LSADC_CTRL13 is the LSADC channel 2 data register.

Data sheet 12.11 LSADC_CTRL13 (offset 0x34, printed page 12-376, `hi3516av200--Hi3516AV200-Datasheet.txt` line 110320).";

        field {
            name = "lsadc_data_in2";
            desc = "Scanned value of LSADC channel 2. Listed RW by some data sheets; modelled read-only (scan result).";
            sw = r;
            hw = w;
            reset = 0x0;
        } lsadc_data_in2[9:0];

    } LSADC_CTRL13 @ 0x34;

    reg {
        name = "LSADC channel 3 data register";
        desc = "LSADC_CTRL14 is the LSADC channel 3 data register.

Data sheet 12.11 LSADC_CTRL14 (offset 0x38, printed page 12-377, `hi3516av200--Hi3516AV200-Datasheet.txt` line 110339).";

        field {
            name = "lsadc_data_in3";
            desc = "Scanned value of LSADC channel 3. Listed RW by some data sheets; modelled read-only (scan result).";
            sw = r;
            hw = w;
            reset = 0x0;
        } lsadc_data_in3[9:0];

    } LSADC_CTRL14 @ 0x38;

`endif
`endif
};

`endif
