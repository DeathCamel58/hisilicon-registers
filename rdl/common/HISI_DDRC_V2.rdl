`ifndef HISI_DDRC_V2_RDL
`define HISI_DDRC_V2_RDL

regfile eHISI_DDRC_V2_AXI {
    name = "DDRC V2 AXI registers";
    desc = "AXI-side registers of the DDR2/DDR3 controller (DDRC), data sheet 4.1.5 (Table 4-5 'Summary of EMI registers', base 0x20110000): function configuration, clock gating, channel configuration, low power, per-port QoS / priority / timeout / outstanding / flux configuration. Port-indexed registers (`ports` = 0..6, stride 4) are register arrays of 7 elements.";

    reg {
        name = "DDRC function configuration register";
        desc = "AXI_CONFIG is a DDRC function configuration register.

Data sheet 4.1.5 AXI_CONFIG (offset 0x0, printed page 4-15, dump line 32425).";

        enum AXI_CONFIG_wr_rcv_mode_enum {
            WRITE_COMMAND_RECEIVED = 0 { name = "Write Command Received"; desc = "The write command is received directly."; };
            WRITE_COMMAND_RECEIVED_2 = 1 { name = "Write Command Received 2"; desc = "The write command is received only after the expected written data arrives."; };
        };

        field {
            name = "wr_rcv_mode";
            desc = "Mode of receiving the write command over the DDRC AXI port";
            sw = rw;
            hw = r;
            encode = AXI_CONFIG_wr_rcv_mode_enum;
            reset = 0x1;
        } wr_rcv_mode[18:18];

        enum AXI_CONFIG_exclusive_en_enum {
            DISABLED = 0 { name = "Disabled"; desc = "disabled"; };
            ENABLED = 1 { name = "Enabled"; desc = "enabled"; };
        };

        field {
            name = "exclusive_en";
            desc = "Exclusive command enable";
            sw = rw;
            hw = r;
            encode = AXI_CONFIG_exclusive_en_enum;
            reset = 0x1;
        } exclusive_en[17:17];

        enum AXI_CONFIG_rd_wrap_split_en_enum {
            NOT_SPLIT = 0 { name = "Not Split"; desc = "not split"; };
            SPLIT = 1 { name = "Split"; desc = "split"; };
        };

        field {
            name = "rd_wrap_split_en";
            desc = "WRAP read command split enable";
            sw = rw;
            hw = r;
            encode = AXI_CONFIG_rd_wrap_split_en_enum;
            reset = 0x0;
        } rd_wrap_split_en[16:16];

        enum AXI_CONFIG_bank_width_enum {
            V_256_BITS = 8 { name = "V 256 Bits"; desc = "256 bits"; };
            V_512_BITS = 9 { name = "V 512 Bits"; desc = "512 bits"; };
            V_1_KB = 10 { name = "V 1 Kb"; desc = "1 KB"; };
            V_2_KB = 11 { name = "V 2 Kb"; desc = "2 KB"; };
            V_4_KB = 12 { name = "V 4 Kb"; desc = "4 KB"; };
            V_8_KB = 13 { name = "V 8 Kb"; desc = "8 KB"; };
            V_16_KB = 14 { name = "V 16 Kb"; desc = "16 KB"; };
            V_32_KB_OTHER = 15 { name = "V 32 Kb Other"; desc = "32 KB Other values: reserved For example, if the column is 10 for a 32-bit DDR, the bank width is calculated as follows: bank_width = (32/8) x (2^10) = 4 KB"; };
        };

        field {
            name = "bank_width";
            desc = "Bank bit width";
            sw = rw;
            hw = r;
            encode = AXI_CONFIG_bank_width_enum;
            reset = 0xC;
        } bank_width[3:0];
    } AXI_CONFIG @ 0x0;

    reg {
        name = "DDRC clock gating configuration register";
        desc = "AXI_CKGCFG is a DDRC clock gating configuration register.

The bit diagram and the Total Reset Value (0xFFFFFFFF) show every reserved bit as 1; the reserved bits are modelled as `reserved_*` fields so that the register reset matches the data sheet.

Data sheet 4.1.5 AXI_CKGCFG (offset 0x4, printed page 4-16, dump line 32481).";

        field {
            name = "reserved_31_29";
            desc = "Reserved in the data sheet bit table, but the data sheet Total Reset Value has non-zero bits here (reset 0x7). Modelled so that the register reset matches the data sheet.";
            sw = rw;
            hw = r;
            reset = 0x7;
        } reserved_31_29[31:29];

        enum AXI_CKGCFG_sta_ckg_pub0_enum {
            DISABLED = 0 { name = "Disabled"; desc = "disabled"; };
            ENABLED = 1 { name = "Enabled"; desc = "enabled"; };
        };

        field {
            name = "sta_ckg_pub0";
            desc = "Static clock gating for PUB0";
            sw = rw;
            hw = r;
            encode = AXI_CKGCFG_sta_ckg_pub0_enum;
            reset = 0x1;
        } sta_ckg_pub0[28:28];

        field {
            name = "reserved_27_25";
            desc = "Reserved in the data sheet bit table, but the data sheet Total Reset Value has non-zero bits here (reset 0x7). Modelled so that the register reset matches the data sheet.";
            sw = rw;
            hw = r;
            reset = 0x7;
        } reserved_27_25[27:25];

        enum AXI_CKGCFG_sta_ckg_dmc0_enum {
            DISABLED = 0 { name = "Disabled"; desc = "disabled"; };
            ENABLED = 1 { name = "Enabled"; desc = "enabled"; };
        };

        field {
            name = "sta_ckg_dmc0";
            desc = "Dynamic clock gating for DMC0";
            sw = rw;
            hw = r;
            encode = AXI_CKGCFG_sta_ckg_dmc0_enum;
            reset = 0x1;
        } sta_ckg_dmc0[24:24];

        field {
            name = "reserved_23_21";
            desc = "Reserved in the data sheet bit table, but the data sheet Total Reset Value has non-zero bits here (reset 0x7). Modelled so that the register reset matches the data sheet.";
            sw = r;
            hw = w;
            reset = 0x7;
        } reserved_23_21[23:21];

        enum AXI_CKGCFG_sta_ckg_apb_enum {
            DISABLED = 0 { name = "Disabled"; desc = "disabled"; };
            ENABLED = 1 { name = "Enabled"; desc = "enabled"; };
        };

        field {
            name = "sta_ckg_apb";
            desc = "Static clock gating for the register configuration module";
            sw = rw;
            hw = r;
            encode = AXI_CKGCFG_sta_ckg_apb_enum;
            reset = 0x1;
        } sta_ckg_apb[20:20];

        field {
            name = "reserved_19_17";
            desc = "Reserved in the data sheet bit table, but the data sheet Total Reset Value has non-zero bits here (reset 0x7). Modelled so that the register reset matches the data sheet.";
            sw = r;
            hw = w;
            reset = 0x7;
        } reserved_19_17[19:17];

        enum AXI_CKGCFG_dyn_ckg_rdr_enum {
            CLOCK_ALWAYS_ENABLED = 0 { name = "Clock Always Enabled"; desc = "The clock is always enabled."; };
            CLOCK_GATING_AUTOMATIC = 1 { name = "Clock Gating Automatic"; desc = "Clock gating is automatic when the module is idle."; };
        };

        field {
            name = "dyn_ckg_rdr";
            desc = "Dynamic clock gating for the REORDER module";
            sw = rw;
            hw = r;
            encode = AXI_CKGCFG_dyn_ckg_rdr_enum;
            reset = 0x1;
        } dyn_ckg_rdr[16:16];

        field {
            name = "reserved_15_7";
            desc = "Reserved in the data sheet bit table, but the data sheet Total Reset Value has non-zero bits here (reset 0x1FF). Modelled so that the register reset matches the data sheet.";
            sw = rw;
            hw = r;
            reset = 0x1FF;
        } reserved_15_7[15:7];

        enum AXI_CKGCFG_dyn_ckg_axi6_enum {
            CLOCK_ALWAYS_ENABLED = 0 { name = "Clock Always Enabled"; desc = "The clock is always enabled."; };
            CLOCK_GATING_AUTOMATIC = 1 { name = "Clock Gating Automatic"; desc = "Clock gating is automatic when the AXI module is idle."; };
        };

        field {
            name = "dyn_ckg_axi6";
            desc = "Dynamic clock gating for AXI port 6";
            sw = rw;
            hw = r;
            encode = AXI_CKGCFG_dyn_ckg_axi6_enum;
            reset = 0x1;
        } dyn_ckg_axi6[6:6];

        enum AXI_CKGCFG_dyn_ckg_axi5_enum {
            CLOCK_ALWAYS_ENABLED = 0 { name = "Clock Always Enabled"; desc = "The clock is always enabled."; };
            CLOCK_GATING_AUTOMATIC = 1 { name = "Clock Gating Automatic"; desc = "Clock gating is automatic when the AXI module is idle."; };
        };

        field {
            name = "dyn_ckg_axi5";
            desc = "Dynamic clock gating for AXI port 5";
            sw = rw;
            hw = r;
            encode = AXI_CKGCFG_dyn_ckg_axi5_enum;
            reset = 0x1;
        } dyn_ckg_axi5[5:5];

        enum AXI_CKGCFG_dyn_ckg_axi4_enum {
            CLOCK_ALWAYS_ENABLED = 0 { name = "Clock Always Enabled"; desc = "The clock is always enabled."; };
            CLOCK_GATING_AUTOMATIC = 1 { name = "Clock Gating Automatic"; desc = "Clock gating is automatic when the AXI module is idle."; };
        };

        field {
            name = "dyn_ckg_axi4";
            desc = "Dynamic clock gating for AXI port 4";
            sw = rw;
            hw = r;
            encode = AXI_CKGCFG_dyn_ckg_axi4_enum;
            reset = 0x1;
        } dyn_ckg_axi4[4:4];

        enum AXI_CKGCFG_dyn_ckg_axi3_enum {
            CLOCK_ALWAYS_ENABLED = 0 { name = "Clock Always Enabled"; desc = "The clock is always enabled."; };
            CLOCK_GATING_AUTOMATIC = 1 { name = "Clock Gating Automatic"; desc = "Clock gating is automatic when the AXI module is idle."; };
        };

        field {
            name = "dyn_ckg_axi3";
            desc = "Dynamic clock gating for AXI port 3";
            sw = rw;
            hw = r;
            encode = AXI_CKGCFG_dyn_ckg_axi3_enum;
            reset = 0x1;
        } dyn_ckg_axi3[3:3];

        enum AXI_CKGCFG_dyn_ckg_axi2_enum {
            CLOCK_ALWAYS_ENABLED = 0 { name = "Clock Always Enabled"; desc = "The clock is always enabled."; };
            CLOCK_GATING_AUTOMATIC = 1 { name = "Clock Gating Automatic"; desc = "Clock gating is automatic when the AXI module is idle."; };
        };

        field {
            name = "dyn_ckg_axi2";
            desc = "Dynamic clock gating for AXI port 2";
            sw = rw;
            hw = r;
            encode = AXI_CKGCFG_dyn_ckg_axi2_enum;
            reset = 0x1;
        } dyn_ckg_axi2[2:2];

        enum AXI_CKGCFG_dyn_ckg_axi1_enum {
            CLOCK_ALWAYS_ENABLED = 0 { name = "Clock Always Enabled"; desc = "The clock is always enabled."; };
            CLOCK_GATING_AUTOMATIC = 1 { name = "Clock Gating Automatic"; desc = "Clock gating is automatic when the AXI module is idle."; };
        };

        field {
            name = "dyn_ckg_axi1";
            desc = "Dynamic clock gating for AXI port 1";
            sw = rw;
            hw = r;
            encode = AXI_CKGCFG_dyn_ckg_axi1_enum;
            reset = 0x1;
        } dyn_ckg_axi1[1:1];

        enum AXI_CKGCFG_dyn_ckg_axi0_enum {
            CLOCK_ALWAYS_ENABLED = 0 { name = "Clock Always Enabled"; desc = "The clock is always enabled."; };
            CLOCK_GATING_AUTOMATIC = 1 { name = "Clock Gating Automatic"; desc = "Clock gating is automatic when the AXI module is idle."; };
        };

        field {
            name = "dyn_ckg_axi0";
            desc = "Dynamic clock gating for AXI port 0";
            sw = rw;
            hw = r;
            encode = AXI_CKGCFG_dyn_ckg_axi0_enum;
            reset = 0x1;
        } dyn_ckg_axi0[0:0];
    } AXI_CKGCFG @ 0x4;

    reg {
        name = "DDRC interface status register";
        desc = "AXI_STATUS is a DDRC interface status register.

Data sheet 4.1.5 AXI_STATUS (offset 0x1C, printed page 4-17, dump line 32556).";

        enum AXI_STATUS_axist6_enum {
            INTERFACE_IDLE = 0 { name = "Interface Idle"; desc = "The interface is idle."; };
            COMMAND_BEING_EXECUTED = 1 { name = "Command Being Executed"; desc = "A command is being executed."; };
        };

        field {
            name = "axist6";
            desc = "Status of controller bus interface 6";
            sw = r;
            hw = w;
            encode = AXI_STATUS_axist6_enum;
            reset = 0x0;
        } axist6[6:6];

        enum AXI_STATUS_axist5_enum {
            INTERFACE_IDLE = 0 { name = "Interface Idle"; desc = "The interface is idle."; };
            COMMAND_BEING_EXECUTED = 1 { name = "Command Being Executed"; desc = "A command is being executed."; };
        };

        field {
            name = "axist5";
            desc = "Status of controller bus interface 5";
            sw = r;
            hw = w;
            encode = AXI_STATUS_axist5_enum;
            reset = 0x0;
        } axist5[5:5];

        enum AXI_STATUS_axist4_enum {
            INTERFACE_IDLE = 0 { name = "Interface Idle"; desc = "The interface is idle."; };
            COMMAND_BEING_EXECUTED = 1 { name = "Command Being Executed"; desc = "A command is being executed."; };
        };

        field {
            name = "axist4";
            desc = "Status of controller bus interface 4";
            sw = r;
            hw = w;
            encode = AXI_STATUS_axist4_enum;
            reset = 0x0;
        } axist4[4:4];

        enum AXI_STATUS_axist3_enum {
            INTERFACE_IDLE = 0 { name = "Interface Idle"; desc = "The interface is idle."; };
            COMMAND_BEING_EXECUTED = 1 { name = "Command Being Executed"; desc = "A command is being executed."; };
        };

        field {
            name = "axist3";
            desc = "Status of controller bus interface 3";
            sw = r;
            hw = w;
            encode = AXI_STATUS_axist3_enum;
            reset = 0x0;
        } axist3[3:3];

        enum AXI_STATUS_axist2_enum {
            INTERFACE_IDLE = 0 { name = "Interface Idle"; desc = "The interface is idle."; };
            COMMAND_BEING_EXECUTED = 1 { name = "Command Being Executed"; desc = "A command is being executed."; };
        };

        field {
            name = "axist2";
            desc = "Status of controller bus interface 2";
            sw = r;
            hw = w;
            encode = AXI_STATUS_axist2_enum;
            reset = 0x0;
        } axist2[2:2];

        enum AXI_STATUS_axist1_enum {
            INTERFACE_IDLE = 0 { name = "Interface Idle"; desc = "The interface is idle."; };
            COMMAND_BEING_EXECUTED = 1 { name = "Command Being Executed"; desc = "A command is being executed."; };
        };

        field {
            name = "axist1";
            desc = "Status of controller bus interface 1";
            sw = r;
            hw = w;
            encode = AXI_STATUS_axist1_enum;
            reset = 0x0;
        } axist1[1:1];

        enum AXI_STATUS_axist0_enum {
            INTERFACE_IDLE = 0 { name = "Interface Idle"; desc = "The interface is idle."; };
            COMMAND_BEING_EXECUTED = 1 { name = "Command Being Executed"; desc = "A command is being executed."; };
        };

        field {
            name = "axist0";
            desc = "Status of controller bus interface 0";
            sw = r;
            hw = w;
            encode = AXI_STATUS_axist0_enum;
            reset = 0x0;
        } axist0[0:0];
    } AXI_STATUS @ 0x1C;

    reg {
        name = "MDDRC channel configuration register 0";
        desc = "AXI_CHCCFG0 is MDDRC channel configuration register 0.

Data sheet 4.1.5 AXI_CHCFG0 (offset 0x20, printed page 4-18, dump line 32607).";

        enum AXI_CHCFG0_ch_addr_msk_idx_enum {
            ADDR_ADDR_WIDTH = 0 { name = "Addr Addr Width"; desc = "addr[ADDR_WIDTH - 1: ADDR_WIDTH - 4]"; };
            ADDR_ADDR_WIDTH_2 = 1 { name = "Addr Addr Width 2"; desc = "addr[ADDR_WIDTH - 2: ADDR_WIDTH - 5]"; };
            ADDR_ADDR_WIDTH_3 = 2 { name = "Addr Addr Width 3"; desc = "addr[ADDR_WIDTH - 3: ADDR_WIDTH - 6]"; };
            ADDR_ADDR_WIDTH_4 = 3 { name = "Addr Addr Width 4"; desc = "addr[ADDR_WIDTH - 4: ADDR_WIDTH - 7]"; };
            ADDR_ADDR_WIDTH_5 = 4 { name = "Addr Addr Width 5"; desc = "addr[ADDR_WIDTH - 5: ADDR_WIDTH - 8]"; };
            ADDR_ADDR_WIDTH_6 = 5 { name = "Addr Addr Width 6"; desc = "addr[ADDR_WIDTH - 6: ADDR_WIDTH - 9]"; };
            ADDR_ADDR_WIDTH_7 = 6 { name = "Addr Addr Width 7"; desc = "addr[ADDR_WIDTH - 7: ADDR_WIDTH - 10]"; };
            ADDR_ADDR_WIDTH_8 = 7 { name = "Addr Addr Width 8"; desc = "addr[ADDR_WIDTH - 8: ADDR_WIDTH - 11] ADDR_WIDTH: bit width of the system address (32 bits to 40 bits) Prevent upper-bit addresses from being wrapped. For example, when the address bit width is 32 bits, if it is set to 3, addr[31:29] must be fixed."; };
        };

        field {
            name = "ch_addr_msk_idx";
            desc = "Sequence number of mask for the address space index Four consecutive bits in the address are obtained for searching the channel configuration table.";
            sw = rw;
            hw = r;
            encode = AXI_CHCFG0_ch_addr_msk_idx_enum;
            reset = 0x0;
        } ch_addr_msk_idx[2:0];
    } AXI_CHCFG0 @ 0x20;

    reg {
        name = "MDDRC channel configuration register 1";
        desc = "AXI_CHCCFG1 is MDDRC channel configuration register 1.

Data sheet 4.1.5 AXI_CHCFG1 (offset 0x24, printed page 4-19, dump line 32660).";

        field {
            name = "ch_start15";
            desc = "Channel configuration table, start channel of address space 15 0-3 correspond to channels 0-3.";
            sw = rw;
            hw = r;
            reset = 0x0;
        } ch_start15[31:30];

        field {
            name = "ch_start14";
            desc = "Channel configuration table, start channel of address space 14 0-3 correspond to channels 0-3.";
            sw = rw;
            hw = r;
            reset = 0x0;
        } ch_start14[29:28];

        field {
            name = "ch_start13";
            desc = "Channel configuration table, start channel of address space 13 0-3 correspond to channels 0-3.";
            sw = rw;
            hw = r;
            reset = 0x0;
        } ch_start13[27:26];

        field {
            name = "ch_start12";
            desc = "Channel configuration table, start channel of address space 12 0-3 correspond to channels 0-3.";
            sw = rw;
            hw = r;
            reset = 0x0;
        } ch_start12[25:24];

        field {
            name = "ch_start11";
            desc = "Channel configuration table, start channel of address space 11 0-3 correspond to channels 0-3.";
            sw = rw;
            hw = r;
            reset = 0x0;
        } ch_start11[23:22];

        field {
            name = "ch_start10";
            desc = "Channel configuration table, start channel of address space 10 0-3 correspond to channels 0-3.";
            sw = rw;
            hw = r;
            reset = 0x0;
        } ch_start10[21:20];

        field {
            name = "ch_start9";
            desc = "Channel configuration table, start channel of address space 9 0-3 correspond to channels 0-3.";
            sw = rw;
            hw = r;
            reset = 0x0;
        } ch_start9[19:18];

        field {
            name = "ch_start8";
            desc = "Channel configuration table, start channel of address space 8 0-3 correspond to channels 0-3.";
            sw = rw;
            hw = r;
            reset = 0x0;
        } ch_start8[17:16];

        field {
            name = "ch_start7";
            desc = "Channel configuration table, start channel of address space 7 0-3 correspond to channels 0-3.";
            sw = rw;
            hw = r;
            reset = 0x0;
        } ch_start7[15:14];

        field {
            name = "ch_start6";
            desc = "Channel configuration table, start channel of address space 6 0-3 correspond to channels 0-3.";
            sw = rw;
            hw = r;
            reset = 0x0;
        } ch_start6[13:12];

        field {
            name = "ch_start5";
            desc = "Channel configuration table, start channel of address space 5 0-3 correspond to channels 0-3.";
            sw = rw;
            hw = r;
            reset = 0x0;
        } ch_start5[11:10];

        field {
            name = "ch_start4";
            desc = "Channel configuration table, start channel of address space 4 0-3 correspond to channels 0-3.";
            sw = rw;
            hw = r;
            reset = 0x0;
        } ch_start4[9:8];

        field {
            name = "ch_start3";
            desc = "Channel configuration table, start channel of address space 3 0-3 correspond to channels 0-3.";
            sw = rw;
            hw = r;
            reset = 0x0;
        } ch_start3[7:6];

        field {
            name = "ch_start2";
            desc = "Channel configuration table, start channel of address space 2 0-3 correspond to channels 0-3.";
            sw = rw;
            hw = r;
            reset = 0x0;
        } ch_start2[5:4];

        field {
            name = "ch_start1";
            desc = "Channel configuration table, start channel of address space 1 0-3 correspond to channels 0-3.";
            sw = rw;
            hw = r;
            reset = 0x0;
        } ch_start1[3:2];

        field {
            name = "ch_start0";
            desc = "Channel configuration table, start channel of address space 0 0-3 correspond to channels 0-3.";
            sw = rw;
            hw = r;
            reset = 0x0;
        } ch_start0[1:0];
    } AXI_CHCFG1 @ 0x24;

    reg {
        name = "MDDRC channel configuration register 2";
        desc = "AXI_CHCCFG2 is MDDRC channel configuration register 2.

Data sheet 4.1.5 AXI_CHCFG2 (offset 0x28, printed page 4-21, dump line 32747).";

        enum AXI_CHCFG2_ch_mode15_enum {
            ADDRESS_INDEPENDENT = 0 { name = "Address Independent"; desc = "address-independent"; };
            RESERVED = 1 { name = "Reserved"; desc = "reserved"; };
            DUAL_CHANNEL_INTERLEAVED = 2 { name = "Dual Channel Interleaved"; desc = "dual-channel-interleaved"; };
            QUAD_CHANNEL_INTERLEAVED = 3 { name = "Quad Channel Interleaved"; desc = "quad-channel-interleaved"; };
        };

        field {
            name = "ch_mode15";
            desc = "Channel configuration table, channel mode of address space 15";
            sw = rw;
            hw = r;
            encode = AXI_CHCFG2_ch_mode15_enum;
            reset = 0x0;
        } ch_mode15[31:30];

        enum AXI_CHCFG2_ch_mode14_enum {
            ADDRESS_INDEPENDENT = 0 { name = "Address Independent"; desc = "address-independent"; };
            RESERVED = 1 { name = "Reserved"; desc = "reserved"; };
            DUAL_CHANNEL_INTERLEAVED = 2 { name = "Dual Channel Interleaved"; desc = "dual-channel-interleaved"; };
            QUAD_CHANNEL_INTERLEAVED = 3 { name = "Quad Channel Interleaved"; desc = "quad-channel-interleaved"; };
        };

        field {
            name = "ch_mode14";
            desc = "Channel configuration table, channel mode of address space 14";
            sw = rw;
            hw = r;
            encode = AXI_CHCFG2_ch_mode14_enum;
            reset = 0x0;
        } ch_mode14[29:28];

        enum AXI_CHCFG2_ch_mode13_enum {
            ADDRESS_INDEPENDENT = 0 { name = "Address Independent"; desc = "address-independent"; };
            RESERVED = 1 { name = "Reserved"; desc = "reserved"; };
            DUAL_CHANNEL_INTERLEAVED = 2 { name = "Dual Channel Interleaved"; desc = "dual-channel-interleaved"; };
            QUAD_CHANNEL_INTERLEAVED = 3 { name = "Quad Channel Interleaved"; desc = "quad-channel-interleaved"; };
        };

        field {
            name = "ch_mode13";
            desc = "Channel configuration table, channel mode of address space 13";
            sw = rw;
            hw = r;
            encode = AXI_CHCFG2_ch_mode13_enum;
            reset = 0x0;
        } ch_mode13[27:26];

        enum AXI_CHCFG2_ch_mode12_enum {
            ADDRESS_INDEPENDENT = 0 { name = "Address Independent"; desc = "address-independent"; };
            RESERVED = 1 { name = "Reserved"; desc = "reserved"; };
            DUAL_CHANNEL_INTERLEAVED = 2 { name = "Dual Channel Interleaved"; desc = "dual-channel-interleaved"; };
            QUAD_CHANNEL_INTERLEAVED = 3 { name = "Quad Channel Interleaved"; desc = "quad-channel-interleaved"; };
        };

        field {
            name = "ch_mode12";
            desc = "Channel configuration table, channel mode of address space 12";
            sw = rw;
            hw = r;
            encode = AXI_CHCFG2_ch_mode12_enum;
            reset = 0x0;
        } ch_mode12[25:24];

        enum AXI_CHCFG2_ch_mode11_enum {
            ADDRESS_INDEPENDENT = 0 { name = "Address Independent"; desc = "address-independent"; };
            RESERVED = 1 { name = "Reserved"; desc = "reserved"; };
            DUAL_CHANNEL_INTERLEAVED = 2 { name = "Dual Channel Interleaved"; desc = "dual-channel-interleaved"; };
            QUAD_CHANNEL_INTERLEAVED = 3 { name = "Quad Channel Interleaved"; desc = "quad-channel-interleaved"; };
        };

        field {
            name = "ch_mode11";
            desc = "Channel configuration table, channel mode of address space 11";
            sw = rw;
            hw = r;
            encode = AXI_CHCFG2_ch_mode11_enum;
            reset = 0x0;
        } ch_mode11[23:22];

        enum AXI_CHCFG2_ch_mode10_enum {
            ADDRESS_INDEPENDENT = 0 { name = "Address Independent"; desc = "address-independent"; };
            RESERVED = 1 { name = "Reserved"; desc = "reserved"; };
            DUAL_CHANNEL_INTERLEAVED = 2 { name = "Dual Channel Interleaved"; desc = "dual-channel-interleaved"; };
            QUAD_CHANNEL_INTERLEAVED = 3 { name = "Quad Channel Interleaved"; desc = "quad-channel-interleaved"; };
        };

        field {
            name = "ch_mode10";
            desc = "Channel configuration table, channel mode of address space 10";
            sw = rw;
            hw = r;
            encode = AXI_CHCFG2_ch_mode10_enum;
            reset = 0x0;
        } ch_mode10[21:20];

        enum AXI_CHCFG2_ch_mode9_enum {
            ADDRESS_INDEPENDENT = 0 { name = "Address Independent"; desc = "address-independent"; };
            RESERVED = 1 { name = "Reserved"; desc = "reserved"; };
            DUAL_CHANNEL_INTERLEAVED = 2 { name = "Dual Channel Interleaved"; desc = "dual-channel-interleaved"; };
            QUAD_CHANNEL_INTERLEAVED = 3 { name = "Quad Channel Interleaved"; desc = "quad-channel-interleaved"; };
        };

        field {
            name = "ch_mode9";
            desc = "Channel configuration table, channel mode of address space 9";
            sw = rw;
            hw = r;
            encode = AXI_CHCFG2_ch_mode9_enum;
            reset = 0x0;
        } ch_mode9[19:18];

        enum AXI_CHCFG2_ch_mode8_enum {
            ADDRESS_INDEPENDENT = 0 { name = "Address Independent"; desc = "address-independent"; };
            RESERVED = 1 { name = "Reserved"; desc = "reserved"; };
            DUAL_CHANNEL_INTERLEAVED = 2 { name = "Dual Channel Interleaved"; desc = "dual-channel-interleaved"; };
            QUAD_CHANNEL_INTERLEAVED = 3 { name = "Quad Channel Interleaved"; desc = "quad-channel-interleaved"; };
        };

        field {
            name = "ch_mode8";
            desc = "Channel configuration table, channel mode of address space 8";
            sw = rw;
            hw = r;
            encode = AXI_CHCFG2_ch_mode8_enum;
            reset = 0x0;
        } ch_mode8[17:16];

        enum AXI_CHCFG2_ch_mode7_enum {
            ADDRESS_INDEPENDENT = 0 { name = "Address Independent"; desc = "address-independent"; };
            RESERVED = 1 { name = "Reserved"; desc = "reserved"; };
            DUAL_CHANNEL_INTERLEAVED = 2 { name = "Dual Channel Interleaved"; desc = "dual-channel-interleaved"; };
            QUAD_CHANNEL_INTERLEAVED = 3 { name = "Quad Channel Interleaved"; desc = "quad-channel-interleaved"; };
        };

        field {
            name = "ch_mode7";
            desc = "Channel configuration table, channel mode of address space 7";
            sw = rw;
            hw = r;
            encode = AXI_CHCFG2_ch_mode7_enum;
            reset = 0x0;
        } ch_mode7[15:14];

        enum AXI_CHCFG2_ch_mode6_enum {
            ADDRESS_INDEPENDENT = 0 { name = "Address Independent"; desc = "address-independent"; };
            RESERVED = 1 { name = "Reserved"; desc = "reserved"; };
            DUAL_CHANNEL_INTERLEAVED = 2 { name = "Dual Channel Interleaved"; desc = "dual-channel-interleaved"; };
            QUAD_CHANNEL_INTERLEAVED = 3 { name = "Quad Channel Interleaved"; desc = "quad-channel-interleaved"; };
        };

        field {
            name = "ch_mode6";
            desc = "Channel configuration table, channel mode of address space 6";
            sw = rw;
            hw = r;
            encode = AXI_CHCFG2_ch_mode6_enum;
            reset = 0x0;
        } ch_mode6[13:12];

        enum AXI_CHCFG2_ch_mode5_enum {
            ADDRESS_INDEPENDENT = 0 { name = "Address Independent"; desc = "address-independent"; };
            RESERVED = 1 { name = "Reserved"; desc = "reserved"; };
            DUAL_CHANNEL_INTERLEAVED = 2 { name = "Dual Channel Interleaved"; desc = "dual-channel-interleaved"; };
            QUAD_CHANNEL_INTERLEAVED = 3 { name = "Quad Channel Interleaved"; desc = "quad-channel-interleaved"; };
        };

        field {
            name = "ch_mode5";
            desc = "Channel configuration table, channel mode of address space 5";
            sw = rw;
            hw = r;
            encode = AXI_CHCFG2_ch_mode5_enum;
            reset = 0x0;
        } ch_mode5[11:10];

        enum AXI_CHCFG2_ch_mode4_enum {
            ADDRESS_INDEPENDENT = 0 { name = "Address Independent"; desc = "address-independent"; };
            RESERVED = 1 { name = "Reserved"; desc = "reserved"; };
            DUAL_CHANNEL_INTERLEAVED = 2 { name = "Dual Channel Interleaved"; desc = "dual-channel-interleaved"; };
            QUAD_CHANNEL_INTERLEAVED = 3 { name = "Quad Channel Interleaved"; desc = "quad-channel-interleaved"; };
        };

        field {
            name = "ch_mode4";
            desc = "Channel configuration table, channel mode of address space 4";
            sw = rw;
            hw = r;
            encode = AXI_CHCFG2_ch_mode4_enum;
            reset = 0x0;
        } ch_mode4[9:8];

        enum AXI_CHCFG2_ch_mode3_enum {
            ADDRESS_INDEPENDENT = 0 { name = "Address Independent"; desc = "address-independent"; };
            RESERVED = 1 { name = "Reserved"; desc = "reserved"; };
            DUAL_CHANNEL_INTERLEAVED = 2 { name = "Dual Channel Interleaved"; desc = "dual-channel-interleaved"; };
            QUAD_CHANNEL_INTERLEAVED = 3 { name = "Quad Channel Interleaved"; desc = "quad-channel-interleaved"; };
        };

        field {
            name = "ch_mode3";
            desc = "Channel configuration table, channel mode of address space 3";
            sw = rw;
            hw = r;
            encode = AXI_CHCFG2_ch_mode3_enum;
            reset = 0x0;
        } ch_mode3[7:6];

        enum AXI_CHCFG2_ch_mode2_enum {
            ADDRESS_INDEPENDENT = 0 { name = "Address Independent"; desc = "address-independent"; };
            RESERVED = 1 { name = "Reserved"; desc = "reserved"; };
            DUAL_CHANNEL_INTERLEAVED = 2 { name = "Dual Channel Interleaved"; desc = "dual-channel-interleaved"; };
            QUAD_CHANNEL_INTERLEAVED = 3 { name = "Quad Channel Interleaved"; desc = "quad-channel-interleaved"; };
        };

        field {
            name = "ch_mode2";
            desc = "Channel configuration table, channel mode of address space 2";
            sw = rw;
            hw = r;
            encode = AXI_CHCFG2_ch_mode2_enum;
            reset = 0x0;
        } ch_mode2[5:4];

        enum AXI_CHCFG2_ch_mode1_enum {
            ADDRESS_INDEPENDENT = 0 { name = "Address Independent"; desc = "address-independent"; };
            RESERVED = 1 { name = "Reserved"; desc = "reserved"; };
            DUAL_CHANNEL_INTERLEAVED = 2 { name = "Dual Channel Interleaved"; desc = "dual-channel-interleaved"; };
            QUAD_CHANNEL_INTERLEAVED = 3 { name = "Quad Channel Interleaved"; desc = "quad-channel-interleaved"; };
        };

        field {
            name = "ch_mode1";
            desc = "Channel configuration table, channel mode of address space 1";
            sw = rw;
            hw = r;
            encode = AXI_CHCFG2_ch_mode1_enum;
            reset = 0x0;
        } ch_mode1[3:2];

        enum AXI_CHCFG2_ch_mode0_enum {
            ADDRESS_INDEPENDENT = 0 { name = "Address Independent"; desc = "address-independent"; };
            RESERVED = 1 { name = "Reserved"; desc = "reserved"; };
            DUAL_CHANNEL_INTERLEAVED = 2 { name = "Dual Channel Interleaved"; desc = "dual-channel-interleaved"; };
            QUAD_CHANNEL_INTERLEAVED = 3 { name = "Quad Channel Interleaved"; desc = "quad-channel-interleaved"; };
        };

        field {
            name = "ch_mode0";
            desc = "Channel configuration table, channel mode of address space 0";
            sw = rw;
            hw = r;
            encode = AXI_CHCFG2_ch_mode0_enum;
            reset = 0x0;
        } ch_mode0[1:0];
    } AXI_CHCFG2 @ 0x28;

    reg {
        name = "MDDRC channel configuration register 3";
        desc = "AXI_CHCCFG3 is MDDRC channel configuration register 3.

Data sheet 4.1.5 AXI_CHCFG3 (offset 0x2C, printed page 4-23, dump line 32872).";

        enum AXI_CHCFG3_ch_invld15_enum {
            CURRENT_ADDRESS_SPACE = 0 { name = "Current Address Space"; desc = "The current address space is valid."; };
            CURRENT_ADDRESS_SPACE_2 = 1 { name = "Current Address Space 2"; desc = "The current address space is invalid."; };
        };

        field {
            name = "ch_invld15";
            desc = "Channel configuration table, address space 15 mask enable";
            sw = rw;
            hw = r;
            encode = AXI_CHCFG3_ch_invld15_enum;
            reset = 0x0;
        } ch_invld15[15:15];

        enum AXI_CHCFG3_ch_invld14_enum {
            CURRENT_ADDRESS_SPACE = 0 { name = "Current Address Space"; desc = "The current address space is valid."; };
            CURRENT_ADDRESS_SPACE_2 = 1 { name = "Current Address Space 2"; desc = "The current address space is invalid."; };
        };

        field {
            name = "ch_invld14";
            desc = "Channel configuration table, address space 14 mask enable";
            sw = rw;
            hw = r;
            encode = AXI_CHCFG3_ch_invld14_enum;
            reset = 0x0;
        } ch_invld14[14:14];

        enum AXI_CHCFG3_ch_invld13_enum {
            CURRENT_ADDRESS_SPACE = 0 { name = "Current Address Space"; desc = "The current address space is valid."; };
            CURRENT_ADDRESS_SPACE_2 = 1 { name = "Current Address Space 2"; desc = "The current address space is invalid."; };
        };

        field {
            name = "ch_invld13";
            desc = "Channel configuration table, address space 13 mask enable";
            sw = rw;
            hw = r;
            encode = AXI_CHCFG3_ch_invld13_enum;
            reset = 0x0;
        } ch_invld13[13:13];

        enum AXI_CHCFG3_ch_invld12_enum {
            CURRENT_ADDRESS_SPACE = 0 { name = "Current Address Space"; desc = "The current address space is valid."; };
            CURRENT_ADDRESS_SPACE_2 = 1 { name = "Current Address Space 2"; desc = "The current address space is invalid."; };
        };

        field {
            name = "ch_invld12";
            desc = "Channel configuration table, address space 12 mask enable";
            sw = rw;
            hw = r;
            encode = AXI_CHCFG3_ch_invld12_enum;
            reset = 0x0;
        } ch_invld12[12:12];

        enum AXI_CHCFG3_ch_invld11_enum {
            CURRENT_ADDRESS_SPACE = 0 { name = "Current Address Space"; desc = "The current address space is valid."; };
            CURRENT_ADDRESS_SPACE_2 = 1 { name = "Current Address Space 2"; desc = "The current address space is invalid."; };
        };

        field {
            name = "ch_invld11";
            desc = "Channel configuration table, address space 11 mask enable";
            sw = rw;
            hw = r;
            encode = AXI_CHCFG3_ch_invld11_enum;
            reset = 0x0;
        } ch_invld11[11:11];

        enum AXI_CHCFG3_ch_invld10_enum {
            CURRENT_ADDRESS_SPACE = 0 { name = "Current Address Space"; desc = "The current address space is valid."; };
            CURRENT_ADDRESS_SPACE_2 = 1 { name = "Current Address Space 2"; desc = "The current address space is invalid."; };
        };

        field {
            name = "ch_invld10";
            desc = "Channel configuration table, address space 10 mask enable";
            sw = rw;
            hw = r;
            encode = AXI_CHCFG3_ch_invld10_enum;
            reset = 0x0;
        } ch_invld10[10:10];

        enum AXI_CHCFG3_ch_invld9_enum {
            CURRENT_ADDRESS_SPACE = 0 { name = "Current Address Space"; desc = "The current address space is valid."; };
            CURRENT_ADDRESS_SPACE_2 = 1 { name = "Current Address Space 2"; desc = "The current address space is invalid."; };
        };

        field {
            name = "ch_invld9";
            desc = "Channel configuration table, address space 9 mask enable";
            sw = rw;
            hw = r;
            encode = AXI_CHCFG3_ch_invld9_enum;
            reset = 0x0;
        } ch_invld9[9:9];

        enum AXI_CHCFG3_ch_invld8_enum {
            CURRENT_ADDRESS_SPACE = 0 { name = "Current Address Space"; desc = "The current address space is valid."; };
            CURRENT_ADDRESS_SPACE_2 = 1 { name = "Current Address Space 2"; desc = "The current address space is invalid."; };
        };

        field {
            name = "ch_invld8";
            desc = "Channel configuration table, address space 8 mask enable";
            sw = rw;
            hw = r;
            encode = AXI_CHCFG3_ch_invld8_enum;
            reset = 0x0;
        } ch_invld8[8:8];

        enum AXI_CHCFG3_ch_invld7_enum {
            CURRENT_ADDRESS_SPACE = 0 { name = "Current Address Space"; desc = "The current address space is valid."; };
            CURRENT_ADDRESS_SPACE_2 = 1 { name = "Current Address Space 2"; desc = "The current address space is invalid."; };
        };

        field {
            name = "ch_invld7";
            desc = "Channel configuration table, address space 7 mask enable";
            sw = rw;
            hw = r;
            encode = AXI_CHCFG3_ch_invld7_enum;
            reset = 0x0;
        } ch_invld7[7:7];

        enum AXI_CHCFG3_ch_invld6_enum {
            CURRENT_ADDRESS_SPACE = 0 { name = "Current Address Space"; desc = "The current address space is valid."; };
            CURRENT_ADDRESS_SPACE_2 = 1 { name = "Current Address Space 2"; desc = "The current address space is invalid."; };
        };

        field {
            name = "ch_invld6";
            desc = "Channel configuration table, address space 6 mask enable";
            sw = rw;
            hw = r;
            encode = AXI_CHCFG3_ch_invld6_enum;
            reset = 0x0;
        } ch_invld6[6:6];

        enum AXI_CHCFG3_ch_invld5_enum {
            CURRENT_ADDRESS_SPACE = 0 { name = "Current Address Space"; desc = "The current address space is valid."; };
            CURRENT_ADDRESS_SPACE_2 = 1 { name = "Current Address Space 2"; desc = "The current address space is invalid."; };
        };

        field {
            name = "ch_invld5";
            desc = "Channel configuration table, address space 5 mask enable";
            sw = rw;
            hw = r;
            encode = AXI_CHCFG3_ch_invld5_enum;
            reset = 0x0;
        } ch_invld5[5:5];

        enum AXI_CHCFG3_ch_invld4_enum {
            CURRENT_ADDRESS_SPACE = 0 { name = "Current Address Space"; desc = "The current address space is valid."; };
            CURRENT_ADDRESS_SPACE_2 = 1 { name = "Current Address Space 2"; desc = "The current address space is invalid."; };
        };

        field {
            name = "ch_invld4";
            desc = "Channel configuration table, address space 4 mask enable";
            sw = rw;
            hw = r;
            encode = AXI_CHCFG3_ch_invld4_enum;
            reset = 0x0;
        } ch_invld4[4:4];

        enum AXI_CHCFG3_ch_invld3_enum {
            CURRENT_ADDRESS_SPACE = 0 { name = "Current Address Space"; desc = "The current address space is valid."; };
            CURRENT_ADDRESS_SPACE_2 = 1 { name = "Current Address Space 2"; desc = "The current address space is invalid."; };
        };

        field {
            name = "ch_invld3";
            desc = "Channel configuration table, address space 3 mask enable";
            sw = rw;
            hw = r;
            encode = AXI_CHCFG3_ch_invld3_enum;
            reset = 0x0;
        } ch_invld3[3:3];

        enum AXI_CHCFG3_ch_invld2_enum {
            CURRENT_ADDRESS_SPACE = 0 { name = "Current Address Space"; desc = "The current address space is valid."; };
            CURRENT_ADDRESS_SPACE_2 = 1 { name = "Current Address Space 2"; desc = "The current address space is invalid."; };
        };

        field {
            name = "ch_invld2";
            desc = "Channel configuration table, address space 2 mask enable";
            sw = rw;
            hw = r;
            encode = AXI_CHCFG3_ch_invld2_enum;
            reset = 0x0;
        } ch_invld2[2:2];

        enum AXI_CHCFG3_ch_invld1_enum {
            CURRENT_ADDRESS_SPACE = 0 { name = "Current Address Space"; desc = "The current address space is valid."; };
            CURRENT_ADDRESS_SPACE_2 = 1 { name = "Current Address Space 2"; desc = "The current address space is invalid."; };
        };

        field {
            name = "ch_invld1";
            desc = "Channel configuration table, address space 1 mask enable";
            sw = rw;
            hw = r;
            encode = AXI_CHCFG3_ch_invld1_enum;
            reset = 0x0;
        } ch_invld1[1:1];

        enum AXI_CHCFG3_ch_invld0_enum {
            CURRENT_ADDRESS_SPACE = 0 { name = "Current Address Space"; desc = "The current address space is valid."; };
            CURRENT_ADDRESS_SPACE_2 = 1 { name = "Current Address Space 2"; desc = "The current address space is invalid."; };
        };

        field {
            name = "ch_invld0";
            desc = "Channel configuration table, address space 0 mask enable";
            sw = rw;
            hw = r;
            encode = AXI_CHCFG3_ch_invld0_enum;
            reset = 0x0;
        } ch_invld0[0:0];
    } AXI_CHCFG3 @ 0x2C;

    reg {
        name = "MDDRC channel configuration register 4";
        desc = "AXI_CHCCFG4 is MDDRC channel configuration register 4.

Data sheet 4.1.5 AXI_CHCFG4 (offset 0x30, printed page 4-25, dump line 32967).";

        field {
            name = "ch_sect7";
            desc = "Channel configuration table, position of the channel section to which address space 7 is mapped";
            sw = rw;
            hw = r;
            reset = 0x7;
        } ch_sect7[31:28];

        field {
            name = "ch_sect6";
            desc = "Channel configuration table, position of the channel section to which address space 6 is mapped";
            sw = rw;
            hw = r;
            reset = 0x6;
        } ch_sect6[27:24];

        field {
            name = "ch_sect5";
            desc = "Channel configuration table, position of the channel section to which address space 5 is mapped";
            sw = rw;
            hw = r;
            reset = 0x5;
        } ch_sect5[23:20];

        field {
            name = "ch_sect4";
            desc = "Channel configuration table, position of the channel section to which address space 4 is mapped";
            sw = rw;
            hw = r;
            reset = 0x4;
        } ch_sect4[19:16];

        field {
            name = "ch_sect3";
            desc = "Channel configuration table, position of the channel section to which address space 3 is mapped";
            sw = rw;
            hw = r;
            reset = 0x3;
        } ch_sect3[15:12];

        field {
            name = "ch_sect2";
            desc = "Channel configuration table, position of the channel section to which address space 2 is mapped";
            sw = rw;
            hw = r;
            reset = 0x2;
        } ch_sect2[11:8];

        field {
            name = "ch_sect1";
            desc = "Channel configuration table, position of the channel section to which address space 1 is mapped";
            sw = rw;
            hw = r;
            reset = 0x1;
        } ch_sect1[7:4];

        field {
            name = "ch_sect0";
            desc = "Channel configuration table, position of the channel section to which address space 0 is mapped";
            sw = rw;
            hw = r;
            reset = 0x0;
        } ch_sect0[3:0];
    } AXI_CHCFG4 @ 0x30;

    reg {
        name = "MDDRC channel configuration register 5";
        desc = "AXI_CHCCFG5 is MDDRC channel configuration register 5.

Data sheet 4.1.5 AXI_CHCFG5 (offset 0x34, printed page 4-26, dump line 33015).";

        field {
            name = "ch_sect15";
            desc = "Channel configuration table, position of the channel section to which address space 15 is mapped";
            sw = rw;
            hw = r;
            reset = 0xF;
        } ch_sect15[31:28];

        field {
            name = "ch_sect14";
            desc = "Channel configuration table, position of the channel section to which address space 14 is mapped";
            sw = rw;
            hw = r;
            reset = 0xE;
        } ch_sect14[27:24];

        field {
            name = "ch_sect13";
            desc = "Channel configuration table, position of the channel section to which address space 13 is mapped";
            sw = rw;
            hw = r;
            reset = 0xD;
        } ch_sect13[23:20];

        field {
            name = "ch_sect12";
            desc = "Channel configuration table, position of the channel section to which address space 12 is mapped";
            sw = rw;
            hw = r;
            reset = 0xC;
        } ch_sect12[19:16];

        field {
            name = "ch_sect11";
            desc = "Channel configuration table, position of the channel section to which address space 11 is mapped";
            sw = rw;
            hw = r;
            reset = 0xB;
        } ch_sect11[15:12];

        field {
            name = "ch_sect10";
            desc = "Channel configuration table, position of the channel section to which address space 10 is mapped";
            sw = rw;
            hw = r;
            reset = 0xA;
        } ch_sect10[11:8];

        field {
            name = "ch_sect9";
            desc = "Channel configuration table, position of the channel section to which address space 9 is mapped";
            sw = rw;
            hw = r;
            reset = 0x9;
        } ch_sect9[7:4];

        field {
            name = "ch_sect8";
            desc = "Channel configuration table, position of the channel section to which address space 8 is mapped";
            sw = rw;
            hw = r;
            reset = 0x8;
        } ch_sect8[3:0];
    } AXI_CHCFG5 @ 0x34;

    reg {
        name = "MDDRC low-power zone configuration register";
        desc = "AXI_LPCFG is a low-power zone configuration register of the MDDRC.

Data sheet 4.1.5 AXI_LPCFG (offset 0x38, printed page 4-27, dump line 33063).";

        enum AXI_LPCFG_lp_zone_size_enum {
            V_1_MB = 0x0 { name = "V 1 Mb"; desc = "1 MB"; };
            V_2_MB = 0x1 { name = "V 2 Mb"; desc = "2 MB"; };
            V_4_MB = 0x3 { name = "V 4 Mb"; desc = "4 MB"; };
            V_8_MB_IF = 0x7 { name = "V 8 Mb If"; desc = "8 MB ... If the address space where the low-power zone is located is dual-/quad-channel interleaved, the size of the low-power zone cannot exceed half or a quarter of the address space."; };
        };

        field {
            name = "lp_zone_size";
            desc = "Size of the low-power zone The zone size (in MB) equals lp_zone_size plus 1 and increases by the multiple of 2.";
            sw = rw;
            hw = r;
            encode = AXI_LPCFG_lp_zone_size_enum;
            reset = 0x0;
        } lp_zone_size[31:16];

        enum AXI_LPCFG_lp_zone_en_enum {
            DISABLED = 0 { name = "Disabled"; desc = "disabled"; };
            ENABLED = 1 { name = "Enabled"; desc = "enabled"; };
        };

        field {
            name = "lp_zone_en";
            desc = "Low-power zone enable";
            sw = rw;
            hw = r;
            encode = AXI_LPCFG_lp_zone_en_enum;
            reset = 0x0;
        } lp_zone_en[0:0];
    } AXI_LPCFG @ 0x38;

    reg {
        name = "AXI_QOSCFG0 DDRC QoS configuration register 0 ports";
        desc = "AXI_QOSCFG0 is DDRC QoS configuration register 0.

Data sheet 4.1.5 AXI_QOSCFG0 (offset 0x40, printed page 4-28, dump line 33110).

Hardware (Hi3518E V200 board, live dump 2026-11-10): ports 0-6 read 0x01001000 after the vendor register table (which writes exactly that value to ports 0-6), and the unwritten slots 7..15 at +0x1C..+0x3C read 0x01001000 as well, so the data sheet reset 0 is not what the silicon holds for the slots nobody wrote. The array is modelled with 7 elements as in the data sheet.";

        enum AXI_QOSCFG0_pri_deliver_en_enum {
            DISABLED = 0 { name = "Disabled"; desc = "disabled"; };
            ENABLED = 1 { name = "Enabled"; desc = "enabled"; };
        };

        field {
            name = "pri_deliver_en";
            desc = "Port priority deliver enable";
            sw = rw;
            hw = r;
            encode = AXI_QOSCFG0_pri_deliver_en_enum;
            reset = 0x0;
        } pri_deliver_en[31:31];

        enum AXI_QOSCFG0_push_deliver_en_enum {
            DISABLED = 0 { name = "Disabled"; desc = "disabled"; };
            ENABLED = 1 { name = "Enabled"; desc = "enabled"; };
        };

        field {
            name = "push_deliver_en";
            desc = "Push priority deliver enable";
            sw = rw;
            hw = r;
            encode = AXI_QOSCFG0_push_deliver_en_enum;
            reset = 0x0;
        } push_deliver_en[30:30];

        enum AXI_QOSCFG0_tout_map_mode_enum {
            MAPPING_MODE_SPECIFIED = 0 { name = "Mapping Mode Specified"; desc = "mapping mode specified by tout_id_map"; };
            MAPPING_MODE_SPECIFIED_2 = 1 { name = "Mapping Mode Specified 2"; desc = "mapping mode specified by the command associated signal wr(rd)_tout_sel"; };
        };

        field {
            name = "tout_map_mode";
            desc = "Timeout mapping mode of the read/write command";
            sw = rw;
            hw = r;
            encode = AXI_QOSCFG0_tout_map_mode_enum;
            reset = 0x0;
        } tout_map_mode[24:24];

        field {
            name = "tout_id_map";
            desc = "Two bits of the read/write command ID for timeout configuration id_map[7:4]: bit[1] for ID mapping id_map[3:0]: bit[0] for ID mapping For example, if ID_MAP is set to 0x32, {ID[3], ID[2]} of the read/write command ID is used for ID mapping and priority configuration. Note that the lower four bits of the read/write command ID indicate the AXI port ID. That is, read/write command ID = {Bus ID, 4-bit AXI port ID}.";
            sw = rw;
            hw = r;
            reset = 0x0;
        } tout_id_map[23:16];

        enum AXI_QOSCFG0_pri_map_mode_enum {
            MAPPING_MODE_SPECIFIED = 0 { name = "Mapping Mode Specified"; desc = "mapping mode specified by pri_id_map"; };
            QOS_MAPPING_MODE = 1 { name = "Qos Mapping Mode"; desc = "QoS mapping mode specified by using the AxQOS[2:0] signal of the AXI4 read/write command"; };
        };

        field {
            name = "pri_map_mode";
            desc = "Priority mapping mode of the read/write command";
            sw = rw;
            hw = r;
            encode = AXI_QOSCFG0_pri_map_mode_enum;
            reset = 0x0;
        } pri_map_mode[12:12];

        field {
            name = "pri_id_map";
            desc = "Three bits of the read/write command ID for QoS configuration pri_id_map[11:8]: bit[2] for ID mapping pri_id_map[7:4]: bit[1] for IP mapping pri_id_map[3:0]: bit[0] for ID mapping For example, if ID_MAP is set to 0x320, {ID[3], ID[2], ID[0]} of the read/write command ID is used for ID mapping and priority configuration. Note that the lower four bits of the read/write command ID indicate the AXI port ID. That is, read/write command ID = {Bus ID, 4-bit AXI port ID}.";
            sw = rw;
            hw = r;
            reset = 0x0;
        } pri_id_map[11:0];
    } AXI_QOSCFG0[7] @ 0x40 += 0x4;

    reg {
        name = "AXI_QOSCFG1 DDRC QoS configuration register 1 ports";
        desc = "AXI_QOSCFG1 is a DDRC QoS configuration register 1.

Data sheet 4.1.5 AXI_QOSCFG1 (offset 0x80, printed page 4-29, dump line 33186).";

        field {
            name = "wr_pri_apt";
            desc = "Write command priority adaptation cycle 0x0: disabled 0x1-0xF: (n x 16) clock cycles";
            sw = rw;
            hw = r;
            reset = 0x0;
        } wr_pri_apt[23:20];

        field {
            name = "wr_age_prd";
            desc = "Write command aging cycle 0x0: disabled 0x1-0xF: (n x 16) clock cycles";
            sw = rw;
            hw = r;
            reset = 0x0;
        } wr_age_prd[19:16];

        field {
            name = "rd_pri_apt";
            desc = "Read command priority adaptation cycle 0x0: disabled 0x1-0xF: (n x 16) clock cycles";
            sw = rw;
            hw = r;
            reset = 0x0;
        } rd_pri_apt[7:4];

        field {
            name = "rd_age_prd";
            desc = "Read command aging cycle 0x0: disabled 0x1-0xF: (n x 16) clock cycles";
            sw = rw;
            hw = r;
            reset = 0x0;
        } rd_age_prd[3:0];
    } AXI_QOSCFG1[7] @ 0x80 += 0x4;

    reg {
        name = "AXI_WRPRI DDRC write command priority ports configuration register";
        desc = "AXI_WRPRI is a DDRC write command priority configuration register.

Data sheet 4.1.5 AXI_WRPRI (offset 0xC0, printed page 4-30, dump line 33231).

Hardware (Hi3518E V200 board, live dump): ports 0-6 read 0x76543210 (the value the vendor table writes) and the never-written slots 7..15 read 0x76543210 too, so the data sheet reset 0 is not what the silicon holds there.";

        enum AXI_WRPRI_wr_pri7_enum {
            HIGHEST_PRIORITY = 0 { name = "Highest Priority"; desc = "highest priority ..."; };
            LOWEST_PRIORITY = 7 { name = "Lowest Priority"; desc = "lowest priority"; };
        };

        field {
            name = "wr_pri7";
            desc = "Priority when the write command ID mapping is 7";
            sw = rw;
            hw = r;
            encode = AXI_WRPRI_wr_pri7_enum;
            reset = 0x0;
        } wr_pri7[30:28];

        enum AXI_WRPRI_wr_pri6_enum {
            HIGHEST_PRIORITY = 0 { name = "Highest Priority"; desc = "highest priority ..."; };
            LOWEST_PRIORITY = 7 { name = "Lowest Priority"; desc = "lowest priority"; };
        };

        field {
            name = "wr_pri6";
            desc = "Priority when the write command ID mapping is 6";
            sw = rw;
            hw = r;
            encode = AXI_WRPRI_wr_pri6_enum;
            reset = 0x0;
        } wr_pri6[26:24];

        enum AXI_WRPRI_wr_pri5_enum {
            HIGHEST_PRIORITY = 0 { name = "Highest Priority"; desc = "highest priority ..."; };
            LOWEST_PRIORITY = 7 { name = "Lowest Priority"; desc = "lowest priority"; };
        };

        field {
            name = "wr_pri5";
            desc = "Priority when the write command ID mapping is 5";
            sw = rw;
            hw = r;
            encode = AXI_WRPRI_wr_pri5_enum;
            reset = 0x0;
        } wr_pri5[22:20];

        enum AXI_WRPRI_wr_pri4_enum {
            HIGHEST_PRIORITY = 0 { name = "Highest Priority"; desc = "highest priority ..."; };
            LOWEST_PRIORITY = 7 { name = "Lowest Priority"; desc = "lowest priority"; };
        };

        field {
            name = "wr_pri4";
            desc = "Priority when the write command ID mapping is 4";
            sw = rw;
            hw = r;
            encode = AXI_WRPRI_wr_pri4_enum;
            reset = 0x0;
        } wr_pri4[18:16];

        enum AXI_WRPRI_wr_pri3_enum {
            HIGHEST_PRIORITY = 0 { name = "Highest Priority"; desc = "highest priority ..."; };
            LOWEST_PRIORITY = 7 { name = "Lowest Priority"; desc = "lowest priority"; };
        };

        field {
            name = "wr_pri3";
            desc = "Priority when the write command ID mapping is 3";
            sw = rw;
            hw = r;
            encode = AXI_WRPRI_wr_pri3_enum;
            reset = 0x0;
        } wr_pri3[14:12];

        enum AXI_WRPRI_wr_pri2_enum {
            HIGHEST_PRIORITY = 0 { name = "Highest Priority"; desc = "highest priority ..."; };
            LOWEST_PRIORITY = 7 { name = "Lowest Priority"; desc = "lowest priority"; };
        };

        field {
            name = "wr_pri2";
            desc = "Priority when the write command ID mapping is 2";
            sw = rw;
            hw = r;
            encode = AXI_WRPRI_wr_pri2_enum;
            reset = 0x0;
        } wr_pri2[10:8];

        enum AXI_WRPRI_wr_pri1_enum {
            HIGHEST_PRIORITY = 0 { name = "Highest Priority"; desc = "highest priority ..."; };
            LOWEST_PRIORITY = 7 { name = "Lowest Priority"; desc = "lowest priority"; };
        };

        field {
            name = "wr_pri1";
            desc = "Priority when the write command ID mapping is 1";
            sw = rw;
            hw = r;
            encode = AXI_WRPRI_wr_pri1_enum;
            reset = 0x0;
        } wr_pri1[6:4];

        enum AXI_WRPRI_wr_pri0_enum {
            HIGHEST_PRIORITY = 0 { name = "Highest Priority"; desc = "highest priority ..."; };
            LOWEST_PRIORITY = 7 { name = "Lowest Priority"; desc = "lowest priority"; };
        };

        field {
            name = "wr_pri0";
            desc = "Priority when the write command ID mapping is 0";
            sw = rw;
            hw = r;
            encode = AXI_WRPRI_wr_pri0_enum;
            reset = 0x0;
        } wr_pri0[2:0];
    } AXI_WRPRI[7] @ 0xC0 += 0x4;

    reg {
        name = "AXI_RDPRI DDRC read command priority ports configuration register";
        desc = "AXI_RDPRI is a DDRC read command priority configuration register.

Data sheet 4.1.5 AXI_RDPRI (offset 0x100, printed page 4-31, dump line 33313).

Hardware (Hi3518E V200 board, live dump): ports 0-6 read 0x76543210 (the value the vendor table writes) and the never-written slots 7..15 read 0x76543210 too, so the data sheet reset 0 is not what the silicon holds there.";

        enum AXI_RDPRI_rd_pri7_enum {
            HIGHEST_PRIORITY = 0 { name = "Highest Priority"; desc = "highest priority ..."; };
            LOWEST_PRIORITY = 7 { name = "Lowest Priority"; desc = "lowest priority"; };
        };

        field {
            name = "rd_pri7";
            desc = "Priority when the read command ID mapping is 7";
            sw = rw;
            hw = r;
            encode = AXI_RDPRI_rd_pri7_enum;
            reset = 0x0;
        } rd_pri7[30:28];

        enum AXI_RDPRI_rd_pri6_enum {
            HIGHEST_PRIORITY = 0 { name = "Highest Priority"; desc = "highest priority ..."; };
            LOWEST_PRIORITY = 7 { name = "Lowest Priority"; desc = "lowest priority"; };
        };

        field {
            name = "rd_pri6";
            desc = "Priority when the read command ID mapping is 6";
            sw = rw;
            hw = r;
            encode = AXI_RDPRI_rd_pri6_enum;
            reset = 0x0;
        } rd_pri6[26:24];

        enum AXI_RDPRI_rd_pri5_enum {
            HIGHEST_PRIORITY = 0 { name = "Highest Priority"; desc = "highest priority ..."; };
            LOWEST_PRIORITY = 7 { name = "Lowest Priority"; desc = "lowest priority"; };
        };

        field {
            name = "rd_pri5";
            desc = "Priority when the read command ID mapping is 5";
            sw = rw;
            hw = r;
            encode = AXI_RDPRI_rd_pri5_enum;
            reset = 0x0;
        } rd_pri5[22:20];

        enum AXI_RDPRI_rd_pri4_enum {
            HIGHEST_PRIORITY = 0 { name = "Highest Priority"; desc = "highest priority ..."; };
            LOWEST_PRIORITY = 7 { name = "Lowest Priority"; desc = "lowest priority"; };
        };

        field {
            name = "rd_pri4";
            desc = "Priority when the read command ID mapping is 4";
            sw = rw;
            hw = r;
            encode = AXI_RDPRI_rd_pri4_enum;
            reset = 0x0;
        } rd_pri4[18:16];

        enum AXI_RDPRI_rd_pri3_enum {
            HIGHEST_PRIORITY = 0 { name = "Highest Priority"; desc = "highest priority ..."; };
            LOWEST_PRIORITY = 7 { name = "Lowest Priority"; desc = "lowest priority"; };
        };

        field {
            name = "rd_pri3";
            desc = "Priority when the read command ID mapping is 3";
            sw = rw;
            hw = r;
            encode = AXI_RDPRI_rd_pri3_enum;
            reset = 0x0;
        } rd_pri3[14:12];

        enum AXI_RDPRI_rd_pri2_enum {
            HIGHEST_PRIORITY = 0 { name = "Highest Priority"; desc = "highest priority ..."; };
            LOWEST_PRIORITY = 7 { name = "Lowest Priority"; desc = "lowest priority"; };
        };

        field {
            name = "rd_pri2";
            desc = "Priority when the read command ID mapping is 2";
            sw = rw;
            hw = r;
            encode = AXI_RDPRI_rd_pri2_enum;
            reset = 0x0;
        } rd_pri2[10:8];

        enum AXI_RDPRI_rd_pri1_enum {
            HIGHEST_PRIORITY = 0 { name = "Highest Priority"; desc = "highest priority ..."; };
            LOWEST_PRIORITY = 7 { name = "Lowest Priority"; desc = "lowest priority"; };
        };

        field {
            name = "rd_pri1";
            desc = "Priority when the read command ID mapping is 1";
            sw = rw;
            hw = r;
            encode = AXI_RDPRI_rd_pri1_enum;
            reset = 0x0;
        } rd_pri1[6:4];

        enum AXI_RDPRI_rd_pri0_enum {
            HIGHEST_PRIORITY = 0 { name = "Highest Priority"; desc = "highest priority ..."; };
            LOWEST_PRIORITY = 7 { name = "Lowest Priority"; desc = "lowest priority"; };
        };

        field {
            name = "rd_pri0";
            desc = "Priority when the read command ID mapping is 0";
            sw = rw;
            hw = r;
            encode = AXI_RDPRI_rd_pri0_enum;
            reset = 0x0;
        } rd_pri0[2:0];
    } AXI_RDPRI[7] @ 0x100 += 0x4;

    reg {
        name = "AXI_WRTOUT DDRC write command timeout ports configuration register";
        desc = "AXI_WRTOUT is a DDRC write command timeout configuration register.

Data sheet 4.1.5 AXI_WRTOUT (offset 0x140, printed page 4-33, dump line 33407).

Hardware (Hi3518E V200 board, live dump): ports read 0x08040200 (port 1: 0x08040100, as the vendor table writes) and the never-written slots 7..15 read 0x08040200, so the data sheet reset 0 is not what the silicon holds there.";

        field {
            name = "wr_tout3";
            desc = "Write command timeout period (level 3) The configuration mode is the same as that of wr_tout0.";
            sw = rw;
            hw = r;
            reset = 0x0;
        } wr_tout3[31:24];

        field {
            name = "wr_tout2";
            desc = "Write command timeout period (level 2) The configuration mode is the same as that of wr_tout0.";
            sw = rw;
            hw = r;
            reset = 0x0;
        } wr_tout2[23:16];

        field {
            name = "wr_tout1";
            desc = "Write command timeout period (level 1) The configuration mode is the same as that of wr_tout0.";
            sw = rw;
            hw = r;
            reset = 0x0;
        } wr_tout1[15:8];

        field {
            name = "wr_tout0";
            desc = "Write command timeout period (level 0) 0x0: disabled 0x01-0xFF: (n x 4) clock cycles";
            sw = rw;
            hw = r;
            reset = 0x0;
        } wr_tout0[7:0];
    } AXI_WRTOUT[7] @ 0x140 += 0x4;

    reg {
        name = "AXI_RDTOUT DDRC read command timeout ports configuration register";
        desc = "AXI_RDTOUT is a DDRC read command timeout configuration register.

Data sheet 4.1.5 AXI_RDTOUT (offset 0x180, printed page 4-34, dump line 33454).

Hardware (Hi3518E V200 board, live dump): ports read 0x08040200 (as the vendor table writes) and the never-written slots 7..15 read 0x08040200, so the data sheet reset 0 is not what the silicon holds there.";

        field {
            name = "rd_tout3";
            desc = "Read command timeout period (level 3) The configuration mode is the same as that of rd_tout0.";
            sw = rw;
            hw = r;
            reset = 0x0;
        } rd_tout3[31:24];

        field {
            name = "rd_tout2";
            desc = "Read command timeout period (level 2) The configuration mode is the same as that of rd_tout0.";
            sw = rw;
            hw = r;
            reset = 0x0;
        } rd_tout2[23:16];

        field {
            name = "rd_tout1";
            desc = "Read command timeout period (level 1) The configuration mode is the same as that of rd_tout0.";
            sw = rw;
            hw = r;
            reset = 0x0;
        } rd_tout1[15:8];

        field {
            name = "rd_tout0";
            desc = "Read command timeout period (level 0) 0x0: disabled 0x01-0xFF: (n x 4) clock cycles";
            sw = rw;
            hw = r;
            reset = 0x0;
        } rd_tout0[7:0];
    } AXI_RDTOUT[7] @ 0x180 += 0x4;

    reg {
        name = "AXI_OSTDCFG0 DDRC port command outstanding ports configuration register 0";
        desc = "AXI_OSTDCFG0 is DDRC port command outstanding configuration register 0.

The data sheet Total Reset Value is 0x1F1F1F1F and its bit diagram shows bits 28:24, 20:16 and 12:8 as 1 although the bit table lists only port_ostd_lvl0 [4:0] (the rest is `reserved`, RO); the upper bits are modelled as a non-zero-reset `reserved_*` field so the total matches. Array index `ports` = 0..6 (AXI port number).

Data sheet 4.1.5 AXI_OSTDCFG0 (offset 0x200, printed page 4-34, dump line 33490).";

        field {
            name = "reserved_31_5";
            desc = "Reserved in the data sheet bit table, but the data sheet Total Reset Value has non-zero bits here (reset 0xF8F8F8). Modelled so that the register reset matches the data sheet.";
            sw = r;
            hw = w;
            reset = 0x00F8F8F8;
        } reserved_31_5[31:5];

        field {
            name = "port_ostd_lvl0";
            desc = "OSTD threshold of the command transmitted from the port to channel 0 (used with the AXI_OSTDCFG2 register)";
            sw = rw;
            hw = r;
            reset = 0x1F;
        } port_ostd_lvl0[4:0];
    } AXI_OSTDCFG0[7] @ 0x200 += 0x4;

    reg {
        name = "DDRC port command outstanding configuration register 1";
        desc = "AXI_OSTDCFG1 is DDRC port command outstanding configuration register 1.

Same data-sheet inconsistency as AXI_OSTDCFG0 (Total Reset Value 0x1F1F1F1F, only [4:0] documented).

Data sheet 4.1.5 AXI_OSTDCFG1 (offset 0x240, printed page 4-35, dump line 33523).";

        field {
            name = "reserved_31_5";
            desc = "Reserved in the data sheet bit table, but the data sheet Total Reset Value has non-zero bits here (reset 0xF8F8F8). Modelled so that the register reset matches the data sheet.";
            sw = r;
            hw = w;
            reset = 0x00F8F8F8;
        } reserved_31_5[31:5];

        field {
            name = "dmc_ostd_lvl0";
            desc = "Accumulated OSTD threshold of commands transmitted from all ports to channel 0 (used with the AXI_OSTDCFG2 register)";
            sw = rw;
            hw = r;
            reset = 0x1F;
        } dmc_ostd_lvl0[4:0];
    } AXI_OSTDCFG1 @ 0x240;

    reg {
        name = "DDRC port command outstanding configuration register 2";
        desc = "AXI_OSTDCFG2 is DDRC port command outstanding configuration register 2.

Data sheet 4.1.5 AXI_OSTDCFG2 (offset 0x244, printed page 4-35, dump line 33549).";

        enum AXI_OSTDCFG2_ostd_mode6_enum {
            OSTD_STATISTICS_CURRENT = 0 { name = "Ostd Statistics Current"; desc = "The OSTD statistics of the current port are disabled."; };
            GREEN_PORT_MODE = 1 { name = "Green Port Mode"; desc = "green port. The mode is controlled by channel. When the OSTD of the current port reaches port_ostd_lvl, the port is blocked."; };
            NON_GREEN_PORT = 2 { name = "Non Green Port"; desc = "non-green port mode 0. The mode is controlled by channel. If the accumulated OSTD of all ports reaches dmc_ostd_lvl, the current port is blocked."; };
            NON_GREEN_PORT_2 = 3 { name = "Non Green Port 2"; desc = "non-green port mode 1. The mode is controlled by channel. If the accumulated OSTD of all ports reaches dmc_ostd_lvl or the OSTD of the current port reaches port_ostd_lvl, the current port is blocked."; };
        };

        field {
            name = "ostd_mode6";
            desc = "OSTD mode of port 6";
            sw = rw;
            hw = r;
            encode = AXI_OSTDCFG2_ostd_mode6_enum;
            reset = 0x0;
        } ostd_mode6[13:12];

        enum AXI_OSTDCFG2_ostd_mode5_enum {
            OSTD_STATISTICS_CURRENT = 0 { name = "Ostd Statistics Current"; desc = "The OSTD statistics of the current port are disabled."; };
            GREEN_PORT_MODE = 1 { name = "Green Port Mode"; desc = "green port. The mode is controlled by channel. When the OSTD of the current port reaches port_ostd_lvl, the port is blocked."; };
            NON_GREEN_PORT = 2 { name = "Non Green Port"; desc = "non-green port mode 0. The mode is controlled by channel. If the accumulated OSTD of all ports reaches dmc_ostd_lvl, the current port is blocked."; };
            NON_GREEN_PORT_2 = 3 { name = "Non Green Port 2"; desc = "non-green port mode 1. The mode is controlled by channel. If the accumulated OSTD of all ports reaches dmc_ostd_lvl or the OSTD of the current port reaches port_ostd_lvl, the current port is blocked."; };
        };

        field {
            name = "ostd_mode5";
            desc = "OSTD mode of port 5";
            sw = rw;
            hw = r;
            encode = AXI_OSTDCFG2_ostd_mode5_enum;
            reset = 0x0;
        } ostd_mode5[11:10];

        enum AXI_OSTDCFG2_ostd_mode4_enum {
            OSTD_STATISTICS_CURRENT = 0 { name = "Ostd Statistics Current"; desc = "The OSTD statistics of the current port are disabled."; };
            GREEN_PORT_MODE = 1 { name = "Green Port Mode"; desc = "green port. The mode is controlled by channel. When the OSTD of the current port reaches port_ostd_lvl, the port is blocked."; };
            NON_GREEN_PORT = 2 { name = "Non Green Port"; desc = "non-green port mode 0. The mode is controlled by channel. If the accumulated OSTD of all ports reaches dmc_ostd_lvl, the current port is blocked."; };
            NON_GREEN_PORT_2 = 3 { name = "Non Green Port 2"; desc = "non-green port mode 1. The mode is controlled by channel. If the accumulated OSTD of all ports reaches dmc_ostd_lvl or the OSTD of the current port reaches port_ostd_lvl, the current port is blocked."; };
        };

        field {
            name = "ostd_mode4";
            desc = "OSTD mode of port 4";
            sw = rw;
            hw = r;
            encode = AXI_OSTDCFG2_ostd_mode4_enum;
            reset = 0x0;
        } ostd_mode4[9:8];

        enum AXI_OSTDCFG2_ostd_mode3_enum {
            OSTD_STATISTICS_CURRENT = 0 { name = "Ostd Statistics Current"; desc = "The OSTD statistics of the current port are disabled."; };
            GREEN_PORT_MODE = 1 { name = "Green Port Mode"; desc = "green port. The mode is controlled by channel. When the OSTD of the current port reaches port_ostd_lvl, the port is blocked."; };
            NON_GREEN_PORT = 2 { name = "Non Green Port"; desc = "non-green port mode 0. The mode is controlled by channel. If the accumulated OSTD of all ports reaches dmc_ostd_lvl, the current port is blocked."; };
            NON_GREEN_PORT_2 = 3 { name = "Non Green Port 2"; desc = "non-green port mode 1. The mode is controlled by channel. If the accumulated OSTD of all ports reaches dmc_ostd_lvl or the OSTD of the current port reaches port_ostd_lvl, the current port is blocked."; };
        };

        field {
            name = "ostd_mode3";
            desc = "OSTD mode of port 3";
            sw = rw;
            hw = r;
            encode = AXI_OSTDCFG2_ostd_mode3_enum;
            reset = 0x0;
        } ostd_mode3[7:6];

        enum AXI_OSTDCFG2_ostd_mode2_enum {
            OSTD_STATISTICS_CURRENT = 0 { name = "Ostd Statistics Current"; desc = "The OSTD statistics of the current port are disabled."; };
            GREEN_PORT_MODE = 1 { name = "Green Port Mode"; desc = "green port. The mode is controlled by channel. When the OSTD of the current port reaches port_ostd_lvl, the port is blocked."; };
            NON_GREEN_PORT = 2 { name = "Non Green Port"; desc = "non-green port mode 0. The mode is controlled by channel. If the accumulated OSTD of all ports reaches dmc_ostd_lvl, the current port is blocked."; };
            NON_GREEN_PORT_2 = 3 { name = "Non Green Port 2"; desc = "non-green port mode 1. The mode is controlled by channel. If the accumulated OSTD of all ports reaches dmc_ostd_lvl or the OSTD of the current port reaches port_ostd_lvl, the current port is blocked."; };
        };

        field {
            name = "ostd_mode2";
            desc = "OSTD mode of port 2";
            sw = rw;
            hw = r;
            encode = AXI_OSTDCFG2_ostd_mode2_enum;
            reset = 0x0;
        } ostd_mode2[5:4];

        enum AXI_OSTDCFG2_ostd_mode1_enum {
            OSTD_STATISTICS_CURRENT = 0 { name = "Ostd Statistics Current"; desc = "The OSTD statistics of the current port are disabled."; };
            GREEN_PORT_MODE = 1 { name = "Green Port Mode"; desc = "green port. The mode is controlled by channel. When the OSTD of the current port reaches port_ostd_lvl, the port is blocked."; };
            NON_GREEN_PORT = 2 { name = "Non Green Port"; desc = "non-green port mode 0. The mode is controlled by channel. If the accumulated OSTD of all ports reaches dmc_ostd_lvl, the current port is blocked."; };
            NON_GREEN_PORT_2 = 3 { name = "Non Green Port 2"; desc = "non-green port mode 1. The mode is controlled by channel. If the accumulated OSTD of all ports reaches dmc_ostd_lvl or the OSTD of the current port reaches port_ostd_lvl, the current port is blocked."; };
        };

        field {
            name = "ostd_mode1";
            desc = "OSTD mode of port 1";
            sw = rw;
            hw = r;
            encode = AXI_OSTDCFG2_ostd_mode1_enum;
            reset = 0x0;
        } ostd_mode1[3:2];

        enum AXI_OSTDCFG2_ostd_mode0_enum {
            OSTD_STATISTICS_CURRENT = 0 { name = "Ostd Statistics Current"; desc = "The OSTD statistics of the current port are disabled."; };
            GREEN_PORT_MODE = 1 { name = "Green Port Mode"; desc = "green port. The mode is controlled by channel. When the OSTD of the current port reaches port_ostd_lvl, the port is blocked."; };
            NON_GREEN_PORT = 2 { name = "Non Green Port"; desc = "non-green port mode 0. The mode is controlled by channel. If the accumulated OSTD of all ports reaches dmc_ostd_lvl, the current port is blocked."; };
            NON_GREEN_PORT_2 = 3 { name = "Non Green Port 2"; desc = "non-green port mode 1. The mode is controlled by channel. If the accumulated OSTD of all ports reaches dmc_ostd_lvl or the OSTD of the current port reaches port_ostd_lvl, the current port is blocked."; };
        };

        field {
            name = "ostd_mode0";
            desc = "OSTD mode of port 0";
            sw = rw;
            hw = r;
            encode = AXI_OSTDCFG2_ostd_mode0_enum;
            reset = 0x0;
        } ostd_mode0[1:0];
    } AXI_OSTDCFG2 @ 0x244;

    reg {
        name = "DDRC channel command outstanding status register";
        desc = "AXI_OSTDSTATUS is a DDRC channel command outstanding status register.

Data sheet 4.1.5 AXI_OSTDSTATUS (offset 0x248, printed page 4-38, dump line 33692).";

        field {
            name = "ostd_st0";
            desc = "Command OSTD status of channel 0. The statistics are valid when at least a port is in non-green port mode.";
            sw = r;
            hw = w;
            reset = 0x0;
        } ostd_st0[4:0];
    } AXI_OSTDSTATUS @ 0x248;

    reg {
        name = "AXI_FLUX0 DDRC port bandwidth traffic control ports configuration register for channel 0";
        desc = "AXI_FLUX0 is a DDRC port bandwidth traffic control configuration register for channel 0.

Data sheet 4.1.5 AXI_FLUX0 (offset 0x280, printed page 4-39, dump line 33726).";

        enum AXI_FLUX0_flux_port_en0_enum {
            DISABLED = 0 { name = "Disabled"; desc = "disabled"; };
            ENABLED = 1 { name = "Enabled"; desc = "enabled"; };
        };

        field {
            name = "flux_port_en0";
            desc = "AXI interface DDRC traffic statistics enable";
            sw = rw;
            hw = r;
            encode = AXI_FLUX0_flux_port_en0_enum;
            reset = 0x0;
        } flux_port_en0[21:21];

        enum AXI_FLUX0_flux_ovfl_en0_enum {
            DISABLED = 0 { name = "Disabled"; desc = "disabled"; };
            ENABLED_WHEN_THIS = 1 { name = "Enabled When This"; desc = "enabled When this field is set to 1, the bandwidth of the AXI interface can exceed the configured traffic if the AXI interface traffic exceeds the bandwidth limit, there is no AXI interface with traffic overflow, and a command request is initiated."; };
        };

        field {
            name = "flux_ovfl_en0";
            desc = "AXI interface traffic overflow allow enable";
            sw = rw;
            hw = r;
            encode = AXI_FLUX0_flux_ovfl_en0_enum;
            reset = 0x0;
        } flux_ovfl_en0[20:20];

        field {
            name = "flux_ovfl_lvl0";
            desc = "AXI interface traffic overflow threshold 0x0-0x10: DMC threshold for allowing traffic overflow Other values: reserved When the AXI interface traffic exceeds the configured bandwidth of flux, flux_ovfl is 1, and the number of commands to be processed in the DMC is less than the configured threshold, transmission is allowed. Otherwise, no arbitration is performed.";
            sw = rw;
            hw = r;
            reset = 0x0;
        } flux_ovfl_lvl0[16:12];

        field {
            name = "flux_cfg0";
            desc = "Allowed bandwidth of the AXI interface 0x0-0x3FF: ratio of the maximum DDR bandwidth to the total bandwidth accessed by the AXI interface. The total bandwidth is 1024. The configured value is a ratio of the allowed bandwidth to the total bandwidth. Other values: reserved";
            sw = rw;
            hw = r;
            reset = 0x0;
        } flux_cfg0[9:0];
    } AXI_FLUX0[7] @ 0x280 += 0x4;

};

regfile eHISI_DDRC_V2_DMC {
    name = "DDRC V2 DMC registers";
    desc = "DMC (DDR memory controller) registers of the DDRC, data sheet 4.1.6 (Table 4-6, base 0x20111000): self-refresh/init/software-command control, SDRAM configuration (mode, rank volume, EMRS, timing 0-6 and their `NXT` shadow set), ODT, PHY interface, statistics counters, interrupts and status.

Initialisation order (data sheet 4.1.4.3 / vendor stock U-Boot image): CFG_SREF, CFG_AREF/CFG_PD off, CFG_WORKMODE, CFG_DDRMODE, CFG_RNKVOL, CFG_TIMING0-5, CFG_ODT, then the PHY registers (see eHISI_DDRC_V2_PHY), PHYINITCTRL, CFG_TIMING2 (enables auto-refresh), CTRL_SREF = 2 (exit self-refresh) and poll CURR_FUNC.in_sref == 0, then CTRL_SREF.sref_done = 1.";

    reg {
        name = "DDRC self-refresh control register";
        desc = "DDRC_CTRL_SREF is a DDRC self-refresh control register.

Data sheet 4.1.6 DDRC_CTRL_SREF (offset 0x0, printed page 4-44, dump line 33988).";

        field {
            name = "sref_done";
            desc = "DDR PHY self-refresh done 1: The transition from 0 to 1 indicates that the DDR PHY completes all required operations after exiting the self-refresh status and the DMC can accept new requests.";
            sw = rw;
            hw = r;
            reset = 0x0;
        } sref_done[1:1];

        enum DDRC_CTRL_SREF_sref_req_enum {
            EXIT_SELF_REFRESH = 0 { name = "Exit Self Refresh"; desc = "exit the self-refresh status"; };
            ENTER_SELF_REFRESH = 1 { name = "Enter Self Refresh"; desc = "enter the self-refresh status"; };
        };

        field {
            name = "sref_req";
            desc = "SDRAM self-refresh request";
            sw = rw;
            hw = r;
            encode = DDRC_CTRL_SREF_sref_req_enum;
            reset = 0x1;
        } sref_req[0:0];
    } DDRC_CTRL_SREF @ 0x0;

    reg {
        name = "DDRC initialization control register";
        desc = "DDRC_CTRL_INIT is a DDRC initialization control register.

Data sheet 4.1.6 DDRC_CTRL_INIT (offset 0x4, printed page 4-44, dump line 34019).";

        enum DDRC_CTRL_INIT_dfi_init_start_enum {
            NORMAL_STATE = 0 { name = "Normal State"; desc = "normal state"; };
            DFI_INTERFACE_INITIALIZATION = 1 { name = "Dfi Interface Initialization"; desc = "DFI interface initialization is started, and the PHY implements related control processes. This bit is automatically cleared by hardware after initialization is complete."; };
        };

        field {
            name = "dfi_init_start";
            desc = "DFI initialization start";
            sw = rw;
            hw = r;
            encode = DDRC_CTRL_INIT_dfi_init_start_enum;
            reset = 0x0;
        } dfi_init_start[1:1];

        enum DDRC_CTRL_INIT_init_req_enum {
            INITIALIZATION_COMPLETE_INITIA = 0 { name = "Initialization Complete Initia"; desc = "Initialization is complete or initialization is performed properly."; };
            SDRAM_STARTS_INITIALIZED = 1 { name = "Sdram Starts Initialized"; desc = "The SDRAM starts to be initialized."; };
        };

        field {
            name = "init_req";
            desc = "Initialization enable";
            sw = rw;
            hw = r;
            encode = DDRC_CTRL_INIT_init_req_enum;
            reset = 0x0;
        } init_req[0:0];
    } DDRC_CTRL_INIT @ 0x4;

    reg {
        name = "DDRC software configuration command start register";
        desc = "DDRC_CTRL_SFC is a DDRC software configuration command start register.

Data sheet 4.1.6 DDRC_CTRL_SFC (offset 0xC, printed page 4-45, dump line 34064).";

        enum DDRC_CTRL_SFC_cmd_req_enum {
            COMMAND_NOT_EXECUTED = 0 { name = "Command Not Executed"; desc = "The command is not executed or the parameter is automatically cleared after the command is executed."; };
            COMMAND_REQUESTED_EXECUTED = 1 { name = "Command Requested Executed"; desc = "The command is requested to be executed."; };
        };

        field {
            name = "cmd_req";
            desc = "Request of executing the configuration command of the DDRC";
            sw = rw;
            hw = r;
            encode = DDRC_CTRL_SFC_cmd_req_enum;
            reset = 0x0;
        } cmd_req[0:0];
    } DDRC_CTRL_SFC @ 0xC;

    reg {
        name = "DDRC performance statistics control register";
        desc = "DDRC_CTRL_PERF is a DDRC performance statistics enable register.

The data sheet Total Reset Value is 0x0014F000 although the bit table lists only perf_en [0]; the non-zero reserved bits are modelled as a `reserved_*` field so that the total matches.

Data sheet 4.1.6 DDRC_CTRL_PERF (offset 0x10, printed page 4-45, dump line 34093).

Hardware (Hi3518E V200 board, live dump): reads 0x00000000 at U-Boot and under Linux, with nothing in the vendor init writing it, although the data sheet total reset value is 0x0014F000 (reserved non-zero bits). The reserved bits are probably read as 0.";

        field {
            name = "reserved_31_1";
            desc = "Reserved in the data sheet bit table, but the data sheet Total Reset Value has non-zero bits here (reset 0xA7800). Modelled so that the register reset matches the data sheet.";
            sw = r;
            hw = w;
            reset = 0x000A7800;
        } reserved_31_1[31:1];

        enum DDRC_CTRL_PERF_perf_en_enum {
            DISABLED = 0 { name = "Disabled"; desc = "disabled"; };
            ENABLED = 1 { name = "Enabled"; desc = "enabled"; };
        };

        field {
            name = "perf_en";
            desc = "Performance statistics mode";
            sw = rw;
            hw = r;
            encode = DDRC_CTRL_PERF_perf_en_enum;
            reset = 0x0;
        } perf_en[0:0];
    } DDRC_CTRL_PERF @ 0x10;

    reg {
        name = "DDR self-refresh configuration register";
        desc = "DDRC_CFG_SREF is a DDRC self-refresh configuration register.

Data sheet 4.1.6 DDRC_CFG_SREF (offset 0x20, printed page 4-46, dump line 34131).";

        field {
            name = "sref_arefnum";
            desc = "Number of self-refresh operations initiated after DDRn SDRAM exits the self-refresh status during the DFS process 0x0: No self-refresh operation is initiated. 0x1-0xF: n";
            sw = rw;
            hw = r;
            reset = 0x0;
        } sref_arefnum[15:12];

        enum DDRC_CFG_SREF_clk_switch_enum {
            INTERFACE_COMMANDS_NOT = 0 { name = "Interface Commands Not"; desc = "The interface commands are not back pressed, and an error is returned directly."; };
            INTERFACE_COMMANDS_BACK = 1 { name = "Interface Commands Back"; desc = "The interface commands are back pressed, and the original command is executed after the clock is switched."; };
        };

        field {
            name = "clk_switch";
            desc = "DDRC low-power clock switch. Whether to back press AXI interface command when the DDRC enters the low-power status (DDR self-refresh).";
            sw = rw;
            hw = r;
            encode = DDRC_CFG_SREF_clk_switch_enum;
            reset = 0x0;
        } clk_switch[8:8];

        enum DDRC_CFG_SREF_sref_odis_enum {
            ENABLED = 0 { name = "Enabled"; desc = "enabled"; };
            DISABLED = 1 { name = "Disabled"; desc = "disabled"; };
        };

        field {
            name = "sref_odis";
            desc = "Output disable for the DDR command and data I/O in self-refresh mode.";
            sw = rw;
            hw = r;
            encode = DDRC_CFG_SREF_sref_odis_enum;
            reset = 0x0;
        } sref_odis[4:4];

        enum DDRC_CFG_SREF_sref_cc_enum {
            SDRAM_CLOCK_ENABLED = 0 { name = "Sdram Clock Enabled"; desc = "The SDRAM clock is enabled."; };
            SDRAM_CLOCK_DISABLED = 1 { name = "Sdram Clock Disabled"; desc = "The SDRAM clock is disabled."; };
        };

        field {
            name = "sref_cc";
            desc = "SDRAM clock control in self-refresh mode";
            sw = rw;
            hw = r;
            encode = DDRC_CFG_SREF_sref_cc_enum;
            reset = 0x0;
        } sref_cc[0:0];
    } DDRC_CFG_SREF @ 0x20;

    reg {
        name = "DDRC vendor register at 0x24 (not in the data sheet)";
        desc = "Not in the Hi3518E V20X / Hi3516C V200 data sheet (the DMC list jumps from DDRC_CFG_SREF 0x20 to DDRC_CFG_PD 0x28). The vendor register table (OpenIPC/vendor U-Boot reg_info for Hi3518E V200, DDR2) writes 0x00000008 here before DDRC_CFG_PD, and a live dump of a Hi3518E V200 board reads 0x00000008 at U-Boot and under Linux, so the register exists and holds the written value. [inferred] Probably a self-refresh / power-down related timing word next to DDRC_CFG_SREF and DDRC_CFG_PD; meaning unknown. Reset value unknown (not 0x8 necessarily).";
        field { name = "value"; desc = "[inferred] Undocumented word (vendor table writes 0x8)"; sw = rw; hw = r; } value[31:0];
    } DDRC_VENDOR_24 @ 0x24;

    reg {
        name = "DDR power-down status register";
        desc = "DDRC_CFG_PD is a DDR power-down status register.

The data sheet titles this register 'power-down status register' but all its fields are read/write configuration fields. The vendor U-Boot writes 0x401 (pd_prd = 0x40, pd_en = 1) after DDR training (lowlevel_init_v300.c: `the value should config after training, or it will cause chip compatibility problems`) and 0 during initialisation.

Data sheet 4.1.6 DDRC_CFG_PD (offset 0x28, printed page 4-47, dump line 34197).

Hardware (Hi3518E V200 board, live dump): reads 0x00000401 (pd_en 1, pd_prd 0x40) at U-Boot and under Linux. The vendor register table writes 0 first; the value 0x401 is written by the SPL AFTER DDR training (start_ddr_training, 'should config after training, or it will cause chip compatibility problems'), so the live value confirms that write.";

        field {
            name = "t_clk_cke";
            desc = "Relationship between CKL and CKE 0x0-0x7: The delay relative to CKE when the PHY disables the clock is related to the DDR PHY. For example, it is set to 5 for SNPS G2 MULTIPHY or 0 for SNPS 32PHY.";
            sw = rw;
            hw = r;
            reset = 0x0;
        } t_clk_cke[23:20];

        enum DDRC_CFG_PD_pd_ac_enum {
            ENABLED = 0 { name = "Enabled"; desc = "enabled"; };
            DISABLED = 1 { name = "Disabled"; desc = "disabled"; };
        };

        field {
            name = "pd_ac";
            desc = "SDRAM address command dynamic disable in power-down mode";
            sw = rw;
            hw = r;
            encode = DDRC_CFG_PD_pd_ac_enum;
            reset = 0x0;
        } pd_ac[16:16];

        enum DDRC_CFG_PD_pd_cc_enum {
            SDRAM_CLOCK_ENABLED = 0 { name = "Sdram Clock Enabled"; desc = "The SDRAM clock is enabled."; };
            SDRAM_CLOCK_DISABLED = 1 { name = "Sdram Clock Disabled"; desc = "The SDRAM clock is disabled. Note: This field is valid only when the LPDDR SDRAM or LPDDR2 SDRAM is used."; };
        };

        field {
            name = "pd_cc";
            desc = "SDRAM clock control in power-down mode";
            sw = rw;
            hw = r;
            encode = DDRC_CFG_PD_pd_cc_enum;
            reset = 0x0;
        } pd_cc[12:12];

        field {
            name = "pd_prd";
            desc = "SDRAM power-down cycle. When the DDRC does not receive any command in consecutive pd_prd cycles, it forces the SDRAM to enter the power-down status. When a command is received, the DDRC forces the SDRAM to exit the power-down status. 0x00: not to enter the power-down status 0x01-0xFF: n clock cycles";
            sw = rw;
            hw = r;
            reset = 0x0;
        } pd_prd[11:4];

        enum DDRC_CFG_PD_pd_en_enum {
            DISABLED = 0 { name = "Disabled"; desc = "disabled"; };
            ENABLED = 1 { name = "Enabled"; desc = "enabled"; };
        };

        field {
            name = "pd_en";
            desc = "Automatic power-down enable for the SDRAM";
            sw = rw;
            hw = r;
            encode = DDRC_CFG_PD_pd_en_enum;
            reset = 0x0;
        } pd_en[0:0];
    } DDRC_CFG_PD @ 0x28;

    reg {
        name = "DDRC auto-refresh mode register";
        desc = "DDRC_CFG_AREF is a DDRC auto-refresh mode register.

Data sheet 4.1.6 DDRC_CFG_AREF (offset 0x2C, printed page 4-48, dump line 34263).";

        field {
            name = "aref_alarm_num";
            desc = "The auto-refresh command is forced to be transmitted if a specific number of auto-refresh commands cannot be transmitted. 0x0-0xFF: lack of (n + 1) auto-refresh commands Note that only one auto-refresh command is considered when n is 255 because the upper bits are lost after the bits of the 8-bit counter are carried.";
            sw = rw;
            hw = r;
            reset = 0x0;
        } aref_alarm_num[15:8];

        enum DDRC_CFG_AREF_aref_alarm_en_enum {
            DISABLED = 0 { name = "Disabled"; desc = "disabled"; };
            ENABLED = 1 { name = "Enabled"; desc = "enabled"; };
        };

        field {
            name = "aref_alarm_en";
            desc = "Auto-refresh loss alarm enable (AREF function)";
            sw = rw;
            hw = r;
            encode = DDRC_CFG_AREF_aref_alarm_en_enum;
            reset = 0x0;
        } aref_alarm_en[4:4];

        enum DDRC_CFG_AREF_aref_mode_enum {
            AUTO_REFRESH_OPERATION = 0 { name = "Auto Refresh Operation"; desc = "An auto-refresh operation is performed every one tREFI cycle."; };
            THREE_AUTO_REFRESH = 1 { name = "Three Auto Refresh"; desc = "Three auto-refresh operations are performed every three tREFI cycles."; };
            FOUR_AUTO_REFRESH = 2 { name = "Four Auto Refresh"; desc = "Four auto-refresh operations are performed every five tREFI cycles."; };
            EIGHT_AUTO_REFRESH = 3 { name = "Eight Auto Refresh"; desc = "Eight auto-refresh operations are performed every nine tREFI cycles."; };
        };

        field {
            name = "aref_mode";
            desc = "Auto-refresh mode";
            sw = rw;
            hw = r;
            encode = DDRC_CFG_AREF_aref_mode_enum;
            reset = 0x0;
        } aref_mode[1:0];
    } DDRC_CFG_AREF @ 0x2C;

    reg {
        name = "DDRC operating mode register";
        desc = "DDRC_CFG_WORKMODE is a DDRC operating mode register.

The data sheet init procedure writes 0x11002011 (bits 28 and 24 are not documented in the bit table); the stock vendor U-Boot writes 0x2001 (hdr_mode = 1, clk_ratio = 1).

Data sheet 4.1.6 DDRC_CFG_WORKMODE (offset 0x40, printed page 4-49, dump line 34321).";

        enum DDRC_CFG_WORKMODE_hdr_mode_enum {
            SDR_MODE = 0 { name = "Sdr Mode"; desc = "SDR mode"; };
            HDR_MODE_ONLY = 1 { name = "Hdr Mode Only"; desc = "HDR mode Only the HDR mode is supported. Therefore, this bit is fixed at 1."; };
        };

        field {
            name = "hdr_mode";
            desc = "DFI interface mode select";
            sw = rw;
            hw = r;
            encode = DDRC_CFG_WORKMODE_hdr_mode_enum;
            reset = 0x0;
        } hdr_mode[13:13];

        enum DDRC_CFG_WORKMODE_read_mode_enum {
            ASSOCIATED_READ_MODE = 0 { name = "Associated Read Mode"; desc = "associated read mode"; };
            DELAY_READ_MODE = 1 { name = "Delay Read Mode"; desc = "delay read mode The associated read mode is a mode in which the DDRC samples data based on the data valid signal from the PHY. The delay read mode is a mode in which the DDRC samples the data from the PHY after the internal delay of the DDRC."; };
        };

        field {
            name = "read_mode";
            desc = "DDRC read mode";
            sw = rw;
            hw = r;
            encode = DDRC_CFG_WORKMODE_read_mode_enum;
            reset = 0x0;
        } read_mode[12:12];

        enum DDRC_CFG_WORKMODE_wrap_en_enum {
            DISABLED = 0 { name = "Disabled"; desc = "disabled"; };
            ENABLED = 1 { name = "Enabled"; desc = "enabled"; };
        };

        field {
            name = "wrap_en";
            desc = "Wrap command optimization enable";
            sw = rw;
            hw = r;
            encode = DDRC_CFG_WORKMODE_wrap_en_enum;
            reset = 0x0;
        } wrap_en[8:8];

        enum DDRC_CFG_WORKMODE_apre_en_enum {
            DISABLED = 0 { name = "Disabled"; desc = "disabled"; };
            ENABLED = 1 { name = "Enabled"; desc = "enabled"; };
        };

        field {
            name = "apre_en";
            desc = "Auto-precharge enable";
            sw = rw;
            hw = r;
            encode = DDRC_CFG_WORKMODE_apre_en_enum;
            reset = 0x0;
        } apre_en[4:4];

        enum DDRC_CFG_WORKMODE_func_clkon_enum {
            CLOCK_INTERNALLY_CONTROLLED = 0 { name = "Clock Internally Controlled"; desc = "The clock is internally controlled."; };
            CLOCK_FORCIBLY_ENABLED = 1 { name = "Clock Forcibly Enabled"; desc = "The clock is forcibly enabled."; };
        };

        field {
            name = "func_clkon";
            desc = "Functional module clock enable";
            sw = rw;
            hw = r;
            encode = DDRC_CFG_WORKMODE_func_clkon_enum;
            reset = 0x0;
        } func_clkon[3:3];

        enum DDRC_CFG_WORKMODE_data_clkon_enum {
            CLOCK_INTERNALLY_CONTROLLED = 0 { name = "Clock Internally Controlled"; desc = "The clock is internally controlled."; };
            CLOCK_FORCIBLY_ENABLED = 1 { name = "Clock Forcibly Enabled"; desc = "The clock is forcibly enabled."; };
        };

        field {
            name = "data_clkon";
            desc = "Data channel clock enable";
            sw = rw;
            hw = r;
            encode = DDRC_CFG_WORKMODE_data_clkon_enum;
            reset = 0x0;
        } data_clkon[2:2];

        enum DDRC_CFG_WORKMODE_cmd_clkon_enum {
            CLOCK_INTERNALLY_CONTROLLED = 0 { name = "Clock Internally Controlled"; desc = "The clock is internally controlled."; };
            CLOCK_FORCIBLY_ENABLED = 1 { name = "Clock Forcibly Enabled"; desc = "The clock is forcibly enabled."; };
        };

        field {
            name = "cmd_clkon";
            desc = "Command channel clock enable";
            sw = rw;
            hw = r;
            encode = DDRC_CFG_WORKMODE_cmd_clkon_enum;
            reset = 0x0;
        } cmd_clkon[1:1];

        enum DDRC_CFG_WORKMODE_clk_ratio_enum {
            RATIO_DDRC_FREQUENCY = 0 { name = "Ratio Ddrc Frequency"; desc = "The ratio of the DDRC frequency to the PHY frequency is 1:1."; };
            RATIO_DDRC_FREQUENCY_2 = 1 { name = "Ratio Ddrc Frequency 2"; desc = "The ratio of the DDRC frequency to the PHY frequency is 1:2. Only the HDR mode is supported. Therefore, this bit is fixed at 1."; };
        };

        field {
            name = "clk_ratio";
            desc = "Operating mode of the DDRC";
            sw = rw;
            hw = r;
            encode = DDRC_CFG_WORKMODE_clk_ratio_enum;
            reset = 0x0;
        } clk_ratio[0:0];
    } DDRC_CFG_WORKMODE @ 0x40;

    reg {
        name = "DDR operating mode register";
        desc = "DDRC_CFG_DDRMODE is a DDR operating mode register.

Vendor U-Boot (stock flash image) writes 0x15 for a 16-bit DDR2: dram_type = 5 (DDR2), mem_width = 1 (16 bit), brstlen = 0 (BL4). The data sheet init procedure (4.1.4.3 step 5) prints 0x25 for the same configuration, which would be mem_width = 2 (32 bit): data sheet typo.

Data sheet 4.1.6 DDRC_CFG_DDRMODE (offset 0x50, printed page 4-51, dump line 34406).

Hardware (Hi3518E V200 board, live dump): reads 0x00000015 (dram_type 5 = DDR2, mem_width 1 = 16 bit, brstlen 0 = BL4, rank 0 = 1 rank). This is the value the vendor register table writes; the DDR type is not sensed by hardware, software reads back what it programmed (the 'last digit 5 = DDR2, 6 = DDR3' rule of the OpenIPC README).";

        enum DDRC_CFG_DDRMODE_rank_enum {
            V_1_RANK = 0 { name = "V 1 Rank"; desc = "1 rank"; };
            V_2_RANKS = 1 { name = "V 2 Ranks"; desc = "2 ranks"; };
            V_3_RANKS = 2 { name = "V 3 Ranks"; desc = "3 ranks"; };
            V_4_RANKS = 3 { name = "V 4 Ranks"; desc = "4 ranks"; };
        };

        field {
            name = "rank";
            desc = "DDRC rank";
            sw = rw;
            hw = r;
            encode = DDRC_CFG_DDRMODE_rank_enum;
            reset = 0x0;
        } rank[21:20];

        enum DDRC_CFG_DDRMODE_odt_on_enum {
            SIGNAL_CONTROLLED_DDRC = 0 { name = "Signal Controlled Ddrc"; desc = "The signal is controlled by the DDRC."; };
            OUTPUT_FIXED_AT = 1 { name = "Output Fixed At"; desc = "The output is fixed at the wodt configuration of rank 0."; };
        };

        field {
            name = "odt_on";
            desc = "Whether the ODT signal output to the SDRAM is fixed";
            sw = rw;
            hw = r;
            encode = DDRC_CFG_DDRMODE_odt_on_enum;
            reset = 0x0;
        } odt_on[17:17];

        enum DDRC_CFG_DDRMODE_zqc_en_enum {
            DISABLED = 0 { name = "Disabled"; desc = "disabled"; };
            ENABLED = 1 { name = "Enabled"; desc = "enabled"; };
        };

        field {
            name = "zqc_en";
            desc = "DDR3 SDRAM ZQ enable";
            sw = rw;
            hw = r;
            encode = DDRC_CFG_DDRMODE_zqc_en_enum;
            reset = 0x0;
        } zqc_en[16:16];

        enum DDRC_CFG_DDRMODE_bc_en_enum {
            DISABLED = 0 { name = "Disabled"; desc = "disabled"; };
            ENABLED = 1 { name = "Enabled"; desc = "enabled"; };
        };

        field {
            name = "bc_en";
            desc = "DDR3 burst chop mode";
            sw = rw;
            hw = r;
            encode = DDRC_CFG_DDRMODE_bc_en_enum;
            reset = 0x0;
        } bc_en[12:12];

        enum DDRC_CFG_DDRMODE_brstlen_enum {
            BL4 = 0 { name = "Bl4"; desc = "BL4"; };
            BL8_BURST_MODE = 1 { name = "Bl8 Burst Mode"; desc = "BL8 The burst mode of the DDR2 SDRAM can be set to burst4 or burst8 mode. The burst mode of the DDR3 SDRAM must be burst8 mode."; };
        };

        field {
            name = "brstlen";
            desc = "Burst length of the DDRC";
            sw = rw;
            hw = r;
            encode = DDRC_CFG_DDRMODE_brstlen_enum;
            reset = 0x0;
        } brstlen[8:8];

        enum DDRC_CFG_DDRMODE_mem_width_enum {
            V_8_BITS = 0 { name = "V 8 Bits"; desc = "8 bits"; };
            V_16_BITS = 1 { name = "V 16 Bits"; desc = "16 bits"; };
            V_32_BITS = 2 { name = "V 32 Bits"; desc = "32 bits"; };
            V_64_BITS = 3 { name = "V 64 Bits"; desc = "64 bits"; };
        };

        field {
            name = "mem_width";
            desc = "Bit width of the storage data bus";
            sw = rw;
            hw = r;
            encode = DDRC_CFG_DDRMODE_mem_width_enum;
            reset = 0x0;
        } mem_width[5:4];

        enum DDRC_CFG_DDRMODE_dram_type_enum {
            RESERVED = 0 { name = "Reserved"; desc = "reserved"; };
            LPDDR = 1 { name = "Lpddr"; desc = "LPDDR"; };
            LPDDR2 = 2 { name = "Lpddr2"; desc = "LPDDR2"; };
            LPDDR3 = 3 { name = "Lpddr3"; desc = "LPDDR3"; };
            DDR = 4 { name = "Ddr"; desc = "DDR"; };
            DDR2 = 5 { name = "Ddr2"; desc = "DDR2"; };
            DDR3 = 6 { name = "Ddr3"; desc = "DDR3"; };
            DDR4 = 7 { name = "Ddr4"; desc = "DDR4"; };
        };

        field {
            name = "dram_type";
            desc = "External memory type";
            sw = rw;
            hw = r;
            encode = DDRC_CFG_DDRMODE_dram_type_enum;
            reset = 0x0;
        } dram_type[2:0];
    } DDRC_CFG_DDRMODE @ 0x50;

    reg {
        name = "DDRC-controlled DDR capacity configuration register";
        desc = "DDRC_CFG_RNKVOL is a DDRC-controlled DDR capacity configuration register.

Reset 0x22 = mem_row 13 bits, mem_col 10 bits, 4 banks, RBC mapping (DDR2-512 Mbit x16). The vendor stock image also writes 0x22.

Data sheet 4.1.6 DDRC_CFG_RNKVOL (offset 0x60, printed page 4-52, dump line 34495).

Hardware (Hi3518E V200 board, live dump): reads 0x00000022 = 13 row bits, 10 column bits, 4 banks, mapping 0 (Rank,Row,Ba,Col,DW): 8192 x 1024 x 4 x 2 bytes = 64 MiB, which matches the real 64 MiB DDR2 of the Hi3518E V200 (written by the vendor table, not sensed).";

        enum DDRC_CFG_RNKVOL_mem_map_enum {
            RANK_ROW_BA = 0 { name = "Rank Row Ba"; desc = "{Rank, Row, Ba, Col, DW} = AXI_Address"; };
            RANK_BA_ROW = 1 { name = "Rank Ba Row"; desc = "{Rank, Ba, Row, Col, DW}= AXI_Address"; };
            RANK_ROW_BA_2 = 2 { name = "Rank Row Ba 2"; desc = "{Rank, Row, Ba, Col, cs, Col, DW}= AXI_Address"; };
            RANK_BA_ROW_2 = 3 { name = "Rank Ba Row 2"; desc = "{Rank, Ba, Row, Col, cs, Col, DW}= AXI_Address This parameter can be set to 10 or 11 only when DDRC_CFG_AREF is valid. When there are multiple ranks, the configuration must be the same for each rank."; };
        };

        field {
            name = "mem_map";
            desc = "Address translation mode of the SDRAM";
            sw = rw;
            hw = r;
            encode = DDRC_CFG_RNKVOL_mem_map_enum;
            reset = 0x0;
        } mem_map[13:12];

        enum DDRC_CFG_RNKVOL_mem_bank_enum {
            V_4_BANKS = 0 { name = "V 4 Banks"; desc = "4 banks"; };
            V_8_BANKS = 1 { name = "V 8 Banks"; desc = "8 banks"; };
        };

        field {
            name = "mem_bank";
            desc = "Number of banks of a single SDRAM";
            sw = rw;
            hw = r;
            encode = DDRC_CFG_RNKVOL_mem_bank_enum;
            reset = 0x0;
        } mem_bank[8:8];

        enum DDRC_CFG_RNKVOL_mem_row_enum {
            V_11_BITS = 0 { name = "V 11 Bits"; desc = "11 bits"; };
            V_12_BITS = 1 { name = "V 12 Bits"; desc = "12 bits"; };
            V_13_BITS = 2 { name = "V 13 Bits"; desc = "13 bits"; };
            V_14_BITS = 3 { name = "V 14 Bits"; desc = "14 bits"; };
            V_15_BITS = 4 { name = "V 15 Bits"; desc = "15 bits"; };
            V_16_BITS_OTHER = 5 { name = "V 16 Bits Other"; desc = "16 bits Other values: reserved"; };
        };

        field {
            name = "mem_row";
            desc = "Bit width of the row address of a single SDRAM";
            sw = rw;
            hw = r;
            encode = DDRC_CFG_RNKVOL_mem_row_enum;
            reset = 0x2;
        } mem_row[6:4];

        enum DDRC_CFG_RNKVOL_mem_col_enum {
            V_8_BITS = 0 { name = "V 8 Bits"; desc = "8 bits"; };
            V_9_BITS = 1 { name = "V 9 Bits"; desc = "9 bits"; };
            V_10_BITS = 2 { name = "V 10 Bits"; desc = "10 bits"; };
            V_11_BITS = 3 { name = "V 11 Bits"; desc = "11 bits"; };
            V_12_BITS_OTHER = 4 { name = "V 12 Bits Other"; desc = "12 bits Other values: reserved"; };
        };

        field {
            name = "mem_col";
            desc = "Bit width of the column address of a single SDRAM";
            sw = rw;
            hw = r;
            encode = DDRC_CFG_RNKVOL_mem_col_enum;
            reset = 0x2;
        } mem_col[2:0];
    } DDRC_CFG_RNKVOL @ 0x60;

    reg {
        name = "DDR mode register 0 and mode register 1";
        desc = "DDRC_CFG_EMRS01 is a configuration register for DDR mode register 0 and mode register 1.

Data sheet 4.1.6 DDRC_CFG_EMRS01 (offset 0x70, printed page 4-54, dump line 34570).";

        field {
            name = "emrs1";
            desc = "DDRn SDRAM extended mode register 1";
            sw = rw;
            hw = r;
            reset = 0x0;
        } emrs1[31:16];

        field {
            name = "mrs";
            desc = "DDRn SDRAM mode register";
            sw = rw;
            hw = r;
            reset = 0x0;
        } mrs[15:0];
    } DDRC_CFG_EMRS01 @ 0x70;

    reg {
        name = "DDR mode register 2 and mode register 3";
        desc = "DDRC_CFG_EMRS23 is a configuration register for DDR mode register 2 and mode register 3.

Data sheet 4.1.6 DDRC_CFG_EMRS23 (offset 0x74, printed page 4-54, dump line 34591).";

        field {
            name = "emrs3";
            desc = "DDRn SDRAM extended mode register 3";
            sw = rw;
            hw = r;
            reset = 0x0;
        } emrs3[31:16];

        field {
            name = "emrs2";
            desc = "DDRn SDRAM extended mode register 2";
            sw = rw;
            hw = r;
            reset = 0x0;
        } emrs2[15:0];
    } DDRC_CFG_EMRS23 @ 0x74;

    reg {
        name = "DDRC timing parameter register 0";
        desc = "Data sheet 4.1.6 DDRC_CFG_TIMING0 (offset 0x80, printed page 4-55, dump line 34626).";

        field {
            name = "tmrd";
            desc = "Number of wait cycles for the load mode register (LMR) command. The value is the larger value between tMOD and tMRD for the DDR2 or LPDDR2 and is tMRD for the DDR3. 0x0-0x1: 1 clock cycle 0x2-0xF: n clock cycles";
            sw = rw;
            hw = r;
            reset = 0xF;
        } tmrd[31:28];

        field {
            name = "trrd";
            desc = "Number of wait cycles from ACT bank A to ACT bank B 0x0-0x1: 1 clock cycle 0x2-0xF: clock cycles";
            sw = rw;
            hw = r;
            reset = 0xF;
        } trrd[27:24];

        field {
            name = "trp";
            desc = "Number of wait cycles for the disable command (PRE period) 0x0-0x1: 1 clock cycle 0x2-0xF: n clock cycles";
            sw = rw;
            hw = r;
            reset = 0x1F;
        } trp[23:19];

        field {
            name = "trcd";
            desc = "Number of wait cycles from the ACT bank command to the read or write command 0x0-0x3: 3 clock cycles 0x4-0xF: clock cycles";
            sw = rw;
            hw = r;
            reset = 0x1F;
        } trcd[18:14];

        field {
            name = "trc";
            desc = "Number of wait cycles from an ACT bank command to the next ACT bank command 0x00-0x01: 1 clock cycle 0x02-0x3F: n clock cycles";
            sw = rw;
            hw = r;
            reset = 0x3F;
        } trc[13:8];

        field {
            name = "tras";
            desc = "Number of wait cycles from the ACT bank command to the disable command (PRE) 0x0-0x1: 1 clock cycle 0x2-0xF: n clock cycles";
            sw = rw;
            hw = r;
            reset = 0x3F;
        } tras[5:0];
    } DDRC_CFG_TIMING0 @ 0x80;

    reg {
        name = "DDRC timing parameter register 1";
        desc = "Data sheet 4.1.6 DDRC_CFG_TIMING1 (offset 0x84, printed page 4-56, dump line 34686).";

        field {
            name = "tsre";
            desc = "Number of wait cycles from the self-refresh exit command to the read command 0x0: reserved 0x01-0xFF: (n x 4) clock cycles This field is set to the larger value between tXSDLL and tXS for the DDR3 SDRAM.";
            sw = rw;
            hw = r;
            reset = 0xFF;
        } tsre[31:24];

        field {
            name = "trtw";
            desc = "Delay from the last read data command to the first write data command 0x0-0x1: 1 clock cycle 0x2-0xF: (n + 1) clock cycles";
            sw = rw;
            hw = r;
            reset = 0x2;
        } trtw[23:20];

        field {
            name = "twl";
            desc = "Number of wait cycles from the write command to the write data command 0x0-0x1: 1 clock cycle 0x2-0xF: n clock cycles For example, 0x3 indicates three clock cycles. The clock cycles are obtained from DDR user manuals. You can directly configure this field based on the clock cycles.";
            sw = rw;
            hw = r;
            reset = 0x4;
        } twl[19:16];

        field {
            name = "tcl";
            desc = "Column address strobe latency (CL) from the read command to the read data operation 0x0-0x1: 1 clock cycle 0x2-0xF: n clock cycles The clock cycles are obtained from DDR user manuals. You can directly configure this field based on the clock cycles.";
            sw = rw;
            hw = r;
            reset = 0x5;
        } tcl[15:12];

        field {
            name = "trfc";
            desc = "Number of wait cycles for the AREF period or AREF to the ACT command. The field value is set to the maximum value of max{trfc, tzqcs}. 0x00: reserved 0x01-0x1FF: n clock cycles";
            sw = rw;
            hw = r;
            reset = 0x1FF;
        } trfc[8:0];
    } DDRC_CFG_TIMING1 @ 0x84;

    reg {
        name = "DDRC timing parameter register 2";
        desc = "DDRC_CFG_TIMING2 is DDRC timing parameter register 2. Timing parameters in the register are obtained from DDR user manuals.       If DDRC_CFG_WORKMODE[clk_ration] is 1, convert the time specified in the DDR user manuals into the DDR clock cycle and then divide it by 2. If the value has a remainder, add 1 to the value.       If DDRC_CFG_WORKMODE[clk_ration] is 0, convert the time specified in the DDR user manuals into the DDR clock cycle and then use it directly.

Data sheet 4.1.6 DDRC_CFG_TIMING2 (offset 0x88, printed page 4-57, dump line 34761).";

        field {
            name = "tcke";
            desc = "Minimum cycle of retaining the self-refresh mode 0x0: reserved 0x1-0xF: clock cycles The field value must be the maximum value among tCKESR, tCKSRE, tCKSRX, and tCKE.";
            sw = rw;
            hw = r;
            reset = 0xF;
        } tcke[31:28];

        field {
            name = "twtr";
            desc = "Number of wait cycles for the last write data to the write-to-read command 0x0-0x1: 1 clock cycle 0x2-0xF: clock cycles For example, the value 0x3 indicates three clock cycles.";
            sw = rw;
            hw = r;
            reset = 0x3;
        } twtr[27:24];

        field {
            name = "tfaw";
            desc = "Number of clock cycles for four consecutive activation commands 0x00-0x3F: n clock cycles For example, the value 0x14 indicates 20 clock cycles.";
            sw = rw;
            hw = r;
            reset = 0x3F;
        } tfaw[17:12];

        field {
            name = "taref";
            desc = "Number of auto-refresh cycles 0x000: forbidden 0x001-0x7FF: The auto-refresh cycle of the SDRAM is (16 x n) clock cycles. For example, the value 0x008 indicates 128 (16 x 8) clock cycles. The interval tREFI is 7800/16/tclk. Tclk is the running cycle of the SDRAM. When DDRC_CFG_AREF[aref_mode] is 1, the interval must be set to 8 x tREFI.";
            sw = rw;
            hw = r;
            reset = 0x0;
        } taref[10:0];
    } DDRC_CFG_TIMING2 @ 0x88;

    reg {
        name = "DDRC timing parameter register 3";
        desc = "DDRC_CFG_TIMING3 is DDRC timing parameter register 3. Timing parameters in the register are obtained from DDR user manuals.      If DDRC_CFG_WORKMODE[clk_ration] is 1, convert the time specified in the DDR user manuals into the DDR clock cycle and then divide it by 2. If the value has a remainder, add 1 to the value.      If DDRC_CFG_WORKMODE[clk_ration] is 0, convert the time specified in the DDR user manuals into the DDR clock cycle and then use it directly.

Data sheet 4.1.6 DDRC_CFG_TIMING3 (offset 0x8C, printed page 4-58, dump line 34821).";

        field {
            name = "tzq_prd";
            desc = "Number of ZQCS command cycles 0x000: The ZQCS command is forbidden. 0x001-0x3FF: (n x 128) AREF cycles The number of ZQCS command cycles is equal to (n x 128) taref clock cycles.";
            sw = rw;
            hw = r;
            reset = 0x3FF;
        } tzq_prd[31:22];

        field {
            name = "tzqinit";
            desc = "Number of ZQ initialization delay cycles 0x0-0x1FF: (n + 1) clock cycles The field value must be the larger value between tZQINIT and tDLLK.";
            sw = rw;
            hw = r;
            reset = 0x1FF;
        } tzqinit[21:12];

        enum DDRC_CFG_TIMING3_taond_enum {
            V_2_2_5 = 0 { name = "V 2 2 5"; desc = "2/2.5"; };
            V_3_3_5 = 1 { name = "V 3 3 5"; desc = "3/3.5"; };
            V_4_4_5 = 2 { name = "V 4 4 5"; desc = "4/4.5"; };
            V_5_5_5 = 3 { name = "V 5 5 5"; desc = "5/5.5"; };
        };

        field {
            name = "taond";
            desc = "Number of ODT enable/disable cycles In DDR2 mode (taond/taofd):";
            sw = rw;
            hw = r;
            encode = DDRC_CFG_TIMING3_taond_enum;
            reset = 0x0;
        } taond[11:8];

        field {
            name = "txard";
            desc = "Other values: reserved In DDR3 mode, this value is set to tWL - 1. In 1:2 mode, this value needs to be set to tWL - 2. However, if the PHY has been separately processed, the value tWL - 1 is used. In LPDDR3 mode, the value is set to tODTon(max)/tCK. Number of wait cycles of exiting the DDR low-power mode 0x0-0xF: clock cycles (in decimal) For example, 0x7 indicates seven clock cycles. The field value is the maximum value among tXP, tXARD, tXARDS, and tXS. In DDR3 mode, the field value is the larger value between tXP and tCKE.";
            sw = rw;
            hw = r;
            reset = 0xF;
        } txard[7:4];

        field {
            name = "trtp";
            desc = "Wait delay from the read command to the disable command 000-010: 2 clock cycles 011-111: n clock cycles Trtp is calculated as follows: Trtp = AL + BL/2 + Max (trtp, 2) - 2";
            sw = rw;
            hw = r;
            reset = 0x2;
        } trtp[3:0];
    } DDRC_CFG_TIMING3 @ 0x8C;

    reg {
        name = "DDRC timing parameter register 4";
        desc = "DDRC_CFG_TIMING4 is DDRC timing parameter register 4. Timing parameters in the register are obtained from DDR user manuals.       If DDRC_CFG_WORKMODE[clk_ration] is 1, convert the time specified in the DDR user manuals into the DDR clock cycle and then divide it by 2. If the value has a remainder, add 1 to the value.       If DDRC_CFG_WORKMODE[clk_ration] is 0, convert the time specified in the DDR user manuals into the DDR clock cycle and then use it directly.

Data sheet 4.1.6 DDRC_CFG_TIMING4 (offset 0x90, printed page 4-59, dump line 34889).";

        field {
            name = "tmod";
            desc = "Delay from the MRS command to ODT and ZQCL validity 0x0-0x1: 1 clock cycle 0x2-0x1F: n clock cycles";
            sw = rw;
            hw = r;
            reset = 0x1F;
        } tmod[24:20];

        field {
            name = "twlo";
            desc = "DDR3 write level status delay 0x0 and 0x1: one clock cycle 0x2-0xF: clock cycles The parameter is equal to twlo + twloe.";
            sw = rw;
            hw = r;
            reset = 0xF;
        } twlo[19:16];

        field {
            name = "twldqsen";
            desc = "DDR3 write level start delay 0x0 and 0x1: one clock cycle 0x2-0x3F: n clock cycles";
            sw = rw;
            hw = r;
            reset = 0x20;
        } twldqsen[13:8];

        field {
            name = "twlmrd";
            desc = "Delay of the initial valid DDR3 write level DQS 0x0 and 0x1: one clock cycle 0x2-0x3F: n clock cycles";
            sw = rw;
            hw = r;
            reset = 0x0;
        } twlmrd[5:0];
    } DDRC_CFG_TIMING4 @ 0x90;

    reg {
        name = "DDRC timing parameter register 5";
        desc = "DDRC_CFG_TIMING5 is DDRC timing parameter register 5. Timing parameters in the register are obtained from DDR user manuals.       If DDRC_CFG_WORKMODE[clk_ration] is 1, convert the time specified in the DDR user manuals into the DDR clock cycle and then divide it by 2. If the value has a remainder, add 1 to the value.       If DDRC_CFG_WORKMODE[clk_ration] is 0, convert the time specified in the DDR user manuals into the DDR clock cycle and then use it directly.

The data sheet Total Reset Value (0x1113FF1F) has non-zero bits in the reserved fields [31:20]; modelled as a `reserved_*` field.

Data sheet 4.1.6 DDRC_CFG_TIMING5 (offset 0x94, printed page 4-60, dump line 34945).";

        field {
            name = "reserved_31_20";
            desc = "Reserved in the data sheet bit table, but the data sheet Total Reset Value has non-zero bits here (reset 0x111). Modelled so that the register reset matches the data sheet.";
            sw = rw;
            hw = r;
            reset = 0x111;
        } reserved_31_20[31:20];

        field {
            name = "trnk2rnk";
            desc = "Rank-to-rank delay 0000-1111: n clock cycles Note: In DDR2/DDR3 mode, the field value depends on the latency of the board, package, and I/O; in LPDDR/LPDDR2/LPDDR3 mode, the field value depends on the latency of the board, package, and I/O, and tdqsckmax.";
            sw = rw;
            hw = r;
            reset = 0x3;
        } trnk2rnk[19:16];

        field {
            name = "tzqcs";
            desc = "ZQCS calibration delay period 0x0-0xFF: (n + 1) clock cycles The field value must be greater than or equal to 10 due to the DMC design.";
            sw = rw;
            hw = r;
            reset = 0xFF;
        } tzqcs[15:8];

        field {
            name = "twr";
            desc = "Number of wait cycles of write recovery 0x0-0x1: 1 clock cycle 0x2-0x1F: clock cycles";
            sw = rw;
            hw = r;
            reset = 0x1F;
        } twr[4:0];
    } DDRC_CFG_TIMING5 @ 0x94;

    reg {
        name = "DDRC timing parameter register 6";
        desc = "DDRC_CFG_TIMING6 is DDRC timing parameter register 6. Timing parameters in the register are obtained from DDR user manuals.       If DDRC_CFG_WORKMODE[clk_ration] is 1, convert the time specified in the DDR user manuals into the DDR clock cycle and then divide it by 2. If the value has a remainder, add 1 to the value.       If DDRC_CFG_WORKMODE[clk_ration] is 0, convert the time specified in the DDR user manuals into the DDR clock cycle and then use it directly.

Data sheet 4.1.6 DDRC_CFG_TIMING6 (offset 0x98, printed page 4-61, dump line 35003).";

        field {
            name = "tcksrx";
            desc = "tCKSRX for the DDR3 or DDR4, that is, number of advanced valid beats before the DDR exits the self-refresh status 0x0-0x1: 1 clock cycle 0x2-0xF: n clock cycles";
            sw = rw;
            hw = r;
            reset = 0xF;
        } tcksrx[7:4];

        field {
            name = "tcksre";
            desc = "tCKSRE for the DDR3 or DDR4, that is, number of beats to be retained after the DDR enters the self-refresh status 0x0-0x1: 1 clock cycle 0x2-0xF: n clock cycles";
            sw = rw;
            hw = r;
            reset = 0xF;
        } tcksre[3:0];
    } DDRC_CFG_TIMING6 @ 0x98;

    reg {
        name = "DDRC timing parameter 0 register 0 for switching the frequency";
        desc = "DDRC_CFG_NXT_TIMING0 is DDRC timing parameter register 0 for switching the frequency.

Data sheet 4.1.6 DDRC_CFG_NXT_TIMING0 (offset 0xA0, printed page 4-62, dump line 35044).

Hardware (Hi3518E V200 board, live dump): reads 0x000000FF at U-Boot and under Linux; nothing in the vendor init writes this register, so the data sheet reset value (equal to the matching DDRC_CFG_TIMING0 reset) is not what the silicon holds. [inferred] The frequency-switch timing set is probably unused on this chip.";

        field {
            name = "tmrd";
            desc = "Number of wait cycles for the loading command of the loading mode register (LMR) 0x0 and 0x1: one clock cycle 0x2-0xF: n clock cycles";
            sw = rw;
            hw = r;
            reset = 0xF;
        } tmrd[31:28];

        field {
            name = "trrd";
            desc = "Number of wait cycles from ACT bank A to ACT bank B 0x0 and 0x1: one clock cycle 0x2-0xF: n clock cycles";
            sw = rw;
            hw = r;
            reset = 0xF;
        } trrd[27:24];

        field {
            name = "trp";
            desc = "Number of wait cycles for the disable command (PRE period) 0x0 and 0x1: one clock cycle 0x2-0xF: clock cycles";
            sw = rw;
            hw = r;
            reset = 0x1F;
        } trp[23:19];

        field {
            name = "trcd";
            desc = "Number of wait cycles from the ACT bank command to the read or write command 0x0-0x3: three clock cycles 0x4-0xF: n clock cycles";
            sw = rw;
            hw = r;
            reset = 0x1F;
        } trcd[18:14];

        field {
            name = "trc";
            desc = "Number of wait cycles from an ACT bank command to the next ACT bank command 0x00-0x01: one clock cycle 0x02-0x3F: clock cycles";
            sw = rw;
            hw = r;
            reset = 0x3F;
        } trc[13:8];

        field {
            name = "tras";
            desc = "Number of wait cycles from the ACT bank command to the disable command (PRE) 0x00-0x01: one clock cycle 0x02-0x3F: n clock cycles";
            sw = rw;
            hw = r;
            reset = 0x3F;
        } tras[5:0];
    } DDRC_CFG_NXT_TIMING0 @ 0xA0;

    reg {
        name = "DDRC timing parameter 1 register 1 for switching the frequency";
        desc = "DDRC_CFG_NXT_TIMING1 is DDRC timing parameter register 1 for switching the frequency.

Data sheet 4.1.6 DDRC_CFG_NXT_TIMING1 (offset 0xA4, printed page 4-63, dump line 35106).

Hardware (Hi3518E V200 board, live dump): reads 0x000000FF at U-Boot and under Linux; nothing in the vendor init writes this register, so the data sheet reset value (equal to the matching DDRC_CFG_TIMING1 reset) is not what the silicon holds. [inferred] The frequency-switch timing set is probably unused on this chip.";

        field {
            name = "tsre";
            desc = "Number of wait cycles from the self-refresh exit command to the read command 0x0: one clock cycle 0x01-0xFF: n x 4 clock cycles When the DDR3 SDRAM is used, the value is set to tXSDLL.";
            sw = rw;
            hw = r;
            reset = 0xFF;
        } tsre[31:24];

        field {
            name = "trtw";
            desc = "Delay from the last read data command to the first write data command 0x0 and 0x1: one clock cycle 0x2-0xF: n + 1 clock cycles";
            sw = rw;
            hw = r;
            reset = 0x2;
        } trtw[23:20];

        field {
            name = "twl";
            desc = "Number of wait cycles from the write command to the data write operation 0x0 and 0x1: one clock cycle 0x2-0xF: n clock cycles For example, the value 0x3 indicates three clock cycles. Note: In DDR2 mode, tw1 is set to tcl - 1 and the condition (twl - taond >= 1) must be met.";
            sw = rw;
            hw = r;
            reset = 0x4;
        } twl[19:16];

        field {
            name = "tcl";
            desc = "Column address strobe latency (CL) from the read command to the data read operation 0x0 and 0x1: one clock cycle 0x2-0xF: n clock cycles";
            sw = rw;
            hw = r;
            reset = 0x5;
        } tcl[15:12];

        field {
            name = "trfc";
            desc = "Number of wait cycles for the AREF period or AREF to the ACT command. The field value is set to the maximum value of max{trfc, tzqcs}. 0x00-0x01: one clock cycle 0x02-0xFF: n clock cycles";
            sw = rw;
            hw = r;
            reset = 0x1FF;
        } trfc[8:0];
    } DDRC_CFG_NXT_TIMING1 @ 0xA4;

    reg {
        name = "DDRC timing parameter 2 register 2 for switching the frequency";
        desc = "DDRC_CFG_NXT_TIMING2 is DDRC timing parameter register 2 for switching the frequency.

Data sheet 4.1.6 DDRC_CFG_NXT_TIMING2 (offset 0xA8, printed page 4-64, dump line 35166).

Hardware (Hi3518E V200 board, live dump): reads 0x000000FF at U-Boot and under Linux; nothing in the vendor init writes this register, so the data sheet reset value (equal to the matching DDRC_CFG_TIMING2 reset) is not what the silicon holds. [inferred] The frequency-switch timing set is probably unused on this chip.";

        field {
            name = "tcke";
            desc = "Minimum cycle of retaining the low-power mode 0x0 and 0x1: one clock cycle 0x2-0xF: n clock cycles The field value must be the maximum value among tCKESR, tCKSRE, tCKSRX, and tCKE.";
            sw = rw;
            hw = r;
            reset = 0xF;
        } tcke[31:28];

        field {
            name = "twtr";
            desc = "Number of wait cycles for the last data write operation to the write-to-read command 0x0 and 0x1: one clock cycle 0x2-0xF: n clock cycles For example, the value 0x3 indicates three clock cycles.";
            sw = rw;
            hw = r;
            reset = 0x3;
        } twtr[27:24];

        field {
            name = "tfaw";
            desc = "Number of clock cycles for four consecutive activation commands 0x00-0x3F: n clock cycles For example, the value 0x14 indicates 20 clock cycles.";
            sw = rw;
            hw = r;
            reset = 0x3F;
        } tfaw[17:12];

        field {
            name = "taref";
            desc = "Number of auto-refresh cycles 0x000: auto-refresh disabled 0x001-0x7FF: The auto-refresh cycle of the SDRAM is 16 x n clock cycles. For example, the value 0x008 indicates 128 (16 x 8) clock cycles. The interval tREF is 7800/16/tclk. Tclk is the running cycle of the SDRAM.";
            sw = rw;
            hw = r;
            reset = 0x0;
        } taref[10:0];
    } DDRC_CFG_NXT_TIMING2 @ 0xA8;

    reg {
        name = "DDRC timing parameter 3 register 3 for switching the frequency";
        desc = "DDRC_CFG_NXT_TIMING3 is DDRC timing parameter register 3 for switching the frequency.

Data sheet 4.1.6 DDRC_CFG_NXT_TIMING3 (offset 0xAC, printed page 4-65, dump line 35221).

Hardware (Hi3518E V200 board, live dump): reads 0x000000FF at U-Boot and under Linux; nothing in the vendor init writes this register, so the data sheet reset value (equal to the matching DDRC_CFG_TIMING3 reset) is not what the silicon holds. [inferred] The frequency-switch timing set is probably unused on this chip.";

        field {
            name = "tzq_prd";
            desc = "Number of ZQCS command cycles 0x000: The ZQCS command is disabled. 0x001-0x3FF: n x 128 AREF cycles The time of ZQCS command cycles is equal to n x 128 taref clock cycles.";
            sw = rw;
            hw = r;
            reset = 0x3FF;
        } tzq_prd[31:22];

        field {
            name = "tzqinit";
            desc = "Number of ZQ initialization delay cycles 0x0-0x3ff: (n + 1) clock cycles The value needs to be set to the larger one between tZQINIT and tDLLK.";
            sw = rw;
            hw = r;
            reset = 0x1FF;
        } tzqinit[21:12];

        enum DDRC_CFG_NXT_TIMING3_taond_enum {
            V_2_2_5 = 0 { name = "V 2 2 5"; desc = "2/2.5"; };
            V_3_3_5 = 1 { name = "V 3 3 5"; desc = "3/3.5"; };
            V_4_4_5 = 2 { name = "V 4 4 5"; desc = "4/4.5"; };
            V_5_5_5 = 3 { name = "V 5 5 5"; desc = "5/5.5 Other values: reserved In DDR3 mode, the value is set to tWL - 1. In 1:2 mode, the value needs to be set to tWL - 2. However, if the PHY has been separately processed, the value tWL - 1 is used. In LPDDR3 mode, the value is set to tODTon(max)/tCK."; };
        };

        field {
            name = "taond";
            desc = "Number of ODT enable/disable cycles In DDR2 mode (taond/taofd):";
            sw = rw;
            hw = r;
            encode = DDRC_CFG_NXT_TIMING3_taond_enum;
            reset = 0x0;
        } taond[11:8];

        field {
            name = "txard";
            desc = "Number of wait cycles of exiting the DDR low-power mode";
            sw = rw;
            hw = r;
            reset = 0xF;
        } txard[7:4];

        field {
            name = "trtp";
            desc = "0x0-0xF: clock cycles. indicates a decimal value. For example, 0x7 indicates seven clock cycles. The field value is the maximum value among tXP, tXARD, tXARDS, and tXS. In DDR3 mode, when the register is set to tXS, txard only needs to be set to an equivalent clock cycle of 10 ns. Wait delay from the read command to the disable command 0000-0010: two clock cycles 0011-1111: n clock cycles Trtp = AL + BL/2 + Max (trtp, 2) - 2";
            sw = rw;
            hw = r;
            reset = 0x2;
        } trtp[3:0];
    } DDRC_CFG_NXT_TIMING3 @ 0xAC;

    reg {
        name = "DDRC timing parameter 4 register 4 for switching the frequency";
        desc = "DDRC_CFG_NXT_TIMING4 is DDRC timing parameter register 4 for switching the frequency.

Data sheet 4.1.6 DDRC_CFG_NXT_TIMING4 (offset 0xB0, printed page 4-66, dump line 35283).

Hardware (Hi3518E V200 board, live dump): reads 0x000000FF at U-Boot and under Linux; nothing in the vendor init writes this register, so the data sheet reset value (equal to the matching DDRC_CFG_TIMING4 reset) is not what the silicon holds. [inferred] The frequency-switch timing set is probably unused on this chip.";

        field {
            name = "tmod";
            desc = "Delay from the MRS command to ODT valid 0x0 and 0x1: one clock cycle 0x02-0x1F: n clock cycles";
            sw = rw;
            hw = r;
            reset = 0x1F;
        } tmod[24:20];

        field {
            name = "twlo";
            desc = "DDR3 write level status delay parameter 0x0 and 0x1: one clock cycle 0x2-0xF: n clock cycles The parameter is equal to (twlo + twloe).";
            sw = rw;
            hw = r;
            reset = 0xF;
        } twlo[19:16];

        field {
            name = "twldqsen";
            desc = "DDR3 write level start delay 0x0 and 0x1: one clock cycle 0x2-0x3F: clock cycles";
            sw = rw;
            hw = r;
            reset = 0x20;
        } twldqsen[13:8];

        field {
            name = "twlmrd";
            desc = "Delay of the initial valid DDR3 write level DQS 0x0 and 0x1: one clock cycle 0x2-0x3F: clock cycles";
            sw = rw;
            hw = r;
            reset = 0x0;
        } twlmrd[5:0];
    } DDRC_CFG_NXT_TIMING4 @ 0xB0;

    reg {
        name = "DDRC timing parameter 5 register 5 for switching the frequency";
        desc = "DDRC_CFG_NXT_TIMING5 is DDRC timing parameter register 5 for switching the frequency.

Same non-zero reserved bits as DDRC_CFG_TIMING5 (data sheet Total Reset Value).

Data sheet 4.1.6 DDRC_CFG_NXT_TIMING5 (offset 0xB4, printed page 4-67, dump line 35336).

Hardware (Hi3518E V200 board, live dump): reads 0x000000FF at U-Boot and under Linux; nothing in the vendor init writes this register, so the data sheet reset value (equal to the matching DDRC_CFG_TIMING5 reset) is not what the silicon holds. [inferred] The frequency-switch timing set is probably unused on this chip.";

        field {
            name = "reserved_31_20";
            desc = "Reserved in the data sheet bit table, but the data sheet Total Reset Value has non-zero bits here (reset 0x111). Modelled so that the register reset matches the data sheet.";
            sw = rw;
            hw = r;
            reset = 0x111;
        } reserved_31_20[31:20];

        field {
            name = "trnk2rnk";
            desc = "Rank-to-rank delay 0000-1111: clock cycles";
            sw = rw;
            hw = r;
            reset = 0x3;
        } trnk2rnk[19:16];

        field {
            name = "tzqcs";
            desc = "ZQCS calibration delay period 0x0-0xFF: (n + 1) clock cycles";
            sw = rw;
            hw = r;
            reset = 0xFF;
        } tzqcs[15:8];

        field {
            name = "twr";
            desc = "Number of wait cycles of write recovery 0x0 and 0x1: one clock cycle 0x2-0x1F: n clock cycles";
            sw = rw;
            hw = r;
            reset = 0x1F;
        } twr[4:0];
    } DDRC_CFG_NXT_TIMING5 @ 0xB4;

    reg {
        name = "DDRC timing parameter 6 register 6 for switching the frequency";
        desc = "DDRC_CFG_NXT_TIMING6 is DDRC timing parameter register 6 for switching the frequency.

Data sheet 4.1.6 DDRC_CFG_NXT_TIMING6 (offset 0xB8, printed page 4-68, dump line 35381).";

        field {
            name = "todt_sft";
            desc = "ODT delay control in LPDDR3 mode, for compensating the delay of the DDR PHY for ODT IO of POP LPDDR3 0x0-0xF: n clock cycles ODT delay = tWL - taond + todt_sft. Note that the maximum ODT delay cannot exceed 0xF.";
            sw = rw;
            hw = r;
            reset = 0x0;
        } todt_sft[11:8];

        field {
            name = "tcksrx";
            desc = "tCKSRX for the DDR3 or DDR4, that is, number of advanced valid beats before the DDR exits the self-refresh status 0x0 and 0x1: one clock cycle 0x2-0xF: n clock cycles";
            sw = rw;
            hw = r;
            reset = 0xF;
        } tcksrx[7:4];

        field {
            name = "tcksre";
            desc = "tCKSRE for the DDR3 or DDR4, that is, number of beats to be retained after the DDR enters the self-refresh status 0x0 and 0x1: one clock cycle 0x2-0xF: clock cycles";
            sw = rw;
            hw = r;
            reset = 0xF;
        } tcksre[3:0];
    } DDRC_CFG_NXT_TIMING6 @ 0xB8;

    reg {
        name = "DDRC pre-received write data configuration register";
        desc = "DDRC_CFG_BLDATA is a DDRC pre-received write data configuration register.

Data sheet 4.1.6 DDRC_CFG_BLDATA (offset 0xBC, printed page 4-68, dump line 35415).";

        field {
            name = "bl_data";
            desc = "Number of DMC data segments corresponding to each DDR command in the current mode 0x0-0xF: n data segments";
            sw = rw;
            hw = r;
            reset = 0x2;
        } bl_data[3:0];
    } DDRC_CFG_BLDATA @ 0xBC;

    reg {
        name = "DDR ODT feature configuration register";
        desc = "DDRC_CFG_ODT is a DDR ODT feature configuration register.

Data sheet 4.1.6 DDRC_CFG_ODT (offset 0xC0, printed page 4-69, dump line 35440).";

        enum DDRC_CFG_ODT_rodt3_enum {
            DISABLED = 0 { name = "Disabled"; desc = "disabled"; };
            ENABLED = 1 { name = "Enabled"; desc = "enabled"; };
        };

        field {
            name = "rodt3";
            desc = "Read ODT enable for rank 3";
            sw = rw;
            hw = r;
            encode = DDRC_CFG_ODT_rodt3_enum;
            reset = 0x0;
        } rodt3[31:28];

        enum DDRC_CFG_ODT_rodt2_enum {
            DISABLED = 0 { name = "Disabled"; desc = "disabled"; };
            ENABLED = 1 { name = "Enabled"; desc = "enabled"; };
        };

        field {
            name = "rodt2";
            desc = "Read ODT enable for rank 2";
            sw = rw;
            hw = r;
            encode = DDRC_CFG_ODT_rodt2_enum;
            reset = 0x0;
        } rodt2[27:24];

        enum DDRC_CFG_ODT_rodt1_enum {
            DISABLED = 0 { name = "Disabled"; desc = "disabled"; };
            ENABLED = 1 { name = "Enabled"; desc = "enabled"; };
        };

        field {
            name = "rodt1";
            desc = "Read ODT enable for rank 1";
            sw = rw;
            hw = r;
            encode = DDRC_CFG_ODT_rodt1_enum;
            reset = 0x0;
        } rodt1[23:20];

        enum DDRC_CFG_ODT_rodt0_enum {
            DISABLED = 0 { name = "Disabled"; desc = "disabled"; };
            ENABLED = 1 { name = "Enabled"; desc = "enabled"; };
        };

        field {
            name = "rodt0";
            desc = "Read ODT enable for rank 0";
            sw = rw;
            hw = r;
            encode = DDRC_CFG_ODT_rodt0_enum;
            reset = 0x0;
        } rodt0[19:16];

        enum DDRC_CFG_ODT_wodt3_enum {
            DISABLED = 0 { name = "Disabled"; desc = "disabled"; };
            ENABLED = 1 { name = "Enabled"; desc = "enabled"; };
        };

        field {
            name = "wodt3";
            desc = "Write ODT enable for rank 3";
            sw = rw;
            hw = r;
            encode = DDRC_CFG_ODT_wodt3_enum;
            reset = 0x0;
        } wodt3[15:12];

        enum DDRC_CFG_ODT_wodt2_enum {
            DISABLED = 0 { name = "Disabled"; desc = "disabled"; };
            ENABLED = 1 { name = "Enabled"; desc = "enabled"; };
        };

        field {
            name = "wodt2";
            desc = "Write ODT enable for rank 2";
            sw = rw;
            hw = r;
            encode = DDRC_CFG_ODT_wodt2_enum;
            reset = 0x0;
        } wodt2[11:8];

        enum DDRC_CFG_ODT_wodt1_enum {
            DISABLED = 0 { name = "Disabled"; desc = "disabled"; };
            ENABLED = 1 { name = "Enabled"; desc = "enabled"; };
        };

        field {
            name = "wodt1";
            desc = "Write ODT enable for rank 1";
            sw = rw;
            hw = r;
            encode = DDRC_CFG_ODT_wodt1_enum;
            reset = 0x0;
        } wodt1[7:4];

        enum DDRC_CFG_ODT_wodt0_enum {
            DISABLED = 0 { name = "Disabled"; desc = "disabled"; };
            ENABLED = 1 { name = "Enabled"; desc = "enabled"; };
        };

        field {
            name = "wodt0";
            desc = "Write ODT enable for rank 0";
            sw = rw;
            hw = r;
            encode = DDRC_CFG_ODT_wodt0_enum;
            reset = 0x0;
        } wodt0[3:0];
    } DDRC_CFG_ODT @ 0xC0;

    reg {
        name = "DDRC command queue depth threshold configuration register";
        desc = "DDRC_CFG_DMCLVL is a DDRC command queue depth threshold configuration register.

Total Reset Value 0x0000010C: bit 8 is in the reserved field [31:5]; modelled as a `reserved_*` field.

Data sheet 4.1.6 DDRC_CFG_DMCLVL (offset 0xC4, printed page 4-70, dump line 35488).";

        field {
            name = "reserved_31_5";
            desc = "Reserved in the data sheet bit table, but the data sheet Total Reset Value has non-zero bits here (reset 0x8). Modelled so that the register reset matches the data sheet.";
            sw = r;
            hw = w;
            reset = 0x8;
        } reserved_31_5[31:5];

        field {
            name = "que_level";
            desc = "Depth of the command register FIFO in the DMC 0x1-0x10: depth of n commands Other values: reserved";
            sw = rw;
            hw = r;
            reset = 0xC;
        } que_level[4:0];
    } DDRC_CFG_DMCLVL @ 0xC4;

    reg {
        name = "DDR I/O configuration register";
        desc = "DDRC_CFG_DDRPHY is a DDR IO configuration register.

Data sheet 4.1.6 DDRC_CFG_DDRPHY (offset 0x200, printed page 4-70, dump line 35510).";

        enum DDRC_CFG_DDRPHY_phy_upden_enum {
            DISABLED = 0 { name = "Disabled"; desc = "disabled"; };
            ENABLED = 1 { name = "Enabled"; desc = "enabled"; };
        };

        field {
            name = "phy_upden";
            desc = "dfi_phyupd_en enable in response to the DDR PHY";
            sw = rw;
            hw = r;
            encode = DDRC_CFG_DDRPHY_phy_upden_enum;
            reset = 0x1;
        } phy_upden[12:12];

        field {
            name = "trdlat";
            desc = "Inherent delay of the DDR PHY 0x0-0xF: (n + 1) clock cycles The value needs to be set to 8 when synopsys3/2phy is used.";
            sw = rw;
            hw = r;
            reset = 0x0;
        } trdlat[11:8];

        enum DDRC_CFG_DDRPHY_phy_zqen_enum {
            DISABLED = 0 { name = "Disabled"; desc = "disabled"; };
            ENABLED = 1 { name = "Enabled"; desc = "enabled"; };
        };

        field {
            name = "phy_zqen";
            desc = "DDRPHY dfi_ctrlupd_req enable";
            sw = rw;
            hw = r;
            encode = DDRC_CFG_DDRPHY_phy_zqen_enum;
            reset = 0x0;
        } phy_zqen[4:4];
    } DDRC_CFG_DDRPHY @ 0x200;

    reg {
        name = "DDRC software DDR command attribute register";
        desc = "DDRC_CFG_SFC is a DDRC software DDR command attribute register.

Data sheet 4.1.6 DDRC_CFG_SFC (offset 0x210, printed page 4-71, dump line 35556).";

        field {
            name = "cmd_mrs";
            desc = "Value of the DDR mode register when the LMR command is configured. This field is valid for the lower eight bits of the LPDDR2.";
            sw = rw;
            hw = r;
            reset = 0x0;
        } cmd_mrs[31:16];

        field {
            name = "cmd_ma";
            desc = "Address for the mode register to be configured when the LMR command is configured in LPDDR mode";
            sw = rw;
            hw = r;
            reset = 0x0;
        } cmd_ma[15:8];

        enum DDRC_CFG_SFC_cmd_rank_enum {
            CONFIGURATION_COMMAND_NOT = 0 { name = "Configuration Command Not"; desc = "The configuration command is not executed."; };
            CONFIGURATION_COMMAND_EXECUTED = 1 { name = "Configuration Command Executed"; desc = "The configuration command is executed."; };
        };

        field {
            name = "cmd_rank";
            desc = "DDR rank for executing commands";
            sw = rw;
            hw = r;
            encode = DDRC_CFG_SFC_cmd_rank_enum;
            reset = 0x0;
        } cmd_rank[7:4];

        enum DDRC_CFG_SFC_cmd_type_enum {
            ENTER_DEEP_POWER = 0 { name = "Enter Deep Power"; desc = "enter the deep power-down status"; };
            EXIT_DEEP_POWER = 1 { name = "Exit Deep Power"; desc = "exit the deep power-down status"; };
            LMR_COMMAND = 2 { name = "Lmr Command"; desc = "LMR command"; };
            ZQCL = 3 { name = "Zqcl"; desc = "ZQCL"; };
            WRITE_COMMAND = 4 { name = "Write Command"; desc = "WRITE command"; };
            READ_COMMAND = 5 { name = "Read Command"; desc = "read command"; };
            PRECHARGE_ALL_COMMAND = 6 { name = "Precharge All Command"; desc = "precharge all command"; };
            READ_MRS_COMMAND = 7 { name = "Read Mrs Command"; desc = "read MRS command"; };
        };

        field {
            name = "cmd_type";
            desc = "DDR command configuration";
            sw = rw;
            hw = r;
            encode = DDRC_CFG_SFC_cmd_type_enum;
            reset = 0x0;
        } cmd_type[2:0];
    } DDRC_CFG_SFC @ 0x210;

    reg {
        name = "Read/Write memory address register 0 for the software configuration module";
        desc = "DDRC_CFG_SFC_ADDR0 is read/write memory address register 0 for the software configuration module.

Data sheet 4.1.6 DDRC_CFG_SFC_ADDR0 (offset 0x214, printed page 4-72, dump line 35608).";

        field {
            name = "sfc_row";
            desc = "Row address for the memory that is read or written by the software configuration module.";
            sw = rw;
            hw = r;
            reset = 0x0;
        } sfc_row[31:16];

        field {
            name = "sfc_col";
            desc = "Column address for the memory that is read or written by the software configuration module. The DDRC access address must be aligned to the current DMC bit width, e.g. for a 128-bit DMC and 64-/72-bit external DDR the DMC addresses are accessed as {sfc_col[15:1], 1'b0}; for 32-/36-bit external DDR as {sfc_col[15:2], 2'b0} (data sheet text).";
            sw = rw;
            hw = r;
            reset = 0x0;
        } sfc_col[15:0];
    } DDRC_CFG_SFC_ADDR0 @ 0x214;

    reg {
        name = "Read/Write memory address register 1 for the software configuration module";
        desc = "DDRC_CFG_SFC_ADDR1 is read/write memory address register 1 for the software configuration module.

Data sheet 4.1.6 DDRC_CFG_SFC_ADDR1 (offset 0x218, printed page 4-72, dump line 35640).";

        field {
            name = "sfc_bank";
            desc = "Bank address for the memory that is read or written by the software configuration module";
            sw = rw;
            hw = r;
            reset = 0x0;
        } sfc_bank[2:0];
    } DDRC_CFG_SFC_ADDR1 @ 0x218;

    reg {
        name = "Write data register 0 for the 0 software configuration module";
        desc = "DDRC_CFG_SFC_WDATA0 is write data configuration register 0 for the software configuration module.

Data sheet 4.1.6 DDRC_CFG_SFC_WDATA0 (offset 0x21C, printed page 4-73, dump line 35674).";

        field {
            name = "wdata0";
            desc = "Bits 127-96 of the written data of the software configuration module";
            sw = rw;
            hw = r;
            reset = 0x0;
        } wdata0[31:0];
    } DDRC_CFG_SFC_WDATA0 @ 0x21C;

    reg {
        name = "Write data register 1 for the 1 software configuration module";
        desc = "DDRC_CFG_SFC_WDATA1 is write data configuration register 1 for the software configuration module.

Data sheet 4.1.6 DDRC_CFG_SFC_WDATA1 (offset 0x220, printed page 4-73, dump line 35696).";

        field {
            name = "wdata1";
            desc = "Bits 95-64 of the written data of the software configuration module";
            sw = rw;
            hw = r;
            reset = 0x0;
        } wdata1[31:0];
    } DDRC_CFG_SFC_WDATA1 @ 0x220;

    reg {
        name = "Write data register 2 for the 2 software configuration module";
        desc = "DDRC_CFG_SFC_WDATA2 is write data configuration register 2 for the software configuration module.

Data sheet 4.1.6 DDRC_CFG_SFC_WDATA2 (offset 0x224, printed page 4-74, dump line 35728).";

        field {
            name = "wdata2";
            desc = "Bits 63-32 of the written data of the software configuration module";
            sw = rw;
            hw = r;
            reset = 0x0;
        } wdata2[31:0];
    } DDRC_CFG_SFC_WDATA2 @ 0x224;

    reg {
        name = "Write data register 3 for the 3 software configuration module";
        desc = "DDRC_CFG_SFC_WDATA3 is write data configuration register 3 for the software configuration module.

Data sheet 4.1.6 DDRC_CFG_SFC_WDATA3 (offset 0x228, printed page 4-74, dump line 35749).";

        field {
            name = "wdata3";
            desc = "Bits 31-0 of the written data of the software configuration module";
            sw = rw;
            hw = r;
            reset = 0x0;
        } wdata3[31:0];
    } DDRC_CFG_SFC_WDATA3 @ 0x228;

    reg {
        name = "DDRC performance statistics mode register";
        desc = "DDRC_CFG_PERF is a DDRC performance statistics mode register.

Data sheet 4.1.6 DDRC_CFG_PERF (offset 0x270, printed page 4-74, dump line 35767).";

        enum DDRC_CFG_PERF_flux_en_enum {
            DISABLED = 0 { name = "Disabled"; desc = "disabled"; };
            ENABLED_WHEN_TRAFFIC = 1 { name = "Enabled When Traffic"; desc = "enabled When traffic monitoring is enabled, the statistics module provides the number of cycles occupied by the DDR interface by ID to each request port. The traffic can be controlled by using this field and the port traffic setting function."; };
        };

        field {
            name = "flux_en";
            desc = "DMC traffic monitoring enable";
            sw = rw;
            hw = r;
            encode = DDRC_CFG_PERF_flux_en_enum;
            reset = 0x0;
        } flux_en[29:29];

        enum DDRC_CFG_PERF_perf_mode_enum {
            CONTINUOUS_TRIGGER_MODE = 0 { name = "Continuous Trigger Mode"; desc = "continuous trigger mode. The performance counter continues to count. This ensures no overflow within 1s in continuous count mode."; };
            SINGLE_TRIGGER_MODE = 1 { name = "Single Trigger Mode"; desc = "single trigger mode. When the performance statistics time reaches perf_prd, the count value is retained and counting stops."; };
        };

        field {
            name = "perf_mode";
            desc = "Performance statistical mode";
            sw = rw;
            hw = r;
            encode = DDRC_CFG_PERF_perf_mode_enum;
            reset = 0x0;
        } perf_mode[28:28];

        field {
            name = "perf_prd";
            desc = "Performance statistics cycle 0x0-0x1: invalid 0x2-0xFFFFFFF: statistics cycles The actual statistics cycle is perf_prd x 16 x tclk (tclk is the bus clock cycle of the DDRC)";
            sw = rw;
            hw = r;
            reset = 0x0;
        } perf_prd[27:0];
    } DDRC_CFG_PERF @ 0x270;

    reg {
        name = "DDRC performance statistics command ID register";
        desc = "DDRC_CFG_STAID is a DDRC performance statistics command ID register.

Data sheet 4.1.6 DDRC_CFG_STAID (offset 0x274, printed page 4-75, dump line 35830).";

        field {
            name = "sta_id";
            desc = "Performance statistics by a specified ID. This field works with sta_idmask.";
            sw = rw;
            hw = r;
            reset = 0x0;
        } sta_id[20:0];
    } DDRC_CFG_STAID @ 0x274;

    reg {
        name = "DDR performance statistics command ID mask register";
        desc = "DDRC_CFG_STAIDMSK is a DDR performance statistics command ID mask register.

Data sheet 4.1.6 DDRC_CFG_STAIDMSK (offset 0x278, printed page 4-76, dump line 35858).";

        field {
            name = "sta_idmask";
            desc = "Specified ID mask The DDRC performance statistics register collects statistics only for specified ID commands. Cmd_id&sta_idmask = sta_id";
            sw = rw;
            hw = r;
            reset = 0x1FFF;
        } sta_idmask[12:0];
    } DDRC_CFG_STAIDMSK @ 0x278;

    reg {
        name = "DDRC interrupt mask register";
        desc = "DDRC_INTMSK is a DDRC interrupt mask register.

Data sheet 4.1.6 DDRC_INTMSK (offset 0x280, printed page 4-76, dump line 35882).";

        enum DDRC_INTMSK_aref_alarm_int_mask_enum {
            ENABLED = 0 { name = "Enabled"; desc = "enabled"; };
            DISABLED = 1 { name = "Disabled"; desc = "disabled"; };
        };

        field {
            name = "aref_alarm_int_mask";
            desc = "DDR AREF command error interrupt mask enable";
            sw = rw;
            hw = r;
            encode = DDRC_INTMSK_aref_alarm_int_mask_enum;
            reset = 0x0;
        } aref_alarm_int_mask[16:16];

        enum DDRC_INTMSK_rdtimeout_int_mask_enum {
            ENABLED = 0 { name = "Enabled"; desc = "enabled"; };
            DISABLED = 1 { name = "Disabled"; desc = "disabled"; };
        };

        field {
            name = "rdtimeout_int_mask";
            desc = "DDR PHY read data timeout interrupt mask enable";
            sw = rw;
            hw = r;
            encode = DDRC_INTMSK_rdtimeout_int_mask_enum;
            reset = 0x0;
        } rdtimeout_int_mask[12:12];

        enum DDRC_INTMSK_sref_err_int_mask_enum {
            ENABLED = 0 { name = "Enabled"; desc = "enabled"; };
            DISABLED = 1 { name = "Disabled"; desc = "disabled"; };
        };

        field {
            name = "sref_err_int_mask";
            desc = "Interface command error interrupt enable in DDR self-refresh mode";
            sw = rw;
            hw = r;
            encode = DDRC_INTMSK_sref_err_int_mask_enum;
            reset = 0x0;
        } sref_err_int_mask[5:5];

        enum DDRC_INTMSK_flux_int_mask_enum {
            ENABLED = 0 { name = "Enabled"; desc = "enabled"; };
            DISABLED = 1 { name = "Disabled"; desc = "disabled"; };
        };

        field {
            name = "flux_int_mask";
            desc = "DDR FLUX statistics period reach interrupt mask enable";
            sw = rw;
            hw = r;
            encode = DDRC_INTMSK_flux_int_mask_enum;
            reset = 0x0;
        } flux_int_mask[1:1];

        enum DDRC_INTMSK_serr_int_mask_enum {
            ENABLED = 0 { name = "Enabled"; desc = "enabled"; };
            DISABLED = 1 { name = "Disabled"; desc = "disabled"; };
        };

        field {
            name = "serr_int_mask";
            desc = "DDR ECC single-bit error interrupt mask enable";
            sw = rw;
            hw = r;
            encode = DDRC_INTMSK_serr_int_mask_enum;
            reset = 0x0;
        } serr_int_mask[0:0];
    } DDRC_INTMSK @ 0x280;

    reg {
        name = "DDRC raw interrupt register";
        desc = "DDRC_RINT is a DDRC raw interrupt register.

The data sheet access word of the interrupt bits is `INT_WC` (raw interrupt, write 1 to clear); the bit table rows were not understood by the extraction tool and the fields were entered by hand from the data sheet text (lines 35943-35995). flux_rint is printed `RW` but its text says writing 1 clears it: modelled write-1-to-clear.

Data sheet 4.1.6 DDRC_RINT (offset 0x284, printed page 4-77, dump line 35943).";

        field {
            name = "aref_alarm_rint";
            desc = "DDR AREF command error raw interrupt. Writing 1 clears the interrupt.";
            sw = rw;
            hw = w;
            onwrite = woclr;
            reset = 0x0;
        } aref_alarm_rint[16:16];

        field {
            name = "rdtimeout_rint";
            desc = "DDR PHY read data timeout raw interrupt. Writing 1 clears the interrupt.";
            sw = rw;
            hw = w;
            onwrite = woclr;
            reset = 0x0;
        } rdtimeout_rint[12:12];

        field {
            name = "sref_err_rint";
            desc = "Self-refresh interface command access interrupt. Writing 1 clears the interrupt.";
            sw = rw;
            hw = w;
            onwrite = woclr;
            reset = 0x0;
        } sref_err_rint[5:5];

        field {
            name = "flux_rint";
            desc = "DDR FLUX statistics period reach interrupt. Writing 1 clears the interrupt. DDR ECC single-bit error raw interrupt. Writing 1 clears the interrupt.";
            sw = rw;
            hw = w;
            onwrite = woclr;
            reset = 0x0;
        } flux_rint[1:1];

        field {
            name = "serr_rint";
            desc = "DDR ECC single-bit error raw interrupt. Writing 1 clears the interrupt.";
            sw = rw;
            hw = w;
            onwrite = woclr;
            reset = 0x0;
        } serr_rint[0:0];
    } DDRC_RINT @ 0x284;

    reg {
        name = "DDRC interrupt status register";
        desc = "DDRC_INTSTS is a DDRC interrupt status register.

The data sheet access word of the status bits is `INT` (read-only masked status); the fields were entered by hand from the data sheet text (lines 36017-36024). flux_intsts is printed `RW`: modelled read-only (it is the masked status of flux_rint).

Data sheet 4.1.6 DDRC_INTSTS (offset 0x288, printed page 4-78, dump line 35999).";

        field {
            name = "aref_alarm_intsts";
            desc = "DDR AREF command error interrupt";
            sw = r;
            hw = w;
            reset = 0x0;
        } aref_alarm_intsts[16:16];

        field {
            name = "rdtimeout_intsts";
            desc = "DDR PHY read data timeout interrupt";
            sw = r;
            hw = w;
            reset = 0x0;
        } rdtimeout_intsts[12:12];

        field {
            name = "sref_err_intsts";
            desc = "Self-refresh interface command access interrupt";
            sw = r;
            hw = w;
            reset = 0x0;
        } sref_err_intsts[5:5];

        field {
            name = "flux_intsts";
            desc = "DDR FLUX statistics period reach interrupt DDR ECC single-bit error interrupt";
            sw = r;
            hw = w;
            reset = 0x0;
        } flux_intsts[1:1];

        field {
            name = "serr_intsts";
            desc = "DDR ECC single-bit error interrupt";
            sw = r;
            hw = w;
            reset = 0x0;
        } serr_intsts[0:0];
    } DDRC_INTSTS @ 0x288;

    reg {
        name = "DDRC status register";
        desc = "DDRC_CURR_STATUS is a DDRC status register.

Data sheet 4.1.6 DDRC_CURR_STATUS (offset 0x290, printed page 4-79, dump line 36043).";

        enum DDRC_CURR_STATUS_busy_func_enum {
            IDLE = 0 { name = "Idle"; desc = "idle"; };
            COMMAND_BEING_PROCESSED = 1 { name = "Command Being Processed"; desc = "A command is being processed."; };
        };

        field {
            name = "busy_func";
            desc = "Status of the DDRC FUNC module. This field is in the SREF status during reset.";
            sw = r;
            hw = w;
            encode = DDRC_CURR_STATUS_busy_func_enum;
            reset = 0x1;
        } busy_func[8:8];

        enum DDRC_CURR_STATUS_busy_dmc_enum {
            IDLE = 0 { name = "Idle"; desc = "idle"; };
            COMMAND_BEING_PROCESSED = 1 { name = "Command Being Processed"; desc = "A command is being processed."; };
        };

        field {
            name = "busy_dmc";
            desc = "Status of the DDRC DMC";
            sw = r;
            hw = w;
            encode = DDRC_CURR_STATUS_busy_dmc_enum;
            reset = 0x0;
        } busy_dmc[4:4];

        enum DDRC_CURR_STATUS_busy_enum {
            IDLE = 0 { name = "Idle"; desc = "idle"; };
            COMMAND_BEING_PROCESSED = 1 { name = "Command Being Processed"; desc = "A command is being processed."; };
        };

        field {
            name = "busy";
            desc = "Overall status of the DDRC";
            sw = r;
            hw = w;
            encode = DDRC_CURR_STATUS_busy_enum;
            reset = 0x1;
        } busy[0:0];
    } DDRC_CURR_STATUS @ 0x290;

    reg {
        name = "DDRC FUNC module status register";
        desc = "DDRC_CURR_FUNC is a DDRC FUNC module status register.

Data sheet 4.1.6 DDRC_CURR_FUNC (offset 0x294, printed page 4-79, dump line 36081).

Hardware (Hi3518E V200 board, live dump): reads 0x00000000 at U-Boot and under Linux after a completed init: in_sref 0, in_init 0, dfi_init_complete 0. dfi_init_complete is therefore not a level that stays 1 after init (or it reads 0 here); do not poll it for completion after init.";

        enum DDRC_CURR_FUNC_in_phyupd_enum {
            IDLE = 0 { name = "Idle"; desc = "idle"; };
            PHY_BEING_UPDATED = 1 { name = "Phy Being Updated"; desc = "The PHY is being updated."; };
        };

        field {
            name = "in_phyupd";
            desc = "DDRC PHY update status";
            sw = r;
            hw = w;
            encode = DDRC_CURR_FUNC_in_phyupd_enum;
            reset = 0x0;
        } in_phyupd[28:28];

        enum DDRC_CURR_FUNC_in_sfc_enum {
            IDLE = 0 { name = "Idle"; desc = "idle"; };
            SFC_COMMAND_BEING = 1 { name = "Sfc Command Being"; desc = "An SFC command is being processed."; };
        };

        field {
            name = "in_sfc";
            desc = "DDRC SFC status";
            sw = r;
            hw = w;
            encode = DDRC_CURR_FUNC_in_sfc_enum;
            reset = 0x0;
        } in_sfc[12:12];

        field {
            name = "in_pd";
            desc = "DDRC power-down status 0: normal 0: power-down status Each bit represents a rank.";
            sw = r;
            hw = w;
            reset = 0x0;
        } in_pd[11:8];

        enum DDRC_CURR_FUNC_dfi_init_complete_enum {
            INITIALIZING = 0 { name = "Initializing"; desc = "initializing"; };
            NORMAL_OPERATING_MODE = 1 { name = "Normal Operating Mode"; desc = "normal operating mode"; };
        };

        field {
            name = "dfi_init_complete";
            desc = "DFI initialization status";
            sw = r;
            hw = w;
            encode = DDRC_CURR_FUNC_dfi_init_complete_enum;
            reset = 0x0;
        } dfi_init_complete[5:5];

        enum DDRC_CURR_FUNC_in_init_enum {
            NORMAL = 0 { name = "Normal"; desc = "normal"; };
            INITIALIZING = 1 { name = "Initializing"; desc = "initializing"; };
        };

        field {
            name = "in_init";
            desc = "DDRC initialization status";
            sw = r;
            hw = w;
            encode = DDRC_CURR_FUNC_in_init_enum;
            reset = 0x0;
        } in_init[4:4];

        enum DDRC_CURR_FUNC_in_sref_enum {
            NORMAL = 0 { name = "Normal"; desc = "normal"; };
            SELF_REFRESH = 1 { name = "Self Refresh"; desc = "self-refresh"; };
        };

        field {
            name = "in_sref";
            desc = "DDR self-refresh status";
            sw = r;
            hw = w;
            encode = DDRC_CURR_FUNC_in_sref_enum;
            reset = 0x1;
        } in_sref[0:0];
    } DDRC_CURR_FUNC @ 0x294;

    reg {
        name = "DDRC command state machine status register";
        desc = "DDRC_CURR_EXECST is a DDRC command state machine status register.

Data sheet 4.1.6 DDRC_CURR_EXECST (offset 0x2A0, printed page 4-80, dump line 36137).";

        enum DDRC_CURR_EXECST_dmc_ct_enum {
            READ_COMMAND = 0x0 { name = "Read Command"; desc = "read command"; };
            WRITE_COMMAND = 0x1 { name = "Write Command"; desc = "write command"; };
        };

        field {
            name = "dmc_ct";
            desc = "Controller command type";
            sw = r;
            hw = w;
            encode = DDRC_CURR_EXECST_dmc_ct_enum;
            reset = 0x0;
        } dmc_ct[31:16];

        enum DDRC_CURR_EXECST_dmc_cv_enum {
            INVALID = 0x0 { name = "Invalid"; desc = "invalid"; };
            VALID = 0x1 { name = "Valid"; desc = "valid"; };
        };

        field {
            name = "dmc_cv";
            desc = "Controller command validity flag";
            sw = r;
            hw = w;
            encode = DDRC_CURR_EXECST_dmc_cv_enum;
            reset = 0x0;
        } dmc_cv[15:0];
    } DDRC_CURR_EXECST @ 0x2A0;

    reg {
        name = "DDRC write data FIFO status register";
        desc = "DDRC_CURR_WGFIFOST is a DDRC write data FIFO status register.

Data sheet 4.1.6 DDRC_CURR_WGFIFOST (offset 0x2A4, printed page 4-81, dump line 36170).";

        enum DDRC_CURR_WGFIFOST_wgntfifo_e_enum {
            NOT_EMPTY = 0 { name = "Not Empty"; desc = "not empty"; };
            EMPTY = 1 { name = "Empty"; desc = "empty"; };
        };

        field {
            name = "wgntfifo_e";
            desc = "WGNT_FIFO empty or full status. The empty status indicates that all written data is received, and the non-empty status indicates that the written data is not completely received.";
            sw = r;
            hw = w;
            encode = DDRC_CURR_WGFIFOST_wgntfifo_e_enum;
            reset = 0x1;
        } wgntfifo_e[0:0];
    } DDRC_CURR_WGFIFOST @ 0x2A4;

    reg {
        name = "DDRC all write command traffic statistics register";
        desc = "DDRC_HIS_FLUX_WR is a DDRC all write command traffic statistics register.

Data sheet 4.1.6 DDRC_HIS_FLUX_WR (offset 0x380, printed page 4-81, dump line 36201).";

        field {
            name = "flux_wr";
            desc = "Write traffic statistics of all masters with the IDs of the DDRC. The counting is performed in the valid statistics cycle. The unit is the DMC bit width. When perf_mode is 0, the value is wrapped when overflow occurs. When perf_mode is 1, the value is retained when overflow occurs. This field is cleared when the next statistics start.";
            sw = r;
            hw = w;
            reset = 0x0;
        } flux_wr[31:0];
    } DDRC_HIS_FLUX_WR @ 0x380;

    reg {
        name = "DDRC all read command traffic statistics register";
        desc = "DDRC_HIS_FLUX_RD is a DDRC all read command traffic statistics register.

Data sheet 4.1.6 DDRC_HIS_FLUX_RD (offset 0x384, printed page 4-82, dump line 36235).";

        field {
            name = "flux_rd";
            desc = "Read traffic statistics of all masters with the IDs of the DDRC. The counting is performed in the valid statistics cycle. The unit is the DMC bit width. When perf_mode is 0, the value is wrapped when overflow occurs. When perf_mode is 1, the value is retained when overflow occurs. This field is cleared when the next statistics start.";
            sw = r;
            hw = w;
            reset = 0x0;
        } flux_rd[31:0];
    } DDRC_HIS_FLUX_RD @ 0x384;

    reg {
        name = "DDRC all write command count register";
        desc = "DDRC_HIS_FLUX_WCMD is a DDRC all write command count register.

Data sheet 4.1.6 DDRC_HIS_FLUX_WCMD (offset 0x388, printed page 4-82, dump line 36259).";

        field {
            name = "flux_wr_cmd";
            desc = "Write command count of the masters with all IDs of the DDRC. The counting is performed in the valid statistics cycle.";
            sw = r;
            hw = w;
            reset = 0x0;
        } flux_wr_cmd[31:0];
    } DDRC_HIS_FLUX_WCMD @ 0x388;

    reg {
        name = "DDRC all read command";
        desc = "DDRC_HIS_FLUX_RCMD is a DDRC all read command count register.

Data sheet 4.1.6 DDRC_HIS_FLUX_RCMD (offset 0x38C, printed page 4-83, dump line 36292).";

        field {
            name = "flux_rd_cmd";
            desc = "Read command count of the masters with all IDs of the DDRC. The counting is performed in the valid statistics cycle. When perf_mode is 0, the value is wrapped when overflow occurs. When perf_mode is 1, the value is retained when overflow occurs. This field is cleared when the next statistics start.";
            sw = r;
            hw = w;
            reset = 0x0;
        } flux_rd_cmd[31:0];
    } DDRC_HIS_FLUX_RCMD @ 0x38C;

    reg {
        name = "DDRC specified ID write traffic statistics registers";
        desc = "DDRC_HIS_FLUXID_WR is a DDRC specified ID write traffic statistics registers.

Data sheet 4.1.6 DDRC_HIS_FLUXID_WR (offset 0x390, printed page 4-83, dump line 36314).";

        field {
            name = "fluxid_wr";
            desc = "Write traffic statistics of the master with the specified ID of the DDRC. The counting is performed in the valid statistics cycle. The unit is the DMC bit width. When perf_mode is 0, the value is wrapped when overflow occurs. When perf_mode is 1, the value is retained when overflow occurs. This field is cleared when the next statistics start.";
            sw = r;
            hw = w;
            reset = 0x0;
        } fluxid_wr[31:0];
    } DDRC_HIS_FLUXID_WR @ 0x390;

    reg {
        name = "DDRC specified ID read traffic statistics registers";
        desc = "DDRC_HIS_FLUXID_RD is a DDRC specified ID read traffic statistics registers.

Data sheet 4.1.6 DDRC_HIS_FLUXID_RD (offset 0x394, printed page 4-84, dump line 36344).";

        field {
            name = "fluxid_rd";
            desc = "Read traffic statistics of the master with the specified ID of the DDRC. The counting is performed in the valid statistics cycle. The unit is the DMC bit width. When perf_mode is 0, the value is wrapped when overflow occurs. When perf_mode is 1, the value is retained when overflow occurs. This field is cleared when the next statistics start.";
            sw = r;
            hw = w;
            reset = 0x0;
        } fluxid_rd[31:0];
    } DDRC_HIS_FLUXID_RD @ 0x394;

    reg {
        name = "DDRC all ID write MD command count register";
        desc = "DDRC_HIS_FLUXID_WCMD is a DDRC all ID write command count register.

Data sheet 4.1.6 DDRC_HIS_FLUXID_WCMD (offset 0x398, printed page 4-84, dump line 36368).";

        field {
            name = "fluxid_wr_cmd";
            desc = "Read traffic statistics of the master based on specified IDs. The counting is performed in the valid statistics cycle. The unit is the DMC bit width. When perf_mode is 0, the value is wrapped when overflow occurs. When perf_mode is 1, the value is retained when overflow occurs. This field is cleared when the next statistics start.";
            sw = r;
            hw = w;
            reset = 0x0;
        } fluxid_wr_cmd[31:0];
    } DDRC_HIS_FLUXID_WCMD @ 0x398;

    reg {
        name = "DDRC all ID read command D count register";
        desc = "DDRC_HIS_FLUXID_RCMD is a DDRC all ID read command count register.

Data sheet 4.1.6 DDRC_HIS_FLUXID_RCMD (offset 0x39C, printed page 4-85, dump line 36402).";

        field {
            name = "fluxid_rd_cmd";
            desc = "Read command count of the master based on specified IDs. The counting is performed in the valid statistics cycle. When perf_mode is 0, the value is wrapped when overflow occurs. When perf_mode is 1, the value is retained when overflow occurs. This field is cleared when the next statistics start.";
            sw = r;
            hw = w;
            reset = 0x0;
        } fluxid_rd_cmd[31:0];
    } DDRC_HIS_FLUXID_RCMD @ 0x39C;

    reg {
        name = "DDRC specified ID write command latency statistics register 0";
        desc = "DDRC_HIS_WLATCNT0 is DDRC specified ID write command latency statistics register 0.

Data sheet 4.1.6 DDRC_HIS_WLATCNT0 (offset 0x3A0, printed page 4-85, dump line 36424).";

        field {
            name = "wlatcnt_max";
            desc = "Maximum latency of the write command with the specified ID of the DDRC This field is cleared when the next statistics start.";
            sw = r;
            hw = w;
            reset = 0x0;
        } wlatcnt_max[31:16];

        field {
            name = "wlatcnt_min";
            desc = "Minimum latency of the write command with the specified ID of the DDRC. The maximum value is retained if overflow occurs. This field is cleared when the next statistics start.";
            sw = r;
            hw = w;
            reset = 0xFFFF;
        } wlatcnt_min[15:0];
    } DDRC_HIS_WLATCNT0 @ 0x3A0;

    reg {
        name = "DDRC specified ID write command latency statistics register 1";
        desc = "DDRC_HIS_WLATCNT1 is DDRC specified ID write command latency statistics register 1.

Data sheet 4.1.6 DDRC_HIS_WLATCNT1 (offset 0x3A4, printed page 4-85, dump line 36447).";

        field {
            name = "wlatcnt_all";
            desc = "Accumulated latency of the write command with the specified ID in the statistics cycle (the results of the lower four bits are ignored) When perf_mode is 0, the value is wrapped when overflow occurs. When perf_mode is 1, the value is retained when overflow occurs. This field is cleared when the next statistics start.";
            sw = r;
            hw = w;
            reset = 0x0;
        } wlatcnt_all[31:0];
    } DDRC_HIS_WLATCNT1 @ 0x3A4;

    reg {
        name = "DDRC specified ID read command latency statistics register 0";
        desc = "DDRC_HIS_RLATCNT0 is a DDRC specified ID read command latency statistics register 0.

Data sheet 4.1.6 DDRC_HIS_RLATCNT0 (offset 0x3A8, printed page 4-86, dump line 36484).";

        field {
            name = "rlatcnt_max";
            desc = "Maximum latency of the read command with the specified ID of the DDRC The actual maximum read latency is rlatcnt_max plus inhere_rlatcnt. The maximum value is retained if overflow occurs. This field is cleared when the next statistics start.";
            sw = r;
            hw = w;
            reset = 0x0;
        } rlatcnt_max[31:16];

        field {
            name = "rlatcnt_min";
            desc = "Minimum latency of the read command with the specified ID of the DDRC Note that the actual minimum read latency is rlatcnt_min plus inhere_rlatcnt. The maximum value is retained if overflow occurs. This field is cleared when the next statistics start.";
            sw = r;
            hw = w;
            reset = 0xFFFF;
        } rlatcnt_min[15:0];
    } DDRC_HIS_RLATCNT0 @ 0x3A8;

    reg {
        name = "DDRC specified ID read command latency statistics register 1";
        desc = "DDRC_HIS_RLATCNT1 is DDRC specified ID read command latency statistics register 1.

Data sheet 4.1.6 DDRC_HIS_RLATCNT1 (offset 0x3AC, printed page 4-87, dump line 36523).";

        field {
            name = "rlatcnt_all";
            desc = "Accumulated latency of the read command with the specified ID in the statistics cycle (the results of the lower four bits are ignored) When perf_mode is 0, the value is wrapped when overflow occurs. When perf_mode is 1, the value is retained when overflow occurs. This field is cleared when the next statistics start.";
            sw = r;
            hw = w;
            reset = 0x0;
        } rlatcnt_all[31:0];
    } DDRC_HIS_RLATCNT1 @ 0x3AC;

    reg {
        name = "Read channel inherent T_CNT latency register";
        desc = "DDRC_HIS_INHERE_RLAT_CNT is a read channel inherent latency register.

Data sheet 4.1.6 DDRC_HIS_INHERE_RLAT_CNT (offset 0x3B0, printed page 4-87, dump line 36550).";

        field {
            name = "inhere_rlatcnt";
            desc = "Inherent latency of the read data channel for the DDRC and PHY. The actual latency can be obtained only by using this register and rlatcnt_min, rlatcnt_max, rlatcnt_all, and fluxid_rd_cmd.";
            sw = r;
            hw = w;
            reset = 0x0;
        } inhere_rlatcnt[15:0];
    } DDRC_HIS_INHERE_RLAT_CNT @ 0x3B0;

    reg {
        name = "DMC accumulated command count register";
        desc = "DDRC_HIS_CMD_SUM is a DDRC accumulated command count register.

Data sheet 4.1.6 DDRC_HIS_CMD_SUM (offset 0x3BC, printed page 4-87, dump line 36572).";

        field {
            name = "dmc_cmd_sum";
            desc = "Accumulated value of the commands that are temporarily stored in the DMC in the cycle. The value is wrapped if overflow occurs.";
            sw = r;
            hw = w;
            reset = 0x0;
        } dmc_cmd_sum[31:0];
    } DDRC_HIS_CMD_SUM @ 0x3BC;

`ifdef DDRC_V2_CV300
    reg {
        name = "SFC read data register 0";
        desc = "DDRC_HIS_SFC_RDATA0 is an SFC read data register.

Hi3516C V300 / E V100 edition: the data sheet documents four SFC read data registers 0x4A8..0x4B4 holding bits 127:0 of the data read by the software configuration module (field names rdata4..rdata7 as printed), matching the vendor U-Boot header `ddr_ddrc_v500.h` (DDR_DMC_SFC_RDATA0..3 = data[127:96]..data[31:0]). The Hi3518E V20X data sheet instead documents RDATA3..7 and RDATA_ECC at 0x4B4..0x4C8 (see the default branch). Printed access RW; modelled read-only.

Data sheet 4.1.6 DDRC_HIS_SFC_RDATA0 (offset 0x4A8, printed page 4-84, Hi3516C V300 dump line 19795).";

        field {
            name = "rdata4";
            desc = "Bits 127-96 of the data read by the SFC";
            sw = r;
            hw = w;
            reset = 0x0;
        } rdata4[31:0];
    } DDRC_HIS_SFC_RDATA0 @ 0x4A8;

    reg {
        name = "SFC read data register 1";
        desc = "DDRC_HIS_SFC_RDATA1 is an SFC read data register (Hi3516C V300 / E V100 edition; printed access RW, modelled read-only).

Data sheet 4.1.6 DDRC_HIS_SFC_RDATA1 (offset 0x4AC, printed page 4-84, Hi3516C V300 dump line 19814).";

        field {
            name = "rdata5";
            desc = "Bits 95-64 of the data read by the SFC";
            sw = r;
            hw = w;
            reset = 0x0;
        } rdata5[31:0];
    } DDRC_HIS_SFC_RDATA1 @ 0x4AC;

    reg {
        name = "SFC read data register 2";
        desc = "DDRC_HIS_SFC_RDATA2 is an SFC read data register (Hi3516C V300 / E V100 edition; printed access RW, modelled read-only).

Data sheet 4.1.6 DDRC_HIS_SFC_RDATA2 (offset 0x4B0, printed page 4-84, Hi3516C V300 dump line 19842).";

        field {
            name = "rdata6";
            desc = "Bits 63-32 of the data read by the SFC";
            sw = r;
            hw = w;
            reset = 0x0;
        } rdata6[31:0];
    } DDRC_HIS_SFC_RDATA2 @ 0x4B0;

    reg {
        name = "SFC read data register 3";
        desc = "DDRC_HIS_SFC_RDATA3 is an SFC read data register (Hi3516C V300 / E V100 edition: the lowest data word; printed access RW, modelled read-only).

Data sheet 4.1.6 DDRC_HIS_SFC_RDATA3 (offset 0x4B4, printed page 4-85, Hi3516C V300 dump line 19860).";

        field {
            name = "rdata7";
            desc = "Bits 31-0 of the data read by the SFC. In RD_MRS mode bits 7-0 are the read-back value of the LPDDR2 MRS register.";
            sw = r;
            hw = w;
            reset = 0x0;
        } rdata7[31:0];
    } DDRC_HIS_SFC_RDATA3 @ 0x4B4;

    reg {
        name = "Push timeout control register";
        desc = "DDRC_TEST_GENPOSE0 is a push timeout control register (Hi3516C V300 / E V100 only; not in the Hi3518E V20X or Hi3516A/D data sheets).

Data sheet 4.1.6 DDRC_TEST_GENPOSE0 (offset 0x4BC, printed page 4-85, Hi3516C V300 dump line 19880).";

        field {
            name = "push_timeout_en";
            desc = "push_timeout enable. 0: disabled; 1: enabled.";
            sw = rw;
            hw = r;
            reset = 0x0;
        } push_timeout_en[8:8];

        field {
            name = "push_timeout";
            desc = "Timeout value that is pushed to the preceding command when the push timeout conditions are met.";
            sw = rw;
            hw = r;
            reset = 0x0;
        } push_timeout[7:0];
    } DDRC_TEST_GENPOSE0 @ 0x4BC;
`else
    reg {
        name = "SFC read data register 0 (not in the data sheet)";
        desc = "DDRC_HIS_SFC_RDATA0 is an SFC read data register that the data sheet does NOT document (vendor ddr_ddrc_v500.h defines DDR_DMC_SFC_RDATA0 at 0x4A8).

Vendor `ddr_ddrc_v500.h` calls this DDR_DMC_SFC_RDATA0 = SFC read data[127:96]; the Hi3518E V20X and Hi3516A/D data sheets have no such register (their lists jump from 0x3BC to 0x4B4). The Hi3516C V300 / E V100 data sheet does document 0x4A8..0x4B4 as the four read data words 127:0 (`DDRC_V2_CV300` branch), which supports the vendor layout.

Not in the data sheet: vendor `drivers/ddr/ddr_ddrc_v500.h` (u-boot-vendor-2010.06).";

        field {
            name = "rdata0";
            desc = "Read data word 0 of the software configuration module (undocumented in the data sheet; bit positions in the 256-bit data are unknown: the data sheet gives bits 159-128 for RDATA3; the Hi3516C V300 data sheet gives bits 127-96 for this offset).";
            sw = r;
            hw = w;
            reset = 0x0;
        } rdata0[31:0];
    } DDRC_HIS_SFC_RDATA0 @ 0x4A8;

    reg {
        name = "SFC read data register 1 (not in the data sheet)";
        desc = "DDRC_HIS_SFC_RDATA1 is an SFC read data register that the data sheet does NOT document (vendor ddr_ddrc_v500.h defines DDR_DMC_SFC_RDATA1 at 0x4AC).

Not in the data sheet: vendor `drivers/ddr/ddr_ddrc_v500.h` (u-boot-vendor-2010.06).";

        field {
            name = "rdata1";
            desc = "Read data word 1 of the software configuration module (undocumented in the data sheet; bit positions in the 256-bit data are unknown: the data sheet gives bits 159-128 for RDATA3; the Hi3516C V300 data sheet gives bits 95-64 for this offset).";
            sw = r;
            hw = w;
            reset = 0x0;
        } rdata1[31:0];
    } DDRC_HIS_SFC_RDATA1 @ 0x4AC;

    reg {
        name = "SFC read data register 2 (not in the data sheet)";
        desc = "DDRC_HIS_SFC_RDATA2 is an SFC read data register that the data sheet does NOT document (vendor ddr_ddrc_v500.h defines DDR_DMC_SFC_RDATA2 at 0x4B0).

Not in the data sheet: vendor `drivers/ddr/ddr_ddrc_v500.h` (u-boot-vendor-2010.06).";

        field {
            name = "rdata2";
            desc = "Read data word 2 of the software configuration module (undocumented in the data sheet; bit positions in the 256-bit data are unknown: the data sheet gives bits 159-128 for RDATA3; the Hi3516C V300 data sheet gives bits 63-32 for this offset).";
            sw = r;
            hw = w;
            reset = 0x0;
        } rdata2[31:0];
    } DDRC_HIS_SFC_RDATA2 @ 0x4B0;

    reg {
        name = "Software configuration read data register 3";
        desc = "DDRC_HIS_SFC_RDATA3 is software configuration read data register 3.

The data sheet prints the access of the SFC read data registers as RW; modelled read-only. The vendor U-Boot header `ddr_ddrc_v500.h` calls 0x4A8..0x4B4 DDR_DMC_SFC_RDATA0..3 = data[127:96]..data[31:0], i.e. 0x4B4 is the lowest word, whereas this data sheet puts bits 31:0 in DDRC_HIS_SFC_RDATA7 (0x4C4): the two sources disagree (see NOTES). The Hi3516C V300 / E V100 data sheet agrees with the vendor header (0x4B4 = bits 31:0, named rdata7).

Data sheet 4.1.6 DDRC_HIS_SFC_RDATA3 (offset 0x4B4, printed page 4-88, dump line 36602).";

        field {
            name = "rdata3";
            desc = "Bits 159-128 of the data read by the SFC";
            sw = r;
            hw = w;
            reset = 0x0;
        } rdata3[31:0];
    } DDRC_HIS_SFC_RDATA3 @ 0x4B4;

    reg {
        name = "SFC read data register";
        desc = "DDRC_HIS_SFC_RDATA4 is an SFC read data register.

Data sheet 4.1.6 DDRC_HIS_SFC_RDATA4 (offset 0x4B8, printed page 4-88, dump line 36621).";

        field {
            name = "rdata4";
            desc = "Bits 127-96 of the data read by the SFC";
            sw = r;
            hw = w;
            reset = 0x0;
        } rdata4[31:0];
    } DDRC_HIS_SFC_RDATA4 @ 0x4B8;

    reg {
        name = "SFC read data register";
        desc = "DDRC_HIS_SFC_RDATA5 is an SFC read data register.

Data sheet 4.1.6 DDRC_HIS_SFC_RDATA5 (offset 0x4BC, printed page 4-89, dump line 36649).";

        field {
            name = "rdata5";
            desc = "Bits 95-64 of the data read by the SFC";
            sw = r;
            hw = w;
            reset = 0x0;
        } rdata5[31:0];
    } DDRC_HIS_SFC_RDATA5 @ 0x4BC;

    reg {
        name = "SFC read data register";
        desc = "DDRC_HIS_SFC_RDATA6 is an SFC read data register.

Data sheet 4.1.6 DDRC_HIS_SFC_RDATA6 (offset 0x4C0, printed page 4-89, dump line 36667).";

        field {
            name = "rdata6";
            desc = "Bits 63-32 of the data read by the SFC";
            sw = r;
            hw = w;
            reset = 0x0;
        } rdata6[31:0];
    } DDRC_HIS_SFC_RDATA6 @ 0x4C0;

    reg {
        name = "SFC read data register";
        desc = "DDRC_HIS_SFC_RDATA7 is an SFC read data register.

Data sheet 4.1.6 DDRC_HIS_SFC_RDATA7 (offset 0x4C4, printed page 4-89, dump line 36686).";

        field {
            name = "rdata7";
            desc = "Bits 31-0 of the data read by the SFC The value of bits 7-0 is the readback value of the LPDDR2 MRS register in RD_MRS mode.";
            sw = r;
            hw = w;
            reset = 0x0;
        } rdata7[31:0];
    } DDRC_HIS_SFC_RDATA7 @ 0x4C4;

    reg {
        name = "SFC read data error ECC correcting code (ECC) register";
        desc = "DDRC_HIS_SFC_RDATA_ECC is an SFC read data ECC register.

The data sheet prints the access as RW; modelled read-only.

Data sheet 4.1.6 DDRC_HIS_SFC_RDATA_ECC (offset 0x4C8, printed page 4-90, dump line 36713).";

        field {
            name = "rdata_ecc3";
            desc = "8-bit ECC for bits 255-192 of the data read by the SFC";
            sw = r;
            hw = w;
            reset = 0x0;
        } rdata_ecc3[31:24];

        field {
            name = "rdata_ecc2";
            desc = "8-bit ECC for bits 191-128 of the data read by the SFC";
            sw = r;
            hw = w;
            reset = 0x0;
        } rdata_ecc2[23:16];

        field {
            name = "rdata_ecc1";
            desc = "8-bit ECC for bits 127-64 of the data read by the SFC";
            sw = r;
            hw = w;
            reset = 0x0;
        } rdata_ecc1[15:8];

        field {
            name = "rdata_ecc0";
            desc = "8-bit ECC for bits 63-0 of the data read by the SFC";
            sw = r;
            hw = w;
            reset = 0x0;
        } rdata_ecc0[7:0];
    } DDRC_HIS_SFC_RDATA_ECC @ 0x4C8;
`endif

};

regfile eHISI_DDRC_V2_PHY_DX {
    name = "DDRC V2 PHY data block";
    desc = "One DDR PHY data block (byte lane pair), data sheet 4.1.7: registers DXN* of the data sheet at `0x200 + n x 0x80` (n = 0..3), offsets here are relative to the start of block n. The Hi3518E uses a 16-bit bus; the vendor init disables byte lanes 2 and 3 (DXNCTRL = 3).";

    reg {
        name = "Loopback data comparison control register during BIST of data blocks";
        desc = "DXNBISTCTRL is a loopback data comparison control register during BIST of data blocks.

Data sheet 4.1.7 DXNBISTCTRL (offset 0x200, printed page 4-170, dump line 41228).";

        field {
            name = "lfsr_seed";
            desc = "LFSR seed value This field specifies the initial seed value of the LFSR generator to this byte lane.";
            sw = rw;
            hw = r;
            reset = 0x0;
        } lfsr_seed[31:24];

        enum DXNBISTCTRL_dqm_cmp_mask_enum {
            NOT_COMPARED = 0 { name = "Not Compared"; desc = "not compared"; };
            COMPARED = 1 { name = "Compared"; desc = "compared"; };
        };

        field {
            name = "dqm_cmp_mask";
            desc = "DQM loopback compare mask This field controls whether the comparison of the loopback data on DQM bits is disabled.";
            sw = rw;
            hw = r;
            encode = DXNBISTCTRL_dqm_cmp_mask_enum;
            reset = 0x0;
        } dqm_cmp_mask[16:16];

        enum DXNBISTCTRL_dq_cmp_mask_enum {
            NOT_COMPARED = 0x0 { name = "Not Compared"; desc = "not compared"; };
            COMPARED = 0x1 { name = "Compared"; desc = "compared"; };
        };

        field {
            name = "dq_cmp_mask";
            desc = "DQ loopback compare mask This field controls whether the comparison of the loopback data on DQ bits is disabled.";
            sw = rw;
            hw = r;
            encode = DXNBISTCTRL_dq_cmp_mask_enum;
            reset = 0x0;
        } dq_cmp_mask[15:8];

        field {
            name = "bist_en";
            desc = "BIST enable This field specifies whether the data block is included for the loopback test while bist_op is set to BIST Enable.";
            sw = rw;
            hw = r;
            reset = 0x0;
        } bist_en[0:0];
    } DXNBISTCTRL @ 0x0;

    reg {
        name = "BIST test result and status register";
        desc = "DXNBISTSTS is a BIST test result and status register. Note that this register is read-only, and can be reset only by setting bist_op to BIST Reset.

Data sheet 4.1.7 DXNBISTSTS (offset 0x204, printed page 4-171, dump line 41285).";

        field {
            name = "dqm_cmp_err";
            desc = "BIST error on DQM";
            sw = r;
            hw = w;
            reset = 0x0;
        } dqm_cmp_err[16:16];

        field {
            name = "dq_cmp_ferr";
            desc = "BIST error on DQ at the falling edge of DQS";
            sw = r;
            hw = w;
            reset = 0x0;
        } dq_cmp_ferr[15:8];

        field {
            name = "dq_cmp_rerr";
            desc = "BIST error on DQ at the rising edge of DQS";
            sw = r;
            hw = w;
            reset = 0x0;
        } dq_cmp_rerr[7:0];
    } DXNBISTSTS @ 0x4;

    reg {
        name = "Data block control register";
        desc = "DXNCTRL is a data block control register.

The Hi3518E has a 16-bit bus: the stock vendor init writes DXNCTRL = 3 (bl_dis = dm_dis = 1) for the unused byte lanes DX2 and DX3.

Data sheet 4.1.7 DXNCTRL (offset 0x208, printed page 4-172, dump line 41322).";

        field {
            name = "dm_dis";
            desc = "Data mask disable This field specifies whether the corresponding write data mask (DM) is enabled. When this field is set to 1, the corresponding DM is not used and calibrated during training.";
            sw = rw;
            hw = r;
            reset = 0x0;
        } dm_dis[1:1];

        field {
            name = "bl_dis";
            desc = "Byte lane disable This field specifies whether the corresponding byte lane is in use. If the corresponding byte lane is not used, the PLL/DDL is powered down, and the output driver is turned off.";
            sw = rw;
            hw = r;
            reset = 0x0;
        } bl_dis[0:0];
    } DXNCTRL @ 0x8;

    reg {
        name = "Data block bit delay configuration register 0";
        desc = "DXNWDQNBDL0 is data block bit delay configuration register 0.

Data sheet 4.1.7 DXNWDQNBDL0 (offset 0x210, printed page 4-172, dump line 41354).";

        field {
            name = "wdq3bdl";
            desc = "Delay select of WDQ3 This field specifies the delay value of the bit delay line on the write path of DQ3.";
            sw = rw;
            hw = r;
            reset = 0x0;
        } wdq3bdl[28:24];

        field {
            name = "wdq2bdl";
            desc = "Delay select of WDQ2 This field specifies the delay value of the bit delay line on the write path of DQ2.";
            sw = rw;
            hw = r;
            reset = 0x0;
        } wdq2bdl[20:16];

        field {
            name = "wdq1bdl";
            desc = "Delay select of WDQ1 This field specifies the delay value of the bit delay line on the write path of DQ1.";
            sw = rw;
            hw = r;
            reset = 0x0;
        } wdq1bdl[12:8];

        field {
            name = "wdq0bdl";
            desc = "Delay select of WDQ0 This field specifies the delay value of the bit delay line on the write path of DQ0.";
            sw = rw;
            hw = r;
            reset = 0x0;
        } wdq0bdl[4:0];
    } DXNWDQNBDL0 @ 0x10;

    reg {
        name = "Data block bit delay configuration register 1";
        desc = "DXNWDQNBDL1 is data block bit delay configuration register 1.

Data sheet 4.1.7 DXNWDQNBDL1 (offset 0x214, printed page 4-173, dump line 41404).";

        field {
            name = "wdq7bdl";
            desc = "Delay select of WDQ7 This field specifies the delay value of the bit delay line on the write path of DQ3.";
            sw = rw;
            hw = r;
            reset = 0x0;
        } wdq7bdl[28:24];

        field {
            name = "wdq6bdl";
            desc = "Delay select of WDQ6 This field specifies the delay value of the bit delay line on the write path of DQ2.";
            sw = rw;
            hw = r;
            reset = 0x0;
        } wdq6bdl[20:16];

        field {
            name = "wdq5bdl";
            desc = "Delay select of WDQ5 This field specifies the delay value of the bit delay line on the write path of DQ1.";
            sw = rw;
            hw = r;
            reset = 0x0;
        } wdq5bdl[12:8];

        field {
            name = "wdq4bdl";
            desc = "Delay select of WDQ4 This field specifies the delay value of the bit delay line on the write path of DQ0.";
            sw = rw;
            hw = r;
            reset = 0x0;
        } wdq4bdl[4:0];
    } DXNWDQNBDL1 @ 0x14;

    reg {
        name = "Data block bit delay configuration register 2";
        desc = "DXNWDQNBDL2 is data block bit delay configuration register 2.

Data sheet 4.1.7 DXNWDQNBDL2 (offset 0x218, printed page 4-174, dump line 41453).";

        field {
            name = "wdmbdl";
            desc = "Delay select of WDQM This field specifies the delay value of the bit delay line on DQM.";
            sw = rw;
            hw = r;
            reset = 0x0;
        } wdmbdl[4:0];
    } DXNWDQNBDL2 @ 0x18;

    reg {
        name = "Data block bit delay configuration register 4";
        desc = "DXNRDQNBDL0 is data block bit delay configuration register 4.

Data sheet 4.1.7 DXNRDQNBDL0 (offset 0x21C, printed page 4-174, dump line 41478).";

        field {
            name = "rdq3bdl";
            desc = "Delay select of RDQ3 This field specifies the delay value of the bit delay line on the write path of DQ3.";
            sw = rw;
            hw = r;
            reset = 0x0;
        } rdq3bdl[28:24];

        field {
            name = "rdq2bdl";
            desc = "Delay select of RDQ2 This field specifies the delay value of the bit delay line on the write path of DQ2.";
            sw = rw;
            hw = r;
            reset = 0x0;
        } rdq2bdl[20:16];

        field {
            name = "rdq1bdl";
            desc = "Delay select of RDQ1 This field specifies the delay value of the bit delay line on the write path of DQ1.";
            sw = rw;
            hw = r;
            reset = 0x0;
        } rdq1bdl[12:8];

        field {
            name = "rdq0bdl";
            desc = "Delay select of RDQ0 This field specifies the delay value of the bit delay line on the write path of DQ0.";
            sw = rw;
            hw = r;
            reset = 0x0;
        } rdq0bdl[4:0];
    } DXNRDQNBDL0 @ 0x1C;

    reg {
        name = "Data block bit delay configuration register 5";
        desc = "DXNRDQNBDL1 is data block bit delay configuration register 5.

Data sheet 4.1.7 DXNRDQNBDL1 (offset 0x220, printed page 4-175, dump line 41528).";

        field {
            name = "rdq7bdl";
            desc = "Delay select of RDQ7 This field specifies the delay value of the bit delay line on the write path of DQ3.";
            sw = rw;
            hw = r;
            reset = 0x0;
        } rdq7bdl[28:24];

        field {
            name = "rdq6bdl";
            desc = "Delay select of RDQ6 This field specifies the delay value of the bit delay line on the write path of DQ2.";
            sw = rw;
            hw = r;
            reset = 0x0;
        } rdq6bdl[20:16];

        field {
            name = "rdq5bdl";
            desc = "Delay select of RDQ5 This field specifies the delay value of the bit delay line on the write path of DQ1.";
            sw = rw;
            hw = r;
            reset = 0x0;
        } rdq5bdl[12:8];

        field {
            name = "rdq4bdl";
            desc = "Delay select of RDQ4 This field specifies the delay value of the bit delay line on the write path of DQ0.";
            sw = rw;
            hw = r;
            reset = 0x0;
        } rdq4bdl[4:0];
    } DXNRDQNBDL1 @ 0x20;

    reg {
        name = "Data block bit delay configuration register 6";
        desc = "DXNRDQNBDL2 is data block bit delay configuration register 6.

Data sheet 4.1.7 DXNRDQNBDL2 (offset 0x224, printed page 4-176, dump line 41577).";

        field {
            name = "rdmbdl";
            desc = "Delay select of RDQM This field specifies the delay value of the bit delay line on loopback read path of DQM.";
            sw = rw;
            hw = r;
            reset = 0x0;
        } rdmbdl[4:0];
    } DXNRDQNBDL2 @ 0x24;

    reg {
        name = "Local delay line control register";
        desc = "DXNRDQSDLY is a local delay line control register.

Data sheet 4.1.7 DXNRDQSDLY (offset 0x22C, printed page 4-176, dump line 41602).";

        field {
            name = "rdqscyc";
            desc = "Read DQS clock phase select This field specifies the number of taps in one clock cycle for the 1-T delay measurement type or the number of taps in half of clock cycle for the half-T delay measurement type. This field is used to create 90 degree delays for RDQS.";
            sw = rw;
            hw = r;
            reset = 0x0;
        } rdqscyc[22:16];

        field {
            name = "rdqsbdl";
            desc = "Read DQS delay select This field specifies the phase shift of the read DQS to create 90 degree delays.";
            sw = rw;
            hw = r;
            reset = 0x0;
        } rdqsbdl[6:0];
    } DXNRDQSDLY @ 0x2C;

    reg {
        name = "Write leveling DQS delay control register";
        desc = "DXNWDQSDLY is a write leveling DQS delay control register.

Data sheet 4.1.7 DXNWDQSDLY (offset 0x230, printed page 4-177, dump line 41642).";

        field {
            name = "wdqsphase";
            desc = "Write DQS clock phase select";
            sw = rw;
            hw = r;
            reset = 0x0;
        } wdqsphase[11:8];

        field {
            name = "wdqsbdl";
            desc = "Write leveling DQS delay select This field specifies the delay value of delay applied on WDQS for write leveling.";
            sw = rw;
            hw = r;
            reset = 0x0;
        } wdqsbdl[4:0];
    } DXNWDQSDLY @ 0x30;

    reg {
        name = "Write leveling delay line control register";
        desc = "DXNWDQDLY is a write leveling delay line control register.

Data sheet 4.1.7 DXNWDQDLY (offset 0x234, printed page 4-177, dump line 41672).";

        field {
            name = "wdqphase";
            desc = "Write data eye clock phase select";
            sw = rw;
            hw = r;
            reset = 0xC;
        } wdqphase[12:8];
    } DXNWDQDLY @ 0x34;

    reg {
        name = "Extra system latency addition control register";
        desc = "DXNWLSL is an extra system latency addition control register.

Data sheet 4.1.7 DXNWLSL (offset 0x238, printed page 4-178, dump line 41704).";

        field {
            name = "wlsl";
            desc = "Write leveling system latency This field is used to adjust the write latency after write leveling.";
            sw = rw;
            hw = r;
            reset = 0x1;
        } wlsl[17:16];
    } DXNWLSL @ 0x38;

    reg {
        name = "Local delay line control register";
        desc = "DXNRDQSGDLY is a local delay line control register.

The data sheet prints the offset as `0x23C + n x 0x80 + m x 0x400` (n = 0-3, m = 0-1). Instance m = 0 is part of the DX[n] block here (offset 0x3C inside DX[n]); the m = 1 copy (PHY offset 0x63C + n x 0x80) is the register array DXNRDQSGDLY_M1. Only m = 0 is used by the vendor code.

Data sheet 4.1.7 DXNRDQSGDLY (offset 0x23C, printed page 4-178, dump line 41732).

Hardware (Hi3518E V200 board, live dump): the vendor table writes 0 here, and the gate training results are lane 0 = 0x1F001416 (rdqsgphase 0x14, rdqsgbdl 0x16, org_rdqsgph 0x1F) at U-Boot and under Linux; lane 1 = 0x1F001416 at U-Boot but 0x1F001800 under Linux (rdqsgphase 0x18, rdqsgbdl 0), so the value moves at run time without the vendor code writing it ([inferred] hardware gate re-training/tracking, see TRAINCTRL0 dqsgrt_shft/dqsgrt_chk). Lanes 2 and 3 read 0.";

        field {
            name = "org_rdqsgph";
            desc = "Original read DQS gate phase before HW gate training post-update stage (for debugging)";
            sw = r;
            hw = w;
            reset = 0x0;
        } org_rdqsgph[29:24];

        field {
            name = "rdqsgtxbdl";
            desc = "Read DQS gate delay select This field specifies the delay value of the read gating delay before DQS dummy PAD.";
            sw = rw;
            hw = r;
            reset = 0x0;
        } rdqsgtxbdl[20:16];

        field {
            name = "rdqsgphase";
            desc = "Read DQS gating clock phase select";
            sw = rw;
            hw = r;
            reset = 0x0;
        } rdqsgphase[13:8];

        field {
            name = "rdqsgbdl";
            desc = "Read DQS gating delay select This field specifies the delay value of the read gating delay after DQS dummy PAD.";
            sw = rw;
            hw = r;
            reset = 0x10;
        } rdqsgbdl[5:0];
    } DXNRDQSGDLY @ 0x3C;

    reg {
        name = "DX PHY control register";
        desc = "DXPHYCTRL is a DX PHY control register.

Data sheet 4.1.7 DXPHYCTRL (offset 0x240, printed page 4-179, dump line 41781).";

        field {
            name = "dx_pll_cal";
            desc = "The value 0x0 is recommended.";
            sw = rw;
            hw = r;
            reset = 0x0;
        } dx_pll_cal[14:14];

        field {
            name = "dx_pll_calm";
            desc = "The value 0x0 is recommended.";
            sw = rw;
            hw = r;
            reset = 0x0;
        } dx_pll_calm[13:13];

        field {
            name = "dx_pll_calt";
            desc = "The value 0x0 is recommended.";
            sw = rw;
            hw = r;
            reset = 0x0;
        } dx_pll_calt[12:12];

        field {
            name = "dx_pll_lt";
            desc = "The value 0x0 is recommended.";
            sw = rw;
            hw = r;
            reset = 0x0;
        } dx_pll_lt[11:10];

        field {
            name = "dx_pll_sp";
            desc = "The value 0x2 is recommended.";
            sw = rw;
            hw = r;
            reset = 0x0;
        } dx_pll_sp[9:7];

        field {
            name = "dx_pll_cpi";
            desc = "The value 0x4 is recommended.";
            sw = rw;
            hw = r;
            reset = 0x0;
        } dx_pll_cpi[6:4];

        field {
            name = "dx_pll_init";
            desc = "The value 0x0 is recommended.";
            sw = rw;
            hw = r;
            reset = 0x0;
        } dx_pll_init[3:3];

        field {
            name = "dx_pll_testen";
            desc = "The value 0x0 is recommended.";
            sw = rw;
            hw = r;
            reset = 0x0;
        } dx_pll_testen[2:2];

        field {
            name = "dx_pll_testpem";
            desc = "The value 0x0 is recommended.";
            sw = rw;
            hw = r;
            reset = 0x0;
        } dx_pll_testpem[1:1];

        field {
            name = "dx_pll_thrm";
            desc = "The value 0x0 is recommended.";
            sw = rw;
            hw = r;
            reset = 0x0;
        } dx_pll_thrm[0:0];
    } DXPHYCTRL @ 0x40;

    reg {
        name = "Latch enable register";
        desc = "DXNGDS is a latch enable register. It is used to control the latch enable within the PHY to obtain stable data.

Data sheet 4.1.7 DXNGDS (offset 0x248, printed page 4-180, dump line 41832).";

        field {
            name = "gds";
            desc = "Rank 0 read data latch delay This field is used as a reference stable region for the PHY to latch the read data.";
            sw = rw;
            hw = r;
            reset = 0x0;
        } gds[2:0];
    } DXNGDS @ 0x48;

    reg {
        name = "Data block clock bit delay line configuration register";
        desc = "DXNCLKBDL is a data block clock bit delay line configuration register.

Data sheet 4.1.7 DXNCLKBDL (offset 0x24C, printed page 4-180, dump line 41857).";

        field {
            name = "dx_refclk_bdl";
            desc = "Bit delay line of REFCLK";
            sw = rw;
            hw = r;
            reset = 0x0;
        } dx_refclk_bdl[20:16];

        field {
            name = "dx_fbclk_bdl";
            desc = "Bit delay line of FBCLK";
            sw = rw;
            hw = r;
            reset = 0x0;
        } dx_fbclk_bdl[4:0];
    } DXNCLKBDL @ 0x4C;

    reg {
        name = "Read data eye boundary register";
        desc = "DXNRDBOUND is a read data eye boundary register. This register indicates the left and right boundaries of RDQSQDL of the data eye.

Data sheet 4.1.7 DXNRDBOUND (offset 0x250, printed page 4-181, dump line 41893).";

        field {
            name = "rdqsbdl_left";
            desc = "Left boundary of read data eye";
            sw = r;
            hw = w;
            reset = 0x0;
        } rdqsbdl_left[22:16];

        field {
            name = "rdqsbdl_right";
            desc = "Right boundary of read data eye";
            sw = r;
            hw = w;
            reset = 0x0;
        } rdqsbdl_right[6:0];
    } DXNRDBOUND @ 0x50;

    reg {
        name = "Write data eye boundary register";
        desc = "DXNWRBOUND is a write data eye boundary register. This register indicates the left and right boundaries of WDQSQDL of the data eye.

Data sheet 4.1.7 DXNWRBOUND (offset 0x254, printed page 4-181, dump line 41918).";

        field {
            name = "wdqphase_left";
            desc = "Left boundary of the write data eye";
            sw = r;
            hw = w;
            reset = 0x0;
        } wdqphase_left[20:16];

        field {
            name = "wdqphase_right";
            desc = "Right boundary of the write data eye";
            sw = r;
            hw = w;
            reset = 0x0;
        } wdqphase_right[4:0];
    } DXNWRBOUND @ 0x54;

    reg {
        name = "Output enable delay line control register";
        desc = "DXNOEBDL is an output enable delay line control register. This register specifies the delay line value of the output enable delay line within the PHY data block.

Data sheet 4.1.7 DXNOEBDL (offset 0x258, printed page 4-182, dump line 41949).";

        field {
            name = "wdqsoe_bdl";
            desc = "Write DQS output enable delay control";
            sw = rw;
            hw = r;
            reset = 0x0;
        } wdqsoe_bdl[20:16];

        field {
            name = "oen_bdl";
            desc = "DQ output enable delay control";
            sw = rw;
            hw = r;
            reset = 0x0;
        } oen_bdl[4:0];
    } DXNOEBDL @ 0x58;

    reg {
        name = "Data block PHY miscellaneous control register 0";
        desc = "DXNMISCCTRL0 is data block PHY miscellaneous control register 0. This register is used to control the PHY and should not be modified.

Data sheet 4.1.7 DXNMISCCTRL0 (offset 0x260, printed page 4-182, dump line 41974).";

        field {
            name = "ptrgated_en";
            desc = "Set this bit to the default value.";
            sw = rw;
            hw = r;
            reset = 0x0;
        } ptrgated_en[26:26];

        field {
            name = "enshift_a0";
            desc = "Set this bit to the default value.";
            sw = rw;
            hw = r;
            reset = 0x0;
        } enshift_a0[25:25];

        field {
            name = "margin_a0";
            desc = "After this field is modified, \"phyconn_rst\" is required to update the latest setting. If the dly_track_type=1 tracking type is required, this field should be set to 0x1 before initial trainings and dly_track_type should be set to 0x1 after initial trainings.";
            sw = rw;
            hw = r;
            reset = 0x0;
        } margin_a0[24:24];

        field {
            name = "bufphyclkdiv2";
            desc = "Set this bit to the default value.";
            sw = rw;
            hw = r;
            reset = 0x0;
        } bufphyclkdiv2[23:23];

        field {
            name = "lvdqclkdiv2";
            desc = "Set this bit to the default value.";
            sw = rw;
            hw = r;
            reset = 0x0;
        } lvdqclkdiv2[22:22];

        field {
            name = "dqsgatedla";
            desc = "Set this bit to the default value.";
            sw = rw;
            hw = r;
            reset = 0x0;
        } dqsgatedla[21:21];

        field {
            name = "dx_rxp_2nd_dm";
            desc = "After this field is modified, \"phyconn_rst\" is required to update the latest setting. If the dly_track_type=1 tracking type is required, this field should be set to 0x1 before initial trainings and dly_track_type should be set to 0x1 after initial trainings.";
            sw = rw;
            hw = r;
            reset = 0x0;
        } dx_rxp_2nd_dm[20:20];

        field {
            name = "dx_rxn_2nd_dm";
            desc = "After this field is modified, \"phyconn_rst\" is required to update the latest setting. If the dly_track_type=1 tracking type is required, this field should be set to 0x1 before initial trainings and dly_track_type should be set to 0x1 after initial trainings.";
            sw = rw;
            hw = r;
            reset = 0x0;
        } dx_rxn_2nd_dm[19:19];

        field {
            name = "dx_dqs_h";
            desc = "Set this bit to the default value.";
            sw = rw;
            hw = r;
            reset = 0x0;
        } dx_dqs_h[18:18];

        field {
            name = "dx_dqs_l";
            desc = "Set this bit to the default value.";
            sw = rw;
            hw = r;
            reset = 0x1;
        } dx_dqs_l[17:17];

        field {
            name = "dx_margin_a1";
            desc = "After this field is modified, \"phyconn_rst\" is required to update the latest setting. If the dly_track_type=1 tracking type is required, this field should be set to 0x1 before initial trainings and dly_track_type should be set to 0x1 after initial trainings.";
            sw = rw;
            hw = r;
            reset = 0x0;
        } dx_margin_a1[16:16];

        field {
            name = "rxp_2nd_dq";
            desc = "After this field is modified, \"phyconn_rst\" is required to update the latest setting. When the dly_track_type=1 tracking type is required, this field should be set to 0xFF before initial trainings and dly_track_type should be set to 0x1 after initial trainings.";
            sw = rw;
            hw = r;
            reset = 0x0;
        } rxp_2nd_dq[15:8];

        field {
            name = "rxn_2nd_dq";
            desc = "After this field is modified, \"phyconn_rst\" is required to update the latest setting. When the dly_track_type=1 tracking type is required, this field should be set to 0xFF before initial trainings and dly_track_type should be set to 0x1 after initial trainings.";
            sw = rw;
            hw = r;
            reset = 0x0;
        } rxn_2nd_dq[7:0];
    } DXNMISCCTRL0 @ 0x60;

    reg {
        name = "Data block PHY miscellaneous control register 1";
        desc = "DXNMISCCTRL1 is data block PHY miscellaneous control register 1. This register is used to control the PHY and should not be modified.

Data sheet 4.1.7 DXNMISCCTRL1 (offset 0x264, printed page 4-184, dump line 42063).";

        field {
            name = "dqclk1x";
            desc = "Set this field to the default value.";
            sw = rw;
            hw = r;
            reset = 0x0;
        } dqclk1x[31:28];

        field {
            name = "dqclk2x";
            desc = "Set this field to the default value.";
            sw = rw;
            hw = r;
            reset = 0x0;
        } dqclk2x[27:24];

        field {
            name = "dqsgclk1x";
            desc = "Set this field to the default value.";
            sw = rw;
            hw = r;
            reset = 0x0;
        } dqsgclk1x[23:20];

        field {
            name = "dqsgclk2x";
            desc = "Set this field to the default value.";
            sw = rw;
            hw = r;
            reset = 0x0;
        } dqsgclk2x[19:16];

        field {
            name = "dqsclk1x";
            desc = "Set this field to the default value.";
            sw = rw;
            hw = r;
            reset = 0x0;
        } dqsclk1x[15:12];

        field {
            name = "dqsclk2x";
            desc = "Set this field to the default value.";
            sw = rw;
            hw = r;
            reset = 0x0;
        } dqsclk2x[11:8];

        field {
            name = "mclk1x";
            desc = "Set this field to the default value.";
            sw = rw;
            hw = r;
            reset = 0x0;
        } mclk1x[7:4];

        field {
            name = "mclk2x";
            desc = "Set this field to the default value.";
            sw = rw;
            hw = r;
            reset = 0x0;
        } mclk2x[3:0];
    } DXNMISCCTRL1 @ 0x64;

    reg {
        name = "Data block PHY debug signal register 0";
        desc = "DXDEBUG0 is data block PHY debug signal register 0.

Data sheet 4.1.7 DXDEBUG0 (offset 0x268, printed page 4-184, dump line 42091).

Hardware (Hi3518E V200 board, live dump): lane 0 reads 0x00006000 at U-Boot and 0x00000100 under Linux, lane 1 reads 0x00007E00 and 0x00000100: a run-time status snapshot (s0a/s0b bits) that differs between the two captures; do not use it for anything but debug.";

        field {
            name = "s0a";
            desc = "Set this bit to the default value.";
            sw = r;
            hw = w;
            reset = 0x1;
        } s0a[14:14];

        field {
            name = "s0b";
            desc = "Set this bit to the default value.";
            sw = r;
            hw = w;
            reset = 0x0;
        } s0b[13:13];

        field {
            name = "s1a";
            desc = "Set this bit to the default value.";
            sw = r;
            hw = w;
            reset = 0x1;
        } s1a[12:12];

        field {
            name = "reserved_11_0";
            desc = "Reserved in the data sheet bit table, but the data sheet Total Reset Value has non-zero bits here (reset 0x415). Modelled so that the register reset matches the data sheet.";
            sw = r;
            hw = w;
            reset = 0x415;
        } reserved_11_0[11:0];
    } DXDEBUG0 @ 0x68;

    reg {
        name = "Data block PHY debug signal register 1";
        desc = "DXDEBUG1 is data block PHY debug signal register 1.

DATA SHEET ERROR: the bit table prints dqs0 as [23:0] which overlaps dqs0b [15:8] and dqs0_gold [7:0]; dqs0 is modelled as [23:16].

Data sheet 4.1.7 DXDEBUG1 (offset 0x26C, printed page 4-185, dump line 42127).

Hardware (Hi3518E V200 board, live dump): lane 0 reads 0x00101010 in both; lane 1 reads 0x00010101 at U-Boot and 0x00101010 under Linux: run-time debug snapshot.";

        field {
            name = "dqs0";
            desc = "Reserved";
            sw = r;
            hw = w;
            reset = 0x0;
        } dqs0[23:16];

        field {
            name = "dqs0b";
            desc = "Reserved";
            sw = r;
            hw = w;
            reset = 0x0;
        } dqs0b[15:8];

        field {
            name = "dqs0_gold";
            desc = "Reserved";
            sw = r;
            hw = w;
            reset = 0x1;
        } dqs0_gold[7:0];
    } DXDEBUG1 @ 0x6C;

    reg {
        name = "Data block PHY reserved control pin register";
        desc = "DXPHYRSVD is a data block PHY reserved control pin register. This register is used to control the PHY and should not be modified.

Data sheet 4.1.7 DXPHYRSVD (offset 0x270, printed page 4-185, dump line 42154).";

        field {
            name = "dx_rsv_status";
            desc = "Reserved";
            sw = r;
            hw = w;
            reset = 0x0;
        } dx_rsv_status[31:16];

        field {
            name = "dx_rsv_control";
            desc = "Reserved The followings are for (n = 0, 2): Bit 1 (reg_DQSG_extend_2T): 0/1: extend DQSG 1T/2T dfi_clk, when reg_DQSG_extend_en is 1 Bit 0 (reg_DQSG_extend_en): 0/1: disable/enable the DQSG extend function";
            sw = rw;
            hw = r;
            reset = 0xFF00;
        } dx_rsv_control[15:0];
    } DXPHYRSVD @ 0x70;

    reg {
        name = "Data block PHY miscellaneous control register 2";
        desc = "DXNMISCCTRL2 is data block PHY miscellaneous control register 2. This register is used to control the PHY and should not be modified.

Data sheet 4.1.7 DXNMISCCTRL2 (offset 0x274, printed page 4-186, dump line 42189).";

        field {
            name = "reg_OE_extend1T_en";
            desc = "Set this bit to the default value.";
            sw = rw;
            hw = r;
            reset = 0x0;
        } reg_OE_extend1T_en[10:10];

        field {
            name = "reg_dqsg_TX_2path";
            desc = "Set this bit to the default value.";
            sw = rw;
            hw = r;
            reset = 0x1;
        } reg_dqsg_TX_2path[9:9];

        field {
            name = "reg_squeach_en";
            desc = "Set this bit to the default value.";
            sw = rw;
            hw = r;
            reset = 0x0;
        } reg_squeach_en[8:8];

        field {
            name = "reg_dqsglat1T_en";
            desc = "Set this bit to the default value.";
            sw = rw;
            hw = r;
            reset = 0x0;
        } reg_dqsglat1T_en[7:7];

        field {
            name = "reg_sel_halfT_gated_16b";
            desc = "Set this bit to the default value.";
            sw = rw;
            hw = r;
            reset = 0x1;
        } reg_sel_halfT_gated_16b[6:6];

        field {
            name = "reg_dynamic_PUPDEN_16b";
            desc = "Set this bit to the default value.";
            sw = rw;
            hw = r;
            reset = 0x1;
        } reg_dynamic_PUPDEN_16b[5:5];

        field {
            name = "reg_dummypad_use";
            desc = "Set this bit to the default value.";
            sw = rw;
            hw = r;
            reset = 0x0;
        } reg_dummypad_use[4:4];

        field {
            name = "reg_ODTEN_gated";
            desc = "Set this bit to the default value.";
            sw = rw;
            hw = r;
            reset = 0x1;
        } reg_ODTEN_gated[3:3];

        field {
            name = "reg_GDS_r1T_sel_16b";
            desc = "Set this bit to the default value.";
            sw = rw;
            hw = r;
            reset = 0x1;
        } reg_GDS_r1T_sel_16b[2:2];

        field {
            name = "BUFRESETCONTN_gated_TDC";
            desc = "Set this bit to the default value.";
            sw = rw;
            hw = r;
            reset = 0x1;
        } BUFRESETCONTN_gated_TDC[1:1];

        field {
            name = "BUFRESETCONTN_gated_DQSGERROR";
            desc = "Set this bit to the default value.";
            sw = rw;
            hw = r;
            reset = 0x1;
        } BUFRESETCONTN_gated_DQSGERROR[0:0];
    } DXNMISCCTRL2 @ 0x74;

    reg {
        name = "Data block PHY debugging control register";
        desc = "DXDEBUGCONFIG is a data block PHY debugging control register. This register is used to control the PHY and should not be modified.

Data sheet 4.1.7 DXDEBUGCONFIG (offset 0x278, printed page 4-187, dump line 42258).";

        field {
            name = "DESKEW_regread";
            desc = "Reserved";
            sw = r;
            hw = w;
            reset = 0x0;
        } DESKEW_regread[4:4];

        field {
            name = "reg_dbg_prepost_sel";
            desc = "Set this bit to the default value.";
            sw = rw;
            hw = r;
            reset = 0x0;
        } reg_dbg_prepost_sel[3:3];

        field {
            name = "reg_dbg_pllclk_sel";
            desc = "Set this bit to the default value.";
            sw = rw;
            hw = r;
            reset = 0x0;
        } reg_dbg_pllclk_sel[2:2];

        field {
            name = "reg_dbg_REFFB_predly";
            desc = "Set this bit to the default value.";
            sw = rw;
            hw = r;
            reset = 0x0;
        } reg_dbg_REFFB_predly[1:1];

        field {
            name = "reg_dbg_REFFB_postdly";
            desc = "Set this bit to the default value.";
            sw = rw;
            hw = r;
            reset = 0x0;
        } reg_dbg_REFFB_postdly[0:0];
    } DXDEBUGCONFIG @ 0x78;

    reg {
        name = "Data block PHY DCC control register";
        desc = "DXNDCC is a data block PHY DCC control register. This register is used to control the PHY and should not be modified.

Data sheet 4.1.7 DXNDCC (offset 0x27C, printed page 4-188, dump line 42310).";

        field {
            name = "dxctl_mclk_dcc";
            desc = "bit[11]: dly_sel_xxx_DCC_16b bit[10]: ctrlC_xxx_DCC_16b bit[9]: ctrl2_xxx_DCC_16b";
            sw = rw;
            hw = r;
            reset = 0x0;
        } dxctl_mclk_dcc[11:9];

        field {
            name = "dxctl_dqs_dcc";
            desc = "bit[8]: dly_sel_xxx_DCC_16b bit[7]: ctrlC_xxx_DCC_16b bit[6]: ctrl2_xxx_DCC_16b";
            sw = rw;
            hw = r;
            reset = 0x0;
        } dxctl_dqs_dcc[8:6];

        field {
            name = "dxctl_dqsg_dcc";
            desc = "bit[5]: dly_sel_xxx_DCC_16b bit[4]: ctrlC_xxx_DCC_16b bit[3]: ctrl2_xxx_DCC_16b";
            sw = rw;
            hw = r;
            reset = 0x0;
        } dxctl_dqsg_dcc[5:3];

        field {
            name = "dxctl_dq_dcc";
            desc = "bit[2]: dly_sel_xxx_DCC_16b bit[1]: ctrlC_xxx_DCC_16b bit[0]: ctrl2_xxx_DCC_16b";
            sw = rw;
            hw = r;
            reset = 0x0;
        } dxctl_dq_dcc[2:0];
    } DXNDCC @ 0x7C;

};

regfile eHISI_DDRC_V2_PHY {
    name = "DDRC V2 DDR PHY registers";
    desc = "DDR PHY registers, data sheet 4.1.7 (Table 4-7, base 0x20118000): PHY initialisation control/status, PLL, delay measurement, ZQ impedance calibration, DRAM configuration/timers, training (write leveling, gate, read/write data eye), BIST, address/command block (AC*) and the four data blocks `DX[n]`.";

    reg {
        name = "PHY control block version register";
        desc = "REVISION is a PHY control block version register.

Data sheet 4.1.7 REVISION (offset 0x0, printed page 4-96, dump line 37030).

Hardware: reads 0x00000012 on a Hi3518E V200 board (matches the reset value; never written).";

        field {
            name = "major";
            desc = "Major version of the PHY control block";
            sw = r;
            hw = w;
            reset = 0x0;
        } major[15:8];

        field {
            name = "minor";
            desc = "Minor version of the PHY control block";
            sw = r;
            hw = w;
            reset = 0x12;
        } minor[7:0];
    } REVISION @ 0x0;

    reg {
        name = "PHY initialization control register";
        desc = "Data sheet 4.1.7 PHYINITCTRL (offset 0x4, printed page 4-97, dump line 37063).

Hardware (Hi3518E V200 board, live dump of the PHY window): reads 0x80000000 at U-Boot and under Linux, i.e. after init and training only ctl_cke_bypass (bit 31) remains set and all trigger bits are 0 (the vendor table writes 0x80000021 for gate training, polls until the low bits clear, then clears phyconn_rst).";

        field {
            name = "ctl_cke_bypass";
            desc = "PACK CKE bypass function enable 1'b1: CKE is controlled by MC even when PACK controls the DFI interface. 1'b0: CKE is controlled by PACK when PACK controls the DFI interface.";
            sw = rw;
            hw = r;
            reset = 0x0;
        } ctl_cke_bypass[31:31];

        field {
            name = "phyconn_rst";
            desc = "PHY counter reset This field is used to set the PHY counter reset signal. To issue a reset signal to PHY counter, this field should be set to 1. To end the reset signal to PHY counter, this field should be cleared. Note that the reset signal connects to the A/C block counter and the counter of all of the data blocks.";
            sw = rw;
            hw = r;
            reset = 0x0;
        } phyconn_rst[15:15];

        field {
            name = "pack_rst";
            desc = "PACK reset This field is used to issue reset to all the digital circuits of the PACK including the register file. If this field is set to 1, all of the digital parts (including control registers) of the PHY will be set to default value. The reset will be automatically executed, and this bit will be cleared after reset is complete.";
            sw = rw;
            hw = r;
            reset = 0x0;
        } pack_rst[14:14];

        field {
            name = "phy_rst";
            desc = "PHY reset This field is used to set PHY reset signal. To issue a reset signal to the PHY, this field should be set to 1. To end the reset signal to the PHY, this field should be cleared. Note that the reset signal connects to the A/C block and all of the data blocks.";
            sw = rw;
            hw = r;
            reset = 0x0;
        } phy_rst[13:13];

        field {
            name = "dram_rst";
            desc = "DRAM reset This field is used to initiate the DRAM reset sequence. If this field is set to 1, RESET# and CKE will be pulled low for t_dram_rst. After t_dram_rst, the CKE RESET# is pulled to high while keeping CKE at low for t_cke_low. After t_cke_low, CKE is pulled to high, and after t_cke_high, this field is cleared automatically. For LPDDR2/LPDDR3, only CKE will be active during DRAM reset sequence.";
            sw = rw;
            hw = r;
            reset = 0x0;
        } dram_rst[12:12];

        field {
            name = "cat_en";
            desc = "HW CA training enable Writing 1 to this field starts the HW CA training sequence. This field will be cleared after CA training is complete. Note that the CA training applies only to LPDDR3.";
            sw = rw;
            hw = r;
            reset = 0x0;
        } cat_en[11:11];

        field {
            name = "dram_init_en";
            desc = "DRAM initialization enable This field is used to control whether the internal DRAM initialization sequence is executed after PHY initialization is complete. For LPDDR2/LPDDR3, this field will complete the initial sequence including tINIT3-tINIT5 & tZQC.";
            sw = rw;
            hw = r;
            reset = 0x0;
        } dram_init_en[10:10];

        field {
            name = "wdet_en";
            desc = "Write data eye training enable Writing 1 to this field starts the write data eye training sequence. This field will be cleared after the write data eye training is complete.";
            sw = rw;
            hw = r;
            reset = 0x0;
        } wdet_en[9:9];

        field {
            name = "rdet_en";
            desc = "Read data eye training enable Writing 1 to this field starts the read data eye training sequence. This field will be cleared after the read data eye training is complete.";
            sw = rw;
            hw = r;
            reset = 0x0;
        } rdet_en[8:8];

        field {
            name = "wl2_en";
            desc = "Second write leveling enable Writing 1 to this field starts write latency adjustment. This field will be cleared after adjustment is complete. Note that write leveling adjustment applies only to DDR3.";
            sw = rw;
            hw = r;
            reset = 0x0;
        } wl2_en[7:7];

        field {
            name = "gdst_en";
            desc = "PHY read data latch train enable Writing 1 to this field starts the read data latch position training. This field will be cleared after write leveling is complete.";
            sw = rw;
            hw = r;
            reset = 0x0;
        } gdst_en[6:6];

        field {
            name = "gt_en";
            desc = "Gate training enable Writing 1 to this field starts the gate training sequence. This field will be cleared after the gate training is complete.";
            sw = rw;
            hw = r;
            reset = 0x0;
        } gt_en[5:5];

        field {
            name = "wl_en";
            desc = "Write leveling enable Writing 1 to this field starts the write leveling sequence. This field will be cleared after write leveling is complete. Note that write leveling applies only to DDR3.";
            sw = rw;
            hw = r;
            reset = 0x0;
        } wl_en[4:4];

        field {
            name = "zcal_en";
            desc = "Impedance calibration enable This field is used to specify whether impedance calibration is executed. This bit will be cleared after impedance calibration is complete.";
            sw = rw;
            hw = r;
            reset = 0x1;
        } zcal_en[3:3];

        field {
            name = "dlymeas_en";
            desc = "Delay measurement enable This field is used to enable initial delay measurement of the activated read delay line. If it is set to 1, delay measurement is enabled.";
            sw = rw;
            hw = r;
            reset = 0x1;
        } dlymeas_en[2:2];

        field {
            name = "pll_init_en";
            desc = "PLL initialization enable If this field is used to activate the PLL initialization. If it is set to 1, the PLL is reset and waiting for a period of time for PLL to be locked.";
            sw = rw;
            hw = r;
            reset = 0x1;
        } pll_init_en[1:1];

        field {
            name = "init_en";
            desc = "PHY initialization enable Writing 1 to this field triggers the PHY initialization sequence. The exact initialization executed is specified in bits 1-15 of this register. If PHY initialization is complete, this bit will be cleared. Note that writing 0 to this field has no effect.";
            sw = rw;
            hw = r;
            reset = 0x0;
        } init_en[0:0];
    } PHYINITCTRL @ 0x4;

    reg {
        name = "PHY status register";
        desc = "PHYINITSTATUS is a PHY status register.

All error flags are `RWC` in the data sheet: modelled write-1-to-clear (the text of each field says writing 1 clears the error status).

Data sheet 4.1.7 PHYINITSTATUS (offset 0x8, printed page 4-99, dump line 37194).";

        field {
            name = "cat_err";
            desc = "CA training error This field indicates whether an error occurs during CA training. Writing 1 to this field clears the error status.";
            sw = rw;
            hw = w;
            onwrite = woclr;
            reset = 0x0;
        } cat_err[10:10];

        field {
            name = "wdet_err";
            desc = "Write data eye calibration error This field indicates whether an error occurs during write data eye calibration. Writing 1 to this field clears the error status.";
            sw = rw;
            hw = w;
            onwrite = woclr;
            reset = 0x0;
        } wdet_err[9:9];

        field {
            name = "rdet_err";
            desc = "Read data eye calibration error This field indicates whether an error occurs during read data eye calibration. Writing 1 to this field clears the error status.";
            sw = rw;
            hw = w;
            onwrite = woclr;
            reset = 0x0;
        } rdet_err[8:8];

        field {
            name = "wl2_err";
            desc = "Write leveling adjustment error This field indicates whether an error occurs during write leveling adjustment. Writing 1 to this field clears the error status.";
            sw = rw;
            hw = w;
            onwrite = woclr;
            reset = 0x0;
        } wl2_err[7:7];

        field {
            name = "gdst_err";
            desc = "PHY read data latch train error This field indicates whether an error occurs during read data latch training. Writing 1 to this field clears the error status.";
            sw = rw;
            hw = w;
            onwrite = woclr;
            reset = 0x0;
        } gdst_err[6:6];

        field {
            name = "gt_err";
            desc = "Gate training error This field indicates whether an error occurs during gate training. Writing 1 to this field clears the error status.";
            sw = rw;
            hw = w;
            onwrite = woclr;
            reset = 0x0;
        } gt_err[5:5];

        field {
            name = "wl_err";
            desc = "Write leveling error This field indicates whether an error occurs during write leveling. Writing 1 to this field clears the error status.";
            sw = rw;
            hw = w;
            onwrite = woclr;
            reset = 0x0;
        } wl_err[4:4];

        field {
            name = "zcal_err";
            desc = "Impedance calibration error This field indicates whether an error occurs during impedance calibration. Writing 1 to this field clears the error status.";
            sw = rw;
            hw = w;
            onwrite = woclr;
            reset = 0x0;
        } zcal_err[3:3];

        field {
            name = "dlymeas_err";
            desc = "Delay measurement fail This field indicates whether one of the initial delay measurements fails. Writing 1 to this field clears the error status.";
            sw = rw;
            hw = w;
            onwrite = woclr;
            reset = 0x0;
        } dlymeas_err[2:2];

        field {
            name = "pll_lock_err";
            desc = "PLL locked fail This field indicates whether one of the PLLs within the PHY fails to assert locked flag after t_pll_lock timer. Writing 1 to this field clears the error status.";
            sw = rw;
            hw = w;
            onwrite = woclr;
            reset = 0x0;
        } pll_lock_err[1:1];
    } PHYINITSTATUS @ 0x8;

    reg {
        name = "PHY clock gating control register";
        desc = "PHYCLKGATED is a PHY clock gating control register.

Data sheet 4.1.7 PHYCLKGATED (offset 0xC, printed page 4-100, dump line 37263).

Hardware (Hi3518E V200 board, live dump): the vendor table writes 0x80000F0F, the PHY reads 0x80000F03 at U-Boot and under Linux, so dx_phy_clkgated[3:2] (data lanes 2 and 3, unused with the 16-bit bus) read 0. Nothing in the vendor training writes this register; the change is made by the PHY or the init.";

        enum PHYCLKGATED_byp_pll_lock_enum {
            USE_PLL_LOCK = 0 { name = "Use Pll Lock"; desc = "use the PLL lock to gate the PHY clocks to prevent clock glitch"; };
            BYPASS_PLL_LOCK = 1 { name = "Bypass Pll Lock"; desc = "bypass the PLL lock (do not use the PLL lock signal to gate the PHY clocks)"; };
        };

        field {
            name = "byp_pll_lock";
            desc = "PLL lock bypass. The user can assert this field to bypass the PLL lock signal when re-locking the PLL in the bypass mode (DFS) or when the PLL lock signal cannot be used.";
            sw = rw;
            hw = r;
            encode = PHYCLKGATED_byp_pll_lock_enum;
            reset = 0x0;
        } byp_pll_lock[31:31];

        enum PHYCLKGATED_dx_phgated_men_enum {
            DISABLED = 0 { name = "Disabled"; desc = "disabled"; };
            ENABLED = 1 { name = "Enabled"; desc = "enabled"; };
        };

        field {
            name = "dx_phgated_men";
            desc = "PHY phase clock gated manual control enable. This field takes effect only when dx_phgated_en is 1'b0. If dx_phgated_en is high and this field is high, the user can use dx_phclkgated to manually control the clock gating of the PHY phase clock.";
            sw = rw;
            hw = r;
            encode = PHYCLKGATED_dx_phgated_men_enum;
            reset = 0x0;
        } dx_phgated_men[12:12];

        enum PHYCLKGATED_dx_phclkgated_enum {
            CLOCK_DISABLED = 0 { name = "Clock Disabled"; desc = "The clock is disabled."; };
            CLOCK_ENABLED = 1 { name = "Clock Enabled"; desc = "The clock is enabled."; };
        };

        field {
            name = "dx_phclkgated";
            desc = "PHY phase clock gated control. This field takes effect only when dx_phgated_en is 1'b0. If dx_phgated_en is '1b1, this field is used, and the gated function is automatically controlled by PACK FSM.";
            sw = rw;
            hw = r;
            encode = PHYCLKGATED_dx_phclkgated_enum;
            reset = 0x0;
        } dx_phclkgated[11:11];

        enum PHYCLKGATED_dx_phgated_en_enum {
            DISABLED = 0 { name = "Disabled"; desc = "disabled"; };
            ENABLED = 1 { name = "Enabled"; desc = "enabled"; };
        };

        field {
            name = "dx_phgated_en";
            desc = "PHY phase clock gated function (automatically controlled by PACK FSM) enable";
            sw = rw;
            hw = r;
            encode = PHYCLKGATED_dx_phgated_en_enum;
            reset = 0x1;
        } dx_phgated_en[10:10];

        enum PHYCLKGATED_ck_phy_clkgated_enum {
            CLOCK_GATED = 0 { name = "Clock Gated"; desc = "The clock is gated."; };
            CLOCK_ENABLED = 1 { name = "Clock Enabled"; desc = "The clock is enabled."; };
        };

        field {
            name = "ck_phy_clkgated";
            desc = "Dedicated clock gated control for the output CK and related circuits";
            sw = rw;
            hw = r;
            encode = PHYCLKGATED_ck_phy_clkgated_enum;
            reset = 0x0;
        } ck_phy_clkgated[9:9];

        enum PHYCLKGATED_ac_phy_clkgated_enum {
            CLOCK_GATED = 0 { name = "Clock Gated"; desc = "The clock is gated."; };
            CLOCK_ENABLED = 1 { name = "Clock Enabled"; desc = "The clock is enabled."; };
        };

        field {
            name = "ac_phy_clkgated";
            desc = "Clock gated for the circuits in AC block except CK and CK related circuits";
            sw = rw;
            hw = r;
            encode = PHYCLKGATED_ac_phy_clkgated_enum;
            reset = 0x0;
        } ac_phy_clkgated[8:8];

        enum PHYCLKGATED_dx_phy_clkgated_enum {
            CLOCK_GATED = 0 { name = "Clock Gated"; desc = "The clock is gated."; };
            CLOCK_ENABLED = 1 { name = "Clock Enabled"; desc = "The clock is enabled."; };
        };

        field {
            name = "dx_phy_clkgated";
            desc = "Clock gated for circuits in data blocks";
            sw = rw;
            hw = r;
            encode = PHYCLKGATED_dx_phy_clkgated_enum;
            reset = 0x0;
        } dx_phy_clkgated[3:0];
    } PHYCLKGATED @ 0xC;

    reg {
        name = "PHY timing parameter register";
        desc = "PHYTIMER0 is a PHY timing parameter register. The timing parameters are required by the PHY.

Data sheet 4.1.7 PHYTIMER0 (offset 0x10, printed page 4-102, dump line 37361).";

        field {
            name = "t_dram_cke_high";
            desc = "DRAM CKE high initialization This field specifies the number of PCLK clock cycles of the first DRAM command from CKE pulled to high (LPDDR2/LPDDR3 tINIT3).";
            sw = rw;
            hw = r;
            reset = 0x00027100;
        } t_dram_cke_high[31:12];

        field {
            name = "t_dram_reset";
            desc = "DDR3 DRAM reset. This field is used to specify the time issuing reset signaling to the DRAM (number of PCLK clock cycles).";
            sw = rw;
            hw = r;
            reset = 0xF;
        } t_dram_reset[7:0];
    } PHYTIMER0 @ 0x10;

    reg {
        name = "DRAM CKE low initialization register";
        desc = "PHYTIMER1 is a DRAM CKE low initialization register.

Data sheet 4.1.7 PHYTIMER1 (offset 0x14, printed page 4-102, dump line 37386).";

        field {
            name = "t_dram_cke_low";
            desc = "DRAM CKE low initialization This field specifies the number of PCLK clock cycles during which CKE should be kept low after power is reset and the clock is stable.";
            sw = rw;
            hw = r;
            reset = 0x2000;
        } t_dram_cke_low[15:0];
    } PHYTIMER1 @ 0x14;

    reg {
        name = "Timing parameter register for the PLL in both address/command and data block";
        desc = "PLLCTRL is a timing parameter register for the PLL in both address/command and data block.

Data sheet 4.1.7 PLLCTRL (offset 0x18, printed page 4-103, dump line 37419).";

        field {
            name = "pll_freq_range";
            desc = "PLL frequency range select This field specifies the frequency input range of the PLLs.";
            sw = rw;
            hw = r;
            reset = 0x0;
        } pll_freq_range[5:4];

        field {
            name = "pll_pwdn";
            desc = "PLL power down This field is used to set the power-down status of the PLL input. If this field is set to 1, the PLL power-down pin is activated. Writing 0 to this field will remove the deactivated PLL power down pin. Bit[2] for AC PLL Bit[1] for DX1 (DATA1) PLL Bit[0] for DX0 (DATA0) PLL";
            sw = rw;
            hw = r;
            reset = 0x0;
        } pll_pwdn[2:0];
    } PLLCTRL @ 0x18;

    reg {
        name = "PLL address/command and data block control register";
        desc = "PLLTIMER is a PLL address/command and data block control register.

Data sheet 4.1.7 PLLTIMER (offset 0x1C, printed page 4-103, dump line 37456).";

        field {
            name = "t_pll_lock";
            desc = "PLL lock time This field specifies the number of PCLK clock cycles waiting for the PLL to be locked.";
            sw = rw;
            hw = r;
            reset = 0x4E20;
        } t_pll_lock[31:16];

        field {
            name = "t_pll_rst";
            desc = "PLL reset time This field specifies the number of PCLK clock cycles to issue reset to the PLL.";
            sw = rw;
            hw = r;
            reset = 0x80;
        } t_pll_rst[7:0];
    } PLLTIMER @ 0x1C;

    reg {
        name = "Read delay line delay measurement control register";
        desc = "DLYMEASCTRL is a read delay line delay measurement control register.

Data sheet 4.1.7 DLYMEASCTRL (offset 0x20, printed page 4-104, dump line 37492).";

        field {
            name = "dly_track_limit";
            desc = "Delay tracking limit This field specifies the maximum number of accumulated taps allowed while dynamic tracking.";
            sw = rw;
            hw = r;
            reset = 0x4;
        } dly_track_limit[14:8];

        field {
            name = "phy_autoref_en";
            desc = "PHY auto-refresh tracking enable";
            sw = rw;
            hw = r;
            reset = 0x1;
        } phy_autoref_en[6:6];

        field {
            name = "dynamic_dqsen";
            desc = "Dynamic DQS tracking enable This field should be set to high during delay measurement.";
            sw = rw;
            hw = r;
            reset = 0x1;
        } dynamic_dqsen[5:5];

        field {
            name = "dynamic_dqsgen";
            desc = "Dynamic DQSG tracking enable";
            sw = rw;
            hw = r;
            reset = 0x1;
        } dynamic_dqsgen[4:4];

        enum DLYMEASCTRL_dynamic_dqsgth_enum {
            UPDATE_EVERY_4 = 0 { name = "Update Every 4"; desc = "update every 4 times"; };
            UPDATE_EVERY_2 = 1 { name = "Update Every 2"; desc = "update every 2 times 2 or 3: update each time"; };
        };

        field {
            name = "dynamic_dqsgth";
            desc = "Dynamic DQSG update threshold This field specifies the number of taps accumulated before the RDQSG delay line is updated.";
            sw = rw;
            hw = r;
            encode = DLYMEASCTRL_dynamic_dqsgth_enum;
            reset = 0x0;
        } dynamic_dqsgth[3:2];

        field {
            name = "dly_track_type";
            desc = "Delay tracking type This field specifies whether priority updated from the PHY is used during dynamic tracking. If this field is set to 1, the priority updated from the PHY is used.";
            sw = rw;
            hw = r;
            reset = 0x0;
        } dly_track_type[1:1];

        field {
            name = "dly_meas_type";
            desc = "Delay measurement type This field specifies whether the delay measurement is for one clock cycle or half a clock cycle. If this field is set to 1, a full clock cycle is measured.";
            sw = rw;
            hw = r;
            reset = 0x1;
        } dly_meas_type[0:0];
    } DLYMEASCTRL @ 0x20;

    reg {
        name = "ZQ calibration control register";
        desc = "IMPCTRL is a ZQ calibration control register.

Data sheet 4.1.7 IMPCTRL (offset 0x24, printed page 4-105, dump line 37553).";

        enum IMPCTRL_zcfuzzy_en_enum {
            DISABLED = 0 { name = "Disabled"; desc = "disabled"; };
            ENABLED = 1 { name = "Enabled"; desc = "enabled (default)"; };
        };

        field {
            name = "zcfuzzy_en";
            desc = "ZQ comparator result selection by weighted method. When this function is disabled, the precision is improved but ZQ comparison may fail. When this function is enabled, ZQ comparison is successful.";
            sw = rw;
            hw = r;
            encode = IMPCTRL_zcfuzzy_en_enum;
            reset = 0x1;
        } zcfuzzy_en[31:31];

        field {
            name = "zcomp_num";
            desc = "ZQ comparator iteration time This field specifies the iteration time of zcomp changing detection.";
            sw = rw;
            hw = r;
            reset = 0x8;
        } zcomp_num[15:12];

        field {
            name = "zcomp_rsp_dly";
            desc = "ZQ comparator response time This field specifies the delay of the zcomp result after zctrl is used.";
            sw = rw;
            hw = r;
            reset = 0x20;
        } zcomp_rsp_dly[5:0];
    } IMPCTRL @ 0x24;

    reg {
        name = "ZQ calibration result register";
        desc = "IMPSTATUS is a ZQ calibration status register.

The stock vendor image writes 0x121B0B18 here: the writable zcode_pdrv [21:16] / zcode_ndrv [5:0] manual impedance codes (the other fields are read-only calibration results).

Data sheet 4.1.7 IMPSTATUS (offset 0x28, printed page 4-106, dump line 37601).

Hardware (Hi3518E V200 board, live dump): the vendor table writes 0x121B0B18 (manual impedance codes) but the register reads 0x001B0018 at U-Boot and under Linux, so the PHY updates it (impedance calibration result), treat it as a status the PHY overwrites.";

        field {
            name = "zcode_pdrv_cal";
            desc = "P-drive impedance calibration code This field shows the p-drive calibration code during impedance calibration.";
            sw = r;
            hw = w;
            reset = 0x0;
        } zcode_pdrv_cal[30:24];

        enum IMPSTATUS_pdrv_cal_result_enum {
            CALIBRATION_COMPLETE_WITHOUT = 0 { name = "Calibration Complete Without"; desc = "The calibration is complete without error."; };
            CALIBRATION_COMPLETE_WITH = 1 { name = "Calibration Complete With"; desc = "The calibration is complete with an error. Writing 1 to this field clears this field."; };
        };

        field {
            name = "pdrv_cal_result";
            desc = "P-drive calibration result This field specifies the ZQ calibration result. The valid values are as follows:";
            sw = r;
            hw = w;
            encode = IMPSTATUS_pdrv_cal_result_enum;
            reset = 0x0;
        } pdrv_cal_result[23:23];

        field {
            name = "zcode_pdrv";
            desc = "P-drive impedance control code This field is used to specify the p-drive impedance control code. This register is updated by the user or is updated each time the ZQ calibration is complete.";
            sw = rw;
            hw = r;
            reset = 0x20;
        } zcode_pdrv[21:16];

        field {
            name = "zcode_ndrv_cal";
            desc = "N-drive impedance calibration code This field shows the n-driver calibration code during impedance calibration.";
            sw = r;
            hw = w;
            reset = 0x0;
        } zcode_ndrv_cal[14:8];

        enum IMPSTATUS_ndrv_cal_result_enum {
            CALIBRATION_COMPLETE_WITHOUT = 0 { name = "Calibration Complete Without"; desc = "The calibration is complete without error."; };
            CALIBRATION_COMPLETE_WITH = 1 { name = "Calibration Complete With"; desc = "The calibration is complete with an error. Writing 1 to this field clears this field."; };
        };

        field {
            name = "ndrv_cal_result";
            desc = "N-drive calibration result This field specifies the ZQ calibration result. The valid values are as follows:";
            sw = r;
            hw = w;
            encode = IMPSTATUS_ndrv_cal_result_enum;
            reset = 0x0;
        } ndrv_cal_result[7:7];

        field {
            name = "zcode_ndrv";
            desc = "N-drive impedance control code This field is used to specify the n-drive impedance control code. This register is updated by the user or is updated each time the ZQ calibration is complete.";
            sw = rw;
            hw = r;
            reset = 0x20;
        } zcode_ndrv[5:0];
    } IMPSTATUS @ 0x28;

    reg {
        name = "DRAM system configuration register";
        desc = "DRAMCFG is a DRAM system configuration register.

DATA SHEET ERROR: the dcfg_type table lists only 010 = DDR3 and 101 = LPDDR2/LPDDR3, but the data sheet init procedure (4.1.4.3 step 10) writes DRAMCFG = 0x21 for DDR2 (dcfg_type = 001, ma2t = 1) and the stock vendor image writes 0x21: 001 = DDR2.

Data sheet 4.1.7 DRAMCFG (offset 0x2C, printed page 4-107, dump line 37668).";

        enum DRAMCFG_lpddr23_zqc_en_enum {
            DISABLED = 0 { name = "Disabled"; desc = "disabled"; };
            ISSUE_ZQC_COMMANDS = 1 { name = "Issue Zqc Commands"; desc = "issue ZQC(init) commands during initialization sequence rank by rank (default)."; };
        };

        field {
            name = "lpddr23_zqc_en";
            desc = "LPDDR2/LPDDR3 initialization ZQC (init) enable";
            sw = rw;
            hw = r;
            encode = DRAMCFG_lpddr23_zqc_en_enum;
            reset = 0x1;
        } lpddr23_zqc_en[10:10];

        enum DRAMCFG_lpddr23_mrw1617_en_enum {
            DISABLED = 0 { name = "Disabled"; desc = "disabled (default)"; };
            ISSUE_MRW16_THEN = 1 { name = "Issue Mrw16 Then"; desc = "issue MRW16 then MRW17 commands during initialization sequence"; };
        };

        field {
            name = "lpddr23_mrw1617_en";
            desc = "LPDDR2/LPDDR3 initialization MRW16/17 enable";
            sw = rw;
            hw = r;
            encode = DRAMCFG_lpddr23_mrw1617_en_enum;
            reset = 0x0;
        } lpddr23_mrw1617_en[9:9];

        enum DRAMCFG_lpddr23_pre_en_enum {
            DISABLED = 0 { name = "Disabled"; desc = "disabled (default)"; };
            ISSUE_PRECHARGE_ALL = 1 { name = "Issue Precharge All"; desc = "issue the precharge all command before the reset command during initialization sequence"; };
        };

        field {
            name = "lpddr23_pre_en";
            desc = "LPDDR2/LPDDR3 initialization precharge all enable";
            sw = rw;
            hw = r;
            encode = DRAMCFG_lpddr23_pre_en_enum;
            reset = 0x0;
        } lpddr23_pre_en[8:8];

        field {
            name = "maddr_mir";
            desc = "Address mirroring This bit should be set to 0 in single rank configuration";
            sw = rw;
            hw = r;
            reset = 0x0;
        } maddr_mir[6:6];

        field {
            name = "ma2t";
            desc = "Two cycles on address/command This field specifies whether the 2T timing should be used by the PHY controller that internally generates the DRAM command.";
            sw = rw;
            hw = r;
            reset = 0x0;
        } ma2t[5:5];

        field {
            name = "nosra";
            desc = "No simultaneous rank access This field specifies whether simultaneously rank access in the same clock cycle is allowed. If it set to 1, the rank access will be taken in turn. Note that this field can be enabled only when the number of ranks is 2 or 4. This field should be set to 0 in single rank configuration.";
            sw = rw;
            hw = r;
            reset = 0x0;
        } nosra[4:4];

        enum DRAMCFG_dcfg_type_enum {
            DDR3 = 2 { name = "Ddr3"; desc = "DDR3"; };
            LPDDR2_LPDDR3_OTHER = 5 { name = "Lpddr2 Lpddr3 Other"; desc = "LPDDR2/LPDDR3 Other values: reserved"; };
        };

        field {
            name = "dcfg_type";
            desc = "DRAM type selection This field specifies the DDR RAM type. The valid values are as follows:";
            sw = rw;
            hw = r;
            encode = DRAMCFG_dcfg_type_enum;
            reset = 0x5;
        } dcfg_type[2:0];
    } DRAMCFG @ 0x2C;

    reg {
        name = "DRAM timing parameter register 0";
        desc = "DRAMTIMER0 is a DRAM timing parameter register. The command delay specified in this register applies only to the command issued by the PHY controller internally.

Data sheet 4.1.7 DRAMTIMER0 (offset 0x30, printed page 4-108, dump line 37749).";

        field {
            name = "t_rc";
            desc = "Activated to activated on same bank command delay";
            sw = rw;
            hw = r;
            reset = 0x0;
        } t_rc[31:26];

        field {
            name = "t_rrd";
            desc = "Activated to activated on different bank command delay";
            sw = rw;
            hw = r;
            reset = 0x0;
        } t_rrd[25:22];

        field {
            name = "t_ras";
            desc = "Activated to precharge command delay";
            sw = rw;
            hw = r;
            reset = 0x0;
        } t_ras[21:16];

        field {
            name = "t_rcd";
            desc = "Activated to read/write delay";
            sw = rw;
            hw = r;
            reset = 0x0;
        } t_rcd[15:12];

        field {
            name = "t_rp";
            desc = "Precharge command period The unit is two clock cycles.";
            sw = rw;
            hw = r;
            reset = 0x0;
        } t_rp[11:8];

        field {
            name = "t_wtr";
            desc = "Write to read command delay";
            sw = rw;
            hw = r;
            reset = 0x0;
        } t_wtr[7:4];

        field {
            name = "t_rtp";
            desc = "Read to precharge command delay";
            sw = rw;
            hw = r;
            reset = 0x0;
        } t_rtp[3:0];
    } DRAMTIMER0 @ 0x30;

    reg {
        name = "DRAM timing parameter register 1";
        desc = "Data sheet 4.1.7 DRAMTIMER1 (offset 0x34, printed page 4-109, dump line 37785).";

        field {
            name = "t_rtw";
            desc = "Read to write command delay This field specifies whether to insert extra cycles between read and write commands to compensate tdqsck. This value should be 3 for the common condition when DDR3 is used. This value should be 6 for the common condition when LPDDR2/LPDDR3 is used.";
            sw = rw;
            hw = r;
            reset = 0x0;
        } t_rtw[29:25];

        field {
            name = "t_rfc";
            desc = "Refresh to refresh command delay";
            sw = rw;
            hw = r;
            reset = 0x0;
        } t_rfc[24:16];

        field {
            name = "t_faw";
            desc = "Four-bank activated period. This field applies only to the 8-bank device.";
            sw = rw;
            hw = r;
            reset = 0x0;
        } t_faw[14:9];

        field {
            name = "t_mod";
            desc = "Load mode register to non load mode register command delay. This field is used as max (t_mod, t_mrd) in DDR3, max (t_mrw, tmrd) in LPDDR3, and t_mrw in LPDDR2.";
            sw = rw;
            hw = r;
            reset = 0x0;
        } t_mod[8:4];

        field {
            name = "t_mrd";
            desc = "Load mode register to load mode register command delay (not used)";
            sw = rw;
            hw = r;
            reset = 0x0;
        } t_mrd[3:0];
    } DRAMTIMER1 @ 0x34;

    reg {
        name = "DRAM timing parameter register 2";
        desc = "Data sheet 4.1.7 DRAMTIMER2 (offset 0x38, printed page 4-110, dump line 37829).";

        field {
            name = "t_ccd";
            desc = "Read to read and write to write command delay 0 = BL/2 (for DDR3, this value should be 4) 1 = BL/2 + 1 (for DDR3, this value should be 5)";
            sw = rw;
            hw = r;
            reset = 0x0;
        } t_ccd[31:31];

        field {
            name = "t_dllk";
            desc = "DLL lock time";
            sw = rw;
            hw = r;
            reset = 0x0;
        } t_dllk[29:20];

        field {
            name = "t_cke";
            desc = "CKE minimum pulse width";
            sw = rw;
            hw = r;
            reset = 0x0;
        } t_cke[19:16];

        field {
            name = "t_xp";
            desc = "Power down exit delay";
            sw = rw;
            hw = r;
            reset = 0x0;
        } t_xp[14:10];

        field {
            name = "t_xs";
            desc = "Self refresh exit delay";
            sw = rw;
            hw = r;
            reset = 0x0;
        } t_xs[9:0];
    } DRAMTIMER2 @ 0x38;

    reg {
        name = "DRAM timing parameter register 3";
        desc = "Data sheet 4.1.7 DRAMTIMER3 (offset 0x3C, printed page 4-110, dump line 37858).";

        field {
            name = "t_wr";
            desc = "Write recovery cycle";
            sw = rw;
            hw = r;
            reset = 0x0;
        } t_wr[31:28];

        field {
            name = "t_wl";
            desc = "Write latency (AL + CWL)";
            sw = rw;
            hw = r;
            reset = 0x0;
        } t_wl[27:24];

        field {
            name = "t_init5";
            desc = "LPDDR device initialization time This field specifies the time during which the LPDDR sets the DAI bit to 1.";
            sw = rw;
            hw = r;
            reset = 0x400;
        } t_init5[23:10];

        field {
            name = "t_zcal";
            desc = "ZQ calibration to command delay This field specifies the number of clock cycles to wait after initial ZQ calibration. For DDR3 ZQ normal operation full calibration, this value is divided by 2. For DDR3 ZQ initialization calibration, this value is divided by 4. For LPDDR2/3, this field specifies the value of tZQINIT during initialization.";
            sw = rw;
            hw = r;
            reset = 0x200;
        } t_zcal[9:0];
    } DRAMTIMER3 @ 0x3C;

    reg {
        name = "DRAM write leveling timing parameter register";
        desc = "DRAMTIMER4 is a DRAM write leveling timing parameter register. This register applies only to the DDR3/LPDDR3 SDRAM.

Data sheet 4.1.7 DRAMTIMER4 (offset 0x40, printed page 4-111, dump line 37899).";

        field {
            name = "t_odton";
            desc = "ODT turn-on latency (number of cycles from write command to assert of ODT)";
            sw = rw;
            hw = r;
            reset = 0x0;
        } t_odton[27:24];

        field {
            name = "t_odt";
            desc = "ODT turn-on cycles";
            sw = rw;
            hw = r;
            reset = 0x0;
        } t_odt[15:12];

        field {
            name = "t_wlo";
            desc = "Write leveling output delay This field specifies the write leveling output delay in cycles (dficlk cycle).";
            sw = rw;
            hw = r;
            reset = 0x0;
        } t_wlo[11:7];

        field {
            name = "t_wlmrd";
            desc = "Write leveling mode programmed (load mode register) to first DQS/DQS# rising edge delay (dficlk cycle)";
            sw = rw;
            hw = r;
            reset = 0x0;
        } t_wlmrd[5:0];
    } DRAMTIMER4 @ 0x40;

    reg {
        name = "Rank ODT control register while reading or writing to particular ranks";
        desc = "ODTCR is a rank ODT control register while reading or writing to particular ranks.

Data sheet 4.1.7 ODTCR (offset 0x44, printed page 4-112, dump line 37944).";

        field {
            name = "wodt_rank3";
            desc = "Write rank 3 ODT control This field specifies the ODT issued while write on rank 3. The valid bit width is the number of ranks.";
            sw = rw;
            hw = r;
            reset = 0x0;
        } wodt_rank3[15:12];

        field {
            name = "wodt_rank2";
            desc = "Write rank 2 ODT control This field specifies the ODT issued while write on rank 2. The valid bit width is the number of ranks.";
            sw = rw;
            hw = r;
            reset = 0x0;
        } wodt_rank2[11:8];

        field {
            name = "wodt_rank1";
            desc = "Write rank 1 ODT control This field specifies the ODT issued while write on rank 1. The valid bit width is the number of ranks.";
            sw = rw;
            hw = r;
            reset = 0x0;
        } wodt_rank1[7:4];

        field {
            name = "wodt_rank0";
            desc = "Write rank 0 ODT control This field specifies the ODT issued while write on rank 0. The valid bit width is the number of ranks.";
            sw = rw;
            hw = r;
            reset = 0x0;
        } wodt_rank0[3:0];
    } ODTCR @ 0x44;

    reg {
        name = "Training control register";
        desc = "TRAINCTRL0 is a training control register.

Data sheet 4.1.7 TRAINCTRL0 (offset 0x48, printed page 4-113, dump line 37984).

Hardware: reads 0xD0441080 on a Hi3518E V200 board in both U-Boot and Linux, which equals the data sheet reset value although nothing in the vendor init writes it.";

        field {
            name = "skip_eye_opening";
            desc = "Skip eye opening of data eye training This field specifies whether the eye opening should be skipped. If this field is set to 1, the eye opening before data eye training is skipped. If this field is set to 0, the eye opening is executed before data eye training.";
            sw = rw;
            hw = r;
            reset = 0x1;
        } skip_eye_opening[31:31];

        field {
            name = "dtrerrstop";
            desc = "Data training error stop This field controls whether the data training is terminated if an error occurs. The data training is stopped if this bit is set to 1. If this bit set to 0, the training will continue even an error occurs. The error status is recorded no matter when this field is set to 0 or 1.";
            sw = rw;
            hw = r;
            reset = 0x1;
        } dtrerrstop[30:30];

        field {
            name = "gtds_rspdly";
            desc = "Gate/Read latch training response delay This field specifies the waiting time to check the response from PHY while gate and read latch training is performed (dficlk cycle).";
            sw = rw;
            hw = r;
            reset = 0x10;
        } gtds_rspdly[29:24];

        field {
            name = "dqsg_cstep";
            desc = "Gate training coarse tuning step (the unit is phase). The recommended values are 0x0-0x2. 2'd0: step = 1 2'd1: step = 2 (default) 2'd2: step = 3 2'd3: step = 4";
            sw = rw;
            hw = r;
            reset = 0x1;
        } dqsg_cstep[23:22];

        field {
            name = "dqsgrt_chk";
            desc = "Gate retraining check window This field specifies the delta value to be checked during gate retraining check. The delta is added/subtracted to/from the read DQS gate. This position is checked to determine whether gating phase adjustment is required. The phase movement is the configured value multiple by 2. Note that 3'b000 is reserved and should not be used. The recommended values are 0x1-0x3.";
            sw = rw;
            hw = r;
            reset = 0x4;
        } dqsgrt_chk[21:16];

        field {
            name = "dqsgrt_shft";
            desc = "Gate retraining shift window This field specifies the value to be shifted if gate phase adjustment is required after gate retraining checks. The phase movement is the configured value multiple by 2. Note that 3'b000 is reserved and should not be used. The recommended value is dqsgrt_chk.";
            sw = rw;
            hw = r;
            reset = 0x4;
        } dqsgrt_shft[15:10];

        field {
            name = "dqsgsl_mrgn";
            desc = "Read DQS gate margin This field specifies the margin to be reserved after the DQS gate training. The number of phases specified in this field is decreased to create DQS gating margin. The valid values are as follows: 6'b00100: 1/4 cycle 6'b01000: 1/2 cycle (recommended) 6'b01100: 3/4 cycle 6'b10000: 1 cycle Other values: reserved";
            sw = rw;
            hw = r;
            reset = 0x8;
        } dqsgsl_mrgn[9:4];

        field {
            name = "dtr_rank";
            desc = "Training rank This field specifies the rank used for training. After the training, this field is used to select the source of rank specific settings.";
            sw = rw;
            hw = r;
            reset = 0x0;
        } dtr_rank[3:0];
    } TRAINCTRL0 @ 0x48;

    reg {
        name = "Training rank control register";
        desc = "RANKEN is a training rank control register.

Data sheet 4.1.7 RANKEN (offset 0x4C, printed page 4-114, dump line 38070).

Hardware (Hi3518E V200 board, live dump): reads 0x00000001 (one rank enabled) although the data sheet reset value is 0x3; nothing in the vendor table writes it, so the PHY derives it (probably from the DMC rank setting).";

        enum RANKEN_rank_en_enum {
            DISABLED = 0x0 { name = "Disabled"; desc = "disabled"; };
            ENABLED_BIT_0 = 0x1 { name = "Enabled Bit 0"; desc = "enabled (default) Bit 0 indicates rank 0. Bit 1 indicates rank 1. ... Bit 15 indicates rank 15. The maximum number of ranks is specified by the system."; };
        };

        field {
            name = "rank_en";
            desc = "Training rank enable This field specifies whether the dtr_rank is enabled.";
            sw = rw;
            hw = r;
            encode = RANKEN_rank_en_enum;
            reset = 0x3;
        } rank_en[15:0];
    } RANKEN @ 0x4C;

    reg {
        name = "Data training memory start address register";
        desc = "TRAINMADDR is a data training memory start address register. The minimum space required for the data training is 64 bytes, and the allocated memory must be 64-byte-aligned.

Data sheet 4.1.7 TRAINMADDR (offset 0x50, printed page 4-115, dump line 38107).";

        field {
            name = "dtrow";
            desc = "Data training row address This field is used to configure the memory row address required for the data training.";
            sw = rw;
            hw = r;
            reset = 0x0;
        } dtrow[31:16];

        field {
            name = "dtcol";
            desc = "Data training column address This field is used to configure the column address required for the data training. The field should be 0.";
            sw = rw;
            hw = r;
            reset = 0x0;
        } dtcol[15:4];

        field {
            name = "dtbank";
            desc = "Data training bank address This field is used to configure the memory bank address required for the data training.";
            sw = rw;
            hw = r;
            reset = 0x0;
        } dtbank[2:0];
    } TRAINMADDR @ 0x50;

    reg {
        name = "Built-in self test (BIST) behavior register";
        desc = "BISTCTRL is a BIST behavior register.

Data sheet 4.1.7 BISTCTRL (offset 0x54, printed page 4-116, dump line 38148).";

        field {
            name = "bist_fail_stop";
            desc = "BIST stop error count This field specifies the number of failures at which the BIST should be stopped. If this field is set to 0x00, the BIST will run infinite until the BIST operation is stopped or reset. If a non-zero value is specified, the BIST is stopped while the accumulated errors reach the count specified in this field.";
            sw = rw;
            hw = r;
            reset = 0x0;
        } bist_fail_stop[23:16];

        enum BISTCTRL_bist_pat_enum {
            WALKING_0 = 0 { name = "Walking 0"; desc = "walking 0"; };
            WALKING_1 = 1 { name = "Walking 1"; desc = "walking 1"; };
            LFSR_BASED_RANDOM = 2 { name = "Lfsr Based Random"; desc = "LFSR-based random generation"; };
            USER_PROGRAMMED = 3 { name = "User Programmed"; desc = "user programmed"; };
        };

        field {
            name = "bist_pat";
            desc = "BIST pattern generation This field specifies the BIST pattern generated for test. Note that bist_pat can be changed only when bist_done is 1.";
            sw = rw;
            hw = r;
            encode = BISTCTRL_bist_pat_enum;
            reset = 0x0;
        } bist_pat[9:8];

        enum BISTCTRL_bist_mode_enum {
            PATTERN_GENERATED_ONLY = 0 { name = "Pattern Generated Only"; desc = "pattern generated only"; };
            LOOPBACK_BEFORE_OUTPUT = 4 { name = "Loopback Before Output"; desc = "loopback before output buffer"; };
            LOOPBACK_AFTER_OUTPUT = 5 { name = "Loopback After Output"; desc = "loopback after output buffer"; };
            DRAM_READ_WRITE = 6 { name = "Dram Read Write"; desc = "DRAM read/write mode Other values: reserved Note that bist_mode can be changed only when bist_done is 1. When the data loopback mode is selected, swapwl_en/swap_en must be set to all zeros (no swap)."; };
        };

        field {
            name = "bist_mode";
            desc = "BIST mode select This field specifies the BIST mode. The valid values are as follows:";
            sw = rw;
            hw = r;
            encode = BISTCTRL_bist_mode_enum;
            reset = 0x0;
        } bist_mode[6:4];

        field {
            name = "bist_op";
            desc = "During Reg write, this field is used for selecting the BIST operation. The valid values are as follows: 00: BIST stop 01: BIST run 10: BIST reset 11: reserved Writing the Reset clears all the status registers, and this field is cleared to BIST Stop. During Reg read, this field is for BIST active status (only bit 0 is valid, and bit1 is read as 1'b0). 0: BIST inactive 1: BIST active";
            sw = rw;
            hw = r;
            reset = 0x0;
        } bist_op[1:0];
    } BISTCTRL @ 0x54;

    reg {
        name = "DRAM loopback test BIST data register 0";
        desc = "BISTDATA0 is DRAM loopback test BIST data register 0. This register is valid only when bist_pat is set to \"User Defined.\"

Data sheet 4.1.7 BISTDATA0 (offset 0x58, printed page 4-117, dump line 38227).";

        field {
            name = "bist_data_b3";
            desc = "BIST data byte 3 This field is used as the fourth beat of burst during BIST test";
            sw = rw;
            hw = r;
            reset = 0x0;
        } bist_data_b3[31:24];

        field {
            name = "bist_data_b2";
            desc = "BIST data byte 2 This field is used as the third beat of burst during BIST test.";
            sw = rw;
            hw = r;
            reset = 0x0;
        } bist_data_b2[23:16];

        field {
            name = "bist_data_b1";
            desc = "BIST data byte 1 This field is used as the second beat of burst during BIST test.";
            sw = rw;
            hw = r;
            reset = 0x0;
        } bist_data_b1[15:8];

        field {
            name = "bist_data_b0";
            desc = "BIST data byte 0 This field is used as the first beat of burst during BIST test.";
            sw = rw;
            hw = r;
            reset = 0x0;
        } bist_data_b0[7:0];
    } BISTDATA0 @ 0x58;

    reg {
        name = "DRAM loopback test BIST data register 1";
        desc = "BISTDATA1 is DRAM loopback test BIST data register 1.

Data sheet 4.1.7 BISTDATA1 (offset 0x5C, printed page 4-118, dump line 38266).";

        field {
            name = "bist_data_b7";
            desc = "BIST data byte 7 This field is used as the eighth beat of burst during BIST test";
            sw = rw;
            hw = r;
            reset = 0x0;
        } bist_data_b7[31:24];

        field {
            name = "bist_data_b6";
            desc = "BIST data byte 6 This field is used as the sixth beat of burst during BIST test.";
            sw = rw;
            hw = r;
            reset = 0x0;
        } bist_data_b6[23:16];

        field {
            name = "bist_data_b5";
            desc = "BIST data byte 5 This field is used as the fifth beat of burst during BIST test.";
            sw = rw;
            hw = r;
            reset = 0x0;
        } bist_data_b5[15:8];

        field {
            name = "bist_data_b4";
            desc = "BIST data byte 4 This field is used as the fourth beat of burst during BIST test.";
            sw = rw;
            hw = r;
            reset = 0x0;
        } bist_data_b4[7:0];
    } BISTDATA1 @ 0x5C;

    reg {
        name = "BIST test result and status register";
        desc = "BISTSTATUS is a BIST test result and status register.

Data sheet 4.1.7 BISTSTATUS (offset 0x60, printed page 4-118, dump line 38295).";

        field {
            name = "bist_dxerr";
            desc = "BIST error on DX blocks This bit shows whether any error occurs on the DXn during BIST test.";
            sw = r;
            hw = w;
            reset = 0x0;
        } bist_dxerr[2:2];

        field {
            name = "bist_acerr";
            desc = "BIST error on AC block This bit shows whether any error occurs on the AC during BIST test.";
            sw = r;
            hw = w;
            reset = 0x0;
        } bist_acerr[1:1];

        field {
            name = "bist_done";
            desc = "BIST done This field shows whether the BIST is complete. Note that if the BIST Stop Error Count field (bist_fail_stop) is set to 0, this field is never asserted.";
            sw = r;
            hw = w;
            reset = 0x1;
        } bist_done[0:0];
    } BISTSTATUS @ 0x60;

    reg {
        name = "Mode register content register 1";
        desc = "MODEREG01 is mode register content register 1.

Data sheet 4.1.7 MODEREG01 (offset 0x64, printed page 4-119, dump line 38342).";

        field {
            name = "mr1";
            desc = "Mode register 1 For DDR/DDR2/DDR3/LPDDR, this field specifies the content of extend mode register 1. For LPDDR2/LPDDR3, this field defines the content of MR3/MR9 (mode register). bit[31:24]: MR9 OP bit[23:16]: MR3 OP";
            sw = rw;
            hw = r;
            reset = 0x0;
        } mr1[31:16];

        field {
            name = "mr0";
            desc = "Mode register 0 For DDR/DDR2/DDR3/LPDDR, this field specifies the content of mode register 0. For LPDDR2/LPDDR3, this field defines the mode registers MR1/MR2. bit[15:8]: MR2 OP bit[7:0]: MR1 OP";
            sw = rw;
            hw = r;
            reset = 0x0;
        } mr0[15:0];
    } MODEREG01 @ 0x64;

    reg {
        name = "Mode register content register 2";
        desc = "MODEREG23 is mode register content register 2.

Data sheet 4.1.7 MODEREG23 (offset 0x68, printed page 4-120, dump line 38384).";

        field {
            name = "mr3";
            desc = "Mode register 3 For DDR/DDR2/DDR3, this field specifies extend mode register 3. For LPDDR2/LPDDR3, this field is for the ZQ commands. bit[31:24]: OP bit[23:16]: MA The ZQ commands are issued rank by rank after tINIT5. bit[31:24]: MR10 OP bit[23:16]: MR10 MA";
            sw = rw;
            hw = r;
            reset = 0xFF0A;
        } mr3[31:16];

        field {
            name = "mr2";
            desc = "Mode register 2 For DDR/DDR2/DDR3, this field specifies extend mode register 2. For LPDDR2/LPDDR3, this field specifies MR16/MR17. bit[15:8]: MR17 OP bit[7:0]: MR16 OP";
            sw = rw;
            hw = r;
            reset = 0x0;
        } mr2[15:0];
    } MODEREG23 @ 0x68;

    reg {
        name = "Write/Read DET pattern register";
        desc = "DETPATTERN is a write/read DET pattern register. These fields are used to fine-tune the training procedure. You are advised not to modify them.

Data sheet 4.1.7 DETPATTERN (offset 0x6C, printed page 4-120, dump line 38420).";

        field {
            name = "det_patFF";
            desc = "DET pattern 2";
            sw = rw;
            hw = r;
            reset = 0xFF;
        } det_patFF[23:16];

        field {
            name = "det_patAA";
            desc = "DET pattern 1";
            sw = rw;
            hw = r;
            reset = 0xAA;
        } det_patAA[15:8];

        field {
            name = "det_pat55";
            desc = "DET pattern 0";
            sw = rw;
            hw = r;
            reset = 0x55;
        } det_pat55[7:0];
    } DETPATTERN @ 0x6C;

    reg {
        name = "Miscellaneous control register";
        desc = "MISC is a miscellaneous control register.

Data sheet 4.1.7 MISC (offset 0x70, printed page 4-121, dump line 38452).";

        enum MISC_swapdfibyte_en_enum {
            NO_SWAP = 0 { name = "No Swap"; desc = "no swap"; };
            SWAP = 1 { name = "Swap"; desc = "swap"; };
        };

        field {
            name = "swapdfibyte_en";
            desc = "Swap DFI byte lane";
            sw = rw;
            hw = r;
            encode = MISC_swapdfibyte_en_enum;
            reset = 0x0;
        } swapdfibyte_en[31:30];

        enum MISC_swapwl_en_enum {
            NO_SWAP = 0 { name = "No Swap"; desc = "no swap"; };
            SWAP_1 = 1 { name = "Swap 1"; desc = "swap 1"; };
            SWAP_2 = 2 { name = "Swap 2"; desc = "swap 2"; };
            SWAP_3 = 3 { name = "Swap 3"; desc = "swap 3"; };
            SWAP_4_NOTE = 4 { name = "Swap 4 Note"; desc = "swap 4 Note: When the data BIST loopback mode is selected, this field must be set to 0x0."; };
        };

        field {
            name = "swapwl_en";
            desc = "Swap WL/CA result";
            sw = rw;
            hw = r;
            encode = MISC_swapwl_en_enum;
            reset = 0x0;
        } swapwl_en[29:27];

        enum MISC_swapdm_en_enum {
            NO_SWAP = 0 { name = "No Swap"; desc = "no swap"; };
            V_16_BIT_T2 = 1 { name = "V 16 Bit T2"; desc = "16-bit T2 swap"; };
        };

        field {
            name = "swapdm_en";
            desc = "Swap DM bus";
            sw = rw;
            hw = r;
            encode = MISC_swapdm_en_enum;
            reset = 0x0;
        } swapdm_en[26:25];

        enum MISC_swapaddr_en_enum {
            NO_SWAP = 0 { name = "No Swap"; desc = "no swap"; };
            V_32_BIT_FLYBY = 1 { name = "V 32 Bit Flyby"; desc = "32-bit flyby-4, flyby-2 swap"; };
            V_16_BIT_T = 2 { name = "V 16 Bit T"; desc = "16-bit T-2 swap"; };
        };

        field {
            name = "swapaddr_en";
            desc = "Swap address bus";
            sw = rw;
            hw = r;
            encode = MISC_swapaddr_en_enum;
            reset = 0x0;
        } swapaddr_en[24:23];

        field {
            name = "swap_en";
            desc = "Swap DQ bus bit[1:0] 000: no swap 001: swap 1 010: swap 2 011: swap 3 100: swap 4";
            sw = rw;
            hw = r;
            reset = 0x0;
        } swap_en[22:21];

        field {
            name = "cfg_dlyupd";
            desc = "Transparent mode for the delay update module. When this bit is set to 1, the delay setting in registers are applied to the PHY immediately.";
            sw = rw;
            hw = r;
            reset = 0x0;
        } cfg_dlyupd[20:20];

        field {
            name = "addr_delay";
            desc = "Add 1-T delay on address/command This bit must be set to 1 when CWL is 5.";
            sw = rw;
            hw = r;
            reset = 0x1;
        } addr_delay[19:19];

        field {
            name = "swap_en_msb";
            desc = "Swap DQ bus bit[2] 000: no swap 001: swap 1 010: swap 2 011: swap 3 100: swap 4";
            sw = rw;
            hw = r;
            reset = 0x0;
        } swap_en_msb[18:18];

        field {
            name = "addr_toggle";
            desc = "Toggle address bus every clock cycle This bit is set to 1 only for the burn-in test.";
            sw = rw;
            hw = r;
            reset = 0x0;
        } addr_toggle[17:17];

        field {
            name = "scramb_en";
            desc = "Data scrambler enable Set this field to 1 to enable data scramble function";
            sw = rw;
            hw = r;
            reset = 0x0;
        } scramb_en[16:16];

        field {
            name = "cfg_rl";
            desc = "PHY read latency It defines the number of cycles from read command to assert of rddata_en and is equal to CL + AL - 2 (for LPDDR2/3, the field should be RL-2).";
            sw = rw;
            hw = r;
            reset = 0x0;
        } cfg_rl[11:7];

        field {
            name = "cfg_wl";
            desc = "PHY write latency It defines the number of cycles from write command to assert of wrdata_en and is equal to CWL + AL - 1 (for LPDDR2/3, the field should be WL + 1). If the DFI clock ratio is 1:2, cfg_wl must be greater than or equal to 2.";
            sw = rw;
            hw = r;
            reset = 0x0;
        } cfg_wl[4:0];
    } MISC @ 0x70;

    reg {
        name = "Rank-to-rank delay control register";
        desc = "RNK2RNK is a rank-to-rank delay control register.

Data sheet 4.1.7 RNK2RNK (offset 0x74, printed page 4-123, dump line 38559).";

        field {
            name = "trnkwtr";
            desc = "Delay from write to read command targeted to different ranks";
            sw = rw;
            hw = r;
            reset = 0x0;
        } trnkwtr[19:15];

        field {
            name = "trnkrtw";
            desc = "Delay from read to write command targeted to different ranks";
            sw = rw;
            hw = r;
            reset = 0x0;
        } trnkrtw[14:10];

        field {
            name = "trnkrtr";
            desc = "Delay from read to read command targeted to different ranks";
            sw = rw;
            hw = r;
            reset = 0x0;
        } trnkrtr[9:5];

        field {
            name = "trnkwtw";
            desc = "Delay from write to write command targeted to different ranks";
            sw = rw;
            hw = r;
            reset = 0x0;
        } trnkwtw[4:0];
    } RNK2RNK @ 0x74;

    reg {
        name = "PHY control register 0";
        desc = "PHYCTRL0 is PHY control register 0. Register in this field are connected to PHY interface directly

Data sheet 4.1.7 PHYCTRL0 (offset 0x78, printed page 4-123, dump line 38585).";

        field {
            name = "resetoen";
            desc = "Set this bit to the default value.";
            sw = rw;
            hw = r;
            reset = 0x1;
        } resetoen[13:13];

        field {
            name = "csoen";
            desc = "Set this bit to the default value.";
            sw = rw;
            hw = r;
            reset = 0x1;
        } csoen[12:12];

        field {
            name = "ckeoen";
            desc = "Set this bit to the default value.";
            sw = rw;
            hw = r;
            reset = 0x1;
        } ckeoen[11:11];

        field {
            name = "ckoen";
            desc = "Set this field to the default value.";
            sw = rw;
            hw = r;
            reset = 0x1;
        } ckoen[10:8];

        field {
            name = "cmdoen";
            desc = "Set this bit to the default value.";
            sw = rw;
            hw = r;
            reset = 0x1;
        } cmdoen[7:7];

        field {
            name = "lp_ck_sel";
            desc = "Set this field to the default value.";
            sw = rw;
            hw = r;
            reset = 0x0;
        } lp_ck_sel[4:3];

        enum PHYCTRL0_sel_pos_rx_enum {
            FALLING_EDGE = 0 { name = "Falling Edge"; desc = "falling edge"; };
            RISING_EDGE = 1 { name = "Rising Edge"; desc = "rising edge"; };
        };

        field {
            name = "sel_pos_rx";
            desc = "PHY output trigger edge select";
            sw = rw;
            hw = r;
            encode = PHYCTRL0_sel_pos_rx_enum;
            reset = 0x0;
        } sel_pos_rx[2:2];
    } PHYCTRL0 @ 0x78;

    reg {
        name = "PHY debug register";
        desc = "PHYDBG is a PHY debug register.

Data sheet 4.1.7 PHYDBG (offset 0x7C, printed page 4-124, dump line 38630).";

        field {
            name = "dqsb_gated_error";
            desc = "DQSN gated error flag This error flag can be cleared only by issuing PHY reset.";
            sw = r;
            hw = w;
            reset = 0x0;
        } dqsb_gated_error[23:16];

        field {
            name = "dqs_gated_error";
            desc = "DQS gated error flag This error flag can be cleared only by issuing PHY reset.";
            sw = r;
            hw = w;
            reset = 0x0;
        } dqs_gated_error[7:0];
    } PHYDBG @ 0x7C;

    reg {
        name = "Retraining control register";
        desc = "RETCTRL0 is a retraining control register.

Data sheet 4.1.7 RETCTRL0 (offset 0x80, printed page 4-125, dump line 38666).";

        field {
            name = "retrain_thrd";
            desc = "Retraining threshold The PHY counts the number of AREFs issued by MC. When the number reaches the threshold, the retraining operation is triggered to be started. Only a non-zero value is valid.";
            sw = rw;
            hw = r;
            reset = 0x1;
        } retrain_thrd[31:16];

        field {
            name = "gtrten";
            desc = "Gate retraining active This field controls whether the gate retraining is executed during retraining on-going. This field should be asserted only after the initial gate training is complete.";
            sw = rw;
            hw = r;
            reset = 0x0;
        } gtrten[14:14];

        field {
            name = "retrain_en";
            desc = "PHY retraining enable This field controls whether the PHY is enabled to request memory controller for retraining.";
            sw = rw;
            hw = r;
            reset = 0x1;
        } retrain_en[13:13];

        field {
            name = "phyupd_resp";
            desc = "PHY update response latency When the PHY asserts dfi_phyupd_req to MC, MC should assert dfi_phyupd_ack no later than the number of cycles configured by the response latency.";
            sw = rw;
            hw = r;
            reset = 0x400;
        } phyupd_resp[12:0];
    } RETCTRL0 @ 0x80;

    reg {
        name = "DM swap selection register";
        desc = "DMSEL is a DM swap selection register.

Data sheet 4.1.7 DMSEL (offset 0x84, printed page 4-125, dump line 38703).";

        field {
            name = "dxctl_dmswap_sel";
            desc = "bit[3:2]: DM1 swap select bit[1:0]: DM0 swap select";
            sw = rw;
            hw = r;
            reset = 0xA;
        } dxctl_dmswap_sel[3:0];
    } DMSEL @ 0x84;

    reg {
        name = "I/O control register";
        desc = "IOCTL is an I/O control register.

Data sheet 4.1.7 IOCTL (offset 0x88, printed page 4-126, dump line 38734).";

        field {
            name = "odtsel_dqs";
            desc = "Set this field to the default value.";
            sw = rw;
            hw = r;
            reset = 0x2;
        } odtsel_dqs[31:29];

        field {
            name = "odtsel";
            desc = "Set this field to the default value.";
            sw = rw;
            hw = r;
            reset = 0x2;
        } odtsel[28:26];

        field {
            name = "ronsel_ck";
            desc = "Set this field to the default value.";
            sw = rw;
            hw = r;
            reset = 0x7;
        } ronsel_ck[25:23];

        field {
            name = "ronsel_ac2t";
            desc = "Set this field to the default value.";
            sw = rw;
            hw = r;
            reset = 0x7;
        } ronsel_ac2t[22:20];

        field {
            name = "ronsel_ac1t";
            desc = "Set this field to the default value.";
            sw = rw;
            hw = r;
            reset = 0x7;
        } ronsel_ac1t[19:17];

        field {
            name = "ronsel_dqs";
            desc = "Set this field to the default value.";
            sw = rw;
            hw = r;
            reset = 0x7;
        } ronsel_dqs[16:14];

        field {
            name = "ronsel";
            desc = "Set this field to the default value.";
            sw = rw;
            hw = r;
            reset = 0x7;
        } ronsel[13:11];

        field {
            name = "aciopldn";
            desc = "Set this bit to the default value.";
            sw = rw;
            hw = r;
            reset = 0x0;
        } aciopldn[2:2];

        field {
            name = "dxiopldn";
            desc = "Set this bit to the default value.";
            sw = rw;
            hw = r;
            reset = 0x0;
        } dxiopldn[1:1];

        field {
            name = "diff_dqs_en";
            desc = "Differential DQS enable";
            sw = rw;
            hw = r;
            reset = 0x1;
        } diff_dqs_en[0:0];
    } IOCTL @ 0x88;

    reg {
        name = "PHY DQ swap register";
        desc = "DQSSEL is a PHY DQ swap register.

Data sheet 4.1.7 DQSSEL (offset 0x8C, printed page 4-127, dump line 38780).";

        enum DQSSEL_dqswap_sel_enum {
            RELATIVE_DQS0 = 0x0 { name = "Relative Dqs0"; desc = "relative to DQS0"; };
            RELATIVE_DQS1 = 0x1 { name = "Relative Dqs1"; desc = "relative to DQS1"; };
        };

        field {
            name = "dqswap_sel";
            desc = "DQ swap in PHY Each bit determines the relative DQS with DQ.";
            sw = rw;
            hw = r;
            encode = DQSSEL_dqswap_sel_enum;
            reset = 0xFF00FF00;
        } dqswap_sel[31:0];
    } DQSSEL @ 0x8C;

    reg {
        name = "AC PHY control register";
        desc = "PHYCTRL1 is an AC PHY control register. Register in this field are connected to PHY interface directly

Data sheet 4.1.7 PHYCTRL1 (offset 0x90, printed page 4-127, dump line 38805).";

        field {
            name = "ac_pll_cal";
            desc = "The value 0x0 is recommended.";
            sw = rw;
            hw = r;
            reset = 0x0;
        } ac_pll_cal[30:30];

        field {
            name = "ac_pll_calm";
            desc = "The value 0x0 is recommended.";
            sw = rw;
            hw = r;
            reset = 0x0;
        } ac_pll_calm[29:29];

        field {
            name = "ac_pll_calt";
            desc = "The value 0x0 is recommended.";
            sw = rw;
            hw = r;
            reset = 0x0;
        } ac_pll_calt[28:28];

        field {
            name = "ac_pll_lt";
            desc = "The value 0x0 is recommended.";
            sw = rw;
            hw = r;
            reset = 0x0;
        } ac_pll_lt[27:26];

        field {
            name = "ac_pll_sp";
            desc = "The value 0x2 is recommended.";
            sw = rw;
            hw = r;
            reset = 0x0;
        } ac_pll_sp[25:23];

        field {
            name = "ac_pll_cpi";
            desc = "The value 0x4 is recommended.";
            sw = rw;
            hw = r;
            reset = 0x0;
        } ac_pll_cpi[22:20];

        field {
            name = "ac_pll_init";
            desc = "The value 0x0 is recommended.";
            sw = rw;
            hw = r;
            reset = 0x0;
        } ac_pll_init[19:19];

        field {
            name = "ac_pll_testen";
            desc = "The value 0x0 is recommended.";
            sw = rw;
            hw = r;
            reset = 0x0;
        } ac_pll_testen[18:18];

        field {
            name = "ac_pll_testpem";
            desc = "The value 0x0 is recommended.";
            sw = rw;
            hw = r;
            reset = 0x0;
        } ac_pll_testpem[17:17];

        field {
            name = "ac_pll_thrm";
            desc = "The value 0x0 is recommended.";
            sw = rw;
            hw = r;
            reset = 0x0;
        } ac_pll_thrm[16:16];
    } PHYCTRL1 @ 0x90;

    reg {
        name = "PLL phase selection register";
        desc = "DXNCKCTRL is a PLL phase selection (within the PHY) register. You are advised not to modify this register.

Data sheet 4.1.7 DXNCKCTRL (offset 0x94, printed page 4-128, dump line 38854).";

        field {
            name = "dx_ckd2";
            desc = "Set this field to the default value.";
            sw = rw;
            hw = r;
            reset = 0x0;
        } dx_ckd2[5:3];

        field {
            name = "dx_ck0p_mclk";
            desc = "Set this field to the default value.";
            sw = rw;
            hw = r;
            reset = 0x0;
        } dx_ck0p_mclk[2:0];
    } DXNCKCTRL @ 0x94;

    reg {
        name = "PHY PLL control register 1";
        desc = "Data sheet 4.1.7 PHYPLLCTRL_AC (offset 0x98, printed page 4-129, dump line 38893).";

        enum PHYPLLCTRL_AC_ac_pll_lock_enum {
            NOT_LOCKED = 0 { name = "Not Locked"; desc = "not locked"; };
            LOCKED = 1 { name = "Locked"; desc = "locked"; };
        };

        field {
            name = "ac_pll_lock";
            desc = "AC PLL lock signal";
            sw = r;
            hw = w;
            encode = PHYPLLCTRL_AC_ac_pll_lock_enum;
            reset = 0x0;
        } ac_pll_lock[31:31];

        enum PHYPLLCTRL_AC_ac_pll_test_enum {
            NORMAL_MODE = 0x0 { name = "Normal Mode"; desc = "normal mode"; };
            TEST_MODE = 0x1 { name = "Test Mode"; desc = "test mode"; };
        };

        field {
            name = "ac_pll_test";
            desc = "AC PLL test mode";
            sw = rw;
            hw = r;
            encode = PHYPLLCTRL_AC_ac_pll_test_enum;
            reset = 0x0;
        } ac_pll_test[7:0];
    } PHYPLLCTRL_AC @ 0x98;

    reg {
        name = "PHY PLL control register 2";
        desc = "PHYPLLCTRL_DX is PHY PLL control register 2.

Data sheet 4.1.7 PHYPLLCTRL_DX (offset 0x9C, printed page 4-129, dump line 38925).";

        enum PHYPLLCTRL_DX_dx_pll_lock_enum {
            NOT_LOCKED = 0 { name = "Not Locked"; desc = "not locked"; };
            LOCKED = 1 { name = "Locked"; desc = "locked"; };
        };

        field {
            name = "dx_pll_lock";
            desc = "ND: number of data PHY blocks DX PLL lock signals for each byte lane";
            sw = r;
            hw = w;
            encode = PHYPLLCTRL_DX_dx_pll_lock_enum;
            reset = 0x0;
        } dx_pll_lock[31:28];

        field {
            name = "dx_pll_test";
            desc = "PLL test for 16-bit data block bit[7:0]: 16-bit block 0 bit[15:8]: 16-bit block 1";
            sw = rw;
            hw = r;
            reset = 0x0;
        } dx_pll_test[15:0];
    } PHYPLLCTRL_DX @ 0x9C;

    reg {
        name = "S/W training mode register";
        desc = "SWTMODE is an S/W training mode register.

Data sheet 4.1.7 SWTMODE (offset 0xA0, printed page 4-130, dump line 38958).";

        enum SWTMODE_wl_wdqs_gated_enum {
            NOT_GATED = 0 { name = "Not Gated"; desc = "not gated"; };
            GATED = 1 { name = "Gated"; desc = "gated (disable WDQS strobe)"; };
        };

        field {
            name = "wl_wdqs_gated";
            desc = "Write leveling WDQS strobe disable when the related PH/BDL is tuned to prevent glitch";
            sw = rw;
            hw = r;
            encode = SWTMODE_wl_wdqs_gated_enum;
            reset = 0x0;
        } wl_wdqs_gated[31:31];

        field {
            name = "sw_gtmode";
            desc = "Set this bit to 1 when performing S/W gate training or GDS training.";
            sw = rw;
            hw = r;
            reset = 0x0;
        } sw_gtmode[1:1];

        field {
            name = "sw_wlmode";
            desc = "Set this bit to 1 when performing S/W write leveling training.";
            sw = rw;
            hw = r;
            reset = 0x0;
        } sw_wlmode[0:0];
    } SWTMODE @ 0xA0;

    reg {
        name = "Write DQS issue register during S/W write leveling training";
        desc = "SWTWLDQS is a write DQS issue register during S/W write leveling training.

Data sheet 4.1.7 SWTWLDQS (offset 0xA4, printed page 4-130, dump line 38992).";

        field {
            name = "sw_wl_dqs";
            desc = "Writing 1 to this bit once issues one DQS pulse from the PHY to DRAM.";
            sw = w;
            hw = r;
            reset = 0x0;
        } sw_wl_dqs[0:0];
    } SWTWLDQS @ 0xA4;

    reg {
        name = "S/W training result register";
        desc = "SWTRLT is an S/W training result register.

Data sheet 4.1.7 SWTRLT (offset 0xA8, printed page 4-131, dump line 39031).

Hardware (Hi3518E V200 board, live dump): reads 0x00030000 at U-Boot and under Linux, i.e. gds_result = 0x3 (both byte lanes passed the gate-DS step) after the vendor SW training; read-only result.";

        field {
            name = "gds_result";
            desc = "Each bit corresponds to one byte lane.";
            sw = r;
            hw = w;
            reset = 0x0;
        } gds_result[23:16];

        field {
            name = "gt_result";
            desc = "Each bit corresponds to one byte lane.";
            sw = r;
            hw = w;
            reset = 0x0;
        } gt_result[15:8];

        field {
            name = "wl_dq_result";
            desc = "Each bit corresponds to one byte lane.";
            sw = r;
            hw = w;
            reset = 0x0;
        } wl_dq_result[7:0];
    } SWTRLT @ 0xA8;

    reg {
        name = "PHY control register 2";
        desc = "PHYCTRL2 is PHY control register 2. Register in this field are connected to PHY interface directly

Data sheet 4.1.7 PHYCTRL2 (offset 0xAC, printed page 4-131, dump line 39056).";

        field {
            name = "phy_dyn_pupden";
            desc = "DATA16BIT_blk.reg_dynamic_PUPDEN_16b control";
            sw = rw;
            hw = r;
            reset = 0x0;
        } phy_dyn_pupden[4:4];

        field {
            name = "phy_dummypad_use";
            desc = "DATA16BIT_blk.reg_dummypad_use control";
            sw = rw;
            hw = r;
            reset = 0x1;
        } phy_dummypad_use[3:3];

        field {
            name = "phy_odten_gated";
            desc = "DATA16BIT_blk.reg_ODTEN_Gated control";
            sw = rw;
            hw = r;
            reset = 0x0;
        } phy_odten_gated[2:2];

        field {
            name = "phy_gatetdc";
            desc = "DATA16BIT_blk.BUFRESETCONTN_gated_TDC control";
            sw = rw;
            hw = r;
            reset = 0x1;
        } phy_gatetdc[1:1];

        field {
            name = "phy_dqsgerror";
            desc = "DATA16BIT_blk.BUFRESETCONTN_gated_DQSGERROR control";
            sw = rw;
            hw = r;
            reset = 0x1;
        } phy_dqsgerror[0:0];
    } PHYCTRL2 @ 0xAC;

    reg {
        name = "PHY I/O control register 1";
        desc = "IOCTL1 is I/O PHY control register 1. Register in this field are connected to PHY interface directly

Data sheet 4.1.7 IOCTL1 (offset 0xB0, printed page 4-132, dump line 39104).";

        field {
            name = "ioctl_squeach_pd";
            desc = "Set this field to the default value.";
            sw = rw;
            hw = r;
            reset = 0x0;
        } ioctl_squeach_pd[27:24];

        field {
            name = "ioctl_genvref_pd";
            desc = "Set this field to the default value.";
            sw = rw;
            hw = r;
            reset = 0x0;
        } ioctl_genvref_pd[17:12];

        field {
            name = "ioctl_genvref_ie";
            desc = "Set this field to the default value.";
            sw = rw;
            hw = r;
            reset = 0x0;
        } ioctl_genvref_ie[11:6];

        field {
            name = "ioctl_popmode";
            desc = "Set this field to the default value.";
            sw = rw;
            hw = r;
            reset = 0x0;
        } ioctl_popmode[5:0];
    } IOCTL1 @ 0xB0;

    reg {
        name = "PHY I/O control register 2";
        desc = "Vendor use (ddr_phy_s40.h DDR_PHY_VREF_HOST_SET): the host Vref is written as ((val & 7) << 12) | ((val >> 3) & 3), i.e. refsel in ioctl_genvref_refsel_0 [14:12] and range in the low two bits of ioctl_genvref_rangel_0.

Data sheet 4.1.7 IOCTL2 (offset 0xB4, printed page 4-133, dump line 39143).";

        field {
            name = "ioctl_genvref_refsel_2";
            desc = "Set this field to the default value.";
            sw = rw;
            hw = r;
            reset = 0x0;
        } ioctl_genvref_refsel_2[29:24];

        field {
            name = "ioctl_genvref_refsel_1";
            desc = "Set this field to the default value.";
            sw = rw;
            hw = r;
            reset = 0x0;
        } ioctl_genvref_refsel_1[23:18];

        field {
            name = "ioctl_genvref_refsel_0";
            desc = "Set this field to the default value.";
            sw = rw;
            hw = r;
            reset = 0x0;
        } ioctl_genvref_refsel_0[17:12];

        field {
            name = "ioctl_genvref_rangel_1";
            desc = "Set this field to the default value.";
            sw = rw;
            hw = r;
            reset = 0x0;
        } ioctl_genvref_rangel_1[11:6];

        field {
            name = "ioctl_genvref_rangel_0";
            desc = "Set this field to the default value.";
            sw = rw;
            hw = r;
            reset = 0x0;
        } ioctl_genvref_rangel_0[5:0];
    } IOCTL2 @ 0xB4;

    reg {
        name = "Code update period register during BIST running";
        desc = "BISTTIMER is a code update period register during BIST running.

Data sheet 4.1.7 BISTTIMER (offset 0xB8, printed page 4-133, dump line 39181).";

        field {
            name = "bstupdt_timer";
            desc = "BIST update code timer This field controls the code update period. If this field is programmed to a non-zero value, the BIST is temporarily stopped, and the internal delay code is updated to the PHY when the timer reaches the configured value. The BIST will continue if the code update is complete. If this field is programmed to zero, the update code mechanism is disabled.";
            sw = rw;
            hw = r;
            reset = 0x0;
        } bstupdt_timer[15:0];
    } BISTTIMER @ 0xB8;

    reg {
        name = "Data training control register 1";
        desc = "TRAINCTRL1 is data training control register 1.

Data sheet 4.1.7 TRAINCTRL1 (offset 0xD0, printed page 4-134, dump line 39220).";

        field {
            name = "rdet_lbs_en";
            desc = "Read DET left boundary search enable";
            sw = rw;
            hw = r;
            reset = 0x1;
        } rdet_lbs_en[31:31];

        field {
            name = "rdet_ds_en";
            desc = "Read DET deskew enable";
            sw = rw;
            hw = r;
            reset = 0x1;
        } rdet_ds_en[30:30];

        field {
            name = "rdet_rbs_en";
            desc = "Read DET right boundary search enable";
            sw = rw;
            hw = r;
            reset = 0x1;
        } rdet_rbs_en[29:29];

        field {
            name = "rdet_av_en";
            desc = "Read DET average stage enable";
            sw = rw;
            hw = r;
            reset = 0x1;
        } rdet_av_en[28:28];

        field {
            name = "rdet_rb_backtap";
            desc = "Read DET right boundary back tap. This field is used to offset (+) the rdqsbdl before the right boundary search is started to overcome meta-sable zone.";
            sw = rw;
            hw = r;
            reset = 0x3;
        } rdet_rb_backtap[26:20];

        field {
            name = "rdet_samp_num";
            desc = "Read DET sample number control. The multiple sample is used to overcome the meta situations. Valid value: 1-15";
            sw = rw;
            hw = r;
            reset = 0x6;
        } rdet_samp_num[19:16];

        field {
            name = "wdet_lbs_en";
            desc = "Write DET left boundary search enable";
            sw = rw;
            hw = r;
            reset = 0x1;
        } wdet_lbs_en[15:15];

        field {
            name = "wdet_ds_en";
            desc = "Write DET deskew enable";
            sw = rw;
            hw = r;
            reset = 0x1;
        } wdet_ds_en[14:14];

        field {
            name = "wdet_rbs_en";
            desc = "Write DET right boundary search enable";
            sw = rw;
            hw = r;
            reset = 0x1;
        } wdet_rbs_en[13:13];

        field {
            name = "wrdet_av_en";
            desc = "Write DET average stage enable";
            sw = rw;
            hw = r;
            reset = 0x1;
        } wrdet_av_en[12:12];

        field {
            name = "wdet_rb_backtap";
            desc = "Write DET right boundary back tap. This field is used to offset (-) the wdqphase before the right boundary search is started to overcome meta-sable zone.";
            sw = rw;
            hw = r;
            reset = 0x2;
        } wdet_rb_backtap[7:4];

        field {
            name = "wdet_samp_num";
            desc = "Write DET sample number control. The multiple sample is used to overcome the meta situations. Valid value: 1-15";
            sw = rw;
            hw = r;
            reset = 0x6;
        } wdet_samp_num[3:0];
    } TRAINCTRL1 @ 0xD0;

    reg {
        name = "Data training control register 2";
        desc = "TRAINCTRL2 is data training control register 2.

Data sheet 4.1.7 TRAINCTRL2 (offset 0xD4, printed page 4-135, dump line 39280).";

        enum TRAINCTRL2_rdet_method_sel_enum {
            WRITE_THEN_READ = 0 { name = "Write Then Read"; desc = "write-then-read"; };
            MRR32_40 = 1 { name = "Mrr32 40"; desc = "MRR32/40 (only for LPDDR3)"; };
        };

        field {
            name = "rdet_method_sel";
            desc = "Read DET method select";
            sw = rw;
            hw = r;
            encode = TRAINCTRL2_rdet_method_sel_enum;
            reset = 0x0;
        } rdet_method_sel[31:31];

        enum TRAINCTRL2_mrr_pat_order_enum {
            MRR32 = 0 { name = "Mrr32"; desc = "MRR32"; };
            MRR40 = 1 { name = "Mrr40"; desc = "MRR40"; };
        };

        field {
            name = "mrr_pat_order";
            desc = "MRR pattern order. If MRR is used in the read DET, PACK will issue three MRR commands. The order is indicated by bit 2 -> bit 1 -> bit 0.";
            sw = rw;
            hw = r;
            encode = TRAINCTRL2_mrr_pat_order_enum;
            reset = 0x0;
        } mrr_pat_order[30:28];

        enum TRAINCTRL2_mrr_bl4_enum {
            MRR32_40_BURST = 0 { name = "Mrr32 40 Burst"; desc = "MRR32/40 burst length = 8 (default)"; };
            MRR32_40_BURST_2 = 1 { name = "Mrr32 40 Burst 2"; desc = "MRR32/40 burst length = 4"; };
        };

        field {
            name = "mrr_bl4";
            desc = "MRR burst 4 indicator. If MRR is used in the read DET, PACK needs to know whether MRR burst is 4 (LPDDR2) or 8 (LPDDR3).";
            sw = rw;
            hw = r;
            encode = TRAINCTRL2_mrr_bl4_enum;
            reset = 0x0;
        } mrr_bl4[27:27];

        enum TRAINCTRL2_gds_automrg_en_enum {
            DISABLE_GDS_AUTO = 0 { name = "Disable Gds Auto"; desc = "disable GDS auto margin tuning (will increase GDS when GDS training/retraining is complete)"; };
            ENABLE_GDS_AUTO = 1 { name = "Enable Gds Auto"; desc = "enable GDS auto margin tuning (default)"; };
        };

        field {
            name = "gds_automrg_en";
            desc = "GDS training/retraining auto tuning enable";
            sw = rw;
            hw = r;
            encode = TRAINCTRL2_gds_automrg_en_enum;
            reset = 0x0;
        } gds_automrg_en[24:24];

        enum TRAINCTRL2_mrr_pat_mask_enum {
            NOT_MASKED = 0x0 { name = "Not Masked"; desc = "not masked"; };
            MASKED = 0x1 { name = "Masked"; desc = "masked (does not compare data)"; };
        };

        field {
            name = "mrr_pat_mask";
            desc = "MRR pattern mask";
            sw = rw;
            hw = r;
            encode = TRAINCTRL2_mrr_pat_mask_enum;
            reset = 0x0;
        } mrr_pat_mask[23:16];

        field {
            name = "mrr_pat_B";
            desc = "MRR40 pattern. This field should comply with the LPDDR2/LPDDR3 specifications.";
            sw = rw;
            hw = r;
            reset = 0xCC;
        } mrr_pat_B[15:8];

        field {
            name = "mrr_pat_A";
            desc = "MRR32 pattern. This field should comply with the LPDDR2/LPDDR3 specifications.";
            sw = rw;
            hw = r;
            reset = 0x55;
        } mrr_pat_A[7:0];
    } TRAINCTRL2 @ 0xD4;

    reg {
        name = "Register bank control register";
        desc = "REGBANKCTRL is register bank control register.

Data sheet 4.1.7 REGBANKCTRL (offset 0xD8, printed page 4-136, dump line 39342).";

        enum REGBANKCTRL_op_sel_enum {
            BANK_0_PHY = 0 { name = "Bank 0 Phy"; desc = "bank 0 for PHY operating"; };
            BANK_1_PHY = 1 { name = "Bank 1 Phy"; desc = "bank 1 for PHY operating"; };
        };

        field {
            name = "op_sel";
            desc = "Register bank select related to DFS";
            sw = rw;
            hw = r;
            encode = REGBANKCTRL_op_sel_enum;
            reset = 0x0;
        } op_sel[1:1];

        enum REGBANKCTRL_wr_sel_enum {
            BANK_0_WHILE = 0 { name = "Bank 0 While"; desc = "bank 0 while APB read/write"; };
            BANK_1_WHILE = 1 { name = "Bank 1 While"; desc = "bank 1 while APB read/write"; };
        };

        field {
            name = "wr_sel";
            desc = "Register bank select related to DFS";
            sw = rw;
            hw = r;
            encode = REGBANKCTRL_wr_sel_enum;
            reset = 0x0;
        } wr_sel[0:0];
    } REGBANKCTRL @ 0xD8;

    reg {
        name = "Data training control register 3";
        desc = "TRAINCTRL3 is data training control register 3.

Data sheet 4.1.7 TRAINCTRL3 (offset 0xDC, printed page 4-137, dump line 39379).";

        enum TRAINCTRL3_exd_gtres_en_enum {
            DISABLED = 0 { name = "Disabled"; desc = "disabled"; };
            ENABLED = 1 { name = "Enabled"; desc = "enabled (default)"; };
        };

        field {
            name = "exd_gtres_en";
            desc = "Extended gate result enable. When this field is set as high, the PACK will use additional information (EN_DQSx_regread) to help extend the gate result in the \"fine tune stage of gate training\" and \"gate retraining.\"";
            sw = rw;
            hw = r;
            encode = TRAINCTRL3_exd_gtres_en_enum;
            reset = 0x1;
        } exd_gtres_en[31:31];

        field {
            name = "gdsrt_backtap";
            desc = "GDS retraining back tap. This field controls the number of back taps during GDS retraining. The value range is 1-7. The recommended value range is 1-2.";
            sw = rw;
            hw = r;
            reset = 0x2;
        } gdsrt_backtap[18:16];

        enum TRAINCTRL3_rpat_cnt_num_open_enum {
            PATTERN_LENGTH_1 = 0 { name = "Pattern Length 1"; desc = "pattern length = 1"; };
            PATTERN_LENGTH_2 = 1 { name = "Pattern Length 2"; desc = "pattern length = 2 ..."; };
            PATTERN_LENGTH_16 = 15 { name = "Pattern Length 16"; desc = "pattern length = 16"; };
        };

        field {
            name = "rpat_cnt_num_open";
            desc = "RDET pattern length control for eye open. This field is used to set the pattern length for eye open. The same RDET pattern will be extended as the following settings (field value + 1):";
            sw = rw;
            hw = r;
            encode = TRAINCTRL3_rpat_cnt_num_open_enum;
            reset = 0x3;
        } rpat_cnt_num_open[11:8];

        enum TRAINCTRL3_rpat_cnt_num_enum {
            PATTERN_LENGTH_1 = 0 { name = "Pattern Length 1"; desc = "pattern length = 1"; };
            PATTERN_LENGTH_2 = 1 { name = "Pattern Length 2"; desc = "pattern length = 2 ..."; };
            PATTERN_LENGTH_16 = 15 { name = "Pattern Length 16"; desc = "pattern length = 16"; };
        };

        field {
            name = "rpat_cnt_num";
            desc = "RDET pattern length control. This field is used to set the pattern length. The same RDET pattern will be extended as the following settings (field value + 1):";
            sw = rw;
            hw = r;
            encode = TRAINCTRL3_rpat_cnt_num_enum;
            reset = 0x0;
        } rpat_cnt_num[3:0];
    } TRAINCTRL3 @ 0xDC;

    reg {
        name = "Comparison control register 0 while BIST activated";
        desc = "ACBISTCTRL0 is comparison control register 0 while BIST activated.

Data sheet 4.1.7 ACBISTCTRL0 (offset 0x100, printed page 4-138, dump line 39439).";

        field {
            name = "ac_rdffsel";
            desc = "AC loopback read latch select";
            sw = rw;
            hw = r;
            reset = 0x2;
        } ac_rdffsel[31:29];

        enum ACBISTCTRL0_aclpbk_tg_enum {
            V_28LPP_PHY = 0 { name = "V 28Lpp Phy"; desc = "28LPP PHY (default)"; };
            V_40PHY = 1 { name = "V 40Phy"; desc = "40PHY"; };
        };

        field {
            name = "aclpbk_tg";
            desc = "AC loopback toggle control. The user should not modify this bit. It is related to the analog PHY design.";
            sw = rw;
            hw = r;
            encode = ACBISTCTRL0_aclpbk_tg_enum;
            reset = 0x0;
        } aclpbk_tg[28:28];

        field {
            name = "acbist_en";
            desc = "BIST enable This field specifies whether the AC block is included for loopback test while bist_op is set to BIST Enable.";
            sw = rw;
            hw = r;
            reset = 0x0;
        } acbist_en[27:27];

        enum ACBISTCTRL0_rst_cmp_mask_enum {
            NOT_COMPARED = 0 { name = "Not Compared"; desc = "not compared"; };
            COMPARED = 1 { name = "Compared"; desc = "compared"; };
        };

        field {
            name = "rst_cmp_mask";
            desc = "RST loopback compare mask This field controls whether the comparison of the loopback data on the RST bit is disabled.";
            sw = rw;
            hw = r;
            encode = ACBISTCTRL0_rst_cmp_mask_enum;
            reset = 0x0;
        } rst_cmp_mask[26:26];

        enum ACBISTCTRL0_cs_cmp_mask_enum {
            NOT_COMPARED = 0 { name = "Not Compared"; desc = "not compared"; };
            COMPARED = 1 { name = "Compared"; desc = "compared"; };
        };

        field {
            name = "cs_cmp_mask";
            desc = "CS loopback compare mask This field controls whether the comparison of the loopback data on the CS bits is disabled.";
            sw = rw;
            hw = r;
            encode = ACBISTCTRL0_cs_cmp_mask_enum;
            reset = 0x0;
        } cs_cmp_mask[25:22];

        enum ACBISTCTRL0_ras_cmp_mask_enum {
            NOT_COMPARED = 0 { name = "Not Compared"; desc = "not compared"; };
            COMPARED = 1 { name = "Compared"; desc = "compared"; };
        };

        field {
            name = "ras_cmp_mask";
            desc = "RAS loopback compare mask This field controls whether the comparison of the loopback data on RAS is disabled.";
            sw = rw;
            hw = r;
            encode = ACBISTCTRL0_ras_cmp_mask_enum;
            reset = 0x0;
        } ras_cmp_mask[21:21];

        enum ACBISTCTRL0_cas_cmp_mask_enum {
            NOT_COMPARED = 0 { name = "Not Compared"; desc = "not compared"; };
            COMPARED = 1 { name = "Compared"; desc = "compared"; };
        };

        field {
            name = "cas_cmp_mask";
            desc = "CAS loopback compare mask This field controls whether the comparison of the loopback data on CAS is disabled.";
            sw = rw;
            hw = r;
            encode = ACBISTCTRL0_cas_cmp_mask_enum;
            reset = 0x0;
        } cas_cmp_mask[20:20];

        enum ACBISTCTRL0_we_cmp_mask_enum {
            NOT_COMPARED = 0 { name = "Not Compared"; desc = "not compared"; };
            COMPARED = 1 { name = "Compared"; desc = "compared"; };
        };

        field {
            name = "we_cmp_mask";
            desc = "Write enable loopback compare mask This field controls whether the comparison of the loopback data on WE is disabled.";
            sw = rw;
            hw = r;
            encode = ACBISTCTRL0_we_cmp_mask_enum;
            reset = 0x0;
        } we_cmp_mask[19:19];

        enum ACBISTCTRL0_ba_cmp_mask_enum {
            NOT_COMPARED = 0 { name = "Not Compared"; desc = "not compared"; };
            COMPARED = 1 { name = "Compared"; desc = "compared"; };
        };

        field {
            name = "ba_cmp_mask";
            desc = "Bank address loopback compare mask This field controls whether the comparison of the loopback data on bank address bits is disabled.";
            sw = rw;
            hw = r;
            encode = ACBISTCTRL0_ba_cmp_mask_enum;
            reset = 0x0;
        } ba_cmp_mask[18:16];

        enum ACBISTCTRL0_addr_cmp_mask_enum {
            NOT_COMPARED = 0x0 { name = "Not Compared"; desc = "not compared"; };
            COMPARED = 0x1 { name = "Compared"; desc = "compared"; };
        };

        field {
            name = "addr_cmp_mask";
            desc = "Memory address loopback compare mask This field controls whether the comparison of the loopback data on address bits is disabled.";
            sw = rw;
            hw = r;
            encode = ACBISTCTRL0_addr_cmp_mask_enum;
            reset = 0x0;
        } addr_cmp_mask[15:0];
    } ACBISTCTRL0 @ 0x100;

    reg {
        name = "Comparison control register 1 while BIST activated";
        desc = "ACBISTCTRL1 is comparison control register 1 while BIST activated.

Data sheet 4.1.7 ACBISTCTRL1 (offset 0x104, printed page 4-139, dump line 39520).";

        field {
            name = "ac_lfsr_seed";
            desc = "LFSR seed value This field specifies the initial seed value of the LFSR generator to this byte lane.";
            sw = rw;
            hw = r;
            reset = 0x0;
        } ac_lfsr_seed[15:8];

        enum ACBISTCTRL1_cke_cmp_mask_enum {
            NOT_COMPARED = 0 { name = "Not Compared"; desc = "not compared"; };
            COMPARED = 1 { name = "Compared"; desc = "compared"; };
        };

        field {
            name = "cke_cmp_mask";
            desc = "CKE loopback compare mask This field controls whether the comparison of the loopback data on CKE bits is disabled.";
            sw = rw;
            hw = r;
            encode = ACBISTCTRL1_cke_cmp_mask_enum;
            reset = 0x0;
        } cke_cmp_mask[7:4];

        enum ACBISTCTRL1_odt_cmp_mask_enum {
            NOT_COMPARED = 0 { name = "Not Compared"; desc = "not compared"; };
            COMPARED = 1 { name = "Compared"; desc = "compared"; };
        };

        field {
            name = "odt_cmp_mask";
            desc = "ODT loopback compare mask This field controls whether the comparison of the loopback data on ODT bits is disabled.";
            sw = rw;
            hw = r;
            encode = ACBISTCTRL1_odt_cmp_mask_enum;
            reset = 0x0;
        } odt_cmp_mask[3:0];
    } ACBISTCTRL1 @ 0x104;

    reg {
        name = "BIST test result and status register 0";
        desc = "ACBISTSTS0 is BIST test result and status register 0. This register is read-only, and can only be reset by setting bist_op to BIST Reset.

Data sheet 4.1.7 ACBISTSTS0 (offset 0x108, printed page 4-140, dump line 39566).";

        field {
            name = "rst_bist_err";
            desc = "BIST error on RST";
            sw = r;
            hw = w;
            reset = 0x0;
        } rst_bist_err[26:26];

        field {
            name = "cs_bist_err";
            desc = "BIST error on CS";
            sw = r;
            hw = w;
            reset = 0x0;
        } cs_bist_err[25:22];

        field {
            name = "ras_bist_err";
            desc = "BIST error on RAS";
            sw = r;
            hw = w;
            reset = 0x0;
        } ras_bist_err[21:21];

        field {
            name = "cas_bist_err";
            desc = "BIST error on CAS";
            sw = r;
            hw = w;
            reset = 0x0;
        } cas_bist_err[20:20];

        field {
            name = "we_bist_err";
            desc = "BIST error on write enable";
            sw = r;
            hw = w;
            reset = 0x0;
        } we_bist_err[19:19];

        field {
            name = "ba_bist_err";
            desc = "BIST error on bank address";
            sw = r;
            hw = w;
            reset = 0x0;
        } ba_bist_err[18:16];

        field {
            name = "addr_bist_err";
            desc = "BIST error on address bus";
            sw = r;
            hw = w;
            reset = 0x0;
        } addr_bist_err[15:0];
    } ACBISTSTS0 @ 0x108;

    reg {
        name = "BIST test result and status register 1";
        desc = "ACBISTSTS1 is BIST test result and status register 1. This register is read-only, and can only be reset by setting bist_op to BIST Reset.

Data sheet 4.1.7 ACBISTSTS1 (offset 0x10C, printed page 4-141, dump line 39608).";

        field {
            name = "cke_bist_err";
            desc = "BIST error on CKE";
            sw = r;
            hw = w;
            reset = 0x0;
        } cke_bist_err[7:4];

        field {
            name = "odt_bist_err";
            desc = "BIST error on ODT";
            sw = r;
            hw = w;
            reset = 0x0;
        } odt_bist_err[3:0];
    } ACBISTSTS1 @ 0x10C;

    reg {
        name = "AC command bit delay line configuration register 0";
        desc = "ACCMDBDL0 is AC command bit delay line configuration register 0.

Data sheet 4.1.7 ACCMDBDL0 (offset 0x120, printed page 4-141, dump line 39629).";

        field {
            name = "odt1_bdl";
            desc = "Bit delay line of ODT1";
            sw = rw;
            hw = r;
            reset = 0x0;
        } odt1_bdl[20:16];

        field {
            name = "odt0_bdl";
            desc = "Bit delay line of ODT0";
            sw = rw;
            hw = r;
            reset = 0x0;
        } odt0_bdl[4:0];
    } ACCMDBDL0 @ 0x120;

    reg {
        name = "AC command bit delay line configuration register 1";
        desc = "ACCMDBDL1 is AC command bit delay line configuration register 1.

Data sheet 4.1.7 ACCMDBDL1 (offset 0x124, printed page 4-142, dump line 39661).";

        field {
            name = "odt3_bdl";
            desc = "Bit delay line of ODT3";
            sw = rw;
            hw = r;
            reset = 0x0;
        } odt3_bdl[20:16];

        field {
            name = "odt2_bdl";
            desc = "Bit delay line of ODT2";
            sw = rw;
            hw = r;
            reset = 0x0;
        } odt2_bdl[4:0];
    } ACCMDBDL1 @ 0x124;

    reg {
        name = "AC command bit delay line configuration register 2";
        desc = "ACCMDBDL2 is AC command bit delay line configuration register 2.

Data sheet 4.1.7 ACCMDBDL2 (offset 0x128, printed page 4-142, dump line 39682).";

        field {
            name = "cs1_bdl";
            desc = "Bit delay line of CS1";
            sw = rw;
            hw = r;
            reset = 0x0;
        } cs1_bdl[20:16];

        field {
            name = "cs0_bdl";
            desc = "Bit delay line of CS0";
            sw = rw;
            hw = r;
            reset = 0x0;
        } cs0_bdl[4:0];
    } ACCMDBDL2 @ 0x128;

    reg {
        name = "AC command bit delay line configuration register 3";
        desc = "ACCMDBDL3 is AC command bit delay line configuration register 3.

Data sheet 4.1.7 ACCMDBDL3 (offset 0x12C, printed page 4-143, dump line 39714).";

        field {
            name = "cs3_bdl";
            desc = "Bit delay line of CS3";
            sw = rw;
            hw = r;
            reset = 0x0;
        } cs3_bdl[20:16];

        field {
            name = "cs2_bdl";
            desc = "Bit delay line of CS2";
            sw = rw;
            hw = r;
            reset = 0x0;
        } cs2_bdl[4:0];
    } ACCMDBDL3 @ 0x12C;

    reg {
        name = "AC command bit delay line configuration register 4";
        desc = "ACCMDBDL4 is AC command bit delay line configuration register 4.

Data sheet 4.1.7 ACCMDBDL4 (offset 0x130, printed page 4-143, dump line 39735).";

        field {
            name = "cke1_bdl";
            desc = "Bit delay line of CKE1";
            sw = rw;
            hw = r;
            reset = 0x0;
        } cke1_bdl[20:16];

        field {
            name = "cke0_bdl";
            desc = "Bit delay line of CKE0";
            sw = rw;
            hw = r;
            reset = 0x0;
        } cke0_bdl[4:0];
    } ACCMDBDL4 @ 0x130;

    reg {
        name = "AC command bit delay line configuration register 5";
        desc = "ACCMDBDL5 is AC command bit delay line configuration register 5.

Data sheet 4.1.7 ACCMDBDL5 (offset 0x134, printed page 4-144, dump line 39767).";

        field {
            name = "cke3_bdl";
            desc = "Bit delay line of CKE3";
            sw = rw;
            hw = r;
            reset = 0x0;
        } cke3_bdl[20:16];

        field {
            name = "cke2_bdl";
            desc = "Bit delay line of CKE2";
            sw = rw;
            hw = r;
            reset = 0x0;
        } cke2_bdl[4:0];
    } ACCMDBDL5 @ 0x134;

    reg {
        name = "AC command bit delay line configuration register 6";
        desc = "ACCMDBDL6 is AC command bit delay line configuration register 6.

Data sheet 4.1.7 ACCMDBDL6 (offset 0x138, printed page 4-144, dump line 39788).";

        field {
            name = "cas_bdl";
            desc = "Bit delay line of CAS";
            sw = rw;
            hw = r;
            reset = 0x0;
        } cas_bdl[20:16];

        field {
            name = "we_bdl";
            desc = "Bit delay line of WE";
            sw = rw;
            hw = r;
            reset = 0x0;
        } we_bdl[4:0];
    } ACCMDBDL6 @ 0x138;

    reg {
        name = "AC command bit delay line configuration register 7";
        desc = "ACCMDBDL7 is AC command bit delay line configuration register 7.

Data sheet 4.1.7 ACCMDBDL7 (offset 0x13C, printed page 4-145, dump line 39820).";

        field {
            name = "resetn_bdl";
            desc = "Bit delay line of RESETN";
            sw = rw;
            hw = r;
            reset = 0x0;
        } resetn_bdl[20:16];

        field {
            name = "ras_bdl";
            desc = "Bit delay line of RAS";
            sw = rw;
            hw = r;
            reset = 0x0;
        } ras_bdl[4:0];
    } ACCMDBDL7 @ 0x13C;

    reg {
        name = "AC address bit delay line configuration register 0";
        desc = "ACADDRBDL0 is AC address bit delay line configuration register 0.

Data sheet 4.1.7 ACADDRBDL0 (offset 0x140, printed page 4-145, dump line 39841).";

        field {
            name = "addr1_bdl";
            desc = "Bit delay line of ADDR1";
            sw = rw;
            hw = r;
            reset = 0x0;
        } addr1_bdl[20:16];

        field {
            name = "addr0_bdl";
            desc = "Bit delay line of ADDR0";
            sw = rw;
            hw = r;
            reset = 0x0;
        } addr0_bdl[4:0];
    } ACADDRBDL0 @ 0x140;

    reg {
        name = "AC address bit delay line configuration register 1";
        desc = "ACADDRBDL1 is AC address bit delay line configuration register 1.

Data sheet 4.1.7 ACADDRBDL1 (offset 0x144, printed page 4-146, dump line 39873).";

        field {
            name = "addr3_bdl";
            desc = "Bit delay line of ADDR3";
            sw = rw;
            hw = r;
            reset = 0x0;
        } addr3_bdl[20:16];

        field {
            name = "addr2_bdl";
            desc = "Bit delay line of ADDR2";
            sw = rw;
            hw = r;
            reset = 0x0;
        } addr2_bdl[4:0];
    } ACADDRBDL1 @ 0x144;

    reg {
        name = "AC address bit delay line configuration register 2";
        desc = "ACADDRBDL2 is AC address bit delay line configuration register 2.

Data sheet 4.1.7 ACADDRBDL2 (offset 0x148, printed page 4-146, dump line 39894).";

        field {
            name = "addr5_bdl";
            desc = "Bit delay line of ADDR5";
            sw = rw;
            hw = r;
            reset = 0x0;
        } addr5_bdl[20:16];

        field {
            name = "addr4_bdl";
            desc = "Bit delay line of ADDR4";
            sw = rw;
            hw = r;
            reset = 0x0;
        } addr4_bdl[4:0];
    } ACADDRBDL2 @ 0x148;

    reg {
        name = "AC address bit delay line configuration register 3";
        desc = "ACADDRBDL3 is AC address bit delay line configuration register 3.

Data sheet 4.1.7 ACADDRBDL3 (offset 0x14C, printed page 4-147, dump line 39926).";

        field {
            name = "addr7_bdl";
            desc = "Bit delay line of ADDR7";
            sw = rw;
            hw = r;
            reset = 0x0;
        } addr7_bdl[20:16];

        field {
            name = "addr6_bdl";
            desc = "Bit delay line of ADDR6";
            sw = rw;
            hw = r;
            reset = 0x0;
        } addr6_bdl[4:0];
    } ACADDRBDL3 @ 0x14C;

    reg {
        name = "AC address bit delay line configuration register 4";
        desc = "ACADDRBDL4 is AC address bit delay line configuration register 4.

Data sheet 4.1.7 ACADDRBDL4 (offset 0x150, printed page 4-147, dump line 39947).";

        field {
            name = "addr9_bdl";
            desc = "Bit delay line of ADDR9";
            sw = rw;
            hw = r;
            reset = 0x0;
        } addr9_bdl[20:16];

        field {
            name = "addr8_bdl";
            desc = "Bit delay line of ADDR8";
            sw = rw;
            hw = r;
            reset = 0x0;
        } addr8_bdl[4:0];
    } ACADDRBDL4 @ 0x150;

    reg {
        name = "AC address bit delay line configuration register 5";
        desc = "ACADDRBDL5 is AC address bit delay line configuration register 5.

Data sheet 4.1.7 ACADDRBDL5 (offset 0x154, printed page 4-148, dump line 39979).";

        field {
            name = "addr11_bdl";
            desc = "Bit delay line of ADDR11";
            sw = rw;
            hw = r;
            reset = 0x0;
        } addr11_bdl[20:16];

        field {
            name = "addr10_bdl";
            desc = "Bit delay line of ADDR10";
            sw = rw;
            hw = r;
            reset = 0x0;
        } addr10_bdl[4:0];
    } ACADDRBDL5 @ 0x154;

    reg {
        name = "AC address bit delay line configuration register 6";
        desc = "ACADDRBDL6 is AC address bit delay line configuration register 6.

Data sheet 4.1.7 ACADDRBDL6 (offset 0x158, printed page 4-148, dump line 40000).";

        field {
            name = "addr13_bdl";
            desc = "Bit delay line of ADDR13";
            sw = rw;
            hw = r;
            reset = 0x0;
        } addr13_bdl[20:16];

        field {
            name = "addr12_bdl";
            desc = "Bit delay line of ADDR12";
            sw = rw;
            hw = r;
            reset = 0x0;
        } addr12_bdl[4:0];
    } ACADDRBDL6 @ 0x158;

    reg {
        name = "AC address bit delay line configuration register 7";
        desc = "ACADDRBDL7 is AC address bit delay line configuration register 7.

Data sheet 4.1.7 ACADDRBDL7 (offset 0x15C, printed page 4-149, dump line 40032).";

        field {
            name = "addr15_bdl";
            desc = "Bit delay line of ADDR15";
            sw = rw;
            hw = r;
            reset = 0x0;
        } addr15_bdl[20:16];

        field {
            name = "addr14_bdl";
            desc = "Bit delay line of ADDR14";
            sw = rw;
            hw = r;
            reset = 0x0;
        } addr14_bdl[4:0];
    } ACADDRBDL7 @ 0x15C;

    reg {
        name = "AC address bit delay line configuration register 8";
        desc = "ACADDRBDL8 is AC address bit delay line configuration register 8.

Data sheet 4.1.7 ACADDRBDL8 (offset 0x160, printed page 4-149, dump line 40053).";

        field {
            name = "ba1_bdl";
            desc = "Bit delay line of BA1";
            sw = rw;
            hw = r;
            reset = 0x0;
        } ba1_bdl[20:16];

        field {
            name = "ba0_bdl";
            desc = "Bit delay line of BA0";
            sw = rw;
            hw = r;
            reset = 0x0;
        } ba0_bdl[4:0];
    } ACADDRBDL8 @ 0x160;

    reg {
        name = "AC address bit delay line configuration register 9";
        desc = "ACADDRBDL9 is AC address bit delay line configuration register 9.

Data sheet 4.1.7 ACADDRBDL9 (offset 0x164, printed page 4-150, dump line 40085).";

        field {
            name = "ba2_bdl";
            desc = "Bit delay line of BA2";
            sw = rw;
            hw = r;
            reset = 0x0;
        } ba2_bdl[4:0];
    } ACADDRBDL9 @ 0x164;

    reg {
        name = "AC clock bit delay line configuration register";
        desc = "ACCLKBDL is an AC clock bit delay line configuration register.

Data sheet 4.1.7 ACCLKBDL (offset 0x168, printed page 4-150, dump line 40104).";

        field {
            name = "fbclk_bdl";
            desc = "Bit delay line of FBCLK";
            sw = rw;
            hw = r;
            reset = 0x0;
        } fbclk_bdl[28:24];

        field {
            name = "refclk_bdl";
            desc = "Bit delay line of REFCLK";
            sw = rw;
            hw = r;
            reset = 0x0;
        } refclk_bdl[20:16];

        field {
            name = "dramclk1_bdl";
            desc = "Set this field to default value";
            sw = rw;
            hw = r;
            reset = 0x0;
        } dramclk1_bdl[12:8];

        field {
            name = "dramclk0_bdl";
            desc = "Set this field to default value";
            sw = rw;
            hw = r;
            reset = 0x0;
        } dramclk0_bdl[4:0];
    } ACCLKBDL @ 0x168;

    reg {
        name = "AC block PHY control register 0";
        desc = "ACPHYCTL0 is AC block PHY control register 0. This register is used to control the PHY and should not be modified.

Data sheet 4.1.7 ACPHYCTL0 (offset 0x170, printed page 4-151, dump line 40144).";

        field {
            name = "bufphyclk_div2";
            desc = "PHY control";
            sw = rw;
            hw = r;
            reset = 0x0;
        } bufphyclk_div2[6:6];

        field {
            name = "lvdqclkdiv2";
            desc = "PHY control";
            sw = rw;
            hw = r;
            reset = 0x0;
        } lvdqclkdiv2[5:5];

        field {
            name = "dramclk_l";
            desc = "PHY control";
            sw = rw;
            hw = r;
            reset = 0x1;
        } dramclk_l[4:4];

        field {
            name = "dramclk_h";
            desc = "PHY control";
            sw = rw;
            hw = r;
            reset = 0x0;
        } dramclk_h[3:3];

        field {
            name = "margin_a1";
            desc = "PHY control";
            sw = rw;
            hw = r;
            reset = 0x0;
        } margin_a1[2:2];

        field {
            name = "margin_a0";
            desc = "PHY control";
            sw = rw;
            hw = r;
            reset = 0x0;
        } margin_a0[1:1];

        field {
            name = "enshift_a0";
            desc = "PHY control";
            sw = rw;
            hw = r;
            reset = 0x0;
        } enshift_a0[0:0];
    } ACPHYCTL0 @ 0x170;

    reg {
        name = "AC block PHY control register 1";
        desc = "ACPHYCTL1 is AC block PHY control register 1. This register is used to control the PHY and should not be modified.

Data sheet 4.1.7 ACPHYCTL1 (offset 0x174, printed page 4-152, dump line 40188).";

        field {
            name = "dram1sel_addr";
            desc = "PHY control";
            sw = rw;
            hw = r;
            reset = 0x0;
        } dram1sel_addr[31:16];

        field {
            name = "dram1sel_ba";
            desc = "PHY control";
            sw = rw;
            hw = r;
            reset = 0x0;
        } dram1sel_ba[10:8];

        field {
            name = "dram1sel_we";
            desc = "PHY control";
            sw = rw;
            hw = r;
            reset = 0x0;
        } dram1sel_we[6:6];

        field {
            name = "dram1sel_cas";
            desc = "PHY control";
            sw = rw;
            hw = r;
            reset = 0x0;
        } dram1sel_cas[5:5];

        field {
            name = "dram1sel_ras";
            desc = "PHY control";
            sw = rw;
            hw = r;
            reset = 0x0;
        } dram1sel_ras[4:4];

        field {
            name = "dram1sel_odt";
            desc = "PHY control";
            sw = rw;
            hw = r;
            reset = 0x0;
        } dram1sel_odt[3:3];

        field {
            name = "dram1sel_cke";
            desc = "PHY control";
            sw = rw;
            hw = r;
            reset = 0x0;
        } dram1sel_cke[2:2];

        field {
            name = "dram1sel_cs";
            desc = "PHY control";
            sw = rw;
            hw = r;
            reset = 0x0;
        } dram1sel_cs[1:1];

        field {
            name = "dram1sel_reset";
            desc = "PHY control";
            sw = rw;
            hw = r;
            reset = 0x0;
        } dram1sel_reset[0:0];
    } ACPHYCTL1 @ 0x174;

    reg {
        name = "AC block PHY control register 2";
        desc = "ACPHYCTL2 is AC block PHY control register 2. This register is used to control the PHY and should not be modified.

Data sheet 4.1.7 ACPHYCTL2 (offset 0x178, printed page 4-153, dump line 40235).";

        field {
            name = "sdrsel_addr";
            desc = "PHY control";
            sw = rw;
            hw = r;
            reset = 0x0;
        } sdrsel_addr[31:16];

        field {
            name = "sdrsel_ba";
            desc = "PHY control";
            sw = rw;
            hw = r;
            reset = 0x0;
        } sdrsel_ba[10:8];

        field {
            name = "sdrsel_we";
            desc = "PHY control";
            sw = rw;
            hw = r;
            reset = 0x0;
        } sdrsel_we[6:6];

        field {
            name = "sdrsel_cas";
            desc = "PHY control";
            sw = rw;
            hw = r;
            reset = 0x0;
        } sdrsel_cas[5:5];

        field {
            name = "sdrsel_ras";
            desc = "PHY control";
            sw = rw;
            hw = r;
            reset = 0x0;
        } sdrsel_ras[4:4];

        field {
            name = "sdrsel_odt";
            desc = "PHY control";
            sw = rw;
            hw = r;
            reset = 0x0;
        } sdrsel_odt[3:3];

        field {
            name = "sdrsel_cke";
            desc = "PHY control";
            sw = rw;
            hw = r;
            reset = 0x0;
        } sdrsel_cke[2:2];

        field {
            name = "sdrsel_cs";
            desc = "PHY control";
            sw = rw;
            hw = r;
            reset = 0x0;
        } sdrsel_cs[1:1];

        field {
            name = "sdrsel_reset";
            desc = "PHY control";
            sw = rw;
            hw = r;
            reset = 0x0;
        } sdrsel_reset[0:0];
    } ACPHYCTL2 @ 0x178;

    reg {
        name = "AC block PHY control register 3";
        desc = "ACPHYCTL3 is AC block PHY control register 3. This register is used to control the PHY and should not be modified.

Data sheet 4.1.7 ACPHYCTL3 (offset 0x17C, printed page 4-154, dump line 40281).";

        field {
            name = "posedge_addr";
            desc = "PHY control";
            sw = rw;
            hw = r;
            reset = 0x0;
        } posedge_addr[31:16];

        field {
            name = "posedge_ba";
            desc = "PHY control";
            sw = rw;
            hw = r;
            reset = 0x0;
        } posedge_ba[10:8];

        field {
            name = "posedge_we";
            desc = "PHY control";
            sw = rw;
            hw = r;
            reset = 0x0;
        } posedge_we[6:6];

        field {
            name = "posedge_cas";
            desc = "PHY control";
            sw = rw;
            hw = r;
            reset = 0x0;
        } posedge_cas[5:5];

        field {
            name = "posedge_ras";
            desc = "PHY control";
            sw = rw;
            hw = r;
            reset = 0x0;
        } posedge_ras[4:4];

        field {
            name = "posedge_odt";
            desc = "PHY control";
            sw = rw;
            hw = r;
            reset = 0x0;
        } posedge_odt[3:3];

        field {
            name = "posedge_cke";
            desc = "PHY control";
            sw = rw;
            hw = r;
            reset = 0x0;
        } posedge_cke[2:2];

        field {
            name = "posedge_cs";
            desc = "PHY control";
            sw = rw;
            hw = r;
            reset = 0x0;
        } posedge_cs[1:1];

        field {
            name = "posedge_reset";
            desc = "PHY control";
            sw = rw;
            hw = r;
            reset = 0x0;
        } posedge_reset[0:0];
    } ACPHYCTL3 @ 0x17C;

    reg {
        name = "AC block PHY control register 4";
        desc = "ACPHYCTL4 is AC block PHY control register 4. This register is used to control the PHY and should not be modified.

Data sheet 4.1.7 ACPHYCTL4 (offset 0x180, printed page 4-155, dump line 40327).";

        field {
            name = "timing2T_addr";
            desc = "PHY control";
            sw = rw;
            hw = r;
            reset = 0x0;
        } timing2T_addr[31:16];

        field {
            name = "timing2T_ba";
            desc = "PHY control";
            sw = rw;
            hw = r;
            reset = 0x0;
        } timing2T_ba[10:8];

        field {
            name = "timing2T_we";
            desc = "PHY control";
            sw = rw;
            hw = r;
            reset = 0x0;
        } timing2T_we[6:6];

        field {
            name = "timing2T_cas";
            desc = "PHY control";
            sw = rw;
            hw = r;
            reset = 0x0;
        } timing2T_cas[5:5];

        field {
            name = "timing2T_ras";
            desc = "PHY control";
            sw = rw;
            hw = r;
            reset = 0x0;
        } timing2T_ras[4:4];

        field {
            name = "timing2T_odt";
            desc = "PHY control";
            sw = rw;
            hw = r;
            reset = 0x0;
        } timing2T_odt[3:3];

        field {
            name = "timing2T_cke";
            desc = "PHY control";
            sw = rw;
            hw = r;
            reset = 0x0;
        } timing2T_cke[2:2];

        field {
            name = "timing2T_cs";
            desc = "PHY control";
            sw = rw;
            hw = r;
            reset = 0x0;
        } timing2T_cs[1:1];

        field {
            name = "timing2T_reset";
            desc = "PHY control";
            sw = rw;
            hw = r;
            reset = 0x0;
        } timing2T_reset[0:0];
    } ACPHYCTL4 @ 0x180;

    reg {
        name = "AC block PHY control register 5";
        desc = "ACPHYCTL5 is AC block PHY control register 5. This register is used to control the PHY and should not be modified.

Data sheet 4.1.7 ACPHYCTL5 (offset 0x184, printed page 4-155, dump line 40363).";

        field {
            name = "clk1x_cmd2t_ctl2";
            desc = "PHY control";
            sw = rw;
            hw = r;
            reset = 0x0;
        } clk1x_cmd2t_ctl2[27:24];

        field {
            name = "clk1x_mclk";
            desc = "PHY control";
            sw = rw;
            hw = r;
            reset = 0x0;
        } clk1x_mclk[23:20];

        field {
            name = "clk1x_cmd1t";
            desc = "PHY control";
            sw = rw;
            hw = r;
            reset = 0x0;
        } clk1x_cmd1t[19:16];

        field {
            name = "clk1x_cmd2t";
            desc = "PHY control";
            sw = rw;
            hw = r;
            reset = 0x0;
        } clk1x_cmd2t[15:12];

        field {
            name = "clk1x_cmd2t_ctl";
            desc = "PHY control";
            sw = rw;
            hw = r;
            reset = 0x0;
        } clk1x_cmd2t_ctl[11:8];

        field {
            name = "clk1x_dramclk1";
            desc = "PHY control";
            sw = rw;
            hw = r;
            reset = 0x0;
        } clk1x_dramclk1[7:4];

        field {
            name = "clk1x_dramclk0";
            desc = "PHY control";
            sw = rw;
            hw = r;
            reset = 0x0;
        } clk1x_dramclk0[3:0];
    } ACPHYCTL5 @ 0x184;

    reg {
        name = "AC block PHY control register 6";
        desc = "ACPHYCTL6 is AC block PHY control register 6. This register is used to control the PHY and should not be modified.

Data sheet 4.1.7 ACPHYCTL6 (offset 0x188, printed page 4-156, dump line 40402).";

        field {
            name = "clk2x_cmd2t_ctl2";
            desc = "PHY control";
            sw = rw;
            hw = r;
            reset = 0x0;
        } clk2x_cmd2t_ctl2[27:24];

        field {
            name = "clk2x_mclk";
            desc = "PHY control";
            sw = rw;
            hw = r;
            reset = 0x0;
        } clk2x_mclk[23:20];

        field {
            name = "clk2x_cmd1t";
            desc = "PHY control";
            sw = rw;
            hw = r;
            reset = 0x0;
        } clk2x_cmd1t[19:16];

        field {
            name = "clk2x_cmd2t";
            desc = "PHY control";
            sw = rw;
            hw = r;
            reset = 0x0;
        } clk2x_cmd2t[15:12];

        field {
            name = "clk2x_cmd2t_ctl";
            desc = "PHY control";
            sw = rw;
            hw = r;
            reset = 0x0;
        } clk2x_cmd2t_ctl[11:8];

        field {
            name = "clk2x_dramclk1";
            desc = "PHY control";
            sw = rw;
            hw = r;
            reset = 0x0;
        } clk2x_dramclk1[7:4];

        field {
            name = "clk2x_dramclk0";
            desc = "PHY control";
            sw = rw;
            hw = r;
            reset = 0x0;
        } clk2x_dramclk0[3:0];
    } ACPHYCTL6 @ 0x188;

    reg {
        name = "AC block PHY control register 7";
        desc = "ACPHYCTL7 is AC block PHY control register 7. This register is used to control the PHY and should not be modified.

Data sheet 4.1.7 ACPHYCTL7 (offset 0x18C, printed page 4-157, dump line 40441).";

        field {
            name = "halft_cmd2tctl2";
            desc = "Set this bit to the default value.";
            sw = rw;
            hw = r;
            reset = 0x0;
        } halft_cmd2tctl2[26:26];

        field {
            name = "halft_dramclk0";
            desc = "Set this bit to the default value.";
            sw = rw;
            hw = r;
            reset = 0x0;
        } halft_dramclk0[25:25];

        field {
            name = "halft_dramclk1";
            desc = "Set this bit to the default value.";
            sw = rw;
            hw = r;
            reset = 0x0;
        } halft_dramclk1[24:24];

        field {
            name = "halft_cmd1t";
            desc = "Set this bit to the default value.";
            sw = rw;
            hw = r;
            reset = 0x1;
        } halft_cmd1t[23:23];

        field {
            name = "halft_cmd2tctl";
            desc = "Set this bit to the default value.";
            sw = rw;
            hw = r;
            reset = 0x0;
        } halft_cmd2tctl[21:21];

        field {
            name = "ck5p_cmd2tc";
            desc = "Set this field to the default value.";
            sw = rw;
            hw = r;
            reset = 0x0;
        } ck5p_cmd2tc[20:18];

        field {
            name = "ck3p_cmd1t";
            desc = "Set this field to the default value.";
            sw = rw;
            hw = r;
            reset = 0x0;
        } ck3p_cmd1t[14:12];

        field {
            name = "ck2p_dclk1";
            desc = "Configure DRAM CK1 clock phase from PLL1 tap: 1/16 T.";
            sw = rw;
            hw = r;
            reset = 0x0;
        } ck2p_dclk1[11:9];

        field {
            name = "ck1p_dclk0";
            desc = "Configure DRAM CK0 clock phase from PLL1 tap: 1/16 T.";
            sw = rw;
            hw = r;
            reset = 0x0;
        } ck1p_dclk0[8:6];

        field {
            name = "ck0p_mclk";
            desc = "Set this field to the default value.";
            sw = rw;
            hw = r;
            reset = 0x0;
        } ck0p_mclk[5:3];

        field {
            name = "ckd2_mclk";
            desc = "Set this field to the default value.";
            sw = rw;
            hw = r;
            reset = 0x0;
        } ckd2_mclk[2:0];
    } ACPHYCTL7 @ 0x18C;

    reg {
        name = "PHY debugging register";
        desc = "ACDEBUG is a PHY debugging register.

Data sheet 4.1.7 ACDEBUG (offset 0x190, printed page 4-158, dump line 40491).";

        field {
            name = "acdbg_config";
            desc = "Set this field to the default value.";
            sw = rw;
            hw = r;
            reset = 0x0;
        } acdbg_config[19:16];

        field {
            name = "DESKEW_regread";
            desc = "Set this bit to the default value.";
            sw = r;
            hw = w;
            reset = 0x0;
        } DESKEW_regread[8:8];

        field {
            name = "ac_rdcnt";
            desc = "Set this field to the default value.";
            sw = r;
            hw = w;
            reset = 0x0;
        } ac_rdcnt[2:0];
    } ACDEBUG @ 0x190;

    reg {
        name = "AC block PHY reserved control pin register 1";
        desc = "ACPHYRSVDC is AC block PHY reserved control pin register 1. This register is used to control the PHY and should not be modified.

Data sheet 4.1.7 ACPHYRSVDC (offset 0x194, printed page 4-158, dump line 40522).";

        field {
            name = "ac_rsv_control";
            desc = "Reserved";
            sw = rw;
            hw = r;
            reset = 0xFFFF0000;
        } ac_rsv_control[31:0];
    } ACPHYRSVDC @ 0x194;

    reg {
        name = "AC block PHY reserved control pin register 2";
        desc = "ACPHYRSVDS is AC block PHY reserved control pin register 2. This register is used to control the PHY and should not be modified.

Data sheet 4.1.7 ACPHYRSVDS (offset 0x198, printed page 4-159, dump line 40552).";

        field {
            name = "ac_rsv_status";
            desc = "Reserved";
            sw = r;
            hw = w;
            reset = 0xFFFF0000;
        } ac_rsv_status[31:0];
    } ACPHYRSVDS @ 0x198;

    reg {
        name = "AC block PHY control register 8";
        desc = "ACPHYCTL8 is AC block PHY control register 8. This register is used to control the PHY and should not be modified.

Data sheet 4.1.7 ACPHYCTL8 (offset 0x19C, printed page 4-159, dump line 40571).";

        field {
            name = "ac_ck12p_reserve";
            desc = "Set this field to the default value.";
            sw = rw;
            hw = r;
            reset = 0x0;
        } ac_ck12p_reserve[20:18];

        field {
            name = "ac_ck11p_reserve";
            desc = "Set this field to the default value.";
            sw = rw;
            hw = r;
            reset = 0x0;
        } ac_ck11p_reserve[17:15];

        field {
            name = "ac_ck10p_reserve";
            desc = "Set this field to the default value.";
            sw = rw;
            hw = r;
            reset = 0x0;
        } ac_ck10p_reserve[14:12];

        field {
            name = "ac_ck9p_reserve";
            desc = "Set this field to the default value.";
            sw = rw;
            hw = r;
            reset = 0x0;
        } ac_ck9p_reserve[11:9];

        field {
            name = "ac_ck8p_reserve";
            desc = "Set this field to the default value.";
            sw = rw;
            hw = r;
            reset = 0x0;
        } ac_ck8p_reserve[8:6];

        field {
            name = "ac_ck7p_reserve";
            desc = "Set this field to the default value.";
            sw = rw;
            hw = r;
            reset = 0x0;
        } ac_ck7p_reserve[5:3];

        field {
            name = "ac_ck6p_reserve";
            desc = "Set this field to the default value.";
            sw = rw;
            hw = r;
            reset = 0x0;
        } ac_ck6p_reserve[2:0];
    } ACPHYCTL8 @ 0x19C;

    reg {
        name = "AC command bit delay line configuration register 8";
        desc = "ACCMDBDL8 is AC command bit delay line configuration register 8.

Data sheet 4.1.7 ACCMDBDL8 (offset 0x1A0, printed page 4-160, dump line 40613).";

        field {
            name = "odt1_bdl1";
            desc = "Set this field to the default value.";
            sw = rw;
            hw = r;
            reset = 0x0;
        } odt1_bdl1[20:16];

        field {
            name = "odt1_bdl0";
            desc = "Set this field to the default value.";
            sw = rw;
            hw = r;
            reset = 0x0;
        } odt1_bdl0[4:0];
    } ACCMDBDL8 @ 0x1A0;

    reg {
        name = "AC command bit delay line configuration register 9";
        desc = "ACCMDBDL9 is AC command bit delay line configuration register 9.

Data sheet 4.1.7 ACCMDBDL9 (offset 0x1A4, printed page 4-160, dump line 40634).";

        field {
            name = "odt1_bdl3";
            desc = "Set this field to the default value.";
            sw = rw;
            hw = r;
            reset = 0x0;
        } odt1_bdl3[20:16];

        field {
            name = "odt1_bdl2";
            desc = "Set this field to the default value.";
            sw = rw;
            hw = r;
            reset = 0x0;
        } odt1_bdl2[4:0];
    } ACCMDBDL9 @ 0x1A4;

    reg {
        name = "AC command bit delay line configuration register 10";
        desc = "ACCMDBDL10 is AC command bit delay line configuration register 10.

Data sheet 4.1.7 ACCMDBDL10 (offset 0x1A8, printed page 4-161, dump line 40666).";

        field {
            name = "cs1_bdl1";
            desc = "Set this field to the default value.";
            sw = rw;
            hw = r;
            reset = 0x0;
        } cs1_bdl1[20:16];

        field {
            name = "cs1_bdl0";
            desc = "Set this field to the default value.";
            sw = rw;
            hw = r;
            reset = 0x0;
        } cs1_bdl0[4:0];
    } ACCMDBDL10 @ 0x1A8;

    reg {
        name = "AC command bit delay line configuration register 11";
        desc = "ACCMDBDL11 is AC command bit delay line configuration register 11.

Data sheet 4.1.7 ACCMDBDL11 (offset 0x1AC, printed page 4-161, dump line 40687).";

        field {
            name = "cs1_bdl3";
            desc = "Set this field to the default value.";
            sw = rw;
            hw = r;
            reset = 0x0;
        } cs1_bdl3[20:16];

        field {
            name = "cs1_bdl2";
            desc = "Set this field to the default value.";
            sw = rw;
            hw = r;
            reset = 0x0;
        } cs1_bdl2[4:0];
    } ACCMDBDL11 @ 0x1AC;

    reg {
        name = "AC block PHY DCC control register";
        desc = "ACPHYDCC is an AC block PHY DCC control register. This register is used to control the PHY and should not be modified.

Data sheet 4.1.7 ACPHYDCC (offset 0x1B0, printed page 4-162, dump line 40720).";

        field {
            name = "acdcc_mclk";
            desc = "Set this field to the default value.";
            sw = rw;
            hw = r;
            reset = 0x0;
        } acdcc_mclk[18:16];

        field {
            name = "acdcc_dqs0";
            desc = "Set this field to the default value.";
            sw = rw;
            hw = r;
            reset = 0x0;
        } acdcc_dqs0[14:12];

        field {
            name = "acdcc_dqs1";
            desc = "Set this field to the default value.";
            sw = rw;
            hw = r;
            reset = 0x0;
        } acdcc_dqs1[10:8];

        field {
            name = "acdcc_dq0";
            desc = "Set this field to the default value.";
            sw = rw;
            hw = r;
            reset = 0x0;
        } acdcc_dq0[6:4];

        field {
            name = "acdcc_dq1";
            desc = "Set this field to the default value.";
            sw = rw;
            hw = r;
            reset = 0x0;
        } acdcc_dq1[2:0];
    } ACPHYDCC @ 0x1B0;

    reg {
        name = "AC block PHY control register 9";
        desc = "ACPHYCTL9 is AC block PHY control register 9. This register is used to control the PHY and should not be modified.

Data sheet 4.1.7 ACPHYCTL9 (offset 0x1B4, printed page 4-162, dump line 40754).";

        field {
            name = "actiming2t_odt1";
            desc = "Set this bit to the default value.";
            sw = rw;
            hw = r;
            reset = 0x0;
        } actiming2t_odt1[11:11];

        field {
            name = "actiming2t_cke1";
            desc = "Set this bit to the default value.";
            sw = rw;
            hw = r;
            reset = 0x0;
        } actiming2t_cke1[10:10];

        field {
            name = "actiming2t_cs1";
            desc = "Set this bit to the default value.";
            sw = rw;
            hw = r;
            reset = 0x0;
        } actiming2t_cs1[9:9];

        field {
            name = "acdram1sel_odt1";
            desc = "Set this bit to the default value.";
            sw = rw;
            hw = r;
            reset = 0x0;
        } acdram1sel_odt1[8:8];

        field {
            name = "acdram1sel_cke1";
            desc = "Set this bit to the default value.";
            sw = rw;
            hw = r;
            reset = 0x0;
        } acdram1sel_cke1[7:7];

        field {
            name = "acdram1sel_cs1";
            desc = "Set this bit to the default value.";
            sw = rw;
            hw = r;
            reset = 0x0;
        } acdram1sel_cs1[6:6];

        field {
            name = "acposedge_odt1";
            desc = "Set this bit to the default value.";
            sw = rw;
            hw = r;
            reset = 0x0;
        } acposedge_odt1[5:5];

        field {
            name = "acposedge_cke1";
            desc = "Set this bit to the default value.";
            sw = rw;
            hw = r;
            reset = 0x0;
        } acposedge_cke1[4:4];

        field {
            name = "acposedge_cs1";
            desc = "Set this bit to the default value.";
            sw = rw;
            hw = r;
            reset = 0x0;
        } acposedge_cs1[3:3];

        field {
            name = "acsdrsel_odt1";
            desc = "Set this bit to the default value.";
            sw = rw;
            hw = r;
            reset = 0x0;
        } acsdrsel_odt1[2:2];

        field {
            name = "acsdrsel_cke1";
            desc = "Set this bit to the default value.";
            sw = rw;
            hw = r;
            reset = 0x0;
        } acsdrsel_cke1[1:1];

        field {
            name = "acsdrsel_cs1";
            desc = "Set this bit to the default value.";
            sw = rw;
            hw = r;
            reset = 0x0;
        } acsdrsel_cs1[0:0];
    } ACPHYCTL9 @ 0x1B4;

    reg {
        name = "CA training timer 0 register";
        desc = "CATTIMER0 is a CA training timer 0 register.

Data sheet 4.1.7 CATTIMER0 (offset 0x1C0, printed page 4-163, dump line 40802).";

        field {
            name = "tcackeh";
            desc = "tCACKEH (dficlk cycle)";
            sw = rw;
            hw = r;
            reset = 0xB;
        } tcackeh[29:24];

        field {
            name = "tcacd";
            desc = "tCACD (dficlk cycle)";
            sw = rw;
            hw = r;
            reset = 0x17;
        } tcacd[21:16];

        field {
            name = "tcaent";
            desc = "tCAENT (dficlk cycle)";
            sw = rw;
            hw = r;
            reset = 0xB;
        } tcaent[13:8];

        field {
            name = "tcackel";
            desc = "tCACKEL (dficlk cycle)";
            sw = rw;
            hw = r;
            reset = 0xB;
        } tcackel[5:0];
    } CATTIMER0 @ 0x1C0;

    reg {
        name = "CA training timer 1 register";
        desc = "CATTIMER1 is CA training timer 1 register.

Data sheet 4.1.7 CATTIMER1 (offset 0x1C4, printed page 4-164, dump line 40838).";

        field {
            name = "tmrz";
            desc = "tMRZ (dficlk cycle)";
            sw = rw;
            hw = r;
            reset = 0x4;
        } tmrz[13:8];

        field {
            name = "tcaext";
            desc = "tCAEXT (dficlk cycle)";
            sw = rw;
            hw = r;
            reset = 0xB;
        } tcaext[5:0];
    } CATTIMER1 @ 0x1C4;

    reg {
        name = "CA training configuration register";
        desc = "CATCONFIG is a CA training configuration register.

Data sheet 4.1.7 CATCONFIG (offset 0x1C8, printed page 4-164, dump line 40864).";

        enum CATCONFIG_sw_cat_en_enum {
            DISABLED = 0 { name = "Disabled"; desc = "disabled (default)"; };
            ENABLED = 1 { name = "Enabled"; desc = "enabled"; };
        };

        field {
            name = "sw_cat_en";
            desc = "SW CA training enable When this field is asserted, PACK will enter the SW CA training state. After the SW CA training is complete, this bit should be deasserted by firmware.";
            sw = rw;
            hw = r;
            encode = CATCONFIG_sw_cat_en_enum;
            reset = 0x0;
        } sw_cat_en[31:31];

        enum CATCONFIG_sw_cat_dqvalid_enum {
            NOT_VALID = 0 { name = "Not Valid"; desc = "not valid"; };
            VALID = 1 { name = "Valid"; desc = "valid"; };
        };

        field {
            name = "sw_cat_dqvalid";
            desc = "SW CA training. This field indicates whether the CA result is ready. This bit is cleared when sw_cat_strobe is asserted. Then after the timing tCACD, this bit is asserted.";
            sw = rw;
            hw = r;
            encode = CATCONFIG_sw_cat_dqvalid_enum;
            reset = 0x0;
        } sw_cat_dqvalid[30:30];

        field {
            name = "sw_cat_cke_low";
            desc = "SW CA training. This field is used to request the CKE to be low and it cleared by HW.";
            sw = rw;
            hw = r;
            reset = 0x0;
        } sw_cat_cke_low[29:29];

        field {
            name = "sw_cat_cke_high";
            desc = "SW CA training. This field is used to request the CKE to be high and is cleared by HW.";
            sw = rw;
            hw = r;
            reset = 0x0;
        } sw_cat_cke_high[28:28];

        field {
            name = "sw_cat_strobe";
            desc = "SW CA training. This field is used to issue the predefined SW CA pattern and is cleared by HW.";
            sw = rw;
            hw = r;
            reset = 0x0;
        } sw_cat_strobe[27:27];

        field {
            name = "sw_cat_mrw41";
            desc = "SW CA training. This field is used to issue the MRW41 command and is cleared by HW.";
            sw = rw;
            hw = r;
            reset = 0x0;
        } sw_cat_mrw41[26:26];

        field {
            name = "sw_cat_mrw48";
            desc = "SW CA training. This field is used to issue the MRW48 command and is cleared by HW.";
            sw = rw;
            hw = r;
            reset = 0x0;
        } sw_cat_mrw48[25:25];

        field {
            name = "sw_cat_mrw42";
            desc = "SW CA training. This field is used to issue the MRW42 command and is cleared by HW.";
            sw = rw;
            hw = r;
            reset = 0x0;
        } sw_cat_mrw42[24:24];

        enum CATCONFIG_cat_openeye_en_enum {
            DISABLED = 0 { name = "Disabled"; desc = "disabled (default)"; };
            ENABLED = 1 { name = "Enabled"; desc = "enabled"; };
        };

        field {
            name = "cat_openeye_en";
            desc = "HW CA training open eye enable";
            sw = rw;
            hw = r;
            encode = CATCONFIG_cat_openeye_en_enum;
            reset = 0x0;
        } cat_openeye_en[20:20];

        enum CATCONFIG_cat_restore_en_enum {
            DISABLED = 0 { name = "Disabled"; desc = "disabled"; };
            ENABLED = 1 { name = "Enabled"; desc = "enabled (default)"; };
        };

        field {
            name = "cat_restore_en";
            desc = "HW CA training restore enable. If this field is set to high, the CA training will restore the CA phase before the second CA training (mapping stage) starts. This field is recommended to set to high.";
            sw = rw;
            hw = r;
            encode = CATCONFIG_cat_restore_en_enum;
            reset = 0x1;
        } cat_restore_en[19:19];

        enum CATCONFIG_cat_cat_phydq_sel_enum {
            LSB = 0 { name = "Lsb"; desc = "LSB (default)"; };
            MSB = 1 { name = "Msb"; desc = "MSB"; };
        };

        field {
            name = "cat_cat_phydq_sel";
            desc = "HW CA training PHY DQ CA result select";
            sw = rw;
            hw = r;
            encode = CATCONFIG_cat_cat_phydq_sel_enum;
            reset = 0x0;
        } cat_cat_phydq_sel[18:18];

        field {
            name = "cat_rb_backtap";
            desc = "HW CA training right boundary back tap. This field is used to offset the addrph_a before the right boundary search is started to overcome meta-sable zone.";
            sw = rw;
            hw = r;
            reset = 0x2;
        } cat_rb_backtap[15:12];

        field {
            name = "ca_samp_num_ph";
            desc = "HW CA training sample count for CA phase Value range: 1-15";
            sw = rw;
            hw = r;
            reset = 0x6;
        } ca_samp_num_ph[11:8];

        field {
            name = "ca_samp_num_bdl";
            desc = "HW CA training sample count for CA BDL Value range: 1-15";
            sw = rw;
            hw = r;
            reset = 0x6;
        } ca_samp_num_bdl[3:0];
    } CATCONFIG @ 0x1C8;

    reg {
        name = "CA training result register (for debugging)";
        desc = "CATRESULT is a CA training result register (for debugging).

Data sheet 4.1.7 CATRESULT (offset 0x1CC, printed page 4-166, dump line 40959).";

        enum CATRESULT_cat_reault_enum {
            FAIL = 0x0 { name = "Fail"; desc = "fail"; };
            SUCCESS = 0x1 { name = "Success"; desc = "success"; };
        };

        field {
            name = "cat_reault";
            desc = "CA training. HW CA training result for each address bit during each HW CA training state. This field is meaningful only after the HW CA training is complete and is only for debugging.";
            sw = r;
            hw = w;
            encode = CATRESULT_cat_reault_enum;
            reset = 0x0;
        } cat_reault[9:0];
    } CATRESULT @ 0x1CC;

    reg {
        name = "SW CA training DQ result (from PHY) register";
        desc = "PHYDQRESULT is a SW CA training DQ result (from PHY) register.

Data sheet 4.1.7 PHYDQRESULT (offset 0x1D0, printed page 4-166, dump line 40983).";

        field {
            name = "phy_dq_result";
            desc = "SW CA training. SW CA training latched results from the DRAM device. For the LPDDR3 CA training, the meaningful bits are [15:0] (mapped to DQ[15:0]). PACK and PHY will not latch these bits, so these bits are those you obtained on DQ of the DRAM device.";
            sw = r;
            hw = w;
            reset = 0x0;
        } phy_dq_result[31:0];
    } PHYDQRESULT @ 0x1D0;

    reg {
        name = "CA training address phase boundary register";
        desc = "ADDRPHBOUND is a CA training address phase boundary register.

Data sheet 4.1.7 ADDRPHBOUND (offset 0x1D4, printed page 4-167, dump line 41015).";

        field {
            name = "addrph_a_ori";
            desc = "HW CA training. This field records the address phase before the HW CA training (for debugging).";
            sw = r;
            hw = w;
            reset = 0x0;
        } addrph_a_ori[28:24];

        field {
            name = "addrph_a";
            desc = "HW CA training. This field records the left boundary of the address phase after the HW CA training (for debugging).";
            sw = rw;
            hw = r;
            reset = 0x8;
        } addrph_a[20:16];

        field {
            name = "addrph_a_left";
            desc = "HW CA training. This field records the left boundary of the address phase after the HW CA training (for debugging).";
            sw = r;
            hw = w;
            reset = 0x0;
        } addrph_a_left[12:8];

        field {
            name = "addrph_a_right";
            desc = "HW CA training. This field records the right boundary of the address phase after the HW CA training (for debugging).";
            sw = r;
            hw = w;
            reset = 0x0;
        } addrph_a_right[4:0];
    } ADDRPHBOUND @ 0x1D4;

    reg {
        name = "SW CA training pattern register for the _P positive CK edge";
        desc = "SWCATPATTERN_P is an SW CA training pattern register for the positive CK edge.

Data sheet 4.1.7 SWCATPATTERN_P (offset 0x1D8, printed page 4-167, dump line 41053).";

        field {
            name = "sw_cat_pat_p";
            desc = "SW CA training pattern for the positive CK edge. You can fill any pattern.";
            sw = rw;
            hw = r;
            reset = 0x0;
        } sw_cat_pat_p[9:0];
    } SWCATPATTERN_P @ 0x1D8;

    reg {
        name = "SW CA training pattern register for the _N negative CK edge";
        desc = "SWCATPATTERN_N is an SW CA training pattern register for the negative CK edge.

Data sheet 4.1.7 SWCATPATTERN_N (offset 0x1DC, printed page 4-168, dump line 41081).";

        field {
            name = "sw_cat_pat_n";
            desc = "SW CA training pattern for the negative CK edge. You can fill any pattern.";
            sw = rw;
            hw = r;
            reset = 0x3FF;
        } sw_cat_pat_n[9:0];
    } SWCATPATTERN_N @ 0x1DC;

    reg {
        name = "Low-power control register";
        desc = "LPCTRL is a low-power control register.

Data sheet 4.1.7 LPCTRL (offset 0x1E4, printed page 4-168, dump line 41103).";

        enum LPCTRL_gcken_auto_en_enum {
            OFF = 0 { name = "Off"; desc = "off"; };
            V_1 = 1 { name = "V 1"; desc = "on (default)"; };
        };

        field {
            name = "gcken_auto_en";
            desc = "Auto gated clock control enable. If this field is set to high, HW automatically/dynamically controls the PACK high-level clock gating.";
            sw = rw;
            hw = r;
            encode = LPCTRL_gcken_auto_en_enum;
            reset = 0x1;
        } gcken_auto_en[31:31];

        enum LPCTRL_gcken_dfi_main_enum {
            CLOCK_OFF = 0 { name = "Clock Off"; desc = "clock off"; };
            CLOCK_WHEN_THIS = 1 { name = "Clock When This"; desc = "clock on (default) When this field is set to low (clock off), some control registers that use the dfi_main clock are affected."; };
        };

        field {
            name = "gcken_dfi_main";
            desc = "Manual gating control, main DFI clock gating switch";
            sw = rw;
            hw = r;
            encode = LPCTRL_gcken_dfi_main_enum;
            reset = 0x1;
        } gcken_dfi_main[30:30];

        enum LPCTRL_gcken_dinit_enum {
            CLOCK_OFF = 0 { name = "Clock Off"; desc = "clock off"; };
            CLOCK_V = 1 { name = "Clock V"; desc = "clock on (default)"; };
        };

        field {
            name = "gcken_dinit";
            desc = "Manual gating control, DRAM initialization clock gating";
            sw = rw;
            hw = r;
            encode = LPCTRL_gcken_dinit_enum;
            reset = 0x1;
        } gcken_dinit[29:29];

        enum LPCTRL_gcken_dtrain_enum {
            CLOCK_OFF = 0 { name = "Clock Off"; desc = "clock off"; };
            CLOCK_V = 1 { name = "Clock V"; desc = "clock on (default)"; };
        };

        field {
            name = "gcken_dtrain";
            desc = "Manual gating control, data training clock gating";
            sw = rw;
            hw = r;
            encode = LPCTRL_gcken_dtrain_enum;
            reset = 0x1;
        } gcken_dtrain[28:28];

        enum LPCTRL_gcken_retrain_enum {
            CLOCK_OFF = 0 { name = "Clock Off"; desc = "clock off"; };
            CLOCK_V = 1 { name = "Clock V"; desc = "clock on (default)"; };
        };

        field {
            name = "gcken_retrain";
            desc = "Manual gating control, retraining clock gating";
            sw = rw;
            hw = r;
            encode = LPCTRL_gcken_retrain_enum;
            reset = 0x1;
        } gcken_retrain[27:27];

        enum LPCTRL_gcken_acbist_enum {
            CLOCK_OFF = 0 { name = "Clock Off"; desc = "clock off"; };
            CLOCK_V = 1 { name = "Clock V"; desc = "clock on (default)"; };
        };

        field {
            name = "gcken_acbist";
            desc = "Manual gating control, AC BIST clock gating";
            sw = rw;
            hw = r;
            encode = LPCTRL_gcken_acbist_enum;
            reset = 0x1;
        } gcken_acbist[26:26];

        enum LPCTRL_gcken_dxbist_enum {
            CLOCK_OFF = 0 { name = "Clock Off"; desc = "clock off"; };
            CLOCK_V = 1 { name = "Clock V"; desc = "clock on (default)"; };
        };

        field {
            name = "gcken_dxbist";
            desc = "Manual gating control, data BIST clock gating";
            sw = rw;
            hw = r;
            encode = LPCTRL_gcken_dxbist_enum;
            reset = 0x1;
        } gcken_dxbist[25:25];

        field {
            name = "t_wakeup_thrd_lv2";
            desc = "DFI low-power control interface timing threshold >= wakeup_thrd_lv2: PHY clock gating, disable AC output enable >= wakeup_thrd_lv3: PHY clock gating, disable AC output enable, PHY PLL disable";
            sw = rw;
            hw = r;
            reset = 0x4;
        } t_wakeup_thrd_lv2[24:21];

        enum LPCTRL_lp_cmdoen_disable_enum {
            LP_RELATED_FUNCTION = 0 { name = "Lp Related Function"; desc = "LP-related function enabled (default)"; };
            LP_RELATED_FUNCTION_2 = 1 { name = "Lp Related Function 2"; desc = "LP-related function disabled"; };
        };

        field {
            name = "lp_cmdoen_disable";
            desc = "LP CMDOEN function disable when low-power assert. If this function is enabled, the I/O output of CA is floating to reduce I/O power.";
            sw = rw;
            hw = r;
            encode = LPCTRL_lp_cmdoen_disable_enum;
            reset = 0x0;
        } lp_cmdoen_disable[20:20];

        enum LPCTRL_lp_ac_phy_clkgated_disable_enum {
            LP_RELATED_FUNCTION = 0 { name = "Lp Related Function"; desc = "LP-related function enabled (default)"; };
            LP_RELATED_FUNCTION_2 = 1 { name = "Lp Related Function 2"; desc = "LP-related function disabled"; };
        };

        field {
            name = "lp_ac_phy_clkgated_disable";
            desc = "LP AC PHY clock gating disable when low-power assert";
            sw = rw;
            hw = r;
            encode = LPCTRL_lp_ac_phy_clkgated_disable_enum;
            reset = 0x0;
        } lp_ac_phy_clkgated_disable[19:19];

        enum LPCTRL_lp_dx_phy_clkgated_disable_enum {
            LP_RELATED_FUNCTION = 0 { name = "Lp Related Function"; desc = "LP-related function enabled (default)"; };
            LP_RELATED_FUNCTION_2 = 1 { name = "Lp Related Function 2"; desc = "LP-related function disabled"; };
        };

        field {
            name = "lp_dx_phy_clkgated_disable";
            desc = "LP DX PHY clock gating disable when low-power assert";
            sw = rw;
            hw = r;
            encode = LPCTRL_lp_dx_phy_clkgated_disable_enum;
            reset = 0x0;
        } lp_dx_phy_clkgated_disable[18:18];

        enum LPCTRL_lp_dx_phy_phgated_disable_enum {
            LP_RELATED_FUNCTION = 0 { name = "Lp Related Function"; desc = "LP-related function enabled (default)"; };
            LP_RELATED_FUNCTION_2 = 1 { name = "Lp Related Function 2"; desc = "LP-related function disabled"; };
        };

        field {
            name = "lp_dx_phy_phgated_disable";
            desc = "DX PHY clock phase gating disable when low-power assert";
            sw = rw;
            hw = r;
            encode = LPCTRL_lp_dx_phy_phgated_disable_enum;
            reset = 0x0;
        } lp_dx_phy_phgated_disable[17:17];

        enum LPCTRL_lp_pll_powerdown_disable_enum {
            LP_RELATED_FUNCTION = 0 { name = "Lp Related Function"; desc = "LP-related function enabled (default)"; };
            LP_RELATED_FUNCTION_2 = 1 { name = "Lp Related Function 2"; desc = "LP-related function disabled"; };
        };

        field {
            name = "lp_pll_powerdown_disable";
            desc = "LP PLL disable function disable when low-power assert";
            sw = rw;
            hw = r;
            encode = LPCTRL_lp_pll_powerdown_disable_enum;
            reset = 0x0;
        } lp_pll_powerdown_disable[16:16];

        field {
            name = "t_resp";
            desc = "DFI low-power control interface timing parameter. The field value must be smaller than DFI tlp_resp.";
            sw = rw;
            hw = r;
            reset = 0x8;
        } t_resp[15:12];

        field {
            name = "t_wakeup_thrd_lv3";
            desc = "DFI low-power control interface timing threshold >= wakeup_thrd_lv2: PHY clock gating, disable AC output enable >= wakeup_thrd_lv3: PHY clock gating, disable AC output enable, PHY PLL power down Note: wakeup_thrd_lv3 should >= wakeup_thrd_lv2";
            sw = rw;
            hw = r;
            reset = 0x6;
        } t_wakeup_thrd_lv3[11:8];

        field {
            name = "t_dram_clk_disable";
            desc = "DFI DRAM clock disable timing parameter. This field is used to count down before DRAM CK is disabled.";
            sw = rw;
            hw = r;
            reset = 0x8;
        } t_dram_clk_disable[7:4];

        field {
            name = "t_dram_clk_enable";
            desc = "DFI DRAM clock enable timing parameter. This field is used to count down before DRAM CK is enabled.";
            sw = rw;
            hw = r;
            reset = 0x8;
        } t_dram_clk_enable[3:0];
    } LPCTRL @ 0x1E4;


    eHISI_DDRC_V2_PHY_DX DX[4] @ 0x200 += 0x80;

    reg {
        name = "Local delay line control register (m = 1 copy)";
        desc = "DXNRDQSGDLY is a local delay line control register.

Copy m = 1 of DXNRDQSGDLY (offset formula `0x23C + n x 0x80 + m x 0x400` of the data sheet, m = 1). Not used by any vendor code; the formula looks inherited from a two-rank PHY (the Hi3518E has one rank).

Data sheet 4.1.7 DXNRDQSGDLY (offset 0x23C, printed page 4-178, dump line 41732).";

        field {
            name = "org_rdqsgph";
            desc = "Original read DQS gate phase before HW gate training post-update stage (for debugging)";
            sw = r;
            hw = w;
            reset = 0x0;
        } org_rdqsgph[29:24];

        field {
            name = "rdqsgtxbdl";
            desc = "Read DQS gate delay select This field specifies the delay value of the read gating delay before DQS dummy PAD.";
            sw = rw;
            hw = r;
            reset = 0x0;
        } rdqsgtxbdl[20:16];

        field {
            name = "rdqsgphase";
            desc = "Read DQS gating clock phase select";
            sw = rw;
            hw = r;
            reset = 0x0;
        } rdqsgphase[13:8];

        field {
            name = "rdqsgbdl";
            desc = "Read DQS gating delay select This field specifies the delay value of the read gating delay after DQS dummy PAD.";
            sw = rw;
            hw = r;
            reset = 0x10;
        } rdqsgbdl[5:0];
    } DXNRDQSGDLY_M1[4] @ 0x63C += 0x80;
};

regfile eHISI_DDRC_V2 {
    name = "HiSilicon DDRC V2 (DDR2/DDR3 controller and DDR PHY, Hi3518E V20X / Hi3516C V200 / Hi3516A/D V100 / Hi3516C V300)";
    desc = "
    DDR2/DDR3/DDR3L SDRAM controller with its AXI front end, DMC and DDR PHY as found in the Hi3518E V200/V201 and Hi3516C V200 (data sheet chapter 4.1), the Hi3516A/D V100 and the Hi3516C V300 / E V100. Not the same IP as `eHISI_DDRC` (Hi3520D / Hi3518 V100): none of its register layout matches.

    Chips and editions (data-sheet table comparison, 2026-11-10):
    - Hi3518E V200/V201: embedded 16-bit DDR2 SDRAM (512 Mbit / 256 Mbit, max 360 MHz, 720 Mbit/s); Hi3516C V200: 16-bit DDR2/DDR3/DDR3L up to 4 Gbit and 400 MHz. One chip select. Instance base 0x20110000: AXI registers at +0x0000, DMC registers at +0x1000 (0x20111000), DDR PHY registers at +0x8000 (0x20118000), as printed in the data sheet summary tables. This is the default (unguarded) edition; the register and field descriptions were written from this data sheet, and the vendor-settled values quoted in some descs (e.g. DRAMCFG 0x21, DDRMODE 0x15) are Hi3518E V200 stock-image values.
    - Hi3516A/D V100 (data sheet chapter 4.1, Tables 4-5/4-6/4-7): one 32-bit DDR3/DDR3L interface up to 600 MHz (16-bit on the Hi3516D, 4 Gbit per 16-bit device, two devices max). The AXI, DMC and DDR PHY tables are register-for-register identical to the Hi3518E V20X ones (214 of 216 registers byte-identical; the two differences are PDF extraction artefacts in IOCTL/IOCTL2), same bases 0x20110000 / 0x20111000 / 0x20118000, so the chip instantiates this regfile unchanged. Values quoted from the Hi3518E stock image do not apply.
    - Hi3516C V300 / E V100 (`DDRC_V2_CV300`, data sheet 4.1 Tables 4-4/4-5): AXI base 0x12060000 (the address map calls the window 'MDDRC register'), DMC at 0x12061000. 16-bit DDR3. AXI and DMC tables identical to the Hi3518E V20X ones except the end of the DMC: the data sheet documents DDRC_HIS_SFC_RDATA0..3 (0x4A8..0x4B4) as the four read-data words 127:0 (confirming the vendor `ddr_ddrc_v500.h` layout) plus a new DDRC_TEST_GENPOSE0 (0x4BC), and has no RDATA4..7 / RDATA_ECC (0x4B8..0x4C8). The data sheet has no DDR PHY chapter and the PHY regfile is NOT instantiated for this chip: the vendor U-Boot (`hi3516cv300/ddr_training_custom.h`) puts a 28 nm 'T28' PHY at DDRC0_REG_BASE + 0x8000 (0x12068000) whose layout differs from the 'S40' PHY of the Hi3518E V20X / Hi3516A/D described by `eHISI_DDRC_V2_PHY` (vendor `drivers/ddr/ddr_phy_t28.h` vs `ddr_phy_s40.h`: AC block ACCMDBDL2/ACPHYCTL4/ACPHYCTL7 at 0x1040/0x1064/0x1070 instead of 0x128/0x180/0x18C, new DVRFTCTRL 0xC4 and CATSWAPINDEX/CATSWAPSEL 0x1B8/0x1BC, DXNOEBDL at DX+0x28 instead of +0x58, DXNRDQSGDLY at DX+0x40 instead of +0x3C, 7-bit instead of 5-bit BDLs, DVREFT/HVREFT_STATUS at DX+0x70/0x74). The same T28 PHY (with the V510 DMC) is selected for the Hi3516A V200 / Hi3519 V101 / Hi3519 / Hi3559, so it belongs to the MDDRC generation; no data sheet in the workspace documents it.

    The DDRC cannot be reset separately (global soft reset only) and must be re-initialised after any reset.
    ";

    eHISI_DDRC_V2_AXI   AXI @ 0x0000;
    eHISI_DDRC_V2_DMC   DMC @ 0x1000;
`ifndef DDRC_V2_CV300
    eHISI_DDRC_V2_PHY   PHY @ 0x8000;
`endif
};

`endif
