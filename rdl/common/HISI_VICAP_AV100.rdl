`ifndef HISI_VICAP_AV100_RDL
`define HISI_VICAP_AV100_RDL


regfile eHISI_VICAP_AV100 {
    name = "VICAP (video capture and ISP, Hi3516A V100 / Hi3516D V100)";
    desc = "Video capture unit (VICAP) of the Hi3516A V100 and Hi3516D V100 at 0x20580000 (256 KB window, data sheet chapter 10.1). The data sheet chapter also lists the ISP register range (ISP_*, up to 0x19BFC) of this window, so this regfile holds both. 73 of its registers also appear (same names and offsets) in the Hi3518E V20X `eHISI_VICAP_V2`, which is the single-channel edition. Register ranges of the summary table (CH_DIS_VSTAT/HSTAT, CH_AF_STAT_RDATA, ISP_FPN_MEM, ISP_DEHAZE_MINSTAT/PRESTAT/MAXSTAT/LUT) are arrays of consecutive 32-bit words. Generated 2026-11-15 by scripts/rdl-extract/gen_m_cells.py from the data sheet register tables (ds_extract2 + description extraction from the PDF); PROVENANCE: PROVEN = offsets, names, bit fields, access and reset values from the data sheet tables; nothing here is hardware verified.

    Register sources: 254 registers from the data sheet (hi3516av100--Hi3516A-Hi3516D-Datasheet.txt, section 10.1.6). ";

    reg {
        name = "Bus configuration register";
        desc = "AXI_CFG is a bus configuration register. Huawei Proprietary and Confidential Hi3516A/Hi3516D Professional HD IP Camera SoC

Data sheet 10.1.6 AXI_CFG (offset 0x10, printed page 10-26, `hi3516av100--Hi3516A-Hi3516D-Datasheet.txt` line 60257).";

        field {
            name = "r_outstanding";
            desc = "Number of read request outstandings. The value range is [1, 8].";
            sw = rw;
            hw = r;
            reset = 0x0;
        } r_outstanding[15:12];

        field {
            name = "w_outstanding";
            desc = "Number of write request outstandings. The value range is [1, 8].";
            sw = rw;
            hw = r;
            reset = 0x0;
        } w_outstanding[7:4];
    } AXI_CFG @ 0x10;

    reg {
        name = "MAC configuration register";
        desc = "MAC_CFG is an MAC configuration register.

Data sheet 10.1.6 MAC_CFG (offset 0x14, printed page 10-26, `hi3516av100--Hi3516A-Hi3516D-Datasheet.txt` line 60283).";

        enum MAC_CFG_r_req_prio_enum {
            LOW_PRIORITY = 0x0 { name = "Low Priority"; desc = "low priority"; };
            HIGH_PRIORITY_BIT = 0x1 { name = "High Priority Bit"; desc = "high priority bit 0: SRC0 read request priority bit 1: SRC1 read request priority bit 2: reserved bit 3: reserved bit 4: reserved bit 5: reserved bit 6: reserved bit 7: reserved"; };
        };

        field {
            name = "r_req_prio";
            desc = "Read request arbitration priority.";
            sw = rw;
            hw = r;
            encode = MAC_CFG_r_req_prio_enum;
            reset = 0x0;
        } r_req_prio[15:8];

        field {
            name = "w_req_prio";
            desc = "w_req_prio";
            sw = rw;
            hw = r;
            reset = 0x0;
        } w_req_prio[7:0];
    } MAC_CFG @ 0x14;

    reg {
        name = "Channel input data selection register";
        desc = "CH_SEL is a channel input data selection register.

Data sheet 10.1.6 CH_SEL (offset 0x30, printed page 10-27, `hi3516av100--Hi3516A-Hi3516D-Datasheet.txt` line 60344).";

        enum CH_SEL_ch_sel_enum {
            CHANNEL_CONNECTS_PORT = 0 { name = "Channel Connects Port"; desc = "The channel connects to the port."; };
            CHANNEL_CONNECTS_ISP = 1 { name = "Channel Connects Isp"; desc = "The channel connects to the ISP. Other values: reserved"; };
        };

        field {
            name = "ch_sel";
            desc = "Channel input data select.";
            sw = rw;
            hw = r;
            encode = CH_SEL_ch_sel_enum;
            reset = 0x0;
        } ch_sel[2:0];
    } CH_SEL @ 0x30;

    reg {
        name = "DES input data selection register";
        desc = "DES_SEL is a DES input data selection register.

Data sheet 10.1.6 DES_SEL (offset 0x40, printed page 10-28, `hi3516av100--Hi3516A-Hi3516D-Datasheet.txt` line 60375).";

        enum DES_SEL_des_sel_enum {
            DES_CONNECTS_PORT = 0 { name = "Des Connects Port"; desc = "The DES connects to the port."; };
            DES_CONNECTS_LINE = 1 { name = "Des Connects Line"; desc = "The DES connects to LINE_BUF."; };
            DES_CONNECTS_FPN = 2 { name = "Des Connects Fpn"; desc = "The DES connects to the FPN."; };
            RESERVED = 3 { name = "Reserved"; desc = "reserved"; };
        };

        field {
            name = "des_sel";
            desc = "DES input data select.";
            sw = rw;
            hw = r;
            encode = DES_SEL_des_sel_enum;
            reset = 0x0;
        } des_sel[1:0];
    } DES_SEL @ 0x40;

    reg {
        name = "ISP input data selection register";
        desc = "ISP_SEL is an ISP input data selection register.

Data sheet 10.1.6 ISP_SEL (offset 0x50, printed page 10-28, `hi3516av100--Hi3516A-Hi3516D-Datasheet.txt` line 60400).";

        enum ISP_SEL_isp_sel_enum {
            ISP_CONNECTS_LINE = 0 { name = "Isp Connects Line"; desc = "The ISP connects to LINE_BUF."; };
            ISP_CONNECTS_SRC0 = 1 { name = "Isp Connects Src0"; desc = "The ISP connects to SRC0."; };
            ISP_CONNECTS_SRC1 = 2 { name = "Isp Connects Src1"; desc = "The ISP connects to SRC1."; };
            RESERVED = 3 { name = "Reserved"; desc = "reserved"; };
        };

        field {
            name = "isp_sel";
            desc = "ISP input data select.";
            sw = rw;
            hw = r;
            encode = ISP_SEL_isp_sel_enum;
            reset = 0x0;
        } isp_sel[1:0];
    } ISP_SEL @ 0x50;

    reg {
        name = "APB timeout register";
        desc = "APB_TIMEOUT is an APB timeout register.

Data sheet 10.1.6 APB_TIMEOUT (offset 0xE0, printed page 10-29, `hi3516av100--Hi3516A-Hi3516D-Datasheet.txt` line 60430).";

        enum APB_TIMEOUT_enable_f_enum {
            DISABLED = 0 { name = "Disabled"; desc = "disabled"; };
            ENABLED = 1 { name = "Enabled"; desc = "enabled"; };
        };

        field {
            name = "enable";
            desc = "Timeout enable.";
            sw = rw;
            hw = r;
            encode = APB_TIMEOUT_enable_f_enum;
            reset = 0x1;
        } enable_f[31:31];

        field {
            name = "timeout";
            desc = "Timeout threshold (in APB clock).";
            sw = rw;
            hw = r;
            reset = 0x100;
        } timeout[15:0];
    } APB_TIMEOUT @ 0xE0;

    reg {
        name = "Interrupt status register";
        desc = "VICAP_INT is an interrupt status register.

Data sheet 10.1.6 VICAP_INT (offset 0xF0, printed page 10-29, `hi3516av100--Hi3516A-Hi3516D-Datasheet.txt` line 60454).";

        enum VICAP_INT_int_isp_enum {
            NO_INTERRUPT_GENERATED = 0 { name = "No Interrupt Generated"; desc = "No interrupt is generated."; };
            INTERRUPT_GENERATED = 1 { name = "Interrupt Generated"; desc = "An interrupt is generated."; };
        };

        field {
            name = "int_isp";
            desc = "ISP interrupt status.";
            sw = r;
            hw = w;
            encode = VICAP_INT_int_isp_enum;
            reset = 0x0;
        } int_isp[16:16];

        enum VICAP_INT_int_buf_enum {
            NO_INTERRUPT_GENERATED = 0 { name = "No Interrupt Generated"; desc = "No interrupt is generated."; };
            INTERRUPT_GENERATED = 1 { name = "Interrupt Generated"; desc = "An interrupt is generated."; };
        };

        field {
            name = "int_buf";
            desc = "LINE_BUF interrupt status.";
            sw = r;
            hw = w;
            encode = VICAP_INT_int_buf_enum;
            reset = 0x0;
        } int_buf[5:5];

        enum VICAP_INT_int_src1_enum {
            NO_INTERRUPT_GENERATED = 0 { name = "No Interrupt Generated"; desc = "No interrupt is generated."; };
            INTERRUPT_GENERATED = 1 { name = "Interrupt Generated"; desc = "An interrupt is generated."; };
        };

        field {
            name = "int_src1";
            desc = "SRC1 interrupt status.";
            sw = r;
            hw = w;
            encode = VICAP_INT_int_src1_enum;
            reset = 0x0;
        } int_src1[4:4];

        enum VICAP_INT_int_src0_enum {
            NO_INTERRUPT_GENERATED = 0 { name = "No Interrupt Generated"; desc = "No interrupt is generated."; };
            INTERRUPT_GENERATED = 1 { name = "Interrupt Generated"; desc = "An interrupt is generated."; };
        };

        field {
            name = "int_src0";
            desc = "SRC0 interrupt status.";
            sw = r;
            hw = w;
            encode = VICAP_INT_int_src0_enum;
            reset = 0x0;
        } int_src0[3:3];

        enum VICAP_INT_int_des0_enum {
            NO_INTERRUPT_GENERATED = 0 { name = "No Interrupt Generated"; desc = "No interrupt is generated."; };
            INTERRUPT_GENERATED = 1 { name = "Interrupt Generated"; desc = "An interrupt is generated."; };
        };

        field {
            name = "int_des0";
            desc = "DES0 interrupt status.";
            sw = r;
            hw = w;
            encode = VICAP_INT_int_des0_enum;
            reset = 0x0;
        } int_des0[2:2];

        enum VICAP_INT_int_ch_enum {
            NO_INTERRUPT_GENERATED = 0 { name = "No Interrupt Generated"; desc = "No interrupt is generated."; };
            INTERRUPT_GENERATED = 1 { name = "Interrupt Generated"; desc = "An interrupt is generated."; };
        };

        field {
            name = "int_ch";
            desc = "Channel interrupt status.";
            sw = r;
            hw = w;
            encode = VICAP_INT_int_ch_enum;
            reset = 0x0;
        } int_ch[1:1];

        enum VICAP_INT_int_pt_enum {
            NO_INTERRUPT_GENERATED = 0 { name = "No Interrupt Generated"; desc = "No interrupt is generated."; };
            INTERRUPT_GENERATED = 1 { name = "Interrupt Generated"; desc = "An interrupt is generated."; };
        };

        field {
            name = "int_pt";
            desc = "Port interrupt status.";
            sw = r;
            hw = w;
            encode = VICAP_INT_int_pt_enum;
            reset = 0x0;
        } int_pt[0:0];
    } VICAP_INT @ 0xF0;

    reg {
        name = "Interrupt mask register";
        desc = "VICAP_INT_MASK is an interrupt mask register.

Data sheet 10.1.6 VICAP_INT_MASK (offset 0xF8, printed page 10-30, `hi3516av100--Hi3516A-Hi3516D-Datasheet.txt` line 60507).";

        enum VICAP_INT_MASK_int_isp_enum {
            MASKED = 0 { name = "Masked"; desc = "masked"; };
            ENABLED = 1 { name = "Enabled"; desc = "enabled"; };
        };

        field {
            name = "int_isp";
            desc = "ISP interrupt enable.";
            sw = rw;
            hw = r;
            encode = VICAP_INT_MASK_int_isp_enum;
            reset = 0x0;
        } int_isp[16:16];

        enum VICAP_INT_MASK_int_buf_enum {
            MASKED = 0 { name = "Masked"; desc = "masked"; };
            ENABLED = 1 { name = "Enabled"; desc = "enabled"; };
        };

        field {
            name = "int_buf";
            desc = "LINE_BUF interrupt enable.";
            sw = rw;
            hw = r;
            encode = VICAP_INT_MASK_int_buf_enum;
            reset = 0x0;
        } int_buf[5:5];

        enum VICAP_INT_MASK_int_src1_enum {
            MASKED = 0 { name = "Masked"; desc = "masked"; };
            ENABLED = 1 { name = "Enabled"; desc = "enabled"; };
        };

        field {
            name = "int_src1";
            desc = "SRC1 interrupt enable.";
            sw = rw;
            hw = r;
            encode = VICAP_INT_MASK_int_src1_enum;
            reset = 0x0;
        } int_src1[4:4];

        enum VICAP_INT_MASK_int_src0_enum {
            MASKED = 0 { name = "Masked"; desc = "masked"; };
            ENABLED = 1 { name = "Enabled"; desc = "enabled"; };
        };

        field {
            name = "int_src0";
            desc = "SRC0 interrupt enable.";
            sw = rw;
            hw = r;
            encode = VICAP_INT_MASK_int_src0_enum;
            reset = 0x0;
        } int_src0[3:3];

        enum VICAP_INT_MASK_int_des0_enum {
            MASKED = 0 { name = "Masked"; desc = "masked"; };
            ENABLED = 1 { name = "Enabled"; desc = "enabled"; };
        };

        field {
            name = "int_des0";
            desc = "DES0 interrupt enable.";
            sw = rw;
            hw = r;
            encode = VICAP_INT_MASK_int_des0_enum;
            reset = 0x0;
        } int_des0[2:2];

        enum VICAP_INT_MASK_int_ch_enum {
            MASKED = 0 { name = "Masked"; desc = "masked"; };
            ENABLED = 1 { name = "Enabled"; desc = "enabled"; };
        };

        field {
            name = "int_ch";
            desc = "Channel interrupt enable.";
            sw = rw;
            hw = r;
            encode = VICAP_INT_MASK_int_ch_enum;
            reset = 0x0;
        } int_ch[1:1];

        enum VICAP_INT_MASK_int_pt_enum {
            MASKED = 0 { name = "Masked"; desc = "masked"; };
            ENABLED = 1 { name = "Enabled"; desc = "enabled"; };
        };

        field {
            name = "int_pt";
            desc = "Port interrupt enable.";
            sw = rw;
            hw = r;
            encode = VICAP_INT_MASK_int_pt_enum;
            reset = 0x0;
        } int_pt[0:0];
    } VICAP_INT_MASK @ 0xF8;

    reg {
        name = "Port mode register";
        desc = "PT_INTF_MOD is a port mode register.

Data sheet 10.1.6 PT_INTF_MOD (offset 0x100, printed page 10-31, `hi3516av100--Hi3516A-Hi3516D-Datasheet.txt` line 60560).";

        enum PT_INTF_MOD_enable_f_enum {
            DISABLED = 0 { name = "Disabled"; desc = "disabled"; };
            ENABLED = 1 { name = "Enabled"; desc = "enabled"; };
        };

        field {
            name = "enable";
            desc = "Port enable.";
            sw = rw;
            hw = r;
            encode = PT_INTF_MOD_enable_f_enum;
            reset = 0x0;
        } enable_f[31:31];

        enum PT_INTF_MOD_mode_enum {
            EXTERNAL_SYNC = 0 { name = "External Sync"; desc = "external sync"; };
            BT_656 = 1 { name = "Bt 656"; desc = "BT.656"; };
        };

        field {
            name = "mode";
            desc = "Timing mode.";
            sw = rw;
            hw = r;
            encode = PT_INTF_MOD_mode_enum;
            reset = 0x0;
        } mode[0:0];
    } PT_INTF_MOD @ 0x100;

    reg {
        name = "Component 0 offset register";
        desc = "PT_OFFSET0 is a component 0 offset register.

Data sheet 10.1.6 PT_OFFSET0 (offset 0x110, printed page 10-32, `hi3516av100--Hi3516A-Hi3516D-Datasheet.txt` line 60591).";

        field {
            name = "mask";
            desc = "Component 0 mask.";
            sw = rw;
            hw = r;
            reset = 0xFFF0;
        } mask_f[31:16];

        enum PT_OFFSET0_rev_enum {
            NO = 0 { name = "No"; desc = "no"; };
            YES = 1 { name = "Yes"; desc = "yes"; };
        };

        field {
            name = "rev";
            desc = "Whether the data line is reversed.";
            sw = rw;
            hw = r;
            encode = PT_OFFSET0_rev_enum;
            reset = 0x0;
        } rev[15:15];

        field {
            name = "offset";
            desc = "Component 0 offset.";
            sw = rw;
            hw = r;
            reset = 0x0;
        } offset[5:0];
    } PT_OFFSET0 @ 0x110;

    reg {
        name = "Component 1 offset register";
        desc = "PT_OFFSET1 is a component 1 offset register.

Data sheet 10.1.6 PT_OFFSET1 (offset 0x114, printed page 10-32, `hi3516av100--Hi3516A-Hi3516D-Datasheet.txt` line 60614).";

        field {
            name = "mask";
            desc = "Component 1 mask.";
            sw = rw;
            hw = r;
            reset = 0xFFF0;
        } mask_f[31:16];

        enum PT_OFFSET1_rev_enum {
            NO = 0 { name = "No"; desc = "no"; };
            YES = 1 { name = "Yes"; desc = "yes"; };
        };

        field {
            name = "rev";
            desc = "Whether the data line is reversed.";
            sw = rw;
            hw = r;
            encode = PT_OFFSET1_rev_enum;
            reset = 0x0;
        } rev[15:15];

        field {
            name = "offset";
            desc = "Component 1 offset.";
            sw = rw;
            hw = r;
            reset = 0x10;
        } offset[5:0];
    } PT_OFFSET1 @ 0x114;

    reg {
        name = "Component 2 offset register";
        desc = "PT_OFFSET2 is a component 2 offset register. Huawei Proprietary and Confidential Hi3516A/Hi3516D Professional HD IP Camera SoC

Data sheet 10.1.6 PT_OFFSET2 (offset 0x118, printed page 10-33, `hi3516av100--Hi3516A-Hi3516D-Datasheet.txt` line 60646).";

        field {
            name = "mask";
            desc = "Component 2 mask.";
            sw = rw;
            hw = r;
            reset = 0xFFF0;
        } mask_f[31:16];

        enum PT_OFFSET2_rev_enum {
            NO = 0 { name = "No"; desc = "no"; };
            YES = 1 { name = "Yes"; desc = "yes"; };
        };

        field {
            name = "rev";
            desc = "Whether the data line is reversed.";
            sw = rw;
            hw = r;
            encode = PT_OFFSET2_rev_enum;
            reset = 0x0;
        } rev[15:15];

        field {
            name = "offset";
            desc = "Component 2 offset.";
            sw = rw;
            hw = r;
            reset = 0x20;
        } offset[5:0];
    } PT_OFFSET2 @ 0x118;

    reg {
        name = "PT_BT656_CFG";
        desc = "PT_BT656_CFG is a BT.656 configuration register.

Data sheet 10.1.6 PT_BT656_CFG (offset 0x120, printed page 10-33, `hi3516av100--Hi3516A-Hi3516D-Datasheet.txt` line 60669).";

        enum PT_BT656_CFG_enable_f_enum {
            DISABLED = 0 { name = "Disabled"; desc = "disabled"; };
            ENABLED = 1 { name = "Enabled"; desc = "enabled"; };
        };

        field {
            name = "enable";
            desc = "BT.656 enable.";
            sw = rw;
            hw = r;
            encode = PT_BT656_CFG_enable_f_enum;
            reset = 0x0;
        } enable_f[31:31];

        enum PT_BT656_CFG_field_inv_enum {
            NOT_REVERSED = 0 { name = "Not Reversed"; desc = "not reversed"; };
            REVERSED = 1 { name = "Reversed"; desc = "reversed"; };
        };

        field {
            name = "field_inv";
            desc = "Reverse control.";
            sw = rw;
            hw = r;
            encode = PT_BT656_CFG_field_inv_enum;
            reset = 0x0;
        } field_inv[10:10];

        enum PT_BT656_CFG_vsync_inv_enum {
            NOT_REVERSED = 0 { name = "Not Reversed"; desc = "not reversed"; };
            REVERSED = 1 { name = "Reversed"; desc = "reversed"; };
        };

        field {
            name = "vsync_inv";
            desc = "Reverse control.";
            sw = rw;
            hw = r;
            encode = PT_BT656_CFG_vsync_inv_enum;
            reset = 0x1;
        } vsync_inv[9:9];

        enum PT_BT656_CFG_hsync_inv_enum {
            NOT_REVERSED = 0 { name = "Not Reversed"; desc = "not reversed"; };
            REVERSED = 1 { name = "Reversed"; desc = "reversed"; };
        };

        field {
            name = "hsync_inv";
            desc = "Reverse control.";
            sw = rw;
            hw = r;
            encode = PT_BT656_CFG_hsync_inv_enum;
            reset = 0x1;
        } hsync_inv[8:8];

        field {
            name = "mode";
            desc = "Mode select. mode[0] 0: hsync is not an active signal. 1: hsync is an active signal. mode[1] 0: The hsync output is active low. 1: The hsync output is active high. mode[3:2] 00: Component 0 is parsed. 01: Component 1 is parsed. 10: Component 2 is parsed. 11: reserved";
            sw = rw;
            hw = r;
            reset = 0x3;
        } mode[3:0];
    } PT_BT656_CFG @ 0x120;

    reg {
        name = "Timing configuration register";
        desc = "PT_UNIFY_TIMING_CFG is a timing configuration register.

Data sheet 10.1.6 PT_UNIFY_TIMING_CFG (offset 0x130, printed page 10-34, `hi3516av100--Hi3516A-Hi3516D-Datasheet.txt` line 60729).";

        enum PT_UNIFY_TIMING_CFG_field_inv_enum {
            NOT_INVERTED = 0 { name = "Not Inverted"; desc = "not inverted"; };
            INVERTED = 1 { name = "Inverted"; desc = "inverted"; };
        };

        field {
            name = "field_inv";
            desc = "Field inverse (level-1 field processing).";
            sw = rw;
            hw = r;
            encode = PT_UNIFY_TIMING_CFG_field_inv_enum;
            reset = 0x0;
        } field_inv[26:26];

        enum PT_UNIFY_TIMING_CFG_field_sel_enum {
            INPUT_FIELD = 0 { name = "Input Field"; desc = "input field"; };
            INPUT_VSYNC = 1 { name = "Input Vsync"; desc = "input vsync"; };
            DETECTED_BASED_RELATIONSHIP = 2 { name = "Detected Based Relationship"; desc = "detected based on the relationship between vsync and hsync"; };
            FIXED_AT_0 = 3 { name = "Fixed At 0"; desc = "fixed at 0"; };
        };

        field {
            name = "field_sel";
            desc = "Field source select (level-0 field processing).";
            sw = rw;
            hw = r;
            encode = PT_UNIFY_TIMING_CFG_field_sel_enum;
            reset = 0x0;
        } field_sel[25:24];

        enum PT_UNIFY_TIMING_CFG_vsync_mode_enum {
            NOT_PROCESSED = 0 { name = "Not Processed"; desc = "not processed"; };
            DETECT_RISING_EDGE = 1 { name = "Detect Rising Edge"; desc = "detect the rising edge"; };
            DETECT_RISING_EDGE_2 = 2 { name = "Detect Rising Edge 2"; desc = "detect the rising edge and falling edge"; };
            RESERVED = 3 { name = "Reserved"; desc = "reserved"; };
        };

        field {
            name = "vsync_mode";
            desc = "vsync processing mode (level-2 vsync processing).";
            sw = rw;
            hw = r;
            encode = PT_UNIFY_TIMING_CFG_vsync_mode_enum;
            reset = 0x0;
        } vsync_mode[20:19];

        enum PT_UNIFY_TIMING_CFG_vsync_inv_enum {
            NOT_INVERTED = 0 { name = "Not Inverted"; desc = "not inverted"; };
            INVERTED = 1 { name = "Inverted"; desc = "inverted"; };
        };

        field {
            name = "vsync_inv";
            desc = "vsync inversion (level-1 vsync processing).";
            sw = rw;
            hw = r;
            encode = PT_UNIFY_TIMING_CFG_vsync_inv_enum;
            reset = 0x0;
        } vsync_inv[18:18];

        enum PT_UNIFY_TIMING_CFG_vsync_sel_enum {
            INPUT_VSYNC = 0 { name = "Input Vsync"; desc = "input vsync"; };
            INPUT_FIELD = 1 { name = "Input Field"; desc = "input field"; };
            FIXED_AT_0 = 2 { name = "Fixed At 0"; desc = "fixed at 0"; };
            RESERVED = 3 { name = "Reserved"; desc = "reserved"; };
        };

        field {
            name = "vsync_sel";
            desc = "vsync source select (level-0 vsync processing).";
            sw = rw;
            hw = r;
            encode = PT_UNIFY_TIMING_CFG_vsync_sel_enum;
            reset = 0x0;
        } vsync_sel[17:16];

        enum PT_UNIFY_TIMING_CFG_hsync_mode_enum {
            NOT_PROCESSED = 0 { name = "Not Processed"; desc = "not processed"; };
            DETECT_RISING_EDGE = 1 { name = "Detect Rising Edge"; desc = "detect the rising edge"; };
        };

        field {
            name = "hsync_mode";
            desc = "hsync processing mode (level-3 hsync processing).";
            sw = rw;
            hw = r;
            encode = PT_UNIFY_TIMING_CFG_hsync_mode_enum;
            reset = 0x0;
        } hsync_mode[14:13];

        enum PT_UNIFY_TIMING_CFG_hsync_and_enum {
            NOT_PROCESSED = 0 { name = "Not Processed"; desc = "not processed"; };
            ANDED = 1 { name = "Anded"; desc = "ANDed"; };
            EXCLUSIVE_ORED = 2 { name = "Exclusive Ored"; desc = "exclusive ORed"; };
            RESERVED = 3 { name = "Reserved"; desc = "reserved"; };
        };

        field {
            name = "hsync_and";
            desc = "Whether hsync is operated with the result of level-1 vsync processing (level-2 hsync processing).";
            sw = rw;
            hw = r;
            encode = PT_UNIFY_TIMING_CFG_hsync_and_enum;
            reset = 0x0;
        } hsync_and[12:11];

        enum PT_UNIFY_TIMING_CFG_hsync_inv_enum {
            NOT_INVERTED = 0 { name = "Not Inverted"; desc = "not inverted"; };
            INVERTED = 1 { name = "Inverted"; desc = "inverted"; };
        };

        field {
            name = "hsync_inv";
            desc = "hsync inversion (level-1 hsync processing).";
            sw = rw;
            hw = r;
            encode = PT_UNIFY_TIMING_CFG_hsync_inv_enum;
            reset = 0x0;
        } hsync_inv[10:10];

        enum PT_UNIFY_TIMING_CFG_hsync_sel_enum {
            INPUT_HSYNC = 0 { name = "Input Hsync"; desc = "input hsync"; };
            INPUT_DE = 1 { name = "Input De"; desc = "input de"; };
            FIXED_AT_0 = 2 { name = "Fixed At 0"; desc = "fixed at 0"; };
            RESERVED = 3 { name = "Reserved"; desc = "reserved"; };
        };

        field {
            name = "hsync_sel";
            desc = "hsync source select (level-0 hsync processing).";
            sw = rw;
            hw = r;
            encode = PT_UNIFY_TIMING_CFG_hsync_sel_enum;
            reset = 0x0;
        } hsync_sel[9:8];

        enum PT_UNIFY_TIMING_CFG_de_inv_enum {
            NOT_INVERTED = 0 { name = "Not Inverted"; desc = "not inverted"; };
            INVERTED = 1 { name = "Inverted"; desc = "inverted"; };
        };

        field {
            name = "de_inv";
            desc = "de inversion (level-1 de processing).";
            sw = rw;
            hw = r;
            encode = PT_UNIFY_TIMING_CFG_de_inv_enum;
            reset = 0x0;
        } de_inv[2:2];

        enum PT_UNIFY_TIMING_CFG_de_sel_enum {
            INPUT_DE = 0 { name = "Input De"; desc = "input de"; };
            RESULT_LEVEL_2 = 1 { name = "Result Level 2"; desc = "result of level-2 hsync processing"; };
            FIXED_AT_1 = 2 { name = "Fixed At 1"; desc = "fixed at 1"; };
            FIXED_AT_0 = 3 { name = "Fixed At 0"; desc = "fixed at 0"; };
        };

        field {
            name = "de_sel";
            desc = "de source select (level-0 de processing).";
            sw = rw;
            hw = r;
            encode = PT_UNIFY_TIMING_CFG_de_sel_enum;
            reset = 0x0;
        } de_sel[1:0];
    } PT_UNIFY_TIMING_CFG @ 0x130;

    reg {
        name = "Timing recovery module configuration register";
        desc = "PT_GEN_TIMING_CFG is a timing recovery module configuration register.

Data sheet 10.1.6 PT_GEN_TIMING_CFG (offset 0x134, printed page 10-36, `hi3516av100--Hi3516A-Hi3516D-Datasheet.txt` line 60823).";

        enum PT_GEN_TIMING_CFG_enable_f_enum {
            DISABLED = 0 { name = "Disabled"; desc = "disabled"; };
            ENABLED = 1 { name = "Enabled"; desc = "enabled"; };
        };

        field {
            name = "enable";
            desc = "Timing recovery enable (timings are recovered based on timing parameters).";
            sw = rw;
            hw = r;
            encode = PT_GEN_TIMING_CFG_enable_f_enum;
            reset = 0x0;
        } enable_f[31:31];

        enum PT_GEN_TIMING_CFG_mode_enum {
            TIMINGS_GENERATED_BASED = 0 { name = "Timings Generated Based"; desc = "Timings are generated based on the input valid signal of PT."; };
            TIMINGS_INTERNALLY_CALCULATED = 1 { name = "Timings Internally Calculated"; desc = "Timings are internally calculated and generated."; };
        };

        field {
            name = "mode";
            desc = "Timing recovery mode (timings are recovered based on timing parameters).";
            sw = rw;
            hw = r;
            encode = PT_GEN_TIMING_CFG_mode_enum;
            reset = 0x0;
        } mode[30:30];

        enum PT_GEN_TIMING_CFG_vsync_mode_enum {
            NOT_RECOVERED = 0 { name = "Not Recovered"; desc = "not recovered"; };
            RECOVERED = 1 { name = "Recovered"; desc = "recovered"; };
        };

        field {
            name = "vsync_mode";
            desc = "vsync recovery.";
            sw = rw;
            hw = r;
            encode = PT_GEN_TIMING_CFG_vsync_mode_enum;
            reset = 0x0;
        } vsync_mode[2:2];

        enum PT_GEN_TIMING_CFG_hsync_mode_enum {
            NOT_RECOVERED = 0 { name = "Not Recovered"; desc = "not recovered"; };
            RECOVERED = 1 { name = "Recovered"; desc = "recovered"; };
        };

        field {
            name = "hsync_mode";
            desc = "hsync recovery.";
            sw = rw;
            hw = r;
            encode = PT_GEN_TIMING_CFG_hsync_mode_enum;
            reset = 0x0;
        } hsync_mode[1:1];
    } PT_GEN_TIMING_CFG @ 0x134;

    reg {
        name = "Data configuration register";
        desc = "PT_UNIFY_DATA_CFG is a data configuration register.

Data sheet 10.1.6 PT_UNIFY_DATA_CFG (offset 0x140, printed page 10-37, `hi3516av100--Hi3516A-Hi3516D-Datasheet.txt` line 60870).";

        enum PT_UNIFY_DATA_CFG_enable_f_enum {
            DISABLED = 0 { name = "Disabled"; desc = "disabled"; };
            ENABLED = 1 { name = "Enabled"; desc = "enabled"; };
        };

        field {
            name = "enable";
            desc = "Data separation enable.";
            sw = rw;
            hw = r;
            encode = PT_UNIFY_DATA_CFG_enable_f_enum;
            reset = 0x0;
        } enable_f[31:31];

        enum PT_UNIFY_DATA_CFG_uv_seq_enum {
            CBCR = 0 { name = "Cbcr"; desc = "CbCr"; };
            CRCB = 1 { name = "Crcb"; desc = "CrCb"; };
        };

        field {
            name = "uv_seq";
            desc = "CbCr sequence.";
            sw = rw;
            hw = r;
            encode = PT_UNIFY_DATA_CFG_uv_seq_enum;
            reset = 0x0;
        } uv_seq[3:3];

        enum PT_UNIFY_DATA_CFG_yc_seq_enum {
            CY = 0 { name = "Cy"; desc = "CY"; };
            YC = 1 { name = "Yc"; desc = "YC"; };
        };

        field {
            name = "yc_seq";
            desc = "YC sequence.";
            sw = rw;
            hw = r;
            encode = PT_UNIFY_DATA_CFG_yc_seq_enum;
            reset = 0x0;
        } yc_seq[2:2];

        enum PT_UNIFY_DATA_CFG_comp_num_enum {
            COMPONENT_1 = 0 { name = "Component 1"; desc = "component 1"; };
            COMPONENT_2 = 1 { name = "Component 2"; desc = "component 2"; };
            COMPONENT_3 = 2 { name = "Component 3"; desc = "component 3"; };
            RESERVED = 3 { name = "Reserved"; desc = "reserved"; };
        };

        field {
            name = "comp_num";
            desc = "Data component select.";
            sw = rw;
            hw = r;
            encode = PT_UNIFY_DATA_CFG_comp_num_enum;
            reset = 0x0;
        } comp_num[1:0];
    } PT_UNIFY_DATA_CFG @ 0x140;

    reg {
        name = "YUV444 configuration register";
        desc = "PT_YUV444_CFG is a YUV444 configuration register. Huawei Proprietary and Confidential Hi3516A/Hi3516D Professional HD IP Camera SoC

Data sheet 10.1.6 PT_YUV444_CFG (offset 0x150, printed page 10-38, `hi3516av100--Hi3516A-Hi3516D-Datasheet.txt` line 60917).";

        enum PT_YUV444_CFG_enable_f_enum {
            DISABLED = 0 { name = "Disabled"; desc = "disabled"; };
            ENABLED = 1 { name = "Enabled"; desc = "enabled"; };
        };

        field {
            name = "enable";
            desc = "YUV enable for converting YUV422 signals into YUV444 signals.";
            sw = rw;
            hw = r;
            encode = PT_YUV444_CFG_enable_f_enum;
            reset = 0x0;
        } enable_f[31:31];
    } PT_YUV444_CFG @ 0x150;

    reg {
        name = "Horizontal front blanking width register";
        desc = "PT_INTF_HFB is a horizontal front blanking width register.

Data sheet 10.1.6 PT_INTF_HFB (offset 0x180, printed page 10-38, `hi3516av100--Hi3516A-Hi3516D-Datasheet.txt` line 60942).";

        field {
            name = "hfb";
            desc = "Horizontal front blanking width.";
            sw = rw;
            hw = r;
            reset = 0x10;
        } hfb[15:0];
    } PT_INTF_HFB @ 0x180;

    reg {
        name = "Horizontal active width register";
        desc = "PT_INTF_HACT is a horizontal active width register. Huawei Proprietary and Confidential Hi3516A/Hi3516D Professional HD IP Camera SoC

Data sheet 10.1.6 PT_INTF_HACT (offset 0x184, printed page 10-39, `hi3516av100--Hi3516A-Hi3516D-Datasheet.txt` line 60971).";

        field {
            name = "hact";
            desc = "Horizontal active width (in clock cycle).";
            sw = rw;
            hw = r;
            reset = 0x10;
        } hact[31:0];
    } PT_INTF_HACT @ 0x184;

    reg {
        name = "Horizontal back blanking width register";
        desc = "PT_INTF_HBB is a horizontal back blanking width register.

Data sheet 10.1.6 PT_INTF_HBB (offset 0x188, printed page 10-39, `hi3516av100--Hi3516A-Hi3516D-Datasheet.txt` line 60989).";

        field {
            name = "hbb";
            desc = "Horizontal back blanking width.";
            sw = rw;
            hw = r;
            reset = 0x10;
        } hbb[15:0];
    } PT_INTF_HBB @ 0x188;

    reg {
        name = "Vertical front blanking width register";
        desc = "PT_INTF_VFB is a vertical front blanking width register.

Data sheet 10.1.6 PT_INTF_VFB (offset 0x18C, printed page 10-39, `hi3516av100--Hi3516A-Hi3516D-Datasheet.txt` line 61008).";

        field {
            name = "vfb";
            desc = "Vertical front blanking width.";
            sw = rw;
            hw = r;
            reset = 0x10;
        } vfb[15:0];
    } PT_INTF_VFB @ 0x18C;

    reg {
        name = "Vertical active width register";
        desc = "PT_INTF_VACT is a vertical active width register.

Data sheet 10.1.6 PT_INTF_VACT (offset 0x190, printed page 10-40, `hi3516av100--Hi3516A-Hi3516D-Datasheet.txt` line 61033).";

        field {
            name = "vact";
            desc = "Vertical active width.";
            sw = rw;
            hw = r;
            reset = 0x10;
        } vact[15:0];
    } PT_INTF_VACT @ 0x190;

    reg {
        name = "Vertical back blanking width register";
        desc = "PT_INTF_VBB is a vertical back blanking width register.

Data sheet 10.1.6 PT_INTF_VBB (offset 0x194, printed page 10-40, `hi3516av100--Hi3516A-Hi3516D-Datasheet.txt` line 61052).";

        field {
            name = "vbb";
            desc = "Vertical back blanking width.";
            sw = rw;
            hw = r;
            reset = 0x10;
        } vbb[15:0];
    } PT_INTF_VBB @ 0x194;

    reg {
        name = "Vertical bottom front blanking width register";
        desc = "PT_INTF_VBFB is a vertical bottom front blanking width register.

Data sheet 10.1.6 PT_INTF_VBFB (offset 0x198, printed page 10-40, `hi3516av100--Hi3516A-Hi3516D-Datasheet.txt` line 61071).";

        field {
            name = "vbfb";
            desc = "Vertical bottom front blanking width.";
            sw = rw;
            hw = r;
            reset = 0x10;
        } vbfb[15:0];
    } PT_INTF_VBFB @ 0x198;

    reg {
        name = "Vertical bottom active width register";
        desc = "PT_INTF_VBACT is a vertical bottom active width register.

Data sheet 10.1.6 PT_INTF_VBACT (offset 0x19C, printed page 10-41, `hi3516av100--Hi3516A-Hi3516D-Datasheet.txt` line 61100).";

        field {
            name = "vbact";
            desc = "Vertical bottom active width.";
            sw = rw;
            hw = r;
            reset = 0x10;
        } vbact[15:0];
    } PT_INTF_VBACT @ 0x19C;

    reg {
        name = "Vertical bottom back blanking width register";
        desc = "PT_INTF_VBBB is a vertical bottom back blanking width register.

Data sheet 10.1.6 PT_INTF_VBBB (offset 0x1A0, printed page 10-41, `hi3516av100--Hi3516A-Hi3516D-Datasheet.txt` line 61119).";

        field {
            name = "vbbb";
            desc = "Vertical bottom back blanking width.";
            sw = rw;
            hw = r;
            reset = 0x10;
        } vbbb[15:0];
    } PT_INTF_VBBB @ 0x1A0;

    reg {
        name = "ID configuration register";
        desc = "PT_ID_CFG is an ID configuration register. Huawei Proprietary and Confidential Hi3516A/Hi3516D Professional HD IP Camera SoC

Data sheet 10.1.6 PT_ID_CFG (offset 0x1A4, printed page 10-42, `hi3516av100--Hi3516A-Hi3516D-Datasheet.txt` line 61148).";

        enum PT_ID_CFG_enable_f_enum {
            DISABLED = 0 { name = "Disabled"; desc = "disabled"; };
            ENABLED = 1 { name = "Enabled"; desc = "enabled"; };
        };

        field {
            name = "enable";
            desc = "ID generation enable.";
            sw = rw;
            hw = r;
            encode = PT_ID_CFG_enable_f_enum;
            reset = 0x0;
        } enable_f[31:31];

        enum PT_ID_CFG_mode_enum {
            AUTOMATIC_MODE = 0 { name = "Automatic Mode"; desc = "automatic mode (the ID automatically increases for each frame)"; };
            NON_AUTOMATIC_MODE = 1 { name = "Non Automatic Mode"; desc = "non-automatic mode (the ID depends on the configured value)"; };
        };

        field {
            name = "mode";
            desc = "ID generation mode.";
            sw = rw;
            hw = r;
            encode = PT_ID_CFG_mode_enum;
            reset = 0x0;
        } mode[30:30];

        field {
            name = "reset";
            desc = "In automatic mode, setting this field to 1 restores the ID of the next frame to the initial value. This field is automatically cleared after restoration.";
            sw = w;
            hw = r;
            reset = 0x0;
        } reset_f[29:29];

        field {
            name = "id_det";
            desc = "ID of the frame whose width and height are detected.";
            sw = rw;
            hw = r;
            reset = 0x0;
        } id_det[5:4];

        field {
            name = "id_max";
            desc = "Maximum ID in automatic mode.";
            sw = rw;
            hw = r;
            reset = 0x0;
        } id_max[3:2];

        field {
            name = "id";
            desc = "Initial ID in automatic mode or generated ID in non-automatic mode.";
            sw = rw;
            hw = r;
            reset = 0x0;
        } id[1:0];
    } PT_ID_CFG @ 0x1A4;

    reg {
        name = "Flash configuration register";
        desc = "PT_FLASH_CFG is a flash configuration register. Huawei Proprietary and Confidential Hi3516A/Hi3516D Professional HD IP Camera SoC

Data sheet 10.1.6 PT_FLASH_CFG (offset 0x1B0, printed page 10-43, `hi3516av100--Hi3516A-Hi3516D-Datasheet.txt` line 61192).";

        enum PT_FLASH_CFG_id_sel_enum {
            TRIGGERED_USING_START = 1 { name = "Triggered Using Start"; desc = "triggered by using the start interrupt of the frame whose ID is 0"; };
            TRIGGERED_USING_START_2 = 2 { name = "Triggered Using Start 2"; desc = "triggered by using the start interrupt of the frame whose ID is 1"; };
            TRIGGERED_USING_START_3 = 4 { name = "Triggered Using Start 3"; desc = "triggered by using the start interrupt of the frame whose ID is 2"; };
            TRIGGERED_USING_START_4 = 8 { name = "Triggered Using Start 4"; desc = "triggered by using the start interrupt of the frame whose ID is 3"; };
        };

        field {
            name = "id_sel";
            desc = "Trigger frame ID.";
            sw = rw;
            hw = r;
            encode = PT_FLASH_CFG_id_sel_enum;
            reset = 0x1;
        } id_sel[31:28];

        enum PT_FLASH_CFG_shutter_times_enum {
            TWICE = 0 { name = "Twice"; desc = "twice"; };
            ONCE = 1 { name = "Once"; desc = "once"; };
        };

        field {
            name = "shutter_times";
            desc = "Shutter pulse times.";
            sw = rw;
            hw = r;
            encode = PT_FLASH_CFG_shutter_times_enum;
            reset = 0x0;
        } shutter_times[18:18];

        enum PT_FLASH_CFG_shutter_phase_enum {
            NOT_REVERSED = 0 { name = "Not Reversed"; desc = "not reversed"; };
            REVERSED = 1 { name = "Reversed"; desc = "reversed"; };
        };

        field {
            name = "shutter_phase";
            desc = "Shutter signal reverse.";
            sw = rw;
            hw = r;
            encode = PT_FLASH_CFG_shutter_phase_enum;
            reset = 0x0;
        } shutter_phase[17:17];

        field {
            name = "shutter_en";
            desc = "Shutter trigger enable. This field is automatically cleared.";
            sw = w;
            hw = r;
            reset = 0x0;
        } shutter_en[16:16];

        enum PT_FLASH_CFG_flash_phase_enum {
            NOT_REVERSED = 0 { name = "Not Reversed"; desc = "not reversed"; };
            REVERSED = 1 { name = "Reversed"; desc = "reversed"; };
        };

        field {
            name = "flash_phase";
            desc = "Flash signal reverse.";
            sw = rw;
            hw = r;
            encode = PT_FLASH_CFG_flash_phase_enum;
            reset = 0x0;
        } flash_phase[1:1];

        field {
            name = "flash_en";
            desc = "Flash trigger enable. This field is automatically cleared.";
            sw = w;
            hw = r;
            reset = 0x0;
        } flash_en[0:0];
    } PT_FLASH_CFG @ 0x1B0;

    reg {
        name = "Flash timing 0 width register";
        desc = "PT_FLASH_CYC0 is a flash timing 0 width register. Huawei Proprietary and Confidential Hi3516A/Hi3516D Professional HD IP Camera SoC

Data sheet 10.1.6 PT_FLASH_CYC0 (offset 0x1C0, printed page 10-44, `hi3516av100--Hi3516A-Hi3516D-Datasheet.txt` line 61247).";

        field {
            name = "cyc";
            desc = "Duration of flash timing 0 (in PT clock). The configured value is the actual value minus 1.";
            sw = rw;
            hw = r;
            reset = 0x0;
        } cyc[31:0];
    } PT_FLASH_CYC0 @ 0x1C0;

    reg {
        name = "Flash timing 1 width register";
        desc = "PT_FLASH_CYC1 is a flash timing 1 width register.

Data sheet 10.1.6 PT_FLASH_CYC1 (offset 0x1C4, printed page 10-44, `hi3516av100--Hi3516A-Hi3516D-Datasheet.txt` line 61267).";

        field {
            name = "cyc";
            desc = "Duration of flash timing 1 (in PT clock). The configured value is the actual value minus 1.";
            sw = rw;
            hw = r;
            reset = 0x0;
        } cyc[31:0];
    } PT_FLASH_CYC1 @ 0x1C4;

    reg {
        name = "Shutter timing 0 width register";
        desc = "PT_SHUTTER_CYC0 is a shutter timing 0 width register.

Data sheet 10.1.6 PT_SHUTTER_CYC0 (offset 0x1D0, printed page 10-44, `hi3516av100--Hi3516A-Hi3516D-Datasheet.txt` line 61287).";

        field {
            name = "cyc";
            desc = "Duration of shutter timing 0 (in PT clock). The configured value is the actual value minus 1.";
            sw = rw;
            hw = r;
            reset = 0x0;
        } cyc[31:0];
    } PT_SHUTTER_CYC0 @ 0x1D0;

    reg {
        name = "Shutter timing 1 width register";
        desc = "PT_SHUTTER_CYC1 is a shutter timing 1 width register.

Data sheet 10.1.6 PT_SHUTTER_CYC1 (offset 0x1D4, printed page 10-45, `hi3516av100--Hi3516A-Hi3516D-Datasheet.txt` line 61313).";

        field {
            name = "cyc";
            desc = "Duration of shutter timing 1 (in PT clock). The configured value is the actual value minus 1.";
            sw = rw;
            hw = r;
            reset = 0x0;
        } cyc[31:0];
    } PT_SHUTTER_CYC1 @ 0x1D4;

    reg {
        name = "Shutter timing 2 width register";
        desc = "PT_SHUTTER_CYC2 is a shutter timing 2 width register.

Data sheet 10.1.6 PT_SHUTTER_CYC2 (offset 0x1D8, printed page 10-45, `hi3516av100--Hi3516A-Hi3516D-Datasheet.txt` line 61333).";

        field {
            name = "cyc";
            desc = "Duration of shutter timing 2 (in PT clock). The configured value is the actual value minus 1.";
            sw = rw;
            hw = r;
            reset = 0x0;
        } cyc[31:0];
    } PT_SHUTTER_CYC2 @ 0x1D8;

    reg {
        name = "Shutter timing 3 width register";
        desc = "PT_SHUTTER_CYC3 is a shutter timing 3 width register. Huawei Proprietary and Confidential Hi3516A/Hi3516D Professional HD IP Camera SoC

Data sheet 10.1.6 PT_SHUTTER_CYC3 (offset 0x1DC, printed page 10-46, `hi3516av100--Hi3516A-Hi3516D-Datasheet.txt` line 61363).";

        field {
            name = "cyc";
            desc = "Duration of shutter timing 3 (in PT clock). The configured value is the actual value minus 1.";
            sw = rw;
            hw = r;
            reset = 0x0;
        } cyc[31:0];
    } PT_SHUTTER_CYC3 @ 0x1DC;

    reg {
        name = "Port status register";
        desc = "PT_STATUS is a port status register.

Data sheet 10.1.6 PT_STATUS (offset 0x1E0, printed page 10-46, `hi3516av100--Hi3516A-Hi3516D-Datasheet.txt` line 61383).";

        field {
            name = "id";
            desc = "Port output ID.";
            sw = r;
            hw = w;
            reset = 0x0;
        } id[5:4];

        field {
            name = "field";
            desc = "Field output over the port.";
            sw = r;
            hw = w;
            reset = 0x0;
        } field_f[3:3];

        field {
            name = "vysnc";
            desc = "vysnc signal output over the port.";
            sw = r;
            hw = w;
            reset = 0x0;
        } vysnc[2:2];

        field {
            name = "hsync";
            desc = "hsync signal over the port.";
            sw = r;
            hw = w;
            reset = 0x0;
        } hsync[1:1];

        field {
            name = "de";
            desc = "de signal output over the port.";
            sw = r;
            hw = w;
            reset = 0x0;
        } de[0:0];
    } PT_STATUS @ 0x1E0;

    reg {
        name = "PT_BT656_STATUS";
        desc = "PT_BT656_STATUS is a BT.656 status register. Huawei Proprietary and Confidential Hi3516A/Hi3516D Professional HD IP Camera SoC

Data sheet 10.1.6 PT_BT656_STATUS (offset 0x1E4, printed page 10-47, `hi3516av100--Hi3516A-Hi3516D-Datasheet.txt` line 61418).";

        field {
            name = "seav";
            desc = "Sync code.";
            sw = r;
            hw = w;
            reset = 0x0;
        } seav[15:8];
    } PT_BT656_STATUS @ 0x1E4;

    reg {
        name = "Input picture size register";
        desc = "PT_SIZE is an input picture size register.

Data sheet 10.1.6 PT_SIZE (offset 0x1EC, printed page 10-47, `hi3516av100--Hi3516A-Hi3516D-Datasheet.txt` line 61438).";

        field {
            name = "height";
            desc = "Picture height.";
            sw = r;
            hw = w;
            reset = 0x0;
        } height[31:16];

        field {
            name = "width";
            desc = "Picture width.";
            sw = r;
            hw = w;
            reset = 0x0;
        } width[15:0];
    } PT_SIZE @ 0x1EC;

    reg {
        name = "Channel interrupt status register";
        desc = "PT_INT is a channel interrupt status register. Huawei Proprietary and Confidential Hi3516A/Hi3516D Professional HD IP Camera SoC

Data sheet 10.1.6 PT_INT (offset 0x1F0, printed page 10-48, `hi3516av100--Hi3516A-Hi3516D-Datasheet.txt` line 61467).";

        enum PT_INT_height_err_enum {
            NO_INTERRUPT_GENERATED = 0 { name = "No Interrupt Generated"; desc = "No interrupt is generated."; };
            INTERRUPT_GENERATED = 1 { name = "Interrupt Generated"; desc = "An interrupt is generated."; };
        };

        field {
            name = "height_err";
            desc = "Status of the picture height change interrupt. Writing 1 clears the interrupt.";
            sw = rw;
            hw = w;
            onwrite = woclr;
            encode = PT_INT_height_err_enum;
            reset = 0x0;
        } height_err[2:2];

        enum PT_INT_width_err_enum {
            NO_INTERRUPT_GENERATED = 0 { name = "No Interrupt Generated"; desc = "No interrupt is generated."; };
            INTERRUPT_GENERATED = 1 { name = "Interrupt Generated"; desc = "An interrupt is generated."; };
        };

        field {
            name = "width_err";
            desc = "Status of the picture width change interrupt. Writing 1 clears the interrupt.";
            sw = rw;
            hw = w;
            onwrite = woclr;
            encode = PT_INT_width_err_enum;
            reset = 0x0;
        } width_err[1:1];

        enum PT_INT_fstart_enum {
            NO_INTERRUPT_GENERATED = 0 { name = "No Interrupt Generated"; desc = "No interrupt is generated."; };
            INTERRUPT_GENERATED = 1 { name = "Interrupt Generated"; desc = "An interrupt is generated."; };
        };

        field {
            name = "fstart";
            desc = "Status of the field/frame start interrupt. Writing 1 clears the interrupt.";
            sw = rw;
            hw = w;
            onwrite = woclr;
            encode = PT_INT_fstart_enum;
            reset = 0x0;
        } fstart[0:0];
    } PT_INT @ 0x1F0;

    reg {
        name = "Port interrupt mask register";
        desc = "PT_INT_MASK is a port interrupt mask register.

Data sheet 10.1.6 PT_INT_MASK (offset 0x1F8, printed page 10-48, `hi3516av100--Hi3516A-Hi3516D-Datasheet.txt` line 61506).";

        enum PT_INT_MASK_height_err_enum {
            MASKED = 0 { name = "Masked"; desc = "masked"; };
            ENABLED = 1 { name = "Enabled"; desc = "enabled"; };
        };

        field {
            name = "height_err";
            desc = "Picture height change interrupt enable.";
            sw = rw;
            hw = r;
            encode = PT_INT_MASK_height_err_enum;
            reset = 0x0;
        } height_err[2:2];

        enum PT_INT_MASK_width_err_enum {
            MASKED = 0 { name = "Masked"; desc = "masked"; };
            ENABLED = 1 { name = "Enabled"; desc = "enabled"; };
        };

        field {
            name = "width_err";
            desc = "Picture width change interrupt enable.";
            sw = rw;
            hw = r;
            encode = PT_INT_MASK_width_err_enum;
            reset = 0x0;
        } width_err[1:1];

        enum PT_INT_MASK_fstart_enum {
            MASKED = 0 { name = "Masked"; desc = "masked"; };
            ENABLED = 1 { name = "Enabled"; desc = "enabled"; };
        };

        field {
            name = "fstart";
            desc = "Frame/Field start interrupt enable.";
            sw = rw;
            hw = r;
            encode = PT_INT_MASK_fstart_enum;
            reset = 0x0;
        } fstart[0:0];
    } PT_INT_MASK @ 0x1F8;

    reg {
        name = "DES control register";
        desc = "DES_CTRL is a DES control register.

Data sheet 10.1.6 DES_CTRL (offset 0x200, printed page 10-49, `hi3516av100--Hi3516A-Hi3516D-Datasheet.txt` line 61550).";

        enum DES_CTRL_enable_f_enum {
            DISABLED = 0 { name = "Disabled"; desc = "disabled"; };
            ENABLED = 1 { name = "Enabled"; desc = "enabled"; };
        };

        field {
            name = "enable";
            desc = "DES enable.";
            sw = rw;
            hw = r;
            encode = DES_CTRL_enable_f_enum;
            reset = 0x0;
        } enable_f[31:31];

        enum DES_CTRL_bit_width_enum {
            V_8_BITS = 0x8 { name = "V 8 Bits"; desc = "8 bits"; };
            V_10_BITS = 0xA { name = "V 10 Bits"; desc = "10 bits"; };
            V_12_BITS = 0xC { name = "V 12 Bits"; desc = "12 bits"; };
            V_14_BITS = 0xE { name = "V 14 Bits"; desc = "14 bits"; };
            V_16_BITS_OTHER = 0x10 { name = "V 16 Bits Other"; desc = "16 bits Other values: reserved"; };
        };

        field {
            name = "bit_width";
            desc = "Data width.";
            sw = rw;
            hw = r;
            encode = DES_CTRL_bit_width_enum;
            reset = 0x0;
        } bit_width[5:0];
    } DES_CTRL @ 0x200;

    reg {
        name = "Capture control register";
        desc = "DES_REG_NEWER is a capture control register. Huawei Proprietary and Confidential Hi3516A/Hi3516D Professional HD IP Camera SoC

Data sheet 10.1.6 DES_REG_NEWER (offset 0x204, printed page 10-50, `hi3516av100--Hi3516A-Hi3516D-Datasheet.txt` line 61590).";

        field {
            name = "reg_newer";
            desc = "DES update. This bit is automatically cleared for each frame.";
            sw = rw;
            hw = r;
            reset = 0x0;
        } reg_newer[0:0];
    } DES_REG_NEWER @ 0x204;

    reg {
        name = "DES RX ID selection register";
        desc = "DES_ID_CFG is a DES RX ID selection register (instant register).

Data sheet 10.1.6 DES_ID_CFG (offset 0x210, printed page 10-50, `hi3516av100--Hi3516A-Hi3516D-Datasheet.txt` line 61615).";

        field {
            name = "id_sel";
            desc = "ID of the data received by the DES. XXX1: 0 XX1X: 1 X1XX: 2 1XXX: 3";
            sw = rw;
            hw = r;
            reset = 0x0;
        } id_sel[3:0];
    } DES_ID_CFG @ 0x210;

    reg {
        name = "Crop enable register";
        desc = "DES_CROP_CFG is a crop enable register. Huawei Proprietary and Confidential Hi3516A/Hi3516D Professional HD IP Camera SoC

Data sheet 10.1.6 DES_CROP_CFG (offset 0x220, printed page 10-51, `hi3516av100--Hi3516A-Hi3516D-Datasheet.txt` line 61648).";

        enum DES_CROP_CFG_n0_en_enum {
            DISABLED = 0 { name = "Disabled"; desc = "disabled"; };
            ENABLED = 1 { name = "Enabled"; desc = "enabled"; };
        };

        field {
            name = "n0_en";
            desc = "Region 0 enable.";
            sw = rw;
            hw = r;
            encode = DES_CROP_CFG_n0_en_enum;
            reset = 0x0;
        } n0_en[0:0];
    } DES_CROP_CFG @ 0x220;

    reg {
        name = "Crop start position register for region 0";
        desc = "DES_CROP0_START is a crop start position register for region 0.

Data sheet 10.1.6 DES_CROP0_START (offset 0x230, printed page 10-51, `hi3516av100--Hi3516A-Hi3516D-Datasheet.txt` line 61671).";

        field {
            name = "y_start";
            desc = "ID of the line from which pictures start to be captured.";
            sw = rw;
            hw = r;
            reset = 0x0;
        } y_start[28:16];

        field {
            name = "x_start";
            desc = "ID of the pixel from which pictures start to be captured.";
            sw = rw;
            hw = r;
            reset = 0x0;
        } x_start[12:0];
    } DES_CROP0_START @ 0x230;

    reg {
        name = "Crop size configuration register for region 0";
        desc = "DES_CROP0_SIZE is a crop size configuration register for region 0. Huawei Proprietary and Confidential Hi3516A/Hi3516D Professional HD IP Camera SoC

Data sheet 10.1.6 DES_CROP0_SIZE (offset 0x234, printed page 10-52, `hi3516av100--Hi3516A-Hi3516D-Datasheet.txt` line 61704).";

        field {
            name = "height";
            desc = "Height (in line) of the obtained picture. The configured value is the actual value minus 1.";
            sw = rw;
            hw = r;
            reset = 0x0;
        } height[28:16];

        field {
            name = "width";
            desc = "Width (in pixel) of the obtained picture. The configured value is the actual value minus 1.";
            sw = rw;
            hw = r;
            reset = 0x0;
        } width[12:0];
    } DES_CROP0_SIZE @ 0x234;

    reg {
        name = "DES configuration register";
        desc = "DES_CFG is a DES configuration register.

Data sheet 10.1.6 DES_CFG (offset 0x270, printed page 10-52, `hi3516av100--Hi3516A-Hi3516D-Datasheet.txt` line 61731).";

        enum DES_CFG_cmp_en_enum {
            DISABLED = 0 { name = "Disabled"; desc = "disabled"; };
            ENABLED = 1 { name = "Enabled"; desc = "enabled"; };
        };

        field {
            name = "cmp_en";
            desc = "DES channel frame compress enable.";
            sw = rw;
            hw = r;
            encode = DES_CFG_cmp_en_enum;
            reset = 0x0;
        } cmp_en[31:31];

        field {
            name = "k_coef_range";
            desc = "Frame compression rate of the DES channel. The value range is [7:12]. The typical value is the data bit width minus 1. The configured value is 12 when the data bit width is 14 bits.";
            sw = r;
            hw = w;
            reset = 0x0;
        } k_coef_range[30:27];
    } DES_CFG @ 0x270;

    reg {
        name = "DES compressed data length register";
        desc = "DES_CMP_FRM_LEN is a DES compressed data length register. Huawei Proprietary and Confidential Hi3516A/Hi3516D Professional HD IP Camera SoC

Data sheet 10.1.6 DES_CMP_FRM_LEN (offset 0x274, printed page 10-53, `hi3516av100--Hi3516A-Hi3516D-Datasheet.txt` line 61766).";

        field {
            name = "cmp_frm_len";
            desc = "Length of the compressed DES frame data (a multiple of 128 bits).";
            sw = r;
            hw = w;
            reset = 0x0;
        } cmp_frm_len[31:0];
    } DES_CMP_FRM_LEN @ 0x274;

    reg {
        name = "DES storage size register";
        desc = "DES_SIZE is a DES storage size register.

Data sheet 10.1.6 DES_SIZE (offset 0x284, printed page 10-53, `hi3516av100--Hi3516A-Hi3516D-Datasheet.txt` line 61784).";

        field {
            name = "height";
            desc = "Height (in line) of the stored picture. The configured value is the actual value minus 1.";
            sw = rw;
            hw = r;
            reset = 0x0;
        } height[28:16];

        field {
            name = "width";
            desc = "Width (in pixel) of the stored picture. The configured value is the actual value minus 1.";
            sw = rw;
            hw = r;
            reset = 0x0;
        } width[12:0];
    } DES_SIZE @ 0x284;

    reg {
        name = "DES storage base address register";
        desc = "DES_FADDR is a DES storage base address register. Huawei Proprietary and Confidential Hi3516A/Hi3516D Professional HD IP Camera SoC

Data sheet 10.1.6 DES_FADDR (offset 0x290, printed page 10-54, `hi3516av100--Hi3516A-Hi3516D-Datasheet.txt` line 61821).";

        field {
            name = "faddr";
            desc = "DES storage base address.";
            sw = rw;
            hw = r;
            reset = 0x0;
        } faddr[31:0];
    } DES_FADDR @ 0x290;

    reg {
        name = "DES bus buffer control register";
        desc = "DES_BUF_CFG is a DES bus buffer control register.

Data sheet 10.1.6 DES_BUF_CFG (offset 0x29C, printed page 10-54, `hi3516av100--Hi3516A-Hi3516D-Datasheet.txt` line 61839).";

        field {
            name = "buf_thd";
            desc = "Depth of the bus buffer.";
            sw = rw;
            hw = r;
            reset = 0x80;
        } buf_thd[15:0];
    } DES_BUF_CFG @ 0x29C;

    reg {
        name = "DES raw interrupt register";
        desc = "DES_INT is a DES raw interrupt register.

Data sheet 10.1.6 DES_INT (offset 0x2F0, printed page 10-54, `hi3516av100--Hi3516A-Hi3516D-Datasheet.txt` line 61858).";

        enum DES_INT_update_cfg_enum {
            NO_INTERRUPT_GENERATED = 0 { name = "No Interrupt Generated"; desc = "No interrupt is generated."; };
            INTERRUPT_GENERATED = 1 { name = "Interrupt Generated"; desc = "An interrupt is generated."; };
        };

        field {
            name = "update_cfg";
            desc = "Status of the register update interrupt. Writing 1 clears the interrupt.";
            sw = rw;
            hw = w;
            onwrite = woclr;
            encode = DES_INT_update_cfg_enum;
            reset = 0x0;
        } update_cfg[4:4];

        enum DES_INT_field_throw_enum {
            NO_INTERRUPT_GENERATED = 0 { name = "No Interrupt Generated"; desc = "No interrupt is generated."; };
            INTERRUPT_GENERATED = 1 { name = "Interrupt Generated"; desc = "An interrupt is generated."; };
        };

        field {
            name = "field_throw";
            desc = "Status of the field/frame loss interrupt. Writing 1 clears the interrupt.";
            sw = rw;
            hw = w;
            onwrite = woclr;
            encode = DES_INT_field_throw_enum;
            reset = 0x0;
        } field_throw[3:3];

        enum DES_INT_buf_ovf_enum {
            NO_INTERRUPT_GENERATED = 0 { name = "No Interrupt Generated"; desc = "No interrupt is generated."; };
            INTERRUPT_GENERATED = 1 { name = "Interrupt Generated"; desc = "An interrupt is generated."; };
        };

        field {
            name = "buf_ovf";
            desc = "Status of the internal FIFO overflow error interrupt. Writing 1 clears the interrupt.";
            sw = rw;
            hw = w;
            onwrite = woclr;
            encode = DES_INT_buf_ovf_enum;
            reset = 0x0;
        } buf_ovf[2:2];

        enum DES_INT_cc_int_enum {
            NO_INTERRUPT_GENERATED = 0 { name = "No Interrupt Generated"; desc = "No interrupt is generated."; };
            INTERRUPT_GENERATED = 1 { name = "Interrupt Generated"; desc = "An interrupt is generated."; };
        };

        field {
            name = "cc_int";
            desc = "Status of the capture completion interrupt. Writing 1 clears the interrupt.";
            sw = rw;
            hw = w;
            onwrite = woclr;
            encode = DES_INT_cc_int_enum;
            reset = 0x0;
        } cc_int[1:1];

        enum DES_INT_fstart_enum {
            NO_INTERRUPT_GENERATED = 0 { name = "No Interrupt Generated"; desc = "No interrupt is generated."; };
            INTERRUPT_GENERATED = 1 { name = "Interrupt Generated"; desc = "An interrupt is generated."; };
        };

        field {
            name = "fstart";
            desc = "Status of the field/frame start interrupt. Writing 1 clears the interrupt.";
            sw = rw;
            hw = w;
            onwrite = woclr;
            encode = DES_INT_fstart_enum;
            reset = 0x0;
        } fstart[0:0];
    } DES_INT @ 0x2F0;

    reg {
        name = "DES interrupt mask register";
        desc = "DES_MASK is a DES interrupt mask register.

Data sheet 10.1.6 DES_MASK (offset 0x2F8, printed page 10-55, `hi3516av100--Hi3516A-Hi3516D-Datasheet.txt` line 61918).";

        enum DES_MASK_update_cfg_enum {
            NO_INTERRUPT_GENERATED = 0 { name = "No Interrupt Generated"; desc = "No interrupt is generated."; };
            INTERRUPT_GENERATED = 1 { name = "Interrupt Generated"; desc = "An interrupt is generated."; };
        };

        field {
            name = "update_cfg";
            desc = "Register update interrupt enable.";
            sw = rw;
            hw = r;
            encode = DES_MASK_update_cfg_enum;
            reset = 0x0;
        } update_cfg[4:4];

        enum DES_MASK_field_throw_enum {
            MASKED = 0 { name = "Masked"; desc = "masked"; };
            ENABLED = 1 { name = "Enabled"; desc = "enabled"; };
        };

        field {
            name = "field_throw";
            desc = "Field/Frame loss interrupt enable.";
            sw = rw;
            hw = r;
            encode = DES_MASK_field_throw_enum;
            reset = 0x0;
        } field_throw[3:3];

        enum DES_MASK_buf_ovf_enum {
            MASKED = 0 { name = "Masked"; desc = "masked"; };
            ENABLED = 1 { name = "Enabled"; desc = "enabled"; };
        };

        field {
            name = "buf_ovf";
            desc = "Internal FIFO overflow error interrupt enable.";
            sw = rw;
            hw = r;
            encode = DES_MASK_buf_ovf_enum;
            reset = 0x0;
        } buf_ovf[2:2];

        enum DES_MASK_cc_int_enum {
            MASKED = 0 { name = "Masked"; desc = "masked"; };
            ENABLED = 1 { name = "Enabled"; desc = "enabled"; };
        };

        field {
            name = "cc_int";
            desc = "Capture completion interrupt enable.";
            sw = rw;
            hw = r;
            encode = DES_MASK_cc_int_enum;
            reset = 0x0;
        } cc_int[1:1];

        enum DES_MASK_fstart_enum {
            MASKED = 0 { name = "Masked"; desc = "masked"; };
            ENABLED = 1 { name = "Enabled"; desc = "enabled"; };
        };

        field {
            name = "fstart";
            desc = "Field/Frame start interrupt enable.";
            sw = rw;
            hw = r;
            encode = DES_MASK_fstart_enum;
            reset = 0x0;
        } fstart[0:0];
    } DES_MASK @ 0x2F8;

    reg {
        name = "LINE_BUF control register";
        desc = "LINE_BUF_CFG is a LINE_BUF control register.

Data sheet 10.1.6 LINE_BUF_CFG (offset 0x500, printed page 10-56, `hi3516av100--Hi3516A-Hi3516D-Datasheet.txt` line 61968).";

        enum LINE_BUF_CFG_enable_f_enum {
            DISABLED = 0 { name = "Disabled"; desc = "disabled"; };
            ENABLED = 1 { name = "Enabled"; desc = "enabled"; };
        };

        field {
            name = "enable";
            desc = "LINE_BUF enable.";
            sw = rw;
            hw = r;
            encode = LINE_BUF_CFG_enable_f_enum;
            reset = 0x0;
        } enable_f[31:31];
    } LINE_BUF_CFG @ 0x500;

    reg {
        name = "LINE_BUF update register";
        desc = "LINE_BUF_REG_NEWER is a LINE_BUF update register. Huawei Proprietary and Confidential Hi3516A/Hi3516D Professional HD IP Camera SoC

Data sheet 10.1.6 LINE_BUF_REG_NEWER (offset 0x504, printed page 10-57, `hi3516av100--Hi3516A-Hi3516D-Datasheet.txt` line 62001).";

        field {
            name = "reg_newer";
            desc = "LINE_BUF update. This bit is automatically cleared for each frame.";
            sw = w;
            hw = r;
            reset = 0x0;
        } reg_newer[0:0];
    } LINE_BUF_REG_NEWER @ 0x504;

    reg {
        name = "LINE_BUF RX ID selection register";
        desc = "LINE_BUF_ID_CFG is a LINE_BUF RX ID selection register (instant register).

Data sheet 10.1.6 LINE_BUF_ID_CFG (offset 0x510, printed page 10-57, `hi3516av100--Hi3516A-Hi3516D-Datasheet.txt` line 62028).";

        field {
            name = "id_sel";
            desc = "ID of the data received by the LINE_BUF. XXX1: 0 XX1X: 1 X1XX: 2 1XXX: 3";
            sw = rw;
            hw = r;
            reset = 0x0;
        } id_sel[3:0];
    } LINE_BUF_ID_CFG @ 0x510;

    reg {
        name = "Crop register";
        desc = "LINE_BUF_CROP_CFG is a crop register. Huawei Proprietary and Confidential Hi3516A/Hi3516D Professional HD IP Camera SoC

Data sheet 10.1.6 LINE_BUF_CROP_CFG (offset 0x520, printed page 10-58, `hi3516av100--Hi3516A-Hi3516D-Datasheet.txt` line 62061).";

        enum LINE_BUF_CROP_CFG_n0_en_enum {
            DISABLED = 0 { name = "Disabled"; desc = "disabled"; };
            ENABLED = 1 { name = "Enabled"; desc = "enabled"; };
        };

        field {
            name = "n0_en";
            desc = "Region 0 enable.";
            sw = rw;
            hw = r;
            encode = LINE_BUF_CROP_CFG_n0_en_enum;
            reset = 0x0;
        } n0_en[0:0];
    } LINE_BUF_CROP_CFG @ 0x520;

    reg {
        name = "Crop start position register for region 0";
        desc = "LINE_BUF_CROP0_START is a crop start position register for region 0.

Data sheet 10.1.6 LINE_BUF_CROP0_START (offset 0x530, printed page 10-58, `hi3516av100--Hi3516A-Hi3516D-Datasheet.txt` line 62084).";

        field {
            name = "y_start";
            desc = "ID of the line from which pictures start to be captured.";
            sw = rw;
            hw = r;
            reset = 0x0;
        } y_start[28:16];

        field {
            name = "x_start";
            desc = "ID of the pixel from which pictures start to be captured.";
            sw = rw;
            hw = r;
            reset = 0x0;
        } x_start[12:0];
    } LINE_BUF_CROP0_START @ 0x530;

    reg {
        name = "Crop size configuration register for region 0";
        desc = "LINE_BUF_CROP0_SIZE is a crop size configuration register for region 0. Huawei Proprietary and Confidential Hi3516A/Hi3516D Professional HD IP Camera SoC

Data sheet 10.1.6 LINE_BUF_CROP0_SIZE (offset 0x534, printed page 10-59, `hi3516av100--Hi3516A-Hi3516D-Datasheet.txt` line 62117).";

        field {
            name = "height";
            desc = "Height (in line) of the obtained picture. The configured value is the actual value minus 1.";
            sw = rw;
            hw = r;
            reset = 0x0;
        } height[28:16];

        field {
            name = "width";
            desc = "Width (in pixel) of the obtained picture. The configured value is the actual value minus 1.";
            sw = rw;
            hw = r;
            reset = 0x0;
        } width[12:0];
    } LINE_BUF_CROP0_SIZE @ 0x534;

    reg {
        name = "LINE_BUF picture width register";
        desc = "LINE_BUF_WIDTH is a LINE_BUF picture width register.

Data sheet 10.1.6 LINE_BUF_WIDTH (offset 0x550, printed page 10-59, `hi3516av100--Hi3516A-Hi3516D-Datasheet.txt` line 62144).";

        field {
            name = "line_buf_thd";
            desc = "Threshold for starting the LINE_BUF RAM read operation.";
            sw = rw;
            hw = r;
            reset = 0x77F;
        } line_buf_thd[27:16];

        field {
            name = "line_buf_width";
            desc = "LINE_BUF picture width.";
            sw = rw;
            hw = r;
            reset = 0x77F;
        } line_buf_width[11:0];
    } LINE_BUF_WIDTH @ 0x550;

    reg {
        name = "LINE_BUF picture height register";
        desc = "LINE_BUF_HEIGHT is a LINE_BUF picture height register. Huawei Proprietary and Confidential Hi3516A/Hi3516D Professional HD IP Camera SoC

Data sheet 10.1.6 LINE_BUF_HEIGHT (offset 0x554, printed page 10-60, `hi3516av100--Hi3516A-Hi3516D-Datasheet.txt` line 62175).";

        field {
            name = "line_buf_height";
            desc = "LINE_BUF picture height.";
            sw = rw;
            hw = r;
            reset = 0x437;
        } line_buf_height[11:0];
    } LINE_BUF_HEIGHT @ 0x554;

    reg {
        name = "LINE_BUF raw interrupt register";
        desc = "LINE_BUF_INT is a LINE_BUF raw interrupt register.

Data sheet 10.1.6 LINE_BUF_INT (offset 0x5F0, printed page 10-60, `hi3516av100--Hi3516A-Hi3516D-Datasheet.txt` line 62194).";

        enum LINE_BUF_INT_update_cfg_enum {
            NO_INTERRUPT_GENERATED = 0 { name = "No Interrupt Generated"; desc = "No interrupt is generated."; };
            INTERRUPT_GENERATED = 1 { name = "Interrupt Generated"; desc = "An interrupt is generated."; };
        };

        field {
            name = "update_cfg";
            desc = "Status of the register update interrupt. Writing 1 clears the interrupt.";
            sw = rw;
            hw = w;
            onwrite = woclr;
            encode = LINE_BUF_INT_update_cfg_enum;
            reset = 0x0;
        } update_cfg[4:4];

        enum LINE_BUF_INT_field_throw_enum {
            NO_INTERRUPT_GENERATED = 0 { name = "No Interrupt Generated"; desc = "No interrupt is generated."; };
            INTERRUPT_GENERATED = 1 { name = "Interrupt Generated"; desc = "An interrupt is generated."; };
        };

        field {
            name = "field_throw";
            desc = "Status of the field/frame loss interrupt. Writing 1 clears the interrupt.";
            sw = rw;
            hw = w;
            onwrite = woclr;
            encode = LINE_BUF_INT_field_throw_enum;
            reset = 0x0;
        } field_throw[3:3];

        enum LINE_BUF_INT_fstart_enum {
            NO_INTERRUPT_GENERATED = 0 { name = "No Interrupt Generated"; desc = "No interrupt is generated."; };
            INTERRUPT_GENERATED = 1 { name = "Interrupt Generated"; desc = "An interrupt is generated."; };
        };

        field {
            name = "fstart";
            desc = "Status of the field/frame start interrupt. Writing 1 clears the interrupt.";
            sw = rw;
            hw = w;
            onwrite = woclr;
            encode = LINE_BUF_INT_fstart_enum;
            reset = 0x0;
        } fstart[0:0];
    } LINE_BUF_INT @ 0x5F0;

    reg {
        name = "LINE_BUF interrupt mask register";
        desc = "LINE_BUF_MASK is a LINE_BUF interrupt mask register.

Data sheet 10.1.6 LINE_BUF_MASK (offset 0x5F8, printed page 10-61, `hi3516av100--Hi3516A-Hi3516D-Datasheet.txt` line 62246).";

        enum LINE_BUF_MASK_update_cfg_enum {
            NO_INTERRUPT_GENERATED = 0 { name = "No Interrupt Generated"; desc = "No interrupt is generated."; };
            INTERRUPT_GENERATED = 1 { name = "Interrupt Generated"; desc = "An interrupt is generated."; };
        };

        field {
            name = "update_cfg";
            desc = "Register update interrupt enable.";
            sw = rw;
            hw = r;
            encode = LINE_BUF_MASK_update_cfg_enum;
            reset = 0x0;
        } update_cfg[4:4];

        enum LINE_BUF_MASK_field_throw_enum {
            MASKED = 0 { name = "Masked"; desc = "masked"; };
            ENABLED = 1 { name = "Enabled"; desc = "enabled"; };
        };

        field {
            name = "field_throw";
            desc = "Field/Frame loss interrupt enable.";
            sw = rw;
            hw = r;
            encode = LINE_BUF_MASK_field_throw_enum;
            reset = 0x0;
        } field_throw[3:3];

        enum LINE_BUF_MASK_fstart_enum {
            MASKED = 0 { name = "Masked"; desc = "masked"; };
            ENABLED = 1 { name = "Enabled"; desc = "enabled"; };
        };

        field {
            name = "fstart";
            desc = "Field/Frame start interrupt enable.";
            sw = rw;
            hw = r;
            encode = LINE_BUF_MASK_fstart_enum;
            reset = 0x0;
        } fstart[0:0];
    } LINE_BUF_MASK @ 0x5F8;

    reg {
        name = "SRC control register";
        desc = "SRC_CTRL is an SRC control register. Huawei Proprietary and Confidential Hi3516A/Hi3516D Professional HD IP Camera SoC

Data sheet 10.1.6 SRC_CTRL (offset 0x600, printed page 10-62, `hi3516av100--Hi3516A-Hi3516D-Datasheet.txt` line 62291).";

        enum SRC_CTRL_enable_f_enum {
            DISABLED = 0 { name = "Disabled"; desc = "disabled"; };
            ENABLED_0X600_0X6FF = 1 { name = "Enabled 0X600 0X6Ff"; desc = "enabled 0x600-0x6FF: address space of the SRC0 register 0x700-0x7FF: address space of the SRC1 register"; };
        };

        field {
            name = "enable";
            desc = "SRC enable.";
            sw = rw;
            hw = r;
            encode = SRC_CTRL_enable_f_enum;
            reset = 0x0;
        } enable_f[31:31];

        enum SRC_CTRL_bit_width_enum {
            V_8_BITS = 0x8 { name = "V 8 Bits"; desc = "8 bits"; };
            V_10_BITS = 0xA { name = "V 10 Bits"; desc = "10 bits"; };
            V_12_BITS = 0xC { name = "V 12 Bits"; desc = "12 bits"; };
            V_14_BITS = 0xE { name = "V 14 Bits"; desc = "14 bits"; };
            V_16_BITS_OTHER = 0x10 { name = "V 16 Bits Other"; desc = "16 bits Other values: reserved"; };
        };

        field {
            name = "bit_width";
            desc = "Data bit width.";
            sw = rw;
            hw = r;
            encode = SRC_CTRL_bit_width_enum;
            reset = 0x0;
        } bit_width[5:0];
    } SRC_CTRL @ 0x600;

    reg {
        name = "Capture control register";
        desc = "SRC_REG_NEWER is a capture control register.

Data sheet 10.1.6 SRC_REG_NEWER (offset 0x604, printed page 10-62, `hi3516av100--Hi3516A-Hi3516D-Datasheet.txt` line 62323).";

        field {
            name = "reg_newer";
            desc = "SRC update. This bit is automatically cleared for each frame.";
            sw = rw;
            hw = r;
            reset = 0x0;
        } reg_newer[0:0];
    } SRC_REG_NEWER @ 0x604;

    reg {
        name = "SRC configuration register";
        desc = "SRC_CFG is an SRC configuration register.

Data sheet 10.1.6 SRC_CFG (offset 0x670, printed page 10-63, `hi3516av100--Hi3516A-Hi3516D-Datasheet.txt` line 62354).";

        enum SRC_CFG_dcmp_en_enum {
            DISABLED = 0 { name = "Disabled"; desc = "disabled"; };
            ENABLED = 1 { name = "Enabled"; desc = "enabled"; };
        };

        field {
            name = "dcmp_en";
            desc = "SRC read channel frame compress enable.";
            sw = rw;
            hw = r;
            encode = SRC_CFG_dcmp_en_enum;
            reset = 0x0;
        } dcmp_en[31:31];

        field {
            name = "k_coef_range";
            desc = "Frame compression rate of the SRC channel. The value range is [7:12]. The configuration during decompression must be the same as the that during data compression. The typical value is the bit width minus 1. The configured value is 12 when the bit width is 14 bits.";
            sw = rw;
            hw = r;
            reset = 0x0;
        } k_coef_range[30:27];

        enum SRC_CFG_dcmp_mode_enum {
            LENGTH_READ_COMPRESSED = 0 { name = "Length Read Compressed"; desc = "The length of the read compressed data is determined by the internal DES channel of the logic."; };
            LENGTH_READ_COMPRESSED_2 = 1 { name = "Length Read Compressed 2"; desc = "The length of the read compressed data is specified by configuring the related register."; };
        };

        field {
            name = "dcmp_mode";
            desc = "Frame compression mode of the SRC read channel.";
            sw = rw;
            hw = r;
            encode = SRC_CFG_dcmp_mode_enum;
            reset = 0x0;
        } dcmp_mode[26:26];
    } SRC_CFG @ 0x670;

    reg {
        name = "Read compressed data length configuration register for the SRC channel";
        desc = "SRC_DCMP_FRM_LEN is a read compressed data length configuration register for the SRC channel.

Data sheet 10.1.6 SRC_DCMP_FRM_LEN (offset 0x674, printed page 10-63, `hi3516av100--Hi3516A-Hi3516D-Datasheet.txt` line 62392).";

        field {
            name = "dcmp_frm_len";
            desc = "Length of the compressed frame data read by the SRC read channel (a multiple of 128 bits).";
            sw = rw;
            hw = r;
            reset = 0x0;
        } dcmp_frm_len[31:0];
    } SRC_DCMP_FRM_LEN @ 0x674;

    reg {
        name = "SRC storage size register";
        desc = "SRC_SIZE is an SRC storage size register.

Data sheet 10.1.6 SRC_SIZE (offset 0x684, printed page 10-64, `hi3516av100--Hi3516A-Hi3516D-Datasheet.txt` line 62420).";

        field {
            name = "height";
            desc = "Height (in line) of the stored picture. The configured value is the actual value minus 1.";
            sw = rw;
            hw = r;
            reset = 0x0;
        } height[28:16];

        field {
            name = "width";
            desc = "Width (in pixel) of the stored picture. The configured value is the actual value minus 1.";
            sw = rw;
            hw = r;
            reset = 0x0;
        } width[12:0];
    } SRC_SIZE @ 0x684;

    reg {
        name = "SRC storage base address register";
        desc = "SRC_FADDR is an SRC storage base address register.

Data sheet 10.1.6 SRC_FADDR (offset 0x690, printed page 10-64, `hi3516av100--Hi3516A-Hi3516D-Datasheet.txt` line 62447).";

        field {
            name = "faddr";
            desc = "SRC storage base address.";
            sw = rw;
            hw = r;
            reset = 0x0;
        } faddr[31:0];
    } SRC_FADDR @ 0x690;

    reg {
        name = "SRC bus buffer control register";
        desc = "SRC_BUF_CFG is an SRC bus buffer control register. Huawei Proprietary and Confidential Hi3516A/Hi3516D Professional HD IP Camera SoC

Data sheet 10.1.6 SRC_BUF_CFG (offset 0x69C, printed page 10-65, `hi3516av100--Hi3516A-Hi3516D-Datasheet.txt` line 62475).";

        field {
            name = "buf_thd";
            desc = "Depth of the bus buffer.";
            sw = rw;
            hw = r;
            reset = 0x80;
        } buf_thd[15:0];
    } SRC_BUF_CFG @ 0x69C;

    reg {
        name = "SRC raw interrupt register";
        desc = "SRC_INT is an SRC raw interrupt register.

Data sheet 10.1.6 SRC_INT (offset 0x6F0, printed page 10-65, `hi3516av100--Hi3516A-Hi3516D-Datasheet.txt` line 62494).";

        enum SRC_INT_dcmp_wrong_enum {
            NO_INTERRUPT_GENERATED = 0 { name = "No Interrupt Generated"; desc = "No interrupt is generated."; };
            INTERRUPT_GENERATED = 1 { name = "Interrupt Generated"; desc = "An interrupt is generated."; };
        };

        field {
            name = "dcmp_wrong";
            desc = "Status of the decompress error interrupt. Writing 1 clears the interrupt.";
            sw = rw;
            hw = w;
            onwrite = woclr;
            encode = SRC_INT_dcmp_wrong_enum;
            reset = 0x0;
        } dcmp_wrong[5:5];

        enum SRC_INT_update_cfg_enum {
            NO_INTERRUPT_GENERATED = 0 { name = "No Interrupt Generated"; desc = "No interrupt is generated."; };
            INTERRUPT_GENERATED = 1 { name = "Interrupt Generated"; desc = "An interrupt is generated."; };
        };

        field {
            name = "update_cfg";
            desc = "Status of the register update interrupt. Writing 1 clears the interrupt.";
            sw = rw;
            hw = w;
            onwrite = woclr;
            encode = SRC_INT_update_cfg_enum;
            reset = 0x0;
        } update_cfg[4:4];

        enum SRC_INT_field_throw_enum {
            NO_INTERRUPT_GENERATED = 0 { name = "No Interrupt Generated"; desc = "No interrupt is generated."; };
            INTERRUPT_GENERATED = 1 { name = "Interrupt Generated"; desc = "An interrupt is generated."; };
        };

        field {
            name = "field_throw";
            desc = "Status of the field/frame loss interrupt. Writing 1 clears the interrupt.";
            sw = rw;
            hw = w;
            onwrite = woclr;
            encode = SRC_INT_field_throw_enum;
            reset = 0x0;
        } field_throw[3:3];

        enum SRC_INT_buf_ovf_enum {
            NO_INTERRUPT_GENERATED = 0 { name = "No Interrupt Generated"; desc = "No interrupt is generated."; };
            INTERRUPT_GENERATED = 1 { name = "Interrupt Generated"; desc = "An interrupt is generated."; };
        };

        field {
            name = "buf_ovf";
            desc = "Status of the internal FIFO overflow error interrupt. Writing 1 clears the interrupt.";
            sw = rw;
            hw = w;
            onwrite = woclr;
            encode = SRC_INT_buf_ovf_enum;
            reset = 0x0;
        } buf_ovf[2:2];

        enum SRC_INT_cc_int_enum {
            NO_INTERRUPT_GENERATED = 0 { name = "No Interrupt Generated"; desc = "No interrupt is generated."; };
            INTERRUPT_GENERATED = 1 { name = "Interrupt Generated"; desc = "An interrupt is generated."; };
        };

        field {
            name = "cc_int";
            desc = "Status of the capture completion interrupt. Writing 1 clears the interrupt.";
            sw = rw;
            hw = w;
            onwrite = woclr;
            encode = SRC_INT_cc_int_enum;
            reset = 0x0;
        } cc_int[1:1];

        enum SRC_INT_fstart_enum {
            NO_INTERRUPT_GENERATED = 0 { name = "No Interrupt Generated"; desc = "No interrupt is generated."; };
            INTERRUPT_GENERATED = 1 { name = "Interrupt Generated"; desc = "An interrupt is generated."; };
        };

        field {
            name = "fstart";
            desc = "Status of the field/frame start interrupt. Writing 1 clears the interrupt.";
            sw = rw;
            hw = w;
            onwrite = woclr;
            encode = SRC_INT_fstart_enum;
            reset = 0x0;
        } fstart[0:0];
    } SRC_INT @ 0x6F0;

    reg {
        name = "SRC interrupt mask register";
        desc = "SRC_MASK is an SRC interrupt mask register.

Data sheet 10.1.6 SRC_MASK (offset 0x6F8, printed page 10-66, `hi3516av100--Hi3516A-Hi3516D-Datasheet.txt` line 62559).";

        enum SRC_MASK_dcmp_wrong_enum {
            NO_INTERRUPT_GENERATED = 0 { name = "No Interrupt Generated"; desc = "No interrupt is generated."; };
            INTERRUPT_GENERATED = 1 { name = "Interrupt Generated"; desc = "An interrupt is generated."; };
        };

        field {
            name = "dcmp_wrong";
            desc = "Decompress error interrupt enable.";
            sw = rw;
            hw = r;
            encode = SRC_MASK_dcmp_wrong_enum;
            reset = 0x0;
        } dcmp_wrong[5:5];

        enum SRC_MASK_update_cfg_enum {
            NO_INTERRUPT_GENERATED = 0 { name = "No Interrupt Generated"; desc = "No interrupt is generated."; };
            INTERRUPT_GENERATED = 1 { name = "Interrupt Generated"; desc = "An interrupt is generated."; };
        };

        field {
            name = "update_cfg";
            desc = "Register update interrupt enable.";
            sw = rw;
            hw = r;
            encode = SRC_MASK_update_cfg_enum;
            reset = 0x0;
        } update_cfg[4:4];

        enum SRC_MASK_field_throw_enum {
            MASKED = 0 { name = "Masked"; desc = "masked"; };
            ENABLED = 1 { name = "Enabled"; desc = "enabled"; };
        };

        field {
            name = "field_throw";
            desc = "Field/Frame loss interrupt enable.";
            sw = rw;
            hw = r;
            encode = SRC_MASK_field_throw_enum;
            reset = 0x0;
        } field_throw[3:3];

        enum SRC_MASK_buf_ovf_enum {
            MASKED = 0 { name = "Masked"; desc = "masked"; };
            ENABLED = 1 { name = "Enabled"; desc = "enabled"; };
        };

        field {
            name = "buf_ovf";
            desc = "Internal FIFO overflow error interrupt enable.";
            sw = rw;
            hw = r;
            encode = SRC_MASK_buf_ovf_enum;
            reset = 0x0;
        } buf_ovf[2:2];

        enum SRC_MASK_cc_int_enum {
            MASKED = 0 { name = "Masked"; desc = "masked"; };
            ENABLED = 1 { name = "Enabled"; desc = "enabled"; };
        };

        field {
            name = "cc_int";
            desc = "Capture completion interrupt enable.";
            sw = rw;
            hw = r;
            encode = SRC_MASK_cc_int_enum;
            reset = 0x0;
        } cc_int[1:1];

        enum SRC_MASK_fstart_enum {
            MASKED = 0 { name = "Masked"; desc = "masked"; };
            ENABLED = 1 { name = "Enabled"; desc = "enabled"; };
        };

        field {
            name = "fstart";
            desc = "Field/Frame start interrupt enable.";
            sw = rw;
            hw = r;
            encode = SRC_MASK_fstart_enum;
            reset = 0x0;
        } fstart[0:0];
    } SRC_MASK @ 0x6F8;

    reg {
        name = "Channel control register";
        desc = "CH_CTRL is a channel control register.

Data sheet 10.1.6 CH_CTRL (offset 0x1000, printed page 10-67, `hi3516av100--Hi3516A-Hi3516D-Datasheet.txt` line 62611).";

        enum CH_CTRL_enable_f_enum {
            DISABLED = 0 { name = "Disabled"; desc = "disabled"; };
            ENABLED = 1 { name = "Enabled"; desc = "enabled"; };
        };

        field {
            name = "enable";
            desc = "Channel enable.";
            sw = rw;
            hw = r;
            encode = CH_CTRL_enable_f_enum;
            reset = 0x0;
        } enable_f[31:31];
    } CH_CTRL @ 0x1000;

    reg {
        name = "Capture control register";
        desc = "CH_REG_NEWER is a capture control register.

Data sheet 10.1.6 CH_REG_NEWER (offset 0x1004, printed page 10-67, `hi3516av100--Hi3516A-Hi3516D-Datasheet.txt` line 62634).";

        field {
            name = "reg_newer";
            desc = "Channel update. This bit is automatically cleared for each frame.";
            sw = rw;
            hw = r;
            reset = 0x0;
        } reg_newer[0:0];
    } CH_REG_NEWER @ 0x1004;

    reg {
        name = "Input picture luminance statistics register";
        desc = "CH_SUM_Y is an input picture luminance statistics register.

Data sheet 10.1.6 CH_SUM_Y (offset 0x1020, printed page 10-68, `hi3516av100--Hi3516A-Hi3516D-Datasheet.txt` line 62669).";

        field {
            name = "sum_y";
            desc = "Luminance statistics.";
            sw = r;
            hw = w;
            reset = 0x0;
        } sum_y[31:0];
    } CH_SUM_Y @ 0x1020;

    reg {
        name = "Channel input picture start interrupt delay configuration register";
        desc = "CH_DLY_CFG is a channel input picture start interrupt delay configuration register.

Data sheet 10.1.6 CH_DLY_CFG (offset 0x1034, printed page 10-68, `hi3516av100--Hi3516A-Hi3516D-Datasheet.txt` line 62687).";

        field {
            name = "v_dly_cfg";
            desc = "Vertical line number delay.";
            sw = rw;
            hw = r;
            reset = 0x10;
        } v_dly_cfg[31:16];
    } CH_DLY_CFG @ 0x1034;

    reg {
        name = "Y component configuration register for the WCH module";
        desc = "CH_WCH_Y_CFG is a Y component configuration register for the WCH module. Huawei Proprietary and Confidential Hi3516A/Hi3516D Professional HD IP Camera SoC

Data sheet 10.1.6 CH_WCH_Y_CFG (offset 0x1080, printed page 10-69, `hi3516av100--Hi3516A-Hi3516D-Datasheet.txt` line 62716).";

        enum CH_WCH_Y_CFG_enable_f_enum {
            DISABLED = 0 { name = "Disabled"; desc = "disabled"; };
            ENABLED = 1 { name = "Enabled"; desc = "enabled"; };
        };

        field {
            name = "enable";
            desc = "CH write channel enable.";
            sw = rw;
            hw = r;
            encode = CH_WCH_Y_CFG_enable_f_enum;
            reset = 0x0;
        } enable_f[31:31];

        enum CH_WCH_Y_CFG_interleave_enum {
            OUTPUT_DATA_PROGRESSIVE = 0 { name = "Output Data Progressive"; desc = "The output data is progressive or interlaced and does not need to be interleaved as frames for storing."; };
            OUTPUT_DATA_INTERLACED = 1 { name = "Output Data Interlaced"; desc = "The output data interlaced and needs to be interleaved as frames for storing."; };
        };

        field {
            name = "interleave";
            desc = "Progressive/Interlaced flag.";
            sw = rw;
            hw = r;
            encode = CH_WCH_Y_CFG_interleave_enum;
            reset = 0x0;
        } interleave[19:19];

        enum CH_WCH_Y_CFG_bfield_enum {
            TOP_FIELD = 0 { name = "Top Field"; desc = "top field"; };
            BOTTOM_FIELD = 1 { name = "Bottom Field"; desc = "bottom field"; };
        };

        field {
            name = "bfield";
            desc = "Top/Bottom field flag. This field is used when the output data interlaced and needs to be interleaved as frames for storing.";
            sw = rw;
            hw = r;
            encode = CH_WCH_Y_CFG_bfield_enum;
            reset = 0x0;
        } bfield[18:18];

        enum CH_WCH_Y_CFG_head_tword_enum {
            V_128_BITS = 0 { name = "V 128 Bits"; desc = "128 bits (128 bits/line)"; };
            V_256_BITS = 1 { name = "V 256 Bits"; desc = "256 bits (256 bits/line)"; };
        };

        field {
            name = "head_tword";
            desc = "Header information stride.";
            sw = rw;
            hw = r;
            encode = CH_WCH_Y_CFG_head_tword_enum;
            reset = 0x0;
        } head_tword[2:2];

        enum CH_WCH_Y_CFG_cmp_mode_enum {
            V_128_PIXELS = 0 { name = "V 128 Pixels"; desc = "128 pixels"; };
            V_256_PIXELS = 1 { name = "V 256 Pixels"; desc = "256 pixels"; };
        };

        field {
            name = "cmp_mode";
            desc = "Compressed segment length.";
            sw = rw;
            hw = r;
            encode = CH_WCH_Y_CFG_cmp_mode_enum;
            reset = 0x1;
        } cmp_mode[1:1];

        enum CH_WCH_Y_CFG_cmp_en_enum {
            DISABLED = 0 { name = "Disabled"; desc = "disabled"; };
            ENABLED = 1 { name = "Enabled"; desc = "enabled"; };
        };

        field {
            name = "cmp_en";
            desc = "Compression enable.";
            sw = rw;
            hw = r;
            encode = CH_WCH_Y_CFG_cmp_en_enum;
            reset = 0x0;
        } cmp_en[0:0];
    } CH_WCH_Y_CFG @ 0x1080;

    reg {
        name = "Y component storage size register for the WCH module";
        desc = "CH_WCH_Y_SIZE is a Y component storage size register for the WCH module. Huawei Proprietary and Confidential Hi3516A/Hi3516D Professional HD IP Camera SoC

Data sheet 10.1.6 CH_WCH_Y_SIZE (offset 0x1084, printed page 10-70, `hi3516av100--Hi3516A-Hi3516D-Datasheet.txt` line 62773).";

        field {
            name = "height";
            desc = "Height (in line) of the stored picture. The configured value is the actual value minus 1.";
            sw = rw;
            hw = r;
            reset = 0x0;
        } height[28:16];

        field {
            name = "width";
            desc = "Width (in pixel) of the stored picture. The configured value is the actual value minus 1.";
            sw = rw;
            hw = r;
            reset = 0x0;
        } width[12:0];
    } CH_WCH_Y_SIZE @ 0x1084;

    reg {
        name = "Y component storage base address register for the WCH module";
        desc = "CH_WCH_Y_FADDR is a Y component storage base address register for the WCH module.

Data sheet 10.1.6 CH_WCH_Y_FADDR (offset 0x1090, printed page 10-70, `hi3516av100--Hi3516A-Hi3516D-Datasheet.txt` line 62800).";

        field {
            name = "faddr";
            desc = "Base address for storing the Y component.";
            sw = rw;
            hw = r;
            reset = 0x0;
        } faddr[31:0];
    } CH_WCH_Y_FADDR @ 0x1090;

    reg {
        name = "Y component header information storage base address register for the WCH module";
        desc = "CH_WCH_Y_HADDR is a Y component header information storage base address register for the WCH module. Huawei Proprietary and Confidential Hi3516A/Hi3516D Professional HD IP Camera SoC

Data sheet 10.1.6 CH_WCH_Y_HADDR (offset 0x1094, printed page 10-71, `hi3516av100--Hi3516A-Hi3516D-Datasheet.txt` line 62829).";

        field {
            name = "haddr";
            desc = "Base address for storing the Y component header information.";
            sw = rw;
            hw = r;
            reset = 0x0;
        } haddr[31:0];
    } CH_WCH_Y_HADDR @ 0x1094;

    reg {
        name = "Y component line offset register for the WCH module";
        desc = "CH_WCH_Y_STRIDE is a Y component line offset register for the WCH module.

Data sheet 10.1.6 CH_WCH_Y_STRIDE (offset 0x1098, printed page 10-71, `hi3516av100--Hi3516A-Hi3516D-Datasheet.txt` line 62847).";

        field {
            name = "stride";
            desc = "Stride (in byte) for storing the Y component.";
            sw = rw;
            hw = r;
            reset = 0x0;
        } stride[15:0];
    } CH_WCH_Y_STRIDE @ 0x1098;

    reg {
        name = "C component configuration register for the WCH module";
        desc = "CH_WCH_C_CFG is a C component configuration register for the WCH module.

Data sheet 10.1.6 CH_WCH_C_CFG (offset 0x10A0, printed page 10-71, `hi3516av100--Hi3516A-Hi3516D-Datasheet.txt` line 62866).";

        enum CH_WCH_C_CFG_enable_f_enum {
            DISABLED = 0 { name = "Disabled"; desc = "disabled"; };
            ENABLED = 1 { name = "Enabled"; desc = "enabled"; };
        };

        field {
            name = "enable";
            desc = "CH write channel enable.";
            sw = rw;
            hw = r;
            encode = CH_WCH_C_CFG_enable_f_enum;
            reset = 0x0;
        } enable_f[31:31];

        enum CH_WCH_C_CFG_interleave_enum {
            OUTPUT_DATA_PROGRESSIVE = 0 { name = "Output Data Progressive"; desc = "The output data is progressive or interlaced and does not need to be interleaved as frames for storing."; };
            OUTPUT_DATA_INTERLACED = 1 { name = "Output Data Interlaced"; desc = "The output data interlaced and needs to be interleaved as frames for storing."; };
        };

        field {
            name = "interleave";
            desc = "Progressive/Interlaced flag.";
            sw = rw;
            hw = r;
            encode = CH_WCH_C_CFG_interleave_enum;
            reset = 0x0;
        } interleave[19:19];

        enum CH_WCH_C_CFG_bfield_enum {
            TOP_FIELD = 0 { name = "Top Field"; desc = "top field"; };
            BOTTOM_FIELD = 1 { name = "Bottom Field"; desc = "bottom field"; };
        };

        field {
            name = "bfield";
            desc = "Top/Bottom field flag. This field is used when the output data interlaced and needs to be interleaved as frames for storing.";
            sw = rw;
            hw = r;
            encode = CH_WCH_C_CFG_bfield_enum;
            reset = 0x0;
        } bfield[18:18];

        enum CH_WCH_C_CFG_head_tword_enum {
            V_128_BITS = 0 { name = "V 128 Bits"; desc = "128 bits (128 bits/line)"; };
            V_256_BITS = 1 { name = "V 256 Bits"; desc = "256 bits (256 bits/line)"; };
        };

        field {
            name = "head_tword";
            desc = "Header information stride.";
            sw = rw;
            hw = r;
            encode = CH_WCH_C_CFG_head_tword_enum;
            reset = 0x0;
        } head_tword[2:2];

        enum CH_WCH_C_CFG_cmp_mode_enum {
            V_128_PIXELS = 0 { name = "V 128 Pixels"; desc = "128 pixels"; };
            V_256_PIXELS = 1 { name = "V 256 Pixels"; desc = "256 pixels"; };
        };

        field {
            name = "cmp_mode";
            desc = "Compressed segment length.";
            sw = rw;
            hw = r;
            encode = CH_WCH_C_CFG_cmp_mode_enum;
            reset = 0x1;
        } cmp_mode[1:1];

        enum CH_WCH_C_CFG_cmp_en_enum {
            DISABLED = 0 { name = "Disabled"; desc = "disabled"; };
            ENABLED = 1 { name = "Enabled"; desc = "enabled"; };
        };

        field {
            name = "cmp_en";
            desc = "Compression enable.";
            sw = rw;
            hw = r;
            encode = CH_WCH_C_CFG_cmp_en_enum;
            reset = 0x0;
        } cmp_en[0:0];
    } CH_WCH_C_CFG @ 0x10A0;

    reg {
        name = "C component storage size register for the WCH module";
        desc = "CH_WCH_C_SIZE is a C component storage size register for the WCH module.

Data sheet 10.1.6 CH_WCH_C_SIZE (offset 0x10A4, printed page 10-72, `hi3516av100--Hi3516A-Hi3516D-Datasheet.txt` line 62923).";

        field {
            name = "height";
            desc = "Height (in line) of the stored picture. The configured value is the actual value minus 1.";
            sw = rw;
            hw = r;
            reset = 0x0;
        } height[28:16];

        field {
            name = "width";
            desc = "Width (in pixel) of the stored picture. The configured value is the actual value minus 1.";
            sw = rw;
            hw = r;
            reset = 0x0;
        } width[12:0];
    } CH_WCH_C_SIZE @ 0x10A4;

    reg {
        name = "C component storage base address register for the WCH module";
        desc = "CH_WCH_C_FADDR is a C component storage base address register for the WCH module.

Data sheet 10.1.6 CH_WCH_C_FADDR (offset 0x10B0, printed page 10-73, `hi3516av100--Hi3516A-Hi3516D-Datasheet.txt` line 62960).";

        field {
            name = "faddr";
            desc = "Base address for storing the C component.";
            sw = rw;
            hw = r;
            reset = 0x0;
        } faddr[31:0];
    } CH_WCH_C_FADDR @ 0x10B0;

    reg {
        name = "C component header information storage base address register for the WCH module";
        desc = "CH_WCH_C_HADDR is a C component header information storage base address register for the WCH module.

Data sheet 10.1.6 CH_WCH_C_HADDR (offset 0x10B4, printed page 10-73, `hi3516av100--Hi3516A-Hi3516D-Datasheet.txt` line 62979).";

        field {
            name = "haddr";
            desc = "Base address for storing the C component header information.";
            sw = rw;
            hw = r;
            reset = 0x0;
        } haddr[31:0];
    } CH_WCH_C_HADDR @ 0x10B4;

    reg {
        name = "C component line offset register for the WCH module";
        desc = "CH_WCH_C_STRIDE is a C component line offset register for the WCH module. Huawei Proprietary and Confidential Hi3516A/Hi3516D Professional HD IP Camera SoC

Data sheet 10.1.6 CH_WCH_C_STRIDE (offset 0x10B8, printed page 10-74, `hi3516av100--Hi3516A-Hi3516D-Datasheet.txt` line 63007).";

        field {
            name = "stride";
            desc = "Stride (in byte) for storing the C component.";
            sw = rw;
            hw = r;
            reset = 0x0;
        } stride[15:0];
    } CH_WCH_C_STRIDE @ 0x10B8;

    reg {
        name = "Channel raw interrupt register";
        desc = "CH_INT is a channel raw interrupt register.

Data sheet 10.1.6 CH_INT (offset 0x10F0, printed page 10-74, `hi3516av100--Hi3516A-Hi3516D-Datasheet.txt` line 63026).";

        enum CH_INT_acm_para_finish_enum {
            NO_INTERRUPT_GENERATED = 0 { name = "No Interrupt Generated"; desc = "No interrupt is generated."; };
            INTERRUPT_GENERATED = 1 { name = "Interrupt Generated"; desc = "An interrupt is generated."; };
        };

        field {
            name = "acm_para_finish";
            desc = "Status of the ACM LUT loading completion interrupt. Writing 1 clears the interrupt.";
            sw = rw;
            hw = w;
            onwrite = woclr;
            encode = CH_INT_acm_para_finish_enum;
            reset = 0x0;
        } acm_para_finish[16:16];

        enum CH_INT_fstart_dly_enum {
            NO_INTERRUPT_GENERATED = 0 { name = "No Interrupt Generated"; desc = "No interrupt is generated."; };
            INTERRUPT_GENERATED = 1 { name = "Interrupt Generated"; desc = "An interrupt is generated."; };
        };

        field {
            name = "fstart_dly";
            desc = "Status of the delayed field/frame start interrupt. Writing 1 clears the interrupt.";
            sw = rw;
            hw = w;
            onwrite = woclr;
            encode = CH_INT_fstart_dly_enum;
            reset = 0x0;
        } fstart_dly[15:15];

        enum CH_INT_update_cfg_enum {
            NO_INTERRUPT_GENERATED = 0 { name = "No Interrupt Generated"; desc = "No interrupt is generated."; };
            INTERRUPT_GENERATED = 1 { name = "Interrupt Generated"; desc = "An interrupt is generated."; };
        };

        field {
            name = "update_cfg";
            desc = "Status of the register update interrupt. Writing 1 clears the interrupt.";
            sw = rw;
            hw = w;
            onwrite = woclr;
            encode = CH_INT_update_cfg_enum;
            reset = 0x0;
        } update_cfg[4:4];

        enum CH_INT_field_throw_enum {
            NO_INTERRUPT_GENERATED = 0 { name = "No Interrupt Generated"; desc = "No interrupt is generated."; };
            INTERRUPT_GENERATED = 1 { name = "Interrupt Generated"; desc = "An interrupt is generated."; };
        };

        field {
            name = "field_throw";
            desc = "Status of the field/frame loss interrupt. Writing 1 clears the interrupt.";
            sw = rw;
            hw = w;
            onwrite = woclr;
            encode = CH_INT_field_throw_enum;
            reset = 0x0;
        } field_throw[3:3];

        enum CH_INT_buf_ovf_enum {
            NO_INTERRUPT_GENERATED = 0 { name = "No Interrupt Generated"; desc = "No interrupt is generated."; };
            INTERRUPT_GENERATED = 1 { name = "Interrupt Generated"; desc = "An interrupt is generated."; };
        };

        field {
            name = "buf_ovf";
            desc = "Status of the internal FIFO overflow error interrupt. Writing 1 clears the interrupt.";
            sw = rw;
            hw = w;
            onwrite = woclr;
            encode = CH_INT_buf_ovf_enum;
            reset = 0x0;
        } buf_ovf[2:2];

        enum CH_INT_cc_int_enum {
            NO_INTERRUPT_GENERATED = 0 { name = "No Interrupt Generated"; desc = "No interrupt is generated."; };
            INTERRUPT_GENERATED = 1 { name = "Interrupt Generated"; desc = "An interrupt is generated."; };
        };

        field {
            name = "cc_int";
            desc = "Status of the capture completion interrupt. Writing 1 clears the interrupt.";
            sw = rw;
            hw = w;
            onwrite = woclr;
            encode = CH_INT_cc_int_enum;
            reset = 0x0;
        } cc_int[1:1];

        enum CH_INT_fstart_enum {
            NO_INTERRUPT_GENERATED = 0 { name = "No Interrupt Generated"; desc = "No interrupt is generated."; };
            INTERRUPT_GENERATED = 1 { name = "Interrupt Generated"; desc = "An interrupt is generated."; };
        };

        field {
            name = "fstart";
            desc = "Status of the field/frame start interrupt. Writing 1 clears the interrupt.";
            sw = rw;
            hw = w;
            onwrite = woclr;
            encode = CH_INT_fstart_enum;
            reset = 0x0;
        } fstart[0:0];
    } CH_INT @ 0x10F0;

    reg {
        name = "Channel interrupt mask register";
        desc = "CH_INT_MASK is a channel interrupt mask register.

Data sheet 10.1.6 CH_INT_MASK (offset 0x10F8, printed page 10-75, `hi3516av100--Hi3516A-Hi3516D-Datasheet.txt` line 63099).";

        enum CH_INT_MASK_acm_para_finish_enum {
            NO_INTERRUPT_GENERATED = 0 { name = "No Interrupt Generated"; desc = "No interrupt is generated."; };
            INTERRUPT_GENERATED = 1 { name = "Interrupt Generated"; desc = "An interrupt is generated."; };
        };

        field {
            name = "acm_para_finish";
            desc = "ACM LUT loading completion interrupt enable.";
            sw = rw;
            hw = r;
            encode = CH_INT_MASK_acm_para_finish_enum;
            reset = 0x0;
        } acm_para_finish[16:16];

        enum CH_INT_MASK_fstart_dly_enum {
            NO_INTERRUPT_GENERATED = 0 { name = "No Interrupt Generated"; desc = "No interrupt is generated."; };
            INTERRUPT_GENERATED = 1 { name = "Interrupt Generated"; desc = "An interrupt is generated."; };
        };

        field {
            name = "fstart_dly";
            desc = "Delayed field/frame start interrupt enable.";
            sw = rw;
            hw = r;
            encode = CH_INT_MASK_fstart_dly_enum;
            reset = 0x0;
        } fstart_dly[15:15];

        enum CH_INT_MASK_update_cfg_enum {
            NO_INTERRUPT_GENERATED = 0 { name = "No Interrupt Generated"; desc = "No interrupt is generated."; };
            INTERRUPT_GENERATED = 1 { name = "Interrupt Generated"; desc = "An interrupt is generated."; };
        };

        field {
            name = "update_cfg";
            desc = "Register update interrupt enable.";
            sw = rw;
            hw = r;
            encode = CH_INT_MASK_update_cfg_enum;
            reset = 0x0;
        } update_cfg[4:4];

        enum CH_INT_MASK_field_throw_enum {
            MASKED = 0 { name = "Masked"; desc = "masked"; };
            ENABLED = 1 { name = "Enabled"; desc = "enabled"; };
        };

        field {
            name = "field_throw";
            desc = "Field/Frame loss interrupt enable.";
            sw = rw;
            hw = r;
            encode = CH_INT_MASK_field_throw_enum;
            reset = 0x0;
        } field_throw[3:3];

        enum CH_INT_MASK_buf_ovf_enum {
            MASKED = 0 { name = "Masked"; desc = "masked"; };
            ENABLED = 1 { name = "Enabled"; desc = "enabled"; };
        };

        field {
            name = "buf_ovf";
            desc = "Internal FIFO overflow error interrupt enable.";
            sw = rw;
            hw = r;
            encode = CH_INT_MASK_buf_ovf_enum;
            reset = 0x0;
        } buf_ovf[2:2];

        enum CH_INT_MASK_cc_int_enum {
            MASKED = 0 { name = "Masked"; desc = "masked"; };
            ENABLED = 1 { name = "Enabled"; desc = "enabled"; };
        };

        field {
            name = "cc_int";
            desc = "Capture completion interrupt enable.";
            sw = rw;
            hw = r;
            encode = CH_INT_MASK_cc_int_enum;
            reset = 0x0;
        } cc_int[1:1];

        enum CH_INT_MASK_fstart_enum {
            MASKED = 0 { name = "Masked"; desc = "masked"; };
            ENABLED = 1 { name = "Enabled"; desc = "enabled"; };
        };

        field {
            name = "fstart";
            desc = "Field/Frame start interrupt enable.";
            sw = rw;
            hw = r;
            encode = CH_INT_MASK_fstart_enum;
            reset = 0x0;
        } fstart[0:0];
    } CH_INT_MASK @ 0x10F8;

    reg {
        name = "Crop register";
        desc = "CH_CROP_CFG is a crop register.

Data sheet 10.1.6 CH_CROP_CFG (offset 0x1100, printed page 10-76, `hi3516av100--Hi3516A-Hi3516D-Datasheet.txt` line 63157).";

        enum CH_CROP_CFG_n0_en_enum {
            DISABLED = 0 { name = "Disabled"; desc = "disabled"; };
            ENABLED = 1 { name = "Enabled"; desc = "enabled"; };
        };

        field {
            name = "n0_en";
            desc = "Region 0 enable.";
            sw = rw;
            hw = r;
            encode = CH_CROP_CFG_n0_en_enum;
            reset = 0x0;
        } n0_en[0:0];
    } CH_CROP_CFG @ 0x1100;

    reg {
        name = "Crop start position register for region 0";
        desc = "CH_CROP0_START is a crop start position register for region 0. Huawei Proprietary and Confidential Hi3516A/Hi3516D Professional HD IP Camera SoC

Data sheet 10.1.6 CH_CROP0_START (offset 0x1110, printed page 10-77, `hi3516av100--Hi3516A-Hi3516D-Datasheet.txt` line 63190).";

        field {
            name = "y_start";
            desc = "ID of the line from which pictures start to be captured.";
            sw = rw;
            hw = r;
            reset = 0x0;
        } y_start[28:16];

        field {
            name = "x_start";
            desc = "ID of the pixel from which pictures start to be captured.";
            sw = rw;
            hw = r;
            reset = 0x0;
        } x_start[12:0];
    } CH_CROP0_START @ 0x1110;

    reg {
        name = "Crop size configuration register for region 0";
        desc = "CH_CROP0_SIZE is a crop size configuration register for region 0.

Data sheet 10.1.6 CH_CROP0_SIZE (offset 0x1114, printed page 10-77, `hi3516av100--Hi3516A-Hi3516D-Datasheet.txt` line 63213).";

        field {
            name = "height";
            desc = "Height (in line) of the obtained picture. The configured value is the actual value minus 1.";
            sw = rw;
            hw = r;
            reset = 0x0;
        } height[28:16];

        field {
            name = "width";
            desc = "Width (in pixel) of the obtained picture. The configured value is the actual value minus 1.";
            sw = rw;
            hw = r;
            reset = 0x0;
        } width[12:0];
    } CH_CROP0_SIZE @ 0x1114;

    reg {
        name = "CSC configuration register";
        desc = "CH_CSC_CFG is a CSC configuration register. Huawei Proprietary and Confidential Hi3516A/Hi3516D Professional HD IP Camera SoC

Data sheet 10.1.6 CH_CSC_CFG (offset 0x1200, printed page 10-78, `hi3516av100--Hi3516A-Hi3516D-Datasheet.txt` line 63250).";

        enum CH_CSC_CFG_enable_f_enum {
            DISABLED = 0 { name = "Disabled"; desc = "disabled"; };
            ENABLED = 1 { name = "Enabled"; desc = "enabled"; };
        };

        field {
            name = "enable";
            desc = "CSC enable.";
            sw = rw;
            hw = r;
            encode = CH_CSC_CFG_enable_f_enum;
            reset = 0x0;
        } enable_f[31:31];
    } CH_CSC_CFG @ 0x1200;

    reg {
        name = "CSC coefficient register 0";
        desc = "CH_CSC_COEF0 is CSC coefficient register 0.

Data sheet 10.1.6 CH_CSC_COEF0 (offset 0x1210, printed page 10-78, `hi3516av100--Hi3516A-Hi3516D-Datasheet.txt` line 63273).";

        field {
            name = "coef01";
            desc = "CSC coefficient. Its format is (s, 4, 10). The value consists of a 1-bit signed part, a 4-bit integer part, and a 10-bit decimal part.";
            sw = rw;
            hw = r;
            reset = 0x0;
        } coef01[31:17];

        field {
            name = "coef00";
            desc = "CSC coefficient. Its format is (s, 4, 10). The value consists of a 1-bit signed part, a 4-bit integer part, and a 10-bit decimal part.";
            sw = rw;
            hw = r;
            reset = 0x0;
        } coef00[15:1];
    } CH_CSC_COEF0 @ 0x1210;

    reg {
        name = "CSC coefficient register 1";
        desc = "CH_CSC_COEF1 is CSC coefficient register 1. Huawei Proprietary and Confidential Hi3516A/Hi3516D Professional HD IP Camera SoC

Data sheet 10.1.6 CH_CSC_COEF1 (offset 0x1214, printed page 10-79, `hi3516av100--Hi3516A-Hi3516D-Datasheet.txt` line 63309).";

        field {
            name = "coef10";
            desc = "CSC coefficient. Its format is (s, 4, 10). The value consists of a 1-bit signed part, a 4-bit integer part, and a 10-bit decimal part.";
            sw = rw;
            hw = r;
            reset = 0x0;
        } coef10[31:17];

        field {
            name = "coef02";
            desc = "CSC coefficient. Its format is (s, 4, 10). The value consists of a 1-bit signed part, a 4-bit integer part, and a 10-bit decimal part.";
            sw = rw;
            hw = r;
            reset = 0x0;
        } coef02[15:1];
    } CH_CSC_COEF1 @ 0x1214;

    reg {
        name = "CSC coefficient register 2";
        desc = "CH_CSC_COEF2 is CSC coefficient register 2.

Data sheet 10.1.6 CH_CSC_COEF2 (offset 0x1218, printed page 10-79, `hi3516av100--Hi3516A-Hi3516D-Datasheet.txt` line 63336).";

        field {
            name = "coef12";
            desc = "CSC coefficient. Its format is (s, 4, 10). The value consists of a 1-bit signed part, a 4-bit integer part, and a 10-bit decimal part.";
            sw = rw;
            hw = r;
            reset = 0x0;
        } coef12[31:17];

        field {
            name = "coef11";
            desc = "CSC coefficient. Its format is (s, 4, 10). The value consists of a 1-bit signed part, a 4-bit integer part, and a 10-bit decimal part.";
            sw = rw;
            hw = r;
            reset = 0x0;
        } coef11[15:1];
    } CH_CSC_COEF2 @ 0x1218;

    reg {
        name = "CSC coefficient register 3";
        desc = "CH_CSC_COEF3 is CSC coefficient register 3.

Data sheet 10.1.6 CH_CSC_COEF3 (offset 0x121C, printed page 10-80, `hi3516av100--Hi3516A-Hi3516D-Datasheet.txt` line 63369).";

        field {
            name = "coef21";
            desc = "CSC coefficient. Its format is (s, 4, 10). The value consists of a 1-bit signed part, a 4-bit integer part, and a 10-bit decimal part.";
            sw = rw;
            hw = r;
            reset = 0x0;
        } coef21[31:17];

        field {
            name = "coef20";
            desc = "CSC coefficient. Its format is (s, 4, 10). The value consists of a 1-bit signed part, a 4-bit integer part, and a 10-bit decimal part.";
            sw = rw;
            hw = r;
            reset = 0x0;
        } coef20[15:1];
    } CH_CSC_COEF3 @ 0x121C;

    reg {
        name = "CSC coefficient register 4";
        desc = "CH_CSC_COEF4 is CSC coefficient register 4.

Data sheet 10.1.6 CH_CSC_COEF4 (offset 0x1220, printed page 10-80, `hi3516av100--Hi3516A-Hi3516D-Datasheet.txt` line 63396).";

        field {
            name = "coef22";
            desc = "CSC coefficient. Its format is (s, 4, 10). The value consists of a 1-bit signed part, a 4-bit integer part, and a 10-bit decimal part.";
            sw = rw;
            hw = r;
            reset = 0x0;
        } coef22[15:1];
    } CH_CSC_COEF4 @ 0x1220;

    reg {
        name = "CSC input DC component register 0";
        desc = "CH_CSC_IN_DC0 is CSC input DC component register 0.

Data sheet 10.1.6 CH_CSC_IN_DC0 (offset 0x1230, printed page 10-81, `hi3516av100--Hi3516A-Hi3516D-Datasheet.txt` line 63429).";

        field {
            name = "in_dc1";
            desc = "DC offset of the input G component, signed integer.";
            sw = rw;
            hw = r;
            reset = 0x0;
        } in_dc1[31:21];

        field {
            name = "in_dc0";
            desc = "DC offset of the input R component, signed integer.";
            sw = rw;
            hw = r;
            reset = 0x0;
        } in_dc0[15:5];
    } CH_CSC_IN_DC0 @ 0x1230;

    reg {
        name = "CSC input DC component register 1";
        desc = "CH_CSC_IN_DC1 is CSC input DC component register 1.

Data sheet 10.1.6 CH_CSC_IN_DC1 (offset 0x1234, printed page 10-81, `hi3516av100--Hi3516A-Hi3516D-Datasheet.txt` line 63450).";

        field {
            name = "in_dc2";
            desc = "DC offset of the input B component, signed integer.";
            sw = rw;
            hw = r;
            reset = 0x0;
        } in_dc2[15:5];
    } CH_CSC_IN_DC1 @ 0x1234;

    reg {
        name = "CSC output DC component register 0";
        desc = "CH_CSC_OUT_DC0 is CSC output DC component register 0. Huawei Proprietary and Confidential Hi3516A/Hi3516D Professional HD IP Camera SoC

Data sheet 10.1.6 CH_CSC_OUT_DC0 (offset 0x1238, printed page 10-82, `hi3516av100--Hi3516A-Hi3516D-Datasheet.txt` line 63481).";

        field {
            name = "out_dc1";
            desc = "DC offset of the output U component, signed integer.";
            sw = rw;
            hw = r;
            reset = 0x0;
        } out_dc1[31:21];

        field {
            name = "out_dc0";
            desc = "DC offset of the output Y component, signed integer.";
            sw = rw;
            hw = r;
            reset = 0x0;
        } out_dc0[15:5];
    } CH_CSC_OUT_DC0 @ 0x1238;

    reg {
        name = "CSC output DC component register 1";
        desc = "CH_CSC_OUT_DC1 is CSC output DC component register 1.

Data sheet 10.1.6 CH_CSC_OUT_DC1 (offset 0x123C, printed page 10-82, `hi3516av100--Hi3516A-Hi3516D-Datasheet.txt` line 63502).";

        field {
            name = "out_dc2";
            desc = "DC offset of the output V component, signed integer.";
            sw = rw;
            hw = r;
            reset = 0x0;
        } out_dc2[15:5];
    } CH_CSC_OUT_DC1 @ 0x123C;

    reg {
        name = "Dither configuration register";
        desc = "CH_DITHER_CFG is a dither configuration register. Huawei Proprietary and Confidential Hi3516A/Hi3516D Professional HD IP Camera SoC

Data sheet 10.1.6 CH_DITHER_CFG (offset 0x1300, printed page 10-83, `hi3516av100--Hi3516A-Hi3516D-Datasheet.txt` line 63533).";

        enum CH_DITHER_CFG_enable_f_enum {
            DISABLED = 0 { name = "Disabled"; desc = "disabled"; };
            ENABLED = 1 { name = "Enabled"; desc = "enabled"; };
        };

        field {
            name = "enable";
            desc = "Dither enable.";
            sw = rw;
            hw = r;
            encode = CH_DITHER_CFG_enable_f_enum;
            reset = 0x0;
        } enable_f[31:31];
    } CH_DITHER_CFG @ 0x1300;

    reg {
        name = "ACM control register";
        desc = "CH_ACM_CTRL is an ACM control register.

Data sheet 10.1.6 CH_ACM_CTRL (offset 0x1400, printed page 10-83, `hi3516av100--Hi3516A-Hi3516D-Datasheet.txt` line 63556).";

        enum CH_ACM_CTRL_acm_en_enum {
            DISABLED = 0 { name = "Disabled"; desc = "disabled (data output bypassed)"; };
            ENABLED = 1 { name = "Enabled"; desc = "enabled (implementing luminance and contrast adjustment)"; };
        };

        field {
            name = "acm_en";
            desc = "ACM enable.";
            sw = rw;
            hw = r;
            encode = CH_ACM_CTRL_acm_en_enum;
            reset = 0x0;
        } acm_en[31:31];

        field {
            name = "acm_dbg_en";
            desc = "ACM debug enable. When acm_dbg_en is valid, the original picture is displayed on the left part of the screen, and the picture processed by the ACM is displayed on the right part of the screen.";
            sw = rw;
            hw = r;
            reset = 0x0;
        } acm_dbg_en[30:30];

        enum CH_ACM_CTRL_acm_stretch_enum {
            Y_64_940 = 0 { name = "Y 64 940"; desc = "Y 64-940, C 64-960"; };
            Y_0_1023 = 1 { name = "Y 0 1023"; desc = "Y 0-1023, C 0-1023"; };
        };

        field {
            name = "acm_stretch";
            desc = "Input pixel range.";
            sw = rw;
            hw = r;
            encode = CH_ACM_CTRL_acm_stretch_enum;
            reset = 0x0;
        } acm_stretch[29:29];

        enum CH_ACM_CTRL_acm_cliprange_enum {
            Y_64_940 = 0 { name = "Y 64 940"; desc = "Y 64-940, C 64-960"; };
            Y_0_1023 = 1 { name = "Y 0 1023"; desc = "Y 0-1023, C 0-1023"; };
        };

        field {
            name = "acm_cliprange";
            desc = "Output pixel range.";
            sw = rw;
            hw = r;
            encode = CH_ACM_CTRL_acm_cliprange_enum;
            reset = 0x0;
        } acm_cliprange[28:28];

        enum CH_ACM_CTRL_acm_cliporwrap_enum {
            HUE_COMPONENT_WRAPPED = 0 { name = "Hue Component Wrapped"; desc = "The hue component is wrapped around to fall within [0, 1023]."; };
            HUE_COMPONENT_CLIPPED = 1 { name = "Hue Component Clipped"; desc = "The hue component is clipped to fall within [0, 1023]."; };
        };

        field {
            name = "acm_cliporwrap";
            desc = "Hue component limit after ACM.";
            sw = rw;
            hw = r;
            encode = CH_ACM_CTRL_acm_cliporwrap_enum;
            reset = 0x0;
        } acm_cliporwrap[27:27];

        field {
            name = "acm_cbcrthr";
            desc = "ACM algorithm enable threshold. It is a 9-bit unsigned number and ranges from 0 to 255.";
            sw = rw;
            hw = r;
            reset = 0x0;
        } acm_cbcrthr[7:0];
    } CH_ACM_CTRL @ 0x1400;

    reg {
        name = "ACM processed pixel change register";
        desc = "CH_ACM_ADJ is an ACM processed pixel change register.

Data sheet 10.1.6 CH_ACM_ADJ (offset 0x1404, printed page 10-84, `hi3516av100--Hi3516A-Hi3516D-Datasheet.txt` line 63609).";

        field {
            name = "acm_gain0";
            desc = "Control coefficient of the luminance adjustment range. The range is 0-512.";
            sw = rw;
            hw = r;
            reset = 0x0;
        } acm_gain0[29:20];

        field {
            name = "acm_gain1";
            desc = "Control coefficient of the hue adjustment range. The range is 0-512.";
            sw = rw;
            hw = r;
            reset = 0x0;
        } acm_gain1[19:10];

        field {
            name = "acm_gain2";
            desc = "Control coefficient of the saturation adjustment range. The range is 0-512.";
            sw = rw;
            hw = r;
            reset = 0x0;
        } acm_gain2[9:0];
    } CH_ACM_ADJ @ 0x1404;

    reg {
        name = "ACM processed picture size register";
        desc = "CH_ACM_SIZE is an ACM processed picture size register. Huawei Proprietary and Confidential Hi3516A/Hi3516D Professional HD IP Camera SoC

Data sheet 10.1.6 CH_ACM_SIZE (offset 0x1410, printed page 10-85, `hi3516av100--Hi3516A-Hi3516D-Datasheet.txt` line 63648).";

        field {
            name = "height";
            desc = "Picture height (in pixel). The configured value is the actual value minus 1.";
            sw = rw;
            hw = r;
            reset = 0x0;
        } height[28:16];

        field {
            name = "width";
            desc = "Picture width (in pixel). The configured value is the actual value minus 1.";
            sw = rw;
            hw = r;
            reset = 0x0;
        } width[12:0];
    } CH_ACM_SIZE @ 0x1410;

    reg {
        name = "ACM coefficient loading address configuration register";
        desc = "CH_ACM_PARA_ADDR is an ACM coefficient loading address configuration register.

Data sheet 10.1.6 CH_ACM_PARA_ADDR (offset 0x1414, printed page 10-85, `hi3516av100--Hi3516A-Hi3516D-Datasheet.txt` line 63675).";

        field {
            name = "acm_para_addr";
            desc = "Address for loading ACM coefficients.";
            sw = r;
            hw = w;
            reset = 0x0;
        } acm_para_addr[31:0];
    } CH_ACM_PARA_ADDR @ 0x1414;

    reg {
        name = "ACM parameter update register";
        desc = "CH_ACM_PARA_UP is an ACM parameter update register. Huawei Proprietary and Confidential Hi3516A/Hi3516D Professional HD IP Camera SoC

Data sheet 10.1.6 CH_ACM_PARA_UP (offset 0x1420, printed page 10-86, `hi3516av100--Hi3516A-Hi3516D-Datasheet.txt` line 63703).";

        field {
            name = "para_up";
            desc = "Parameter update. This bit is automatically cleared for each frame.";
            sw = rw;
            hw = r;
            reset = 0x0;
        } para_up[0:0];
    } CH_ACM_PARA_UP @ 0x1420;

    reg {
        name = "Y skip configuration register";
        desc = "CH_SKIP_Y_CFG is a Y skip configuration register.

Data sheet 10.1.6 CH_SKIP_Y_CFG (offset 0x1500, printed page 10-86, `hi3516av100--Hi3516A-Hi3516D-Datasheet.txt` line 63725).";

        field {
            name = "skip_cfg";
            desc = "Skip configuration.";
            sw = rw;
            hw = r;
            reset = 0xFFFFFFFF;
        } skip_cfg[31:0];
    } CH_SKIP_Y_CFG @ 0x1500;

    reg {
        name = "C component skip configuration register";
        desc = "CH_SKIP_C_CFG is a C component skip configuration register.

Data sheet 10.1.6 CH_SKIP_C_CFG (offset 0x1510, printed page 10-86, `hi3516av100--Hi3516A-Hi3516D-Datasheet.txt` line 63743).";

        field {
            name = "skip_cfg";
            desc = "Skip configuration.";
            sw = rw;
            hw = r;
            reset = 0xFFFFFFFF;
        } skip_cfg[31:0];
    } CH_SKIP_C_CFG @ 0x1510;

    reg {
        name = "Horizontal chrominance down sampling configuration register";
        desc = "CH_HCDS_CFG is a horizontal chrominance down sampling configuration register.

Data sheet 10.1.6 CH_HCDS_CFG (offset 0x1600, printed page 10-87, `hi3516av100--Hi3516A-Hi3516D-Datasheet.txt` line 63767).";

        enum CH_HCDS_CFG_cds_en_enum {
            DISABLED = 0 { name = "Disabled"; desc = "disabled"; };
            ENABLED = 1 { name = "Enabled"; desc = "enabled"; };
        };

        field {
            name = "cds_en";
            desc = "Down sampling enable.";
            sw = rw;
            hw = r;
            encode = CH_HCDS_CFG_cds_en_enum;
            reset = 0x0;
        } cds_en[31:31];
    } CH_HCDS_CFG @ 0x1600;

    reg {
        name = "Horizontal chrominance down sampling offset register";
        desc = "CH_HCDS_OFFSET is a horizontal chrominance down sampling offset register.

Data sheet 10.1.6 CH_HCDS_OFFSET (offset 0x1604, printed page 10-87, `hi3516av100--Hi3516A-Hi3516D-Datasheet.txt` line 63790).";

        field {
            name = "hcds_offset";
            desc = "Horizontal chrominance start position offset in the format of (s, 7, 20). That is, the offset value consists of a 1-bit signed part, 7-bit integer part, and 20-bit decimal part. The value is expressed as a two's complement and ranges from -6 to +15.";
            sw = rw;
            hw = r;
            reset = 0x0;
        } hcds_offset[27:0];
    } CH_HCDS_OFFSET @ 0x1604;

    reg {
        name = "Horizontal chrominance down sampling input size configuration register";
        desc = "CH_HCDS_IN_SIZE is a horizontal chrominance down sampling input size configuration register. Huawei Proprietary and Confidential Hi3516A/Hi3516D Professional HD IP Camera SoC

Data sheet 10.1.6 CH_HCDS_IN_SIZE (offset 0x1610, printed page 10-88, `hi3516av100--Hi3516A-Hi3516D-Datasheet.txt` line 63824).";

        field {
            name = "width";
            desc = "Width (in pixel) of a picture chrominance line. The configured value is the actual value minus 1.";
            sw = rw;
            hw = r;
            reset = 0x4FF;
        } width[12:0];
    } CH_HCDS_IN_SIZE @ 0x1610;

    reg {
        name = "Horizontal chrominance down sampling output size configuration register";
        desc = "CH_HCDS_OUT_SIZE is a horizontal chrominance down sampling output size configuration register.

Data sheet 10.1.6 CH_HCDS_OUT_SIZE (offset 0x1614, printed page 10-88, `hi3516av100--Hi3516A-Hi3516D-Datasheet.txt` line 63846).";

        field {
            name = "width";
            desc = "Width (in pixel) of a picture chrominance line. The configured value is the actual value minus 1.";
            sw = rw;
            hw = r;
            reset = 0x4FF;
        } width[12:0];
    } CH_HCDS_OUT_SIZE @ 0x1614;

    reg {
        name = "Horizontal chrominance down sampling coefficient register 0";
        desc = "CH_HCDS_COEF0 is horizontal chrominance down sampling coefficient register 0.

Data sheet 10.1.6 CH_HCDS_COEF0 (offset 0x1620, printed page 10-89, `hi3516av100--Hi3516A-Hi3516D-Datasheet.txt` line 63873).";

        field {
            name = "coef2";
            desc = "Horizontal chrominance scaling and filtering coefficient 2";
            sw = rw;
            hw = r;
            reset = 0x0;
        } coef2[29:20];

        field {
            name = "coef1";
            desc = "Horizontal chrominance scaling and filtering coefficient 1.";
            sw = rw;
            hw = r;
            reset = 0x0;
        } coef1[19:10];

        field {
            name = "coef0";
            desc = "Horizontal chrominance scaling and filtering coefficient 0. Horizontal scaling contains eight taps, and the sum of the eight coefficients is 512.";
            sw = rw;
            hw = r;
            reset = 0x0;
        } coef0[9:0];
    } CH_HCDS_COEF0 @ 0x1620;

    reg {
        name = "CH_HCDS_COEF1";
        desc = "CH_HCDS_COEF1 horizontal chrominance down sampling coefficient register 1.

Data sheet 10.1.6 CH_HCDS_COEF1 (offset 0x1624, printed page 10-89, `hi3516av100--Hi3516A-Hi3516D-Datasheet.txt` line 63898).";

        field {
            name = "coef5";
            desc = "Horizontal chrominance scaling and filtering coefficient 5.";
            sw = rw;
            hw = r;
            reset = 0x0;
        } coef5[29:20];

        field {
            name = "coef4";
            desc = "Horizontal chrominance scaling and filtering coefficient 4.";
            sw = rw;
            hw = r;
            reset = 0x0;
        } coef4[19:10];

        field {
            name = "coef3";
            desc = "Horizontal chrominance scaling and filtering coefficient 3.";
            sw = rw;
            hw = r;
            reset = 0x0;
        } coef3[9:0];
    } CH_HCDS_COEF1 @ 0x1624;

    reg {
        name = "CH_HCDS_COEF2";
        desc = "CH_HCDS_COEF2 horizontal chrominance down sampling coefficient register 2.

Data sheet 10.1.6 CH_HCDS_COEF2 (offset 0x1628, printed page 10-90, `hi3516av100--Hi3516A-Hi3516D-Datasheet.txt` line 63927).";

        field {
            name = "coef7";
            desc = "Horizontal chrominance scaling and filtering coefficient 7.";
            sw = rw;
            hw = r;
            reset = 0x0;
        } coef7[19:10];

        field {
            name = "coef6";
            desc = "Horizontal chrominance scaling and filtering coefficient 6.";
            sw = rw;
            hw = r;
            reset = 0x0;
        } coef6[9:0];
    } CH_HCDS_COEF2 @ 0x1628;

    reg {
        name = "Vertical chrominance down sampling configuration register for large streams";
        desc = "CH_VCDS_CFG is a vertical chrominance down sampling configuration register for large streams.

Data sheet 10.1.6 CH_VCDS_CFG (offset 0x1700, printed page 10-90, `hi3516av100--Hi3516A-Hi3516D-Datasheet.txt` line 63948).";

        enum CH_VCDS_CFG_enable_f_enum {
            DISABLED = 0 { name = "Disabled"; desc = "disabled"; };
            ENABLED = 1 { name = "Enabled"; desc = "enabled"; };
        };

        field {
            name = "enable";
            desc = "Down scaling enable.";
            sw = r;
            hw = w;
            encode = CH_VCDS_CFG_enable_f_enum;
            reset = 0x0;
        } enable_f[31:31];
    } CH_VCDS_CFG @ 0x1700;

    reg {
        name = "Vertical chrominance down sampling coefficient register for large streams";
        desc = "CH_VCDS_COEF is a vertical chrominance down sampling coefficient register for large streams. Huawei Proprietary and Confidential Hi3516A/Hi3516D Professional HD IP Camera SoC

Data sheet 10.1.6 CH_VCDS_COEF (offset 0x1704, printed page 10-91, `hi3516av100--Hi3516A-Hi3516D-Datasheet.txt` line 63982).";

        field {
            name = "coef1";
            desc = "Down sampling coefficient 1.";
            sw = rw;
            hw = r;
            reset = 0x0;
        } coef1[20:16];

        field {
            name = "coef0";
            desc = "Down sampling coefficient 0.";
            sw = rw;
            hw = r;
            reset = 0x1F;
        } coef0[4:0];
    } CH_VCDS_COEF @ 0x1704;

    reg {
        name = "Luminance clamp configuration register";
        desc = "CH_CLIP_Y_CFG is a luminance clamp configuration register.

Data sheet 10.1.6 CH_CLIP_Y_CFG (offset 0x1800, printed page 10-91, `hi3516av100--Hi3516A-Hi3516D-Datasheet.txt` line 64003).";

        field {
            name = "max";
            desc = "Maximum luminance value. When the data bit width is less than 16 bits, the upper bits are valid.";
            sw = rw;
            hw = r;
            reset = 0xFFFF;
        } max[31:16];

        field {
            name = "min";
            desc = "Minimum luminance value. When the data bit width is less than 16 bits, the upper bits are valid.";
            sw = rw;
            hw = r;
            reset = 0x0;
        } min[15:0];
    } CH_CLIP_Y_CFG @ 0x1800;

    reg {
        name = "Chrominance clamp configuration register";
        desc = "CH_CLIP_C_CFG is a chrominance clamp configuration register. Huawei Proprietary and Confidential Hi3516A/Hi3516D Professional HD IP Camera SoC

Data sheet 10.1.6 CH_CLIP_C_CFG (offset 0x1804, printed page 10-92, `hi3516av100--Hi3516A-Hi3516D-Datasheet.txt` line 64036).";

        field {
            name = "max";
            desc = "Maximum chrominance value. When the data bit width is less than 16 bits, the upper bits are valid.";
            sw = rw;
            hw = r;
            reset = 0xFFFF;
        } max[31:16];

        field {
            name = "min";
            desc = "Minimum chrominance value. When the data bit width is less than 16 bits, the upper bits are valid.";
            sw = rw;
            hw = r;
            reset = 0x0;
        } min[15:0];
    } CH_CLIP_C_CFG @ 0x1804;

    reg {
        name = "UV2C_CFG configuration register";
        desc = "CH_UV2C_CFG is a UV2C_CFG configuration register.

Data sheet 10.1.6 CH_UV2C_CFG (offset 0x1900, printed page 10-92, `hi3516av100--Hi3516A-Hi3516D-Datasheet.txt` line 64059).";

        enum CH_UV2C_CFG_enable_f_enum {
            DISABLED = 0 { name = "Disabled"; desc = "disabled"; };
            ENABLED = 1 { name = "Enabled"; desc = "enabled"; };
        };

        field {
            name = "enable";
            desc = "UV2C enable for converting the internal UV components into the single C component.";
            sw = rw;
            hw = r;
            encode = CH_UV2C_CFG_enable_f_enum;
            reset = 0x1;
        } enable_f[31:31];
    } CH_UV2C_CFG @ 0x1900;

    reg {
        name = "CH_DIS enable register";
        desc = "CH_DIS_CFG is a CH_DIS enable register. Huawei Proprietary and Confidential Hi3516A/Hi3516D Professional HD IP Camera SoC

Data sheet 10.1.6 CH_DIS_CFG (offset 0x1A00, printed page 10-93, `hi3516av100--Hi3516A-Hi3516D-Datasheet.txt` line 64095).";

        enum CH_DIS_CFG_close_clk_enum {
            NORMAL = 0 { name = "Normal"; desc = "normal"; };
            DIS_CORE_CLOCK = 1 { name = "Dis Core Clock"; desc = "DIS core clock disabled (excluding the CPI)"; };
        };

        field {
            name = "close_clk";
            desc = "Clock disable.";
            sw = rw;
            hw = r;
            encode = CH_DIS_CFG_close_clk_enum;
            reset = 0x0;
        } close_clk[31:31];

        enum CH_DIS_CFG_work_en_enum {
            DISABLED = 0 { name = "Disabled"; desc = "disabled"; };
            ENABLED = 1 { name = "Enabled"; desc = "enabled"; };
        };

        field {
            name = "work_en";
            desc = "DIS enable.";
            sw = rw;
            hw = r;
            encode = CH_DIS_CFG_work_en_enum;
            reset = 0x0;
        } work_en[0:0];
    } CH_DIS_CFG @ 0x1A00;

    reg {
        name = "CH_DIS block configuration register";
        desc = "CH_DIS_BLK is a CH_DIS block configuration register.

Data sheet 10.1.6 CH_DIS_BLK (offset 0x1A04, printed page 10-93, `hi3516av100--Hi3516A-Hi3516D-Datasheet.txt` line 64123).";

        field {
            name = "srch_range";
            desc = "Search range. The value is an even number ranging from 8 to 128.";
            sw = rw;
            hw = r;
            reset = 0x0;
        } srch_range[23:16];

        field {
            name = "blk_size";
            desc = "Side length of the square block. The value is an even number ranging from 16 to 256.";
            sw = rw;
            hw = r;
            reset = 0x0;
        } blk_size[8:0];
    } CH_DIS_BLK @ 0x1A04;

    reg {
        name = "CH_DIS vertical PRJ0 block address register";
        desc = "CH_DIS_V0POS is a CH_DIS vertical PRJ0 block address register.

Data sheet 10.1.6 CH_DIS_V0POS (offset 0x1A10, printed page 10-94, `hi3516av100--Hi3516A-Hi3516D-Datasheet.txt` line 64159).";

        field {
            name = "ver";
            desc = "Vertical coordinate of the vertical PRJ0 block. The least significant bit (LSB) of the coordinate value is excluded, and one bit is subtracted.";
            sw = rw;
            hw = r;
            reset = 0x0;
        } ver[26:16];

        field {
            name = "hor";
            desc = "Horizontal coordinate of the vertical PRJ0 block. The LSB of the coordinate value is excluded, and one bit is subtracted.";
            sw = rw;
            hw = r;
            reset = 0x0;
        } hor[10:0];
    } CH_DIS_V0POS @ 0x1A10;

    reg {
        name = "CH_DIS vertical PRJ4 block address register";
        desc = "CH_DIS_V4POS is a CH_DIS vertical PRJ4 block address register.

Data sheet 10.1.6 CH_DIS_V4POS (offset 0x1A14, printed page 10-94, `hi3516av100--Hi3516A-Hi3516D-Datasheet.txt` line 64184).";

        field {
            name = "ver";
            desc = "Vertical coordinate of the vertical PRJ4 block. The LSB of the coordinate value is excluded, and one bit is subtracted.";
            sw = rw;
            hw = r;
            reset = 0x0;
        } ver[26:16];

        field {
            name = "hor";
            desc = "Horizontal coordinate of the vertical PRJ4 block. The LSB of the coordinate value is excluded, and one bit is subtracted.";
            sw = rw;
            hw = r;
            reset = 0x0;
        } hor[10:0];
    } CH_DIS_V4POS @ 0x1A14;

    reg {
        name = "CH_DIS vertical PRJ8 block address register";
        desc = "CH_DIS_V8POS is a CH_DIS vertical PRJ8 block address register. Huawei Proprietary and Confidential Hi3516A/Hi3516D Professional HD IP Camera SoC

Data sheet 10.1.6 CH_DIS_V8POS (offset 0x1A18, printed page 10-95, `hi3516av100--Hi3516A-Hi3516D-Datasheet.txt` line 64218).";

        field {
            name = "ver";
            desc = "Vertical coordinate of the vertical PRJ8 block. The LSB of the coordinate value is excluded, and one bit is subtracted.";
            sw = rw;
            hw = r;
            reset = 0x0;
        } ver[26:16];

        field {
            name = "hor";
            desc = "Horizontal coordinate of the vertical PRJ8 block. The LSB of the coordinate value is excluded, and one bit is subtracted.";
            sw = rw;
            hw = r;
            reset = 0x0;
        } hor[10:0];
    } CH_DIS_V8POS @ 0x1A18;

    reg {
        name = "CH_DIS vertical PRJ0 block address register";
        desc = "CH_DIS_V0POSE is a CH_DIS vertical PRJ0 block address register.

Data sheet 10.1.6 CH_DIS_V0POSE (offset 0x1A20, printed page 10-95, `hi3516av100--Hi3516A-Hi3516D-Datasheet.txt` line 64243).";

        field {
            name = "ver";
            desc = "Vertical coordinate of the end point of the vertical PRJ0 block. The LSB of the coordinate value is excluded, and one bit is subtracted.";
            sw = rw;
            hw = r;
            reset = 0x0;
        } ver[26:16];

        field {
            name = "hor";
            desc = "Horizontal coordinate of the end point of the vertical PRJ0 block. The LSB of the coordinate value is excluded, and one bit is subtracted.";
            sw = rw;
            hw = r;
            reset = 0x0;
        } hor[10:0];
    } CH_DIS_V0POSE @ 0x1A20;

    reg {
        name = "CH_DIS vertical PRJ4 block address register";
        desc = "CH_DIS_V4POSE is a CH_DIS vertical PRJ4 block address register. Huawei Proprietary and Confidential Hi3516A/Hi3516D Professional HD IP Camera SoC

Data sheet 10.1.6 CH_DIS_V4POSE (offset 0x1A24, printed page 10-96, `hi3516av100--Hi3516A-Hi3516D-Datasheet.txt` line 64278).";

        field {
            name = "ver";
            desc = "Vertical coordinate of the end point of the vertical PRJ4 block. The LSB of the coordinate value is excluded, and one bit is subtracted.";
            sw = rw;
            hw = r;
            reset = 0x0;
        } ver[26:16];

        field {
            name = "hor";
            desc = "Horizontal coordinate of the end point of the vertical PRJ4 block. The LSB of the coordinate value is excluded, and one bit is subtracted.";
            sw = rw;
            hw = r;
            reset = 0x0;
        } hor[10:0];
    } CH_DIS_V4POSE @ 0x1A24;

    reg {
        name = "CH_DIS vertical PRJ8 block address register";
        desc = "CH_DIS_V8POSE is a CH_DIS vertical PRJ8 block address register.

Data sheet 10.1.6 CH_DIS_V8POSE (offset 0x1A28, printed page 10-96, `hi3516av100--Hi3516A-Hi3516D-Datasheet.txt` line 64303).";

        field {
            name = "ver";
            desc = "Vertical coordinate of the end point of the vertical PRJ8 block. The LSB of the coordinate value is excluded, and one bit is subtracted.";
            sw = rw;
            hw = r;
            reset = 0x0;
        } ver[26:16];

        field {
            name = "hor";
            desc = "Horizontal coordinate of the end point of the vertical PRJ8 block. The LSB of the coordinate value is excluded, and one bit is subtracted.";
            sw = rw;
            hw = r;
            reset = 0x0;
        } hor[10:0];
    } CH_DIS_V8POSE @ 0x1A28;

    reg {
        name = "CH_DIS horizontal PRJ0 block address register";
        desc = "CH_DIS_H0POS is a CH_DIS horizontal PRJ0 block address register. Huawei Proprietary and Confidential Hi3516A/Hi3516D Professional HD IP Camera SoC

Data sheet 10.1.6 CH_DIS_H0POS (offset 0x1A30, printed page 10-97, `hi3516av100--Hi3516A-Hi3516D-Datasheet.txt` line 64338).";

        field {
            name = "ver";
            desc = "Vertical coordinate of the horizontal PRJ0 block. The LSB of the coordinate value is excluded, and one bit is subtracted.";
            sw = rw;
            hw = r;
            reset = 0x0;
        } ver[26:16];

        field {
            name = "hor";
            desc = "Horizontal coordinate of the horizontal PRJ0 block. The LSB of the coordinate value is excluded, and one bit is subtracted.";
            sw = rw;
            hw = r;
            reset = 0x0;
        } hor[10:0];
    } CH_DIS_H0POS @ 0x1A30;

    reg {
        name = "CH_DIS horizontal PRJ4 block address register";
        desc = "CH_DIS_H4POS is a CH_DIS horizontal PRJ4 block address register.

Data sheet 10.1.6 CH_DIS_H4POS (offset 0x1A34, printed page 10-97, `hi3516av100--Hi3516A-Hi3516D-Datasheet.txt` line 64363).";

        field {
            name = "ver";
            desc = "Vertical coordinate of the horizontal PRJ4 block. The LSB of the coordinate value is excluded, and one bit is subtracted.";
            sw = rw;
            hw = r;
            reset = 0x0;
        } ver[26:16];

        field {
            name = "hor";
            desc = "Horizontal coordinate of the horizontal PRJ4 block. The LSB of the coordinate value is excluded, and one bit is subtracted.";
            sw = rw;
            hw = r;
            reset = 0x0;
        } hor[10:0];
    } CH_DIS_H4POS @ 0x1A34;

    reg {
        name = "CH_DIS horizontal PRJ8 block address register";
        desc = "CH_DIS_H8POS is a CH_DIS horizontal PRJ8 block address register. Huawei Proprietary and Confidential Hi3516A/Hi3516D Professional HD IP Camera SoC

Data sheet 10.1.6 CH_DIS_H8POS (offset 0x1A38, printed page 10-98, `hi3516av100--Hi3516A-Hi3516D-Datasheet.txt` line 64398).";

        field {
            name = "ver";
            desc = "Vertical coordinate of the horizontal PRJ8 block. The LSB of the coordinate value is excluded, and one bit is subtracted.";
            sw = rw;
            hw = r;
            reset = 0x0;
        } ver[26:16];

        field {
            name = "hor";
            desc = "Horizontal coordinate of the horizontal PRJ8 block. The LSB of the coordinate value is excluded, and one bit is subtracted.";
            sw = rw;
            hw = r;
            reset = 0x0;
        } hor[10:0];
    } CH_DIS_H8POS @ 0x1A38;

    reg {
        name = "CH_DIS horizontal PRJ0 block address register";
        desc = "CH_DIS_H0POSE is a CH_DIS horizontal PRJ0 block address register.

Data sheet 10.1.6 CH_DIS_H0POSE (offset 0x1A40, printed page 10-98, `hi3516av100--Hi3516A-Hi3516D-Datasheet.txt` line 64423).";

        field {
            name = "ver";
            desc = "Vertical coordinate of the end point of the horizontal PRJ0 block. The LSB of the coordinate value is excluded, and one bit is subtracted.";
            sw = rw;
            hw = r;
            reset = 0x0;
        } ver[26:16];

        field {
            name = "hor";
            desc = "Horizontal coordinate of the end point of the horizontal PRJ0 block. The LSB of the coordinate value is excluded, and one bit is subtracted.";
            sw = rw;
            hw = r;
            reset = 0x0;
        } hor[10:0];
    } CH_DIS_H0POSE @ 0x1A40;

    reg {
        name = "CH_DIS horizontal PRJ4 block address register";
        desc = "CH_DIS_H4POSE is a CH_DIS horizontal PRJ4 block address register. Huawei Proprietary and Confidential Hi3516A/Hi3516D Professional HD IP Camera SoC

Data sheet 10.1.6 CH_DIS_H4POSE (offset 0x1A44, printed page 10-99, `hi3516av100--Hi3516A-Hi3516D-Datasheet.txt` line 64458).";

        field {
            name = "ver";
            desc = "Vertical coordinate of the end point of the horizontal PRJ4 block. The LSB of the coordinate value is excluded, and one bit is subtracted.";
            sw = rw;
            hw = r;
            reset = 0x0;
        } ver[26:16];

        field {
            name = "hor";
            desc = "Horizontal coordinate of the end point of the horizontal PRJ4 block. The LSB of the coordinate value is excluded, and one bit is subtracted.";
            sw = rw;
            hw = r;
            reset = 0x0;
        } hor[10:0];
    } CH_DIS_H4POSE @ 0x1A44;

    reg {
        name = "CH_DIS horizontal PRJ8 block address register";
        desc = "CH_DIS_H8POSE is a CH_DIS horizontal PRJ8 block address register.

Data sheet 10.1.6 CH_DIS_H8POSE (offset 0x1A48, printed page 10-99, `hi3516av100--Hi3516A-Hi3516D-Datasheet.txt` line 64483).";

        field {
            name = "ver";
            desc = "Vertical coordinate of the end point of the horizontal PRJ8 block. The LSB of the coordinate value is excluded, and one bit is subtracted.";
            sw = rw;
            hw = r;
            reset = 0x0;
        } ver[26:16];

        field {
            name = "hor";
            desc = "Horizontal coordinate of the end point of the horizontal PRJ8 block. The LSB of the coordinate value is excluded, and one bit is subtracted.";
            sw = rw;
            hw = r;
            reset = 0x0;
        } hor[10:0];
    } CH_DIS_H8POSE @ 0x1A48;

    reg {
        name = "Vertical DIS statistics register for all CH_DIS blocks";
        desc = "CH_DIS_VSTAT is a vertical DIS statistics register for all CH_DIS blocks. Huawei Proprietary and Confidential Hi3516A/Hi3516D Professional HD IP Camera SoC

Data sheet 10.1.6 CH_DIS_VSTAT (offset 0x1B00, printed page 10-100, `hi3516av100--Hi3516A-Hi3516D-Datasheet.txt` line 64518).";

        enum CH_DIS_VSTAT_dis_vstat_enum {
            V_DELTA_15 = 0x1900 { name = "V Delta 15"; desc = "v_delta[15:0] of block 1"; };
            V_SAD_23 = 0x1904 { name = "V Sad 23"; desc = "v_sad[23:0] of block 1"; };
            V_MV_8 = 0x1908 { name = "V Mv 8"; desc = "v_mv[8:0] of block 1 The same rule applies to other addresses."; };
        };

        field {
            name = "dis_vstat";
            desc = "v_delta, v_sad, and v_mv information about each block. Each address contains only one piece of information. For example:";
            sw = r;
            hw = w;
            encode = CH_DIS_VSTAT_dis_vstat_enum;
            reset = 0x0;
        } dis_vstat[31:0];
    } CH_DIS_VSTAT[27] @ 0x1B00 += 0x4;

    reg {
        name = "Horizontal DIS statistics register for all CH_DIS blocks";
        desc = "CH_DIS_HSTAT is a horizontal DIS statistics register for all CH_DIS blocks.

Data sheet 10.1.6 CH_DIS_HSTAT (offset 0x1B80, printed page 10-100, `hi3516av100--Hi3516A-Hi3516D-Datasheet.txt` line 64542).";

        enum CH_DIS_HSTAT_dis_hstat_enum {
            H_DELTA_15 = 0x1980 { name = "H Delta 15"; desc = "h_delta[15:0] of block 1"; };
            H_SAD_23 = 0x1984 { name = "H Sad 23"; desc = "h_sad[23:0] of block 1"; };
            H_MV_8 = 0x1988 { name = "H Mv 8"; desc = "h_mv[8:0] of block 1 The same rule applies to other addresses."; };
        };

        field {
            name = "dis_hstat";
            desc = "h_delta, h_sad, and h_mv information about each block. Each address contains only one piece of information. For example:";
            sw = r;
            hw = w;
            encode = CH_DIS_HSTAT_dis_hstat_enum;
            reset = 0x0;
        } dis_hstat[31:0];
    } CH_DIS_HSTAT[27] @ 0x1B80 += 0x4;

    reg {
        name = "DCI control register";
        desc = "CH_VPDCICTRL is a DCI control register. Huawei Proprietary and Confidential Hi3516A/Hi3516D Professional HD IP Camera SoC

Data sheet 10.1.6 CH_VPDCICTRL (offset 0x1C00, printed page 10-101, `hi3516av100--Hi3516A-Hi3516D-Datasheet.txt` line 64576).";

        enum CH_VPDCICTRL_dci_en_enum {
            DISABLED = 0 { name = "Disabled"; desc = "disabled (data output bypassed)"; };
            ENABLED = 1 { name = "Enabled"; desc = "enabled (implementing luminance and contrast adjustment)"; };
        };

        field {
            name = "dci_en";
            desc = "DCI enable.";
            sw = rw;
            hw = r;
            encode = CH_VPDCICTRL_dci_en_enum;
            reset = 0x0;
        } dci_en[31:31];

        enum CH_VPDCICTRL_dci_dbg_en_enum {
            DISABLED = 0 { name = "Disabled"; desc = "disabled"; };
            ORIGINAL_PICTURE_DISPLAYED = 1 { name = "Original Picture Displayed"; desc = "The original picture is displayed on the left part of the screen, and the picture processed by the DCI is displayed on the right part of the screen."; };
        };

        field {
            name = "dci_dbg_en";
            desc = "DCI demo mode enable.";
            sw = rw;
            hw = r;
            encode = CH_VPDCICTRL_dci_dbg_en_enum;
            reset = 0x0;
        } dci_dbg_en[30:30];

        enum CH_VPDCICTRL_dci_scene_flg_enum {
            DISABLED = 0 { name = "Disabled"; desc = "disabled"; };
            ENABLED = 1 { name = "Enabled"; desc = "enabled"; };
        };

        field {
            name = "dci_scene_flg";
            desc = "DCI scenario switch enable.";
            sw = rw;
            hw = r;
            encode = CH_VPDCICTRL_dci_scene_flg_enum;
            reset = 0x0;
        } dci_scene_flg[29:29];

        enum CH_VPDCICTRL_dci_man_adj0_enum {
            AUTOMATIC_MODE = 0 { name = "Automatic Mode"; desc = "automatic mode (the results calculated by hardware are used)"; };
            MANUAL_MODE = 1 { name = "Manual Mode"; desc = "manual mode (the results calculated by software are used)"; };
        };

        field {
            name = "dci_man_adj0";
            desc = "Adjustment mode of curve 0.";
            sw = rw;
            hw = r;
            encode = CH_VPDCICTRL_dci_man_adj0_enum;
            reset = 0x0;
        } dci_man_adj0[28:28];

        enum CH_VPDCICTRL_dci_man_adj1_enum {
            AUTOMATIC_MODE = 0 { name = "Automatic Mode"; desc = "automatic mode (the results calculated by hardware are used)"; };
            MANUAL_MODE = 1 { name = "Manual Mode"; desc = "manual mode (the results calculated by software are used)"; };
        };

        field {
            name = "dci_man_adj1";
            desc = "Adjustment mode of curve 1.";
            sw = rw;
            hw = r;
            encode = CH_VPDCICTRL_dci_man_adj1_enum;
            reset = 0x0;
        } dci_man_adj1[27:27];

        enum CH_VPDCICTRL_dci_man_adj2_enum {
            AUTOMATIC_MODE = 0 { name = "Automatic Mode"; desc = "automatic mode (the results calculated by hardware are used)"; };
            MANUAL_MODE = 1 { name = "Manual Mode"; desc = "manual mode (the results calculated by software are used)"; };
        };

        field {
            name = "dci_man_adj2";
            desc = "Adjustment mode of curve 2.";
            sw = rw;
            hw = r;
            encode = CH_VPDCICTRL_dci_man_adj2_enum;
            reset = 0x0;
        } dci_man_adj2[26:26];

        enum CH_VPDCICTRL_dci_cbcrcmp_en_enum {
            DCI_ALGORITHM_DOES = 0 { name = "Dci Algorithm Does"; desc = "The DCI algorithm does not adjust the chrominance component."; };
            DCI_ALGORITHM_ADJUSTS = 1 { name = "Dci Algorithm Adjusts"; desc = "The DCI algorithm adjusts the chrominance component."; };
        };

        field {
            name = "dci_cbcrcmp_en";
            desc = "DCI chrominance compensation enable.";
            sw = rw;
            hw = r;
            encode = CH_VPDCICTRL_dci_cbcrcmp_en_enum;
            reset = 0x0;
        } dci_cbcrcmp_en[25:25];

        enum CH_VPDCICTRL_dci_cbcrsta_en_enum {
            HISTOGRAM_STATISTICS_COLLECTED = 0 { name = "Histogram Statistics Collected"; desc = "Histogram statistics are collected only on the luminance component."; };
            HISTOGRAM_STATISTICS_COLLECTED_2 = 1 { name = "Histogram Statistics Collected 2"; desc = "Histogram statistics are collected on weighted YCbCr components."; };
        };

        field {
            name = "dci_cbcrsta_en";
            desc = "Histogram statistics select.";
            sw = rw;
            hw = r;
            encode = CH_VPDCICTRL_dci_cbcrsta_en_enum;
            reset = 0x0;
        } dci_cbcrsta_en[24:24];

        enum CH_VPDCICTRL_dci_in_range_enum {
            LIMIT_RANGE = 0 { name = "Limit Range"; desc = "limit range (Y 64-940 and C 64-960 for the input 10-bit pixel data)"; };
            FULL_RANGE = 1 { name = "Full Range"; desc = "full range (Y 0-1023 and C 0-1023 for the input 10-bit pixel data)"; };
        };

        field {
            name = "dci_in_range";
            desc = "Input range.";
            sw = rw;
            hw = r;
            encode = CH_VPDCICTRL_dci_in_range_enum;
            reset = 0x0;
        } dci_in_range[23:23];

        enum CH_VPDCICTRL_dci_out_range_enum {
            LIMIT_RANGE = 0 { name = "Limit Range"; desc = "limit range (Y 64-940 and C 64-960 for the output 10-bit pixel data)"; };
            FULL_RANGE = 1 { name = "Full Range"; desc = "full range (Y 0-1023 and C 0-1023 for the output 10-bit pixel data)"; };
        };

        field {
            name = "dci_out_range";
            desc = "Output range.";
            sw = rw;
            hw = r;
            encode = CH_VPDCICTRL_dci_out_range_enum;
            reset = 0x0;
        } dci_out_range[22:22];

        enum CH_VPDCICTRL_dci_shift_ctrl_enum {
            SHIFTED_RIGHTWARDS_6 = 0 { name = "Shifted Rightwards 6"; desc = "shifted rightwards by 6 bits"; };
            SHIFTED_RIGHTWARDS_7 = 1 { name = "Shifted Rightwards 7"; desc = "shifted rightwards by 7 bits"; };
            SHIFTED_RIGHTWARDS_8 = 2 { name = "Shifted Rightwards 8"; desc = "shifted rightwards by 8 bits"; };
            SHIFTED_RIGHTWARDS_9 = 3 { name = "Shifted Rightwards 9"; desc = "shifted rightwards by 9 bits"; };
        };

        field {
            name = "dci_shift_ctrl";
            desc = "DCI histogram statistics shift control.";
            sw = rw;
            hw = r;
            encode = CH_VPDCICTRL_dci_shift_ctrl_enum;
            reset = 0x0;
        } dci_shift_ctrl[21:20];

        enum CH_VPDCICTRL_dci_histlpf_en_enum {
            DISABLED = 0 { name = "Disabled"; desc = "disabled"; };
            ENABLED = 1 { name = "Enabled"; desc = "enabled"; };
        };

        field {
            name = "dci_histlpf_en";
            desc = "Histogram low-pass filter enable.";
            sw = rw;
            hw = r;
            encode = CH_VPDCICTRL_dci_histlpf_en_enum;
            reset = 0x0;
        } dci_histlpf_en[19:19];
    } CH_VPDCICTRL @ 0x1C00;

    reg {
        name = "DCI algorithm horizontal adjustment region register";
        desc = "CH_VPDCIHPOS is a DCI algorithm horizontal adjustment region register.

Data sheet 10.1.6 CH_VPDCIHPOS (offset 0x1C04, printed page 10-102, `hi3516av100--Hi3516A-Hi3516D-Datasheet.txt` line 64659).";

        field {
            name = "dci_hstart";
            desc = "Start value of the DCI algorithm horizontal active region.";
            sw = rw;
            hw = r;
            reset = 0x0;
        } dci_hstart[31:20];

        field {
            name = "dci_hend";
            desc = "End value of the DCI algorithm horizontal active region.";
            sw = rw;
            hw = r;
            reset = 0x0;
        } dci_hend[19:8];
    } CH_VPDCIHPOS @ 0x1C04;

    reg {
        name = "DCI algorithm vertical adjustment region register";
        desc = "CH_VPDCIVPOS is a DCI algorithm vertical adjustment region register. Huawei Proprietary and Confidential Hi3516A/Hi3516D Professional HD IP Camera SoC

Data sheet 10.1.6 CH_VPDCIVPOS (offset 0x1C08, printed page 10-103, `hi3516av100--Hi3516A-Hi3516D-Datasheet.txt` line 64689).";

        field {
            name = "dci_vstart";
            desc = "Start value of the DCI algorithm vertical active region.";
            sw = rw;
            hw = r;
            reset = 0x0;
        } dci_vstart[31:20];

        field {
            name = "dci_vend";
            desc = "End value of the DCI algorithm vertical active region.";
            sw = rw;
            hw = r;
            reset = 0x0;
        } dci_vend[19:8];
    } CH_VPDCIVPOS @ 0x1C08;

    reg {
        name = "DCI histogram statistics weighted coefficient register";
        desc = "CH_VPDCIHISBLD is a DCI histogram statistics weighted coefficient register.

Data sheet 10.1.6 CH_VPDCIHISBLD (offset 0x1C0C, printed page 10-103, `hi3516av100--Hi3516A-Hi3516D-Datasheet.txt` line 64709).";

        field {
            name = "dci_cbcrsta_y";
            desc = "dci_cbcrsta_y";
            sw = rw;
            hw = r;
            reset = 0x0;
        } dci_cbcrsta_y[31:24];

        field {
            name = "dci_cbcrsta_cb";
            desc = "Weighted coefficient of the Y component when histogram statistics are added. It is an 8-bit signed number and the MSB is the signed bit. Weighted coefficient of the Cb component when histogram statistics are added. It is an 8-bit signed number and the MSB is the signed bit.";
            sw = rw;
            hw = r;
            reset = 0x0;
        } dci_cbcrsta_cb[23:16];

        field {
            name = "dci_cbcrsta_cr";
            desc = "Weighted coefficient of the Cr component when histogram statistics are added. It is an 8-bit signed number and the MSB is the signed bit.";
            sw = rw;
            hw = r;
            reset = 0x0;
        } dci_cbcrsta_cr[15:8];
    } CH_VPDCIHISBLD @ 0x1C0C;

    reg {
        name = "DCI histogram statistics offset register";
        desc = "CH_VPDCIHISOFT is a DCI histogram statistics offset register. Huawei Proprietary and Confidential Hi3516A/Hi3516D Professional HD IP Camera SoC

Data sheet 10.1.6 CH_VPDCIHISOFT (offset 0x1C10, printed page 10-104, `hi3516av100--Hi3516A-Hi3516D-Datasheet.txt` line 64746).";

        field {
            name = "dci_cbcrsta_oft";
            desc = "dci_cbcrsta_oft";
            sw = rw;
            hw = r;
            reset = 0x0;
        } dci_cbcrsta_oft[31:23];
    } CH_VPDCIHISOFT @ 0x1C10;

    reg {
        name = "DCI histogram coring register";
        desc = "CH_VPDCIHISCOR is a DCI histogram coring register.

Data sheet 10.1.6 CH_VPDCIHISCOR (offset 0x1C14, printed page 10-104, `hi3516av100--Hi3516A-Hi3516D-Datasheet.txt` line 64767).";

        field {
            name = "dci_histcor_thr0";
            desc = "Coring threshold for histogram 0.";
            sw = rw;
            hw = r;
            reset = 0x0;
        } dci_histcor_thr0[31:24];

        field {
            name = "dci_histcor_thr1";
            desc = "Coring threshold for histogram 1.";
            sw = rw;
            hw = r;
            reset = 0x0;
        } dci_histcor_thr1[23:16];

        field {
            name = "dci_histcor_thr2";
            desc = "Coring threshold for histogram 2.";
            sw = rw;
            hw = r;
            reset = 0x0;
        } dci_histcor_thr2[15:8];
    } CH_VPDCIHISCOR @ 0x1C14;

    reg {
        name = "Blend value register for the DCI adjustment unit";
        desc = "CH_VPDCIMERBLD is a blend value register for the DCI adjustment unit. Huawei Proprietary and Confidential Hi3516A/Hi3516D Professional HD IP Camera SoC

Data sheet 10.1.6 CH_VPDCIMERBLD (offset 0x1C18, printed page 10-105, `hi3516av100--Hi3516A-Hi3516D-Datasheet.txt` line 64798).";

        field {
            name = "dci_metrc_abld0";
            desc = "Weighted alpha blend value of the current frame for metric 0.";
            sw = rw;
            hw = r;
            reset = 0x0;
        } dci_metrc_abld0[31:26];

        field {
            name = "dci_metrc_abld1";
            desc = "Weighted alpha blend value of the current frame for metric 1.";
            sw = rw;
            hw = r;
            reset = 0x0;
        } dci_metrc_abld1[25:20];

        field {
            name = "dci_metrc_abld2";
            desc = "Weighted alpha blend value of the current frame for metric 2.";
            sw = rw;
            hw = r;
            reset = 0x0;
        } dci_metrc_abld2[19:14];

        field {
            name = "dci_hist_abld";
            desc = "Weighted alpha blend value of the current histogram and the previous histogram.";
            sw = rw;
            hw = r;
            reset = 0x0;
        } dci_hist_abld[13:8];

        field {
            name = "dci_org_abld";
            desc = "Alpha blend value when the luminance component is adjusted.";
            sw = rw;
            hw = r;
            reset = 0x0;
        } dci_org_abld[7:2];
    } CH_VPDCIMERBLD @ 0x1C18;

    reg {
        name = "DCI manually configured curve weight register";
        desc = "CH_VPDCIADJWGT is a DCI manually configured curve weight register.

Data sheet 10.1.6 CH_VPDCIADJWGT (offset 0x1C1C, printed page 10-105, `hi3516av100--Hi3516A-Hi3516D-Datasheet.txt` line 64825).";

        field {
            name = "dci_man_adjwgt0";
            desc = "Weighted value of curve 0 in manual mode.";
            sw = rw;
            hw = r;
            reset = 0x0;
        } dci_man_adjwgt0[31:24];

        field {
            name = "dci_man_adjwgt1";
            desc = "Weighted value of curve 1 in manual mode.";
            sw = rw;
            hw = r;
            reset = 0x0;
        } dci_man_adjwgt1[23:16];

        field {
            name = "dci_man_adjwgt2";
            desc = "Weighted value of curve 2 in manual mode.";
            sw = rw;
            hw = r;
            reset = 0x0;
        } dci_man_adjwgt2[15:8];
    } CH_VPDCIADJWGT @ 0x1C1C;

    reg {
        name = "DCI curve 0 weight range register";
        desc = "CH_VPDCICLIP0 is a DCI curve 0 weight range register. Huawei Proprietary and Confidential Hi3516A/Hi3516D Professional HD IP Camera SoC

Data sheet 10.1.6 CH_VPDCICLIP0 (offset 0x1C20, printed page 10-106, `hi3516av100--Hi3516A-Hi3516D-Datasheet.txt` line 64856).";

        field {
            name = "dci_wgt_cliplow0";
            desc = "Lower limit of the weighted value of curve 0.";
            sw = rw;
            hw = r;
            reset = 0x0;
        } dci_wgt_cliplow0[31:24];

        field {
            name = "dci_wgt_cliphigh0";
            desc = "Upper limit of the weighted value of curve 0.";
            sw = rw;
            hw = r;
            reset = 0x0;
        } dci_wgt_cliphigh0[23:16];
    } CH_VPDCICLIP0 @ 0x1C20;

    reg {
        name = "DCI curve 1 weight range register";
        desc = "CH_VPDCICLIP1 is a DCI curve 1 weight range register.

Data sheet 10.1.6 CH_VPDCICLIP1 (offset 0x1C24, printed page 10-106, `hi3516av100--Hi3516A-Hi3516D-Datasheet.txt` line 64876).";

        field {
            name = "dci_wgt_cliplow1";
            desc = "Lower limit of the weighted value of curve 1.";
            sw = rw;
            hw = r;
            reset = 0x0;
        } dci_wgt_cliplow1[31:24];

        field {
            name = "dci_wgt_cliphigh1";
            desc = "Upper limit of the weighted value of curve 1.";
            sw = rw;
            hw = r;
            reset = 0x0;
        } dci_wgt_cliphigh1[23:16];
    } CH_VPDCICLIP1 @ 0x1C24;

    reg {
        name = "DCI curve 2 weight range register";
        desc = "CH_VPDCICLIP2 is a DCI curve 2 weight range register.

Data sheet 10.1.6 CH_VPDCICLIP2 (offset 0x1C28, printed page 10-106, `hi3516av100--Hi3516A-Hi3516D-Datasheet.txt` line 64896).";

        field {
            name = "dci_wgt_cliplow2";
            desc = "Lower limit of the weighted value of curve 2.";
            sw = rw;
            hw = r;
            reset = 0x0;
        } dci_wgt_cliplow2[31:24];

        field {
            name = "dci_wgt_cliphigh2";
            desc = "Upper limit of the weighted value of curve 2.";
            sw = rw;
            hw = r;
            reset = 0x0;
        } dci_wgt_cliphigh2[23:16];
    } CH_VPDCICLIP2 @ 0x1C28;

    reg {
        name = "Global gain register for the DCI luminance adjustment unit";
        desc = "CH_VPDCIGLBGAIN is a global gain register for the DCI luminance adjustment unit.

Data sheet 10.1.6 CH_VPDCIGLBGAIN (offset 0x1C2C, printed page 10-107, `hi3516av100--Hi3516A-Hi3516D-Datasheet.txt` line 64926).";

        field {
            name = "dci_glb_gain0";
            desc = "Global gain 0 when the luminance component is adjusted.";
            sw = rw;
            hw = r;
            reset = 0x0;
        } dci_glb_gain0[31:26];

        field {
            name = "dci_glb_gain1";
            desc = "Global gain 1 when the luminance component is adjusted.";
            sw = rw;
            hw = r;
            reset = 0x0;
        } dci_glb_gain1[25:20];

        field {
            name = "dci_glb_gain2";
            desc = "Global gain 2 when the luminance component is adjusted.";
            sw = rw;
            hw = r;
            reset = 0x0;
        } dci_glb_gain2[19:14];
    } CH_VPDCIGLBGAIN @ 0x1C2C;

    reg {
        name = "Positive adjustment threshold register 0 for the DCI adjustment unit";
        desc = "CH_VPDCIPOSTHR0 is positive adjustment threshold register 0 for the DCI adjustment unit.

Data sheet 10.1.6 CH_VPDCIPOSTHR0 (offset 0x1C30, printed page 10-107, `hi3516av100--Hi3516A-Hi3516D-Datasheet.txt` line 64947).";

        field {
            name = "dci_gainpos_thr1";
            desc = "Threshold 1 for luminance Y when the picture is adjusted from dark to bright.";
            sw = rw;
            hw = r;
            reset = 0x0;
        } dci_gainpos_thr1[31:24];

        field {
            name = "dci_gainpos_thr2";
            desc = "Threshold 2 for luminance Y when the picture is adjusted from dark to bright.";
            sw = rw;
            hw = r;
            reset = 0x0;
        } dci_gainpos_thr2[23:16];

        field {
            name = "dci_gainpos_thr3";
            desc = "Threshold 3 for luminance Y when the picture is adjusted from dark to bright.";
            sw = rw;
            hw = r;
            reset = 0x0;
        } dci_gainpos_thr3[15:8];

        field {
            name = "dci_gainpos_thr4";
            desc = "Threshold 4 for luminance Y when the picture is adjusted from dark to bright.";
            sw = rw;
            hw = r;
            reset = 0x0;
        } dci_gainpos_thr4[7:0];
    } CH_VPDCIPOSTHR0 @ 0x1C30;

    reg {
        name = "Positive adjustment threshold register 1 for the DCI adjustment unit";
        desc = "CH_VPDCIPOSTHR1 is positive adjustment threshold register 1 for the DCI adjustment unit.

Data sheet 10.1.6 CH_VPDCIPOSTHR1 (offset 0x1C34, printed page 10-108, `hi3516av100--Hi3516A-Hi3516D-Datasheet.txt` line 64982).";

        field {
            name = "dci_gainpos_thr5";
            desc = "Threshold 5 for luminance Y when the picture is adjusted from dark to bright.";
            sw = rw;
            hw = r;
            reset = 0x0;
        } dci_gainpos_thr5[31:24];

        field {
            name = "dci_gainpos_thr6";
            desc = "Threshold 6 for luminance Y when the picture is adjusted from dark to bright.";
            sw = rw;
            hw = r;
            reset = 0x0;
        } dci_gainpos_thr6[23:16];

        field {
            name = "dci_gainpos_thr7";
            desc = "Threshold 7 for luminance Y when the picture is adjusted from dark to bright.";
            sw = rw;
            hw = r;
            reset = 0x0;
        } dci_gainpos_thr7[15:8];
    } CH_VPDCIPOSTHR1 @ 0x1C34;

    reg {
        name = "Positive adjustment gain register 0 for the DCI adjustment unit";
        desc = "CH_VPDCIPOSGAIN0 is positive adjustment gain register 0 for the DCI adjustment unit.

Data sheet 10.1.6 CH_VPDCIPOSGAIN0 (offset 0x1C38, printed page 10-108, `hi3516av100--Hi3516A-Hi3516D-Datasheet.txt` line 65009).";

        field {
            name = "dci_gainpos_cbcr0";
            desc = "Chrominance compensation gain of threshold 0 when the picture is adjusted from dark to bright.";
            sw = rw;
            hw = r;
            reset = 0x0;
        } dci_gainpos_cbcr0[31:28];

        field {
            name = "dci_gainpos_cbcr1";
            desc = "Chrominance compensation gain of threshold 1 when the picture is adjusted from dark to bright.";
            sw = rw;
            hw = r;
            reset = 0x0;
        } dci_gainpos_cbcr1[27:24];

        field {
            name = "dci_gainpos_cbcr2";
            desc = "Chrominance compensation gain of threshold 2 when the picture is adjusted from dark to bright.";
            sw = rw;
            hw = r;
            reset = 0x0;
        } dci_gainpos_cbcr2[23:20];

        field {
            name = "dci_gainpos_cbcr3";
            desc = "Chrominance compensation gain of threshold 3 when the picture is adjusted from dark to bright.";
            sw = rw;
            hw = r;
            reset = 0x0;
        } dci_gainpos_cbcr3[19:16];

        field {
            name = "dci_gainpos_cbcr4";
            desc = "Chrominance compensation gain of threshold 4 when the picture is adjusted from dark to bright.";
            sw = rw;
            hw = r;
            reset = 0x0;
        } dci_gainpos_cbcr4[15:12];

        field {
            name = "dci_gainpos_cbcr5";
            desc = "Chrominance compensation gain of threshold 5 when the picture is adjusted from dark to bright.";
            sw = rw;
            hw = r;
            reset = 0x0;
        } dci_gainpos_cbcr5[11:8];

        field {
            name = "dci_gainpos_cbcr6";
            desc = "Chrominance compensation gain of threshold 6 when the picture is adjusted from dark to bright.";
            sw = rw;
            hw = r;
            reset = 0x0;
        } dci_gainpos_cbcr6[7:4];

        field {
            name = "dci_gainpos_cbcr7";
            desc = "Chrominance compensation gain of threshold 7 when the picture is adjusted from dark to bright.";
            sw = rw;
            hw = r;
            reset = 0x0;
        } dci_gainpos_cbcr7[3:0];
    } CH_VPDCIPOSGAIN0 @ 0x1C38;

    reg {
        name = "Positive adjustment gain register 1 for the DCI adjustment unit";
        desc = "CH_VPDCIPOSGAIN1 is positive adjustment gain register 1 for the DCI adjustment unit.

Data sheet 10.1.6 CH_VPDCIPOSGAIN1 (offset 0x1C3C, printed page 10-109, `hi3516av100--Hi3516A-Hi3516D-Datasheet.txt` line 65063).";

        field {
            name = "dci_gainpos_cbcr8";
            desc = "Chrominance compensation gain of threshold 8 when the picture is adjusted from dark to bright.";
            sw = rw;
            hw = r;
            reset = 0x0;
        } dci_gainpos_cbcr8[31:28];
    } CH_VPDCIPOSGAIN1 @ 0x1C3C;

    reg {
        name = "Positive adjustment slope register 0 for the DCI adjustment unit";
        desc = "CH_VPDCIPOSSLP0 is positive adjustment slope register 0 for the DCI adjustment unit.

Data sheet 10.1.6 CH_VPDCIPOSSLP0 (offset 0x1C40, printed page 10-109, `hi3516av100--Hi3516A-Hi3516D-Datasheet.txt` line 65086).";

        field {
            name = "dci_gainpos_slp0";
            desc = "Slope of region 1 when the picture is adjusted from dark to bright. It is a 10-bit signed number.";
            sw = rw;
            hw = r;
            reset = 0x0;
        } dci_gainpos_slp0[31:22];

        field {
            name = "dci_gainpos_slp1";
            desc = "Slope of region 2 when the picture is adjusted from dark to bright. It is a 10-bit signed number.";
            sw = rw;
            hw = r;
            reset = 0x0;
        } dci_gainpos_slp1[21:12];

        field {
            name = "dci_gainpos_slp2";
            desc = "Slope of region 3 when the picture is adjusted from dark to bright. It is a 10-bit signed number.";
            sw = rw;
            hw = r;
            reset = 0x0;
        } dci_gainpos_slp2[11:2];
    } CH_VPDCIPOSSLP0 @ 0x1C40;

    reg {
        name = "Positive adjustment slope register 1 for the DCI adjustment unit";
        desc = "CH_VPDCIPOSSLP1 is positive adjustment slope register 1 for the DCI adjustment unit.

Data sheet 10.1.6 CH_VPDCIPOSSLP1 (offset 0x1C44, printed page 10-110, `hi3516av100--Hi3516A-Hi3516D-Datasheet.txt` line 65126).";

        field {
            name = "dci_gainpos_slp3";
            desc = "Slope of region 4 when the picture is adjusted from dark to bright. It is a 10-bit signed number.";
            sw = rw;
            hw = r;
            reset = 0x0;
        } dci_gainpos_slp3[31:22];

        field {
            name = "dci_gainpos_slp4";
            desc = "Slope of region 5 when the picture is adjusted from dark to bright. It is a 10-bit signed number.";
            sw = rw;
            hw = r;
            reset = 0x0;
        } dci_gainpos_slp4[21:12];

        field {
            name = "dci_gainpos_slp5";
            desc = "Slope of region 6 when the picture is adjusted from dark to bright. It is a 10-bit signed number.";
            sw = rw;
            hw = r;
            reset = 0x0;
        } dci_gainpos_slp5[11:2];
    } CH_VPDCIPOSSLP1 @ 0x1C44;

    reg {
        name = "Positive adjustment slope register 2 for the DCI adjustment unit";
        desc = "CH_VPDCIPOSSLP2 is positive adjustment slope register 2 for the DCI adjustment unit.

Data sheet 10.1.6 CH_VPDCIPOSSLP2 (offset 0x1C48, printed page 10-110, `hi3516av100--Hi3516A-Hi3516D-Datasheet.txt` line 65156).";

        field {
            name = "dci_gainpos_slp6";
            desc = "Slope of region 7 when the picture is adjusted from dark to bright. It is a 10-bit signed number.";
            sw = rw;
            hw = r;
            reset = 0x0;
        } dci_gainpos_slp6[31:22];

        field {
            name = "dci_gainpos_slp7";
            desc = "Slope of region 8 when the picture is adjusted from dark to bright.";
            sw = rw;
            hw = r;
            reset = 0x0;
        } dci_gainpos_slp7[21:12];
    } CH_VPDCIPOSSLP2 @ 0x1C48;

    reg {
        name = "Negative adjustment threshold register 0 of the DCI adjustment unit";
        desc = "CH_VPDCINEGTHR0 is negative adjustment threshold register 0 of the DCI adjustment unit.

Data sheet 10.1.6 CH_VPDCINEGTHR0 (offset 0x1C4C, printed page 10-111, `hi3516av100--Hi3516A-Hi3516D-Datasheet.txt` line 65188).";

        field {
            name = "dci_gainneg_thr1";
            desc = "Threshold 1 for luminance Y when the picture is adjusted from bright to dark.";
            sw = rw;
            hw = r;
            reset = 0x0;
        } dci_gainneg_thr1[31:24];

        field {
            name = "dci_gainneg_thr2";
            desc = "Threshold 2 for luminance Y when the picture is adjusted from bright to dark.";
            sw = rw;
            hw = r;
            reset = 0x0;
        } dci_gainneg_thr2[23:16];

        field {
            name = "dci_gainneg_thr3";
            desc = "Threshold 3 for luminance Y when the picture is adjusted from bright to dark.";
            sw = rw;
            hw = r;
            reset = 0x0;
        } dci_gainneg_thr3[15:8];

        field {
            name = "dci_gainneg_thr4";
            desc = "Threshold 4 for luminance Y when the picture is adjusted from bright to dark.";
            sw = rw;
            hw = r;
            reset = 0x0;
        } dci_gainneg_thr4[7:0];
    } CH_VPDCINEGTHR0 @ 0x1C4C;

    reg {
        name = "Negative adjustment threshold register 1 of the DCI adjustment unit";
        desc = "CH_VPDCINEGTHR1 is negative adjustment threshold register 1 of the DCI adjustment unit.

Data sheet 10.1.6 CH_VPDCINEGTHR1 (offset 0x1C50, printed page 10-111, `hi3516av100--Hi3516A-Hi3516D-Datasheet.txt` line 65217).";

        field {
            name = "dci_gainneg_thr5";
            desc = "Threshold 5 for luminance Y when the picture is adjusted from bright to dark.";
            sw = rw;
            hw = r;
            reset = 0x0;
        } dci_gainneg_thr5[31:24];

        field {
            name = "dci_gainneg_thr6";
            desc = "Threshold 6 for luminance Y when the picture is adjusted from bright to dark.";
            sw = rw;
            hw = r;
            reset = 0x0;
        } dci_gainneg_thr6[23:16];

        field {
            name = "dci_gainneg_thr7";
            desc = "Threshold 7 for luminance Y when the picture is adjusted from bright to dark.";
            sw = rw;
            hw = r;
            reset = 0x0;
        } dci_gainneg_thr7[15:8];
    } CH_VPDCINEGTHR1 @ 0x1C50;

    reg {
        name = "Negative adjustment gain register 0 for the DCI adjustment unit";
        desc = "CH_VPDCINEGGAIN0 is negative adjustment gain register 0 for the DCI adjustment unit.

Data sheet 10.1.6 CH_VPDCINEGGAIN0 (offset 0x1C54, printed page 10-112, `hi3516av100--Hi3516A-Hi3516D-Datasheet.txt` line 65254).";

        field {
            name = "dci_gainneg_cbcr0";
            desc = "Chrominance compensation gain of threshold 0 when the picture is adjusted from bright to dark.";
            sw = rw;
            hw = r;
            reset = 0x0;
        } dci_gainneg_cbcr0[31:28];

        field {
            name = "dci_gainneg_cbcr1";
            desc = "Chrominance compensation gain of threshold 1 when the picture is adjusted from bright to dark.";
            sw = rw;
            hw = r;
            reset = 0x0;
        } dci_gainneg_cbcr1[27:24];

        field {
            name = "dci_gainneg_cbcr2";
            desc = "Chrominance compensation gain of threshold 2 when the picture is adjusted from bright to dark.";
            sw = rw;
            hw = r;
            reset = 0x0;
        } dci_gainneg_cbcr2[23:20];

        field {
            name = "dci_gainneg_cbcr3";
            desc = "Chrominance compensation gain of threshold 3 when the picture is adjusted from bright to dark.";
            sw = rw;
            hw = r;
            reset = 0x0;
        } dci_gainneg_cbcr3[19:16];

        field {
            name = "dci_gainneg_cbcr4";
            desc = "Chrominance compensation gain of threshold 4 when the picture is adjusted from bright to dark.";
            sw = rw;
            hw = r;
            reset = 0x0;
        } dci_gainneg_cbcr4[15:12];

        field {
            name = "dci_gainneg_cbcr5";
            desc = "Chrominance compensation gain of threshold 5 when the picture is adjusted from bright to dark.";
            sw = rw;
            hw = r;
            reset = 0x0;
        } dci_gainneg_cbcr5[11:8];

        field {
            name = "dci_gainneg_cbcr6";
            desc = "Chrominance compensation gain of threshold 6 when the picture is adjusted from bright to dark.";
            sw = rw;
            hw = r;
            reset = 0x0;
        } dci_gainneg_cbcr6[7:4];

        field {
            name = "dci_gainneg_cbcr7";
            desc = "Chrominance compensation gain of threshold 7 when the picture is adjusted from bright to dark.";
            sw = rw;
            hw = r;
            reset = 0x0;
        } dci_gainneg_cbcr7[3:0];
    } CH_VPDCINEGGAIN0 @ 0x1C54;

    reg {
        name = "Negative adjustment gain register 1 for the DCI adjustment unit";
        desc = "CH_VPDCINEGGAIN1 is negative adjustment gain register 1 for the DCI adjustment unit. Huawei Proprietary and Confidential Hi3516A/Hi3516D Professional HD IP Camera SoC

Data sheet 10.1.6 CH_VPDCINEGGAIN1 (offset 0x1C58, printed page 10-113, `hi3516av100--Hi3516A-Hi3516D-Datasheet.txt` line 65307).";

        field {
            name = "dci_gainneg_cbcr8";
            desc = "Chrominance compensation gain of threshold 8 when the picture is adjusted from bright to dark.";
            sw = rw;
            hw = r;
            reset = 0x0;
        } dci_gainneg_cbcr8[31:28];
    } CH_VPDCINEGGAIN1 @ 0x1C58;

    reg {
        name = "Negative adjustment slope register 0 for the DCI adjustment unit";
        desc = "CH_VPDCINEGSLP0 is negative adjustment slope register 0 for the DCI adjustment unit.

Data sheet 10.1.6 CH_VPDCINEGSLP0 (offset 0x1C5C, printed page 10-113, `hi3516av100--Hi3516A-Hi3516D-Datasheet.txt` line 65330).";

        field {
            name = "dci_gainneg_slp0";
            desc = "Slope of region 1 when the picture is adjusted from bright to dark. It is a 10-bit signed number.";
            sw = rw;
            hw = r;
            reset = 0x0;
        } dci_gainneg_slp0[31:22];

        field {
            name = "dci_gainneg_slp1";
            desc = "Slope of region 2 when the picture is adjusted from bright to dark. It is a 10-bit signed number.";
            sw = rw;
            hw = r;
            reset = 0x0;
        } dci_gainneg_slp1[21:12];

        field {
            name = "dci_gainneg_slp2";
            desc = "Slope of region 3 when the picture is adjusted from bright to dark. It is a 10-bit signed number.";
            sw = rw;
            hw = r;
            reset = 0x0;
        } dci_gainneg_slp2[11:2];
    } CH_VPDCINEGSLP0 @ 0x1C5C;

    reg {
        name = "Negative adjustment slope register 1 for the DCI adjustment unit";
        desc = "CH_VPDCINEGSLP1 is negative adjustment slope register 1 for the DCI adjustment unit. Huawei Proprietary and Confidential Hi3516A/Hi3516D Professional HD IP Camera SoC

Data sheet 10.1.6 CH_VPDCINEGSLP1 (offset 0x1C60, printed page 10-114, `hi3516av100--Hi3516A-Hi3516D-Datasheet.txt` line 65369).";

        field {
            name = "dci_gainneg_slp3";
            desc = "Slope of region 4 when the picture is adjusted from bright to dark. It is a 10-bit signed number.";
            sw = rw;
            hw = r;
            reset = 0x0;
        } dci_gainneg_slp3[31:22];

        field {
            name = "dci_gainneg_slp4";
            desc = "Slope of region 5 when the picture is adjusted from bright to dark. It is a 10-bit signed number.";
            sw = rw;
            hw = r;
            reset = 0x0;
        } dci_gainneg_slp4[21:12];

        field {
            name = "dci_gainneg_slp5";
            desc = "Slope of region 6 when the picture is adjusted from bright to dark. It is a 10-bit signed number.";
            sw = rw;
            hw = r;
            reset = 0x0;
        } dci_gainneg_slp5[11:2];
    } CH_VPDCINEGSLP1 @ 0x1C60;

    reg {
        name = "Negative adjustment slope register 2 for the DCI adjustment unit";
        desc = "CH_VPDCINEGSLP2 is negative adjustment slope register 2 for the DCI adjustment unit.

Data sheet 10.1.6 CH_VPDCINEGSLP2 (offset 0x1C64, printed page 10-114, `hi3516av100--Hi3516A-Hi3516D-Datasheet.txt` line 65398).";

        field {
            name = "dci_gainneg_slp6";
            desc = "Slope of region 7 when the picture is adjusted from bright to dark. It is a 10-bit signed number.";
            sw = rw;
            hw = r;
            reset = 0x0;
        } dci_gainneg_slp6[31:22];

        field {
            name = "dci_gainneg_slp7";
            desc = "Slope of region 8 when the picture is adjusted from bright to dark. It is a 10-bit signed number.";
            sw = rw;
            hw = r;
            reset = 0x0;
        } dci_gainneg_slp7[21:12];
    } CH_VPDCINEGSLP2 @ 0x1C64;

    reg {
        name = "Split enable register";
        desc = "CH_SPLIT_CFG is a split enable register. Huawei Proprietary and Confidential Hi3516A/Hi3516D Professional HD IP Camera SoC

Data sheet 10.1.6 CH_SPLIT_CFG (offset 0x1E00, printed page 10-115, `hi3516av100--Hi3516A-Hi3516D-Datasheet.txt` line 65432).";

        enum CH_SPLIT_CFG_en_enum {
            DISABLED = 0 { name = "Disabled"; desc = "disabled"; };
            ENABLED = 1 { name = "Enabled"; desc = "enabled"; };
        };

        field {
            name = "en";
            desc = "Split enable.";
            sw = rw;
            hw = r;
            encode = CH_SPLIT_CFG_en_enum;
            reset = 0x0;
        } en[0:0];
    } CH_SPLIT_CFG @ 0x1E00;

    reg {
        name = "Split version register";
        desc = "CH_SPLIT_VERSION is a split version register.

Data sheet 10.1.6 CH_SPLIT_VERSION (offset 0x1E0C, printed page 10-115, `hi3516av100--Hi3516A-Hi3516D-Datasheet.txt` line 65453).";

        field {
            name = "version";
            desc = "Split version.";
            sw = r;
            hw = w;
            reset = 0x0;
        } version[31:0];
    } CH_SPLIT_VERSION @ 0x1E0C;

    reg {
        name = "Split configuration register";
        desc = "CH_SPLIT_DATA_CFG is a split configuration register. Huawei Proprietary and Confidential Hi3516A/Hi3516D Professional HD IP Camera SoC

Data sheet 10.1.6 CH_SPLIT_DATA_CFG (offset 0x1E10, printed page 10-116, `hi3516av100--Hi3516A-Hi3516D-Datasheet.txt` line 65481).";

        field {
            name = "dc_data";
            desc = "Split data DC component.";
            sw = rw;
            hw = r;
            reset = 0x0;
        } dc_data[22:16];

        enum CH_SPLIT_DATA_CFG_data_sel_enum {
            DATA_0 = 0 { name = "Data 0"; desc = "data 0"; };
            DATA_1 = 1 { name = "Data 1"; desc = "data 1"; };
            DATA_2 = 2 { name = "Data 2"; desc = "data 2"; };
            DATA_0_2 = 3 { name = "Data 0 2"; desc = "data 0"; };
        };

        field {
            name = "data_sel";
            desc = "Data component to be split.";
            sw = rw;
            hw = r;
            encode = CH_SPLIT_DATA_CFG_data_sel_enum;
            reset = 0x0;
        } data_sel[11:10];

        field {
            name = "split_en";
            desc = "Data split enable.";
            sw = rw;
            hw = r;
            reset = 0x0;
        } split_en[9:9];

        enum CH_SPLIT_DATA_CFG_ex_yuv_en_enum {
            YUV_OUTPUT = 0 { name = "Yuv Output"; desc = "YUV output"; };
            YVU_OUTPUT = 1 { name = "Yvu Output"; desc = "YVU output"; };
            UYV_OUTPUT = 2 { name = "Uyv Output"; desc = "UYV output"; };
            UVY_OUTPUT = 3 { name = "Uvy Output"; desc = "UVY output"; };
            VYU_OUTPUT = 4 { name = "Vyu Output"; desc = "VYU output"; };
            VUY_OUTPUT_OTHER = 5 { name = "Vuy Output Other"; desc = "VUY output Other values: YUV output"; };
        };

        field {
            name = "ex_yuv_en";
            desc = "YUV sequence of split data.";
            sw = rw;
            hw = r;
            encode = CH_SPLIT_DATA_CFG_ex_yuv_en_enum;
            reset = 0x0;
        } ex_yuv_en[8:6];

        field {
            name = "ex_v_en";
            desc = "Exchange with the adjacent data of the split V channel (data cannot be repeatedly exchanged, and data is exchanged every two data segments). 0: disabled 1: enabled Exchange with the adjacent data of the split U channel (data cannot be repeatedly exchanged, and data is exchanged every two data segments). 0: disabled 1: enabled";
            sw = rw;
            hw = r;
            reset = 0x0;
        } ex_v_en[5:5];

        field {
            name = "ex_u_en";
            desc = "ex_u_en";
            sw = rw;
            hw = r;
            reset = 0x0;
        } ex_u_en[4:4];

        enum CH_SPLIT_DATA_CFG_ex_y_en_enum {
            DISABLED = 0 { name = "Disabled"; desc = "disabled"; };
            ENABLED = 1 { name = "Enabled"; desc = "enabled"; };
        };

        field {
            name = "ex_y_en";
            desc = "Exchange with the adjacent data of the split Y channel (data cannot be repeatedly exchanged, and data is exchanged every two data segments).";
            sw = rw;
            hw = r;
            encode = CH_SPLIT_DATA_CFG_ex_y_en_enum;
            reset = 0x0;
        } ex_y_en[3:3];

        enum CH_SPLIT_DATA_CFG_replace_v_en_enum {
            DISABLED = 0 { name = "Disabled"; desc = "disabled"; };
            ENABLED = 1 { name = "Enabled"; desc = "enabled"; };
        };

        field {
            name = "replace_v_en";
            desc = "Split data storage enable (stored in the V channel)";
            sw = rw;
            hw = r;
            encode = CH_SPLIT_DATA_CFG_replace_v_en_enum;
            reset = 0x0;
        } replace_v_en[2:2];

        enum CH_SPLIT_DATA_CFG_replace_u_en_enum {
            DISABLED = 0 { name = "Disabled"; desc = "disabled"; };
            ENABLED = 1 { name = "Enabled"; desc = "enabled"; };
        };

        field {
            name = "replace_u_en";
            desc = "Split data storage enable (stored in the U channel)";
            sw = rw;
            hw = r;
            encode = CH_SPLIT_DATA_CFG_replace_u_en_enum;
            reset = 0x0;
        } replace_u_en[1:1];

        enum CH_SPLIT_DATA_CFG_replace_y_en_enum {
            DISABLED = 0 { name = "Disabled"; desc = "disabled"; };
            ENABLED = 1 { name = "Enabled"; desc = "enabled"; };
        };

        field {
            name = "replace_y_en";
            desc = "Split data storage enable (stored in the Y channel)";
            sw = rw;
            hw = r;
            encode = CH_SPLIT_DATA_CFG_replace_y_en_enum;
            reset = 0x0;
        } replace_y_en[0:0];
    } CH_SPLIT_DATA_CFG @ 0x1E10;

    reg {
        name = "Split data version register";
        desc = "CH_SPLIT_DATA_VERSION is a split data version register.

Data sheet 10.1.6 CH_SPLIT_DATA_VERSION (offset 0x1E14, printed page 10-117, `hi3516av100--Hi3516A-Hi3516D-Datasheet.txt` line 65558).";

        field {
            name = "data_version";
            desc = "Split data version.";
            sw = rw;
            hw = r;
            reset = 0x0;
        } data_version[15:0];
    } CH_SPLIT_DATA_VERSION @ 0x1E14;

    reg {
        name = "Split data bit width register";
        desc = "CH_SPLIT_DATA_BITWIDTH is a split data bit width register. Huawei Proprietary and Confidential Hi3516A/Hi3516D Professional HD IP Camera SoC

Data sheet 10.1.6 CH_SPLIT_DATA_BITWIDTH (offset 0x1E18, printed page 10-118, `hi3516av100--Hi3516A-Hi3516D-Datasheet.txt` line 65587).";

        field {
            name = "data_bitw";
            desc = "Bit width of split data.";
            sw = rw;
            hw = r;
            reset = 0x0;
        } data_bitw[15:0];
    } CH_SPLIT_DATA_BITWIDTH @ 0x1E18;

    reg {
        name = "Split register update control register";
        desc = "CH_SPLIT_CTRL_I is a split register update control register.

Data sheet 10.1.6 CH_SPLIT_CTRL_I (offset 0x1EE4, printed page 10-118, `hi3516av100--Hi3516A-Hi3516D-Datasheet.txt` line 65606).";

        enum CH_SPLIT_CTRL_I_update_mode_enum {
            UPDATE_UPDATE_REGISTER = 0 { name = "Update Update Register"; desc = "update by update register"; };
            UPDATE_FRAME = 1 { name = "Update Frame"; desc = "update by frame"; };
        };

        field {
            name = "update_mode";
            desc = "Split register update mode.";
            sw = rw;
            hw = r;
            encode = CH_SPLIT_CTRL_I_update_mode_enum;
            reset = 0x1;
        } update_mode[0:0];
    } CH_SPLIT_CTRL_I @ 0x1EE4;

    reg {
        name = "Split register update register";
        desc = "CH_SPLIT_UPDATE is a split register update register. Huawei Proprietary and Confidential Hi3516A/Hi3516D Professional HD IP Camera SoC

Data sheet 10.1.6 CH_SPLIT_UPDATE (offset 0x1EEC, printed page 10-119, `hi3516av100--Hi3516A-Hi3516D-Datasheet.txt` line 65644).";

        field {
            name = "newer";
            desc = "Split register update. This bit is automatically cleared for each frame.";
            sw = rw;
            hw = r;
            reset = 0x0;
        } newer[0:0];
    } CH_SPLIT_UPDATE @ 0x1EEC;

    reg {
        name = "AF control register";
        desc = "CH_AF_CFG is an AF control register.

Data sheet 10.1.6 CH_AF_CFG (offset 0x2000, printed page 10-119, `hi3516av100--Hi3516A-Hi3516D-Datasheet.txt` line 65667).";

        field {
            name = "ck_gt_en";
            desc = "AF clock gating enable.";
            sw = rw;
            hw = r;
            reset = 0x0;
        } ck_gt_en[31:31];

        enum CH_AF_CFG_crop_en_enum {
            DISABLED = 0 { name = "Disabled"; desc = "disabled"; };
            ENABLED = 1 { name = "Enabled"; desc = "enabled"; };
        };

        field {
            name = "crop_en";
            desc = "Crop enable.";
            sw = rw;
            hw = r;
            encode = CH_AF_CFG_crop_en_enum;
            reset = 0x0;
        } crop_en[11:11];

        enum CH_AF_CFG_data_mode_enum {
            FIVE_GROUPS_VALUES = 0 { name = "Five Groups Values"; desc = "five groups of values"; };
            NINE_GROUPS_VALUES = 1 { name = "Nine Groups Values"; desc = "nine groups of values"; };
        };

        field {
            name = "data_mode";
            desc = "Statistics mode.";
            sw = rw;
            hw = r;
            encode = CH_AF_CFG_data_mode_enum;
            reset = 0x0;
        } data_mode[9:9];

        enum CH_AF_CFG_squ_mode_enum {
            STATISTICS_DIRECTLY_ADDED = 0 { name = "Statistics Directly Added"; desc = "Statistics are directly added."; };
            STATISTICS_ADDED_AFTER = 1 { name = "Statistics Added After"; desc = "Statistics are added after the square calculation."; };
        };

        field {
            name = "squ_mode";
            desc = "AF statistics square mod.e";
            sw = rw;
            hw = r;
            encode = CH_AF_CFG_squ_mode_enum;
            reset = 0x1;
        } squ_mode[8:8];

        enum CH_AF_CFG_peak_mode_enum {
            ALL_VALUES_BLOCK = 0 { name = "All Values Block"; desc = "All values of a block are selected for statistics."; };
            MAXIMUM_VALUE_EACH = 1 { name = "Maximum Value Each"; desc = "The maximum value in each line of a block is selected for statistics."; };
        };

        field {
            name = "peak_mode";
            desc = "AF statistics peak value mode.";
            sw = rw;
            hw = r;
            encode = CH_AF_CFG_peak_mode_enum;
            reset = 0x1;
        } peak_mode[7:7];

        enum CH_AF_CFG_iir1_en2_enum {
            DISABLED = 0 { name = "Disabled"; desc = "disabled"; };
            ENABLED = 1 { name = "Enabled"; desc = "enabled"; };
        };

        field {
            name = "iir1_en2";
            desc = "Enable for cascaded IIR2 among the three IIRs in group 2.";
            sw = rw;
            hw = r;
            encode = CH_AF_CFG_iir1_en2_enum;
            reset = 0x1;
        } iir1_en2[6:6];

        enum CH_AF_CFG_iir1_en1_enum {
            DISABLED = 0 { name = "Disabled"; desc = "disabled"; };
            ENABLED = 1 { name = "Enabled"; desc = "enabled"; };
        };

        field {
            name = "iir1_en1";
            desc = "Enable for cascaded IIR1 among the three IIRs in group 2.";
            sw = rw;
            hw = r;
            encode = CH_AF_CFG_iir1_en1_enum;
            reset = 0x0;
        } iir1_en1[5:5];

        enum CH_AF_CFG_iir1_en0_enum {
            DISABLED = 0 { name = "Disabled"; desc = "disabled"; };
            ENABLED = 1 { name = "Enabled"; desc = "enabled"; };
        };

        field {
            name = "iir1_en0";
            desc = "Enable for cascaded IIR0 among the three IIRs in group 2.";
            sw = rw;
            hw = r;
            encode = CH_AF_CFG_iir1_en0_enum;
            reset = 0x1;
        } iir1_en0[4:4];

        enum CH_AF_CFG_iir0_en2_enum {
            DISABLED = 0 { name = "Disabled"; desc = "disabled"; };
            ENABLED = 1 { name = "Enabled"; desc = "enabled"; };
        };

        field {
            name = "iir0_en2";
            desc = "Enable for cascaded IIR2 among the three IIRs in group 1.";
            sw = rw;
            hw = r;
            encode = CH_AF_CFG_iir0_en2_enum;
            reset = 0x1;
        } iir0_en2[3:3];

        enum CH_AF_CFG_iir0_en1_enum {
            DISABLED = 0 { name = "Disabled"; desc = "disabled"; };
            ENABLED = 1 { name = "Enabled"; desc = "enabled"; };
        };

        field {
            name = "iir0_en1";
            desc = "Enable for cascaded IIR1 among the three IIRs in group 1.";
            sw = rw;
            hw = r;
            encode = CH_AF_CFG_iir0_en1_enum;
            reset = 0x0;
        } iir0_en1[2:2];

        enum CH_AF_CFG_iir0_en0_enum {
            DISABLED = 0 { name = "Disabled"; desc = "disabled"; };
            ENABLED = 1 { name = "Enabled"; desc = "enabled"; };
        };

        field {
            name = "iir0_en0";
            desc = "Enable for cascaded IIR0 among the three IIRs in group 1.";
            sw = rw;
            hw = r;
            encode = CH_AF_CFG_iir0_en0_enum;
            reset = 0x1;
        } iir0_en0[1:1];

        enum CH_AF_CFG_en_enum {
            DISABLED = 0 { name = "Disabled"; desc = "disabled"; };
            ENABLED = 1 { name = "Enabled"; desc = "enabled"; };
        };

        field {
            name = "en";
            desc = "AF enable.";
            sw = rw;
            hw = r;
            encode = CH_AF_CFG_en_enum;
            reset = 0x1;
        } en[0:0];
    } CH_AF_CFG @ 0x2000;

    reg {
        name = "AF block configuration register";
        desc = "CH_AF_ZONE is an AF block configuration register. Huawei Proprietary and Confidential Hi3516A/Hi3516D Professional HD IP Camera SoC

Data sheet 10.1.6 CH_AF_ZONE (offset 0x2010, printed page 10-121, `hi3516av100--Hi3516A-Hi3516D-Datasheet.txt` line 65749).";

        field {
            name = "vnum";
            desc = "Number of vertical AF blocks (15 blocks at most).";
            sw = rw;
            hw = r;
            reset = 0xF;
        } vnum[12:8];

        field {
            name = "hnum";
            desc = "Number of horizontal AF blocks (17 blocks at most and at least eight horizontal pixels for each block).";
            sw = rw;
            hw = r;
            reset = 0x11;
        } hnum[4:0];
    } CH_AF_ZONE @ 0x2010;

    reg {
        name = "AF crop start coordinate configuration register";
        desc = "CH_AF_CROP_START is an AF crop start coordinate configuration register.

Data sheet 10.1.6 CH_AF_CROP_START (offset 0x2014, printed page 10-121, `hi3516av100--Hi3516A-Hi3516D-Datasheet.txt` line 65774).";

        field {
            name = "y_pos";
            desc = "Start vertical coordinate of the AF picture to be cropped.";
            sw = rw;
            hw = r;
            reset = 0x437;
        } y_pos[27:16];

        field {
            name = "x_pos";
            desc = "Start horizontal coordinate of the AF picture to be cropped.";
            sw = rw;
            hw = r;
            reset = 0x77F;
        } x_pos[11:0];
    } CH_AF_CROP_START @ 0x2014;

    reg {
        name = "AF crop picture size configuration register";
        desc = "CH_AF_CROP_SIZE is an AF crop picture size configuration register. Huawei Proprietary and Confidential Hi3516A/Hi3516D Professional HD IP Camera SoC

Data sheet 10.1.6 CH_AF_CROP_SIZE (offset 0x2018, printed page 10-122, `hi3516av100--Hi3516A-Hi3516D-Datasheet.txt` line 65807).";

        field {
            name = "vsize";
            desc = "Height of the cropped AF picture. The configured value is the actual value minus 1.";
            sw = rw;
            hw = r;
            reset = 0x437;
        } vsize[27:16];

        field {
            name = "hsize";
            desc = "Width of the cropped AF picture. The configured value is the actual value minus 1.";
            sw = rw;
            hw = r;
            reset = 0x77F;
        } hsize[11:0];
    } CH_AF_CROP_SIZE @ 0x2018;

    reg {
        name = "AF IIR filtering parameter 0 register";
        desc = "CH_AF_IIRG0 is an AF IIR filtering parameter 0 register.

Data sheet 10.1.6 CH_AF_IIRG0 (offset 0x2020, printed page 10-122, `hi3516av100--Hi3516A-Hi3516D-Datasheet.txt` line 65834).";

        field {
            name = "iirg0_1";
            desc = "G0 gain of AF IIR filtering group 2 (the configured value of 0x640 ISP_AF_SHIFT is affected).";
            sw = rw;
            hw = r;
            reset = 0xA1;
        } iirg0_1[23:16];

        field {
            name = "iirg0_0";
            desc = "G0 gain of AF IIR filtering group 1 (the configured value of 0x640 ISP_AF_SHIFT is affected).";
            sw = rw;
            hw = r;
            reset = 0xA0;
        } iirg0_0[7:0];
    } CH_AF_IIRG0 @ 0x2020;

    reg {
        name = "AF IIR filtering parameter 1 register";
        desc = "CH_AF_IIRG1 is an AF IIR filtering parameter 1 register. Huawei Proprietary and Confidential Hi3516A/Hi3516D Professional HD IP Camera SoC

Data sheet 10.1.6 CH_AF_IIRG1 (offset 0x2024, printed page 10-123, `hi3516av100--Hi3516A-Hi3516D-Datasheet.txt` line 65869).";

        field {
            name = "iirg1_1";
            desc = "G1 gain of AF IIR filtering group 2. It is a signed number and cannot be the negative boundary value -512.";
            sw = rw;
            hw = r;
            reset = 0x244;
        } iirg1_1[25:16];

        field {
            name = "iirg1_0";
            desc = "G1 gain of AF IIR filtering group 1. It is a signed number and cannot be the negative boundary value -512.";
            sw = rw;
            hw = r;
            reset = 0x1BC;
        } iirg1_0[9:0];
    } CH_AF_IIRG1 @ 0x2024;

    reg {
        name = "AF IIR filtering parameter 2 register";
        desc = "CH_AF_IIRG2 is an AF IIR filtering parameter 2 register.

Data sheet 10.1.6 CH_AF_IIRG2 (offset 0x2028, printed page 10-123, `hi3516av100--Hi3516A-Hi3516D-Datasheet.txt` line 65894).";

        field {
            name = "iirg2_1";
            desc = "G2 gain of AF IIR filtering group 2. It is a signed number and cannot be the negative boundary value -512.";
            sw = rw;
            hw = r;
            reset = 0x328;
        } iirg2_1[25:16];

        field {
            name = "iirg2_0";
            desc = "G2 gain of AF IIR filtering group 1. It is a signed number and cannot be the negative boundary value -512.";
            sw = rw;
            hw = r;
            reset = 0x328;
        } iirg2_0[9:0];
    } CH_AF_IIRG2 @ 0x2028;

    reg {
        name = "AF IIR filtering parameter 3 register";
        desc = "CH_AF_IIRG3 is an AF IIR filtering parameter 3 register. Huawei Proprietary and Confidential Hi3516A/Hi3516D Professional HD IP Camera SoC

Data sheet 10.1.6 CH_AF_IIRG3 (offset 0x202C, printed page 10-124, `hi3516av100--Hi3516A-Hi3516D-Datasheet.txt` line 65929).";

        field {
            name = "iirg3_1";
            desc = "G3 gain of AF IIR filtering group 2. It is a signed number and cannot be the negative boundary value -512.";
            sw = rw;
            hw = r;
            reset = 0x0;
        } iirg3_1[25:16];

        field {
            name = "iirg3_0";
            desc = "G3 gain of AF IIR filtering group 1. It is a signed number and cannot be the negative boundary value -512.";
            sw = rw;
            hw = r;
            reset = 0x0;
        } iirg3_0[9:0];
    } CH_AF_IIRG3 @ 0x202C;

    reg {
        name = "AF IIR filtering parameter 4 register";
        desc = "CH_AF_IIRG4 is an AF IIR filtering parameter 4 register.

Data sheet 10.1.6 CH_AF_IIRG4 (offset 0x2030, printed page 10-124, `hi3516av100--Hi3516A-Hi3516D-Datasheet.txt` line 65954).";

        field {
            name = "iirg4_1";
            desc = "G4 gain of AF IIR filtering group 2. It is a signed number and cannot be the negative boundary value -512.";
            sw = rw;
            hw = r;
            reset = 0x0;
        } iirg4_1[25:16];

        field {
            name = "iirg4_0";
            desc = "G4 gain of AF IIR filtering group 1. It is a signed number and cannot be the negative boundary value -512.";
            sw = rw;
            hw = r;
            reset = 0x0;
        } iirg4_0[9:0];
    } CH_AF_IIRG4 @ 0x2030;

    reg {
        name = "AF IIR filtering parameter 5 register";
        desc = "CH_AF_IIRG5 is an AF IIR filtering parameter 5 register. Huawei Proprietary and Confidential Hi3516A/Hi3516D Professional HD IP Camera SoC

Data sheet 10.1.6 CH_AF_IIRG5 (offset 0x2034, printed page 10-125, `hi3516av100--Hi3516A-Hi3516D-Datasheet.txt` line 65989).";

        field {
            name = "iirg5_1";
            desc = "G5 gain of AF IIR filtering group 2. It is a signed number and cannot be the negative boundary value -512.";
            sw = rw;
            hw = r;
            reset = 0x284;
        } iirg5_1[25:16];

        field {
            name = "iirg5_0";
            desc = "G5 gain of AF IIR filtering group 1. It is a signed number and cannot be the negative boundary value -512.";
            sw = rw;
            hw = r;
            reset = 0x17C;
        } iirg5_0[9:0];
    } CH_AF_IIRG5 @ 0x2034;

    reg {
        name = "AF IIR filtering parameter 6 register";
        desc = "CH_AF_IIRG6 is an AF IIR filtering parameter 6 register.

Data sheet 10.1.6 CH_AF_IIRG6 (offset 0x2038, printed page 10-125, `hi3516av100--Hi3516A-Hi3516D-Datasheet.txt` line 66014).";

        field {
            name = "iirg6_1";
            desc = "G6 gain of AF IIR filtering group 2. It is a signed number and cannot be the negative boundary value -512.";
            sw = rw;
            hw = r;
            reset = 0x33C;
        } iirg6_1[25:16];

        field {
            name = "iirg6_0";
            desc = "G6 gain of AF IIR filtering group 1. It is a signed number and cannot be the negative boundary value -512.";
            sw = rw;
            hw = r;
            reset = 0x33C;
        } iirg6_0[9:0];
    } CH_AF_IIRG6 @ 0x2038;

    reg {
        name = "AF IIR filtering shift parameter register";
        desc = "CH_AF_SHIFT is an AF IIR filtering shift parameter register. Huawei Proprietary and Confidential Hi3516A/Hi3516D Professional HD IP Camera SoC

Data sheet 10.1.6 CH_AF_SHIFT (offset 0x2040, printed page 10-126, `hi3516av100--Hi3516A-Hi3516D-Datasheet.txt` line 66049).";

        field {
            name = "iirshift1_3";
            desc = "Shift adjustment for IIR2 in AF IIR filtering group 2.";
            sw = rw;
            hw = r;
            reset = 0x0;
        } iirshift1_3[31:28];

        field {
            name = "iirshift1_2";
            desc = "Shift adjustment for IIR1 in AF IIR filtering group 2.";
            sw = rw;
            hw = r;
            reset = 0x0;
        } iirshift1_2[27:24];

        field {
            name = "iirshift1_1";
            desc = "Shift adjustment for IIR0 in AF IIR filtering group 2.";
            sw = rw;
            hw = r;
            reset = 0x2;
        } iirshift1_1[23:20];

        field {
            name = "iirshift1_0";
            desc = "Input shift adjustment for AF IIR filtering group 2. iirg0_0 >= 128, iirshift0_0 >= 4 iirg0_0 >= 64, iirshift0_0 >= 3 iirg0_0 >= 32, iirshift0_0 >= 2 iirg0_0 >= 16, iirshift0_0 >= 1)";
            sw = rw;
            hw = r;
            reset = 0x7;
        } iirshift1_0[19:16];

        field {
            name = "iirshift0_3";
            desc = "Shift adjustment for IIR2 in AF IIR filtering group 1.";
            sw = rw;
            hw = r;
            reset = 0x1;
        } iirshift0_3[15:12];

        field {
            name = "iirshift0_2";
            desc = "Shift adjustment for IIR1 in AF IIR filtering group 1.";
            sw = rw;
            hw = r;
            reset = 0x0;
        } iirshift0_2[11:8];

        field {
            name = "iirshift0_1";
            desc = "Shift adjustment for IIR0 in AF IIR filtering group 1.";
            sw = rw;
            hw = r;
            reset = 0x2;
        } iirshift0_1[7:4];

        field {
            name = "iirshift0_0";
            desc = "Input shift adjustment for AF IIR filtering group 1. iirg0_0 >= 128, iirshift0_0 >= 4 iirg0_0 >= 64, iirshift0_0 >= 3 iirg0_0 >= 32, iirshift0_0 >= 2 iirg0_0 >= 16, iirshift0_0 >= 1)";
            sw = rw;
            hw = r;
            reset = 0x7;
        } iirshift0_0[3:0];
    } CH_AF_SHIFT @ 0x2040;

    reg {
        name = "AF FIR filtering parameter 0 register";
        desc = "CH_AF_FIRH0 is an AF FIR filtering parameter 0 register.

Data sheet 10.1.6 CH_AF_FIRH0 (offset 0x2050, printed page 10-126, `hi3516av100--Hi3516A-Hi3516D-Datasheet.txt` line 66082).";

        field {
            name = "firh0_1";
            desc = "H0 gain of AF FIR filtering group 2. It is a signed number and cannot be the negative boundary value -32.";
            sw = rw;
            hw = r;
            reset = 0x30;
        } firh0_1[21:16];

        field {
            name = "firh0_0";
            desc = "H0 gain of AF FIR filtering group 1. It is a signed number and cannot be the negative boundary value -32.";
            sw = rw;
            hw = r;
            reset = 0x30;
        } firh0_0[5:0];
    } CH_AF_FIRH0 @ 0x2050;

    reg {
        name = "AF FIR filtering parameter 1 register";
        desc = "CH_AF_FIRH1 is an AF FIR filtering parameter 1 register.

Data sheet 10.1.6 CH_AF_FIRH1 (offset 0x2054, printed page 10-127, `hi3516av100--Hi3516A-Hi3516D-Datasheet.txt` line 66117).";

        field {
            name = "firh1_1";
            desc = "H1 gain of AF FIR filtering group 2. It is a signed number and cannot be the negative boundary value -32.";
            sw = rw;
            hw = r;
            reset = 0x15;
        } firh1_1[21:16];

        field {
            name = "firh1_0";
            desc = "H1 gain of AF FIR filtering group 1. It is a signed number and cannot be the negative boundary value -32.";
            sw = rw;
            hw = r;
            reset = 0x2B;
        } firh1_0[5:0];
    } CH_AF_FIRH1 @ 0x2054;

    reg {
        name = "AF FIR filtering parameter 2 register";
        desc = "CH_AF_FIRH2 is an AF FIR filtering parameter 2 register.

Data sheet 10.1.6 CH_AF_FIRH2 (offset 0x2058, printed page 10-127, `hi3516av100--Hi3516A-Hi3516D-Datasheet.txt` line 66142).";

        field {
            name = "firh2_1";
            desc = "H2 gain of AF FIR filtering group 2. It is a signed number and cannot be the negative boundary value -32.";
            sw = rw;
            hw = r;
            reset = 0x0;
        } firh2_1[21:16];

        field {
            name = "firh2_0";
            desc = "H2 gain of AF FIR filtering group 1. It is a signed number and cannot be the negative boundary value -32.";
            sw = rw;
            hw = r;
            reset = 0x0;
        } firh2_0[5:0];
    } CH_AF_FIRH2 @ 0x2058;

    reg {
        name = "AF FIR filtering parameter 3 register";
        desc = "CH_AF_FIRH3 is an AF FIR filtering parameter 3 register.

Data sheet 10.1.6 CH_AF_FIRH3 (offset 0x205C, printed page 10-128, `hi3516av100--Hi3516A-Hi3516D-Datasheet.txt` line 66175).";

        field {
            name = "firh3_1";
            desc = "H3 gain of AF FIR filtering group 2. It is a signed number and cannot be the negative boundary value -32.";
            sw = rw;
            hw = r;
            reset = 0x2B;
        } firh3_1[21:16];

        field {
            name = "firh3_0";
            desc = "H3 gain of AF FIR filtering group 1. It is a signed number and cannot be the negative boundary value -32.";
            sw = rw;
            hw = r;
            reset = 0x15;
        } firh3_0[5:0];
    } CH_AF_FIRH3 @ 0x205C;

    reg {
        name = "AF FIR filtering parameter 4 register";
        desc = "CH_AF_FIRH4 is an AF FIR filtering parameter 4 register.

Data sheet 10.1.6 CH_AF_FIRH4 (offset 0x2060, printed page 10-128, `hi3516av100--Hi3516A-Hi3516D-Datasheet.txt` line 66200).";

        field {
            name = "firh4_1";
            desc = "H4 gain of AF FIR filtering group 2. It is a signed number and cannot be the negative boundary value -32.";
            sw = rw;
            hw = r;
            reset = 0x10;
        } firh4_1[21:16];

        field {
            name = "firh4_0";
            desc = "H4 gain of AF FIR filtering group 1. It is a signed number and cannot be the negative boundary value -32.";
            sw = rw;
            hw = r;
            reset = 0x10;
        } firh4_0[5:0];
    } CH_AF_FIRH4 @ 0x2060;

    reg {
        name = "AF IIR filtering threshold register";
        desc = "CH_AF_IIRTHRE is an AF IIR filtering threshold register. Huawei Proprietary and Confidential Hi3516A/Hi3516D Professional HD IP Camera SoC

Data sheet 10.1.6 CH_AF_IIRTHRE (offset 0x2070, printed page 10-129, `hi3516av100--Hi3516A-Hi3516D-Datasheet.txt` line 66233).";

        field {
            name = "thre2_x";
            desc = "Statistics threshold of AF IIR filtering group 2";
            sw = rw;
            hw = r;
            reset = 0x14;
        } thre2_x[26:16];

        field {
            name = "thre1_x";
            desc = "Statistics threshold of AF IIR filtering group 1";
            sw = rw;
            hw = r;
            reset = 0x64;
        } thre1_x[10:0];
    } CH_AF_IIRTHRE @ 0x2070;

    reg {
        name = "AF FIR filtering threshold register";
        desc = "CH_AF_FIRTHRE is an AF FIR filtering threshold register.

Data sheet 10.1.6 CH_AF_FIRTHRE (offset 0x2074, printed page 10-129, `hi3516av100--Hi3516A-Hi3516D-Datasheet.txt` line 66254).";

        field {
            name = "thre2_y";
            desc = "Statistics threshold of AF FIR filtering group 2";
            sw = rw;
            hw = r;
            reset = 0xA;
        } thre2_y[26:16];

        field {
            name = "thre1_y";
            desc = "Statistics threshold of AF FIR filtering group 1";
            sw = rw;
            hw = r;
            reset = 0x32;
        } thre1_y[10:0];
    } CH_AF_FIRTHRE @ 0x2074;

    reg {
        name = "AF statistics shift register";
        desc = "CH_AF_ACC_SHIFT is an AF statistics shift register. Huawei Proprietary and Confidential Hi3516A/Hi3516D Professional HD IP Camera SoC

Data sheet 10.1.6 CH_AF_ACC_SHIFT (offset 0x2078, printed page 10-130, `hi3516av100--Hi3516A-Hi3516D-Datasheet.txt` line 66285).";

        field {
            name = "acc_shift_y";
            desc = "Luminance Y statistics shift (0-15). Y in CH_AF_STAT_RDATA is shifted.";
            sw = rw;
            hw = r;
            reset = 0x2;
        } acc_shift_y[19:16];

        field {
            name = "acc_shift2_v";
            desc = "Shift of vertical FIR filtering statistics in group 2 (0-15). V2 in CH_AF_STAT_RDATA is shifted.";
            sw = rw;
            hw = r;
            reset = 0x0;
        } acc_shift2_v[15:12];

        field {
            name = "acc_shift1_v";
            desc = "Shift of vertical FIR filtering statistics in group 1 (0-15). V1 in CH_AF_STAT_RDATA is shifted.";
            sw = rw;
            hw = r;
            reset = 0x2;
        } acc_shift1_v[11:8];

        field {
            name = "acc_shift2_h";
            desc = "Shift of horizontal IIR filtering statistics in group 2 (0-15). H2 in CH_AF_STAT_RDATA is shifted.";
            sw = rw;
            hw = r;
            reset = 0x0;
        } acc_shift2_h[7:4];

        field {
            name = "acc_shift1_h";
            desc = "Shift of horizontal IIR filtering statistics in group 1 (0-15). H1 in CH_AF_STAT_RDATA is shifted.";
            sw = rw;
            hw = r;
            reset = 0x0;
        } acc_shift1_h[3:0];
    } CH_AF_ACC_SHIFT @ 0x2078;

    reg {
        name = "AF count value shift register";
        desc = "CH_AF_CNT_SHIFT is an AF count value shift register.

Data sheet 10.1.6 CH_AF_CNT_SHIFT (offset 0x207C, printed page 10-130, `hi3516av100--Hi3516A-Hi3516D-Datasheet.txt` line 66318).";

        field {
            name = "cnt_shift2_v";
            desc = "Shift of the vertical FIR filtering count value in group 2 (0-15). vcnt2 in CH_AF_STAT_RDATA is shifted.";
            sw = rw;
            hw = r;
            reset = 0x0;
        } cnt_shift2_v[15:12];

        field {
            name = "cnt_shift1_v";
            desc = "Shift of the vertical FIR filtering count value in group 1 (0-15). vcnt1 in CH_AF_STAT_RDATA is shifted.";
            sw = rw;
            hw = r;
            reset = 0x2;
        } cnt_shift1_v[11:8];

        field {
            name = "cnt_shift2_h";
            desc = "Shift of the horizontal IIR filtering count value in group 2 (0-15). hcnt2 in CH_AF_STAT_RDATA is shifted.";
            sw = rw;
            hw = r;
            reset = 0x0;
        } cnt_shift2_h[7:4];

        field {
            name = "cnt_shift1_h";
            desc = "Shift of the horizontal FIR filtering count value in group 1 (0-15). hcnt1 in CH_AF_STAT_RDATA is shifted.";
            sw = rw;
            hw = r;
            reset = 0x0;
        } cnt_shift1_h[3:0];
    } CH_AF_CNT_SHIFT @ 0x207C;

    reg {
        name = "AF picture size register";
        desc = "CH_AF_SIZE is an AF picture size register.

Data sheet 10.1.6 CH_AF_SIZE (offset 0x20E0, printed page 10-131, `hi3516av100--Hi3516A-Hi3516D-Datasheet.txt` line 66357).";

        field {
            name = "vsize";
            desc = "AF picture height. The configured value is the actual value minus 1.";
            sw = rw;
            hw = r;
            reset = 0x437;
        } vsize[27:16];

        field {
            name = "hsize";
            desc = "AF picture width. The configured value is the actual value minus 1.";
            sw = rw;
            hw = r;
            reset = 0x77F;
        } hsize[11:0];
    } CH_AF_SIZE @ 0x20E0;

    reg {
        name = "Read statistics register for AF blocks";
        desc = "CH_AF_STAT_RDATA is a read statistics register for AF blocks.

Data sheet 10.1.6 CH_AF_STAT_RDATA (offset 0x2100, printed page 10-131, `hi3516av100--Hi3516A-Hi3516D-Datasheet.txt` line 66382).";

        field {
            name = "af_stat_rdata";
            desc = "V1[16], H1[16], V2[16], H2[16], Y[16], hcnt1, hcnt2, vcnt1, and vcnt2 information about each block. The following is the information for each address: When data_mode is 0: 0x00: {V1 (16 bits), H1 (16 bits)} of block 1 0x04: {V2 (16 bits), H2 (16 bits)} of block 1 0x08: Y (16 bits) of block 1 The same rule applies to other addresses. When data_mode is 1: 0x00: {Y_h (6 bits), V1 (13 bits), H1 (13 bits)} of block 1 0x04: {Y_l (6 bits), V2 (13 bits), H2 (13 bits)} of block 1";
            sw = r;
            hw = w;
            reset = 0x0;
        } af_stat_rdata[31:0];
    } CH_AF_STAT_RDATA[765] @ 0x2100 += 0x4;

    reg {
        name = "ISP buffer maximum address register";
        desc = "ISP_MAX_ADDR is an ISP buffer maximum address register.

Data sheet 10.1.6 ISP_MAX_ADDR (offset 0x10000, printed page 10-132, `hi3516av100--Hi3516A-Hi3516D-Datasheet.txt` line 66435).";

        field {
            name = "max_addr";
            desc = "Maximum address for the ISP buffer.";
            sw = rw;
            hw = r;
            reset = 0x51F;
        } max_addr[11:0];
    } ISP_MAX_ADDR @ 0x10000;

    reg {
        name = "DIS Y depth maximum address register";
        desc = "ISP_MAX_ADDR_DIS_Y is a DIS Y depth maximum address register. Huawei Proprietary and Confidential Hi3516A/Hi3516D Professional HD IP Camera SoC

Data sheet 10.1.6 ISP_MAX_ADDR_DIS_Y (offset 0x10004, printed page 10-133, `hi3516av100--Hi3516A-Hi3516D-Datasheet.txt` line 66464).";

        field {
            name = "max_addr_y";
            desc = "Maximum address for the DIS Y depth.";
            sw = rw;
            hw = r;
            reset = 0x3DB;
        } max_addr_y[11:0];
    } ISP_MAX_ADDR_DIS_Y @ 0x10004;

    reg {
        name = "ISP sinter buffer 1 maximum address register";
        desc = "ISP_MAX_ADDR_SINTER1 is an ISP sinter buffer 1 maximum address register.

Data sheet 10.1.6 ISP_MAX_ADDR_SINTER1 (offset 0x10008, printed page 10-133, `hi3516av100--Hi3516A-Hi3516D-Datasheet.txt` line 66483).";

        field {
            name = "max_addr_sinter1";
            desc = "Maximum address for sinter buffer 1.";
            sw = rw;
            hw = r;
            reset = 0x3CF;
        } max_addr_sinter1[11:0];
    } ISP_MAX_ADDR_SINTER1 @ 0x10008;

    reg {
        name = "ISP sinter buffer 2 maximum address register";
        desc = "ISP_MAX_ADDR_SINTER2 is an ISP sinter buffer 2 maximum address register.

Data sheet 10.1.6 ISP_MAX_ADDR_SINTER2 (offset 0x1000C, printed page 10-133, `hi3516av100--Hi3516A-Hi3516D-Datasheet.txt` line 66502).";

        field {
            name = "max_addr_sinter2";
            desc = "Maximum address for sinter buffer 2.";
            sw = rw;
            hw = r;
            reset = 0x1EF;
        } max_addr_sinter2[11:0];
    } ISP_MAX_ADDR_SINTER2 @ 0x1000C;

    reg {
        name = "ISP timing configuration register";
        desc = "ISP_TIMING is an ISP timing configuration register.

Data sheet 10.1.6 ISP_TIMING (offset 0x10010, printed page 10-134, `hi3516av100--Hi3516A-Hi3516D-Datasheet.txt` line 66527).";

        enum ISP_TIMING_vsync_sel_enum {
            NOT_PROCESSED = 0 { name = "Not Processed"; desc = "not processed"; };
            PROCESSED = 1 { name = "Processed"; desc = "processed"; };
        };

        field {
            name = "vsync_sel";
            desc = "Toggle processing control from vsync.";
            sw = rw;
            hw = r;
            encode = ISP_TIMING_vsync_sel_enum;
            reset = 0x0;
        } vsync_sel[1:1];

        enum ISP_TIMING_hsync_sel_enum {
            INPUT_HSYNC = 0 { name = "Input Hsync"; desc = "input hsync"; };
            INPUT_DE = 1 { name = "Input De"; desc = "input de"; };
        };

        field {
            name = "hsync_sel";
            desc = "hsync select.";
            sw = rw;
            hw = r;
            encode = ISP_TIMING_hsync_sel_enum;
            reset = 0x1;
        } hsync_sel[0:0];
    } ISP_TIMING @ 0x10010;

    reg {
        name = "ISP byte enable register";
        desc = "ISP_BYTE_EN is an ISP byte enable register.

Data sheet 10.1.6 ISP_BYTE_EN (offset 0x10020, printed page 10-134, `hi3516av100--Hi3516A-Hi3516D-Datasheet.txt` line 66556).";

        enum ISP_BYTE_EN_byte_en_enum {
            DISABLED = 0 { name = "Disabled"; desc = "disabled"; };
            ENABLED = 1 { name = "Enabled"; desc = "enabled"; };
        };

        field {
            name = "byte_en";
            desc = "Byte enable.";
            sw = rw;
            hw = r;
            encode = ISP_BYTE_EN_byte_en_enum;
            reset = 0xF;
        } byte_en[3:0];
    } ISP_BYTE_EN @ 0x10020;

    reg {
        name = "ISP FSTITCH maximum address register";
        desc = "ISP_MAX_ADDR_FSTITCH is an ISP FSTITCH maximum address register. Huawei Proprietary and Confidential Hi3516A/Hi3516D Professional HD IP Camera SoC

Data sheet 10.1.6 ISP_MAX_ADDR_FSTITCH (offset 0x10024, printed page 10-135, `hi3516av100--Hi3516A-Hi3516D-Datasheet.txt` line 66585).";

        field {
            name = "max_addr_fstitch";
            desc = "Maximum address for the ISP FSTITCH.";
            sw = rw;
            hw = r;
            reset = 0x51F;
        } max_addr_fstitch[11:0];
    } ISP_MAX_ADDR_FSTITCH @ 0x10024;

    reg {
        name = "ISP input switch register";
        desc = "ISP_CH_SWITCH is an ISP input switch register.

Data sheet 10.1.6 ISP_CH_SWITCH (offset 0x10028, printed page 10-135, `hi3516av100--Hi3516A-Hi3516D-Datasheet.txt` line 66604).";

        field {
            name = "isp_ch_switch_4";
            desc = "ISP FPN black frame input data select. 0 indicates channel 0, 1 indicates channel 1, 2 indicates channel 2, 3 indicates channel 3, and 4 indicates the FPN black frame input.";
            sw = rw;
            hw = r;
            reset = 0x0;
        } isp_ch_switch_4[22:20];

        field {
            name = "isp_ch_switch_3";
            desc = "Input data select for ISP channel 3.0 indicates channel 0, 1 indicates channel 1, 2 indicates channel 2, 3 indicates channel 3, and 4 indicates the FPN black frame input.";
            sw = rw;
            hw = r;
            reset = 0x0;
        } isp_ch_switch_3[18:16];

        field {
            name = "isp_ch_switch_2";
            desc = "Input data select for ISP channel 2. 0 indicates channel 0, 1 indicates channel 1, 2 indicates channel 2, 3 indicates channel 3, and 4 indicates the FPN black frame input.";
            sw = rw;
            hw = r;
            reset = 0x0;
        } isp_ch_switch_2[14:12];

        field {
            name = "isp_ch_switch_1";
            desc = "Input data select for ISP channel 1. 0 indicates channel 0, 1 indicates channel 1, 2 indicates channel 2, 3 indicates channel 3, and 4 indicates the FPN black frame input.";
            sw = rw;
            hw = r;
            reset = 0x0;
        } isp_ch_switch_1[10:8];

        field {
            name = "isp_ch_switch_0";
            desc = "Input data select for ISP channel 0. 0 indicates channel 0, 1 indicates channel 1, 2 indicates channel 2, 3 indicates channel 3, and 4 indicates the FPN black frame input.";
            sw = rw;
            hw = r;
            reset = 0x0;
        } isp_ch_switch_0[6:4];

        enum ISP_CH_SWITCH_isp_ch_switch_en_enum {
            DISABLED = 0 { name = "Disabled"; desc = "disabled"; };
            ENABLED = 1 { name = "Enabled"; desc = "enabled"; };
        };

        field {
            name = "isp_ch_switch_en";
            desc = "ISP input switch enable.";
            sw = rw;
            hw = r;
            encode = ISP_CH_SWITCH_isp_ch_switch_en_enum;
            reset = 0x0;
        } isp_ch_switch_en[0:0];
    } ISP_CH_SWITCH @ 0x10028;

    reg {
        name = "Crop register";
        desc = "ISP_CROP_CFG is a crop register.

Data sheet 10.1.6 ISP_CROP_CFG (offset 0x10030, printed page 10-136, `hi3516av100--Hi3516A-Hi3516D-Datasheet.txt` line 66663).";

        enum ISP_CROP_CFG_n1_en_enum {
            DISABLED = 0 { name = "Disabled"; desc = "disabled"; };
            ENABLED = 1 { name = "Enabled"; desc = "enabled"; };
        };

        field {
            name = "n1_en";
            desc = "Region 1 enable.";
            sw = rw;
            hw = r;
            encode = ISP_CROP_CFG_n1_en_enum;
            reset = 0x0;
        } n1_en[1:1];

        enum ISP_CROP_CFG_n0_en_enum {
            DISABLED = 0 { name = "Disabled"; desc = "disabled"; };
            ENABLED = 1 { name = "Enabled"; desc = "enabled"; };
        };

        field {
            name = "n0_en";
            desc = "Region 0 enable.";
            sw = rw;
            hw = r;
            encode = ISP_CROP_CFG_n0_en_enum;
            reset = 0x0;
        } n0_en[0:0];
    } ISP_CROP_CFG @ 0x10030;

    reg {
        name = "Crop window register";
        desc = "ISP_CROP_WIN is a crop window register. Huawei Proprietary and Confidential Hi3516A/Hi3516D Professional HD IP Camera SoC

Data sheet 10.1.6 ISP_CROP_WIN (offset 0x10034, printed page 10-137, `hi3516av100--Hi3516A-Hi3516D-Datasheet.txt` line 66699).";

        field {
            name = "height";
            desc = "Window height (in line). The configured value is the actual value minus 1.";
            sw = rw;
            hw = r;
            reset = 0xFFFF;
        } height[31:16];

        field {
            name = "width";
            desc = "Window width (in pixel). The configured value is the actual value minus 1.";
            sw = rw;
            hw = r;
            reset = 0xFFFF;
        } width[15:0];
    } ISP_CROP_WIN @ 0x10034;

    reg {
        name = "Crop start position register for region 0";
        desc = "ISP_CROP0_START is a crop start position register for region 0.

Data sheet 10.1.6 ISP_CROP0_START (offset 0x10038, printed page 10-137, `hi3516av100--Hi3516A-Hi3516D-Datasheet.txt` line 66722).";

        field {
            name = "y_start";
            desc = "ID of the line from which pictures start to be captured.";
            sw = rw;
            hw = r;
            reset = 0x0;
        } y_start[31:16];

        field {
            name = "x_start";
            desc = "ID of the pixel from which pictures start to be captured.";
            sw = rw;
            hw = r;
            reset = 0x0;
        } x_start[15:0];
    } ISP_CROP0_START @ 0x10038;

    reg {
        name = "Crop size configuration register for region 0";
        desc = "ISP_CROP0_SIZE is a crop size configuration register for region 0.

Data sheet 10.1.6 ISP_CROP0_SIZE (offset 0x1003C, printed page 10-137, `hi3516av100--Hi3516A-Hi3516D-Datasheet.txt` line 66741).";

        field {
            name = "height";
            desc = "Height (in line) of the obtained picture. The configured value is the actual value minus 1.";
            sw = rw;
            hw = r;
            reset = 0xFFFF;
        } height[31:16];

        field {
            name = "width";
            desc = "Width (in pixel) of a line in the obtained picture. The configured value is the actual value minus 1.";
            sw = rw;
            hw = r;
            reset = 0xFFFF;
        } width[15:0];
    } ISP_CROP0_SIZE @ 0x1003C;

    reg {
        name = "Crop start position register for region 1";
        desc = "ISP_CROP1_START is a crop start position register for region 1.

Data sheet 10.1.6 ISP_CROP1_START (offset 0x10040, printed page 10-138, `hi3516av100--Hi3516A-Hi3516D-Datasheet.txt` line 66775).";

        field {
            name = "y_start";
            desc = "ID of the line from which pictures start to be captured.";
            sw = rw;
            hw = r;
            reset = 0x0;
        } y_start[31:16];

        field {
            name = "x_start";
            desc = "ID of the pixel from which pictures start to be captured.";
            sw = rw;
            hw = r;
            reset = 0x0;
        } x_start[15:0];
    } ISP_CROP1_START @ 0x10040;

    reg {
        name = "Crop size configuration register for region 1";
        desc = "ISP_CROP1_SIZE is a crop size configuration register for region 1.

Data sheet 10.1.6 ISP_CROP1_SIZE (offset 0x10044, printed page 10-138, `hi3516av100--Hi3516A-Hi3516D-Datasheet.txt` line 66794).";

        field {
            name = "height";
            desc = "Height (in line) of the obtained picture. The configured value is the actual value minus 1.";
            sw = rw;
            hw = r;
            reset = 0xFFFF;
        } height[31:16];

        field {
            name = "width";
            desc = "Width (in pixel) of a line in the obtained picture. The configured value is the actual value minus 1.";
            sw = rw;
            hw = r;
            reset = 0xFFFF;
        } width[15:0];
    } ISP_CROP1_SIZE @ 0x10044;

    reg {
        name = "ISP interrupt status register";
        desc = "ISP_INT is an ISP interrupt status register. Huawei Proprietary and Confidential Hi3516A/Hi3516D Professional HD IP Camera SoC

Data sheet 10.1.6 ISP_INT (offset 0x100F0, printed page 10-139, `hi3516av100--Hi3516A-Hi3516D-Datasheet.txt` line 66827).";

        enum ISP_INT_int7_enum {
            NO_INTERRUPT_GENERATED = 0 { name = "No Interrupt Generated"; desc = "No interrupt is generated."; };
            INTERRUPT_GENERATED = 1 { name = "Interrupt Generated"; desc = "An interrupt is generated."; };
        };

        field {
            name = "int7";
            desc = "Status of ISP interrupt 7. Writing 1 clears the interrupt.";
            sw = rw;
            hw = w;
            onwrite = woclr;
            encode = ISP_INT_int7_enum;
            reset = 0x0;
        } int7[7:7];

        enum ISP_INT_int6_enum {
            NO_INTERRUPT_GENERATED = 0 { name = "No Interrupt Generated"; desc = "No interrupt is generated."; };
            INTERRUPT_GENERATED = 1 { name = "Interrupt Generated"; desc = "An interrupt is generated."; };
        };

        field {
            name = "int6";
            desc = "Status of ISP interrupt 6. Writing 1 clears the interrupt.";
            sw = rw;
            hw = w;
            onwrite = woclr;
            encode = ISP_INT_int6_enum;
            reset = 0x0;
        } int6[6:6];

        enum ISP_INT_int5_enum {
            NO_INTERRUPT_GENERATED = 0 { name = "No Interrupt Generated"; desc = "No interrupt is generated."; };
            INTERRUPT_GENERATED = 1 { name = "Interrupt Generated"; desc = "An interrupt is generated."; };
        };

        field {
            name = "int5";
            desc = "Status of ISP interrupt 5. Writing 1 clears the interrupt.";
            sw = rw;
            hw = w;
            onwrite = woclr;
            encode = ISP_INT_int5_enum;
            reset = 0x0;
        } int5[5:5];

        enum ISP_INT_int4_enum {
            NO_INTERRUPT_GENERATED = 0 { name = "No Interrupt Generated"; desc = "No interrupt is generated."; };
            INTERRUPT_GENERATED = 1 { name = "Interrupt Generated"; desc = "An interrupt is generated."; };
        };

        field {
            name = "int4";
            desc = "Status of ISP interrupt 4. Writing 1 clears the interrupt.";
            sw = rw;
            hw = w;
            onwrite = woclr;
            encode = ISP_INT_int4_enum;
            reset = 0x0;
        } int4[4:4];

        enum ISP_INT_int3_enum {
            NO_INTERRUPT_GENERATED = 0 { name = "No Interrupt Generated"; desc = "No interrupt is generated."; };
            INTERRUPT_GENERATED = 1 { name = "Interrupt Generated"; desc = "An interrupt is generated."; };
        };

        field {
            name = "int3";
            desc = "Status of ISP interrupt 3. Writing 1 clears the interrupt.";
            sw = rw;
            hw = w;
            onwrite = woclr;
            encode = ISP_INT_int3_enum;
            reset = 0x0;
        } int3[3:3];

        enum ISP_INT_int2_enum {
            NO_INTERRUPT_GENERATED = 0 { name = "No Interrupt Generated"; desc = "No interrupt is generated."; };
            INTERRUPT_GENERATED = 1 { name = "Interrupt Generated"; desc = "An interrupt is generated."; };
        };

        field {
            name = "int2";
            desc = "Status of ISP interrupt 2. Writing 1 clears the interrupt.";
            sw = rw;
            hw = w;
            onwrite = woclr;
            encode = ISP_INT_int2_enum;
            reset = 0x0;
        } int2[2:2];

        enum ISP_INT_int1_enum {
            NO_INTERRUPT_GENERATED = 0 { name = "No Interrupt Generated"; desc = "No interrupt is generated."; };
            INTERRUPT_GENERATED = 1 { name = "Interrupt Generated"; desc = "An interrupt is generated."; };
        };

        field {
            name = "int1";
            desc = "Status of ISP interrupt 1. Writing 1 clears the interrupt.";
            sw = rw;
            hw = w;
            onwrite = woclr;
            encode = ISP_INT_int1_enum;
            reset = 0x0;
        } int1[1:1];

        enum ISP_INT_int0_enum {
            NO_INTERRUPT_GENERATED = 0 { name = "No Interrupt Generated"; desc = "No interrupt is generated."; };
            INTERRUPT_GENERATED = 1 { name = "Interrupt Generated"; desc = "An interrupt is generated."; };
        };

        field {
            name = "int0";
            desc = "Status of ISP interrupt 0. Writing 1 clears the interrupt.";
            sw = rw;
            hw = w;
            onwrite = woclr;
            encode = ISP_INT_int0_enum;
            reset = 0x0;
        } int0[0:0];
    } ISP_INT @ 0x100F0;

    reg {
        name = "ISP interrupt mask register";
        desc = "ISP_INT_MASK is an ISP interrupt mask register. Huawei Proprietary and Confidential Hi3516A/Hi3516D Professional HD IP Camera SoC

Data sheet 10.1.6 ISP_INT_MASK (offset 0x100F8, printed page 10-140, `hi3516av100--Hi3516A-Hi3516D-Datasheet.txt` line 66881).";

        enum ISP_INT_MASK_int7_en_enum {
            NO_INTERRUPT_GENERATED = 0 { name = "No Interrupt Generated"; desc = "No interrupt is generated."; };
            INTERRUPT_GENERATED = 1 { name = "Interrupt Generated"; desc = "An interrupt is generated."; };
        };

        field {
            name = "int7_en";
            desc = "ISP interrupt 7 mask.";
            sw = rw;
            hw = r;
            encode = ISP_INT_MASK_int7_en_enum;
            reset = 0x0;
        } int7_en[7:7];

        enum ISP_INT_MASK_int6_en_enum {
            NO_INTERRUPT_GENERATED = 0 { name = "No Interrupt Generated"; desc = "No interrupt is generated."; };
            INTERRUPT_GENERATED = 1 { name = "Interrupt Generated"; desc = "An interrupt is generated."; };
        };

        field {
            name = "int6_en";
            desc = "ISP interrupt 6 mask.";
            sw = rw;
            hw = r;
            encode = ISP_INT_MASK_int6_en_enum;
            reset = 0x0;
        } int6_en[6:6];

        enum ISP_INT_MASK_int5_en_enum {
            NO_INTERRUPT_GENERATED = 0 { name = "No Interrupt Generated"; desc = "No interrupt is generated."; };
            INTERRUPT_GENERATED = 1 { name = "Interrupt Generated"; desc = "An interrupt is generated."; };
        };

        field {
            name = "int5_en";
            desc = "ISP interrupt 5 mask.";
            sw = rw;
            hw = r;
            encode = ISP_INT_MASK_int5_en_enum;
            reset = 0x0;
        } int5_en[5:5];

        enum ISP_INT_MASK_int4_en_enum {
            NO_INTERRUPT_GENERATED = 0 { name = "No Interrupt Generated"; desc = "No interrupt is generated."; };
            INTERRUPT_GENERATED = 1 { name = "Interrupt Generated"; desc = "An interrupt is generated."; };
        };

        field {
            name = "int4_en";
            desc = "ISP interrupt 4 mask.";
            sw = rw;
            hw = r;
            encode = ISP_INT_MASK_int4_en_enum;
            reset = 0x0;
        } int4_en[4:4];

        enum ISP_INT_MASK_int3_en_enum {
            NO_INTERRUPT_GENERATED = 0 { name = "No Interrupt Generated"; desc = "No interrupt is generated."; };
            INTERRUPT_GENERATED = 1 { name = "Interrupt Generated"; desc = "An interrupt is generated."; };
        };

        field {
            name = "int3_en";
            desc = "ISP interrupt 3 mask.";
            sw = rw;
            hw = r;
            encode = ISP_INT_MASK_int3_en_enum;
            reset = 0x0;
        } int3_en[3:3];

        enum ISP_INT_MASK_int2_en_enum {
            NO_INTERRUPT_GENERATED = 0 { name = "No Interrupt Generated"; desc = "No interrupt is generated."; };
            INTERRUPT_GENERATED = 1 { name = "Interrupt Generated"; desc = "An interrupt is generated."; };
        };

        field {
            name = "int2_en";
            desc = "ISP interrupt 2 mask.";
            sw = rw;
            hw = r;
            encode = ISP_INT_MASK_int2_en_enum;
            reset = 0x0;
        } int2_en[2:2];

        enum ISP_INT_MASK_int1_en_enum {
            NO_INTERRUPT_GENERATED = 0 { name = "No Interrupt Generated"; desc = "No interrupt is generated."; };
            INTERRUPT_GENERATED = 1 { name = "Interrupt Generated"; desc = "An interrupt is generated."; };
        };

        field {
            name = "int1_en";
            desc = "ISP interrupt 1 mask.";
            sw = rw;
            hw = r;
            encode = ISP_INT_MASK_int1_en_enum;
            reset = 0x0;
        } int1_en[1:1];

        enum ISP_INT_MASK_int0_en_enum {
            NO_INTERRUPT_GENERATED = 0 { name = "No Interrupt Generated"; desc = "No interrupt is generated."; };
            INTERRUPT_GENERATED = 1 { name = "Interrupt Generated"; desc = "An interrupt is generated."; };
        };

        field {
            name = "int0_en";
            desc = "ISP interrupt 0 mask.";
            sw = rw;
            hw = r;
            encode = ISP_INT_MASK_int0_en_enum;
            reset = 0x0;
        } int0_en[0:0];
    } ISP_INT_MASK @ 0x100F8;

    reg {
        name = "FPN configuration register";
        desc = "ISP_FPN_CFG is an FPN configuration register. Huawei Proprietary and Confidential Hi3516A/Hi3516D Professional HD IP Camera SoC

Data sheet 10.1.6 ISP_FPN_CFG (offset 0x10100, printed page 10-141, `hi3516av100--Hi3516A-Hi3516D-Datasheet.txt` line 66934).";

        enum ISP_FPN_CFG_gt_en_enum {
            DISABLED = 0 { name = "Disabled"; desc = "disabled (the clock is normal)"; };
            ENABLED = 1 { name = "Enabled"; desc = "enabled (the clock is disabled)"; };
        };

        field {
            name = "gt_en";
            desc = "FPN clock gating enable.";
            sw = rw;
            hw = r;
            encode = ISP_FPN_CFG_gt_en_enum;
            reset = 0x0;
        } gt_en[31:31];

        enum ISP_FPN_CFG_line_frame_enum {
            FRAME_MODE = 0 { name = "Frame Mode"; desc = "frame mode"; };
            LINE_MODE = 1 { name = "Line Mode"; desc = "line mode"; };
        };

        field {
            name = "line_frame";
            desc = "FPN frame/line mode.";
            sw = rw;
            hw = r;
            encode = ISP_FPN_CFG_line_frame_enum;
            reset = 0x0;
        } line_frame[9:9];

        enum ISP_FPN_CFG_calib_corr_enum {
            CORRECTION_MODE = 0 { name = "Correction Mode"; desc = "correction mode"; };
            CALIBRATION_MODE = 1 { name = "Calibration Mode"; desc = "calibration mode"; };
        };

        field {
            name = "calib_corr";
            desc = "FPN correction/calibration mode.";
            sw = rw;
            hw = r;
            encode = ISP_FPN_CFG_calib_corr_enum;
            reset = 0x0;
        } calib_corr[8:8];

        enum ISP_FPN_CFG_enable_f_enum {
            ENABLED = 1 { name = "Enabled"; desc = "enabled"; };
            DISABLED = 0 { name = "Disabled"; desc = "disabled"; };
        };

        field {
            name = "enable";
            desc = "FPN enable.";
            sw = rw;
            hw = r;
            encode = ISP_FPN_CFG_enable_f_enum;
            reset = 0x0;
        } enable_f[0:0];
    } ISP_FPN_CFG @ 0x10100;

    reg {
        name = "FPN calibration start signal register";
        desc = "ISP_FPN_CALIB_START is an FPN calibration start signal register.

Data sheet 10.1.6 ISP_FPN_CALIB_START (offset 0x10104, printed page 10-141, `hi3516av100--Hi3516A-Hi3516D-Datasheet.txt` line 66971).";

        field {
            name = "calib_start";
            desc = "FPN calibration start. This bit is automatically cleared.";
            sw = rw;
            hw = r;
            reset = 0x0;
        } calib_start[0:0];
    } ISP_FPN_CALIB_START @ 0x10104;

    reg {
        name = "FPN correction enable register";
        desc = "ISP_FPN_CORR_CFG is an FPN correction enable register.

Data sheet 10.1.6 ISP_FPN_CORR_CFG (offset 0x10108, printed page 10-142, `hi3516av100--Hi3516A-Hi3516D-Datasheet.txt` line 67006).";

        enum ISP_FPN_CORR_CFG_correct1_en_enum {
            DISABLED = 0 { name = "Disabled"; desc = "disabled"; };
            ENABLED = 1 { name = "Enabled"; desc = "enabled"; };
        };

        field {
            name = "correct1_en";
            desc = "FPN correction enable for channel 1.";
            sw = rw;
            hw = r;
            encode = ISP_FPN_CORR_CFG_correct1_en_enum;
            reset = 0x1;
        } correct1_en[1:1];

        enum ISP_FPN_CORR_CFG_correct0_en_enum {
            DISABLED = 0 { name = "Disabled"; desc = "disabled"; };
            ENABLED = 1 { name = "Enabled"; desc = "enabled"; };
        };

        field {
            name = "correct0_en";
            desc = "FPN correction enable for channel 0.";
            sw = rw;
            hw = r;
            encode = ISP_FPN_CORR_CFG_correct0_en_enum;
            reset = 0x1;
        } correct0_en[0:0];
    } ISP_FPN_CORR_CFG @ 0x10108;

    reg {
        name = "FPN calibration status register";
        desc = "ISP_FPN_STAT is an FPN calibration status register.

Data sheet 10.1.6 ISP_FPN_STAT (offset 0x1010C, printed page 10-142, `hi3516av100--Hi3516A-Hi3516D-Datasheet.txt` line 67036).";

        field {
            name = "hcnt";
            desc = "Number of lines";
            sw = r;
            hw = w;
            reset = 0x0;
        } hcnt[28:16];

        field {
            name = "vcnt";
            desc = "Number of calibrated frames.";
            sw = r;
            hw = w;
            reset = 0x0;
        } vcnt[13:8];

        enum ISP_FPN_STAT_busy_enum {
            IDLE = 0 { name = "Idle"; desc = "idle"; };
            BEING_CALIBRATED = 1 { name = "Being Calibrated"; desc = "being calibrated"; };
        };

        field {
            name = "busy";
            desc = "FPN calibration status";
            sw = r;
            hw = w;
            encode = ISP_FPN_STAT_busy_enum;
            reset = 0x0;
        } busy[0:0];
    } ISP_FPN_STAT @ 0x1010C;

    reg {
        name = "FPN calibration white point configuration register";
        desc = "ISP_FPN_WHITE_LEVEL is an FPN calibration white point configuration register.

Data sheet 10.1.6 ISP_FPN_WHITE_LEVEL (offset 0x10110, printed page 10-143, `hi3516av100--Hi3516A-Hi3516D-Datasheet.txt` line 67074).";

        field {
            name = "white_level";
            desc = "FPN calibration white point configuration.";
            sw = rw;
            hw = r;
            reset = 0x0;
        } white_level[13:0];
    } ISP_FPN_WHITE_LEVEL @ 0x10110;

    reg {
        name = "FPN calibration division coefficient register";
        desc = "ISP_FPN_DIVCOEF is an FPN calibration division coefficient register.

Data sheet 10.1.6 ISP_FPN_DIVCOEF (offset 0x10118, printed page 10-143, `hi3516av100--Hi3516A-Hi3516D-Datasheet.txt` line 67093).";

        field {
            name = "divcoef";
            desc = "FPN calibration division coefficient.";
            sw = rw;
            hw = r;
            reset = 0x0;
        } divcoef[11:0];
    } ISP_FPN_DIVCOEF @ 0x10118;

    reg {
        name = "FPN calibrated frame number register";
        desc = "ISP_FPN_FRAMELOG2 is an FPN calibrated frame number register. Huawei Proprietary and Confidential Hi3516A/Hi3516D Professional HD IP Camera SoC

Data sheet 10.1.6 ISP_FPN_FRAMELOG2 (offset 0x1011C, printed page 10-144, `hi3516av100--Hi3516A-Hi3516D-Datasheet.txt` line 67120).";

        field {
            name = "cpi_fpn_framelog2";
            desc = "Number of FPN calibrated frames. The configured value is obtained by taking the logarithm of the number of frames to 2.";
            sw = rw;
            hw = r;
            reset = 0x0;
        } cpi_fpn_framelog2[2:0];
    } ISP_FPN_FRAMELOG2 @ 0x1011C;

    reg {
        name = "FPN calibration accumulated sum low register";
        desc = "ISP_FPN_SUM0 is an FPN calibration accumulated sum low register.

Data sheet 10.1.6 ISP_FPN_SUM0 (offset 0x10120, printed page 10-144, `hi3516av100--Hi3516A-Hi3516D-Datasheet.txt` line 67148).";

        field {
            name = "sum";
            desc = "Lower bits of the FPN calibration accumulated sum.";
            sw = r;
            hw = w;
            reset = 0x0;
        } sum[31:0];
    } ISP_FPN_SUM0 @ 0x10120;

    reg {
        name = "FPN calibration accumulated sum high register";
        desc = "ISP_FPN_SUM1 is an FPN calibration accumulated sum high register. Huawei Proprietary and Confidential Hi3516A/Hi3516D Professional HD IP Camera SoC

Data sheet 10.1.6 ISP_FPN_SUM1 (offset 0x10124, printed page 10-145, `hi3516av100--Hi3516A-Hi3516D-Datasheet.txt` line 67176).";

        field {
            name = "sum";
            desc = "Upper bits of the FPN calibration accumulated sum.";
            sw = r;
            hw = w;
            reset = 0x0;
        } sum[31:0];
    } ISP_FPN_SUM1 @ 0x10124;

    reg {
        name = "FPN correction configuration register 0";
        desc = "ISP_FPN_CORR0 is FPN correction configuration register 0.

Data sheet 10.1.6 ISP_FPN_CORR0 (offset 0x10130, printed page 10-145, `hi3516av100--Hi3516A-Hi3516D-Datasheet.txt` line 67194).";

        field {
            name = "strength";
            desc = "FPN correction strength, U8.8.";
            sw = rw;
            hw = r;
            reset = 0x0;
        } strength[31:16];

        field {
            name = "offset";
            desc = "FPN correction bias.";
            sw = rw;
            hw = r;
            reset = 0x0;
        } offset[11:0];
    } ISP_FPN_CORR0 @ 0x10130;

    reg {
        name = "FPN correction configuration register 1";
        desc = "ISP_FPN_CORR1 is FPN correction configuration register 1.

Data sheet 10.1.6 ISP_FPN_CORR1 (offset 0x10134, printed page 10-145, `hi3516av100--Hi3516A-Hi3516D-Datasheet.txt` line 67214).";

        field {
            name = "strength";
            desc = "FPN correction strength, U8.8.";
            sw = rw;
            hw = r;
            reset = 0x0;
        } strength[31:16];

        field {
            name = "offset";
            desc = "FPN correction bias.";
            sw = rw;
            hw = r;
            reset = 0x0;
        } offset[11:0];
    } ISP_FPN_CORR1 @ 0x10134;

    reg {
        name = "FPN shift configuration register";
        desc = "ISP_FPN_SHIFT is an FPN shift configuration register.

Data sheet 10.1.6 ISP_FPN_SHIFT (offset 0x10140, printed page 10-146, `hi3516av100--Hi3516A-Hi3516D-Datasheet.txt` line 67242).";

        field {
            name = "frame_calib_shift";
            desc = "Number of left shift bits for the last output frame during frame calibration.";
            sw = rw;
            hw = r;
            reset = 0x0;
        } frame_calib_shift[27:24];

        field {
            name = "out_shift";
            desc = "Number of left shift bits for the output.";
            sw = rw;
            hw = r;
            reset = 0x0;
        } out_shift[19:16];

        field {
            name = "in_shift";
            desc = "Number of right shift bits for the input.";
            sw = rw;
            hw = r;
            reset = 0x0;
        } in_shift[11:8];

        field {
            name = "fpn_shift";
            desc = "Number of right shift bits for the input FPN.";
            sw = rw;
            hw = r;
            reset = 0x0;
        } fpn_shift[3:0];
    } ISP_FPN_SHIFT @ 0x10140;

    reg {
        name = "FPN maximum output value register";
        desc = "ISP_FPN_MAX_O is an FPN maximum output value register.

Data sheet 10.1.6 ISP_FPN_MAX_O (offset 0x10150, printed page 10-146, `hi3516av100--Hi3516A-Hi3516D-Datasheet.txt` line 67271).";

        field {
            name = "max_o";
            desc = "Maximum value of the FPN output.";
            sw = rw;
            hw = r;
            reset = 0x3FFF;
        } max_o[15:0];
    } ISP_FPN_MAX_O @ 0x10150;

    reg {
        name = "FPN picture size register";
        desc = "ISP_FPN_PIC_SIZE is an FPN picture size register.

Data sheet 10.1.6 ISP_FPN_PIC_SIZE (offset 0x101D0, printed page 10-147, `hi3516av100--Hi3516A-Hi3516D-Datasheet.txt` line 67296).";

        field {
            name = "height";
            desc = "Picture height. The configured value is the actual value minus 1. For example, the configured value is 1919 if the actual picture height is 1920.";
            sw = rw;
            hw = r;
            reset = 0x0;
        } height[28:16];

        field {
            name = "width";
            desc = "Picture width. The configured value is the actual value minus 1. For example, the configured value is 1079 if the actual picture width is 1080.";
            sw = rw;
            hw = r;
            reset = 0x0;
        } width[12:0];
    } ISP_FPN_PIC_SIZE @ 0x101D0;

    reg {
        name = "Register update register";
        desc = "ISP_FPN_REG_UPDATE is a register update register.

Data sheet 10.1.6 ISP_FPN_REG_UPDATE (offset 0x101D4, printed page 10-147, `hi3516av100--Hi3516A-Hi3516D-Datasheet.txt` line 67323).";

        field {
            name = "isp_newer";
            desc = "FPN update. This bit is automatically cleared for each frame.";
            sw = rw;
            hw = r;
            reset = 0x0;
        } isp_newer[0:0];
    } ISP_FPN_REG_UPDATE @ 0x101D4;

    reg {
        name = "Register update mode register";
        desc = "ISP_FPN_UPDATE_MODE is a register update mode register. Huawei Proprietary and Confidential Hi3516A/Hi3516D Professional HD IP Camera SoC

Data sheet 10.1.6 ISP_FPN_UPDATE_MODE (offset 0x101D8, printed page 10-148, `hi3516av100--Hi3516A-Hi3516D-Datasheet.txt` line 67356).";

        enum ISP_FPN_UPDATE_MODE_reg_update_mode_enum {
            REG_NEWER_UPDATE = 0 { name = "Reg Newer Update"; desc = "reg_newer update"; };
            UPDATE_FRAME = 1 { name = "Update Frame"; desc = "update by frame"; };
        };

        field {
            name = "reg_update_mode";
            desc = "FPN update mode.";
            sw = rw;
            hw = r;
            encode = ISP_FPN_UPDATE_MODE_reg_update_mode_enum;
            reset = 0x1;
        } reg_update_mode[0:0];
    } ISP_FPN_UPDATE_MODE @ 0x101D8;

    reg {
        name = "Dither configuration register";
        desc = "ISP_DITHER_CFG is a dither configuration register.

Data sheet 10.1.6 ISP_DITHER_CFG (offset 0x10200, printed page 10-148, `hi3516av100--Hi3516A-Hi3516D-Datasheet.txt` line 67384).";

        enum ISP_DITHER_CFG_enable_f_enum {
            DISABLED = 0 { name = "Disabled"; desc = "disabled"; };
            ENABLED = 1 { name = "Enabled"; desc = "enabled"; };
        };

        field {
            name = "enable";
            desc = "Dither enable.";
            sw = rw;
            hw = r;
            encode = ISP_DITHER_CFG_enable_f_enum;
            reset = 0x0;
        } enable_f[31:31];
    } ISP_DITHER_CFG @ 0x10200;

    reg {
        name = "Vertical blanking clock gating configuration register 0";
        desc = "ISP_VB_CFG0 is vertical blanking clock gating configuration register 0. Huawei Proprietary and Confidential Hi3516A/Hi3516D Professional HD IP Camera SoC

Data sheet 10.1.6 ISP_VB_CFG0 (offset 0x10300, printed page 10-149, `hi3516av100--Hi3516A-Hi3516D-Datasheet.txt` line 67417).";

        enum ISP_VB_CFG0_mem_pf_en_enum {
            DISABLED = 0 { name = "Disabled"; desc = "disabled"; };
            ENABLED = 1 { name = "Enabled"; desc = "enabled"; };
        };

        field {
            name = "mem_pf_en";
            desc = "Vertical blanking mem power-off enable.";
            sw = rw;
            hw = r;
            encode = ISP_VB_CFG0_mem_pf_en_enum;
            reset = 0x0;
        } mem_pf_en[4:4];

        enum ISP_VB_CFG0_gt_en_enum {
            DISABLED = 0 { name = "Disabled"; desc = "disabled"; };
            ENABLED = 1 { name = "Enabled"; desc = "enabled"; };
        };

        field {
            name = "gt_en";
            desc = "Vertical blanking clock gating enable.";
            sw = rw;
            hw = r;
            encode = ISP_VB_CFG0_gt_en_enum;
            reset = 0x0;
        } gt_en[0:0];
    } ISP_VB_CFG0 @ 0x10300;

    reg {
        name = "Vertical blanking clock gating configuration register 1";
        desc = "ISP_VB_CFG1 is vertical blanking clock gating configuration register 1.

Data sheet 10.1.6 ISP_VB_CFG1 (offset 0x10304, printed page 10-149, `hi3516av100--Hi3516A-Hi3516D-Datasheet.txt` line 67448).";

        enum ISP_VB_CFG1_vb_hb_en_enum {
            DISABLED = 0 { name = "Disabled"; desc = "disabled"; };
            ENABLED = 1 { name = "Enabled"; desc = "enabled"; };
        };

        field {
            name = "vb_hb_en";
            desc = "Data set-to-0 enable for vertical blanking and horizontal blanking.";
            sw = rw;
            hw = r;
            encode = ISP_VB_CFG1_vb_hb_en_enum;
            reset = 0x0;
        } vb_hb_en[0:0];
    } ISP_VB_CFG1 @ 0x10304;

    reg {
        name = "Wait clock number configuration register for vertical blanking clock gating";
        desc = "ISP_VB_CLKNUM is a wait clock number configuration register for vertical blanking clock gating

Data sheet 10.1.6 ISP_VB_CLKNUM (offset 0x10310, printed page 10-150, `hi3516av100--Hi3516A-Hi3516D-Datasheet.txt` line 67481).";

        field {
            name = "clknum";
            desc = "Number of wait clocks for vertical blanking clock gating.";
            sw = rw;
            hw = r;
            reset = 0xFC60;
        } clknum[31:0];
    } ISP_VB_CLKNUM @ 0x10310;

    reg {
        name = "ISP_VB_DLYN";
        desc = "ISP_VB_DLYN is a wait clock number configuration register for disabling the clock after the vertical blanking clock gating indicator is valid.

Data sheet 10.1.6 ISP_VB_DLYN (offset 0x10314, printed page 10-150, `hi3516av100--Hi3516A-Hi3516D-Datasheet.txt` line 67500).";

        field {
            name = "dlyn";
            desc = "Number of wait clocks for disabling the clock after the vertical blanking clock gating indicator is valid.";
            sw = rw;
            hw = r;
            reset = 0x2;
        } dlyn[31:0];
    } ISP_VB_DLYN @ 0x10314;

    reg {
        name = "Vertical blanking clock count reset trigger configuration register";
        desc = "ISP_VB_TRIG is a vertical blanking clock count reset trigger configuration register. Huawei Proprietary and Confidential Hi3516A/Hi3516D Professional HD IP Camera SoC

Data sheet 10.1.6 ISP_VB_TRIG (offset 0x10318, printed page 10-151, `hi3516av100--Hi3516A-Hi3516D-Datasheet.txt` line 67530).";

        enum ISP_VB_TRIG_vld_rst_en_enum {
            DISABLED = 0 { name = "Disabled"; desc = "disabled"; };
            ENABLED = 1 { name = "Enabled"; desc = "enabled"; };
        };

        field {
            name = "vld_rst_en";
            desc = "Valid count reset enable.";
            sw = rw;
            hw = r;
            encode = ISP_VB_TRIG_vld_rst_en_enum;
            reset = 0x1;
        } vld_rst_en[2:2];

        enum ISP_VB_TRIG_hs_rst_en_enum {
            DISABLED = 0 { name = "Disabled"; desc = "disabled"; };
            ENABLED = 1 { name = "Enabled"; desc = "enabled"; };
        };

        field {
            name = "hs_rst_en";
            desc = "hsync count reset enable.";
            sw = rw;
            hw = r;
            encode = ISP_VB_TRIG_hs_rst_en_enum;
            reset = 0x1;
        } hs_rst_en[1:1];

        enum ISP_VB_TRIG_vs_rst_en_enum {
            DISABLED = 0 { name = "Disabled"; desc = "disabled"; };
            ENABLED = 1 { name = "Enabled"; desc = "enabled"; };
        };

        field {
            name = "vs_rst_en";
            desc = "vsync count reset enable.";
            sw = rw;
            hw = r;
            encode = ISP_VB_TRIG_vs_rst_en_enum;
            reset = 0x1;
        } vs_rst_en[0:0];
    } ISP_VB_TRIG @ 0x10318;

    reg {
        name = "Vertical blanking clock gating status register";
        desc = "ISP_VB_GT_STAT is a vertical blanking clock gating status register.

Data sheet 10.1.6 ISP_VB_GT_STAT (offset 0x1031C, printed page 10-151, `hi3516av100--Hi3516A-Hi3516D-Datasheet.txt` line 67563).";

        field {
            name = "gt_stat";
            desc = "Vertical blanking clock gating status.";
            sw = r;
            hw = w;
            reset = 0x0;
        } gt_stat[0:0];
    } ISP_VB_GT_STAT @ 0x1031C;

    reg {
        name = "Picture size register";
        desc = "ISP_VB_SIZE is a picture size register. Huawei Proprietary and Confidential Hi3516A/Hi3516D Professional HD IP Camera SoC

Data sheet 10.1.6 ISP_VB_SIZE (offset 0x103F0, printed page 10-152, `hi3516av100--Hi3516A-Hi3516D-Datasheet.txt` line 67592).";

        field {
            name = "height";
            desc = "Picture height (in line). The configured value is the actual value minus 1.";
            sw = rw;
            hw = r;
            reset = 0x797;
        } height[28:16];

        field {
            name = "width";
            desc = "Picture width (in pixel). The configured value is the actual value minus 1.";
            sw = rw;
            hw = r;
            reset = 0xA1F;
        } width[12:0];
    } ISP_VB_SIZE @ 0x103F0;

    reg {
        name = "FPN line mode memory register";
        desc = "ISP_FPN_MEM is an FPN line mode memory register.

Data sheet 10.1.6 ISP_FPN_MEM (offset 0x12000, printed page 10-152, `hi3516av100--Hi3516A-Hi3516D-Datasheet.txt` line 67619).";

        field {
            name = "mem1";
            desc = "Line mode FPN. There are 1296 registers in total.";
            sw = rw;
            hw = r;
            reset = 0x0;
        } mem1[31:16];

        field {
            name = "mem0";
            desc = "Line mode FPN.";
            sw = rw;
            hw = r;
            reset = 0x0;
        } mem0[15:0];
    } ISP_FPN_MEM[1296] @ 0x12000 += 0x4;

    reg {
        name = "Dehaze enable register";
        desc = "ISP_DEHAZE_CFG is a dehaze enable register. Huawei Proprietary and Confidential Hi3516A/Hi3516D Professional HD IP Camera SoC

Data sheet 10.1.6 ISP_DEHAZE_CFG (offset 0x19000, printed page 10-153, `hi3516av100--Hi3516A-Hi3516D-Datasheet.txt` line 67648).";

        enum ISP_DEHAZE_CFG_clken_enum {
            DEHAZE_CLOCK_NORMAL = 0 { name = "Dehaze Clock Normal"; desc = "The dehaze clock is normal."; };
            DEHAZE_CLOCK_DISABLED = 1 { name = "Dehaze Clock Disabled"; desc = "The dehaze clock is disabled (low power consumption)."; };
        };

        field {
            name = "clken";
            desc = "Dehaze clock gating enable.";
            sw = rw;
            hw = r;
            encode = ISP_DEHAZE_CFG_clken_enum;
            reset = 0x0;
        } clken[31:31];

        enum ISP_DEHAZE_CFG_en_enum {
            DISABLED = 0 { name = "Disabled"; desc = "disabled"; };
            ENABLED = 1 { name = "Enabled"; desc = "enabled"; };
        };

        field {
            name = "en";
            desc = "Dehaze enable.";
            sw = rw;
            hw = r;
            encode = ISP_DEHAZE_CFG_en_enum;
            reset = 0x0;
        } en[0:0];
    } ISP_DEHAZE_CFG @ 0x19000;

    reg {
        name = "Dehaze version register";
        desc = "ISP_DEHAZE_VERSION is a dehaze version register.

Data sheet 10.1.6 ISP_DEHAZE_VERSION (offset 0x1900C, printed page 10-153, `hi3516av100--Hi3516A-Hi3516D-Datasheet.txt` line 67674).";

        field {
            name = "version";
            desc = "Dehaze version.";
            sw = r;
            hw = w;
            reset = 0x0;
        } version[31:0];
    } ISP_DEHAZE_VERSION @ 0x1900C;

    reg {
        name = "Dehaze statistics update register";
        desc = "ISP_DEHAZE_PRE_UPDATE is a dehaze statistics update register. Huawei Proprietary and Confidential Hi3516A/Hi3516D Professional HD IP Camera SoC

Data sheet 10.1.6 ISP_DEHAZE_PRE_UPDATE (offset 0x19010, printed page 10-154, `hi3516av100--Hi3516A-Hi3516D-Datasheet.txt` line 67702).";

        field {
            name = "pre_update";
            desc = "Dehaze statistics update. This bit is automatically cleared for each frame.";
            sw = rw;
            hw = r;
            reset = 0x0;
        } pre_update[0:0];
    } ISP_DEHAZE_PRE_UPDATE @ 0x19010;

    reg {
        name = "Dehaze block size configuration register";
        desc = "ISP_DEHAZE_BLK_SIZE is a dehaze block size configuration register.

Data sheet 10.1.6 ISP_DEHAZE_BLK_SIZE (offset 0x19014, printed page 10-154, `hi3516av100--Hi3516A-Hi3516D-Datasheet.txt` line 67729).";

        field {
            name = "block_sizeh";
            desc = "Horizontal block size. The configured value is the actual value minus 1.";
            sw = rw;
            hw = r;
            reset = 0x0;
        } block_sizeh[24:16];

        field {
            name = "block_sizev";
            desc = "Vertical block size. The configured value is the actual value minus 1.";
            sw = rw;
            hw = r;
            reset = 0x0;
        } block_sizev[8:0];
    } ISP_DEHAZE_BLK_SIZE @ 0x19014;

    reg {
        name = "Dehaze block number configuration register";
        desc = "ISP_DEHAZE_BLK_NUM is a dehaze block number configuration register. Huawei Proprietary and Confidential Hi3516A/Hi3516D Professional HD IP Camera SoC

Data sheet 10.1.6 ISP_DEHAZE_BLK_NUM (offset 0x19018, printed page 10-155, `hi3516av100--Hi3516A-Hi3516D-Datasheet.txt` line 67764).";

        field {
            name = "block_numh";
            desc = "Number of horizontal blocks. The configured value is the actual value minus 1.";
            sw = rw;
            hw = r;
            reset = 0x0;
        } block_numh[20:16];

        field {
            name = "block_numv";
            desc = "Number of vertical blocks. The configured value is the actual value minus 1.";
            sw = rw;
            hw = r;
            reset = 0x0;
        } block_numv[4:0];
    } ISP_DEHAZE_BLK_NUM @ 0x19018;

    reg {
        name = "Bilinear interpolation point number configuration register";
        desc = "ISP_DEHAZE_DC_SIZE is a bilinear interpolation point number configuration register.

Data sheet 10.1.6 ISP_DEHAZE_DC_SIZE (offset 0x1901C, printed page 10-155, `hi3516av100--Hi3516A-Hi3516D-Datasheet.txt` line 67789).";

        field {
            name = "dc_numh";
            desc = "Number of bilinear interpolation horizontal points. The configured value is the actual value minus 1.";
            sw = rw;
            hw = r;
            reset = 0x0;
        } dc_numh[9:5];

        field {
            name = "dc_numv";
            desc = "Number of bilinear interpolation vertical points. The configured value is the actual value minus 1.";
            sw = rw;
            hw = r;
            reset = 0x0;
        } dc_numv[4:0];
    } ISP_DEHAZE_DC_SIZE @ 0x1901C;

    reg {
        name = "ISP_DEHAZE_X";
        desc = "ISP_DEHAZE_X is a configuration register for the horizontal phase difference between the pixels of the dehaze enlarged picture. Huawei Proprietary and Confidential Hi3516A/Hi3516D Professional HD IP Camera SoC

Data sheet 10.1.6 ISP_DEHAZE_X (offset 0x19020, printed page 10-156, `hi3516av100--Hi3516A-Hi3516D-Datasheet.txt` line 67824).";

        field {
            name = "phase_x";
            desc = "Horizontal phase difference between the pixels of the enlarged picture. It is an unsigned integer.";
            sw = rw;
            hw = r;
            reset = 0x0;
        } phase_x[21:0];
    } ISP_DEHAZE_X @ 0x19020;

    reg {
        name = "ISP_DEHAZE_Y";
        desc = "ISP_DEHAZE_Y is a configuration register for the vertical phase difference between the pixels of the dehaze enlarged picture.

Data sheet 10.1.6 ISP_DEHAZE_Y (offset 0x19024, printed page 10-156, `hi3516av100--Hi3516A-Hi3516D-Datasheet.txt` line 67846).";

        field {
            name = "phase_y";
            desc = "Vertical phase difference between the pixels of the enlarged picture. It is an unsigned integer.";
            sw = rw;
            hw = r;
            reset = 0x0;
        } phase_y[21:0];
    } ISP_DEHAZE_Y @ 0x19024;

    reg {
        name = "Dehaze statistics mode control register";
        desc = "ISP_DEHAZE_STAT_MODE is a dehaze statistics mode control register. Huawei Proprietary and Confidential Hi3516A/Hi3516D Professional HD IP Camera SoC

Data sheet 10.1.6 ISP_DEHAZE_STAT_MODE (offset 0x19028, printed page 10-157, `hi3516av100--Hi3516A-Hi3516D-Datasheet.txt` line 67877).";

        enum ISP_DEHAZE_STAT_MODE_max_mode_enum {
            MEAN_FILTERING_PERFORMED = 0 { name = "Mean Filtering Performed"; desc = "Mean filtering is performed on RGB components, and then the RGB components corresponding to the maximum RGB sum of each window are counted."; };
            RGB_COMPONENTS_CORRESPONDING = 1 { name = "Rgb Components Corresponding"; desc = "The RGB components corresponding to the maximum RGB sum of each window are counted."; };
        };

        field {
            name = "max_mode";
            desc = "Maximum value statistics control.";
            sw = rw;
            hw = r;
            encode = ISP_DEHAZE_STAT_MODE_max_mode_enum;
            reset = 0x0;
        } max_mode[2:2];

        enum ISP_DEHAZE_STAT_MODE_min_mode_enum {
            MINIMUM_VALUE_AMONG = 0 { name = "Minimum Value Among"; desc = "The minimum value among RGB components is selected for mean filtering, and the minimum value of each window is counted."; };
            MINIMUM_VALUE_AMONG_2 = 1 { name = "Minimum Value Among 2"; desc = "The minimum value among RGB components is selected, and the minimum value of each window is counted."; };
            MINIMUM_VALUE_RGB = 2 { name = "Minimum Value Rgb"; desc = "The minimum value of the RGB mean filtering results is selected for mean filtering, and the minimum value of each window is counted. Other values: not processed"; };
        };

        field {
            name = "min_mode";
            desc = "Minimum value statistics control.";
            sw = rw;
            hw = r;
            encode = ISP_DEHAZE_STAT_MODE_min_mode_enum;
            reset = 0x0;
        } min_mode[1:0];
    } ISP_DEHAZE_STAT_MODE @ 0x19028;

    reg {
        name = "Dehaze inversion enable register";
        desc = "ISP_DEHAZE_NEG_MODE is a dehaze inversion enable register.

Data sheet 10.1.6 ISP_DEHAZE_NEG_MODE (offset 0x1902C, printed page 10-157, `hi3516av100--Hi3516A-Hi3516D-Datasheet.txt` line 67917).";

        enum ISP_DEHAZE_NEG_MODE_neg_mode_enum {
            NORMAL_MODE = 0 { name = "Normal Mode"; desc = "normal mode"; };
            INVERSION_MODE = 1 { name = "Inversion Mode"; desc = "inversion mode"; };
        };

        field {
            name = "neg_mode";
            desc = "Inversion mode control.";
            sw = rw;
            hw = r;
            encode = ISP_DEHAZE_NEG_MODE_neg_mode_enum;
            reset = 0x0;
        } neg_mode[0:0];
    } ISP_DEHAZE_NEG_MODE @ 0x1902C;

    reg {
        name = "Dehaze airglow configuration register";
        desc = "ISP_DEHAZE_AIR is a dehaze airglow configuration register.

Data sheet 10.1.6 ISP_DEHAZE_AIR (offset 0x19030, printed page 10-158, `hi3516av100--Hi3516A-Hi3516D-Datasheet.txt` line 67954).";

        field {
            name = "air_r";
            desc = "Airglow A corresponding to the R channel.";
            sw = rw;
            hw = r;
            reset = 0x0;
        } air_r[23:16];

        field {
            name = "air_g";
            desc = "Airglow A corresponding to the G channel.";
            sw = rw;
            hw = r;
            reset = 0x0;
        } air_g[15:8];

        field {
            name = "air_b";
            desc = "Airglow A corresponding to the B channel.";
            sw = rw;
            hw = r;
            reset = 0x0;
        } air_b[7:0];
    } ISP_DEHAZE_AIR @ 0x19030;

    reg {
        name = "T threshold coefficient configuration register";
        desc = "ISP_DEHAZE_THLD is a T threshold coefficient configuration register.

Data sheet 10.1.6 ISP_DEHAZE_THLD (offset 0x19034, printed page 10-158, `hi3516av100--Hi3516A-Hi3516D-Datasheet.txt` line 67975).";

        field {
            name = "thld";
            desc = "T threshold coefficient. It is an unsigned integer.";
            sw = rw;
            hw = r;
            reset = 0x0;
        } thld[7:0];
    } ISP_DEHAZE_THLD @ 0x19034;

    reg {
        name = "T calculation coefficient configuration register";
        desc = "ISP_DEHAZE_GSTRTH is a T calculation coefficient configuration register. Huawei Proprietary and Confidential Hi3516A/Hi3516D Professional HD IP Camera SoC

Data sheet 10.1.6 ISP_DEHAZE_GSTRTH (offset 0x19038, printed page 10-159, `hi3516av100--Hi3516A-Hi3516D-Datasheet.txt` line 68004).";

        field {
            name = "gstrth";
            desc = "T calculation coefficient. It is an unsigned integer.";
            sw = rw;
            hw = r;
            reset = 0x0;
        } gstrth[7:0];
    } ISP_DEHAZE_GSTRTH @ 0x19038;

    reg {
        name = "Minimum value filtering threshold coefficient configuration register";
        desc = "ISP_DEHAZE_BLTHLD is a minimum value filtering threshold coefficient configuration register.

Data sheet 10.1.6 ISP_DEHAZE_BLTHLD (offset 0x1903C, printed page 10-159, `hi3516av100--Hi3516A-Hi3516D-Datasheet.txt` line 68024).";

        field {
            name = "blthld";
            desc = "Minimum value filtering threshold coefficient. It is an unsigned integer.";
            sw = rw;
            hw = r;
            reset = 0x0;
        } blthld[7:0];
    } ISP_DEHAZE_BLTHLD @ 0x1903C;

    reg {
        name = "Dehaze register update control register";
        desc = "ISP_DEHAZE_CTRL_I is a dehaze register update control register. Huawei Proprietary and Confidential Hi3516A/Hi3516D Professional HD IP Camera SoC

Data sheet 10.1.6 ISP_DEHAZE_CTRL_I (offset 0x190E4, printed page 10-160, `hi3516av100--Hi3516A-Hi3516D-Datasheet.txt` line 68055).";

        enum ISP_DEHAZE_CTRL_I_update_mode_enum {
            UPDATE_UPDATE_REGISTER = 0 { name = "Update Update Register"; desc = "update by update register"; };
            UPDATE_FRAME = 1 { name = "Update Frame"; desc = "update by frame"; };
        };

        field {
            name = "update_mode";
            desc = "Dehaze register update mode.";
            sw = rw;
            hw = r;
            encode = ISP_DEHAZE_CTRL_I_update_mode_enum;
            reset = 0x1;
        } update_mode[0:0];
    } ISP_DEHAZE_CTRL_I @ 0x190E4;

    reg {
        name = "Dehaze register update register";
        desc = "ISP_DEHAZE_UPDATE is a dehaze register update register.

Data sheet 10.1.6 ISP_DEHAZE_UPDATE (offset 0x190EC, printed page 10-160, `hi3516av100--Hi3516A-Hi3516D-Datasheet.txt` line 68082).";

        field {
            name = "newer";
            desc = "Dehaze register update. This bit is automatically cleared for each frame.";
            sw = rw;
            hw = r;
            reset = 0x0;
        } newer[0:0];
    } ISP_DEHAZE_UPDATE @ 0x190EC;

    reg {
        name = "DEHAZE picture size register";
        desc = "ISP_DEHAZE_SIZE is a DEHAZE picture size register. Huawei Proprietary and Confidential Hi3516A/Hi3516D Professional HD IP Camera SoC

Data sheet 10.1.6 ISP_DEHAZE_SIZE (offset 0x190F0, printed page 10-161, `hi3516av100--Hi3516A-Hi3516D-Datasheet.txt` line 68115).";

        field {
            name = "height";
            desc = "Window height (in line). The configured value is the actual value minus 1.";
            sw = rw;
            hw = r;
            reset = 0x0;
        } height[28:16];

        field {
            name = "width";
            desc = "Window width (in pixel). The configured value is the actual value minus 1.";
            sw = rw;
            hw = r;
            reset = 0x0;
        } width[12:0];
    } ISP_DEHAZE_SIZE @ 0x190F0;

    reg {
        name = "Dehaze minimum value statistics register";
        desc = "ISP_DEHAZE_MINSTAT is a dehaze minimum value statistics register.

Data sheet 10.1.6 ISP_DEHAZE_MINSTAT (offset 0x19100, printed page 10-161, `hi3516av100--Hi3516A-Hi3516D-Datasheet.txt` line 68142).";

        field {
            name = "minstat";
            desc = "Dehaze minimum value statistics write address. There are 64 minimum values in total.";
            sw = rw;
            hw = r;
            reset = 0x0;
        } minstat[31:0];
    } ISP_DEHAZE_MINSTAT[64] @ 0x19100 += 0x4;

    reg {
        name = "Dehaze processed minimum value statistics register";
        desc = "ISP_DEHAZE_PRESTAT is a dehaze processed minimum value statistics register. Huawei Proprietary and Confidential Hi3516A/Hi3516D Professional HD IP Camera SoC

Data sheet 10.1.6 ISP_DEHAZE_PRESTAT (offset 0x19200, printed page 10-162, `hi3516av100--Hi3516A-Hi3516D-Datasheet.txt` line 68172).";

        field {
            name = "prestat";
            desc = "Processed minimum value statistics to be written. There are 64 minimum values in total.";
            sw = rw;
            hw = r;
            reset = 0x0;
        } prestat[31:0];
    } ISP_DEHAZE_PRESTAT[64] @ 0x19200 += 0x4;

    reg {
        name = "Dehaze maximum value statistics register";
        desc = "ISP_DEHAZE_MAXSTAT is a dehaze maximum value statistics register.

Data sheet 10.1.6 ISP_DEHAZE_MAXSTAT (offset 0x19400, printed page 10-162, `hi3516av100--Hi3516A-Hi3516D-Datasheet.txt` line 68192).";

        field {
            name = "maxstat";
            desc = "Dehaze maximum value statistics. There are 256 maximum values in total.";
            sw = rw;
            hw = r;
            reset = 0x0;
        } maxstat[23:0];
    } ISP_DEHAZE_MAXSTAT[256] @ 0x19400 += 0x4;

    reg {
        name = "Dehaze strength LUT configuration register";
        desc = "ISP_DEHAZE_LUT is a dehaze strength LUT configuration register.

Data sheet 10.1.6 ISP_DEHAZE_LUT (offset 0x19800, printed page 10-162, `hi3516av100--Hi3516A-Hi3516D-Datasheet.txt` line 68213).";

        field {
            name = "lutdata";
            desc = "Dehaze strength LUT. The LUT has 256 entries.";
            sw = rw;
            hw = r;
            reset = 0x0;
        } lutdata[7:0];
    } ISP_DEHAZE_LUT[256] @ 0x19800 += 0x4;
};

`endif
