`ifndef HISI_VEDU_RDL
`define HISI_VEDU_RDL

addrmap aHISI_VEDU {
    name = "HiSilicon VEDU (registers not described)";
    desc = "Not described: no register of this block is described in any data sheet (every data sheet that has the block lists only the memory-map window, the interrupt number and the clock/reset bits; the registers exist only in closed vendor libraries and modules). The 64 KB window is kept only so that the block base address and size exist in the address map (STUB). UPDATE 2026-11-11 (register comparison, docs/rdl-campaign/video-codec-crosschip.md): this stub now remains only on Hi3516C V100, Hi3516 V100, Hi3511 and Hi3512 (no vendor module for these chips); the other chips got aHISI_VEDU_V100 (Hi3518 A/C V100, Hi3518E V200, Hi3516C V200, Hi3516A/D AVC), aHISI_VEDU_V2 (Hi3516A/D VEDU, Hi3516A V200, Hi3519, Hi3516C V300, Hi3516E V100) or aHISI_VEDU_V3 (Hi3516A V300). The survey below is the original list. This stub is instantiated by chips with DIFFERENT encoder generations (cross-chip audit 2026-11-11, docs/rdl-campaign/vedu-crosschip.md): (1) Hi3516C V100 and Hi3518 A/C V100 at 0x20620000 (interrupt 24, H.264 Main/Baseline @4.1 'VENC', clock/reset PERI_CRG16 bits [1:0], separate JPGE at 0x20660000); (2) Hi3516 V100 at 0x20600000 (data sheet name VEDU, interrupt 51, H.264 BP/MP/HP and MPEG4 SP, clock/reset PERI_CRG18, separate JPEG block at 0x20610000 with interrupt 54); (3) Hi3518E V200 and Hi3516C V200 at 0x20620000 (data sheet name AVC, interrupt 24, H.264 High/Main/Baseline @5.1, clock/reset PERI_CRG16 bits [13:12], JPGE 0x20660000 interrupt 26); (4) Hi3516A/D V100 at 0x20640000 (VEDU = H.265 Main @5.1, interrupt 75, PERI_CRG16 bits [1:0]; the H.264 'AVC' encoder at 0x20620000, interrupt 72, PERI_CRG16 bits [13:12], is NOT in the RDL yet); (5) Hi3516A V200 and Hi3519 V101 at 0x11280000 (one VEDU for H.265 Main @6.0 and H.264, interrupt 69, PERI_CRG20, JPGE 0x11200000 interrupt 70); (6) Hi3516A V300 at 0x11500000 (H.265/H.264 with SVC-T, interrupt 72, PERI_CRG41, JPGE 0x11220000); (7) Hi3516C V300 and Hi3516E V100 at 0x11260000 (H.265/H.264, interrupt 24, PERI_CRG16, JPGE 0x11220000 interrupt 26); (8) Hi3511/Hi3512 V100 at 0x90080000 (H.264 Main @L3 encoder AND decoder with embedded ARM firmware, interrupt 28). Hi3515 V100 and Hi3520 V100 have the same kind of firmware-driven codec at 0x100E0000 (Hi3520 also 0x100F0000) with interrupts 20 (and 21); those windows are not in the RDL. The Hi3520D family does not use this stub: it instantiates aHISI_VEDU_V100 below (hardwired H.264 encoder at 0x20620000, interrupt 72, vendor-derived registers). Register layouts of the generations are unknown and must not be assumed equal. Listed as an open item in docs/rdl-sweep/PORT-BLOCKS.md.";

    external mem {
        name = "Undocumented register window";
        desc = "The whole 64 KB window of the block. Register layout unknown; placeholder so the block base address and size exist in the map. No registers are described.";
        mementries = 16384;
        memwidth = 32;
        sw = rw;
    } REGS;
};

addrmap aHISI_VEDU_V100 {
    name = "HiSilicon VEDU (Hi3520D V100 edition, vendor-derived registers)";
    desc = "VEDU, Hi3520D V100 edition (H.264 hardware encoder), vendor-derived, NOT VERIFIED ON HARDWARE. The data sheet has no VEDU register table (chapter 6 is overview only); this edition is derived from the vendor MPP modules of the Hi3520D_MPP_V2.0.5.1 SDK (hi3520D_chnl.ko: VEDU_HAL_*/VEDU_DRV_* and the VPU/IRQ glue; hi3520D_h264e.ko: H264E_DRV_*; hi3520D_sys.ko: CRG16 handling), static disassembly only, see docs/rdl-campaign/vedu-vendor.md. Result: 22 registers are named from vendor code evidence (offset, width and bits confirmed in the Hi3520D code; the names are the HiSTB drv_venc_reg_r006.h names, a neighbor generation whose offsets and bit layouts match the Hi3520D code in every place that could be compared: INTMASK 0x40000003, MODE bit 25 regCfgMode, PICFG0 field layout, QPTHR, PICINFO0..8 at 0xA20..0xA40, REGCFG_ADDR at 0x1E0) and 100 registers are stubbed as UNK_<offset> (all read-only in a vendor debug dump of 0x000-0x15F and 0xA50-0xA9F). Everything else in the 64 KB window is not described. CROSS-CHIP (2026-11-11): the control registers of this edition (INTSTAT 0x000 [end_of_pic 0, buf_full 1, end_of_stream 8], INTMASK 0x004, INTCLR 0x00C, START 0x010, MODE 0x020 [time_mode 11:10, clk_gate_mode 14:13, mem_clk_gate_en 15], OUTSTD 0x0A4 [3:0]) have the same offsets and bit positions in the VEDU_HAL_* functions of hi3518_chnl.ko (Hi3518 A/C V100), hi3518e_h264e.ko (Hi3518E V200, Hi3516C V200) and hi3516a_h264e.ko (the AVC encoder of Hi3516A/D); the configuration table address register 0x1E0 is used in the h264e modules of all of them and the PICINFO area 0xA20-0xA40 in their chnl/h264e code. So this edition is also instantiated on those chips, with the confidence limited to that evidence: the remaining registers (22 named + 100 stubs) are Hi3520D facts assumed to apply; interrupt numbers and clock/reset differ (Hi3520D: GIC 72, PERI_CRG16 [1:0] + skip bits; Hi3518 A/C V100: 24, PERI_CRG16 [1:0]; Hi3518E V200 / Hi3516C V200: 24, PERI_CRG16 [13:12]; Hi3516A/D AVC: 72, PERI_CRG16 [13:12]). The Hi3516C V100 (same base, IRQ 24 and CRG as Hi3518 V100) keeps the undescribed stub: no module of its own. CONFIRMED FACTS (vendor code): base 0x20620000, 64 KB, one VEDU, GIC interrupt 72 (VEDU_GetInfo returns IRQ 72, base 0x20620000, size 0x10000; request_threaded_irq with IRQF_DISABLED, handler ChnlVeduISR), clock and reset PERI_CRG16 (vedu_cken bit 1 on first, then vedu_srst_req bit 0 released, then the undocumented 'skip init' bits [9:4] pulse, then the register init), module parameter g_bVeduPowerSaveEn default 1 (selects the MODE clock-gate codes), watchdog 300 jiffies without an interrupt then reset (assert/release vedu_srst_req, redo VEDU_DRV_Init). HOW THE ENCODER IS PROGRAMMED: almost nothing is written register by register. For every frame software fills a 64-byte-aligned register-config table in DDR (about 0x264 bytes used, 1 KB reserved: source/reconstruction/reference picture addresses and strides, the 32-byte slice header bit string, PICFG0..3, image size, slice-header parameters, ME search window, ROI regions, OSD overlay, QP, scaling matrices, stream buffer address, stream read/write pointer word addresses and buffer length), flushes it, writes its physical address to REGCFG_ADDR (0x1E0), writes INTMASK (0x40000003), MODE (regcfg_mode = 1), PICFG0 and the two chroma QP offset fields of QPTHR, then writes START = 1. On the interrupt (IRQ 72) the handler reads INTSTAT, accepts bit 0, bit 1 or bit 8 as completion, reads the result registers (TIMER, PICINFO0..8, QPTHR.start_qp, MEANQP, PICBITS, TARGETBITS), writes INTCLR = 0xFFFFFFFF (0xFFFFFFFC for a non-completion status), and starts the next channel. SPS, PPS, SEI, user data, P-skip pictures and the slice header are produced by ARM software and written into the stream ring buffer or the table; rate control (hi3520D_rc.ko) is software that only reads the result registers. SED: the second gate/reset pair in PERI_CRG16 (sed_cken [11], sed_srst_req [10]) belongs to the VEDU in the vendor SYS module (SYS_HAL_VeduSedClkEn/ResetSel, commands 74/73) but no vendor module ever calls those two commands, so the vendor leaves SED at its reset state (clock on, reset asserted per the data sheet reset value 0xC03). The r006 VEDU (a combined encoder/decoder block: MODE.vedsel, VDREF addresses, VdecEndOfPic) has SED_STATE/SED_PFMC registers; SED is probably the syntax-element-decoder unit of the decode path, unused when vedsel = 0 (LOW). EDITION: other chips instantiate aHISI_VEDU (the old placeholder, unchanged) at their own bases and have other VEDU generations; this edition is instantiated by the Hi3520D family files (Hi3520D V100, Hi3515A V100, Hi3515C V100 share the data sheet and the MPP V2.0.5.1 modules; the vendor module names Hi3515A/C in its sibling VI checks, no VEDU-specific Hi3515 evidence exists, so the Hi3515A/C instantiation is inferred). Previously (data-sheet facts, still valid): PERI_CRG16 resets to 0x0000_0C03 (vedu_cken [1] = 1 clock on, vedu_srst_req [0] = 1 in reset, plus sed_cken [11] and sed_srst_req [10], both 1 at reset); working clock 225 MHz (EPLL VCO 1350 MHz / 6, shared with VPSS); DDR out-of-order access enabled by the DDR controller bit vedu_ctrl [3], QoS port 'VENC' (media0_port0_pri [2:0], priority 3 = highest, plus its timeout counter); vendor script writes DDRC QoS entry 0x2011017C = 0x10c02 (VEDU) and 0x20620020 = 0, 0x206200a4 = 3. Encoder limits per the data sheet: Semi-Planar YCbCr 4:2:0 input, 160x64 to 1920x2048, 2 kbps to 40 Mbps, H.264 High/Main/Baseline @4.2, 8 ROIs, 8-region OSD overlay, CBR/VBR; vendor channel checks: width 160..1920 and height 64..2048 (even), profile 0..2, stream buffer at least 3/4 of width x height bytes (32 KB in mini-buffer mode) and a multiple of 64. Previously: 'Not described: no register of this block is described; ... placeholder so that the block base address and size exist in the address map (STUB)'. The base address and the 64 KB size are kept (the trailing memory below). GIC interrupt ID 72. Listed as an open item in docs/rdl-sweep/PORT-BLOCKS.md.";

    // SECOND PASS 2026-11-11 summary is carried in the REGCFG_ADDR description and docs/rdl-campaign/vedu-vendor.md section 13. Registers marked INFERRED below were not accessed by register in any vendor code; their offsets assume the r006 register file layout (9 directly accessed Hi3520D offsets match r006 exactly).

    reg {
        name = "Interrupt status (vendor ReadInt)";
        desc = "Interrupt status word, read by the interrupt handler. VEDU_HAL_ReadInt returns the whole word; VEDU_HAL_ReadEndOfPicInt tests bit 0, VEDU_HAL_ReadBufFullInt bit 1, VEDU_HAL_ReadEndOfStreamInt bit 8; VEDU_DRV_IsIntOk reports a good interrupt when bit 0 OR bit 1 OR bit 8 is set (any other bit, for example an error bit, makes the handler take the error path and write 0xFFFFFFFC to INTCLR). H264E_DRV_ReadRegs (hi3520D_h264e.ko, 0x1c080) copies bit 0 and bit 1 into the per-frame result block, H264eIsVeduOK then calls a frame good when bit 0 is set and bit 1 is not. Whether the word is the masked status or the raw status is not visible in the vendor code (INTMASK is written 0x40000003 by the vendor and the r006 header has INTSTAT at this offset and RAWINT at 0x008). Register name and field names are the HiSTB drv_venc_reg_r006.h names (neighbor generation, naming only: the offset and the bits listed here were confirmed in the Hi3520D vendor code, the name is inferred). Source: vendor module hi3520D_chnl.ko (VEDU_HAL_ReadInt 0x5080, ReadEndOfPicInt 0x502c, ReadBufFullInt 0x4fd8, ReadEndOfStreamInt 0x4f84, VEDU_DRV_IsIntOk 0x4a94), confidence HIGH, word-checked: yes; also instruction-identical in the Xiongmai NBD7804T-F copy. Not verified on hardware.";

        field {
            name = "end_of_pic";
            desc = "End of picture: the frame was encoded (vendor ReadEndOfPicInt, HIGH). r006 name VencEndOfPic.";
            sw = r;
            hw = w;
        } end_of_pic[0:0];

        field {
            name = "buf_full";
            desc = "Stream buffer full (vendor ReadBufFullInt, HIGH). r006 name VencBufFull. The vendor treats it as an interrupt to service (good in IsIntOk) but H264eIsVeduOK rejects the frame.";
            sw = r;
            hw = w;
        } buf_full[1:1];

        field {
            name = "end_of_stream";
            desc = "Vendor name 'EndOfStream' (VEDU_HAL_ReadEndOfStreamInt, HIGH for the position, LOW for the meaning). r006 calls the same bit VdecEndOfPic (end of decoded picture; the r006 VEDU also contains a decoder path). Counted as a good interrupt by VEDU_DRV_IsIntOk.";
            sw = r;
            hw = w;
        } end_of_stream[8:8];

        field {
            name = "cfg_err";
            desc = "INFERRED, confidence MEDIUM: configuration error. Reason: the vendor enables bit 30 in INTMASK (0x40000003) and the HiSTB r006 header names bit 30 cfgErr in INTSTAT, INTMASK, RAWINT and INTCLR; VEDU_DRV_IsIntOk does not count bit 30 as a good interrupt, so a status with only bit 30 takes the error path (INTCLR = 0xFFFFFFFC). Never read as a separate bit by the vendor. Other r006 bits of this register (not used by the vendor, offsets assumed from r006, LOW): bit 3 VencPbitOverflow, bit 9 VdecStreamError, bit 16 VeduBreakPoint, bit 17 VeduStep, bit 27 VeduTimeout.";
            sw = r;
            hw = w;
        } cfg_err[30:30];

    } INTSTAT @ 0x000;

    reg {
        name = "Interrupt mask / enable";
        desc = "Interrupt mask register. VEDU_DRV_Init (called at module load and after every reset) first writes 0 (VEDU_HAL_WriteIntMask 0x4e38, every source off); H264E_DRV_WriteRegs writes the constant 0x40000003 (bits 0, 1 and 30) before every frame. Because 0 is written to disable and 0x40000003 to enable, 1 = interrupt enabled is inferred (MEDIUM; the r006 header names the register INTMASK and the same three bit positions VencEndOfPic, VencBufFull and cfgErr). VEDU_HAL_ReadIntMask exists but no caller was found. Bit 30 is in the mask but the vendor never tests it in INTSTAT (r006: cfgErr, configuration error). Register name and field names are the HiSTB drv_venc_reg_r006.h names (neighbor generation, naming only: the offset and the bits listed here were confirmed in the Hi3520D vendor code, the name is inferred). Source: vendor modules hi3520D_chnl.ko (VEDU_HAL_WriteIntMask 0x4e38, VEDU_DRV_Init 0x4990) and hi3520D_h264e.ko (H264E_DRV_WriteRegs 0x1bfec, store of 0x40000003 at +0x4), confidence HIGH for offset and values, MEDIUM for the polarity, word-checked: yes; instruction-identical in the Xiongmai NBD7804T-F copy. Not verified on hardware.";

        field {
            name = "end_of_pic_en";
            desc = "Written 1 per frame (vendor value 0x40000003).";
            sw = rw;
            hw = r;
        } end_of_pic_en[0:0];

        field {
            name = "buf_full_en";
            desc = "Written 1 per frame.";
            sw = rw;
            hw = r;
        } buf_full_en[1:1];

        field {
            name = "cfg_err_en";
            desc = "Written 1 per frame; r006 name cfgErr.";
            sw = rw;
            hw = r;
        } cfg_err_en[30:30];

    } INTMASK @ 0x004;

    reg {
        name = "UNK_0x008";
        desc = "UNK_0x008 (name is a placeholder, not a vendor name). NOT IN THE DATA SHEET. Source: vendor module hi3520D_chnl.ko (VEDU_OutputDebugInfo 0x57e4, called from the channel watchdog ChnlWatchDogTimerISR 0x308c when a frame does not complete): read as part of the debug dump of the ranges 0x000-0x15F and 0xA50-0xA9F (word loads, printed with printk, value not interpreted); never written by the vendor. Neighbors: the whole dump range. r006 has VEDU_RAWINT at this offset (neighbor generation, inferred, LOW; not adopted as a name). Unknown purpose, vendor-observed only, confidence LOW, not verified on hardware.";

        field {
            name = "unk";
            desc = "Unknown 32-bit value (vendor-observed read in the debug dump only).";
            sw = r;
            hw = w;
        } unk[31:0];

    } UNK_0x008 @ 0x008;

    reg {
        name = "Interrupt clear";
        desc = "Interrupt clear, write only in the vendor code (VEDU_HAL_ClearInt 0x4f30). Two values are written: 0xFFFFFFFF by VEDU_DRV_ClearInt (0x4b54) after a frame was processed in the interrupt handler, and 0xFFFFFFFC by VEDU_DRV_ClearErrInt (0x4b00) when the status was not a good completion (clears everything except bits 0 and 1). Write-one-to-clear is inferred from the all-ones pattern (MEDIUM). Register name and field names are the HiSTB drv_venc_reg_r006.h names (neighbor generation, naming only: the offset and the bits listed here were confirmed in the Hi3520D vendor code, the name is inferred). Source: vendor module hi3520D_chnl.ko (VEDU_HAL_ClearInt 0x4f30, VEDU_DRV_ClearInt 0x4b54, VEDU_DRV_ClearErrInt 0x4b00; call order in ChnlVeduIntHandler 0x341c), confidence HIGH for offset and values, MEDIUM for the clear semantics, word-checked: yes. Not verified on hardware.";

        field {
            name = "clear";
            desc = "Vendor writes 0xFFFFFFFF (all sources) or 0xFFFFFFFC (all but end_of_pic and buf_full).";
            sw = w;
            hw = r;
        } clear[31:0];

    } INTCLR @ 0x00C;

    reg {
        name = "Start";
        desc = "Start of one encode run. VEDU_HAL_StartVedu (0x4ed8) writes the constant 1 (a whole-word store). It is the last register write of a frame: the per-frame state is programmed first (INTMASK, MODE, PICFG0, REGCFG_ADDR, QPTHR), then the DDR register-config table is already in memory, then START. Register name and field names are the HiSTB drv_venc_reg_r006.h names (neighbor generation, naming only: the offset and the bits listed here were confirmed in the Hi3520D vendor code, the name is inferred). Source: vendor module hi3520D_chnl.ko (VEDU_HAL_StartVedu 0x4ed8, called through the vpu callback table in ChnlVeduIntHandler after the task start function), confidence HIGH, word-checked: yes. Not verified on hardware.";

        field {
            name = "start";
            desc = "Written 1 to start the run (r006 name VStart).";
            sw = w;
            hw = r;
        } start[0:0];

    } START @ 0x010;

    reg {
        name = "UNK_0x014";
        desc = "UNK_0x014 (name is a placeholder, not a vendor name). NOT IN THE DATA SHEET. Source: vendor module hi3520D_chnl.ko (VEDU_OutputDebugInfo 0x57e4, called from the channel watchdog ChnlWatchDogTimerISR 0x308c when a frame does not complete): read as part of the debug dump of the ranges 0x000-0x15F and 0xA50-0xA9F (word loads, printed with printk, value not interpreted); never written by the vendor. Neighbors: the whole dump range. r006 has no register at this offset (reserved gap in the neighbor map). Unknown purpose, vendor-observed only, confidence LOW, not verified on hardware.";

        field {
            name = "unk";
            desc = "Unknown 32-bit value (vendor-observed read in the debug dump only).";
            sw = r;
            hw = w;
        } unk[31:0];

    } UNK_0x014 @ 0x014;

    reg {
        name = "UNK_0x018";
        desc = "UNK_0x018 (name is a placeholder, not a vendor name). NOT IN THE DATA SHEET. Source: vendor module hi3520D_chnl.ko (VEDU_OutputDebugInfo 0x57e4, called from the channel watchdog ChnlWatchDogTimerISR 0x308c when a frame does not complete): read as part of the debug dump of the ranges 0x000-0x15F and 0xA50-0xA9F (word loads, printed with printk, value not interpreted); never written by the vendor. Neighbors: the whole dump range. r006 has no register at this offset (reserved gap in the neighbor map). Unknown purpose, vendor-observed only, confidence LOW, not verified on hardware.";

        field {
            name = "unk";
            desc = "Unknown 32-bit value (vendor-observed read in the debug dump only).";
            sw = r;
            hw = w;
        } unk[31:0];

    } UNK_0x018 @ 0x018;

    reg {
        name = "UNK_0x01C";
        desc = "UNK_0x01C (name is a placeholder, not a vendor name). NOT IN THE DATA SHEET. Source: vendor module hi3520D_chnl.ko (VEDU_OutputDebugInfo 0x57e4, called from the channel watchdog ChnlWatchDogTimerISR 0x308c when a frame does not complete): read as part of the debug dump of the ranges 0x000-0x15F and 0xA50-0xA9F (word loads, printed with printk, value not interpreted); never written by the vendor. Neighbors: the whole dump range. r006 has no register at this offset (reserved gap in the neighbor map). Unknown purpose, vendor-observed only, confidence LOW, not verified on hardware.";

        field {
            name = "unk";
            desc = "Unknown 32-bit value (vendor-observed read in the debug dump only).";
            sw = r;
            hw = w;
        } unk[31:0];

    } UNK_0x01C @ 0x01C;

    reg {
        name = "Mode and power control";
        desc = "Mode register, always accessed read-modify-write by the VEDU_HAL_Write* helpers (VEDU_HAL_ReadMode 0x4cf4 / WriteMode 0x4ca4). At module init (VEDU_DRV_Init 0x4990) the vendor sets time_mode = 2 (bits 11:10, VEDU_HAL_WriteTimerMode 0x4d44) and, with the module parameter g_bVeduPowerSaveEn at its default 1, clk_gate_mode = 2 (bits 14:13, WriteClkGateMode 0x4dd4) and mem_clk_gate_en = 1 (bit 15, WriteMemClkGateMode 0x4d70); with the parameter 0 both are written 0. Per frame H264E_DRV_WriteRegs (hi3520D_h264e.ko 0x1bfec) clears bit 0 (vedsel = 0), clears bits 4:3 (stdmod = 0), sets bit 2 (osd_en) when an OSD configuration with its enable word set exists and clears it otherwise, and sets bit 25 (regcfg_mode = 1, the register block comes from DDR through REGCFG_ADDR); other bits keep the value read. The board script sysctl_hi3520D.sh additionally writes the whole register to 0 at boot ('vedu lowpower', 0x20620020 = 0). Names are the r006 names (bit 0 vedsel = encoder/decoder select, 1 = decoder in the r006 header; stdmod = standard select; timeEn, clkGateEn, memClkGateEn, regCfgMode); the vendor never writes bit 1 (r006 vencEn) in the decoded paths. Source: vendor modules hi3520D_chnl.ko (VEDU_HAL_*Mode*, VEDU_DRV_Init) and hi3520D_h264e.ko (H264E_DRV_WriteRegs), confidence HIGH for positions and written values, MEDIUM for the meaning of time_mode/clk_gate_mode values, word-checked: yes. Not verified on hardware.";

        field {
            name = "vedsel";
            desc = "Written 0 per frame (r006: encoder/decoder select; 0 = encoder, MEDIUM).";
            sw = rw;
            hw = r;
        } vedsel[0:0];

        field {
            name = "osd_en";
            desc = "Per frame 1 when the OSD front-end overlay is configured and enabled, else 0 (H264E_DRV_WriteRegs: tests the OSD configuration pointer and its word at +8). r006 name osdEn.";
            sw = rw;
            hw = r;
        } osd_en[2:2];

        field {
            name = "stdmod";
            desc = "Written 0 per frame (r006 stdmod).";
            sw = rw;
            hw = r;
        } stdmod[4:3];

        field {
            name = "time_mode";
            desc = "Vendor writes 2 at init (VEDU_HAL_WriteTimerMode, 'TimerMode'); meaning of the code not known (r006 timeEn).";
            sw = rw;
            hw = r;
        } time_mode[11:10];

        field {
            name = "clk_gate_mode";
            desc = "Vendor writes 2 with power save on (default), 0 with it off (VEDU_HAL_WriteClkGateMode); meaning of the codes not known (r006 clkGateEn).";
            sw = rw;
            hw = r;
        } clk_gate_mode[14:13];

        field {
            name = "mem_clk_gate_en";
            desc = "Vendor writes 1 with power save on, 0 otherwise (VEDU_HAL_WriteMemClkGateMode; r006 memClkGateEn).";
            sw = rw;
            hw = r;
        } mem_clk_gate_en[15:15];

        field {
            name = "regcfg_mode";
            desc = "Written 1 per frame: the per-frame registers are loaded from the DDR register-config table at REGCFG_ADDR (r006 regCfgMode, MEDIUM).";
            sw = rw;
            hw = r;
        } regcfg_mode[25:25];

    } MODE @ 0x020;

    reg {
        name = "Picture configuration 0";
        desc = "First picture configuration word, written once per frame by H264E_DRV_WriteRegs from the first word of the DDR register-config table (table word +0x40, kept in memory by H264E_DRV_UpdateRegConfigParam 0x1d4d0). All fields below are the bit positions written there (decoded instruction by instruction); the vendor sets ptbits_en = 0, num_ref_index = 0 in the decoded branch. The same bit layout is the r006 PICFG0. Source: vendor module hi3520D_h264e.ko (H264E_DRV_WriteRegs 0x1bfec, H264E_DRV_UpdateRegConfigParam 0x1d4d0), confidence HIGH for the positions, MEDIUM for the field meanings (r006 names), word-checked: yes; identical in the Xiongmai NBD7804T-F copy. Not verified on hardware.";

        field {
            name = "chn_id";
            desc = "Channel id of the running channel (table byte 0x40).";
            sw = rw;
            hw = r;
        } chn_id[7:0];

        field {
            name = "ptbits_en";
            desc = "Cleared in the decoded branch.";
            sw = rw;
            hw = r;
        } ptbits_en[8:8];

        field {
            name = "cabac_init_idc";
            desc = "CABAC init idc from the channel attributes (vendor check: 0..2).";
            sw = rw;
            hw = r;
        } cabac_init_idc[10:9];

        field {
            name = "cabac_byte_stuff";
            desc = "CABAC byte stuffing enable (vendor check: 0..1).";
            sw = rw;
            hw = r;
        } cabac_byte_stuff[11:11];

        field {
            name = "const_intra";
            desc = "Constrained intra flag from the attributes.";
            sw = rw;
            hw = r;
        } const_intra[12:12];

        field {
            name = "ipicture";
            desc = "Set for an intra picture, cleared otherwise.";
            sw = rw;
            hw = r;
        } ipicture[13:13];

        field {
            name = "trans_mode";
            desc = "Transform mode (4x4 / 8x8 selection) from the attributes.";
            sw = rw;
            hw = r;
        } trans_mode[15:14];

        field {
            name = "nal_ref_idc";
            desc = "nal_ref_idc of the picture.";
            sw = rw;
            hw = r;
        } nal_ref_idc[17:16];

        field {
            name = "num_ref_index";
            desc = "Cleared in the decoded branch.";
            sw = rw;
            hw = r;
        } num_ref_index[18:18];

        field {
            name = "entropy_enc_mode";
            desc = "Entropy coder select: 1 = CABAC, 0 = CAVLC (vendor: Baseline cannot use CABAC).";
            sw = rw;
            hw = r;
        } entropy_enc_mode[19:19];

        field {
            name = "dblk_idc";
            desc = "disable_deblocking_filter_idc. BOARD 2026-11-11 (docs/rdl-campaign/vedu-vendor.md 14.1): with value 0 (alpha 0, beta 0) the hardware wrote the bits 1 1 1 (ue(0) se(0) se(0)) after slice_qp_delta, which needs PPS deblocking_filter_control_present_flag = 1; the field to syntax element mapping of alpha/beta is INFERRED.";
            sw = rw;
            hw = r;
        } dblk_idc[21:20];

        field {
            name = "dblk_alpha";
            desc = "slice_alpha_c0_offset_div2 field (vendor check range -6..6).";
            sw = rw;
            hw = r;
        } dblk_alpha[25:22];

        field {
            name = "dblk_beta";
            desc = "slice_beta_offset_div2 field (vendor check range -6..6).";
            sw = rw;
            hw = r;
        } dblk_beta[29:26];

    } PICFG0 @ 0x024;

    reg {
        name = "UNK_0x034";
        desc = "UNK_0x034 (name is a placeholder, not a vendor name). NOT IN THE DATA SHEET. Source: vendor module hi3520D_chnl.ko (VEDU_OutputDebugInfo 0x57e4, called from the channel watchdog ChnlWatchDogTimerISR 0x308c when a frame does not complete): read as part of the debug dump of the ranges 0x000-0x15F and 0xA50-0xA9F (word loads, printed with printk, value not interpreted); never written by the vendor. Neighbors: the whole dump range. r006 has VEDU_PICFG4 at this offset (neighbor generation, inferred, LOW; not adopted as a name). Unknown purpose, vendor-observed only, confidence LOW, not verified on hardware.";

        field {
            name = "unk";
            desc = "Unknown 32-bit value (vendor-observed read in the debug dump only).";
            sw = r;
            hw = w;
        } unk[31:0];

    } UNK_0x034 @ 0x034;

    reg {
        name = "UNK_0x038";
        desc = "UNK_0x038 (name is a placeholder, not a vendor name). NOT IN THE DATA SHEET. Source: vendor module hi3520D_chnl.ko (VEDU_OutputDebugInfo 0x57e4, called from the channel watchdog ChnlWatchDogTimerISR 0x308c when a frame does not complete): read as part of the debug dump of the ranges 0x000-0x15F and 0xA50-0xA9F (word loads, printed with printk, value not interpreted); never written by the vendor. Neighbors: the whole dump range. r006 has VEDU_PICFG5 at this offset (neighbor generation, inferred, LOW; not adopted as a name). Unknown purpose, vendor-observed only, confidence LOW, not verified on hardware.";

        field {
            name = "unk";
            desc = "Unknown 32-bit value (vendor-observed read in the debug dump only).";
            sw = r;
            hw = w;
        } unk[31:0];

    } UNK_0x038 @ 0x038;

    reg {
        name = "UNK_0x03C";
        desc = "UNK_0x03C (name is a placeholder, not a vendor name). NOT IN THE DATA SHEET. Source: vendor module hi3520D_chnl.ko (VEDU_OutputDebugInfo 0x57e4, called from the channel watchdog ChnlWatchDogTimerISR 0x308c when a frame does not complete): read as part of the debug dump of the ranges 0x000-0x15F and 0xA50-0xA9F (word loads, printed with printk, value not interpreted); never written by the vendor. Neighbors: the whole dump range. r006 has VEDU_CURPOC at this offset (neighbor generation, inferred, LOW; not adopted as a name). Unknown purpose, vendor-observed only, confidence LOW, not verified on hardware.";

        field {
            name = "unk";
            desc = "Unknown 32-bit value (vendor-observed read in the debug dump only).";
            sw = r;
            hw = w;
        } unk[31:0];

    } UNK_0x03C @ 0x03C;

    reg {
        name = "UNK_0x040";
        desc = "UNK_0x040 (name is a placeholder, not a vendor name). NOT IN THE DATA SHEET. Source: vendor module hi3520D_chnl.ko (VEDU_OutputDebugInfo 0x57e4, called from the channel watchdog ChnlWatchDogTimerISR 0x308c when a frame does not complete): read as part of the debug dump of the ranges 0x000-0x15F and 0xA50-0xA9F (word loads, printed with printk, value not interpreted); never written by the vendor. Neighbors: the whole dump range. r006 has VEDU_ENCUPDATE at this offset (neighbor generation, inferred, LOW; not adopted as a name). Unknown purpose, vendor-observed only, confidence LOW, not verified on hardware.";

        field {
            name = "unk";
            desc = "Unknown 32-bit value (vendor-observed read in the debug dump only).";
            sw = r;
            hw = w;
        } unk[31:0];

    } UNK_0x040 @ 0x040;

    reg {
        name = "UNK_0x044";
        desc = "UNK_0x044 (name is a placeholder, not a vendor name). NOT IN THE DATA SHEET. Source: vendor module hi3520D_chnl.ko (VEDU_OutputDebugInfo 0x57e4, called from the channel watchdog ChnlWatchDogTimerISR 0x308c when a frame does not complete): read as part of the debug dump of the ranges 0x000-0x15F and 0xA50-0xA9F (word loads, printed with printk, value not interpreted); never written by the vendor. Neighbors: the whole dump range. r006 has no register at this offset (reserved gap in the neighbor map). Unknown purpose, vendor-observed only, confidence LOW, not verified on hardware.";

        field {
            name = "unk";
            desc = "Unknown 32-bit value (vendor-observed read in the debug dump only).";
            sw = r;
            hw = w;
        } unk[31:0];

    } UNK_0x044 @ 0x044;

    reg {
        name = "UNK_0x048";
        desc = "UNK_0x048 (name is a placeholder, not a vendor name). NOT IN THE DATA SHEET. Source: vendor module hi3520D_chnl.ko (VEDU_OutputDebugInfo 0x57e4, called from the channel watchdog ChnlWatchDogTimerISR 0x308c when a frame does not complete): read as part of the debug dump of the ranges 0x000-0x15F and 0xA50-0xA9F (word loads, printed with printk, value not interpreted); never written by the vendor. Neighbors: the whole dump range. r006 has no register at this offset (reserved gap in the neighbor map). Unknown purpose, vendor-observed only, confidence LOW, not verified on hardware.";

        field {
            name = "unk";
            desc = "Unknown 32-bit value (vendor-observed read in the debug dump only).";
            sw = r;
            hw = w;
        } unk[31:0];

    } UNK_0x048 @ 0x048;

    reg {
        name = "UNK_0x04C";
        desc = "UNK_0x04C (name is a placeholder, not a vendor name). NOT IN THE DATA SHEET. Source: vendor module hi3520D_chnl.ko (VEDU_OutputDebugInfo 0x57e4, called from the channel watchdog ChnlWatchDogTimerISR 0x308c when a frame does not complete): read as part of the debug dump of the ranges 0x000-0x15F and 0xA50-0xA9F (word loads, printed with printk, value not interpreted); never written by the vendor. Neighbors: the whole dump range. r006 has no register at this offset (reserved gap in the neighbor map). Unknown purpose, vendor-observed only, confidence LOW, not verified on hardware.";

        field {
            name = "unk";
            desc = "Unknown 32-bit value (vendor-observed read in the debug dump only).";
            sw = r;
            hw = w;
        } unk[31:0];

    } UNK_0x04C @ 0x04C;

    reg {
        name = "UNK_0x054";
        desc = "UNK_0x054 (name is a placeholder, not a vendor name). NOT IN THE DATA SHEET. Source: vendor module hi3520D_chnl.ko (VEDU_OutputDebugInfo 0x57e4, called from the channel watchdog ChnlWatchDogTimerISR 0x308c when a frame does not complete): read as part of the debug dump of the ranges 0x000-0x15F and 0xA50-0xA9F (word loads, printed with printk, value not interpreted); never written by the vendor. Neighbors: the whole dump range. r006 has no register at this offset (reserved gap in the neighbor map). Unknown purpose, vendor-observed only, confidence LOW, not verified on hardware.";

        field {
            name = "unk";
            desc = "Unknown 32-bit value (vendor-observed read in the debug dump only).";
            sw = r;
            hw = w;
        } unk[31:0];

    } UNK_0x054 @ 0x054;

    reg {
        name = "UNK_0x058";
        desc = "UNK_0x058 (name is a placeholder, not a vendor name). NOT IN THE DATA SHEET. Source: vendor module hi3520D_chnl.ko (VEDU_OutputDebugInfo 0x57e4, called from the channel watchdog ChnlWatchDogTimerISR 0x308c when a frame does not complete): read as part of the debug dump of the ranges 0x000-0x15F and 0xA50-0xA9F (word loads, printed with printk, value not interpreted); never written by the vendor. Neighbors: the whole dump range. r006 has VEDU_PTBITS at this offset (neighbor generation, inferred, LOW; not adopted as a name). Unknown purpose, vendor-observed only, confidence LOW, not verified on hardware.";

        field {
            name = "unk";
            desc = "Unknown 32-bit value (vendor-observed read in the debug dump only).";
            sw = r;
            hw = w;
        } unk[31:0];

    } UNK_0x058 @ 0x058;

    reg {
        name = "UNK_0x05C";
        desc = "UNK_0x05C (name is a placeholder, not a vendor name). NOT IN THE DATA SHEET. Source: vendor module hi3520D_chnl.ko (VEDU_OutputDebugInfo 0x57e4, called from the channel watchdog ChnlWatchDogTimerISR 0x308c when a frame does not complete): read as part of the debug dump of the ranges 0x000-0x15F and 0xA50-0xA9F (word loads, printed with printk, value not interpreted); never written by the vendor. Neighbors: the whole dump range. r006 has no register at this offset (reserved gap in the neighbor map). Unknown purpose, vendor-observed only, confidence LOW, not verified on hardware.";

        field {
            name = "unk";
            desc = "Unknown 32-bit value (vendor-observed read in the debug dump only).";
            sw = r;
            hw = w;
        } unk[31:0];

    } UNK_0x05C @ 0x05C;

    reg {
        name = "UNK_0x084";
        desc = "UNK_0x084 (name is a placeholder, not a vendor name). NOT IN THE DATA SHEET. Source: vendor module hi3520D_chnl.ko (VEDU_OutputDebugInfo 0x57e4, called from the channel watchdog ChnlWatchDogTimerISR 0x308c when a frame does not complete): read as part of the debug dump of the ranges 0x000-0x15F and 0xA50-0xA9F (word loads, printed with printk, value not interpreted); never written by the vendor. Neighbors: the whole dump range. r006 has no register at this offset (reserved gap in the neighbor map). Unknown purpose, vendor-observed only, confidence LOW, not verified on hardware.";

        field {
            name = "unk";
            desc = "Unknown 32-bit value (vendor-observed read in the debug dump only).";
            sw = r;
            hw = w;
        } unk[31:0];

    } UNK_0x084 @ 0x084;

    reg {
        name = "UNK_0x088";
        desc = "UNK_0x088 (name is a placeholder, not a vendor name). NOT IN THE DATA SHEET. Source: vendor module hi3520D_chnl.ko (VEDU_OutputDebugInfo 0x57e4, called from the channel watchdog ChnlWatchDogTimerISR 0x308c when a frame does not complete): read as part of the debug dump of the ranges 0x000-0x15F and 0xA50-0xA9F (word loads, printed with printk, value not interpreted); never written by the vendor. Neighbors: the whole dump range. r006 has no register at this offset (reserved gap in the neighbor map). Unknown purpose, vendor-observed only, confidence LOW, not verified on hardware.";

        field {
            name = "unk";
            desc = "Unknown 32-bit value (vendor-observed read in the debug dump only).";
            sw = r;
            hw = w;
        } unk[31:0];

    } UNK_0x088 @ 0x088;

    reg {
        name = "UNK_0x08C";
        desc = "UNK_0x08C (name is a placeholder, not a vendor name). NOT IN THE DATA SHEET. Source: vendor module hi3520D_chnl.ko (VEDU_OutputDebugInfo 0x57e4, called from the channel watchdog ChnlWatchDogTimerISR 0x308c when a frame does not complete): read as part of the debug dump of the ranges 0x000-0x15F and 0xA50-0xA9F (word loads, printed with printk, value not interpreted); never written by the vendor. Neighbors: the whole dump range. r006 has no register at this offset (reserved gap in the neighbor map). Unknown purpose, vendor-observed only, confidence LOW, not verified on hardware.";

        field {
            name = "unk";
            desc = "Unknown 32-bit value (vendor-observed read in the debug dump only).";
            sw = r;
            hw = w;
        } unk[31:0];

    } UNK_0x08C @ 0x08C;

    reg {
        name = "UNK_0x0A0";
        desc = "UNK_0x0A0 (name is a placeholder, not a vendor name). NOT IN THE DATA SHEET. Source: vendor module hi3520D_chnl.ko (VEDU_OutputDebugInfo 0x57e4, called from the channel watchdog ChnlWatchDogTimerISR 0x308c when a frame does not complete): read as part of the debug dump of the ranges 0x000-0x15F and 0xA50-0xA9F (word loads, printed with printk, value not interpreted); never written by the vendor. Neighbors: the whole dump range. r006 has VEDU_TIMEOUT at this offset (neighbor generation, inferred, LOW; not adopted as a name). Unknown purpose, vendor-observed only, confidence LOW, not verified on hardware.";

        field {
            name = "unk";
            desc = "Unknown 32-bit value (vendor-observed read in the debug dump only).";
            sw = r;
            hw = w;
        } unk[31:0];

    } UNK_0x0A0 @ 0x0A0;

    reg {
        name = "AXI outstanding";
        desc = "Outstanding transaction count of the VEDU AXI master. VEDU_HAL_WriteOutStanding (0x4bf8) read-modify-writes bits [3:0]; VEDU_DRV_Init writes 3. The board script sysctl_hi3520D.sh writes 0x3 to 0x206200a4 ('vedu outstanding'). VEDU_HAL_ReadOutStanding exists. Register name and field names are the HiSTB drv_venc_reg_r006.h names (neighbor generation, naming only: the offset and the bits listed here were confirmed in the Hi3520D vendor code, the name is inferred). Source: vendor module hi3520D_chnl.ko (VEDU_HAL_WriteOutStanding 0x4bf8, VEDU_DRV_Init 0x4990) and Xiongmai script sysctl_hi3520D.sh, confidence HIGH, word-checked: yes. Not verified on hardware.";

        field {
            name = "outstd_num";
            desc = "Vendor value 3 (module and script).";
            sw = rw;
            hw = r;
        } outstd_num[3:0];

    } OUTSTD @ 0x0A4;

    reg {
        name = "Timer";
        desc = "Read in the per-frame result block (H264E_DRV_ReadRegs 0x1c080, result word +8, whole word). The value is stored with the other frame results; the decoded consumers (H264eUpdateStreamInfo) do not use it, so what it counts is not known (the r006 header has VEDU_TIMER at this offset and VEDU_TIMEOUT at 0x0a0). Source: vendor module hi3520D_h264e.ko (H264E_DRV_ReadRegs 0x1c080), confidence HIGH for the access, LOW for the meaning, word-checked: yes. Not verified on hardware.";

        field {
            name = "timer";
            desc = "Unknown 32-bit value, read once per frame.";
            sw = r;
            hw = w;
        } timer[31:0];

    } TIMER @ 0x0A8;

    reg {
        name = "UNK_0x0AC";
        desc = "UNK_0x0AC (name is a placeholder, not a vendor name). NOT IN THE DATA SHEET. Source: vendor module hi3520D_chnl.ko (VEDU_OutputDebugInfo 0x57e4, called from the channel watchdog ChnlWatchDogTimerISR 0x308c when a frame does not complete): read as part of the debug dump of the ranges 0x000-0x15F and 0xA50-0xA9F (word loads, printed with printk, value not interpreted); never written by the vendor. Neighbors: the whole dump range. r006 has VEDU_IDLE_TIMER at this offset (neighbor generation, inferred, LOW; not adopted as a name). Unknown purpose, vendor-observed only, confidence LOW, not verified on hardware.";

        field {
            name = "unk";
            desc = "Unknown 32-bit value (vendor-observed read in the debug dump only).";
            sw = r;
            hw = w;
        } unk[31:0];

    } UNK_0x0AC @ 0x0AC;

    reg {
        name = "UNK_0x0B0";
        desc = "UNK_0x0B0 (name is a placeholder, not a vendor name). NOT IN THE DATA SHEET. Source: vendor module hi3520D_chnl.ko (VEDU_OutputDebugInfo 0x57e4, called from the channel watchdog ChnlWatchDogTimerISR 0x308c when a frame does not complete): read as part of the debug dump of the ranges 0x000-0x15F and 0xA50-0xA9F (word loads, printed with printk, value not interpreted); never written by the vendor. Neighbors: the whole dump range. r006 has no register at this offset (reserved gap in the neighbor map). Unknown purpose, vendor-observed only, confidence LOW, not verified on hardware.";

        field {
            name = "unk";
            desc = "Unknown 32-bit value (vendor-observed read in the debug dump only).";
            sw = r;
            hw = w;
        } unk[31:0];

    } UNK_0x0B0 @ 0x0B0;

    reg {
        name = "UNK_0x0B4";
        desc = "UNK_0x0B4 (name is a placeholder, not a vendor name). NOT IN THE DATA SHEET. Source: vendor module hi3520D_chnl.ko (VEDU_OutputDebugInfo 0x57e4, called from the channel watchdog ChnlWatchDogTimerISR 0x308c when a frame does not complete): read as part of the debug dump of the ranges 0x000-0x15F and 0xA50-0xA9F (word loads, printed with printk, value not interpreted); never written by the vendor. Neighbors: the whole dump range. r006 has no register at this offset (reserved gap in the neighbor map). Unknown purpose, vendor-observed only, confidence LOW, not verified on hardware.";

        field {
            name = "unk";
            desc = "Unknown 32-bit value (vendor-observed read in the debug dump only).";
            sw = r;
            hw = w;
        } unk[31:0];

    } UNK_0x0B4 @ 0x0B4;

    reg {
        name = "UNK_0x0B8";
        desc = "UNK_0x0B8 (name is a placeholder, not a vendor name). NOT IN THE DATA SHEET. Source: vendor module hi3520D_chnl.ko (VEDU_OutputDebugInfo 0x57e4, called from the channel watchdog ChnlWatchDogTimerISR 0x308c when a frame does not complete): read as part of the debug dump of the ranges 0x000-0x15F and 0xA50-0xA9F (word loads, printed with printk, value not interpreted); never written by the vendor. Neighbors: the whole dump range. r006 has no register at this offset (reserved gap in the neighbor map). Unknown purpose, vendor-observed only, confidence LOW, not verified on hardware.";

        field {
            name = "unk";
            desc = "Unknown 32-bit value (vendor-observed read in the debug dump only).";
            sw = r;
            hw = w;
        } unk[31:0];

    } UNK_0x0B8 @ 0x0B8;

    reg {
        name = "UNK_0x0BC";
        desc = "UNK_0x0BC (name is a placeholder, not a vendor name). NOT IN THE DATA SHEET. Source: vendor module hi3520D_chnl.ko (VEDU_OutputDebugInfo 0x57e4, called from the channel watchdog ChnlWatchDogTimerISR 0x308c when a frame does not complete): read as part of the debug dump of the ranges 0x000-0x15F and 0xA50-0xA9F (word loads, printed with printk, value not interpreted); never written by the vendor. Neighbors: the whole dump range. r006 has no register at this offset (reserved gap in the neighbor map). Unknown purpose, vendor-observed only, confidence LOW, not verified on hardware.";

        field {
            name = "unk";
            desc = "Unknown 32-bit value (vendor-observed read in the debug dump only).";
            sw = r;
            hw = w;
        } unk[31:0];

    } UNK_0x0BC @ 0x0BC;

    reg {
        name = "UNK_0x0C0";
        desc = "UNK_0x0C0 (name is a placeholder, not a vendor name). NOT IN THE DATA SHEET. Source: vendor module hi3520D_chnl.ko (VEDU_OutputDebugInfo 0x57e4, called from the channel watchdog ChnlWatchDogTimerISR 0x308c when a frame does not complete): read as part of the debug dump of the ranges 0x000-0x15F and 0xA50-0xA9F (word loads, printed with printk, value not interpreted); never written by the vendor. Neighbors: the whole dump range. r006 has no register at this offset (reserved gap in the neighbor map). Unknown purpose, vendor-observed only, confidence LOW, not verified on hardware.";

        field {
            name = "unk";
            desc = "Unknown 32-bit value (vendor-observed read in the debug dump only).";
            sw = r;
            hw = w;
        } unk[31:0];

    } UNK_0x0C0 @ 0x0C0;

    reg {
        name = "UNK_0x0C4";
        desc = "UNK_0x0C4 (name is a placeholder, not a vendor name). NOT IN THE DATA SHEET. Source: vendor module hi3520D_chnl.ko (VEDU_OutputDebugInfo 0x57e4, called from the channel watchdog ChnlWatchDogTimerISR 0x308c when a frame does not complete): read as part of the debug dump of the ranges 0x000-0x15F and 0xA50-0xA9F (word loads, printed with printk, value not interpreted); never written by the vendor. Neighbors: the whole dump range. r006 has no register at this offset (reserved gap in the neighbor map). Unknown purpose, vendor-observed only, confidence LOW, not verified on hardware.";

        field {
            name = "unk";
            desc = "Unknown 32-bit value (vendor-observed read in the debug dump only).";
            sw = r;
            hw = w;
        } unk[31:0];

    } UNK_0x0C4 @ 0x0C4;

    reg {
        name = "UNK_0x0C8";
        desc = "UNK_0x0C8 (name is a placeholder, not a vendor name). NOT IN THE DATA SHEET. Source: vendor module hi3520D_chnl.ko (VEDU_OutputDebugInfo 0x57e4, called from the channel watchdog ChnlWatchDogTimerISR 0x308c when a frame does not complete): read as part of the debug dump of the ranges 0x000-0x15F and 0xA50-0xA9F (word loads, printed with printk, value not interpreted); never written by the vendor. Neighbors: the whole dump range. r006 has no register at this offset (reserved gap in the neighbor map). Unknown purpose, vendor-observed only, confidence LOW, not verified on hardware.";

        field {
            name = "unk";
            desc = "Unknown 32-bit value (vendor-observed read in the debug dump only).";
            sw = r;
            hw = w;
        } unk[31:0];

    } UNK_0x0C8 @ 0x0C8;

    reg {
        name = "UNK_0x0CC";
        desc = "UNK_0x0CC (name is a placeholder, not a vendor name). NOT IN THE DATA SHEET. Source: vendor module hi3520D_chnl.ko (VEDU_OutputDebugInfo 0x57e4, called from the channel watchdog ChnlWatchDogTimerISR 0x308c when a frame does not complete): read as part of the debug dump of the ranges 0x000-0x15F and 0xA50-0xA9F (word loads, printed with printk, value not interpreted); never written by the vendor. Neighbors: the whole dump range. r006 has no register at this offset (reserved gap in the neighbor map). Unknown purpose, vendor-observed only, confidence LOW, not verified on hardware.";

        field {
            name = "unk";
            desc = "Unknown 32-bit value (vendor-observed read in the debug dump only).";
            sw = r;
            hw = w;
        } unk[31:0];

    } UNK_0x0CC @ 0x0CC;

    reg {
        name = "UNK_0x0D0";
        desc = "UNK_0x0D0 (name is a placeholder, not a vendor name). NOT IN THE DATA SHEET. Source: vendor module hi3520D_chnl.ko (VEDU_OutputDebugInfo 0x57e4, called from the channel watchdog ChnlWatchDogTimerISR 0x308c when a frame does not complete): read as part of the debug dump of the ranges 0x000-0x15F and 0xA50-0xA9F (word loads, printed with printk, value not interpreted); never written by the vendor. Neighbors: the whole dump range. r006 has no register at this offset (reserved gap in the neighbor map). Unknown purpose, vendor-observed only, confidence LOW, not verified on hardware.";

        field {
            name = "unk";
            desc = "Unknown 32-bit value (vendor-observed read in the debug dump only).";
            sw = r;
            hw = w;
        } unk[31:0];

    } UNK_0x0D0 @ 0x0D0;

    reg {
        name = "UNK_0x0D4";
        desc = "UNK_0x0D4 (name is a placeholder, not a vendor name). NOT IN THE DATA SHEET. Source: vendor module hi3520D_chnl.ko (VEDU_OutputDebugInfo 0x57e4, called from the channel watchdog ChnlWatchDogTimerISR 0x308c when a frame does not complete): read as part of the debug dump of the ranges 0x000-0x15F and 0xA50-0xA9F (word loads, printed with printk, value not interpreted); never written by the vendor. Neighbors: the whole dump range. r006 has no register at this offset (reserved gap in the neighbor map). Unknown purpose, vendor-observed only, confidence LOW, not verified on hardware.";

        field {
            name = "unk";
            desc = "Unknown 32-bit value (vendor-observed read in the debug dump only).";
            sw = r;
            hw = w;
        } unk[31:0];

    } UNK_0x0D4 @ 0x0D4;

    reg {
        name = "UNK_0x0D8";
        desc = "UNK_0x0D8 (name is a placeholder, not a vendor name). NOT IN THE DATA SHEET. Source: vendor module hi3520D_chnl.ko (VEDU_OutputDebugInfo 0x57e4, called from the channel watchdog ChnlWatchDogTimerISR 0x308c when a frame does not complete): read as part of the debug dump of the ranges 0x000-0x15F and 0xA50-0xA9F (word loads, printed with printk, value not interpreted); never written by the vendor. Neighbors: the whole dump range. r006 has no register at this offset (reserved gap in the neighbor map). Unknown purpose, vendor-observed only, confidence LOW, not verified on hardware.";

        field {
            name = "unk";
            desc = "Unknown 32-bit value (vendor-observed read in the debug dump only).";
            sw = r;
            hw = w;
        } unk[31:0];

    } UNK_0x0D8 @ 0x0D8;

    reg {
        name = "UNK_0x0DC";
        desc = "UNK_0x0DC (name is a placeholder, not a vendor name). NOT IN THE DATA SHEET. Source: vendor module hi3520D_chnl.ko (VEDU_OutputDebugInfo 0x57e4, called from the channel watchdog ChnlWatchDogTimerISR 0x308c when a frame does not complete): read as part of the debug dump of the ranges 0x000-0x15F and 0xA50-0xA9F (word loads, printed with printk, value not interpreted); never written by the vendor. Neighbors: the whole dump range. r006 has no register at this offset (reserved gap in the neighbor map). Unknown purpose, vendor-observed only, confidence LOW, not verified on hardware.";

        field {
            name = "unk";
            desc = "Unknown 32-bit value (vendor-observed read in the debug dump only).";
            sw = r;
            hw = w;
        } unk[31:0];

    } UNK_0x0DC @ 0x0DC;

    reg {
        name = "UNK_0x0E0";
        desc = "UNK_0x0E0 (name is a placeholder, not a vendor name). NOT IN THE DATA SHEET. Source: vendor module hi3520D_chnl.ko (VEDU_OutputDebugInfo 0x57e4, called from the channel watchdog ChnlWatchDogTimerISR 0x308c when a frame does not complete): read as part of the debug dump of the ranges 0x000-0x15F and 0xA50-0xA9F (word loads, printed with printk, value not interpreted); never written by the vendor. Neighbors: the whole dump range. r006 has no register at this offset (reserved gap in the neighbor map). Unknown purpose, vendor-observed only, confidence LOW, not verified on hardware.";

        field {
            name = "unk";
            desc = "Unknown 32-bit value (vendor-observed read in the debug dump only).";
            sw = r;
            hw = w;
        } unk[31:0];

    } UNK_0x0E0 @ 0x0E0;

    reg {
        name = "UNK_0x0E4";
        desc = "UNK_0x0E4 (name is a placeholder, not a vendor name). NOT IN THE DATA SHEET. Source: vendor module hi3520D_chnl.ko (VEDU_OutputDebugInfo 0x57e4, called from the channel watchdog ChnlWatchDogTimerISR 0x308c when a frame does not complete): read as part of the debug dump of the ranges 0x000-0x15F and 0xA50-0xA9F (word loads, printed with printk, value not interpreted); never written by the vendor. Neighbors: the whole dump range. r006 has no register at this offset (reserved gap in the neighbor map). Unknown purpose, vendor-observed only, confidence LOW, not verified on hardware.";

        field {
            name = "unk";
            desc = "Unknown 32-bit value (vendor-observed read in the debug dump only).";
            sw = r;
            hw = w;
        } unk[31:0];

    } UNK_0x0E4 @ 0x0E4;

    reg {
        name = "UNK_0x0E8";
        desc = "UNK_0x0E8 (name is a placeholder, not a vendor name). NOT IN THE DATA SHEET. Source: vendor module hi3520D_chnl.ko (VEDU_OutputDebugInfo 0x57e4, called from the channel watchdog ChnlWatchDogTimerISR 0x308c when a frame does not complete): read as part of the debug dump of the ranges 0x000-0x15F and 0xA50-0xA9F (word loads, printed with printk, value not interpreted); never written by the vendor. Neighbors: the whole dump range. r006 has no register at this offset (reserved gap in the neighbor map). Unknown purpose, vendor-observed only, confidence LOW, not verified on hardware.";

        field {
            name = "unk";
            desc = "Unknown 32-bit value (vendor-observed read in the debug dump only).";
            sw = r;
            hw = w;
        } unk[31:0];

    } UNK_0x0E8 @ 0x0E8;

    reg {
        name = "UNK_0x0EC";
        desc = "UNK_0x0EC (name is a placeholder, not a vendor name). NOT IN THE DATA SHEET. Source: vendor module hi3520D_chnl.ko (VEDU_OutputDebugInfo 0x57e4, called from the channel watchdog ChnlWatchDogTimerISR 0x308c when a frame does not complete): read as part of the debug dump of the ranges 0x000-0x15F and 0xA50-0xA9F (word loads, printed with printk, value not interpreted); never written by the vendor. Neighbors: the whole dump range. r006 has no register at this offset (reserved gap in the neighbor map). Unknown purpose, vendor-observed only, confidence LOW, not verified on hardware.";

        field {
            name = "unk";
            desc = "Unknown 32-bit value (vendor-observed read in the debug dump only).";
            sw = r;
            hw = w;
        } unk[31:0];

    } UNK_0x0EC @ 0x0EC;

    reg {
        name = "UNK_0x0F0";
        desc = "UNK_0x0F0 (name is a placeholder, not a vendor name). NOT IN THE DATA SHEET. Source: vendor module hi3520D_chnl.ko (VEDU_OutputDebugInfo 0x57e4, called from the channel watchdog ChnlWatchDogTimerISR 0x308c when a frame does not complete): read as part of the debug dump of the ranges 0x000-0x15F and 0xA50-0xA9F (word loads, printed with printk, value not interpreted); never written by the vendor. Neighbors: the whole dump range. r006 has no register at this offset (reserved gap in the neighbor map). Unknown purpose, vendor-observed only, confidence LOW, not verified on hardware.";

        field {
            name = "unk";
            desc = "Unknown 32-bit value (vendor-observed read in the debug dump only).";
            sw = r;
            hw = w;
        } unk[31:0];

    } UNK_0x0F0 @ 0x0F0;

    reg {
        name = "UNK_0x0F4";
        desc = "UNK_0x0F4 (name is a placeholder, not a vendor name). NOT IN THE DATA SHEET. Source: vendor module hi3520D_chnl.ko (VEDU_OutputDebugInfo 0x57e4, called from the channel watchdog ChnlWatchDogTimerISR 0x308c when a frame does not complete): read as part of the debug dump of the ranges 0x000-0x15F and 0xA50-0xA9F (word loads, printed with printk, value not interpreted); never written by the vendor. Neighbors: the whole dump range. r006 has no register at this offset (reserved gap in the neighbor map). Unknown purpose, vendor-observed only, confidence LOW, not verified on hardware.";

        field {
            name = "unk";
            desc = "Unknown 32-bit value (vendor-observed read in the debug dump only).";
            sw = r;
            hw = w;
        } unk[31:0];

    } UNK_0x0F4 @ 0x0F4;

    reg {
        name = "UNK_0x0F8";
        desc = "UNK_0x0F8 (name is a placeholder, not a vendor name). NOT IN THE DATA SHEET. Source: vendor module hi3520D_chnl.ko (VEDU_OutputDebugInfo 0x57e4, called from the channel watchdog ChnlWatchDogTimerISR 0x308c when a frame does not complete): read as part of the debug dump of the ranges 0x000-0x15F and 0xA50-0xA9F (word loads, printed with printk, value not interpreted); never written by the vendor. Neighbors: the whole dump range. r006 has VEDU_VERSION0 at this offset (neighbor generation, inferred, LOW; not adopted as a name). Unknown purpose, vendor-observed only, confidence LOW, not verified on hardware.";

        field {
            name = "unk";
            desc = "Unknown 32-bit value (vendor-observed read in the debug dump only).";
            sw = r;
            hw = w;
        } unk[31:0];

    } UNK_0x0F8 @ 0x0F8;

    reg {
        name = "UNK_0x0FC";
        desc = "UNK_0x0FC (name is a placeholder, not a vendor name). NOT IN THE DATA SHEET. Source: vendor module hi3520D_chnl.ko (VEDU_OutputDebugInfo 0x57e4, called from the channel watchdog ChnlWatchDogTimerISR 0x308c when a frame does not complete): read as part of the debug dump of the ranges 0x000-0x15F and 0xA50-0xA9F (word loads, printed with printk, value not interpreted); never written by the vendor. Neighbors: the whole dump range. r006 has VEDU_VERSION1 at this offset (neighbor generation, inferred, LOW; not adopted as a name). Unknown purpose, vendor-observed only, confidence LOW, not verified on hardware.";

        field {
            name = "unk";
            desc = "Unknown 32-bit value (vendor-observed read in the debug dump only).";
            sw = r;
            hw = w;
        } unk[31:0];

    } UNK_0x0FC @ 0x0FC;

    reg {
        name = "UNK_0x108";
        desc = "UNK_0x108 (name is a placeholder, not a vendor name). NOT IN THE DATA SHEET. Source: vendor module hi3520D_chnl.ko (VEDU_OutputDebugInfo 0x57e4, called from the channel watchdog ChnlWatchDogTimerISR 0x308c when a frame does not complete): read as part of the debug dump of the ranges 0x000-0x15F and 0xA50-0xA9F (word loads, printed with printk, value not interpreted); never written by the vendor. Neighbors: the whole dump range. r006 has no register at this offset (reserved gap in the neighbor map). Unknown purpose, vendor-observed only, confidence LOW, not verified on hardware.";

        field {
            name = "unk";
            desc = "Unknown 32-bit value (vendor-observed read in the debug dump only).";
            sw = r;
            hw = w;
        } unk[31:0];

    } UNK_0x108 @ 0x108;

    reg {
        name = "UNK_0x10C";
        desc = "UNK_0x10C (name is a placeholder, not a vendor name). NOT IN THE DATA SHEET. Source: vendor module hi3520D_chnl.ko (VEDU_OutputDebugInfo 0x57e4, called from the channel watchdog ChnlWatchDogTimerISR 0x308c when a frame does not complete): read as part of the debug dump of the ranges 0x000-0x15F and 0xA50-0xA9F (word loads, printed with printk, value not interpreted); never written by the vendor. Neighbors: the whole dump range. r006 has no register at this offset (reserved gap in the neighbor map). Unknown purpose, vendor-observed only, confidence LOW, not verified on hardware.";

        field {
            name = "unk";
            desc = "Unknown 32-bit value (vendor-observed read in the debug dump only).";
            sw = r;
            hw = w;
        } unk[31:0];

    } UNK_0x10C @ 0x10C;

    reg {
        name = "UNK_0x118";
        desc = "UNK_0x118 (name is a placeholder, not a vendor name). NOT IN THE DATA SHEET. Source: vendor module hi3520D_chnl.ko (VEDU_OutputDebugInfo 0x57e4, called from the channel watchdog ChnlWatchDogTimerISR 0x308c when a frame does not complete): read as part of the debug dump of the ranges 0x000-0x15F and 0xA50-0xA9F (word loads, printed with printk, value not interpreted); never written by the vendor. Neighbors: the whole dump range. r006 has no register at this offset (reserved gap in the neighbor map). Unknown purpose, vendor-observed only, confidence LOW, not verified on hardware.";

        field {
            name = "unk";
            desc = "Unknown 32-bit value (vendor-observed read in the debug dump only).";
            sw = r;
            hw = w;
        } unk[31:0];

    } UNK_0x118 @ 0x118;

    reg {
        name = "UNK_0x11C";
        desc = "UNK_0x11C (name is a placeholder, not a vendor name). NOT IN THE DATA SHEET. Source: vendor module hi3520D_chnl.ko (VEDU_OutputDebugInfo 0x57e4, called from the channel watchdog ChnlWatchDogTimerISR 0x308c when a frame does not complete): read as part of the debug dump of the ranges 0x000-0x15F and 0xA50-0xA9F (word loads, printed with printk, value not interpreted); never written by the vendor. Neighbors: the whole dump range. r006 has no register at this offset (reserved gap in the neighbor map). Unknown purpose, vendor-observed only, confidence LOW, not verified on hardware.";

        field {
            name = "unk";
            desc = "Unknown 32-bit value (vendor-observed read in the debug dump only).";
            sw = r;
            hw = w;
        } unk[31:0];

    } UNK_0x11C @ 0x11C;

    reg {
        name = "UNK_0x128";
        desc = "UNK_0x128 (name is a placeholder, not a vendor name). NOT IN THE DATA SHEET. Source: vendor module hi3520D_chnl.ko (VEDU_OutputDebugInfo 0x57e4, called from the channel watchdog ChnlWatchDogTimerISR 0x308c when a frame does not complete): read as part of the debug dump of the ranges 0x000-0x15F and 0xA50-0xA9F (word loads, printed with printk, value not interpreted); never written by the vendor. Neighbors: the whole dump range. r006 has no register at this offset (reserved gap in the neighbor map). Unknown purpose, vendor-observed only, confidence LOW, not verified on hardware.";

        field {
            name = "unk";
            desc = "Unknown 32-bit value (vendor-observed read in the debug dump only).";
            sw = r;
            hw = w;
        } unk[31:0];

    } UNK_0x128 @ 0x128;

    reg {
        name = "UNK_0x12C";
        desc = "UNK_0x12C (name is a placeholder, not a vendor name). NOT IN THE DATA SHEET. Source: vendor module hi3520D_chnl.ko (VEDU_OutputDebugInfo 0x57e4, called from the channel watchdog ChnlWatchDogTimerISR 0x308c when a frame does not complete): read as part of the debug dump of the ranges 0x000-0x15F and 0xA50-0xA9F (word loads, printed with printk, value not interpreted); never written by the vendor. Neighbors: the whole dump range. r006 has no register at this offset (reserved gap in the neighbor map). Unknown purpose, vendor-observed only, confidence LOW, not verified on hardware.";

        field {
            name = "unk";
            desc = "Unknown 32-bit value (vendor-observed read in the debug dump only).";
            sw = r;
            hw = w;
        } unk[31:0];

    } UNK_0x12C @ 0x12C;

    reg {
        name = "UNK_0x138";
        desc = "UNK_0x138 (name is a placeholder, not a vendor name). NOT IN THE DATA SHEET. Source: vendor module hi3520D_chnl.ko (VEDU_OutputDebugInfo 0x57e4, called from the channel watchdog ChnlWatchDogTimerISR 0x308c when a frame does not complete): read as part of the debug dump of the ranges 0x000-0x15F and 0xA50-0xA9F (word loads, printed with printk, value not interpreted); never written by the vendor. Neighbors: the whole dump range. r006 has no register at this offset (reserved gap in the neighbor map). Unknown purpose, vendor-observed only, confidence LOW, not verified on hardware.";

        field {
            name = "unk";
            desc = "Unknown 32-bit value (vendor-observed read in the debug dump only).";
            sw = r;
            hw = w;
        } unk[31:0];

    } UNK_0x138 @ 0x138;

    reg {
        name = "UNK_0x13C";
        desc = "UNK_0x13C (name is a placeholder, not a vendor name). NOT IN THE DATA SHEET. Source: vendor module hi3520D_chnl.ko (VEDU_OutputDebugInfo 0x57e4, called from the channel watchdog ChnlWatchDogTimerISR 0x308c when a frame does not complete): read as part of the debug dump of the ranges 0x000-0x15F and 0xA50-0xA9F (word loads, printed with printk, value not interpreted); never written by the vendor. Neighbors: the whole dump range. r006 has no register at this offset (reserved gap in the neighbor map). Unknown purpose, vendor-observed only, confidence LOW, not verified on hardware.";

        field {
            name = "unk";
            desc = "Unknown 32-bit value (vendor-observed read in the debug dump only).";
            sw = r;
            hw = w;
        } unk[31:0];

    } UNK_0x13C @ 0x13C;

    reg {
        name = "UNK_0x150";
        desc = "UNK_0x150 (name is a placeholder, not a vendor name). NOT IN THE DATA SHEET. Source: vendor module hi3520D_chnl.ko (VEDU_OutputDebugInfo 0x57e4, called from the channel watchdog ChnlWatchDogTimerISR 0x308c when a frame does not complete): read as part of the debug dump of the ranges 0x000-0x15F and 0xA50-0xA9F (word loads, printed with printk, value not interpreted); never written by the vendor. Neighbors: the whole dump range. r006 has VEDU_TNBUFADDR at this offset (neighbor generation, inferred, LOW; not adopted as a name). Unknown purpose, vendor-observed only, confidence LOW, not verified on hardware.";

        field {
            name = "unk";
            desc = "Unknown 32-bit value (vendor-observed read in the debug dump only).";
            sw = r;
            hw = w;
        } unk[31:0];

    } UNK_0x150 @ 0x150;

    reg {
        name = "UNK_0x154";
        desc = "UNK_0x154 (name is a placeholder, not a vendor name). NOT IN THE DATA SHEET. Source: vendor module hi3520D_chnl.ko (VEDU_OutputDebugInfo 0x57e4, called from the channel watchdog ChnlWatchDogTimerISR 0x308c when a frame does not complete): read as part of the debug dump of the ranges 0x000-0x15F and 0xA50-0xA9F (word loads, printed with printk, value not interpreted); never written by the vendor. Neighbors: the whole dump range. r006 has VEDU_IPIXBUFADDR at this offset (neighbor generation, inferred, LOW; not adopted as a name). Unknown purpose, vendor-observed only, confidence LOW, not verified on hardware.";

        field {
            name = "unk";
            desc = "Unknown 32-bit value (vendor-observed read in the debug dump only).";
            sw = r;
            hw = w;
        } unk[31:0];

    } UNK_0x154 @ 0x154;

    reg {
        name = "UNK_0x158";
        desc = "UNK_0x158 (name is a placeholder, not a vendor name). NOT IN THE DATA SHEET. Source: vendor module hi3520D_chnl.ko (VEDU_OutputDebugInfo 0x57e4, called from the channel watchdog ChnlWatchDogTimerISR 0x308c when a frame does not complete): read as part of the debug dump of the ranges 0x000-0x15F and 0xA50-0xA9F (word loads, printed with printk, value not interpreted); never written by the vendor. Neighbors: the whole dump range. r006 has VEDU_DOWNMSG_ADDR at this offset (neighbor generation, inferred, LOW; not adopted as a name). Unknown purpose, vendor-observed only, confidence LOW, not verified on hardware.";

        field {
            name = "unk";
            desc = "Unknown 32-bit value (vendor-observed read in the debug dump only).";
            sw = r;
            hw = w;
        } unk[31:0];

    } UNK_0x158 @ 0x158;

    reg {
        name = "UNK_0x15C";
        desc = "UNK_0x15C (name is a placeholder, not a vendor name). NOT IN THE DATA SHEET. Source: vendor module hi3520D_chnl.ko (VEDU_OutputDebugInfo 0x57e4, called from the channel watchdog ChnlWatchDogTimerISR 0x308c when a frame does not complete): read as part of the debug dump of the ranges 0x000-0x15F and 0xA50-0xA9F (word loads, printed with printk, value not interpreted); never written by the vendor. Neighbors: the whole dump range. r006 has no register at this offset (reserved gap in the neighbor map). Unknown purpose, vendor-observed only, confidence LOW, not verified on hardware.";

        field {
            name = "unk";
            desc = "Unknown 32-bit value (vendor-observed read in the debug dump only).";
            sw = r;
            hw = w;
        } unk[31:0];

    } UNK_0x15C @ 0x15C;

    reg {
        name = "Register-config table address";
        desc = "Physical address of the per-channel register-config table in DDR, written once per frame by H264E_DRV_WriteRegs (the value is ctx+0x67c of the channel context). The table is 64-byte aligned (the vendor aligns the address up to 64 and reserves 1 KB: H264E_CreateChn) and holds the picture-level registers (source/reconstruction/reference addresses and strides, slice header bits, picture configuration, ME/ROI/OSD/QP/scaling-matrix words, stream buffer address and ring-pointer addresses); software fills it (H264E_DRV_InitRegConfigParam 0x1db40 at channel creation, H264E_DRV_UpdateRegConfigParam 0x1d4d0 per frame, H264E_DRV_UpdateOsdConfigParam 0x1dae0 on OSD change) and flushes the data cache of the touched ranges (hil_mmb_flush_dcache_byaddr) before START. MODE.regcfg_mode = 1 selects this mode. The table layout is documented in docs/rdl-campaign/vedu-vendor.md, section 6. Register name and field names are the HiSTB drv_venc_reg_r006.h names (neighbor generation, naming only: the offset and the bits listed here were confirmed in the Hi3520D vendor code, the name is inferred). Source: vendor module hi3520D_h264e.ko (H264E_DRV_WriteRegs 0x1bfec, store at +0x1e0), confidence HIGH for offset and role, MEDIUM for the table semantics, word-checked: yes. Not verified on hardware.";

        field {
            name = "addr";
            desc = "Physical address of the register-config table (64-byte aligned). SECOND PASS 2026-11-11 (docs/rdl-campaign/vedu-vendor.md section 13): the table is a PACKED image of registers of the r006 register file; the vendor-written words reproduce the r006 bit layouts of about 80 registers (the registers added to this edition at 0x028-0x14C and 0x200-0x3BC are named from that match, each marked INFERRED). Table map (table offset -> r006 register, MEDIUM unless noted; all offsets hex): 00 SRCYADDR, 04 SRCCADDR, 08 RCNYADDR, 0C RCNCADDR, 10 REFYADDR, 14 REFCADDR, 18 SSTRIDE, 1C RSTRIDE, 20-3C SLCHDRSTRM0-7, 40 PICFG0, 44 PICFG1, 48 PICFG2, 4C PICFG3, 50 and 54 written 0 (PICFG4/5? LOW), 58 VEDIMGSIZE, 5C SLCHDRPARA, 60-6C PTS0-3, 70 ROICFG, 74 ROIQP0, 78 ROIQP1, 7C not written, 80 MECFG0, 84-90 not written, 94 METHR0, 98 METHR1, 9C MERDOCFG, A0 MDCFG, A4 MDCFG0, A8-BC MDCFG1-6, C0-DC ROISIZE0-7, E0-FC ROIPOS0-7, 100 OSDQP_CFG, 104 OSD_QP0, 108 OSD_QP1, 10C VPP_OSD_CFG, 110-124 OSD alpha words, 128/12C OSD QP words (LOW), 130-13C four constants (RC1/QPDELTATHR position guess, LOW), 140-15C VPP_OSD_POS0-7, 160-17C VPP_OSD_SIZE0-7, 180-1BC OSD address/stride (LOW), 1C0-23C SCALE (32 words, High profile only), 240 STRMADDR, 244 SRPTRADDR, 248 SWPTRADDR, 24C STRMBUFLEN, 250 MECFG1, 254-260 MERECTCFG0-3, 264 not written, 268-2B4 MODLAMBDA0-19 (HIGH for position and the 12-bit layout; the 40 default values are a vendor constant: 1,1,1,2,2,3,3,4,5,7,9,11,14,17,22,27,34,43,54,69,86,109,137,173,218,274,345,435,548,691,870,1097,1382,1741,2193,2763,3482,4095,4095,4095; the index of the first value is probably QP 12 (LOW, 40 values = QP 12..51), the vendor packs value[2k] in bits [11:0] and value[2k+1] in bits [23:12] of word k). The table order is NOT the register order (STRM* and MECFG1/MERECTCFG sit at the end), so the hardware must use a fixed, hardware-defined gather order; which words it loads is unknown. Picture type codes in the vendor context: 4 = I picture (no reference address, inter enables 0, PICFG0.ipicture = 1), 5 = P picture (reference address from the reference queue; INFERRED from the branches in UpdateRegConfigParam, MEDIUM). MODE writes per frame: bit 0 = 0, bit 2 = OSD present, bits [4:3] = 0, bit 25 = 1; MODE.vencEn (bit 1 in r006) is never set by the vendor code (the board script writes MODE = 0): INFERRED that it is not needed for the table mode (LOW).";
            sw = w;
            hw = r;
        } addr[31:0];

    } REGCFG_ADDR @ 0x1E0;

    reg {
        name = "QP threshold / chroma QP offsets";
        desc = "Read-modify-write per frame by H264E_DRV_WriteRegs: bits [26:22] and [31:27] both get the value (attribute word & 0x1f). Read back in the per-frame result block: bits [21:16] (H264E_DRV_ReadRegs, result word +0x30). In r006 the register is QPTHR (minQp [5:0], maxQp [13:8], startQp [21:16], chromaQpOff [26:22], secondChromaQpOff [31:27]); the vendor code confirms exactly the two upper fields as written and [21:16] as read, nothing else. The rate-control module writes min/max/start QP through the DDR table, not through this register (RC_ConfigHw only builds a parameter block; LOW). Register name and field names are the HiSTB drv_venc_reg_r006.h names (neighbor generation, naming only: the offset and the bits listed here were confirmed in the Hi3520D vendor code, the name is inferred). Source: vendor module hi3520D_h264e.ko (H264E_DRV_WriteRegs 0x1bfec, H264E_DRV_ReadRegs 0x1c080), confidence HIGH for the bit positions, MEDIUM for the meaning, word-checked: yes. Not verified on hardware.";

        field {
            name = "start_qp";
            desc = "Read per frame into the result block (r006 startQp). BOARD 2026-11-11: reads 0x1C (28) after the first encode runs (QPTHR 0x001C3300) and the hardware wrote slice_qp_delta = se(START_QP - 26) = +2 into the slice header (PROVEN, 40 runs), so this field is the slice QP the hardware encodes and signals; it is not loaded from the table (word 0x130 is not this register). A driver that wants another QP must write this field before START (untested).";
            sw = r;
            hw = w;
        } start_qp[21:16];

        field {
            name = "chroma_qp_off";
            desc = "Written per frame (attribute & 0x1f).";
            sw = rw;
            hw = r;
        } chroma_qp_off[26:22];

        field {
            name = "second_chroma_qp_off";
            desc = "Written per frame with the same value as chroma_qp_off.";
            sw = rw;
            hw = r;
        } second_chroma_qp_off[31:27];

    } QPTHR @ 0x350;

    reg {
        name = "Target bits";
        desc = "Read in the per-frame result block (H264E_DRV_ReadRegs, result word +0x3c, whole word); the result block goes to the rate-control module through the module callback table. r006 name VEDU_TARGETBITS at this offset. Meaning (the rate controller's target bit budget as seen by the hardware) is inferred from the r006 name only. Source: vendor module hi3520D_h264e.ko (H264E_DRV_ReadRegs 0x1c080), confidence HIGH for the access, LOW for the meaning, word-checked: yes. Not verified on hardware.";

        field {
            name = "targetbits";
            desc = "Read once per frame.";
            sw = r;
            hw = w;
        } targetbits[31:0];

    } TARGETBITS @ 0x364;

    reg {
        name = "Picture bits";
        desc = "Read in the per-frame result block (H264E_DRV_ReadRegs, result word +0x38, whole word) and handed to rate control. r006 name VEDU_PICBITS (bits of the encoded picture) at this offset; the meaning is inferred from that name (the stream length itself is computed by software from the stream ring pointers, not from this register). Source: vendor module hi3520D_h264e.ko (H264E_DRV_ReadRegs 0x1c080), confidence HIGH for the access, LOW for the meaning, word-checked: yes. Not verified on hardware.";

        field {
            name = "picbits";
            desc = "Read once per frame.";
            sw = r;
            hw = w;
        } picbits[31:0];

    } PICBITS @ 0x374;

    reg {
        name = "Mean QP";
        desc = "Read in the per-frame result block with a 6-bit mask (H264E_DRV_ReadRegs, result word +0x34, value & 0x3f). r006 name VEDU_MEANQP (meanQp [5:0]). Source: vendor module hi3520D_h264e.ko (H264E_DRV_ReadRegs 0x1c080), confidence HIGH for position, MEDIUM for the meaning, word-checked: yes. Not verified on hardware.";

        field {
            name = "mean_qp";
            desc = "Mean QP of the picture (r006 meanQp).";
            sw = r;
            hw = w;
        } mean_qp[5:0];

    } MEANQP @ 0x388;

    reg {
        name = "Macroblock statistics 0";
        desc = "Read in the per-frame result block with a 19-bit mask (H264E_DRV_ReadRegs 0x1c080, result word +0x10, value & 0x7ffff); the block is copied into the stream statistics (H264eUpdateStreamInfo 0x1a6c) returned to the user. r006 names this register PICINFO0 = pskipMbNum: the number of macroblocks of that type in the picture; the order of the nine result words in the vendor block matches r006 PICINFO0..8. Register name and field names are the HiSTB drv_venc_reg_r006.h names (neighbor generation, naming only: the offset and the bits listed here were confirmed in the Hi3520D vendor code, the name is inferred). Source: vendor module hi3520D_h264e.ko (H264E_DRV_ReadRegs 0x1c080), confidence HIGH for offset and width, MEDIUM for the meaning, word-checked: yes. Not verified on hardware.";

        field {
            name = "mb_num";
            desc = "Count of macroblocks (r006 pskipMbNum).";
            sw = r;
            hw = w;
        } mb_num[18:0];

    } PICINFO0 @ 0xA20;

    reg {
        name = "Macroblock statistics 1";
        desc = "Read in the per-frame result block with a 19-bit mask (H264E_DRV_ReadRegs 0x1c080, result word +0x0c, value & 0x7ffff); the block is copied into the stream statistics (H264eUpdateStreamInfo 0x1a6c) returned to the user. r006 names this register PICINFO1 = IPCMMbNum: the number of macroblocks of that type in the picture; the order of the nine result words in the vendor block matches r006 PICINFO0..8. Register name and field names are the HiSTB drv_venc_reg_r006.h names (neighbor generation, naming only: the offset and the bits listed here were confirmed in the Hi3520D vendor code, the name is inferred). Source: vendor module hi3520D_h264e.ko (H264E_DRV_ReadRegs 0x1c080), confidence HIGH for offset and width, MEDIUM for the meaning, word-checked: yes. Not verified on hardware.";

        field {
            name = "mb_num";
            desc = "Count of macroblocks (r006 IPCMMbNum).";
            sw = r;
            hw = w;
        } mb_num[18:0];

    } PICINFO1 @ 0xA24;

    reg {
        name = "Macroblock statistics 2";
        desc = "Read in the per-frame result block with a 19-bit mask (H264E_DRV_ReadRegs 0x1c080, result word +0x14, value & 0x7ffff); the block is copied into the stream statistics (H264eUpdateStreamInfo 0x1a6c) returned to the user. r006 names this register PICINFO2 = inter16x16MbNum: the number of macroblocks of that type in the picture; the order of the nine result words in the vendor block matches r006 PICINFO0..8. Register name and field names are the HiSTB drv_venc_reg_r006.h names (neighbor generation, naming only: the offset and the bits listed here were confirmed in the Hi3520D vendor code, the name is inferred). Source: vendor module hi3520D_h264e.ko (H264E_DRV_ReadRegs 0x1c080), confidence HIGH for offset and width, MEDIUM for the meaning, word-checked: yes. Not verified on hardware.";

        field {
            name = "mb_num";
            desc = "Count of macroblocks (r006 inter16x16MbNum).";
            sw = r;
            hw = w;
        } mb_num[18:0];

    } PICINFO2 @ 0xA28;

    reg {
        name = "Macroblock statistics 3";
        desc = "Read in the per-frame result block with a 19-bit mask (H264E_DRV_ReadRegs 0x1c080, result word +0x18, value & 0x7ffff); the block is copied into the stream statistics (H264eUpdateStreamInfo 0x1a6c) returned to the user. r006 names this register PICINFO3 = inter16x8MbNum: the number of macroblocks of that type in the picture; the order of the nine result words in the vendor block matches r006 PICINFO0..8. Register name and field names are the HiSTB drv_venc_reg_r006.h names (neighbor generation, naming only: the offset and the bits listed here were confirmed in the Hi3520D vendor code, the name is inferred). Source: vendor module hi3520D_h264e.ko (H264E_DRV_ReadRegs 0x1c080), confidence HIGH for offset and width, MEDIUM for the meaning, word-checked: yes. Not verified on hardware.";

        field {
            name = "mb_num";
            desc = "Count of macroblocks (r006 inter16x8MbNum).";
            sw = r;
            hw = w;
        } mb_num[18:0];

    } PICINFO3 @ 0xA2C;

    reg {
        name = "Macroblock statistics 4";
        desc = "Read in the per-frame result block with a 19-bit mask (H264E_DRV_ReadRegs 0x1c080, result word +0x1c, value & 0x7ffff); the block is copied into the stream statistics (H264eUpdateStreamInfo 0x1a6c) returned to the user. r006 names this register PICINFO4 = inter8x16MbNum: the number of macroblocks of that type in the picture; the order of the nine result words in the vendor block matches r006 PICINFO0..8. Register name and field names are the HiSTB drv_venc_reg_r006.h names (neighbor generation, naming only: the offset and the bits listed here were confirmed in the Hi3520D vendor code, the name is inferred). Source: vendor module hi3520D_h264e.ko (H264E_DRV_ReadRegs 0x1c080), confidence HIGH for offset and width, MEDIUM for the meaning, word-checked: yes. Not verified on hardware.";

        field {
            name = "mb_num";
            desc = "Count of macroblocks (r006 inter8x16MbNum).";
            sw = r;
            hw = w;
        } mb_num[18:0];

    } PICINFO4 @ 0xA30;

    reg {
        name = "Macroblock statistics 5";
        desc = "Read in the per-frame result block with a 19-bit mask (H264E_DRV_ReadRegs 0x1c080, result word +0x20, value & 0x7ffff); the block is copied into the stream statistics (H264eUpdateStreamInfo 0x1a6c) returned to the user. r006 names this register PICINFO5 = inter8x8MbNum: the number of macroblocks of that type in the picture; the order of the nine result words in the vendor block matches r006 PICINFO0..8. Register name and field names are the HiSTB drv_venc_reg_r006.h names (neighbor generation, naming only: the offset and the bits listed here were confirmed in the Hi3520D vendor code, the name is inferred). Source: vendor module hi3520D_h264e.ko (H264E_DRV_ReadRegs 0x1c080), confidence HIGH for offset and width, MEDIUM for the meaning, word-checked: yes. Not verified on hardware.";

        field {
            name = "mb_num";
            desc = "Count of macroblocks (r006 inter8x8MbNum).";
            sw = r;
            hw = w;
        } mb_num[18:0];

    } PICINFO5 @ 0xA34;

    reg {
        name = "Macroblock statistics 6";
        desc = "Read in the per-frame result block with a 19-bit mask (H264E_DRV_ReadRegs 0x1c080, result word +0x24, value & 0x7ffff); the block is copied into the stream statistics (H264eUpdateStreamInfo 0x1a6c) returned to the user. r006 names this register PICINFO6 = Intra16MbNum: the number of macroblocks of that type in the picture; the order of the nine result words in the vendor block matches r006 PICINFO0..8. Register name and field names are the HiSTB drv_venc_reg_r006.h names (neighbor generation, naming only: the offset and the bits listed here were confirmed in the Hi3520D vendor code, the name is inferred). Source: vendor module hi3520D_h264e.ko (H264E_DRV_ReadRegs 0x1c080), confidence HIGH for offset and width, MEDIUM for the meaning, word-checked: yes. Not verified on hardware.";

        field {
            name = "mb_num";
            desc = "Count of macroblocks (r006 Intra16MbNum).";
            sw = r;
            hw = w;
        } mb_num[18:0];

    } PICINFO6 @ 0xA38;

    reg {
        name = "Macroblock statistics 7";
        desc = "Read in the per-frame result block with a 19-bit mask (H264E_DRV_ReadRegs 0x1c080, result word +0x2c, value & 0x7ffff); the block is copied into the stream statistics (H264eUpdateStreamInfo 0x1a6c) returned to the user. r006 names this register PICINFO7 = Intra8MbNum: the number of macroblocks of that type in the picture; the order of the nine result words in the vendor block matches r006 PICINFO0..8. Register name and field names are the HiSTB drv_venc_reg_r006.h names (neighbor generation, naming only: the offset and the bits listed here were confirmed in the Hi3520D vendor code, the name is inferred). Source: vendor module hi3520D_h264e.ko (H264E_DRV_ReadRegs 0x1c080), confidence HIGH for offset and width, MEDIUM for the meaning, word-checked: yes. Not verified on hardware.";

        field {
            name = "mb_num";
            desc = "Count of macroblocks (r006 Intra8MbNum).";
            sw = r;
            hw = w;
        } mb_num[18:0];

    } PICINFO7 @ 0xA3C;

    reg {
        name = "Macroblock statistics 8";
        desc = "Read in the per-frame result block with a 19-bit mask (H264E_DRV_ReadRegs 0x1c080, result word +0x28, value & 0x7ffff); the block is copied into the stream statistics (H264eUpdateStreamInfo 0x1a6c) returned to the user. r006 names this register PICINFO8 = Intra4MbNum: the number of macroblocks of that type in the picture; the order of the nine result words in the vendor block matches r006 PICINFO0..8. Register name and field names are the HiSTB drv_venc_reg_r006.h names (neighbor generation, naming only: the offset and the bits listed here were confirmed in the Hi3520D vendor code, the name is inferred). Source: vendor module hi3520D_h264e.ko (H264E_DRV_ReadRegs 0x1c080), confidence HIGH for offset and width, MEDIUM for the meaning, word-checked: yes. Not verified on hardware.";

        field {
            name = "mb_num";
            desc = "Count of macroblocks (r006 Intra4MbNum).";
            sw = r;
            hw = w;
        } mb_num[18:0];

    } PICINFO8 @ 0xA40;

    reg {
        name = "UNK_0xA50";
        desc = "UNK_0xA50 (name is a placeholder, not a vendor name). NOT IN THE DATA SHEET. Source: vendor module hi3520D_chnl.ko (VEDU_OutputDebugInfo 0x57e4, called from the channel watchdog ChnlWatchDogTimerISR 0x308c when a frame does not complete): read as part of the debug dump of the ranges 0x000-0x15F and 0xA50-0xA9F (word loads, printed with printk, value not interpreted); never written by the vendor. Neighbors: the whole dump range. r006 has VEDU_VCTRL_STATE[0] at this offset (neighbor generation, inferred, LOW; not adopted as a name). Unknown purpose, vendor-observed only, confidence LOW, not verified on hardware.";

        field {
            name = "unk";
            desc = "Unknown 32-bit value (vendor-observed read in the debug dump only).";
            sw = r;
            hw = w;
        } unk[31:0];

    } UNK_0xA50 @ 0xA50;

    reg {
        name = "UNK_0xA54";
        desc = "UNK_0xA54 (name is a placeholder, not a vendor name). NOT IN THE DATA SHEET. Source: vendor module hi3520D_chnl.ko (VEDU_OutputDebugInfo 0x57e4, called from the channel watchdog ChnlWatchDogTimerISR 0x308c when a frame does not complete): read as part of the debug dump of the ranges 0x000-0x15F and 0xA50-0xA9F (word loads, printed with printk, value not interpreted); never written by the vendor. Neighbors: the whole dump range. r006 has VEDU_VCTRL_STATE[1] at this offset (neighbor generation, inferred, LOW; not adopted as a name). Unknown purpose, vendor-observed only, confidence LOW, not verified on hardware.";

        field {
            name = "unk";
            desc = "Unknown 32-bit value (vendor-observed read in the debug dump only).";
            sw = r;
            hw = w;
        } unk[31:0];

    } UNK_0xA54 @ 0xA54;

    reg {
        name = "UNK_0xA58";
        desc = "UNK_0xA58 (name is a placeholder, not a vendor name). NOT IN THE DATA SHEET. Source: vendor module hi3520D_chnl.ko (VEDU_OutputDebugInfo 0x57e4, called from the channel watchdog ChnlWatchDogTimerISR 0x308c when a frame does not complete): read as part of the debug dump of the ranges 0x000-0x15F and 0xA50-0xA9F (word loads, printed with printk, value not interpreted); never written by the vendor. Neighbors: the whole dump range. r006 has VEDU_VCTRL_STATE[2] at this offset (neighbor generation, inferred, LOW; not adopted as a name). Unknown purpose, vendor-observed only, confidence LOW, not verified on hardware.";

        field {
            name = "unk";
            desc = "Unknown 32-bit value (vendor-observed read in the debug dump only).";
            sw = r;
            hw = w;
        } unk[31:0];

    } UNK_0xA58 @ 0xA58;

    reg {
        name = "UNK_0xA5C";
        desc = "UNK_0xA5C (name is a placeholder, not a vendor name). NOT IN THE DATA SHEET. Source: vendor module hi3520D_chnl.ko (VEDU_OutputDebugInfo 0x57e4, called from the channel watchdog ChnlWatchDogTimerISR 0x308c when a frame does not complete): read as part of the debug dump of the ranges 0x000-0x15F and 0xA50-0xA9F (word loads, printed with printk, value not interpreted); never written by the vendor. Neighbors: the whole dump range. r006 has VEDU_VCTRL_STATE[3] at this offset (neighbor generation, inferred, LOW; not adopted as a name). Unknown purpose, vendor-observed only, confidence LOW, not verified on hardware.";

        field {
            name = "unk";
            desc = "Unknown 32-bit value (vendor-observed read in the debug dump only).";
            sw = r;
            hw = w;
        } unk[31:0];

    } UNK_0xA5C @ 0xA5C;

    reg {
        name = "UNK_0xA60";
        desc = "UNK_0xA60 (name is a placeholder, not a vendor name). NOT IN THE DATA SHEET. Source: vendor module hi3520D_chnl.ko (VEDU_OutputDebugInfo 0x57e4, called from the channel watchdog ChnlWatchDogTimerISR 0x308c when a frame does not complete): read as part of the debug dump of the ranges 0x000-0x15F and 0xA50-0xA9F (word loads, printed with printk, value not interpreted); never written by the vendor. Neighbors: the whole dump range. r006 has VEDU_VCTRL_STATE[4] at this offset (neighbor generation, inferred, LOW; not adopted as a name). Unknown purpose, vendor-observed only, confidence LOW, not verified on hardware.";

        field {
            name = "unk";
            desc = "Unknown 32-bit value (vendor-observed read in the debug dump only).";
            sw = r;
            hw = w;
        } unk[31:0];

    } UNK_0xA60 @ 0xA60;

    reg {
        name = "UNK_0xA64";
        desc = "UNK_0xA64 (name is a placeholder, not a vendor name). NOT IN THE DATA SHEET. Source: vendor module hi3520D_chnl.ko (VEDU_OutputDebugInfo 0x57e4, called from the channel watchdog ChnlWatchDogTimerISR 0x308c when a frame does not complete): read as part of the debug dump of the ranges 0x000-0x15F and 0xA50-0xA9F (word loads, printed with printk, value not interpreted); never written by the vendor. Neighbors: the whole dump range. r006 has VEDU_VCTRL_STATE[5] at this offset (neighbor generation, inferred, LOW; not adopted as a name). Unknown purpose, vendor-observed only, confidence LOW, not verified on hardware.";

        field {
            name = "unk";
            desc = "Unknown 32-bit value (vendor-observed read in the debug dump only).";
            sw = r;
            hw = w;
        } unk[31:0];

    } UNK_0xA64 @ 0xA64;

    reg {
        name = "UNK_0xA68";
        desc = "UNK_0xA68 (name is a placeholder, not a vendor name). NOT IN THE DATA SHEET. Source: vendor module hi3520D_chnl.ko (VEDU_OutputDebugInfo 0x57e4, called from the channel watchdog ChnlWatchDogTimerISR 0x308c when a frame does not complete): read as part of the debug dump of the ranges 0x000-0x15F and 0xA50-0xA9F (word loads, printed with printk, value not interpreted); never written by the vendor. Neighbors: the whole dump range. r006 has VEDU_VCTRL_STATE[6] at this offset (neighbor generation, inferred, LOW; not adopted as a name). Unknown purpose, vendor-observed only, confidence LOW, not verified on hardware.";

        field {
            name = "unk";
            desc = "Unknown 32-bit value (vendor-observed read in the debug dump only).";
            sw = r;
            hw = w;
        } unk[31:0];

    } UNK_0xA68 @ 0xA68;

    reg {
        name = "UNK_0xA6C";
        desc = "UNK_0xA6C (name is a placeholder, not a vendor name). NOT IN THE DATA SHEET. Source: vendor module hi3520D_chnl.ko (VEDU_OutputDebugInfo 0x57e4, called from the channel watchdog ChnlWatchDogTimerISR 0x308c when a frame does not complete): read as part of the debug dump of the ranges 0x000-0x15F and 0xA50-0xA9F (word loads, printed with printk, value not interpreted); never written by the vendor. Neighbors: the whole dump range. r006 has VEDU_VCTRL_STATE[7] at this offset (neighbor generation, inferred, LOW; not adopted as a name). Unknown purpose, vendor-observed only, confidence LOW, not verified on hardware.";

        field {
            name = "unk";
            desc = "Unknown 32-bit value (vendor-observed read in the debug dump only).";
            sw = r;
            hw = w;
        } unk[31:0];

    } UNK_0xA6C @ 0xA6C;

    reg {
        name = "UNK_0xA70";
        desc = "UNK_0xA70 (name is a placeholder, not a vendor name). NOT IN THE DATA SHEET. Source: vendor module hi3520D_chnl.ko (VEDU_OutputDebugInfo 0x57e4, called from the channel watchdog ChnlWatchDogTimerISR 0x308c when a frame does not complete): read as part of the debug dump of the ranges 0x000-0x15F and 0xA50-0xA9F (word loads, printed with printk, value not interpreted); never written by the vendor. Neighbors: the whole dump range. r006 has VEDU_VCTRL_STATE[8] at this offset (neighbor generation, inferred, LOW; not adopted as a name). Unknown purpose, vendor-observed only, confidence LOW, not verified on hardware.";

        field {
            name = "unk";
            desc = "Unknown 32-bit value (vendor-observed read in the debug dump only).";
            sw = r;
            hw = w;
        } unk[31:0];

    } UNK_0xA70 @ 0xA70;

    reg {
        name = "UNK_0xA74";
        desc = "UNK_0xA74 (name is a placeholder, not a vendor name). NOT IN THE DATA SHEET. Source: vendor module hi3520D_chnl.ko (VEDU_OutputDebugInfo 0x57e4, called from the channel watchdog ChnlWatchDogTimerISR 0x308c when a frame does not complete): read as part of the debug dump of the ranges 0x000-0x15F and 0xA50-0xA9F (word loads, printed with printk, value not interpreted); never written by the vendor. Neighbors: the whole dump range. r006 has VEDU_VCTRL_STATE[9] at this offset (neighbor generation, inferred, LOW; not adopted as a name). Unknown purpose, vendor-observed only, confidence LOW, not verified on hardware.";

        field {
            name = "unk";
            desc = "Unknown 32-bit value (vendor-observed read in the debug dump only).";
            sw = r;
            hw = w;
        } unk[31:0];

    } UNK_0xA74 @ 0xA74;

    reg {
        name = "UNK_0xA78";
        desc = "UNK_0xA78 (name is a placeholder, not a vendor name). NOT IN THE DATA SHEET. Source: vendor module hi3520D_chnl.ko (VEDU_OutputDebugInfo 0x57e4, called from the channel watchdog ChnlWatchDogTimerISR 0x308c when a frame does not complete): read as part of the debug dump of the ranges 0x000-0x15F and 0xA50-0xA9F (word loads, printed with printk, value not interpreted); never written by the vendor. Neighbors: the whole dump range. r006 has VEDU_CREFLD_STATE[0] at this offset (neighbor generation, inferred, LOW; not adopted as a name). Unknown purpose, vendor-observed only, confidence LOW, not verified on hardware.";

        field {
            name = "unk";
            desc = "Unknown 32-bit value (vendor-observed read in the debug dump only).";
            sw = r;
            hw = w;
        } unk[31:0];

    } UNK_0xA78 @ 0xA78;

    reg {
        name = "UNK_0xA7C";
        desc = "UNK_0xA7C (name is a placeholder, not a vendor name). NOT IN THE DATA SHEET. Source: vendor module hi3520D_chnl.ko (VEDU_OutputDebugInfo 0x57e4, called from the channel watchdog ChnlWatchDogTimerISR 0x308c when a frame does not complete): read as part of the debug dump of the ranges 0x000-0x15F and 0xA50-0xA9F (word loads, printed with printk, value not interpreted); never written by the vendor. Neighbors: the whole dump range. r006 has VEDU_CREFLD_STATE[1] at this offset (neighbor generation, inferred, LOW; not adopted as a name). Unknown purpose, vendor-observed only, confidence LOW, not verified on hardware.";

        field {
            name = "unk";
            desc = "Unknown 32-bit value (vendor-observed read in the debug dump only).";
            sw = r;
            hw = w;
        } unk[31:0];

    } UNK_0xA7C @ 0xA7C;

    reg {
        name = "UNK_0xA80";
        desc = "UNK_0xA80 (name is a placeholder, not a vendor name). NOT IN THE DATA SHEET. Source: vendor module hi3520D_chnl.ko (VEDU_OutputDebugInfo 0x57e4, called from the channel watchdog ChnlWatchDogTimerISR 0x308c when a frame does not complete): read as part of the debug dump of the ranges 0x000-0x15F and 0xA50-0xA9F (word loads, printed with printk, value not interpreted); never written by the vendor. Neighbors: the whole dump range. r006 has VEDU_CREFLD_STATE[2] at this offset (neighbor generation, inferred, LOW; not adopted as a name). Unknown purpose, vendor-observed only, confidence LOW, not verified on hardware.";

        field {
            name = "unk";
            desc = "Unknown 32-bit value (vendor-observed read in the debug dump only).";
            sw = r;
            hw = w;
        } unk[31:0];

    } UNK_0xA80 @ 0xA80;

    reg {
        name = "UNK_0xA84";
        desc = "UNK_0xA84 (name is a placeholder, not a vendor name). NOT IN THE DATA SHEET. Source: vendor module hi3520D_chnl.ko (VEDU_OutputDebugInfo 0x57e4, called from the channel watchdog ChnlWatchDogTimerISR 0x308c when a frame does not complete): read as part of the debug dump of the ranges 0x000-0x15F and 0xA50-0xA9F (word loads, printed with printk, value not interpreted); never written by the vendor. Neighbors: the whole dump range. r006 has no register at this offset (reserved gap in the neighbor map). Unknown purpose, vendor-observed only, confidence LOW, not verified on hardware.";

        field {
            name = "unk";
            desc = "Unknown 32-bit value (vendor-observed read in the debug dump only).";
            sw = r;
            hw = w;
        } unk[31:0];

    } UNK_0xA84 @ 0xA84;

    reg {
        name = "UNK_0xA88";
        desc = "UNK_0xA88 (name is a placeholder, not a vendor name). NOT IN THE DATA SHEET. Source: vendor module hi3520D_chnl.ko (VEDU_OutputDebugInfo 0x57e4, called from the channel watchdog ChnlWatchDogTimerISR 0x308c when a frame does not complete): read as part of the debug dump of the ranges 0x000-0x15F and 0xA50-0xA9F (word loads, printed with printk, value not interpreted); never written by the vendor. Neighbors: the whole dump range. r006 has no register at this offset (reserved gap in the neighbor map). Unknown purpose, vendor-observed only, confidence LOW, not verified on hardware.";

        field {
            name = "unk";
            desc = "Unknown 32-bit value (vendor-observed read in the debug dump only).";
            sw = r;
            hw = w;
        } unk[31:0];

    } UNK_0xA88 @ 0xA88;

    reg {
        name = "UNK_0xA8C";
        desc = "UNK_0xA8C (name is a placeholder, not a vendor name). NOT IN THE DATA SHEET. Source: vendor module hi3520D_chnl.ko (VEDU_OutputDebugInfo 0x57e4, called from the channel watchdog ChnlWatchDogTimerISR 0x308c when a frame does not complete): read as part of the debug dump of the ranges 0x000-0x15F and 0xA50-0xA9F (word loads, printed with printk, value not interpreted); never written by the vendor. Neighbors: the whole dump range. r006 has no register at this offset (reserved gap in the neighbor map). Unknown purpose, vendor-observed only, confidence LOW, not verified on hardware.";

        field {
            name = "unk";
            desc = "Unknown 32-bit value (vendor-observed read in the debug dump only).";
            sw = r;
            hw = w;
        } unk[31:0];

    } UNK_0xA8C @ 0xA8C;

    reg {
        name = "UNK_0xA90";
        desc = "UNK_0xA90 (name is a placeholder, not a vendor name). NOT IN THE DATA SHEET. Source: vendor module hi3520D_chnl.ko (VEDU_OutputDebugInfo 0x57e4, called from the channel watchdog ChnlWatchDogTimerISR 0x308c when a frame does not complete): read as part of the debug dump of the ranges 0x000-0x15F and 0xA50-0xA9F (word loads, printed with printk, value not interpreted); never written by the vendor. Neighbors: the whole dump range. r006 has VEDU_LDSTR_STATE[0] at this offset (neighbor generation, inferred, LOW; not adopted as a name). Unknown purpose, vendor-observed only, confidence LOW, not verified on hardware.";

        field {
            name = "unk";
            desc = "Unknown 32-bit value (vendor-observed read in the debug dump only).";
            sw = r;
            hw = w;
        } unk[31:0];

    } UNK_0xA90 @ 0xA90;

    reg {
        name = "UNK_0xA94";
        desc = "UNK_0xA94 (name is a placeholder, not a vendor name). NOT IN THE DATA SHEET. Source: vendor module hi3520D_chnl.ko (VEDU_OutputDebugInfo 0x57e4, called from the channel watchdog ChnlWatchDogTimerISR 0x308c when a frame does not complete): read as part of the debug dump of the ranges 0x000-0x15F and 0xA50-0xA9F (word loads, printed with printk, value not interpreted); never written by the vendor. Neighbors: the whole dump range. r006 has VEDU_LDSTR_STATE[1] at this offset (neighbor generation, inferred, LOW; not adopted as a name). Unknown purpose, vendor-observed only, confidence LOW, not verified on hardware.";

        field {
            name = "unk";
            desc = "Unknown 32-bit value (vendor-observed read in the debug dump only).";
            sw = r;
            hw = w;
        } unk[31:0];

    } UNK_0xA94 @ 0xA94;

    reg {
        name = "UNK_0xA98";
        desc = "UNK_0xA98 (name is a placeholder, not a vendor name). NOT IN THE DATA SHEET. Source: vendor module hi3520D_chnl.ko (VEDU_OutputDebugInfo 0x57e4, called from the channel watchdog ChnlWatchDogTimerISR 0x308c when a frame does not complete): read as part of the debug dump of the ranges 0x000-0x15F and 0xA50-0xA9F (word loads, printed with printk, value not interpreted); never written by the vendor. Neighbors: the whole dump range. r006 has VEDU_LDSTR_STATE[2] at this offset (neighbor generation, inferred, LOW; not adopted as a name). Unknown purpose, vendor-observed only, confidence LOW, not verified on hardware.";

        field {
            name = "unk";
            desc = "Unknown 32-bit value (vendor-observed read in the debug dump only).";
            sw = r;
            hw = w;
        } unk[31:0];

    } UNK_0xA98 @ 0xA98;

    reg {
        name = "UNK_0xA9C";
        desc = "UNK_0xA9C (name is a placeholder, not a vendor name). NOT IN THE DATA SHEET. Source: vendor module hi3520D_chnl.ko (VEDU_OutputDebugInfo 0x57e4, called from the channel watchdog ChnlWatchDogTimerISR 0x308c when a frame does not complete): read as part of the debug dump of the ranges 0x000-0x15F and 0xA50-0xA9F (word loads, printed with printk, value not interpreted); never written by the vendor. Neighbors: the whole dump range. r006 has VEDU_LDSTR_STATE[3] at this offset (neighbor generation, inferred, LOW; not adopted as a name). Unknown purpose, vendor-observed only, confidence LOW, not verified on hardware.";

        field {
            name = "unk";
            desc = "Unknown 32-bit value (vendor-observed read in the debug dump only).";
            sw = r;
            hw = w;
        } unk[31:0];

    } UNK_0xA9C @ 0xA9C;


    reg {
        name = "PICFG1 (INFERRED, MEDIUM)";
        desc = "PICFG1 INFERRED, confidence MEDIUM. Reason: the vendor builds a DDR register-config table (table offset 0x44) whose word has the bit layout of the r006 register VEDU_PICFG1, and 9 offsets that the Hi3520D code accesses directly (MODE 0x020, PICFG0 0x024, REGCFG_ADDR 0x1E0, QPTHR 0x350, TARGETBITS 0x364, PICBITS 0x374, MEANQP 0x388, PICINFO0 0xA20, OUTSTD 0x0A4) all sit at the r006 offsets, so the register file is assumed to follow r006 (a neighbor generation). The offset in the window is therefore an assumption, NOT seen in any vendor register access. Register name and field names are the HiSTB drv_venc_reg_r006.h names (naming only). Not accessed by register in any vendor code (it is programmed through the DDR table, loaded by the hardware from REGCFG_ADDR; whether the hardware loads this exact register from the table is the working assumption).  Source: docs/rdl-campaign/vedu-vendor.md section 13, H264E_DRV_UpdateRegConfigParam 0x1d4d0 / H264E_DRV_InitRegConfigParam 0x1db40 / H264eDrvUpdateMeCfg 0x1c680. Not verified on hardware.";

        field {
            name = "slice_size";
            desc = "r006 field SliceSize (INFERRED, naming and position from the table word, MEDIUM)";
            sw = rw;
            hw = r;
        } slice_size[15:0];

        field {
            name = "slice_spilt_mod";
            desc = "r006 field SliceSpiltMod (INFERRED, naming and position from the table word, MEDIUM)";
            sw = rw;
            hw = r;
        } slice_spilt_mod[16:16];

        field {
            name = "slice_split";
            desc = "r006 field SliceSplit (INFERRED, naming and position from the table word, MEDIUM)";
            sw = rw;
            hw = r;
        } slice_split[17:17];

    } PICFG1 @ 0x028;

    reg {
        name = "PICFG2 (INFERRED, MEDIUM)";
        desc = "PICFG2 INFERRED, confidence MEDIUM. Reason: the vendor builds a DDR register-config table (table offset 0x48) whose word has the bit layout of the r006 register VEDU_PICFG2, and 9 offsets that the Hi3520D code accesses directly (MODE 0x020, PICFG0 0x024, REGCFG_ADDR 0x1E0, QPTHR 0x350, TARGETBITS 0x364, PICBITS 0x374, MEANQP 0x388, PICINFO0 0xA20, OUTSTD 0x0A4) all sit at the r006 offsets, so the register file is assumed to follow r006 (a neighbor generation). The offset in the window is therefore an assumption, NOT seen in any vendor register access. Register name and field names are the HiSTB drv_venc_reg_r006.h names (naming only). Not accessed by register in any vendor code (it is programmed through the DDR table, loaded by the hardware from REGCFG_ADDR; whether the hardware loads this exact register from the table is the working assumption). Bit 4 (intra4ReducedModeEn) is always set by the vendor. Source: docs/rdl-campaign/vedu-vendor.md section 13, H264E_DRV_UpdateRegConfigParam 0x1d4d0 / H264E_DRV_InitRegConfigParam 0x1db40 / H264eDrvUpdateMeCfg 0x1c680. Not verified on hardware.";

        field {
            name = "ipcmpred_en";
            desc = "r006 field IPCMPredEn (INFERRED, naming and position from the table word, MEDIUM)";
            sw = rw;
            hw = r;
        } ipcmpred_en[0:0];

        field {
            name = "intra4x4_pred_en";
            desc = "r006 field Intra4x4PredEn (INFERRED, naming and position from the table word, MEDIUM)";
            sw = rw;
            hw = r;
        } intra4x4_pred_en[1:1];

        field {
            name = "intra8x8_pred_en";
            desc = "r006 field Intra8x8PredEn (INFERRED, naming and position from the table word, MEDIUM)";
            sw = rw;
            hw = r;
        } intra8x8_pred_en[2:2];

        field {
            name = "intra16x16_pred_en";
            desc = "r006 field Intra16x16PredEn (INFERRED, naming and position from the table word, MEDIUM)";
            sw = rw;
            hw = r;
        } intra16x16_pred_en[3:3];

        field {
            name = "intra4_reduced_mode_en";
            desc = "r006 field intra4ReducedModeEn (INFERRED, naming and position from the table word, MEDIUM)";
            sw = rw;
            hw = r;
        } intra4_reduced_mode_en[4:4];

        field {
            name = "intra_low_pow_en";
            desc = "r006 field IntraLowPowEn (INFERRED, naming and position from the table word, MEDIUM)";
            sw = rw;
            hw = r;
        } intra_low_pow_en[31:31];

    } PICFG2 @ 0x02C;

    reg {
        name = "PICFG3 (INFERRED, MEDIUM)";
        desc = "PICFG3 INFERRED, confidence MEDIUM. Reason: the vendor builds a DDR register-config table (table offset 0x4C) whose word has the bit layout of the r006 register VEDU_PICFG3, and 9 offsets that the Hi3520D code accesses directly (MODE 0x020, PICFG0 0x024, REGCFG_ADDR 0x1E0, QPTHR 0x350, TARGETBITS 0x364, PICBITS 0x374, MEANQP 0x388, PICINFO0 0xA20, OUTSTD 0x0A4) all sit at the r006 offsets, so the register file is assumed to follow r006 (a neighbor generation). The offset in the window is therefore an assumption, NOT seen in any vendor register access. Register name and field names are the HiSTB drv_venc_reg_r006.h names (naming only). Not accessed by register in any vendor code (it is programmed through the DDR table, loaded by the hardware from REGCFG_ADDR; whether the hardware loads this exact register from the table is the working assumption). The vendor leaves the inter prediction enables 0 for an I picture (picture type 4) and takes them from the channel configuration otherwise. Source: docs/rdl-campaign/vedu-vendor.md section 13, H264E_DRV_UpdateRegConfigParam 0x1d4d0 / H264E_DRV_InitRegConfigParam 0x1db40 / H264eDrvUpdateMeCfg 0x1c680. Not verified on hardware.";

        field {
            name = "inter8x8_pred_en";
            desc = "r006 field Inter8x8PredEn (INFERRED, naming and position from the table word, MEDIUM)";
            sw = rw;
            hw = r;
        } inter8x8_pred_en[0:0];

        field {
            name = "inter8x16_pred_en";
            desc = "r006 field Inter8x16PredEn (INFERRED, naming and position from the table word, MEDIUM)";
            sw = rw;
            hw = r;
        } inter8x16_pred_en[1:1];

        field {
            name = "inter16x8_pred_en";
            desc = "r006 field Inter16x8PredEn (INFERRED, naming and position from the table word, MEDIUM)";
            sw = rw;
            hw = r;
        } inter16x8_pred_en[2:2];

        field {
            name = "inter16x16_pred_en";
            desc = "r006 field Inter16x16PredEn (INFERRED, naming and position from the table word, MEDIUM)";
            sw = rw;
            hw = r;
        } inter16x16_pred_en[3:3];

        field {
            name = "psk_en";
            desc = "r006 field pskEn (INFERRED, naming and position from the table word, MEDIUM)";
            sw = rw;
            hw = r;
        } psk_en[4:4];

        field {
            name = "frac_low_pow_en";
            desc = "r006 field fracLowPowEn (INFERRED, naming and position from the table word, MEDIUM)";
            sw = rw;
            hw = r;
        } frac_low_pow_en[29:29];

        field {
            name = "intp_low_pow_en";
            desc = "r006 field intpLowPowEn (INFERRED, naming and position from the table word, MEDIUM)";
            sw = rw;
            hw = r;
        } intp_low_pow_en[30:30];

        field {
            name = "extedge_en";
            desc = "r006 field extedgeEn (INFERRED, naming and position from the table word, MEDIUM)";
            sw = rw;
            hw = r;
        } extedge_en[31:31];

    } PICFG3 @ 0x030;

    reg {
        name = "VEDIMGSIZE (INFERRED, HIGH)";
        desc = "VEDIMGSIZE INFERRED, confidence HIGH. Reason: the vendor builds a DDR register-config table (table offset 0x58) whose word has the bit layout of the r006 register VEDU_VEDIMGSIZE, and 9 offsets that the Hi3520D code accesses directly (MODE 0x020, PICFG0 0x024, REGCFG_ADDR 0x1E0, QPTHR 0x350, TARGETBITS 0x364, PICBITS 0x374, MEANQP 0x388, PICINFO0 0xA20, OUTSTD 0x0A4) all sit at the r006 offsets, so the register file is assumed to follow r006 (a neighbor generation). The offset in the window is therefore an assumption, NOT seen in any vendor register access. Register name and field names are the HiSTB drv_venc_reg_r006.h names (naming only). Not accessed by register in any vendor code (it is programmed through the DDR table, loaded by the hardware from REGCFG_ADDR; whether the hardware loads this exact register from the table is the working assumption). The vendor stores (width-1) and (height-1) in pixels. Source: docs/rdl-campaign/vedu-vendor.md section 13, H264E_DRV_UpdateRegConfigParam 0x1d4d0 / H264E_DRV_InitRegConfigParam 0x1db40 / H264eDrvUpdateMeCfg 0x1c680. Not verified on hardware.";

        field {
            name = "img_width_in_pix_minus1";
            desc = "r006 field ImgWidthInPixMinus1 (INFERRED, naming and position from the table word, HIGH)";
            sw = rw;
            hw = r;
        } img_width_in_pix_minus1[12:0];

        field {
            name = "img_height_in_pix_minus1";
            desc = "r006 field ImgHeightInPixMinus1 (INFERRED, naming and position from the table word, HIGH)";
            sw = rw;
            hw = r;
        } img_height_in_pix_minus1[28:16];

    } VEDIMGSIZE @ 0x050;

    reg {
        name = "SLCHDRSTRM0 (INFERRED, MEDIUM)";
        desc = "SLCHDRSTRM0 INFERRED, confidence MEDIUM. Reason: the vendor builds a DDR register-config table (table offset 0x20) whose word has the bit layout of the r006 register VEDU_SLCHDRSTRM0, and 9 offsets that the Hi3520D code accesses directly (MODE 0x020, PICFG0 0x024, REGCFG_ADDR 0x1E0, QPTHR 0x350, TARGETBITS 0x364, PICBITS 0x374, MEANQP 0x388, PICINFO0 0xA20, OUTSTD 0x0A4) all sit at the r006 offsets, so the register file is assumed to follow r006 (a neighbor generation). The offset in the window is therefore an assumption, NOT seen in any vendor register access. Register name and field names are the HiSTB drv_venc_reg_r006.h names (naming only). Not accessed by register in any vendor code (it is programmed through the DDR table, loaded by the hardware from REGCFG_ADDR; whether the hardware loads this exact register from the table is the working assumption). SLICE HEADER SOFTWARE BITS, PARA part word 0 (the low ParaWd+1 bits for a part of up to 32 bits). FORMAT RECOVERED 2026-11-11 (docs/rdl-campaign/vedu-vendor.md section 14; board sweep of 40 runs + vendor H264eWrHWSlcHdr 0x50e0): the hardware writes first_mb_in_slice (one bit '1') itself, then ParaWd+1 bits from words 0..3, then (only if ReorderWd != 0) ReorderWd+1 bits from words 4..5, then MarkingWd+1 bits from words 6..7, then slice_qp_delta = se(START_QP - 26) and, with PPS deblocking_filter_control_present_flag = 1, the deblocking syntax (idc, alpha, beta from PICFG0). Each part is packed RIGHT-aligned: MSB-first 32-bit chunks, every full chunk as is, the last chunk shifted to the low bits, so a part of n <= 32 bits is the number in the low n bits of its first word (PROVEN for the PARA part, all 40 runs reproduced bit-exactly; parts above 32 bits and the REORDER part are INFERRED from the vendor packing code only). Example IDR I slice (POC type 2, log2_max_frame_num 4): word 0x20 = 0x000000E1 (ue(2) ue(0) u(4)=0 ue(0)), MARKING word 0x38 = 0 (two zero flag bits), SLCHDRPARA = 0x00400802. Source: docs/rdl-campaign/vedu-vendor.md section 13, H264E_DRV_UpdateRegConfigParam 0x1d4d0 / H264E_DRV_InitRegConfigParam 0x1db40 / H264eDrvUpdateMeCfg 0x1c680. Not verified on hardware.";

        field {
            name = "value";
            desc = "Whole 32-bit word (INFERRED, MEDIUM).";
            sw = rw;
            hw = r;
        } value[31:0];

    } SLCHDRSTRM0 @ 0x060;

    reg {
        name = "SLCHDRSTRM1 (INFERRED, MEDIUM)";
        desc = "SLCHDRSTRM1 INFERRED, confidence MEDIUM. Reason: the vendor builds a DDR register-config table (table offset 0x24) whose word has the bit layout of the r006 register VEDU_SLCHDRSTRM1, and 9 offsets that the Hi3520D code accesses directly (MODE 0x020, PICFG0 0x024, REGCFG_ADDR 0x1E0, QPTHR 0x350, TARGETBITS 0x364, PICBITS 0x374, MEANQP 0x388, PICINFO0 0xA20, OUTSTD 0x0A4) all sit at the r006 offsets, so the register file is assumed to follow r006 (a neighbor generation). The offset in the window is therefore an assumption, NOT seen in any vendor register access. Register name and field names are the HiSTB drv_venc_reg_r006.h names (naming only). Not accessed by register in any vendor code (it is programmed through the DDR table, loaded by the hardware from REGCFG_ADDR; whether the hardware loads this exact register from the table is the working assumption). SLICE HEADER SOFTWARE BITS, PARA part word 1. FORMAT RECOVERED 2026-11-11 (docs/rdl-campaign/vedu-vendor.md section 14; board sweep of 40 runs + vendor H264eWrHWSlcHdr 0x50e0): the hardware writes first_mb_in_slice (one bit '1') itself, then ParaWd+1 bits from words 0..3, then (only if ReorderWd != 0) ReorderWd+1 bits from words 4..5, then MarkingWd+1 bits from words 6..7, then slice_qp_delta = se(START_QP - 26) and, with PPS deblocking_filter_control_present_flag = 1, the deblocking syntax (idc, alpha, beta from PICFG0). Each part is packed RIGHT-aligned: MSB-first 32-bit chunks, every full chunk as is, the last chunk shifted to the low bits, so a part of n <= 32 bits is the number in the low n bits of its first word (PROVEN for the PARA part, all 40 runs reproduced bit-exactly; parts above 32 bits and the REORDER part are INFERRED from the vendor packing code only). Example IDR I slice (POC type 2, log2_max_frame_num 4): word 0x20 = 0x000000E1 (ue(2) ue(0) u(4)=0 ue(0)), MARKING word 0x38 = 0 (two zero flag bits), SLCHDRPARA = 0x00400802. Source: docs/rdl-campaign/vedu-vendor.md section 13, H264E_DRV_UpdateRegConfigParam 0x1d4d0 / H264E_DRV_InitRegConfigParam 0x1db40 / H264eDrvUpdateMeCfg 0x1c680. Not verified on hardware.";

        field {
            name = "value";
            desc = "Whole 32-bit word (INFERRED, MEDIUM).";
            sw = rw;
            hw = r;
        } value[31:0];

    } SLCHDRSTRM1 @ 0x064;

    reg {
        name = "SLCHDRSTRM2 (INFERRED, MEDIUM)";
        desc = "SLCHDRSTRM2 INFERRED, confidence MEDIUM. Reason: the vendor builds a DDR register-config table (table offset 0x28) whose word has the bit layout of the r006 register VEDU_SLCHDRSTRM2, and 9 offsets that the Hi3520D code accesses directly (MODE 0x020, PICFG0 0x024, REGCFG_ADDR 0x1E0, QPTHR 0x350, TARGETBITS 0x364, PICBITS 0x374, MEANQP 0x388, PICINFO0 0xA20, OUTSTD 0x0A4) all sit at the r006 offsets, so the register file is assumed to follow r006 (a neighbor generation). The offset in the window is therefore an assumption, NOT seen in any vendor register access. Register name and field names are the HiSTB drv_venc_reg_r006.h names (naming only). Not accessed by register in any vendor code (it is programmed through the DDR table, loaded by the hardware from REGCFG_ADDR; whether the hardware loads this exact register from the table is the working assumption). SLICE HEADER SOFTWARE BITS, PARA part word 2. FORMAT RECOVERED 2026-11-11 (docs/rdl-campaign/vedu-vendor.md section 14; board sweep of 40 runs + vendor H264eWrHWSlcHdr 0x50e0): the hardware writes first_mb_in_slice (one bit '1') itself, then ParaWd+1 bits from words 0..3, then (only if ReorderWd != 0) ReorderWd+1 bits from words 4..5, then MarkingWd+1 bits from words 6..7, then slice_qp_delta = se(START_QP - 26) and, with PPS deblocking_filter_control_present_flag = 1, the deblocking syntax (idc, alpha, beta from PICFG0). Each part is packed RIGHT-aligned: MSB-first 32-bit chunks, every full chunk as is, the last chunk shifted to the low bits, so a part of n <= 32 bits is the number in the low n bits of its first word (PROVEN for the PARA part, all 40 runs reproduced bit-exactly; parts above 32 bits and the REORDER part are INFERRED from the vendor packing code only). Example IDR I slice (POC type 2, log2_max_frame_num 4): word 0x20 = 0x000000E1 (ue(2) ue(0) u(4)=0 ue(0)), MARKING word 0x38 = 0 (two zero flag bits), SLCHDRPARA = 0x00400802. Source: docs/rdl-campaign/vedu-vendor.md section 13, H264E_DRV_UpdateRegConfigParam 0x1d4d0 / H264E_DRV_InitRegConfigParam 0x1db40 / H264eDrvUpdateMeCfg 0x1c680. Not verified on hardware.";

        field {
            name = "value";
            desc = "Whole 32-bit word (INFERRED, MEDIUM).";
            sw = rw;
            hw = r;
        } value[31:0];

    } SLCHDRSTRM2 @ 0x068;

    reg {
        name = "SLCHDRSTRM3 (INFERRED, MEDIUM)";
        desc = "SLCHDRSTRM3 INFERRED, confidence MEDIUM. Reason: the vendor builds a DDR register-config table (table offset 0x2C) whose word has the bit layout of the r006 register VEDU_SLCHDRSTRM3, and 9 offsets that the Hi3520D code accesses directly (MODE 0x020, PICFG0 0x024, REGCFG_ADDR 0x1E0, QPTHR 0x350, TARGETBITS 0x364, PICBITS 0x374, MEANQP 0x388, PICINFO0 0xA20, OUTSTD 0x0A4) all sit at the r006 offsets, so the register file is assumed to follow r006 (a neighbor generation). The offset in the window is therefore an assumption, NOT seen in any vendor register access. Register name and field names are the HiSTB drv_venc_reg_r006.h names (naming only). Not accessed by register in any vendor code (it is programmed through the DDR table, loaded by the hardware from REGCFG_ADDR; whether the hardware loads this exact register from the table is the working assumption). SLICE HEADER SOFTWARE BITS, PARA part word 3. FORMAT RECOVERED 2026-11-11 (docs/rdl-campaign/vedu-vendor.md section 14; board sweep of 40 runs + vendor H264eWrHWSlcHdr 0x50e0): the hardware writes first_mb_in_slice (one bit '1') itself, then ParaWd+1 bits from words 0..3, then (only if ReorderWd != 0) ReorderWd+1 bits from words 4..5, then MarkingWd+1 bits from words 6..7, then slice_qp_delta = se(START_QP - 26) and, with PPS deblocking_filter_control_present_flag = 1, the deblocking syntax (idc, alpha, beta from PICFG0). Each part is packed RIGHT-aligned: MSB-first 32-bit chunks, every full chunk as is, the last chunk shifted to the low bits, so a part of n <= 32 bits is the number in the low n bits of its first word (PROVEN for the PARA part, all 40 runs reproduced bit-exactly; parts above 32 bits and the REORDER part are INFERRED from the vendor packing code only). Example IDR I slice (POC type 2, log2_max_frame_num 4): word 0x20 = 0x000000E1 (ue(2) ue(0) u(4)=0 ue(0)), MARKING word 0x38 = 0 (two zero flag bits), SLCHDRPARA = 0x00400802. Source: docs/rdl-campaign/vedu-vendor.md section 13, H264E_DRV_UpdateRegConfigParam 0x1d4d0 / H264E_DRV_InitRegConfigParam 0x1db40 / H264eDrvUpdateMeCfg 0x1c680. Not verified on hardware.";

        field {
            name = "value";
            desc = "Whole 32-bit word (INFERRED, MEDIUM).";
            sw = rw;
            hw = r;
        } value[31:0];

    } SLCHDRSTRM3 @ 0x06C;

    reg {
        name = "SLCHDRSTRM4 (INFERRED, MEDIUM)";
        desc = "SLCHDRSTRM4 INFERRED, confidence MEDIUM. Reason: the vendor builds a DDR register-config table (table offset 0x30) whose word has the bit layout of the r006 register VEDU_SLCHDRSTRM4, and 9 offsets that the Hi3520D code accesses directly (MODE 0x020, PICFG0 0x024, REGCFG_ADDR 0x1E0, QPTHR 0x350, TARGETBITS 0x364, PICBITS 0x374, MEANQP 0x388, PICINFO0 0xA20, OUTSTD 0x0A4) all sit at the r006 offsets, so the register file is assumed to follow r006 (a neighbor generation). The offset in the window is therefore an assumption, NOT seen in any vendor register access. Register name and field names are the HiSTB drv_venc_reg_r006.h names (naming only). Not accessed by register in any vendor code (it is programmed through the DDR table, loaded by the hardware from REGCFG_ADDR; whether the hardware loads this exact register from the table is the working assumption). SLICE HEADER SOFTWARE BITS, REORDER part word 0 (only read when ReorderWd != 0, INFERRED). FORMAT RECOVERED 2026-11-11 (docs/rdl-campaign/vedu-vendor.md section 14; board sweep of 40 runs + vendor H264eWrHWSlcHdr 0x50e0): the hardware writes first_mb_in_slice (one bit '1') itself, then ParaWd+1 bits from words 0..3, then (only if ReorderWd != 0) ReorderWd+1 bits from words 4..5, then MarkingWd+1 bits from words 6..7, then slice_qp_delta = se(START_QP - 26) and, with PPS deblocking_filter_control_present_flag = 1, the deblocking syntax (idc, alpha, beta from PICFG0). Each part is packed RIGHT-aligned: MSB-first 32-bit chunks, every full chunk as is, the last chunk shifted to the low bits, so a part of n <= 32 bits is the number in the low n bits of its first word (PROVEN for the PARA part, all 40 runs reproduced bit-exactly; parts above 32 bits and the REORDER part are INFERRED from the vendor packing code only). Example IDR I slice (POC type 2, log2_max_frame_num 4): word 0x20 = 0x000000E1 (ue(2) ue(0) u(4)=0 ue(0)), MARKING word 0x38 = 0 (two zero flag bits), SLCHDRPARA = 0x00400802. Source: docs/rdl-campaign/vedu-vendor.md section 13, H264E_DRV_UpdateRegConfigParam 0x1d4d0 / H264E_DRV_InitRegConfigParam 0x1db40 / H264eDrvUpdateMeCfg 0x1c680. Not verified on hardware.";

        field {
            name = "value";
            desc = "Whole 32-bit word (INFERRED, MEDIUM).";
            sw = rw;
            hw = r;
        } value[31:0];

    } SLCHDRSTRM4 @ 0x070;

    reg {
        name = "SLCHDRSTRM5 (INFERRED, MEDIUM)";
        desc = "SLCHDRSTRM5 INFERRED, confidence MEDIUM. Reason: the vendor builds a DDR register-config table (table offset 0x34) whose word has the bit layout of the r006 register VEDU_SLCHDRSTRM5, and 9 offsets that the Hi3520D code accesses directly (MODE 0x020, PICFG0 0x024, REGCFG_ADDR 0x1E0, QPTHR 0x350, TARGETBITS 0x364, PICBITS 0x374, MEANQP 0x388, PICINFO0 0xA20, OUTSTD 0x0A4) all sit at the r006 offsets, so the register file is assumed to follow r006 (a neighbor generation). The offset in the window is therefore an assumption, NOT seen in any vendor register access. Register name and field names are the HiSTB drv_venc_reg_r006.h names (naming only). Not accessed by register in any vendor code (it is programmed through the DDR table, loaded by the hardware from REGCFG_ADDR; whether the hardware loads this exact register from the table is the working assumption). SLICE HEADER SOFTWARE BITS, REORDER part word 1. FORMAT RECOVERED 2026-11-11 (docs/rdl-campaign/vedu-vendor.md section 14; board sweep of 40 runs + vendor H264eWrHWSlcHdr 0x50e0): the hardware writes first_mb_in_slice (one bit '1') itself, then ParaWd+1 bits from words 0..3, then (only if ReorderWd != 0) ReorderWd+1 bits from words 4..5, then MarkingWd+1 bits from words 6..7, then slice_qp_delta = se(START_QP - 26) and, with PPS deblocking_filter_control_present_flag = 1, the deblocking syntax (idc, alpha, beta from PICFG0). Each part is packed RIGHT-aligned: MSB-first 32-bit chunks, every full chunk as is, the last chunk shifted to the low bits, so a part of n <= 32 bits is the number in the low n bits of its first word (PROVEN for the PARA part, all 40 runs reproduced bit-exactly; parts above 32 bits and the REORDER part are INFERRED from the vendor packing code only). Example IDR I slice (POC type 2, log2_max_frame_num 4): word 0x20 = 0x000000E1 (ue(2) ue(0) u(4)=0 ue(0)), MARKING word 0x38 = 0 (two zero flag bits), SLCHDRPARA = 0x00400802. Source: docs/rdl-campaign/vedu-vendor.md section 13, H264E_DRV_UpdateRegConfigParam 0x1d4d0 / H264E_DRV_InitRegConfigParam 0x1db40 / H264eDrvUpdateMeCfg 0x1c680. Not verified on hardware.";

        field {
            name = "value";
            desc = "Whole 32-bit word (INFERRED, MEDIUM).";
            sw = rw;
            hw = r;
        } value[31:0];

    } SLCHDRSTRM5 @ 0x074;

    reg {
        name = "SLCHDRSTRM6 (INFERRED, MEDIUM)";
        desc = "SLCHDRSTRM6 INFERRED, confidence MEDIUM. Reason: the vendor builds a DDR register-config table (table offset 0x38) whose word has the bit layout of the r006 register VEDU_SLCHDRSTRM6, and 9 offsets that the Hi3520D code accesses directly (MODE 0x020, PICFG0 0x024, REGCFG_ADDR 0x1E0, QPTHR 0x350, TARGETBITS 0x364, PICBITS 0x374, MEANQP 0x388, PICINFO0 0xA20, OUTSTD 0x0A4) all sit at the r006 offsets, so the register file is assumed to follow r006 (a neighbor generation). The offset in the window is therefore an assumption, NOT seen in any vendor register access. Register name and field names are the HiSTB drv_venc_reg_r006.h names (naming only). Not accessed by register in any vendor code (it is programmed through the DDR table, loaded by the hardware from REGCFG_ADDR; whether the hardware loads this exact register from the table is the working assumption). SLICE HEADER SOFTWARE BITS, MARKING part word 0 (the low MarkingWd+1 bits for a part of up to 32 bits). FORMAT RECOVERED 2026-11-11 (docs/rdl-campaign/vedu-vendor.md section 14; board sweep of 40 runs + vendor H264eWrHWSlcHdr 0x50e0): the hardware writes first_mb_in_slice (one bit '1') itself, then ParaWd+1 bits from words 0..3, then (only if ReorderWd != 0) ReorderWd+1 bits from words 4..5, then MarkingWd+1 bits from words 6..7, then slice_qp_delta = se(START_QP - 26) and, with PPS deblocking_filter_control_present_flag = 1, the deblocking syntax (idc, alpha, beta from PICFG0). Each part is packed RIGHT-aligned: MSB-first 32-bit chunks, every full chunk as is, the last chunk shifted to the low bits, so a part of n <= 32 bits is the number in the low n bits of its first word (PROVEN for the PARA part, all 40 runs reproduced bit-exactly; parts above 32 bits and the REORDER part are INFERRED from the vendor packing code only). Example IDR I slice (POC type 2, log2_max_frame_num 4): word 0x20 = 0x000000E1 (ue(2) ue(0) u(4)=0 ue(0)), MARKING word 0x38 = 0 (two zero flag bits), SLCHDRPARA = 0x00400802. Source: docs/rdl-campaign/vedu-vendor.md section 13, H264E_DRV_UpdateRegConfigParam 0x1d4d0 / H264E_DRV_InitRegConfigParam 0x1db40 / H264eDrvUpdateMeCfg 0x1c680. Not verified on hardware.";

        field {
            name = "value";
            desc = "Whole 32-bit word (INFERRED, MEDIUM).";
            sw = rw;
            hw = r;
        } value[31:0];

    } SLCHDRSTRM6 @ 0x078;

    reg {
        name = "SLCHDRSTRM7 (INFERRED, MEDIUM)";
        desc = "SLCHDRSTRM7 INFERRED, confidence MEDIUM. Reason: the vendor builds a DDR register-config table (table offset 0x3C) whose word has the bit layout of the r006 register VEDU_SLCHDRSTRM7, and 9 offsets that the Hi3520D code accesses directly (MODE 0x020, PICFG0 0x024, REGCFG_ADDR 0x1E0, QPTHR 0x350, TARGETBITS 0x364, PICBITS 0x374, MEANQP 0x388, PICINFO0 0xA20, OUTSTD 0x0A4) all sit at the r006 offsets, so the register file is assumed to follow r006 (a neighbor generation). The offset in the window is therefore an assumption, NOT seen in any vendor register access. Register name and field names are the HiSTB drv_venc_reg_r006.h names (naming only). Not accessed by register in any vendor code (it is programmed through the DDR table, loaded by the hardware from REGCFG_ADDR; whether the hardware loads this exact register from the table is the working assumption). SLICE HEADER SOFTWARE BITS, MARKING part word 1. FORMAT RECOVERED 2026-11-11 (docs/rdl-campaign/vedu-vendor.md section 14; board sweep of 40 runs + vendor H264eWrHWSlcHdr 0x50e0): the hardware writes first_mb_in_slice (one bit '1') itself, then ParaWd+1 bits from words 0..3, then (only if ReorderWd != 0) ReorderWd+1 bits from words 4..5, then MarkingWd+1 bits from words 6..7, then slice_qp_delta = se(START_QP - 26) and, with PPS deblocking_filter_control_present_flag = 1, the deblocking syntax (idc, alpha, beta from PICFG0). Each part is packed RIGHT-aligned: MSB-first 32-bit chunks, every full chunk as is, the last chunk shifted to the low bits, so a part of n <= 32 bits is the number in the low n bits of its first word (PROVEN for the PARA part, all 40 runs reproduced bit-exactly; parts above 32 bits and the REORDER part are INFERRED from the vendor packing code only). Example IDR I slice (POC type 2, log2_max_frame_num 4): word 0x20 = 0x000000E1 (ue(2) ue(0) u(4)=0 ue(0)), MARKING word 0x38 = 0 (two zero flag bits), SLCHDRPARA = 0x00400802. Source: docs/rdl-campaign/vedu-vendor.md section 13, H264E_DRV_UpdateRegConfigParam 0x1d4d0 / H264E_DRV_InitRegConfigParam 0x1db40 / H264eDrvUpdateMeCfg 0x1c680. Not verified on hardware.";

        field {
            name = "value";
            desc = "Whole 32-bit word (INFERRED, MEDIUM).";
            sw = rw;
            hw = r;
        } value[31:0];

    } SLCHDRSTRM7 @ 0x07C;

    reg {
        name = "SLCHDRPARA (INFERRED, MEDIUM)";
        desc = "SLCHDRPARA INFERRED, confidence MEDIUM. Reason: the vendor builds a DDR register-config table (table offset 0x5C) whose word has the bit layout of the r006 register VEDU_SLCHDRPARA, and 9 offsets that the Hi3520D code accesses directly (MODE 0x020, PICFG0 0x024, REGCFG_ADDR 0x1E0, QPTHR 0x350, TARGETBITS 0x364, PICBITS 0x374, MEANQP 0x388, PICINFO0 0xA20, OUTSTD 0x0A4) all sit at the r006 offsets, so the register file is assumed to follow r006 (a neighbor generation). The offset in the window is therefore an assumption, NOT seen in any vendor register access. Register name and field names are the HiSTB drv_venc_reg_r006.h names (naming only). Not accessed by register in any vendor code (it is programmed through the DDR table, loaded by the hardware from REGCFG_ADDR; whether the hardware loads this exact register from the table is the working assumption).  Source: docs/rdl-campaign/vedu-vendor.md section 13, H264E_DRV_UpdateRegConfigParam 0x1d4d0 / H264E_DRV_InitRegConfigParam 0x1db40 / H264eDrvUpdateMeCfg 0x1c680. Not verified on hardware.";

        field {
            name = "markistall";
            desc = "r006 field markistall (INFERRED, naming and position from the table word, MEDIUM)";
            sw = rw;
            hw = r;
        } markistall[0:0];

        field {
            name = "idrind";
            desc = "r006 field IDRind. 1 for an IDR picture: the hardware writes the NAL header 0x65 (nal_ref_idc from PICFG0 [17:16], type 5; PROVEN that the value 1 gives 0x65 in the 40 runs; the vendor sets it for IDR, 0 otherwise is INFERRED).";
            sw = rw;
            hw = r;
        } idrind[1:1];

        field {
            name = "para_wd";
            desc = "r006 field ParaWd. PROVEN 2026-11-11 (40 board runs): the number of software bits of the PARA part MINUS 1 (the hardware emits ParaWd+1 bits from SLCHDRSTRM0-3, right-aligned); vendor stores count-1 (H264eWrHWSlcHdr 0x57f4). Capacity 128 bits (7-bit field), vendor check count <= 128. Example IDR I slice: 8 (9 bits).";
            sw = rw;
            hw = r;
        } para_wd[14:8];

        field {
            name = "reorder_wd";
            desc = "r006 field ReorderWd. INFERRED 2026-11-11: reordering part bit count minus 1 (SLCHDRSTRM4-5, capacity 64 bits); with 0 nothing was emitted in the 40 runs (the vendor writes the part only for non-I slices). Untested for non-zero values.";
            sw = rw;
            hw = r;
        } reorder_wd[21:16];

        field {
            name = "marking_wd";
            desc = "r006 field MarkingWd. PROVEN for the length 2026-11-11 (40 runs: each step of MarkingWd moved the data by exactly one bit): the number of software bits of the MARKING part MINUS 1 (SLCHDRSTRM6-7, capacity 64 bits). IDR picture: 2 flag bits (no_output_of_prior_pics, long_term_reference) = MarkingWd 1.";
            sw = rw;
            hw = r;
        } marking_wd[27:22];

    } SLCHDRPARA @ 0x080;

    reg {
        name = "PTS0 (INFERRED, LOW)";
        desc = "PTS0 INFERRED, confidence LOW. Reason: the vendor builds a DDR register-config table (table offset 0x60) whose word has the bit layout of the r006 register VEDU_PTS0, and 9 offsets that the Hi3520D code accesses directly (MODE 0x020, PICFG0 0x024, REGCFG_ADDR 0x1E0, QPTHR 0x350, TARGETBITS 0x364, PICBITS 0x374, MEANQP 0x388, PICINFO0 0xA20, OUTSTD 0x0A4) all sit at the r006 offsets, so the register file is assumed to follow r006 (a neighbor generation). The offset in the window is therefore an assumption, NOT seen in any vendor register access. Register name and field names are the HiSTB drv_venc_reg_r006.h names (naming only). Not accessed by register in any vendor code (it is programmed through the DDR table, loaded by the hardware from REGCFG_ADDR; whether the hardware loads this exact register from the table is the working assumption). Words 0 and 1 are the frame time stamp from the source picture, words 2 and 3 are 0. Source: docs/rdl-campaign/vedu-vendor.md section 13, H264E_DRV_UpdateRegConfigParam 0x1d4d0 / H264E_DRV_InitRegConfigParam 0x1db40 / H264eDrvUpdateMeCfg 0x1c680. Not verified on hardware.";

        field {
            name = "value";
            desc = "Whole 32-bit word (INFERRED, LOW).";
            sw = rw;
            hw = r;
        } value[31:0];

    } PTS0 @ 0x090;

    reg {
        name = "PTS1 (INFERRED, LOW)";
        desc = "PTS1 INFERRED, confidence LOW. Reason: the vendor builds a DDR register-config table (table offset 0x64) whose word has the bit layout of the r006 register VEDU_PTS1, and 9 offsets that the Hi3520D code accesses directly (MODE 0x020, PICFG0 0x024, REGCFG_ADDR 0x1E0, QPTHR 0x350, TARGETBITS 0x364, PICBITS 0x374, MEANQP 0x388, PICINFO0 0xA20, OUTSTD 0x0A4) all sit at the r006 offsets, so the register file is assumed to follow r006 (a neighbor generation). The offset in the window is therefore an assumption, NOT seen in any vendor register access. Register name and field names are the HiSTB drv_venc_reg_r006.h names (naming only). Not accessed by register in any vendor code (it is programmed through the DDR table, loaded by the hardware from REGCFG_ADDR; whether the hardware loads this exact register from the table is the working assumption). Words 0 and 1 are the frame time stamp from the source picture, words 2 and 3 are 0. Source: docs/rdl-campaign/vedu-vendor.md section 13, H264E_DRV_UpdateRegConfigParam 0x1d4d0 / H264E_DRV_InitRegConfigParam 0x1db40 / H264eDrvUpdateMeCfg 0x1c680. Not verified on hardware.";

        field {
            name = "value";
            desc = "Whole 32-bit word (INFERRED, LOW).";
            sw = rw;
            hw = r;
        } value[31:0];

    } PTS1 @ 0x094;

    reg {
        name = "PTS2 (INFERRED, LOW)";
        desc = "PTS2 INFERRED, confidence LOW. Reason: the vendor builds a DDR register-config table (table offset 0x68) whose word has the bit layout of the r006 register VEDU_PTS2, and 9 offsets that the Hi3520D code accesses directly (MODE 0x020, PICFG0 0x024, REGCFG_ADDR 0x1E0, QPTHR 0x350, TARGETBITS 0x364, PICBITS 0x374, MEANQP 0x388, PICINFO0 0xA20, OUTSTD 0x0A4) all sit at the r006 offsets, so the register file is assumed to follow r006 (a neighbor generation). The offset in the window is therefore an assumption, NOT seen in any vendor register access. Register name and field names are the HiSTB drv_venc_reg_r006.h names (naming only). Not accessed by register in any vendor code (it is programmed through the DDR table, loaded by the hardware from REGCFG_ADDR; whether the hardware loads this exact register from the table is the working assumption). Words 0 and 1 are the frame time stamp from the source picture, words 2 and 3 are 0. Source: docs/rdl-campaign/vedu-vendor.md section 13, H264E_DRV_UpdateRegConfigParam 0x1d4d0 / H264E_DRV_InitRegConfigParam 0x1db40 / H264eDrvUpdateMeCfg 0x1c680. Not verified on hardware.";

        field {
            name = "value";
            desc = "Whole 32-bit word (INFERRED, LOW).";
            sw = rw;
            hw = r;
        } value[31:0];

    } PTS2 @ 0x098;

    reg {
        name = "PTS3 (INFERRED, LOW)";
        desc = "PTS3 INFERRED, confidence LOW. Reason: the vendor builds a DDR register-config table (table offset 0x6C) whose word has the bit layout of the r006 register VEDU_PTS3, and 9 offsets that the Hi3520D code accesses directly (MODE 0x020, PICFG0 0x024, REGCFG_ADDR 0x1E0, QPTHR 0x350, TARGETBITS 0x364, PICBITS 0x374, MEANQP 0x388, PICINFO0 0xA20, OUTSTD 0x0A4) all sit at the r006 offsets, so the register file is assumed to follow r006 (a neighbor generation). The offset in the window is therefore an assumption, NOT seen in any vendor register access. Register name and field names are the HiSTB drv_venc_reg_r006.h names (naming only). Not accessed by register in any vendor code (it is programmed through the DDR table, loaded by the hardware from REGCFG_ADDR; whether the hardware loads this exact register from the table is the working assumption). Words 0 and 1 are the frame time stamp from the source picture, words 2 and 3 are 0. Source: docs/rdl-campaign/vedu-vendor.md section 13, H264E_DRV_UpdateRegConfigParam 0x1d4d0 / H264E_DRV_InitRegConfigParam 0x1db40 / H264eDrvUpdateMeCfg 0x1c680. Not verified on hardware.";

        field {
            name = "value";
            desc = "Whole 32-bit word (INFERRED, LOW).";
            sw = rw;
            hw = r;
        } value[31:0];

    } PTS3 @ 0x09C;

    reg {
        name = "SRCYADDR (INFERRED, MEDIUM)";
        desc = "SRCYADDR INFERRED, confidence MEDIUM. Reason: the vendor builds a DDR register-config table (table offset 0x0) whose word has the bit layout of the r006 register VEDU_SRCYADDR, and 9 offsets that the Hi3520D code accesses directly (MODE 0x020, PICFG0 0x024, REGCFG_ADDR 0x1E0, QPTHR 0x350, TARGETBITS 0x364, PICBITS 0x374, MEANQP 0x388, PICINFO0 0xA20, OUTSTD 0x0A4) all sit at the r006 offsets, so the register file is assumed to follow r006 (a neighbor generation). The offset in the window is therefore an assumption, NOT seen in any vendor register access. Register name and field names are the HiSTB drv_venc_reg_r006.h names (naming only). Not accessed by register in any vendor code (it is programmed through the DDR table, loaded by the hardware from REGCFG_ADDR; whether the hardware loads this exact register from the table is the working assumption). Physical address of the source luma plane. Source: docs/rdl-campaign/vedu-vendor.md section 13, H264E_DRV_UpdateRegConfigParam 0x1d4d0 / H264E_DRV_InitRegConfigParam 0x1db40 / H264eDrvUpdateMeCfg 0x1c680. Not verified on hardware.";

        field {
            name = "value";
            desc = "Whole 32-bit word (INFERRED, MEDIUM).";
            sw = rw;
            hw = r;
        } value[31:0];

    } SRCYADDR @ 0x100;

    reg {
        name = "SRCCADDR (INFERRED, MEDIUM)";
        desc = "SRCCADDR INFERRED, confidence MEDIUM. Reason: the vendor builds a DDR register-config table (table offset 0x4) whose word has the bit layout of the r006 register VEDU_SRCCADDR, and 9 offsets that the Hi3520D code accesses directly (MODE 0x020, PICFG0 0x024, REGCFG_ADDR 0x1E0, QPTHR 0x350, TARGETBITS 0x364, PICBITS 0x374, MEANQP 0x388, PICINFO0 0xA20, OUTSTD 0x0A4) all sit at the r006 offsets, so the register file is assumed to follow r006 (a neighbor generation). The offset in the window is therefore an assumption, NOT seen in any vendor register access. Register name and field names are the HiSTB drv_venc_reg_r006.h names (naming only). Not accessed by register in any vendor code (it is programmed through the DDR table, loaded by the hardware from REGCFG_ADDR; whether the hardware loads this exact register from the table is the working assumption). Physical address of the source chroma plane (semi-planar). Source: docs/rdl-campaign/vedu-vendor.md section 13, H264E_DRV_UpdateRegConfigParam 0x1d4d0 / H264E_DRV_InitRegConfigParam 0x1db40 / H264eDrvUpdateMeCfg 0x1c680. Not verified on hardware.";

        field {
            name = "value";
            desc = "Whole 32-bit word (INFERRED, MEDIUM).";
            sw = rw;
            hw = r;
        } value[31:0];

    } SRCCADDR @ 0x104;

    reg {
        name = "RCNYADDR (INFERRED, MEDIUM)";
        desc = "RCNYADDR INFERRED, confidence MEDIUM. Reason: the vendor builds a DDR register-config table (table offset 0x8) whose word has the bit layout of the r006 register VEDU_RCNYADDR, and 9 offsets that the Hi3520D code accesses directly (MODE 0x020, PICFG0 0x024, REGCFG_ADDR 0x1E0, QPTHR 0x350, TARGETBITS 0x364, PICBITS 0x374, MEANQP 0x388, PICINFO0 0xA20, OUTSTD 0x0A4) all sit at the r006 offsets, so the register file is assumed to follow r006 (a neighbor generation). The offset in the window is therefore an assumption, NOT seen in any vendor register access. Register name and field names are the HiSTB drv_venc_reg_r006.h names (naming only). Not accessed by register in any vendor code (it is programmed through the DDR table, loaded by the hardware from REGCFG_ADDR; whether the hardware loads this exact register from the table is the working assumption). Reconstruction picture luma address. Source: docs/rdl-campaign/vedu-vendor.md section 13, H264E_DRV_UpdateRegConfigParam 0x1d4d0 / H264E_DRV_InitRegConfigParam 0x1db40 / H264eDrvUpdateMeCfg 0x1c680. Not verified on hardware.";

        field {
            name = "value";
            desc = "Whole 32-bit word (INFERRED, MEDIUM).";
            sw = rw;
            hw = r;
        } value[31:0];

    } RCNYADDR @ 0x110;

    reg {
        name = "RCNCADDR (INFERRED, MEDIUM)";
        desc = "RCNCADDR INFERRED, confidence MEDIUM. Reason: the vendor builds a DDR register-config table (table offset 0xC) whose word has the bit layout of the r006 register VEDU_RCNCADDR, and 9 offsets that the Hi3520D code accesses directly (MODE 0x020, PICFG0 0x024, REGCFG_ADDR 0x1E0, QPTHR 0x350, TARGETBITS 0x364, PICBITS 0x374, MEANQP 0x388, PICINFO0 0xA20, OUTSTD 0x0A4) all sit at the r006 offsets, so the register file is assumed to follow r006 (a neighbor generation). The offset in the window is therefore an assumption, NOT seen in any vendor register access. Register name and field names are the HiSTB drv_venc_reg_r006.h names (naming only). Not accessed by register in any vendor code (it is programmed through the DDR table, loaded by the hardware from REGCFG_ADDR; whether the hardware loads this exact register from the table is the working assumption). Reconstruction picture chroma address. Source: docs/rdl-campaign/vedu-vendor.md section 13, H264E_DRV_UpdateRegConfigParam 0x1d4d0 / H264E_DRV_InitRegConfigParam 0x1db40 / H264eDrvUpdateMeCfg 0x1c680. Not verified on hardware.";

        field {
            name = "value";
            desc = "Whole 32-bit word (INFERRED, MEDIUM).";
            sw = rw;
            hw = r;
        } value[31:0];

    } RCNCADDR @ 0x114;

    reg {
        name = "REFYADDR (INFERRED, MEDIUM)";
        desc = "REFYADDR INFERRED, confidence MEDIUM. Reason: the vendor builds a DDR register-config table (table offset 0x10) whose word has the bit layout of the r006 register VEDU_REFYADDR, and 9 offsets that the Hi3520D code accesses directly (MODE 0x020, PICFG0 0x024, REGCFG_ADDR 0x1E0, QPTHR 0x350, TARGETBITS 0x364, PICBITS 0x374, MEANQP 0x388, PICINFO0 0xA20, OUTSTD 0x0A4) all sit at the r006 offsets, so the register file is assumed to follow r006 (a neighbor generation). The offset in the window is therefore an assumption, NOT seen in any vendor register access. Register name and field names are the HiSTB drv_venc_reg_r006.h names (naming only). Not accessed by register in any vendor code (it is programmed through the DDR table, loaded by the hardware from REGCFG_ADDR; whether the hardware loads this exact register from the table is the working assumption). Reference picture luma address; the vendor writes 0 for an I picture. Source: docs/rdl-campaign/vedu-vendor.md section 13, H264E_DRV_UpdateRegConfigParam 0x1d4d0 / H264E_DRV_InitRegConfigParam 0x1db40 / H264eDrvUpdateMeCfg 0x1c680. Not verified on hardware.";

        field {
            name = "value";
            desc = "Whole 32-bit word (INFERRED, MEDIUM).";
            sw = rw;
            hw = r;
        } value[31:0];

    } REFYADDR @ 0x120;

    reg {
        name = "REFCADDR (INFERRED, MEDIUM)";
        desc = "REFCADDR INFERRED, confidence MEDIUM. Reason: the vendor builds a DDR register-config table (table offset 0x14) whose word has the bit layout of the r006 register VEDU_REFCADDR, and 9 offsets that the Hi3520D code accesses directly (MODE 0x020, PICFG0 0x024, REGCFG_ADDR 0x1E0, QPTHR 0x350, TARGETBITS 0x364, PICBITS 0x374, MEANQP 0x388, PICINFO0 0xA20, OUTSTD 0x0A4) all sit at the r006 offsets, so the register file is assumed to follow r006 (a neighbor generation). The offset in the window is therefore an assumption, NOT seen in any vendor register access. Register name and field names are the HiSTB drv_venc_reg_r006.h names (naming only). Not accessed by register in any vendor code (it is programmed through the DDR table, loaded by the hardware from REGCFG_ADDR; whether the hardware loads this exact register from the table is the working assumption). Reference picture chroma address; the vendor writes 0 for an I picture. Source: docs/rdl-campaign/vedu-vendor.md section 13, H264E_DRV_UpdateRegConfigParam 0x1d4d0 / H264E_DRV_InitRegConfigParam 0x1db40 / H264eDrvUpdateMeCfg 0x1c680. Not verified on hardware.";

        field {
            name = "value";
            desc = "Whole 32-bit word (INFERRED, MEDIUM).";
            sw = rw;
            hw = r;
        } value[31:0];

    } REFCADDR @ 0x124;

    reg {
        name = "SSTRIDE (INFERRED, MEDIUM)";
        desc = "SSTRIDE INFERRED, confidence MEDIUM. Reason: the vendor builds a DDR register-config table (table offset 0x18) whose word has the bit layout of the r006 register VEDU_SSTRIDE, and 9 offsets that the Hi3520D code accesses directly (MODE 0x020, PICFG0 0x024, REGCFG_ADDR 0x1E0, QPTHR 0x350, TARGETBITS 0x364, PICBITS 0x374, MEANQP 0x388, PICINFO0 0xA20, OUTSTD 0x0A4) all sit at the r006 offsets, so the register file is assumed to follow r006 (a neighbor generation). The offset in the window is therefore an assumption, NOT seen in any vendor register access. Register name and field names are the HiSTB drv_venc_reg_r006.h names (naming only). Not accessed by register in any vendor code (it is programmed through the DDR table, loaded by the hardware from REGCFG_ADDR; whether the hardware loads this exact register from the table is the working assumption).  Source: docs/rdl-campaign/vedu-vendor.md section 13, H264E_DRV_UpdateRegConfigParam 0x1d4d0 / H264E_DRV_InitRegConfigParam 0x1db40 / H264eDrvUpdateMeCfg 0x1c680. Not verified on hardware.";

        field {
            name = "src_ystride";
            desc = "r006 field SrcYStride (INFERRED, naming and position from the table word, MEDIUM)";
            sw = rw;
            hw = r;
        } src_ystride[15:0];

        field {
            name = "src_cstride";
            desc = "r006 field SrcCStride (INFERRED, naming and position from the table word, MEDIUM)";
            sw = rw;
            hw = r;
        } src_cstride[31:16];

    } SSTRIDE @ 0x130;

    reg {
        name = "RSTRIDE (INFERRED, MEDIUM)";
        desc = "RSTRIDE INFERRED, confidence MEDIUM. Reason: the vendor builds a DDR register-config table (table offset 0x1C) whose word has the bit layout of the r006 register VEDU_RSTRIDE, and 9 offsets that the Hi3520D code accesses directly (MODE 0x020, PICFG0 0x024, REGCFG_ADDR 0x1E0, QPTHR 0x350, TARGETBITS 0x364, PICBITS 0x374, MEANQP 0x388, PICINFO0 0xA20, OUTSTD 0x0A4) all sit at the r006 offsets, so the register file is assumed to follow r006 (a neighbor generation). The offset in the window is therefore an assumption, NOT seen in any vendor register access. Register name and field names are the HiSTB drv_venc_reg_r006.h names (naming only). Not accessed by register in any vendor code (it is programmed through the DDR table, loaded by the hardware from REGCFG_ADDR; whether the hardware loads this exact register from the table is the working assumption). The vendor writes the same value into both halves. Source: docs/rdl-campaign/vedu-vendor.md section 13, H264E_DRV_UpdateRegConfigParam 0x1d4d0 / H264E_DRV_InitRegConfigParam 0x1db40 / H264eDrvUpdateMeCfg 0x1c680. Not verified on hardware.";

        field {
            name = "rystride";
            desc = "r006 field RYStride (INFERRED, naming and position from the table word, MEDIUM)";
            sw = rw;
            hw = r;
        } rystride[15:0];

        field {
            name = "rcstride";
            desc = "r006 field RCStride (INFERRED, naming and position from the table word, MEDIUM)";
            sw = rw;
            hw = r;
        } rcstride[31:16];

    } RSTRIDE @ 0x134;

    reg {
        name = "STRMADDR (INFERRED, MEDIUM)";
        desc = "STRMADDR INFERRED, confidence MEDIUM. Reason: the vendor builds a DDR register-config table (table offset 0x240) whose word has the bit layout of the r006 register VEDU_STRMADDR, and 9 offsets that the Hi3520D code accesses directly (MODE 0x020, PICFG0 0x024, REGCFG_ADDR 0x1E0, QPTHR 0x350, TARGETBITS 0x364, PICBITS 0x374, MEANQP 0x388, PICINFO0 0xA20, OUTSTD 0x0A4) all sit at the r006 offsets, so the register file is assumed to follow r006 (a neighbor generation). The offset in the window is therefore an assumption, NOT seen in any vendor register access. Register name and field names are the HiSTB drv_venc_reg_r006.h names (naming only). Not accessed by register in any vendor code (it is programmed through the DDR table, loaded by the hardware from REGCFG_ADDR; whether the hardware loads this exact register from the table is the working assumption). Physical address of the stream buffer. Source: docs/rdl-campaign/vedu-vendor.md section 13, H264E_DRV_UpdateRegConfigParam 0x1d4d0 / H264E_DRV_InitRegConfigParam 0x1db40 / H264eDrvUpdateMeCfg 0x1c680. Not verified on hardware.";

        field {
            name = "value";
            desc = "Whole 32-bit word (INFERRED, MEDIUM).";
            sw = rw;
            hw = r;
        } value[31:0];

    } STRMADDR @ 0x140;

    reg {
        name = "SRPTRADDR (INFERRED, MEDIUM)";
        desc = "SRPTRADDR INFERRED, confidence MEDIUM. Reason: the vendor builds a DDR register-config table (table offset 0x244) whose word has the bit layout of the r006 register VEDU_SRPTRADDR, and 9 offsets that the Hi3520D code accesses directly (MODE 0x020, PICFG0 0x024, REGCFG_ADDR 0x1E0, QPTHR 0x350, TARGETBITS 0x364, PICBITS 0x374, MEANQP 0x388, PICINFO0 0xA20, OUTSTD 0x0A4) all sit at the r006 offsets, so the register file is assumed to follow r006 (a neighbor generation). The offset in the window is therefore an assumption, NOT seen in any vendor register access. Register name and field names are the HiSTB drv_venc_reg_r006.h names (naming only). Not accessed by register in any vendor code (it is programmed through the DDR table, loaded by the hardware from REGCFG_ADDR; whether the hardware loads this exact register from the table is the working assumption). Physical address of a DDR word (stream descriptor + 0x40). Which of the two pointer words is the read pointer is inferred from the r006 order (read, then write); not seen in code. Source: docs/rdl-campaign/vedu-vendor.md section 13, H264E_DRV_UpdateRegConfigParam 0x1d4d0 / H264E_DRV_InitRegConfigParam 0x1db40 / H264eDrvUpdateMeCfg 0x1c680. Not verified on hardware.";

        field {
            name = "value";
            desc = "Whole 32-bit word (INFERRED, MEDIUM).";
            sw = rw;
            hw = r;
        } value[31:0];

    } SRPTRADDR @ 0x144;

    reg {
        name = "SWPTRADDR (INFERRED, MEDIUM)";
        desc = "SWPTRADDR INFERRED, confidence MEDIUM. Reason: the vendor builds a DDR register-config table (table offset 0x248) whose word has the bit layout of the r006 register VEDU_SWPTRADDR, and 9 offsets that the Hi3520D code accesses directly (MODE 0x020, PICFG0 0x024, REGCFG_ADDR 0x1E0, QPTHR 0x350, TARGETBITS 0x364, PICBITS 0x374, MEANQP 0x388, PICINFO0 0xA20, OUTSTD 0x0A4) all sit at the r006 offsets, so the register file is assumed to follow r006 (a neighbor generation). The offset in the window is therefore an assumption, NOT seen in any vendor register access. Register name and field names are the HiSTB drv_venc_reg_r006.h names (naming only). Not accessed by register in any vendor code (it is programmed through the DDR table, loaded by the hardware from REGCFG_ADDR; whether the hardware loads this exact register from the table is the working assumption). Physical address of a DDR word (stream descriptor + 0x80). Software updates the word after it wrote SPS/PPS into the ring (H264E_PutBitStream), so this is the write pointer word; hardware advances it. Source: docs/rdl-campaign/vedu-vendor.md section 13, H264E_DRV_UpdateRegConfigParam 0x1d4d0 / H264E_DRV_InitRegConfigParam 0x1db40 / H264eDrvUpdateMeCfg 0x1c680. Not verified on hardware.";

        field {
            name = "value";
            desc = "Whole 32-bit word (INFERRED, MEDIUM).";
            sw = rw;
            hw = r;
        } value[31:0];

    } SWPTRADDR @ 0x148;

    reg {
        name = "STRMBUFLEN (INFERRED, HIGH)";
        desc = "STRMBUFLEN INFERRED, confidence HIGH. Reason: the vendor builds a DDR register-config table (table offset 0x24C) whose word has the bit layout of the r006 register VEDU_STRMBUFLEN, and 9 offsets that the Hi3520D code accesses directly (MODE 0x020, PICFG0 0x024, REGCFG_ADDR 0x1E0, QPTHR 0x350, TARGETBITS 0x364, PICBITS 0x374, MEANQP 0x388, PICINFO0 0xA20, OUTSTD 0x0A4) all sit at the r006 offsets, so the register file is assumed to follow r006 (a neighbor generation). The offset in the window is therefore an assumption, NOT seen in any vendor register access. Register name and field names are the HiSTB drv_venc_reg_r006.h names (naming only). Not accessed by register in any vendor code (it is programmed through the DDR table, loaded by the hardware from REGCFG_ADDR; whether the hardware loads this exact register from the table is the working assumption). Stream buffer length in bytes divided by 64 (vendor: length >> 6 into bits [31:6]). Source: docs/rdl-campaign/vedu-vendor.md section 13, H264E_DRV_UpdateRegConfigParam 0x1d4d0 / H264E_DRV_InitRegConfigParam 0x1db40 / H264eDrvUpdateMeCfg 0x1c680. Not verified on hardware.";

        field {
            name = "buffer_length";
            desc = "r006 field BufferLength (INFERRED, naming and position from the table word, HIGH)";
            sw = rw;
            hw = r;
        } buffer_length[31:6];

    } STRMBUFLEN @ 0x14C;

    reg {
        name = "MECFG0 (INFERRED, MEDIUM)";
        desc = "MECFG0 INFERRED, confidence MEDIUM. Reason: the vendor builds a DDR register-config table (table offset 0x80) whose word has the bit layout of the r006 register VEDU_MECFG0, and 9 offsets that the Hi3520D code accesses directly (MODE 0x020, PICFG0 0x024, REGCFG_ADDR 0x1E0, QPTHR 0x350, TARGETBITS 0x364, PICBITS 0x374, MEANQP 0x388, PICINFO0 0xA20, OUTSTD 0x0A4) all sit at the r006 offsets, so the register file is assumed to follow r006 (a neighbor generation). The offset in the window is therefore an assumption, NOT seen in any vendor register access. Register name and field names are the HiSTB drv_venc_reg_r006.h names (naming only). Not accessed by register in any vendor code (it is programmed through the DDR table, loaded by the hardware from REGCFG_ADDR; whether the hardware loads this exact register from the table is the working assumption).  Source: docs/rdl-campaign/vedu-vendor.md section 13, H264E_DRV_UpdateRegConfigParam 0x1d4d0 / H264E_DRV_InitRegConfigParam 0x1db40 / H264eDrvUpdateMeCfg 0x1c680. Not verified on hardware.";

        field {
            name = "hswsize";
            desc = "r006 field HSWSize (INFERRED, naming and position from the table word, MEDIUM)";
            sw = rw;
            hw = r;
        } hswsize[3:0];

        field {
            name = "vswsize";
            desc = "r006 field VSWSize (INFERRED, naming and position from the table word, MEDIUM)";
            sw = rw;
            hw = r;
        } vswsize[6:4];

        field {
            name = "frac_real_mv_thr";
            desc = "r006 field fracRealMvThr (INFERRED, naming and position from the table word, MEDIUM)";
            sw = rw;
            hw = r;
        } frac_real_mv_thr[19:16];

    } MECFG0 @ 0x200;

    reg {
        name = "MECFG1 (INFERRED, MEDIUM)";
        desc = "MECFG1 INFERRED, confidence MEDIUM. Reason: the vendor builds a DDR register-config table (table offset 0x250) whose word has the bit layout of the r006 register VEDU_MECFG1, and 9 offsets that the Hi3520D code accesses directly (MODE 0x020, PICFG0 0x024, REGCFG_ADDR 0x1E0, QPTHR 0x350, TARGETBITS 0x364, PICBITS 0x374, MEANQP 0x388, PICINFO0 0xA20, OUTSTD 0x0A4) all sit at the r006 offsets, so the register file is assumed to follow r006 (a neighbor generation). The offset in the window is therefore an assumption, NOT seen in any vendor register access. Register name and field names are the HiSTB drv_venc_reg_r006.h names (naming only). Not accessed by register in any vendor code (it is programmed through the DDR table, loaded by the hardware from REGCFG_ADDR; whether the hardware loads this exact register from the table is the working assumption).  Source: docs/rdl-campaign/vedu-vendor.md section 13, H264E_DRV_UpdateRegConfigParam 0x1d4d0 / H264E_DRV_InitRegConfigParam 0x1db40 / H264eDrvUpdateMeCfg 0x1c680. Not verified on hardware.";

        field {
            name = "rect0_mod";
            desc = "r006 field Rect0Mod (INFERRED, naming and position from the table word, MEDIUM)";
            sw = rw;
            hw = r;
        } rect0_mod[0:0];

        field {
            name = "rect1_mod";
            desc = "r006 field Rect1Mod (INFERRED, naming and position from the table word, MEDIUM)";
            sw = rw;
            hw = r;
        } rect1_mod[1:1];

        field {
            name = "rect2_mod";
            desc = "r006 field Rect2Mod (INFERRED, naming and position from the table word, MEDIUM)";
            sw = rw;
            hw = r;
        } rect2_mod[2:2];

        field {
            name = "rect3_mod";
            desc = "r006 field Rect3Mod (INFERRED, naming and position from the table word, MEDIUM)";
            sw = rw;
            hw = r;
        } rect3_mod[3:3];

    } MECFG1 @ 0x204;

    reg {
        name = "MERECTCFG0 (INFERRED, MEDIUM)";
        desc = "MERECTCFG INFERRED, confidence MEDIUM. Reason: the vendor builds a DDR register-config table (table offset 0x254) whose word has the bit layout of the r006 register VEDU_MERECTCFG, and 9 offsets that the Hi3520D code accesses directly (MODE 0x020, PICFG0 0x024, REGCFG_ADDR 0x1E0, QPTHR 0x350, TARGETBITS 0x364, PICBITS 0x374, MEANQP 0x388, PICINFO0 0xA20, OUTSTD 0x0A4) all sit at the r006 offsets, so the register file is assumed to follow r006 (a neighbor generation). The offset in the window is therefore an assumption, NOT seen in any vendor register access. Register name and field names are the HiSTB drv_venc_reg_r006.h names (naming only). Not accessed by register in any vendor code (it is programmed through the DDR table, loaded by the hardware from REGCFG_ADDR; whether the hardware loads this exact register from the table is the working assumption). Index 0 of 4. Source: docs/rdl-campaign/vedu-vendor.md section 13, H264E_DRV_UpdateRegConfigParam 0x1d4d0 / H264E_DRV_InitRegConfigParam 0x1db40 / H264eDrvUpdateMeCfg 0x1c680. Not verified on hardware.";

        field {
            name = "rect_width";
            desc = "r006 field RectWidth (INFERRED, naming and position from the table word, MEDIUM)";
            sw = rw;
            hw = r;
        } rect_width[7:0];

        field {
            name = "rect_height";
            desc = "r006 field RectHeight (INFERRED, naming and position from the table word, MEDIUM)";
            sw = rw;
            hw = r;
        } rect_height[14:8];

        field {
            name = "rect_hstep";
            desc = "r006 field RectHstep (INFERRED, naming and position from the table word, MEDIUM)";
            sw = rw;
            hw = r;
        } rect_hstep[16:16];

        field {
            name = "rect_vstep";
            desc = "r006 field RectVstep (INFERRED, naming and position from the table word, MEDIUM)";
            sw = rw;
            hw = r;
        } rect_vstep[24:24];

    } MERECTCFG0 @ 0x208;

    reg {
        name = "MERECTCFG1 (INFERRED, MEDIUM)";
        desc = "MERECTCFG INFERRED, confidence MEDIUM. Reason: the vendor builds a DDR register-config table (table offset 0x258) whose word has the bit layout of the r006 register VEDU_MERECTCFG, and 9 offsets that the Hi3520D code accesses directly (MODE 0x020, PICFG0 0x024, REGCFG_ADDR 0x1E0, QPTHR 0x350, TARGETBITS 0x364, PICBITS 0x374, MEANQP 0x388, PICINFO0 0xA20, OUTSTD 0x0A4) all sit at the r006 offsets, so the register file is assumed to follow r006 (a neighbor generation). The offset in the window is therefore an assumption, NOT seen in any vendor register access. Register name and field names are the HiSTB drv_venc_reg_r006.h names (naming only). Not accessed by register in any vendor code (it is programmed through the DDR table, loaded by the hardware from REGCFG_ADDR; whether the hardware loads this exact register from the table is the working assumption). Index 1 of 4. Source: docs/rdl-campaign/vedu-vendor.md section 13, H264E_DRV_UpdateRegConfigParam 0x1d4d0 / H264E_DRV_InitRegConfigParam 0x1db40 / H264eDrvUpdateMeCfg 0x1c680. Not verified on hardware.";

        field {
            name = "rect_width";
            desc = "r006 field RectWidth (INFERRED, naming and position from the table word, MEDIUM)";
            sw = rw;
            hw = r;
        } rect_width[7:0];

        field {
            name = "rect_height";
            desc = "r006 field RectHeight (INFERRED, naming and position from the table word, MEDIUM)";
            sw = rw;
            hw = r;
        } rect_height[14:8];

        field {
            name = "rect_hstep";
            desc = "r006 field RectHstep (INFERRED, naming and position from the table word, MEDIUM)";
            sw = rw;
            hw = r;
        } rect_hstep[16:16];

        field {
            name = "rect_vstep";
            desc = "r006 field RectVstep (INFERRED, naming and position from the table word, MEDIUM)";
            sw = rw;
            hw = r;
        } rect_vstep[24:24];

    } MERECTCFG1 @ 0x20C;

    reg {
        name = "MERECTCFG2 (INFERRED, MEDIUM)";
        desc = "MERECTCFG INFERRED, confidence MEDIUM. Reason: the vendor builds a DDR register-config table (table offset 0x25C) whose word has the bit layout of the r006 register VEDU_MERECTCFG, and 9 offsets that the Hi3520D code accesses directly (MODE 0x020, PICFG0 0x024, REGCFG_ADDR 0x1E0, QPTHR 0x350, TARGETBITS 0x364, PICBITS 0x374, MEANQP 0x388, PICINFO0 0xA20, OUTSTD 0x0A4) all sit at the r006 offsets, so the register file is assumed to follow r006 (a neighbor generation). The offset in the window is therefore an assumption, NOT seen in any vendor register access. Register name and field names are the HiSTB drv_venc_reg_r006.h names (naming only). Not accessed by register in any vendor code (it is programmed through the DDR table, loaded by the hardware from REGCFG_ADDR; whether the hardware loads this exact register from the table is the working assumption). Index 2 of 4. Source: docs/rdl-campaign/vedu-vendor.md section 13, H264E_DRV_UpdateRegConfigParam 0x1d4d0 / H264E_DRV_InitRegConfigParam 0x1db40 / H264eDrvUpdateMeCfg 0x1c680. Not verified on hardware.";

        field {
            name = "rect_width";
            desc = "r006 field RectWidth (INFERRED, naming and position from the table word, MEDIUM)";
            sw = rw;
            hw = r;
        } rect_width[7:0];

        field {
            name = "rect_height";
            desc = "r006 field RectHeight (INFERRED, naming and position from the table word, MEDIUM)";
            sw = rw;
            hw = r;
        } rect_height[14:8];

        field {
            name = "rect_hstep";
            desc = "r006 field RectHstep (INFERRED, naming and position from the table word, MEDIUM)";
            sw = rw;
            hw = r;
        } rect_hstep[16:16];

        field {
            name = "rect_vstep";
            desc = "r006 field RectVstep (INFERRED, naming and position from the table word, MEDIUM)";
            sw = rw;
            hw = r;
        } rect_vstep[24:24];

    } MERECTCFG2 @ 0x210;

    reg {
        name = "MERECTCFG3 (INFERRED, MEDIUM)";
        desc = "MERECTCFG INFERRED, confidence MEDIUM. Reason: the vendor builds a DDR register-config table (table offset 0x260) whose word has the bit layout of the r006 register VEDU_MERECTCFG, and 9 offsets that the Hi3520D code accesses directly (MODE 0x020, PICFG0 0x024, REGCFG_ADDR 0x1E0, QPTHR 0x350, TARGETBITS 0x364, PICBITS 0x374, MEANQP 0x388, PICINFO0 0xA20, OUTSTD 0x0A4) all sit at the r006 offsets, so the register file is assumed to follow r006 (a neighbor generation). The offset in the window is therefore an assumption, NOT seen in any vendor register access. Register name and field names are the HiSTB drv_venc_reg_r006.h names (naming only). Not accessed by register in any vendor code (it is programmed through the DDR table, loaded by the hardware from REGCFG_ADDR; whether the hardware loads this exact register from the table is the working assumption). Index 3 of 4. Source: docs/rdl-campaign/vedu-vendor.md section 13, H264E_DRV_UpdateRegConfigParam 0x1d4d0 / H264E_DRV_InitRegConfigParam 0x1db40 / H264eDrvUpdateMeCfg 0x1c680. Not verified on hardware.";

        field {
            name = "rect_width";
            desc = "r006 field RectWidth (INFERRED, naming and position from the table word, MEDIUM)";
            sw = rw;
            hw = r;
        } rect_width[7:0];

        field {
            name = "rect_height";
            desc = "r006 field RectHeight (INFERRED, naming and position from the table word, MEDIUM)";
            sw = rw;
            hw = r;
        } rect_height[14:8];

        field {
            name = "rect_hstep";
            desc = "r006 field RectHstep (INFERRED, naming and position from the table word, MEDIUM)";
            sw = rw;
            hw = r;
        } rect_hstep[16:16];

        field {
            name = "rect_vstep";
            desc = "r006 field RectVstep (INFERRED, naming and position from the table word, MEDIUM)";
            sw = rw;
            hw = r;
        } rect_vstep[24:24];

    } MERECTCFG3 @ 0x214;

    reg {
        name = "METHR0 (INFERRED, MEDIUM)";
        desc = "METHR0 INFERRED, confidence MEDIUM. Reason: the vendor builds a DDR register-config table (table offset 0x94) whose word has the bit layout of the r006 register VEDU_METHR0, and 9 offsets that the Hi3520D code accesses directly (MODE 0x020, PICFG0 0x024, REGCFG_ADDR 0x1E0, QPTHR 0x350, TARGETBITS 0x364, PICBITS 0x374, MEANQP 0x388, PICINFO0 0xA20, OUTSTD 0x0A4) all sit at the r006 offsets, so the register file is assumed to follow r006 (a neighbor generation). The offset in the window is therefore an assumption, NOT seen in any vendor register access. Register name and field names are the HiSTB drv_venc_reg_r006.h names (naming only). Not accessed by register in any vendor code (it is programmed through the DDR table, loaded by the hardware from REGCFG_ADDR; whether the hardware loads this exact register from the table is the working assumption).  Source: docs/rdl-campaign/vedu-vendor.md section 13, H264E_DRV_UpdateRegConfigParam 0x1d4d0 / H264E_DRV_InitRegConfigParam 0x1db40 / H264eDrvUpdateMeCfg 0x1c680. Not verified on hardware.";

        field {
            name = "symc_sth1";
            desc = "r006 field SymcSTh1 (INFERRED, naming and position from the table word, MEDIUM)";
            sw = rw;
            hw = r;
        } symc_sth1[15:0];

        field {
            name = "symc_sth2";
            desc = "r006 field SymcSTh2 (INFERRED, naming and position from the table word, MEDIUM)";
            sw = rw;
            hw = r;
        } symc_sth2[31:16];

    } METHR0 @ 0x220;

    reg {
        name = "METHR1 (INFERRED, MEDIUM)";
        desc = "METHR1 INFERRED, confidence MEDIUM. Reason: the vendor builds a DDR register-config table (table offset 0x98) whose word has the bit layout of the r006 register VEDU_METHR1, and 9 offsets that the Hi3520D code accesses directly (MODE 0x020, PICFG0 0x024, REGCFG_ADDR 0x1E0, QPTHR 0x350, TARGETBITS 0x364, PICBITS 0x374, MEANQP 0x388, PICINFO0 0xA20, OUTSTD 0x0A4) all sit at the r006 offsets, so the register file is assumed to follow r006 (a neighbor generation). The offset in the window is therefore an assumption, NOT seen in any vendor register access. Register name and field names are the HiSTB drv_venc_reg_r006.h names (naming only). Not accessed by register in any vendor code (it is programmed through the DDR table, loaded by the hardware from REGCFG_ADDR; whether the hardware loads this exact register from the table is the working assumption).  Source: docs/rdl-campaign/vedu-vendor.md section 13, H264E_DRV_UpdateRegConfigParam 0x1d4d0 / H264E_DRV_InitRegConfigParam 0x1db40 / H264eDrvUpdateMeCfg 0x1c680. Not verified on hardware.";

        field {
            name = "intra_thr";
            desc = "r006 field IntraThr (INFERRED, naming and position from the table word, MEDIUM)";
            sw = rw;
            hw = r;
        } intra_thr[15:0];

    } METHR1 @ 0x224;

    reg {
        name = "MERDOCFG (INFERRED, MEDIUM)";
        desc = "MERDOCFG INFERRED, confidence MEDIUM. Reason: the vendor builds a DDR register-config table (table offset 0x9C) whose word has the bit layout of the r006 register VEDU_MERDOCFG, and 9 offsets that the Hi3520D code accesses directly (MODE 0x020, PICFG0 0x024, REGCFG_ADDR 0x1E0, QPTHR 0x350, TARGETBITS 0x364, PICBITS 0x374, MEANQP 0x388, PICINFO0 0xA20, OUTSTD 0x0A4) all sit at the r006 offsets, so the register file is assumed to follow r006 (a neighbor generation). The offset in the window is therefore an assumption, NOT seen in any vendor register access. Register name and field names are the HiSTB drv_venc_reg_r006.h names (naming only). Not accessed by register in any vendor code (it is programmed through the DDR table, loaded by the hardware from REGCFG_ADDR; whether the hardware loads this exact register from the table is the working assumption).  Source: docs/rdl-campaign/vedu-vendor.md section 13, H264E_DRV_UpdateRegConfigParam 0x1d4d0 / H264E_DRV_InitRegConfigParam 0x1db40 / H264eDrvUpdateMeCfg 0x1c680. Not verified on hardware.";

        field {
            name = "lmda_off16";
            desc = "r006 field LmdaOff16 (INFERRED, naming and position from the table word, MEDIUM)";
            sw = rw;
            hw = r;
        } lmda_off16[7:0];

        field {
            name = "lmda_off16x8";
            desc = "r006 field LmdaOff16x8 (INFERRED, naming and position from the table word, MEDIUM)";
            sw = rw;
            hw = r;
        } lmda_off16x8[15:8];

        field {
            name = "lmda_off8x16";
            desc = "r006 field LmdaOff8x16 (INFERRED, naming and position from the table word, MEDIUM)";
            sw = rw;
            hw = r;
        } lmda_off8x16[23:16];

        field {
            name = "lmda_off8";
            desc = "r006 field LmdaOff8 (INFERRED, naming and position from the table word, MEDIUM)";
            sw = rw;
            hw = r;
        } lmda_off8[31:24];

    } MERDOCFG @ 0x228;

    reg {
        name = "MDCFG (INFERRED, MEDIUM)";
        desc = "MDCFG INFERRED, confidence MEDIUM. Reason: the vendor builds a DDR register-config table (table offset 0xA0) whose word has the bit layout of the r006 register VEDU_MDCFG, and 9 offsets that the Hi3520D code accesses directly (MODE 0x020, PICFG0 0x024, REGCFG_ADDR 0x1E0, QPTHR 0x350, TARGETBITS 0x364, PICBITS 0x374, MEANQP 0x388, PICINFO0 0xA20, OUTSTD 0x0A4) all sit at the r006 offsets, so the register file is assumed to follow r006 (a neighbor generation). The offset in the window is therefore an assumption, NOT seen in any vendor register access. Register name and field names are the HiSTB drv_venc_reg_r006.h names (naming only). Not accessed by register in any vendor code (it is programmed through the DDR table, loaded by the hardware from REGCFG_ADDR; whether the hardware loads this exact register from the table is the working assumption). The vendor default sets rdoEn = 1. Source: docs/rdl-campaign/vedu-vendor.md section 13, H264E_DRV_UpdateRegConfigParam 0x1d4d0 / H264E_DRV_InitRegConfigParam 0x1db40 / H264eDrvUpdateMeCfg 0x1c680. Not verified on hardware.";

        field {
            name = "md_delta";
            desc = "r006 field mdDelta (INFERRED, naming and position from the table word, MEDIUM)";
            sw = rw;
            hw = r;
        } md_delta[13:0];

        field {
            name = "rdo_en";
            desc = "r006 field rdoEn (INFERRED, naming and position from the table word, MEDIUM)";
            sw = rw;
            hw = r;
        } rdo_en[16:16];

    } MDCFG @ 0x230;

    reg {
        name = "MDCFG0 (INFERRED, MEDIUM)";
        desc = "MDCFG0 INFERRED, confidence MEDIUM. Reason: the vendor builds a DDR register-config table (table offset 0xA4) whose word has the bit layout of the r006 register VEDU_MDCFG0, and 9 offsets that the Hi3520D code accesses directly (MODE 0x020, PICFG0 0x024, REGCFG_ADDR 0x1E0, QPTHR 0x350, TARGETBITS 0x364, PICBITS 0x374, MEANQP 0x388, PICINFO0 0xA20, OUTSTD 0x0A4) all sit at the r006 offsets, so the register file is assumed to follow r006 (a neighbor generation). The offset in the window is therefore an assumption, NOT seen in any vendor register access. Register name and field names are the HiSTB drv_venc_reg_r006.h names (naming only). Not accessed by register in any vendor code (it is programmed through the DDR table, loaded by the hardware from REGCFG_ADDR; whether the hardware loads this exact register from the table is the working assumption).  Source: docs/rdl-campaign/vedu-vendor.md section 13, H264E_DRV_UpdateRegConfigParam 0x1d4d0 / H264E_DRV_InitRegConfigParam 0x1db40 / H264eDrvUpdateMeCfg 0x1c680. Not verified on hardware.";

        field {
            name = "itr8_lmd_off";
            desc = "r006 field itr8LmdOff (INFERRED, naming and position from the table word, MEDIUM)";
            sw = rw;
            hw = r;
        } itr8_lmd_off[15:0];

    } MDCFG0 @ 0x23C;

    reg {
        name = "MDCFG1 (INFERRED, MEDIUM)";
        desc = "MDCFG1 INFERRED, confidence MEDIUM. Reason: the vendor builds a DDR register-config table (table offset 0xA8) whose word has the bit layout of the r006 register VEDU_MDCFG1, and 9 offsets that the Hi3520D code accesses directly (MODE 0x020, PICFG0 0x024, REGCFG_ADDR 0x1E0, QPTHR 0x350, TARGETBITS 0x364, PICBITS 0x374, MEANQP 0x388, PICINFO0 0xA20, OUTSTD 0x0A4) all sit at the r006 offsets, so the register file is assumed to follow r006 (a neighbor generation). The offset in the window is therefore an assumption, NOT seen in any vendor register access. Register name and field names are the HiSTB drv_venc_reg_r006.h names (naming only). Not accessed by register in any vendor code (it is programmed through the DDR table, loaded by the hardware from REGCFG_ADDR; whether the hardware loads this exact register from the table is the working assumption).  Source: docs/rdl-campaign/vedu-vendor.md section 13, H264E_DRV_UpdateRegConfigParam 0x1d4d0 / H264E_DRV_InitRegConfigParam 0x1db40 / H264eDrvUpdateMeCfg 0x1c680. Not verified on hardware.";

        field {
            name = "itr4_lmd_off";
            desc = "r006 field itr4LmdOff (INFERRED, naming and position from the table word, MEDIUM)";
            sw = rw;
            hw = r;
        } itr4_lmd_off[15:0];

        field {
            name = "itr16_lmd_off";
            desc = "r006 field itr16LmdOff (INFERRED, naming and position from the table word, MEDIUM)";
            sw = rw;
            hw = r;
        } itr16_lmd_off[31:16];

    } MDCFG1 @ 0x240;

    reg {
        name = "MDCFG2 (INFERRED, MEDIUM)";
        desc = "MDCFG2 INFERRED, confidence MEDIUM. Reason: the vendor builds a DDR register-config table (table offset 0xAC) whose word has the bit layout of the r006 register VEDU_MDCFG2, and 9 offsets that the Hi3520D code accesses directly (MODE 0x020, PICFG0 0x024, REGCFG_ADDR 0x1E0, QPTHR 0x350, TARGETBITS 0x364, PICBITS 0x374, MEANQP 0x388, PICINFO0 0xA20, OUTSTD 0x0A4) all sit at the r006 offsets, so the register file is assumed to follow r006 (a neighbor generation). The offset in the window is therefore an assumption, NOT seen in any vendor register access. Register name and field names are the HiSTB drv_venc_reg_r006.h names (naming only). Not accessed by register in any vendor code (it is programmed through the DDR table, loaded by the hardware from REGCFG_ADDR; whether the hardware loads this exact register from the table is the working assumption).  Source: docs/rdl-campaign/vedu-vendor.md section 13, H264E_DRV_UpdateRegConfigParam 0x1d4d0 / H264E_DRV_InitRegConfigParam 0x1db40 / H264eDrvUpdateMeCfg 0x1c680. Not verified on hardware.";

        field {
            name = "itr16_lmd_off1";
            desc = "r006 field itr16LmdOff1 (INFERRED, naming and position from the table word, MEDIUM)";
            sw = rw;
            hw = r;
        } itr16_lmd_off1[15:0];

        field {
            name = "itr16_lmd_off2";
            desc = "r006 field itr16LmdOff2 (INFERRED, naming and position from the table word, MEDIUM)";
            sw = rw;
            hw = r;
        } itr16_lmd_off2[31:16];

    } MDCFG2 @ 0x244;

    reg {
        name = "MDCFG3 (INFERRED, MEDIUM)";
        desc = "MDCFG3 INFERRED, confidence MEDIUM. Reason: the vendor builds a DDR register-config table (table offset 0xB0) whose word has the bit layout of the r006 register VEDU_MDCFG3, and 9 offsets that the Hi3520D code accesses directly (MODE 0x020, PICFG0 0x024, REGCFG_ADDR 0x1E0, QPTHR 0x350, TARGETBITS 0x364, PICBITS 0x374, MEANQP 0x388, PICINFO0 0xA20, OUTSTD 0x0A4) all sit at the r006 offsets, so the register file is assumed to follow r006 (a neighbor generation). The offset in the window is therefore an assumption, NOT seen in any vendor register access. Register name and field names are the HiSTB drv_venc_reg_r006.h names (naming only). Not accessed by register in any vendor code (it is programmed through the DDR table, loaded by the hardware from REGCFG_ADDR; whether the hardware loads this exact register from the table is the working assumption).  Source: docs/rdl-campaign/vedu-vendor.md section 13, H264E_DRV_UpdateRegConfigParam 0x1d4d0 / H264E_DRV_InitRegConfigParam 0x1db40 / H264eDrvUpdateMeCfg 0x1c680. Not verified on hardware.";

        field {
            name = "itr16_lmd_off3";
            desc = "r006 field itr16LmdOff3 (INFERRED, naming and position from the table word, MEDIUM)";
            sw = rw;
            hw = r;
        } itr16_lmd_off3[15:0];

        field {
            name = "itr16_lmd_off4";
            desc = "r006 field itr16LmdOff4 (INFERRED, naming and position from the table word, MEDIUM)";
            sw = rw;
            hw = r;
        } itr16_lmd_off4[31:16];

    } MDCFG3 @ 0x248;

    reg {
        name = "MDCFG4 (INFERRED, MEDIUM)";
        desc = "MDCFG4 INFERRED, confidence MEDIUM. Reason: the vendor builds a DDR register-config table (table offset 0xB4) whose word has the bit layout of the r006 register VEDU_MDCFG4, and 9 offsets that the Hi3520D code accesses directly (MODE 0x020, PICFG0 0x024, REGCFG_ADDR 0x1E0, QPTHR 0x350, TARGETBITS 0x364, PICBITS 0x374, MEANQP 0x388, PICINFO0 0xA20, OUTSTD 0x0A4) all sit at the r006 offsets, so the register file is assumed to follow r006 (a neighbor generation). The offset in the window is therefore an assumption, NOT seen in any vendor register access. Register name and field names are the HiSTB drv_venc_reg_r006.h names (naming only). Not accessed by register in any vendor code (it is programmed through the DDR table, loaded by the hardware from REGCFG_ADDR; whether the hardware loads this exact register from the table is the working assumption).  Source: docs/rdl-campaign/vedu-vendor.md section 13, H264E_DRV_UpdateRegConfigParam 0x1d4d0 / H264E_DRV_InitRegConfigParam 0x1db40 / H264eDrvUpdateMeCfg 0x1c680. Not verified on hardware.";

        field {
            name = "itr16_lmd_off5";
            desc = "r006 field itr16LmdOff5 (INFERRED, naming and position from the table word, MEDIUM)";
            sw = rw;
            hw = r;
        } itr16_lmd_off5[15:0];

        field {
            name = "itr16_lmd_off6";
            desc = "r006 field itr16LmdOff6 (INFERRED, naming and position from the table word, MEDIUM)";
            sw = rw;
            hw = r;
        } itr16_lmd_off6[31:16];

    } MDCFG4 @ 0x24C;

    reg {
        name = "MDCFG5 (INFERRED, MEDIUM)";
        desc = "MDCFG5 INFERRED, confidence MEDIUM. Reason: the vendor builds a DDR register-config table (table offset 0xB8) whose word has the bit layout of the r006 register VEDU_MDCFG5, and 9 offsets that the Hi3520D code accesses directly (MODE 0x020, PICFG0 0x024, REGCFG_ADDR 0x1E0, QPTHR 0x350, TARGETBITS 0x364, PICBITS 0x374, MEANQP 0x388, PICINFO0 0xA20, OUTSTD 0x0A4) all sit at the r006 offsets, so the register file is assumed to follow r006 (a neighbor generation). The offset in the window is therefore an assumption, NOT seen in any vendor register access. Register name and field names are the HiSTB drv_venc_reg_r006.h names (naming only). Not accessed by register in any vendor code (it is programmed through the DDR table, loaded by the hardware from REGCFG_ADDR; whether the hardware loads this exact register from the table is the working assumption).  Source: docs/rdl-campaign/vedu-vendor.md section 13, H264E_DRV_UpdateRegConfigParam 0x1d4d0 / H264E_DRV_InitRegConfigParam 0x1db40 / H264eDrvUpdateMeCfg 0x1c680. Not verified on hardware.";

        field {
            name = "md_still_thr1";
            desc = "r006 field mdStillThr1 (INFERRED, naming and position from the table word, MEDIUM)";
            sw = rw;
            hw = r;
        } md_still_thr1[15:0];

        field {
            name = "md_still_thr2";
            desc = "r006 field mdStillThr2 (INFERRED, naming and position from the table word, MEDIUM)";
            sw = rw;
            hw = r;
        } md_still_thr2[31:16];

    } MDCFG5 @ 0x250;

    reg {
        name = "MDCFG6 (INFERRED, MEDIUM)";
        desc = "MDCFG6 INFERRED, confidence MEDIUM. Reason: the vendor builds a DDR register-config table (table offset 0xBC) whose word has the bit layout of the r006 register VEDU_MDCFG6, and 9 offsets that the Hi3520D code accesses directly (MODE 0x020, PICFG0 0x024, REGCFG_ADDR 0x1E0, QPTHR 0x350, TARGETBITS 0x364, PICBITS 0x374, MEANQP 0x388, PICINFO0 0xA20, OUTSTD 0x0A4) all sit at the r006 offsets, so the register file is assumed to follow r006 (a neighbor generation). The offset in the window is therefore an assumption, NOT seen in any vendor register access. Register name and field names are the HiSTB drv_venc_reg_r006.h names (naming only). Not accessed by register in any vendor code (it is programmed through the DDR table, loaded by the hardware from REGCFG_ADDR; whether the hardware loads this exact register from the table is the working assumption).  Source: docs/rdl-campaign/vedu-vendor.md section 13, H264E_DRV_UpdateRegConfigParam 0x1d4d0 / H264E_DRV_InitRegConfigParam 0x1db40 / H264eDrvUpdateMeCfg 0x1c680. Not verified on hardware.";

        field {
            name = "md_madi_thr1";
            desc = "r006 field mdMadiThr1 (INFERRED, naming and position from the table word, MEDIUM)";
            sw = rw;
            hw = r;
        } md_madi_thr1[15:0];

        field {
            name = "md_madi_thr2";
            desc = "r006 field mdMadiThr2 (INFERRED, naming and position from the table word, MEDIUM)";
            sw = rw;
            hw = r;
        } md_madi_thr2[31:16];

    } MDCFG6 @ 0x254;

    reg {
        name = "ROICFG (INFERRED, HIGH)";
        desc = "ROICFG INFERRED, confidence HIGH. Reason: the vendor builds a DDR register-config table (table offset 0x70) whose word has the bit layout of the r006 register VEDU_ROICFG, and 9 offsets that the Hi3520D code accesses directly (MODE 0x020, PICFG0 0x024, REGCFG_ADDR 0x1E0, QPTHR 0x350, TARGETBITS 0x364, PICBITS 0x374, MEANQP 0x388, PICINFO0 0xA20, OUTSTD 0x0A4) all sit at the r006 offsets, so the register file is assumed to follow r006 (a neighbor generation). The offset in the window is therefore an assumption, NOT seen in any vendor register access. Register name and field names are the HiSTB drv_venc_reg_r006.h names (naming only). Not accessed by register in any vendor code (it is programmed through the DDR table, loaded by the hardware from REGCFG_ADDR; whether the hardware loads this exact register from the table is the working assumption).  Source: docs/rdl-campaign/vedu-vendor.md section 13, H264E_DRV_UpdateRegConfigParam 0x1d4d0 / H264E_DRV_InitRegConfigParam 0x1db40 / H264eDrvUpdateMeCfg 0x1c680. Not verified on hardware.";

        field {
            name = "region0_en";
            desc = "r006 field region0En (INFERRED, naming and position from the table word, HIGH)";
            sw = rw;
            hw = r;
        } region0_en[0:0];

        field {
            name = "region1_en";
            desc = "r006 field region1En (INFERRED, naming and position from the table word, HIGH)";
            sw = rw;
            hw = r;
        } region1_en[1:1];

        field {
            name = "region2_en";
            desc = "r006 field region2En (INFERRED, naming and position from the table word, HIGH)";
            sw = rw;
            hw = r;
        } region2_en[2:2];

        field {
            name = "region3_en";
            desc = "r006 field region3En (INFERRED, naming and position from the table word, HIGH)";
            sw = rw;
            hw = r;
        } region3_en[3:3];

        field {
            name = "region4_en";
            desc = "r006 field region4En (INFERRED, naming and position from the table word, HIGH)";
            sw = rw;
            hw = r;
        } region4_en[4:4];

        field {
            name = "region5_en";
            desc = "r006 field region5En (INFERRED, naming and position from the table word, HIGH)";
            sw = rw;
            hw = r;
        } region5_en[5:5];

        field {
            name = "region6_en";
            desc = "r006 field region6En (INFERRED, naming and position from the table word, HIGH)";
            sw = rw;
            hw = r;
        } region6_en[6:6];

        field {
            name = "region7_en";
            desc = "r006 field region7En (INFERRED, naming and position from the table word, HIGH)";
            sw = rw;
            hw = r;
        } region7_en[7:7];

        field {
            name = "b_abs_qp0";
            desc = "r006 field bAbsQp0 (INFERRED, naming and position from the table word, HIGH)";
            sw = rw;
            hw = r;
        } b_abs_qp0[8:8];

        field {
            name = "b_abs_qp1";
            desc = "r006 field bAbsQp1 (INFERRED, naming and position from the table word, HIGH)";
            sw = rw;
            hw = r;
        } b_abs_qp1[9:9];

        field {
            name = "b_abs_qp2";
            desc = "r006 field bAbsQp2 (INFERRED, naming and position from the table word, HIGH)";
            sw = rw;
            hw = r;
        } b_abs_qp2[10:10];

        field {
            name = "b_abs_qp3";
            desc = "r006 field bAbsQp3 (INFERRED, naming and position from the table word, HIGH)";
            sw = rw;
            hw = r;
        } b_abs_qp3[11:11];

        field {
            name = "b_abs_qp4";
            desc = "r006 field bAbsQp4 (INFERRED, naming and position from the table word, HIGH)";
            sw = rw;
            hw = r;
        } b_abs_qp4[12:12];

        field {
            name = "b_abs_qp5";
            desc = "r006 field bAbsQp5 (INFERRED, naming and position from the table word, HIGH)";
            sw = rw;
            hw = r;
        } b_abs_qp5[13:13];

        field {
            name = "b_abs_qp6";
            desc = "r006 field bAbsQp6 (INFERRED, naming and position from the table word, HIGH)";
            sw = rw;
            hw = r;
        } b_abs_qp6[14:14];

        field {
            name = "b_abs_qp7";
            desc = "r006 field bAbsQp7 (INFERRED, naming and position from the table word, HIGH)";
            sw = rw;
            hw = r;
        } b_abs_qp7[15:15];

    } ROICFG @ 0x300;

    reg {
        name = "ROIQP0 (INFERRED, HIGH)";
        desc = "ROIQP0 INFERRED, confidence HIGH. Reason: the vendor builds a DDR register-config table (table offset 0x74) whose word has the bit layout of the r006 register VEDU_ROIQP0, and 9 offsets that the Hi3520D code accesses directly (MODE 0x020, PICFG0 0x024, REGCFG_ADDR 0x1E0, QPTHR 0x350, TARGETBITS 0x364, PICBITS 0x374, MEANQP 0x388, PICINFO0 0xA20, OUTSTD 0x0A4) all sit at the r006 offsets, so the register file is assumed to follow r006 (a neighbor generation). The offset in the window is therefore an assumption, NOT seen in any vendor register access. Register name and field names are the HiSTB drv_venc_reg_r006.h names (naming only). Not accessed by register in any vendor code (it is programmed through the DDR table, loaded by the hardware from REGCFG_ADDR; whether the hardware loads this exact register from the table is the working assumption).  Source: docs/rdl-campaign/vedu-vendor.md section 13, H264E_DRV_UpdateRegConfigParam 0x1d4d0 / H264E_DRV_InitRegConfigParam 0x1db40 / H264eDrvUpdateMeCfg 0x1c680. Not verified on hardware.";

        field {
            name = "roiqp0";
            desc = "r006 field ROIQp0 (INFERRED, naming and position from the table word, HIGH)";
            sw = rw;
            hw = r;
        } roiqp0[6:0];

        field {
            name = "roiqp1";
            desc = "r006 field ROIQp1 (INFERRED, naming and position from the table word, HIGH)";
            sw = rw;
            hw = r;
        } roiqp1[13:7];

        field {
            name = "roiqp2";
            desc = "r006 field ROIQp2 (INFERRED, naming and position from the table word, HIGH)";
            sw = rw;
            hw = r;
        } roiqp2[20:14];

        field {
            name = "roiqp3";
            desc = "r006 field ROIQp3 (INFERRED, naming and position from the table word, HIGH)";
            sw = rw;
            hw = r;
        } roiqp3[27:21];

    } ROIQP0 @ 0x304;

    reg {
        name = "ROIQP1 (INFERRED, HIGH)";
        desc = "ROIQP1 INFERRED, confidence HIGH. Reason: the vendor builds a DDR register-config table (table offset 0x78) whose word has the bit layout of the r006 register VEDU_ROIQP1, and 9 offsets that the Hi3520D code accesses directly (MODE 0x020, PICFG0 0x024, REGCFG_ADDR 0x1E0, QPTHR 0x350, TARGETBITS 0x364, PICBITS 0x374, MEANQP 0x388, PICINFO0 0xA20, OUTSTD 0x0A4) all sit at the r006 offsets, so the register file is assumed to follow r006 (a neighbor generation). The offset in the window is therefore an assumption, NOT seen in any vendor register access. Register name and field names are the HiSTB drv_venc_reg_r006.h names (naming only). Not accessed by register in any vendor code (it is programmed through the DDR table, loaded by the hardware from REGCFG_ADDR; whether the hardware loads this exact register from the table is the working assumption).  Source: docs/rdl-campaign/vedu-vendor.md section 13, H264E_DRV_UpdateRegConfigParam 0x1d4d0 / H264E_DRV_InitRegConfigParam 0x1db40 / H264eDrvUpdateMeCfg 0x1c680. Not verified on hardware.";

        field {
            name = "roiqp4";
            desc = "r006 field ROIQp4 (INFERRED, naming and position from the table word, HIGH)";
            sw = rw;
            hw = r;
        } roiqp4[6:0];

        field {
            name = "roiqp5";
            desc = "r006 field ROIQp5 (INFERRED, naming and position from the table word, HIGH)";
            sw = rw;
            hw = r;
        } roiqp5[13:7];

        field {
            name = "roiqp6";
            desc = "r006 field ROIQp6 (INFERRED, naming and position from the table word, HIGH)";
            sw = rw;
            hw = r;
        } roiqp6[20:14];

        field {
            name = "roiqp7";
            desc = "r006 field ROIQp7 (INFERRED, naming and position from the table word, HIGH)";
            sw = rw;
            hw = r;
        } roiqp7[27:21];

    } ROIQP1 @ 0x308;

    reg {
        name = "ROISIZE0 (INFERRED, HIGH)";
        desc = "ROISIZE INFERRED, confidence HIGH. Reason: the vendor builds a DDR register-config table (table offset 0xC0) whose word has the bit layout of the r006 register VEDU_ROISIZE, and 9 offsets that the Hi3520D code accesses directly (MODE 0x020, PICFG0 0x024, REGCFG_ADDR 0x1E0, QPTHR 0x350, TARGETBITS 0x364, PICBITS 0x374, MEANQP 0x388, PICINFO0 0xA20, OUTSTD 0x0A4) all sit at the r006 offsets, so the register file is assumed to follow r006 (a neighbor generation). The offset in the window is therefore an assumption, NOT seen in any vendor register access. Register name and field names are the HiSTB drv_venc_reg_r006.h names (naming only). Not accessed by register in any vendor code (it is programmed through the DDR table, loaded by the hardware from REGCFG_ADDR; whether the hardware loads this exact register from the table is the working assumption). Region 0, width and height in 16 x 16 macroblock units (vendor: pixels >> 4). Source: docs/rdl-campaign/vedu-vendor.md section 13, H264E_DRV_UpdateRegConfigParam 0x1d4d0 / H264E_DRV_InitRegConfigParam 0x1db40 / H264eDrvUpdateMeCfg 0x1c680. Not verified on hardware.";

        field {
            name = "roiwidth";
            desc = "r006 field ROIWidth (INFERRED, naming and position from the table word, HIGH)";
            sw = rw;
            hw = r;
        } roiwidth[9:0];

        field {
            name = "roiheight";
            desc = "r006 field ROIHeight (INFERRED, naming and position from the table word, HIGH)";
            sw = rw;
            hw = r;
        } roiheight[19:10];

    } ROISIZE0 @ 0x30C;

    reg {
        name = "ROISIZE1 (INFERRED, HIGH)";
        desc = "ROISIZE INFERRED, confidence HIGH. Reason: the vendor builds a DDR register-config table (table offset 0xC4) whose word has the bit layout of the r006 register VEDU_ROISIZE, and 9 offsets that the Hi3520D code accesses directly (MODE 0x020, PICFG0 0x024, REGCFG_ADDR 0x1E0, QPTHR 0x350, TARGETBITS 0x364, PICBITS 0x374, MEANQP 0x388, PICINFO0 0xA20, OUTSTD 0x0A4) all sit at the r006 offsets, so the register file is assumed to follow r006 (a neighbor generation). The offset in the window is therefore an assumption, NOT seen in any vendor register access. Register name and field names are the HiSTB drv_venc_reg_r006.h names (naming only). Not accessed by register in any vendor code (it is programmed through the DDR table, loaded by the hardware from REGCFG_ADDR; whether the hardware loads this exact register from the table is the working assumption). Region 1, width and height in 16 x 16 macroblock units (vendor: pixels >> 4). Source: docs/rdl-campaign/vedu-vendor.md section 13, H264E_DRV_UpdateRegConfigParam 0x1d4d0 / H264E_DRV_InitRegConfigParam 0x1db40 / H264eDrvUpdateMeCfg 0x1c680. Not verified on hardware.";

        field {
            name = "roiwidth";
            desc = "r006 field ROIWidth (INFERRED, naming and position from the table word, HIGH)";
            sw = rw;
            hw = r;
        } roiwidth[9:0];

        field {
            name = "roiheight";
            desc = "r006 field ROIHeight (INFERRED, naming and position from the table word, HIGH)";
            sw = rw;
            hw = r;
        } roiheight[19:10];

    } ROISIZE1 @ 0x310;

    reg {
        name = "ROISIZE2 (INFERRED, HIGH)";
        desc = "ROISIZE INFERRED, confidence HIGH. Reason: the vendor builds a DDR register-config table (table offset 0xC8) whose word has the bit layout of the r006 register VEDU_ROISIZE, and 9 offsets that the Hi3520D code accesses directly (MODE 0x020, PICFG0 0x024, REGCFG_ADDR 0x1E0, QPTHR 0x350, TARGETBITS 0x364, PICBITS 0x374, MEANQP 0x388, PICINFO0 0xA20, OUTSTD 0x0A4) all sit at the r006 offsets, so the register file is assumed to follow r006 (a neighbor generation). The offset in the window is therefore an assumption, NOT seen in any vendor register access. Register name and field names are the HiSTB drv_venc_reg_r006.h names (naming only). Not accessed by register in any vendor code (it is programmed through the DDR table, loaded by the hardware from REGCFG_ADDR; whether the hardware loads this exact register from the table is the working assumption). Region 2, width and height in 16 x 16 macroblock units (vendor: pixels >> 4). Source: docs/rdl-campaign/vedu-vendor.md section 13, H264E_DRV_UpdateRegConfigParam 0x1d4d0 / H264E_DRV_InitRegConfigParam 0x1db40 / H264eDrvUpdateMeCfg 0x1c680. Not verified on hardware.";

        field {
            name = "roiwidth";
            desc = "r006 field ROIWidth (INFERRED, naming and position from the table word, HIGH)";
            sw = rw;
            hw = r;
        } roiwidth[9:0];

        field {
            name = "roiheight";
            desc = "r006 field ROIHeight (INFERRED, naming and position from the table word, HIGH)";
            sw = rw;
            hw = r;
        } roiheight[19:10];

    } ROISIZE2 @ 0x314;

    reg {
        name = "ROISIZE3 (INFERRED, HIGH)";
        desc = "ROISIZE INFERRED, confidence HIGH. Reason: the vendor builds a DDR register-config table (table offset 0xCC) whose word has the bit layout of the r006 register VEDU_ROISIZE, and 9 offsets that the Hi3520D code accesses directly (MODE 0x020, PICFG0 0x024, REGCFG_ADDR 0x1E0, QPTHR 0x350, TARGETBITS 0x364, PICBITS 0x374, MEANQP 0x388, PICINFO0 0xA20, OUTSTD 0x0A4) all sit at the r006 offsets, so the register file is assumed to follow r006 (a neighbor generation). The offset in the window is therefore an assumption, NOT seen in any vendor register access. Register name and field names are the HiSTB drv_venc_reg_r006.h names (naming only). Not accessed by register in any vendor code (it is programmed through the DDR table, loaded by the hardware from REGCFG_ADDR; whether the hardware loads this exact register from the table is the working assumption). Region 3, width and height in 16 x 16 macroblock units (vendor: pixels >> 4). Source: docs/rdl-campaign/vedu-vendor.md section 13, H264E_DRV_UpdateRegConfigParam 0x1d4d0 / H264E_DRV_InitRegConfigParam 0x1db40 / H264eDrvUpdateMeCfg 0x1c680. Not verified on hardware.";

        field {
            name = "roiwidth";
            desc = "r006 field ROIWidth (INFERRED, naming and position from the table word, HIGH)";
            sw = rw;
            hw = r;
        } roiwidth[9:0];

        field {
            name = "roiheight";
            desc = "r006 field ROIHeight (INFERRED, naming and position from the table word, HIGH)";
            sw = rw;
            hw = r;
        } roiheight[19:10];

    } ROISIZE3 @ 0x318;

    reg {
        name = "ROISIZE4 (INFERRED, HIGH)";
        desc = "ROISIZE INFERRED, confidence HIGH. Reason: the vendor builds a DDR register-config table (table offset 0xD0) whose word has the bit layout of the r006 register VEDU_ROISIZE, and 9 offsets that the Hi3520D code accesses directly (MODE 0x020, PICFG0 0x024, REGCFG_ADDR 0x1E0, QPTHR 0x350, TARGETBITS 0x364, PICBITS 0x374, MEANQP 0x388, PICINFO0 0xA20, OUTSTD 0x0A4) all sit at the r006 offsets, so the register file is assumed to follow r006 (a neighbor generation). The offset in the window is therefore an assumption, NOT seen in any vendor register access. Register name and field names are the HiSTB drv_venc_reg_r006.h names (naming only). Not accessed by register in any vendor code (it is programmed through the DDR table, loaded by the hardware from REGCFG_ADDR; whether the hardware loads this exact register from the table is the working assumption). Region 4, width and height in 16 x 16 macroblock units (vendor: pixels >> 4). Source: docs/rdl-campaign/vedu-vendor.md section 13, H264E_DRV_UpdateRegConfigParam 0x1d4d0 / H264E_DRV_InitRegConfigParam 0x1db40 / H264eDrvUpdateMeCfg 0x1c680. Not verified on hardware.";

        field {
            name = "roiwidth";
            desc = "r006 field ROIWidth (INFERRED, naming and position from the table word, HIGH)";
            sw = rw;
            hw = r;
        } roiwidth[9:0];

        field {
            name = "roiheight";
            desc = "r006 field ROIHeight (INFERRED, naming and position from the table word, HIGH)";
            sw = rw;
            hw = r;
        } roiheight[19:10];

    } ROISIZE4 @ 0x31C;

    reg {
        name = "ROISIZE5 (INFERRED, HIGH)";
        desc = "ROISIZE INFERRED, confidence HIGH. Reason: the vendor builds a DDR register-config table (table offset 0xD4) whose word has the bit layout of the r006 register VEDU_ROISIZE, and 9 offsets that the Hi3520D code accesses directly (MODE 0x020, PICFG0 0x024, REGCFG_ADDR 0x1E0, QPTHR 0x350, TARGETBITS 0x364, PICBITS 0x374, MEANQP 0x388, PICINFO0 0xA20, OUTSTD 0x0A4) all sit at the r006 offsets, so the register file is assumed to follow r006 (a neighbor generation). The offset in the window is therefore an assumption, NOT seen in any vendor register access. Register name and field names are the HiSTB drv_venc_reg_r006.h names (naming only). Not accessed by register in any vendor code (it is programmed through the DDR table, loaded by the hardware from REGCFG_ADDR; whether the hardware loads this exact register from the table is the working assumption). Region 5, width and height in 16 x 16 macroblock units (vendor: pixels >> 4). Source: docs/rdl-campaign/vedu-vendor.md section 13, H264E_DRV_UpdateRegConfigParam 0x1d4d0 / H264E_DRV_InitRegConfigParam 0x1db40 / H264eDrvUpdateMeCfg 0x1c680. Not verified on hardware.";

        field {
            name = "roiwidth";
            desc = "r006 field ROIWidth (INFERRED, naming and position from the table word, HIGH)";
            sw = rw;
            hw = r;
        } roiwidth[9:0];

        field {
            name = "roiheight";
            desc = "r006 field ROIHeight (INFERRED, naming and position from the table word, HIGH)";
            sw = rw;
            hw = r;
        } roiheight[19:10];

    } ROISIZE5 @ 0x320;

    reg {
        name = "ROISIZE6 (INFERRED, HIGH)";
        desc = "ROISIZE INFERRED, confidence HIGH. Reason: the vendor builds a DDR register-config table (table offset 0xD8) whose word has the bit layout of the r006 register VEDU_ROISIZE, and 9 offsets that the Hi3520D code accesses directly (MODE 0x020, PICFG0 0x024, REGCFG_ADDR 0x1E0, QPTHR 0x350, TARGETBITS 0x364, PICBITS 0x374, MEANQP 0x388, PICINFO0 0xA20, OUTSTD 0x0A4) all sit at the r006 offsets, so the register file is assumed to follow r006 (a neighbor generation). The offset in the window is therefore an assumption, NOT seen in any vendor register access. Register name and field names are the HiSTB drv_venc_reg_r006.h names (naming only). Not accessed by register in any vendor code (it is programmed through the DDR table, loaded by the hardware from REGCFG_ADDR; whether the hardware loads this exact register from the table is the working assumption). Region 6, width and height in 16 x 16 macroblock units (vendor: pixels >> 4). Source: docs/rdl-campaign/vedu-vendor.md section 13, H264E_DRV_UpdateRegConfigParam 0x1d4d0 / H264E_DRV_InitRegConfigParam 0x1db40 / H264eDrvUpdateMeCfg 0x1c680. Not verified on hardware.";

        field {
            name = "roiwidth";
            desc = "r006 field ROIWidth (INFERRED, naming and position from the table word, HIGH)";
            sw = rw;
            hw = r;
        } roiwidth[9:0];

        field {
            name = "roiheight";
            desc = "r006 field ROIHeight (INFERRED, naming and position from the table word, HIGH)";
            sw = rw;
            hw = r;
        } roiheight[19:10];

    } ROISIZE6 @ 0x324;

    reg {
        name = "ROISIZE7 (INFERRED, HIGH)";
        desc = "ROISIZE INFERRED, confidence HIGH. Reason: the vendor builds a DDR register-config table (table offset 0xDC) whose word has the bit layout of the r006 register VEDU_ROISIZE, and 9 offsets that the Hi3520D code accesses directly (MODE 0x020, PICFG0 0x024, REGCFG_ADDR 0x1E0, QPTHR 0x350, TARGETBITS 0x364, PICBITS 0x374, MEANQP 0x388, PICINFO0 0xA20, OUTSTD 0x0A4) all sit at the r006 offsets, so the register file is assumed to follow r006 (a neighbor generation). The offset in the window is therefore an assumption, NOT seen in any vendor register access. Register name and field names are the HiSTB drv_venc_reg_r006.h names (naming only). Not accessed by register in any vendor code (it is programmed through the DDR table, loaded by the hardware from REGCFG_ADDR; whether the hardware loads this exact register from the table is the working assumption). Region 7, width and height in 16 x 16 macroblock units (vendor: pixels >> 4). Source: docs/rdl-campaign/vedu-vendor.md section 13, H264E_DRV_UpdateRegConfigParam 0x1d4d0 / H264E_DRV_InitRegConfigParam 0x1db40 / H264eDrvUpdateMeCfg 0x1c680. Not verified on hardware.";

        field {
            name = "roiwidth";
            desc = "r006 field ROIWidth (INFERRED, naming and position from the table word, HIGH)";
            sw = rw;
            hw = r;
        } roiwidth[9:0];

        field {
            name = "roiheight";
            desc = "r006 field ROIHeight (INFERRED, naming and position from the table word, HIGH)";
            sw = rw;
            hw = r;
        } roiheight[19:10];

    } ROISIZE7 @ 0x328;

    reg {
        name = "ROIPOS0 (INFERRED, HIGH)";
        desc = "ROIPOS INFERRED, confidence HIGH. Reason: the vendor builds a DDR register-config table (table offset 0xE0) whose word has the bit layout of the r006 register VEDU_ROIPOS, and 9 offsets that the Hi3520D code accesses directly (MODE 0x020, PICFG0 0x024, REGCFG_ADDR 0x1E0, QPTHR 0x350, TARGETBITS 0x364, PICBITS 0x374, MEANQP 0x388, PICINFO0 0xA20, OUTSTD 0x0A4) all sit at the r006 offsets, so the register file is assumed to follow r006 (a neighbor generation). The offset in the window is therefore an assumption, NOT seen in any vendor register access. Register name and field names are the HiSTB drv_venc_reg_r006.h names (naming only). Not accessed by register in any vendor code (it is programmed through the DDR table, loaded by the hardware from REGCFG_ADDR; whether the hardware loads this exact register from the table is the working assumption). Region 0, start position in macroblock units (vendor: pixels >> 4). Source: docs/rdl-campaign/vedu-vendor.md section 13, H264E_DRV_UpdateRegConfigParam 0x1d4d0 / H264E_DRV_InitRegConfigParam 0x1db40 / H264eDrvUpdateMeCfg 0x1c680. Not verified on hardware.";

        field {
            name = "roistart_x";
            desc = "r006 field ROIstartX (INFERRED, naming and position from the table word, HIGH)";
            sw = rw;
            hw = r;
        } roistart_x[8:0];

        field {
            name = "roistart_y";
            desc = "r006 field ROIstartY (INFERRED, naming and position from the table word, HIGH)";
            sw = rw;
            hw = r;
        } roistart_y[17:9];

    } ROIPOS0 @ 0x32C;

    reg {
        name = "ROIPOS1 (INFERRED, HIGH)";
        desc = "ROIPOS INFERRED, confidence HIGH. Reason: the vendor builds a DDR register-config table (table offset 0xE4) whose word has the bit layout of the r006 register VEDU_ROIPOS, and 9 offsets that the Hi3520D code accesses directly (MODE 0x020, PICFG0 0x024, REGCFG_ADDR 0x1E0, QPTHR 0x350, TARGETBITS 0x364, PICBITS 0x374, MEANQP 0x388, PICINFO0 0xA20, OUTSTD 0x0A4) all sit at the r006 offsets, so the register file is assumed to follow r006 (a neighbor generation). The offset in the window is therefore an assumption, NOT seen in any vendor register access. Register name and field names are the HiSTB drv_venc_reg_r006.h names (naming only). Not accessed by register in any vendor code (it is programmed through the DDR table, loaded by the hardware from REGCFG_ADDR; whether the hardware loads this exact register from the table is the working assumption). Region 1, start position in macroblock units (vendor: pixels >> 4). Source: docs/rdl-campaign/vedu-vendor.md section 13, H264E_DRV_UpdateRegConfigParam 0x1d4d0 / H264E_DRV_InitRegConfigParam 0x1db40 / H264eDrvUpdateMeCfg 0x1c680. Not verified on hardware.";

        field {
            name = "roistart_x";
            desc = "r006 field ROIstartX (INFERRED, naming and position from the table word, HIGH)";
            sw = rw;
            hw = r;
        } roistart_x[8:0];

        field {
            name = "roistart_y";
            desc = "r006 field ROIstartY (INFERRED, naming and position from the table word, HIGH)";
            sw = rw;
            hw = r;
        } roistart_y[17:9];

    } ROIPOS1 @ 0x330;

    reg {
        name = "ROIPOS2 (INFERRED, HIGH)";
        desc = "ROIPOS INFERRED, confidence HIGH. Reason: the vendor builds a DDR register-config table (table offset 0xE8) whose word has the bit layout of the r006 register VEDU_ROIPOS, and 9 offsets that the Hi3520D code accesses directly (MODE 0x020, PICFG0 0x024, REGCFG_ADDR 0x1E0, QPTHR 0x350, TARGETBITS 0x364, PICBITS 0x374, MEANQP 0x388, PICINFO0 0xA20, OUTSTD 0x0A4) all sit at the r006 offsets, so the register file is assumed to follow r006 (a neighbor generation). The offset in the window is therefore an assumption, NOT seen in any vendor register access. Register name and field names are the HiSTB drv_venc_reg_r006.h names (naming only). Not accessed by register in any vendor code (it is programmed through the DDR table, loaded by the hardware from REGCFG_ADDR; whether the hardware loads this exact register from the table is the working assumption). Region 2, start position in macroblock units (vendor: pixels >> 4). Source: docs/rdl-campaign/vedu-vendor.md section 13, H264E_DRV_UpdateRegConfigParam 0x1d4d0 / H264E_DRV_InitRegConfigParam 0x1db40 / H264eDrvUpdateMeCfg 0x1c680. Not verified on hardware.";

        field {
            name = "roistart_x";
            desc = "r006 field ROIstartX (INFERRED, naming and position from the table word, HIGH)";
            sw = rw;
            hw = r;
        } roistart_x[8:0];

        field {
            name = "roistart_y";
            desc = "r006 field ROIstartY (INFERRED, naming and position from the table word, HIGH)";
            sw = rw;
            hw = r;
        } roistart_y[17:9];

    } ROIPOS2 @ 0x334;

    reg {
        name = "ROIPOS3 (INFERRED, HIGH)";
        desc = "ROIPOS INFERRED, confidence HIGH. Reason: the vendor builds a DDR register-config table (table offset 0xEC) whose word has the bit layout of the r006 register VEDU_ROIPOS, and 9 offsets that the Hi3520D code accesses directly (MODE 0x020, PICFG0 0x024, REGCFG_ADDR 0x1E0, QPTHR 0x350, TARGETBITS 0x364, PICBITS 0x374, MEANQP 0x388, PICINFO0 0xA20, OUTSTD 0x0A4) all sit at the r006 offsets, so the register file is assumed to follow r006 (a neighbor generation). The offset in the window is therefore an assumption, NOT seen in any vendor register access. Register name and field names are the HiSTB drv_venc_reg_r006.h names (naming only). Not accessed by register in any vendor code (it is programmed through the DDR table, loaded by the hardware from REGCFG_ADDR; whether the hardware loads this exact register from the table is the working assumption). Region 3, start position in macroblock units (vendor: pixels >> 4). Source: docs/rdl-campaign/vedu-vendor.md section 13, H264E_DRV_UpdateRegConfigParam 0x1d4d0 / H264E_DRV_InitRegConfigParam 0x1db40 / H264eDrvUpdateMeCfg 0x1c680. Not verified on hardware.";

        field {
            name = "roistart_x";
            desc = "r006 field ROIstartX (INFERRED, naming and position from the table word, HIGH)";
            sw = rw;
            hw = r;
        } roistart_x[8:0];

        field {
            name = "roistart_y";
            desc = "r006 field ROIstartY (INFERRED, naming and position from the table word, HIGH)";
            sw = rw;
            hw = r;
        } roistart_y[17:9];

    } ROIPOS3 @ 0x338;

    reg {
        name = "ROIPOS4 (INFERRED, HIGH)";
        desc = "ROIPOS INFERRED, confidence HIGH. Reason: the vendor builds a DDR register-config table (table offset 0xF0) whose word has the bit layout of the r006 register VEDU_ROIPOS, and 9 offsets that the Hi3520D code accesses directly (MODE 0x020, PICFG0 0x024, REGCFG_ADDR 0x1E0, QPTHR 0x350, TARGETBITS 0x364, PICBITS 0x374, MEANQP 0x388, PICINFO0 0xA20, OUTSTD 0x0A4) all sit at the r006 offsets, so the register file is assumed to follow r006 (a neighbor generation). The offset in the window is therefore an assumption, NOT seen in any vendor register access. Register name and field names are the HiSTB drv_venc_reg_r006.h names (naming only). Not accessed by register in any vendor code (it is programmed through the DDR table, loaded by the hardware from REGCFG_ADDR; whether the hardware loads this exact register from the table is the working assumption). Region 4, start position in macroblock units (vendor: pixels >> 4). Source: docs/rdl-campaign/vedu-vendor.md section 13, H264E_DRV_UpdateRegConfigParam 0x1d4d0 / H264E_DRV_InitRegConfigParam 0x1db40 / H264eDrvUpdateMeCfg 0x1c680. Not verified on hardware.";

        field {
            name = "roistart_x";
            desc = "r006 field ROIstartX (INFERRED, naming and position from the table word, HIGH)";
            sw = rw;
            hw = r;
        } roistart_x[8:0];

        field {
            name = "roistart_y";
            desc = "r006 field ROIstartY (INFERRED, naming and position from the table word, HIGH)";
            sw = rw;
            hw = r;
        } roistart_y[17:9];

    } ROIPOS4 @ 0x33C;

    reg {
        name = "ROIPOS5 (INFERRED, HIGH)";
        desc = "ROIPOS INFERRED, confidence HIGH. Reason: the vendor builds a DDR register-config table (table offset 0xF4) whose word has the bit layout of the r006 register VEDU_ROIPOS, and 9 offsets that the Hi3520D code accesses directly (MODE 0x020, PICFG0 0x024, REGCFG_ADDR 0x1E0, QPTHR 0x350, TARGETBITS 0x364, PICBITS 0x374, MEANQP 0x388, PICINFO0 0xA20, OUTSTD 0x0A4) all sit at the r006 offsets, so the register file is assumed to follow r006 (a neighbor generation). The offset in the window is therefore an assumption, NOT seen in any vendor register access. Register name and field names are the HiSTB drv_venc_reg_r006.h names (naming only). Not accessed by register in any vendor code (it is programmed through the DDR table, loaded by the hardware from REGCFG_ADDR; whether the hardware loads this exact register from the table is the working assumption). Region 5, start position in macroblock units (vendor: pixels >> 4). Source: docs/rdl-campaign/vedu-vendor.md section 13, H264E_DRV_UpdateRegConfigParam 0x1d4d0 / H264E_DRV_InitRegConfigParam 0x1db40 / H264eDrvUpdateMeCfg 0x1c680. Not verified on hardware.";

        field {
            name = "roistart_x";
            desc = "r006 field ROIstartX (INFERRED, naming and position from the table word, HIGH)";
            sw = rw;
            hw = r;
        } roistart_x[8:0];

        field {
            name = "roistart_y";
            desc = "r006 field ROIstartY (INFERRED, naming and position from the table word, HIGH)";
            sw = rw;
            hw = r;
        } roistart_y[17:9];

    } ROIPOS5 @ 0x340;

    reg {
        name = "ROIPOS6 (INFERRED, HIGH)";
        desc = "ROIPOS INFERRED, confidence HIGH. Reason: the vendor builds a DDR register-config table (table offset 0xF8) whose word has the bit layout of the r006 register VEDU_ROIPOS, and 9 offsets that the Hi3520D code accesses directly (MODE 0x020, PICFG0 0x024, REGCFG_ADDR 0x1E0, QPTHR 0x350, TARGETBITS 0x364, PICBITS 0x374, MEANQP 0x388, PICINFO0 0xA20, OUTSTD 0x0A4) all sit at the r006 offsets, so the register file is assumed to follow r006 (a neighbor generation). The offset in the window is therefore an assumption, NOT seen in any vendor register access. Register name and field names are the HiSTB drv_venc_reg_r006.h names (naming only). Not accessed by register in any vendor code (it is programmed through the DDR table, loaded by the hardware from REGCFG_ADDR; whether the hardware loads this exact register from the table is the working assumption). Region 6, start position in macroblock units (vendor: pixels >> 4). Source: docs/rdl-campaign/vedu-vendor.md section 13, H264E_DRV_UpdateRegConfigParam 0x1d4d0 / H264E_DRV_InitRegConfigParam 0x1db40 / H264eDrvUpdateMeCfg 0x1c680. Not verified on hardware.";

        field {
            name = "roistart_x";
            desc = "r006 field ROIstartX (INFERRED, naming and position from the table word, HIGH)";
            sw = rw;
            hw = r;
        } roistart_x[8:0];

        field {
            name = "roistart_y";
            desc = "r006 field ROIstartY (INFERRED, naming and position from the table word, HIGH)";
            sw = rw;
            hw = r;
        } roistart_y[17:9];

    } ROIPOS6 @ 0x344;

    reg {
        name = "ROIPOS7 (INFERRED, HIGH)";
        desc = "ROIPOS INFERRED, confidence HIGH. Reason: the vendor builds a DDR register-config table (table offset 0xFC) whose word has the bit layout of the r006 register VEDU_ROIPOS, and 9 offsets that the Hi3520D code accesses directly (MODE 0x020, PICFG0 0x024, REGCFG_ADDR 0x1E0, QPTHR 0x350, TARGETBITS 0x364, PICBITS 0x374, MEANQP 0x388, PICINFO0 0xA20, OUTSTD 0x0A4) all sit at the r006 offsets, so the register file is assumed to follow r006 (a neighbor generation). The offset in the window is therefore an assumption, NOT seen in any vendor register access. Register name and field names are the HiSTB drv_venc_reg_r006.h names (naming only). Not accessed by register in any vendor code (it is programmed through the DDR table, loaded by the hardware from REGCFG_ADDR; whether the hardware loads this exact register from the table is the working assumption). Region 7, start position in macroblock units (vendor: pixels >> 4). Source: docs/rdl-campaign/vedu-vendor.md section 13, H264E_DRV_UpdateRegConfigParam 0x1d4d0 / H264E_DRV_InitRegConfigParam 0x1db40 / H264eDrvUpdateMeCfg 0x1c680. Not verified on hardware.";

        field {
            name = "roistart_x";
            desc = "r006 field ROIstartX (INFERRED, naming and position from the table word, HIGH)";
            sw = rw;
            hw = r;
        } roistart_x[8:0];

        field {
            name = "roistart_y";
            desc = "r006 field ROIstartY (INFERRED, naming and position from the table word, HIGH)";
            sw = rw;
            hw = r;
        } roistart_y[17:9];

    } ROIPOS7 @ 0x348;

    reg {
        name = "MODLAMBDA0 (INFERRED, MEDIUM)";
        desc = "MODLAMBDA INFERRED, confidence MEDIUM. Reason: the vendor builds a DDR register-config table (table offset 0x268) whose word has the bit layout of the r006 register VEDU_MODLAMBDA, and 9 offsets that the Hi3520D code accesses directly (MODE 0x020, PICFG0 0x024, REGCFG_ADDR 0x1E0, QPTHR 0x350, TARGETBITS 0x364, PICBITS 0x374, MEANQP 0x388, PICINFO0 0xA20, OUTSTD 0x0A4) all sit at the r006 offsets, so the register file is assumed to follow r006 (a neighbor generation). The offset in the window is therefore an assumption, NOT seen in any vendor register access. Register name and field names are the HiSTB drv_venc_reg_r006.h names (naming only). Not accessed by register in any vendor code (it is programmed through the DDR table, loaded by the hardware from REGCFG_ADDR; whether the hardware loads this exact register from the table is the working assumption). Index 0 of 20. Vendor default values: see the address map description (40 twelve-bit values, doubling about every 3 steps). Source: docs/rdl-campaign/vedu-vendor.md section 13, H264E_DRV_UpdateRegConfigParam 0x1d4d0 / H264E_DRV_InitRegConfigParam 0x1db40 / H264eDrvUpdateMeCfg 0x1c680. Not verified on hardware.";

        field {
            name = "mod_lambda0";
            desc = "r006 field ModLambda0 (INFERRED, naming and position from the table word, MEDIUM)";
            sw = rw;
            hw = r;
        } mod_lambda0[11:0];

        field {
            name = "mod_lambda1";
            desc = "r006 field ModLambda1 (INFERRED, naming and position from the table word, MEDIUM)";
            sw = rw;
            hw = r;
        } mod_lambda1[23:12];

    } MODLAMBDA0 @ 0x3A0;

    reg {
        name = "MODLAMBDA1 (INFERRED, MEDIUM)";
        desc = "MODLAMBDA INFERRED, confidence MEDIUM. Reason: the vendor builds a DDR register-config table (table offset 0x26C) whose word has the bit layout of the r006 register VEDU_MODLAMBDA, and 9 offsets that the Hi3520D code accesses directly (MODE 0x020, PICFG0 0x024, REGCFG_ADDR 0x1E0, QPTHR 0x350, TARGETBITS 0x364, PICBITS 0x374, MEANQP 0x388, PICINFO0 0xA20, OUTSTD 0x0A4) all sit at the r006 offsets, so the register file is assumed to follow r006 (a neighbor generation). The offset in the window is therefore an assumption, NOT seen in any vendor register access. Register name and field names are the HiSTB drv_venc_reg_r006.h names (naming only). Not accessed by register in any vendor code (it is programmed through the DDR table, loaded by the hardware from REGCFG_ADDR; whether the hardware loads this exact register from the table is the working assumption). Index 1 of 20. Vendor default values: see the address map description (40 twelve-bit values, doubling about every 3 steps). Source: docs/rdl-campaign/vedu-vendor.md section 13, H264E_DRV_UpdateRegConfigParam 0x1d4d0 / H264E_DRV_InitRegConfigParam 0x1db40 / H264eDrvUpdateMeCfg 0x1c680. Not verified on hardware.";

        field {
            name = "mod_lambda0";
            desc = "r006 field ModLambda0 (INFERRED, naming and position from the table word, MEDIUM)";
            sw = rw;
            hw = r;
        } mod_lambda0[11:0];

        field {
            name = "mod_lambda1";
            desc = "r006 field ModLambda1 (INFERRED, naming and position from the table word, MEDIUM)";
            sw = rw;
            hw = r;
        } mod_lambda1[23:12];

    } MODLAMBDA1 @ 0x3A4;

    reg {
        name = "MODLAMBDA2 (INFERRED, MEDIUM)";
        desc = "MODLAMBDA INFERRED, confidence MEDIUM. Reason: the vendor builds a DDR register-config table (table offset 0x270) whose word has the bit layout of the r006 register VEDU_MODLAMBDA, and 9 offsets that the Hi3520D code accesses directly (MODE 0x020, PICFG0 0x024, REGCFG_ADDR 0x1E0, QPTHR 0x350, TARGETBITS 0x364, PICBITS 0x374, MEANQP 0x388, PICINFO0 0xA20, OUTSTD 0x0A4) all sit at the r006 offsets, so the register file is assumed to follow r006 (a neighbor generation). The offset in the window is therefore an assumption, NOT seen in any vendor register access. Register name and field names are the HiSTB drv_venc_reg_r006.h names (naming only). Not accessed by register in any vendor code (it is programmed through the DDR table, loaded by the hardware from REGCFG_ADDR; whether the hardware loads this exact register from the table is the working assumption). Index 2 of 20. Vendor default values: see the address map description (40 twelve-bit values, doubling about every 3 steps). Source: docs/rdl-campaign/vedu-vendor.md section 13, H264E_DRV_UpdateRegConfigParam 0x1d4d0 / H264E_DRV_InitRegConfigParam 0x1db40 / H264eDrvUpdateMeCfg 0x1c680. Not verified on hardware.";

        field {
            name = "mod_lambda0";
            desc = "r006 field ModLambda0 (INFERRED, naming and position from the table word, MEDIUM)";
            sw = rw;
            hw = r;
        } mod_lambda0[11:0];

        field {
            name = "mod_lambda1";
            desc = "r006 field ModLambda1 (INFERRED, naming and position from the table word, MEDIUM)";
            sw = rw;
            hw = r;
        } mod_lambda1[23:12];

    } MODLAMBDA2 @ 0x3A8;

    reg {
        name = "MODLAMBDA3 (INFERRED, MEDIUM)";
        desc = "MODLAMBDA INFERRED, confidence MEDIUM. Reason: the vendor builds a DDR register-config table (table offset 0x274) whose word has the bit layout of the r006 register VEDU_MODLAMBDA, and 9 offsets that the Hi3520D code accesses directly (MODE 0x020, PICFG0 0x024, REGCFG_ADDR 0x1E0, QPTHR 0x350, TARGETBITS 0x364, PICBITS 0x374, MEANQP 0x388, PICINFO0 0xA20, OUTSTD 0x0A4) all sit at the r006 offsets, so the register file is assumed to follow r006 (a neighbor generation). The offset in the window is therefore an assumption, NOT seen in any vendor register access. Register name and field names are the HiSTB drv_venc_reg_r006.h names (naming only). Not accessed by register in any vendor code (it is programmed through the DDR table, loaded by the hardware from REGCFG_ADDR; whether the hardware loads this exact register from the table is the working assumption). Index 3 of 20. Vendor default values: see the address map description (40 twelve-bit values, doubling about every 3 steps). Source: docs/rdl-campaign/vedu-vendor.md section 13, H264E_DRV_UpdateRegConfigParam 0x1d4d0 / H264E_DRV_InitRegConfigParam 0x1db40 / H264eDrvUpdateMeCfg 0x1c680. Not verified on hardware.";

        field {
            name = "mod_lambda0";
            desc = "r006 field ModLambda0 (INFERRED, naming and position from the table word, MEDIUM)";
            sw = rw;
            hw = r;
        } mod_lambda0[11:0];

        field {
            name = "mod_lambda1";
            desc = "r006 field ModLambda1 (INFERRED, naming and position from the table word, MEDIUM)";
            sw = rw;
            hw = r;
        } mod_lambda1[23:12];

    } MODLAMBDA3 @ 0x3AC;

    reg {
        name = "MODLAMBDA4 (INFERRED, MEDIUM)";
        desc = "MODLAMBDA INFERRED, confidence MEDIUM. Reason: the vendor builds a DDR register-config table (table offset 0x278) whose word has the bit layout of the r006 register VEDU_MODLAMBDA, and 9 offsets that the Hi3520D code accesses directly (MODE 0x020, PICFG0 0x024, REGCFG_ADDR 0x1E0, QPTHR 0x350, TARGETBITS 0x364, PICBITS 0x374, MEANQP 0x388, PICINFO0 0xA20, OUTSTD 0x0A4) all sit at the r006 offsets, so the register file is assumed to follow r006 (a neighbor generation). The offset in the window is therefore an assumption, NOT seen in any vendor register access. Register name and field names are the HiSTB drv_venc_reg_r006.h names (naming only). Not accessed by register in any vendor code (it is programmed through the DDR table, loaded by the hardware from REGCFG_ADDR; whether the hardware loads this exact register from the table is the working assumption). Index 4 of 20. Vendor default values: see the address map description (40 twelve-bit values, doubling about every 3 steps). Source: docs/rdl-campaign/vedu-vendor.md section 13, H264E_DRV_UpdateRegConfigParam 0x1d4d0 / H264E_DRV_InitRegConfigParam 0x1db40 / H264eDrvUpdateMeCfg 0x1c680. Not verified on hardware.";

        field {
            name = "mod_lambda0";
            desc = "r006 field ModLambda0 (INFERRED, naming and position from the table word, MEDIUM)";
            sw = rw;
            hw = r;
        } mod_lambda0[11:0];

        field {
            name = "mod_lambda1";
            desc = "r006 field ModLambda1 (INFERRED, naming and position from the table word, MEDIUM)";
            sw = rw;
            hw = r;
        } mod_lambda1[23:12];

    } MODLAMBDA4 @ 0x3B0;

    reg {
        name = "MODLAMBDA5 (INFERRED, MEDIUM)";
        desc = "MODLAMBDA INFERRED, confidence MEDIUM. Reason: the vendor builds a DDR register-config table (table offset 0x27C) whose word has the bit layout of the r006 register VEDU_MODLAMBDA, and 9 offsets that the Hi3520D code accesses directly (MODE 0x020, PICFG0 0x024, REGCFG_ADDR 0x1E0, QPTHR 0x350, TARGETBITS 0x364, PICBITS 0x374, MEANQP 0x388, PICINFO0 0xA20, OUTSTD 0x0A4) all sit at the r006 offsets, so the register file is assumed to follow r006 (a neighbor generation). The offset in the window is therefore an assumption, NOT seen in any vendor register access. Register name and field names are the HiSTB drv_venc_reg_r006.h names (naming only). Not accessed by register in any vendor code (it is programmed through the DDR table, loaded by the hardware from REGCFG_ADDR; whether the hardware loads this exact register from the table is the working assumption). Index 5 of 20. Vendor default values: see the address map description (40 twelve-bit values, doubling about every 3 steps). Source: docs/rdl-campaign/vedu-vendor.md section 13, H264E_DRV_UpdateRegConfigParam 0x1d4d0 / H264E_DRV_InitRegConfigParam 0x1db40 / H264eDrvUpdateMeCfg 0x1c680. Not verified on hardware.";

        field {
            name = "mod_lambda0";
            desc = "r006 field ModLambda0 (INFERRED, naming and position from the table word, MEDIUM)";
            sw = rw;
            hw = r;
        } mod_lambda0[11:0];

        field {
            name = "mod_lambda1";
            desc = "r006 field ModLambda1 (INFERRED, naming and position from the table word, MEDIUM)";
            sw = rw;
            hw = r;
        } mod_lambda1[23:12];

    } MODLAMBDA5 @ 0x3B4;

    reg {
        name = "MODLAMBDA6 (INFERRED, MEDIUM)";
        desc = "MODLAMBDA INFERRED, confidence MEDIUM. Reason: the vendor builds a DDR register-config table (table offset 0x280) whose word has the bit layout of the r006 register VEDU_MODLAMBDA, and 9 offsets that the Hi3520D code accesses directly (MODE 0x020, PICFG0 0x024, REGCFG_ADDR 0x1E0, QPTHR 0x350, TARGETBITS 0x364, PICBITS 0x374, MEANQP 0x388, PICINFO0 0xA20, OUTSTD 0x0A4) all sit at the r006 offsets, so the register file is assumed to follow r006 (a neighbor generation). The offset in the window is therefore an assumption, NOT seen in any vendor register access. Register name and field names are the HiSTB drv_venc_reg_r006.h names (naming only). Not accessed by register in any vendor code (it is programmed through the DDR table, loaded by the hardware from REGCFG_ADDR; whether the hardware loads this exact register from the table is the working assumption). Index 6 of 20. Vendor default values: see the address map description (40 twelve-bit values, doubling about every 3 steps). Source: docs/rdl-campaign/vedu-vendor.md section 13, H264E_DRV_UpdateRegConfigParam 0x1d4d0 / H264E_DRV_InitRegConfigParam 0x1db40 / H264eDrvUpdateMeCfg 0x1c680. Not verified on hardware.";

        field {
            name = "mod_lambda0";
            desc = "r006 field ModLambda0 (INFERRED, naming and position from the table word, MEDIUM)";
            sw = rw;
            hw = r;
        } mod_lambda0[11:0];

        field {
            name = "mod_lambda1";
            desc = "r006 field ModLambda1 (INFERRED, naming and position from the table word, MEDIUM)";
            sw = rw;
            hw = r;
        } mod_lambda1[23:12];

    } MODLAMBDA6 @ 0x3B8;

    reg {
        name = "MODLAMBDA7 (INFERRED, MEDIUM)";
        desc = "MODLAMBDA INFERRED, confidence MEDIUM. Reason: the vendor builds a DDR register-config table (table offset 0x284) whose word has the bit layout of the r006 register VEDU_MODLAMBDA, and 9 offsets that the Hi3520D code accesses directly (MODE 0x020, PICFG0 0x024, REGCFG_ADDR 0x1E0, QPTHR 0x350, TARGETBITS 0x364, PICBITS 0x374, MEANQP 0x388, PICINFO0 0xA20, OUTSTD 0x0A4) all sit at the r006 offsets, so the register file is assumed to follow r006 (a neighbor generation). The offset in the window is therefore an assumption, NOT seen in any vendor register access. Register name and field names are the HiSTB drv_venc_reg_r006.h names (naming only). Not accessed by register in any vendor code (it is programmed through the DDR table, loaded by the hardware from REGCFG_ADDR; whether the hardware loads this exact register from the table is the working assumption). Index 7 of 20. Vendor default values: see the address map description (40 twelve-bit values, doubling about every 3 steps). Source: docs/rdl-campaign/vedu-vendor.md section 13, H264E_DRV_UpdateRegConfigParam 0x1d4d0 / H264E_DRV_InitRegConfigParam 0x1db40 / H264eDrvUpdateMeCfg 0x1c680. Not verified on hardware.";

        field {
            name = "mod_lambda0";
            desc = "r006 field ModLambda0 (INFERRED, naming and position from the table word, MEDIUM)";
            sw = rw;
            hw = r;
        } mod_lambda0[11:0];

        field {
            name = "mod_lambda1";
            desc = "r006 field ModLambda1 (INFERRED, naming and position from the table word, MEDIUM)";
            sw = rw;
            hw = r;
        } mod_lambda1[23:12];

    } MODLAMBDA7 @ 0x3BC;

    reg {
        name = "MODLAMBDA8 (INFERRED, MEDIUM)";
        desc = "MODLAMBDA INFERRED, confidence MEDIUM. Reason: the vendor builds a DDR register-config table (table offset 0x288) whose word has the bit layout of the r006 register VEDU_MODLAMBDA, and 9 offsets that the Hi3520D code accesses directly (MODE 0x020, PICFG0 0x024, REGCFG_ADDR 0x1E0, QPTHR 0x350, TARGETBITS 0x364, PICBITS 0x374, MEANQP 0x388, PICINFO0 0xA20, OUTSTD 0x0A4) all sit at the r006 offsets, so the register file is assumed to follow r006 (a neighbor generation). The offset in the window is therefore an assumption, NOT seen in any vendor register access. Register name and field names are the HiSTB drv_venc_reg_r006.h names (naming only). Not accessed by register in any vendor code (it is programmed through the DDR table, loaded by the hardware from REGCFG_ADDR; whether the hardware loads this exact register from the table is the working assumption). Index 8 of 20. Vendor default values: see the address map description (40 twelve-bit values, doubling about every 3 steps). Source: docs/rdl-campaign/vedu-vendor.md section 13, H264E_DRV_UpdateRegConfigParam 0x1d4d0 / H264E_DRV_InitRegConfigParam 0x1db40 / H264eDrvUpdateMeCfg 0x1c680. Not verified on hardware.";

        field {
            name = "mod_lambda0";
            desc = "r006 field ModLambda0 (INFERRED, naming and position from the table word, MEDIUM)";
            sw = rw;
            hw = r;
        } mod_lambda0[11:0];

        field {
            name = "mod_lambda1";
            desc = "r006 field ModLambda1 (INFERRED, naming and position from the table word, MEDIUM)";
            sw = rw;
            hw = r;
        } mod_lambda1[23:12];

    } MODLAMBDA8 @ 0x3C0;

    reg {
        name = "MODLAMBDA9 (INFERRED, MEDIUM)";
        desc = "MODLAMBDA INFERRED, confidence MEDIUM. Reason: the vendor builds a DDR register-config table (table offset 0x28C) whose word has the bit layout of the r006 register VEDU_MODLAMBDA, and 9 offsets that the Hi3520D code accesses directly (MODE 0x020, PICFG0 0x024, REGCFG_ADDR 0x1E0, QPTHR 0x350, TARGETBITS 0x364, PICBITS 0x374, MEANQP 0x388, PICINFO0 0xA20, OUTSTD 0x0A4) all sit at the r006 offsets, so the register file is assumed to follow r006 (a neighbor generation). The offset in the window is therefore an assumption, NOT seen in any vendor register access. Register name and field names are the HiSTB drv_venc_reg_r006.h names (naming only). Not accessed by register in any vendor code (it is programmed through the DDR table, loaded by the hardware from REGCFG_ADDR; whether the hardware loads this exact register from the table is the working assumption). Index 9 of 20. Vendor default values: see the address map description (40 twelve-bit values, doubling about every 3 steps). Source: docs/rdl-campaign/vedu-vendor.md section 13, H264E_DRV_UpdateRegConfigParam 0x1d4d0 / H264E_DRV_InitRegConfigParam 0x1db40 / H264eDrvUpdateMeCfg 0x1c680. Not verified on hardware.";

        field {
            name = "mod_lambda0";
            desc = "r006 field ModLambda0 (INFERRED, naming and position from the table word, MEDIUM)";
            sw = rw;
            hw = r;
        } mod_lambda0[11:0];

        field {
            name = "mod_lambda1";
            desc = "r006 field ModLambda1 (INFERRED, naming and position from the table word, MEDIUM)";
            sw = rw;
            hw = r;
        } mod_lambda1[23:12];

    } MODLAMBDA9 @ 0x3C4;

    reg {
        name = "MODLAMBDA10 (INFERRED, MEDIUM)";
        desc = "MODLAMBDA INFERRED, confidence MEDIUM. Reason: the vendor builds a DDR register-config table (table offset 0x290) whose word has the bit layout of the r006 register VEDU_MODLAMBDA, and 9 offsets that the Hi3520D code accesses directly (MODE 0x020, PICFG0 0x024, REGCFG_ADDR 0x1E0, QPTHR 0x350, TARGETBITS 0x364, PICBITS 0x374, MEANQP 0x388, PICINFO0 0xA20, OUTSTD 0x0A4) all sit at the r006 offsets, so the register file is assumed to follow r006 (a neighbor generation). The offset in the window is therefore an assumption, NOT seen in any vendor register access. Register name and field names are the HiSTB drv_venc_reg_r006.h names (naming only). Not accessed by register in any vendor code (it is programmed through the DDR table, loaded by the hardware from REGCFG_ADDR; whether the hardware loads this exact register from the table is the working assumption). Index 10 of 20. Vendor default values: see the address map description (40 twelve-bit values, doubling about every 3 steps). Source: docs/rdl-campaign/vedu-vendor.md section 13, H264E_DRV_UpdateRegConfigParam 0x1d4d0 / H264E_DRV_InitRegConfigParam 0x1db40 / H264eDrvUpdateMeCfg 0x1c680. Not verified on hardware.";

        field {
            name = "mod_lambda0";
            desc = "r006 field ModLambda0 (INFERRED, naming and position from the table word, MEDIUM)";
            sw = rw;
            hw = r;
        } mod_lambda0[11:0];

        field {
            name = "mod_lambda1";
            desc = "r006 field ModLambda1 (INFERRED, naming and position from the table word, MEDIUM)";
            sw = rw;
            hw = r;
        } mod_lambda1[23:12];

    } MODLAMBDA10 @ 0x3C8;

    reg {
        name = "MODLAMBDA11 (INFERRED, MEDIUM)";
        desc = "MODLAMBDA INFERRED, confidence MEDIUM. Reason: the vendor builds a DDR register-config table (table offset 0x294) whose word has the bit layout of the r006 register VEDU_MODLAMBDA, and 9 offsets that the Hi3520D code accesses directly (MODE 0x020, PICFG0 0x024, REGCFG_ADDR 0x1E0, QPTHR 0x350, TARGETBITS 0x364, PICBITS 0x374, MEANQP 0x388, PICINFO0 0xA20, OUTSTD 0x0A4) all sit at the r006 offsets, so the register file is assumed to follow r006 (a neighbor generation). The offset in the window is therefore an assumption, NOT seen in any vendor register access. Register name and field names are the HiSTB drv_venc_reg_r006.h names (naming only). Not accessed by register in any vendor code (it is programmed through the DDR table, loaded by the hardware from REGCFG_ADDR; whether the hardware loads this exact register from the table is the working assumption). Index 11 of 20. Vendor default values: see the address map description (40 twelve-bit values, doubling about every 3 steps). Source: docs/rdl-campaign/vedu-vendor.md section 13, H264E_DRV_UpdateRegConfigParam 0x1d4d0 / H264E_DRV_InitRegConfigParam 0x1db40 / H264eDrvUpdateMeCfg 0x1c680. Not verified on hardware.";

        field {
            name = "mod_lambda0";
            desc = "r006 field ModLambda0 (INFERRED, naming and position from the table word, MEDIUM)";
            sw = rw;
            hw = r;
        } mod_lambda0[11:0];

        field {
            name = "mod_lambda1";
            desc = "r006 field ModLambda1 (INFERRED, naming and position from the table word, MEDIUM)";
            sw = rw;
            hw = r;
        } mod_lambda1[23:12];

    } MODLAMBDA11 @ 0x3CC;

    reg {
        name = "MODLAMBDA12 (INFERRED, MEDIUM)";
        desc = "MODLAMBDA INFERRED, confidence MEDIUM. Reason: the vendor builds a DDR register-config table (table offset 0x298) whose word has the bit layout of the r006 register VEDU_MODLAMBDA, and 9 offsets that the Hi3520D code accesses directly (MODE 0x020, PICFG0 0x024, REGCFG_ADDR 0x1E0, QPTHR 0x350, TARGETBITS 0x364, PICBITS 0x374, MEANQP 0x388, PICINFO0 0xA20, OUTSTD 0x0A4) all sit at the r006 offsets, so the register file is assumed to follow r006 (a neighbor generation). The offset in the window is therefore an assumption, NOT seen in any vendor register access. Register name and field names are the HiSTB drv_venc_reg_r006.h names (naming only). Not accessed by register in any vendor code (it is programmed through the DDR table, loaded by the hardware from REGCFG_ADDR; whether the hardware loads this exact register from the table is the working assumption). Index 12 of 20. Vendor default values: see the address map description (40 twelve-bit values, doubling about every 3 steps). Source: docs/rdl-campaign/vedu-vendor.md section 13, H264E_DRV_UpdateRegConfigParam 0x1d4d0 / H264E_DRV_InitRegConfigParam 0x1db40 / H264eDrvUpdateMeCfg 0x1c680. Not verified on hardware.";

        field {
            name = "mod_lambda0";
            desc = "r006 field ModLambda0 (INFERRED, naming and position from the table word, MEDIUM)";
            sw = rw;
            hw = r;
        } mod_lambda0[11:0];

        field {
            name = "mod_lambda1";
            desc = "r006 field ModLambda1 (INFERRED, naming and position from the table word, MEDIUM)";
            sw = rw;
            hw = r;
        } mod_lambda1[23:12];

    } MODLAMBDA12 @ 0x3D0;

    reg {
        name = "MODLAMBDA13 (INFERRED, MEDIUM)";
        desc = "MODLAMBDA INFERRED, confidence MEDIUM. Reason: the vendor builds a DDR register-config table (table offset 0x29C) whose word has the bit layout of the r006 register VEDU_MODLAMBDA, and 9 offsets that the Hi3520D code accesses directly (MODE 0x020, PICFG0 0x024, REGCFG_ADDR 0x1E0, QPTHR 0x350, TARGETBITS 0x364, PICBITS 0x374, MEANQP 0x388, PICINFO0 0xA20, OUTSTD 0x0A4) all sit at the r006 offsets, so the register file is assumed to follow r006 (a neighbor generation). The offset in the window is therefore an assumption, NOT seen in any vendor register access. Register name and field names are the HiSTB drv_venc_reg_r006.h names (naming only). Not accessed by register in any vendor code (it is programmed through the DDR table, loaded by the hardware from REGCFG_ADDR; whether the hardware loads this exact register from the table is the working assumption). Index 13 of 20. Vendor default values: see the address map description (40 twelve-bit values, doubling about every 3 steps). Source: docs/rdl-campaign/vedu-vendor.md section 13, H264E_DRV_UpdateRegConfigParam 0x1d4d0 / H264E_DRV_InitRegConfigParam 0x1db40 / H264eDrvUpdateMeCfg 0x1c680. Not verified on hardware.";

        field {
            name = "mod_lambda0";
            desc = "r006 field ModLambda0 (INFERRED, naming and position from the table word, MEDIUM)";
            sw = rw;
            hw = r;
        } mod_lambda0[11:0];

        field {
            name = "mod_lambda1";
            desc = "r006 field ModLambda1 (INFERRED, naming and position from the table word, MEDIUM)";
            sw = rw;
            hw = r;
        } mod_lambda1[23:12];

    } MODLAMBDA13 @ 0x3D4;

    reg {
        name = "MODLAMBDA14 (INFERRED, MEDIUM)";
        desc = "MODLAMBDA INFERRED, confidence MEDIUM. Reason: the vendor builds a DDR register-config table (table offset 0x2A0) whose word has the bit layout of the r006 register VEDU_MODLAMBDA, and 9 offsets that the Hi3520D code accesses directly (MODE 0x020, PICFG0 0x024, REGCFG_ADDR 0x1E0, QPTHR 0x350, TARGETBITS 0x364, PICBITS 0x374, MEANQP 0x388, PICINFO0 0xA20, OUTSTD 0x0A4) all sit at the r006 offsets, so the register file is assumed to follow r006 (a neighbor generation). The offset in the window is therefore an assumption, NOT seen in any vendor register access. Register name and field names are the HiSTB drv_venc_reg_r006.h names (naming only). Not accessed by register in any vendor code (it is programmed through the DDR table, loaded by the hardware from REGCFG_ADDR; whether the hardware loads this exact register from the table is the working assumption). Index 14 of 20. Vendor default values: see the address map description (40 twelve-bit values, doubling about every 3 steps). Source: docs/rdl-campaign/vedu-vendor.md section 13, H264E_DRV_UpdateRegConfigParam 0x1d4d0 / H264E_DRV_InitRegConfigParam 0x1db40 / H264eDrvUpdateMeCfg 0x1c680. Not verified on hardware.";

        field {
            name = "mod_lambda0";
            desc = "r006 field ModLambda0 (INFERRED, naming and position from the table word, MEDIUM)";
            sw = rw;
            hw = r;
        } mod_lambda0[11:0];

        field {
            name = "mod_lambda1";
            desc = "r006 field ModLambda1 (INFERRED, naming and position from the table word, MEDIUM)";
            sw = rw;
            hw = r;
        } mod_lambda1[23:12];

    } MODLAMBDA14 @ 0x3D8;

    reg {
        name = "MODLAMBDA15 (INFERRED, MEDIUM)";
        desc = "MODLAMBDA INFERRED, confidence MEDIUM. Reason: the vendor builds a DDR register-config table (table offset 0x2A4) whose word has the bit layout of the r006 register VEDU_MODLAMBDA, and 9 offsets that the Hi3520D code accesses directly (MODE 0x020, PICFG0 0x024, REGCFG_ADDR 0x1E0, QPTHR 0x350, TARGETBITS 0x364, PICBITS 0x374, MEANQP 0x388, PICINFO0 0xA20, OUTSTD 0x0A4) all sit at the r006 offsets, so the register file is assumed to follow r006 (a neighbor generation). The offset in the window is therefore an assumption, NOT seen in any vendor register access. Register name and field names are the HiSTB drv_venc_reg_r006.h names (naming only). Not accessed by register in any vendor code (it is programmed through the DDR table, loaded by the hardware from REGCFG_ADDR; whether the hardware loads this exact register from the table is the working assumption). Index 15 of 20. Vendor default values: see the address map description (40 twelve-bit values, doubling about every 3 steps). Source: docs/rdl-campaign/vedu-vendor.md section 13, H264E_DRV_UpdateRegConfigParam 0x1d4d0 / H264E_DRV_InitRegConfigParam 0x1db40 / H264eDrvUpdateMeCfg 0x1c680. Not verified on hardware.";

        field {
            name = "mod_lambda0";
            desc = "r006 field ModLambda0 (INFERRED, naming and position from the table word, MEDIUM)";
            sw = rw;
            hw = r;
        } mod_lambda0[11:0];

        field {
            name = "mod_lambda1";
            desc = "r006 field ModLambda1 (INFERRED, naming and position from the table word, MEDIUM)";
            sw = rw;
            hw = r;
        } mod_lambda1[23:12];

    } MODLAMBDA15 @ 0x3DC;

    reg {
        name = "MODLAMBDA16 (INFERRED, MEDIUM)";
        desc = "MODLAMBDA INFERRED, confidence MEDIUM. Reason: the vendor builds a DDR register-config table (table offset 0x2A8) whose word has the bit layout of the r006 register VEDU_MODLAMBDA, and 9 offsets that the Hi3520D code accesses directly (MODE 0x020, PICFG0 0x024, REGCFG_ADDR 0x1E0, QPTHR 0x350, TARGETBITS 0x364, PICBITS 0x374, MEANQP 0x388, PICINFO0 0xA20, OUTSTD 0x0A4) all sit at the r006 offsets, so the register file is assumed to follow r006 (a neighbor generation). The offset in the window is therefore an assumption, NOT seen in any vendor register access. Register name and field names are the HiSTB drv_venc_reg_r006.h names (naming only). Not accessed by register in any vendor code (it is programmed through the DDR table, loaded by the hardware from REGCFG_ADDR; whether the hardware loads this exact register from the table is the working assumption). Index 16 of 20. Vendor default values: see the address map description (40 twelve-bit values, doubling about every 3 steps). Source: docs/rdl-campaign/vedu-vendor.md section 13, H264E_DRV_UpdateRegConfigParam 0x1d4d0 / H264E_DRV_InitRegConfigParam 0x1db40 / H264eDrvUpdateMeCfg 0x1c680. Not verified on hardware.";

        field {
            name = "mod_lambda0";
            desc = "r006 field ModLambda0 (INFERRED, naming and position from the table word, MEDIUM)";
            sw = rw;
            hw = r;
        } mod_lambda0[11:0];

        field {
            name = "mod_lambda1";
            desc = "r006 field ModLambda1 (INFERRED, naming and position from the table word, MEDIUM)";
            sw = rw;
            hw = r;
        } mod_lambda1[23:12];

    } MODLAMBDA16 @ 0x3E0;

    reg {
        name = "MODLAMBDA17 (INFERRED, MEDIUM)";
        desc = "MODLAMBDA INFERRED, confidence MEDIUM. Reason: the vendor builds a DDR register-config table (table offset 0x2AC) whose word has the bit layout of the r006 register VEDU_MODLAMBDA, and 9 offsets that the Hi3520D code accesses directly (MODE 0x020, PICFG0 0x024, REGCFG_ADDR 0x1E0, QPTHR 0x350, TARGETBITS 0x364, PICBITS 0x374, MEANQP 0x388, PICINFO0 0xA20, OUTSTD 0x0A4) all sit at the r006 offsets, so the register file is assumed to follow r006 (a neighbor generation). The offset in the window is therefore an assumption, NOT seen in any vendor register access. Register name and field names are the HiSTB drv_venc_reg_r006.h names (naming only). Not accessed by register in any vendor code (it is programmed through the DDR table, loaded by the hardware from REGCFG_ADDR; whether the hardware loads this exact register from the table is the working assumption). Index 17 of 20. Vendor default values: see the address map description (40 twelve-bit values, doubling about every 3 steps). Source: docs/rdl-campaign/vedu-vendor.md section 13, H264E_DRV_UpdateRegConfigParam 0x1d4d0 / H264E_DRV_InitRegConfigParam 0x1db40 / H264eDrvUpdateMeCfg 0x1c680. Not verified on hardware.";

        field {
            name = "mod_lambda0";
            desc = "r006 field ModLambda0 (INFERRED, naming and position from the table word, MEDIUM)";
            sw = rw;
            hw = r;
        } mod_lambda0[11:0];

        field {
            name = "mod_lambda1";
            desc = "r006 field ModLambda1 (INFERRED, naming and position from the table word, MEDIUM)";
            sw = rw;
            hw = r;
        } mod_lambda1[23:12];

    } MODLAMBDA17 @ 0x3E4;

    reg {
        name = "MODLAMBDA18 (INFERRED, MEDIUM)";
        desc = "MODLAMBDA INFERRED, confidence MEDIUM. Reason: the vendor builds a DDR register-config table (table offset 0x2B0) whose word has the bit layout of the r006 register VEDU_MODLAMBDA, and 9 offsets that the Hi3520D code accesses directly (MODE 0x020, PICFG0 0x024, REGCFG_ADDR 0x1E0, QPTHR 0x350, TARGETBITS 0x364, PICBITS 0x374, MEANQP 0x388, PICINFO0 0xA20, OUTSTD 0x0A4) all sit at the r006 offsets, so the register file is assumed to follow r006 (a neighbor generation). The offset in the window is therefore an assumption, NOT seen in any vendor register access. Register name and field names are the HiSTB drv_venc_reg_r006.h names (naming only). Not accessed by register in any vendor code (it is programmed through the DDR table, loaded by the hardware from REGCFG_ADDR; whether the hardware loads this exact register from the table is the working assumption). Index 18 of 20. Vendor default values: see the address map description (40 twelve-bit values, doubling about every 3 steps). Source: docs/rdl-campaign/vedu-vendor.md section 13, H264E_DRV_UpdateRegConfigParam 0x1d4d0 / H264E_DRV_InitRegConfigParam 0x1db40 / H264eDrvUpdateMeCfg 0x1c680. Not verified on hardware.";

        field {
            name = "mod_lambda0";
            desc = "r006 field ModLambda0 (INFERRED, naming and position from the table word, MEDIUM)";
            sw = rw;
            hw = r;
        } mod_lambda0[11:0];

        field {
            name = "mod_lambda1";
            desc = "r006 field ModLambda1 (INFERRED, naming and position from the table word, MEDIUM)";
            sw = rw;
            hw = r;
        } mod_lambda1[23:12];

    } MODLAMBDA18 @ 0x3E8;

    reg {
        name = "MODLAMBDA19 (INFERRED, MEDIUM)";
        desc = "MODLAMBDA INFERRED, confidence MEDIUM. Reason: the vendor builds a DDR register-config table (table offset 0x2B4) whose word has the bit layout of the r006 register VEDU_MODLAMBDA, and 9 offsets that the Hi3520D code accesses directly (MODE 0x020, PICFG0 0x024, REGCFG_ADDR 0x1E0, QPTHR 0x350, TARGETBITS 0x364, PICBITS 0x374, MEANQP 0x388, PICINFO0 0xA20, OUTSTD 0x0A4) all sit at the r006 offsets, so the register file is assumed to follow r006 (a neighbor generation). The offset in the window is therefore an assumption, NOT seen in any vendor register access. Register name and field names are the HiSTB drv_venc_reg_r006.h names (naming only). Not accessed by register in any vendor code (it is programmed through the DDR table, loaded by the hardware from REGCFG_ADDR; whether the hardware loads this exact register from the table is the working assumption). Index 19 of 20. Vendor default values: see the address map description (40 twelve-bit values, doubling about every 3 steps). Source: docs/rdl-campaign/vedu-vendor.md section 13, H264E_DRV_UpdateRegConfigParam 0x1d4d0 / H264E_DRV_InitRegConfigParam 0x1db40 / H264eDrvUpdateMeCfg 0x1c680. Not verified on hardware.";

        field {
            name = "mod_lambda0";
            desc = "r006 field ModLambda0 (INFERRED, naming and position from the table word, MEDIUM)";
            sw = rw;
            hw = r;
        } mod_lambda0[11:0];

        field {
            name = "mod_lambda1";
            desc = "r006 field ModLambda1 (INFERRED, naming and position from the table word, MEDIUM)";
            sw = rw;
            hw = r;
        } mod_lambda1[23:12];

    } MODLAMBDA19 @ 0x3EC;

    reg {
        name = "RC1 (INFERRED, LOW)";
        desc = "RC1 INFERRED, confidence LOW (a position guess, see below). Register name and field names are the HiSTB drv_venc_reg_r006.h names (naming only). Not accessed by register in any vendor code (it is programmed through the DDR table, loaded by the hardware from REGCFG_ADDR; whether the hardware loads this exact register from the table is the working assumption). POSITION GUESS ONLY: the vendor table words 0x130..0x13C (written once at channel creation: 0x03002100, 0x00050A02, 0x0A0A040F, 0x97888888) are four words that could be an image of QPTHR, RC1, QPDELTATHR0, QPDELTATHR1 (0x350..0x35C). Word 0x134 = 0x00050A02 fits rcQpDelta = 2, rcMadpDelta = 10 (r006 bits [31:16] reserved, value 5 there); the other words do not fit the r006 layouts cleanly. Treat the register, not its fields, as the guess. Source: docs/rdl-campaign/vedu-vendor.md section 13, H264E_DRV_UpdateRegConfigParam 0x1d4d0 / H264E_DRV_InitRegConfigParam 0x1db40 / H264eDrvUpdateMeCfg 0x1c680. Not verified on hardware.";

        field {
            name = "rc_qp_delta";
            desc = "r006 field rcQpDelta (INFERRED, naming and position from the table word, LOW)";
            sw = rw;
            hw = r;
        } rc_qp_delta[5:0];

        field {
            name = "rc_madp_delta";
            desc = "r006 field rcMadpDelta (INFERRED, naming and position from the table word, LOW)";
            sw = rw;
            hw = r;
        } rc_madp_delta[15:8];

    } RC1 @ 0x354;

    reg {
        name = "QPDELTATHR0 (INFERRED, LOW)";
        desc = "QPDELTATHR0 INFERRED, confidence LOW (a position guess, see below). Register name and field names are the HiSTB drv_venc_reg_r006.h names (naming only). Not accessed by register in any vendor code (it is programmed through the DDR table, loaded by the hardware from REGCFG_ADDR; whether the hardware loads this exact register from the table is the working assumption). POSITION GUESS ONLY, see RC1: word 0x138 = 0x0A0A040F would be the four thresholds 15, 4, 10, 10. Source: docs/rdl-campaign/vedu-vendor.md section 13, H264E_DRV_UpdateRegConfigParam 0x1d4d0 / H264E_DRV_InitRegConfigParam 0x1db40 / H264eDrvUpdateMeCfg 0x1c680. Not verified on hardware.";

        field {
            name = "rc_qp_delta_thr0";
            desc = "r006 field rcQpDeltaThr0 (INFERRED, naming and position from the table word, LOW)";
            sw = rw;
            hw = r;
        } rc_qp_delta_thr0[7:0];

        field {
            name = "rc_qp_delta_thr1";
            desc = "r006 field rcQpDeltaThr1 (INFERRED, naming and position from the table word, LOW)";
            sw = rw;
            hw = r;
        } rc_qp_delta_thr1[15:8];

        field {
            name = "rc_qp_delta_thr2";
            desc = "r006 field rcQpDeltaThr2 (INFERRED, naming and position from the table word, LOW)";
            sw = rw;
            hw = r;
        } rc_qp_delta_thr2[23:16];

        field {
            name = "rc_qp_delta_thr3";
            desc = "r006 field rcQpDeltaThr3 (INFERRED, naming and position from the table word, LOW)";
            sw = rw;
            hw = r;
        } rc_qp_delta_thr3[31:24];

    } QPDELTATHR0 @ 0x358;

    reg {
        name = "QPDELTATHR1 (INFERRED, LOW)";
        desc = "QPDELTATHR1 INFERRED, confidence LOW (a position guess, see below). Register name and field names are the HiSTB drv_venc_reg_r006.h names (naming only). Not accessed by register in any vendor code (it is programmed through the DDR table, loaded by the hardware from REGCFG_ADDR; whether the hardware loads this exact register from the table is the working assumption). POSITION GUESS ONLY, see RC1: word 0x13C = 0x97888888 (bytes 0x88, 0x88, 0x88, 0x97) does not look like thresholds; may be something else. Source: docs/rdl-campaign/vedu-vendor.md section 13, H264E_DRV_UpdateRegConfigParam 0x1d4d0 / H264E_DRV_InitRegConfigParam 0x1db40 / H264eDrvUpdateMeCfg 0x1c680. Not verified on hardware.";

        field {
            name = "rc_qp_delta_thr4";
            desc = "r006 field rcQpDeltaThr4 (INFERRED, naming and position from the table word, LOW)";
            sw = rw;
            hw = r;
        } rc_qp_delta_thr4[7:0];

        field {
            name = "rc_qp_delta_thr5";
            desc = "r006 field rcQpDeltaThr5 (INFERRED, naming and position from the table word, LOW)";
            sw = rw;
            hw = r;
        } rc_qp_delta_thr5[15:8];

        field {
            name = "rc_qp_delta_thr6";
            desc = "r006 field rcQpDeltaThr6 (INFERRED, naming and position from the table word, LOW)";
            sw = rw;
            hw = r;
        } rc_qp_delta_thr6[23:16];

        field {
            name = "rc_qp_delta_thr7";
            desc = "r006 field rcQpDeltaThr7 (INFERRED, naming and position from the table word, LOW)";
            sw = rw;
            hw = r;
        } rc_qp_delta_thr7[31:24];

    } QPDELTATHR1 @ 0x35C;

    external mem {
        name = "Rest of the window (not described)";
        desc = "The rest of the 64 KB window from 0xAA0 (the registers above 0xAA0 and the gaps between the registers listed above are not described: no vendor access seen). Kept so that the block size stays 64 KB. The r006 neighbor map has further registers up to 0xFF14 (RAWINT 0x008, PTS, VDREF addresses, MECFG..., VPP_OSD, AXI test registers, data RAMs at 0x4000-0x5E80, AXI delay registers 0xFF00-0xFF10); none of them is accessed by the Hi3520D vendor code except the debug-dump reads listed as UNK_ registers.";
        mementries = 15704;
        memwidth = 32;
        sw = rw;
    } REST @ 0xAA0;
};

`endif
