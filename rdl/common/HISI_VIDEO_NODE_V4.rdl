`ifndef HISI_VPSS_NODE_V4_RDL
`define HISI_VPSS_NODE_V4_RDL

regfile eVPSS_NODE_V4_EV300 {
    name = "VPSS job node";
    desc = "Hi3516E V200 / V300 (shared SDK object hi3516ev200_vpss.ko, static analysis with scripts/tools/arm-trace, VPSS_HAL_Set* with the node pointer in argument 0, --keep-call-args, 230 words); cross-checked with scripts/tools/arm-emu (127 write offsets, 76 in common): the 51 extra words found only by arm-emu are 0x1800, 0x2000, 0x2004, 0x2008, 0x200c, 0x2010, 0x2014, 0x2018, 0x201c, 0x2020, 0x2040, 0x2044, 0x2048, 0x204c, 0x2050, 0x2054, 0x2058, 0x205c, 0x2080, 0x2084, 0x2088, 0x208c, 0x2090, 0x2094, 0x2098, 0x209c, 0x4000, 0x4004, 0x4008, 0x400c, 0x4010, 0x4014, 0x4018, 0x401c, 0x4020, 0x4040, 0x4044, 0x4048, 0x404c, 0x4050, 0x4054, 0x4058, 0x405c, 0x6040, 0x6044, 0x6048, 0x604c, 0x6050, 0x6054, 0x6058, 0x605c (PROVEN offsets from the emulator, not in the table below). Most of these words are a DDR job-node image written through argument 0 (ev200b: only 0x010, 0xF0, 0xFC, 0x200-0x2F0, 0x2F8, 0x300, 0x304, 0x308, 0x310, 0x314 are MMIO, those are in eVPSS_V4). Name/meaning of every word UNKNOWN unless stated. NOT A REGISTER FILE unless stated: register image / table written by the traced functions. PROVENANCE LABELS: PROVEN = read from the instruction stream (offset, stored byte lanes, cleared bit extents, ORed constants); INFERRED = role deduced from names or sibling chips; UNKNOWN = everything else. Source: symbolic trace of the module disassembly (arm-trace). Branches are linearized, extents are lower bounds. Not hardware verified.";

    reg {
        name = "Word 0x0";
        desc = "Word 0x0. PROVEN: stored byte lanes 0123, cleared bit extents none seen, ORed constants none, written by VPSS_HAL_Set3dnrEnable, VPSS_HAL_SetChnCrop, VPSS_HAL_SetChnScaleEn, VPSS_HAL_SetCoverCtrl, VPSS_HAL_SetGrpCropAttr, VPSS_HAL_SetImgWorkType, VPSS_HAL_SetMosaicCtrl (9 stores). Meaning UNKNOWN.";
        field {
            name = "word";
            desc = "32-bit word.";
            sw = rw;
            hw = r;
        } word[31:0];
    } W_000 @ 0x0;

    reg {
        name = "Word 0x4";
        desc = "Word 0x4. PROVEN: stored byte lanes 0123, cleared bit extents none seen, ORed constants none, written by VPSS_HAL_Set3dnrGmotion (1 stores). Meaning UNKNOWN.";
        field {
            name = "word";
            desc = "32-bit word.";
            sw = rw;
            hw = r;
        } word[31:0];
    } W_004 @ 0x4;

    reg {
        name = "Word 0x10";
        desc = "Word 0x10. PROVEN: stored byte lanes 0123, cleared bit extents none seen, ORed constants none, written by VPSS_HAL_SetManualRegup, VPSS_HAL_SetRegup (2 stores). Meaning UNKNOWN.";
        field {
            name = "word";
            desc = "32-bit word.";
            sw = rw;
            hw = r;
        } word[31:0];
    } W_010 @ 0x10;

    reg {
        name = "Word 0xF0";
        desc = "Word 0xF0. PROVEN: stored byte lanes 0123, cleared bit extents none seen, ORed constants none, written by VPSS_HAL_SetMask (1 stores). Meaning UNKNOWN.";
        field {
            name = "word";
            desc = "32-bit word.";
            sw = rw;
            hw = r;
        } word[31:0];
    } W_0F0 @ 0xF0;

    reg {
        name = "Word 0xFC";
        desc = "Word 0xFC. PROVEN: stored byte lanes 0123, cleared bit extents none seen, ORed constants none, written by VPSS_HAL_SetNodeID (1 stores). Meaning UNKNOWN.";
        field {
            name = "word";
            desc = "32-bit word.";
            sw = rw;
            hw = r;
        } word[31:0];
    } W_0FC @ 0xFC;

    reg {
        name = "Word 0x100";
        desc = "Word 0x100. PROVEN: stored byte lanes 0123, cleared bit extents none seen, ORed constants none, written by VPSS_HAL_SetGrpCropAttr (1 stores). Meaning UNKNOWN.";
        field {
            name = "word";
            desc = "32-bit word.";
            sw = rw;
            hw = r;
        } word[31:0];
    } W_100 @ 0x100;

    reg {
        name = "Word 0x104";
        desc = "Word 0x104. PROVEN: stored byte lanes 0123, cleared bit extents none seen, ORed constants none, written by VPSS_HAL_SetGrpCropAttr (1 stores). Meaning UNKNOWN.";
        field {
            name = "word";
            desc = "32-bit word.";
            sw = rw;
            hw = r;
        } word[31:0];
    } W_104 @ 0x104;

    reg {
        name = "Word 0x108";
        desc = "Word 0x108. PROVEN: stored byte lanes 0123, cleared bit extents none seen, ORed constants none, written by VPSS_HAL_SetChnCrop (1 stores). Meaning UNKNOWN.";
        field {
            name = "word";
            desc = "32-bit word.";
            sw = rw;
            hw = r;
        } word[31:0];
    } W_108 @ 0x108;

    reg {
        name = "Word 0x10C";
        desc = "Word 0x10C. PROVEN: stored byte lanes 0123, cleared bit extents none seen, ORed constants none, written by VPSS_HAL_SetChnCrop (1 stores). Meaning UNKNOWN.";
        field {
            name = "word";
            desc = "32-bit word.";
            sw = rw;
            hw = r;
        } word[31:0];
    } W_10C @ 0x10C;

    reg {
        name = "Word 0x110";
        desc = "Word 0x110. PROVEN: stored byte lanes 0123, cleared bit extents none seen, ORed constants none, written by VPSS_HAL_SetChnCrop (1 stores). Meaning UNKNOWN.";
        field {
            name = "word";
            desc = "32-bit word.";
            sw = rw;
            hw = r;
        } word[31:0];
    } W_110 @ 0x110;

    reg {
        name = "Word 0x114";
        desc = "Word 0x114. PROVEN: stored byte lanes 0123, cleared bit extents none seen, ORed constants none, written by VPSS_HAL_SetChnCrop (1 stores). Meaning UNKNOWN.";
        field {
            name = "word";
            desc = "32-bit word.";
            sw = rw;
            hw = r;
        } word[31:0];
    } W_114 @ 0x114;

    reg {
        name = "Word 0x118";
        desc = "Word 0x118. PROVEN: stored byte lanes 0123, cleared bit extents none seen, ORed constants none, written by VPSS_HAL_SetChnCrop (1 stores). Meaning UNKNOWN.";
        field {
            name = "word";
            desc = "32-bit word.";
            sw = rw;
            hw = r;
        } word[31:0];
    } W_118 @ 0x118;

    reg {
        name = "Word 0x11C";
        desc = "Word 0x11C. PROVEN: stored byte lanes 0123, cleared bit extents none seen, ORed constants none, written by VPSS_HAL_SetChnCrop (1 stores). Meaning UNKNOWN.";
        field {
            name = "word";
            desc = "32-bit word.";
            sw = rw;
            hw = r;
        } word[31:0];
    } W_11C @ 0x11C;

    reg {
        name = "Word 0x180";
        desc = "Word 0x180. PROVEN: stored byte lanes 0123, cleared bit extents none seen, ORed constants none, written by VPSS_HAL_SetOfflineChnScaleCoeff (1 stores). Meaning UNKNOWN.";
        field {
            name = "word";
            desc = "32-bit word.";
            sw = rw;
            hw = r;
        } word[31:0];
    } W_180 @ 0x180;

    reg {
        name = "Word 0x188";
        desc = "Word 0x188. PROVEN: stored byte lanes 0123, cleared bit extents none seen, ORed constants none, written by VPSS_HAL_SetOfflineChnScaleCoeff (1 stores). Meaning UNKNOWN.";
        field {
            name = "word";
            desc = "32-bit word.";
            sw = rw;
            hw = r;
        } word[31:0];
    } W_188 @ 0x188;

    reg {
        name = "Word 0x190";
        desc = "Word 0x190. PROVEN: stored byte lanes 0123, cleared bit extents none seen, ORed constants none, written by VPSS_HAL_SetOfflineChnScaleCoeff (1 stores). Meaning UNKNOWN.";
        field {
            name = "word";
            desc = "32-bit word.";
            sw = rw;
            hw = r;
        } word[31:0];
    } W_190 @ 0x190;

    reg {
        name = "Word 0x198";
        desc = "Word 0x198. PROVEN: stored byte lanes 0123, cleared bit extents none seen, ORed constants none, written by VPSS_HAL_SetOfflineChnScaleCoeff (1 stores). Meaning UNKNOWN.";
        field {
            name = "word";
            desc = "32-bit word.";
            sw = rw;
            hw = r;
        } word[31:0];
    } W_198 @ 0x198;

    reg {
        name = "Word 0x1A0";
        desc = "Word 0x1A0. PROVEN: stored byte lanes 0123, cleared bit extents none seen, ORed constants none, written by VPSS_HAL_SetOfflineChnScaleCoeff (1 stores). Meaning UNKNOWN.";
        field {
            name = "word";
            desc = "32-bit word.";
            sw = rw;
            hw = r;
        } word[31:0];
    } W_1A0 @ 0x1A0;

    reg {
        name = "Word 0x1A8";
        desc = "Word 0x1A8. PROVEN: stored byte lanes 0123, cleared bit extents none seen, ORed constants none, written by VPSS_HAL_SetOfflineChnScaleCoeff (1 stores). Meaning UNKNOWN.";
        field {
            name = "word";
            desc = "32-bit word.";
            sw = rw;
            hw = r;
        } word[31:0];
    } W_1A8 @ 0x1A8;

    reg {
        name = "Word 0x1B0";
        desc = "Word 0x1B0. PROVEN: stored byte lanes 0123, cleared bit extents none seen, ORed constants none, written by VPSS_HAL_SetOfflineChnScaleCoeff (1 stores). Meaning UNKNOWN.";
        field {
            name = "word";
            desc = "32-bit word.";
            sw = rw;
            hw = r;
        } word[31:0];
    } W_1B0 @ 0x1B0;

    reg {
        name = "Word 0x1B8";
        desc = "Word 0x1B8. PROVEN: stored byte lanes 0123, cleared bit extents none seen, ORed constants none, written by VPSS_HAL_SetOfflineChnScaleCoeff (1 stores). Meaning UNKNOWN.";
        field {
            name = "word";
            desc = "32-bit word.";
            sw = rw;
            hw = r;
        } word[31:0];
    } W_1B8 @ 0x1B8;

    reg {
        name = "Word 0x1C0";
        desc = "Word 0x1C0. PROVEN: stored byte lanes 0123, cleared bit extents none seen, ORed constants none, written by VPSS_HAL_SetOfflineChnScaleCoeff (1 stores). Meaning UNKNOWN.";
        field {
            name = "word";
            desc = "32-bit word.";
            sw = rw;
            hw = r;
        } word[31:0];
    } W_1C0 @ 0x1C0;

    reg {
        name = "Word 0x1C8";
        desc = "Word 0x1C8. PROVEN: stored byte lanes 0123, cleared bit extents none seen, ORed constants none, written by VPSS_HAL_SetOfflineChnScaleCoeff (1 stores). Meaning UNKNOWN.";
        field {
            name = "word";
            desc = "32-bit word.";
            sw = rw;
            hw = r;
        } word[31:0];
    } W_1C8 @ 0x1C8;

    reg {
        name = "Word 0x1D0";
        desc = "Word 0x1D0. PROVEN: stored byte lanes 0123, cleared bit extents none seen, ORed constants none, written by VPSS_HAL_SetOfflineChnScaleCoeff (1 stores). Meaning UNKNOWN.";
        field {
            name = "word";
            desc = "32-bit word.";
            sw = rw;
            hw = r;
        } word[31:0];
    } W_1D0 @ 0x1D0;

    reg {
        name = "Word 0x1D8";
        desc = "Word 0x1D8. PROVEN: stored byte lanes 0123, cleared bit extents none seen, ORed constants none, written by VPSS_HAL_SetOfflineChnScaleCoeff (1 stores). Meaning UNKNOWN.";
        field {
            name = "word";
            desc = "32-bit word.";
            sw = rw;
            hw = r;
        } word[31:0];
    } W_1D8 @ 0x1D8;

    reg {
        name = "Word 0x200";
        desc = "Word 0x200. PROVEN: stored byte lanes 0123, cleared bit extents none seen, ORed constants none, written by VPSS_HAL_SetCoverLoadAddr, VPSS_HAL_SetLoadAddr (2 stores). Meaning UNKNOWN.";
        field {
            name = "word";
            desc = "32-bit word.";
            sw = rw;
            hw = r;
        } word[31:0];
    } W_200 @ 0x200;

    reg {
        name = "Word 0x208";
        desc = "Word 0x208. PROVEN: stored byte lanes 0123, cleared bit extents none seen, ORed constants none, written by VPSS_HAL_SetLoadAddr, VPSS_HAL_SetMosaicLoadAddr (2 stores). Meaning UNKNOWN.";
        field {
            name = "word";
            desc = "32-bit word.";
            sw = rw;
            hw = r;
        } word[31:0];
    } W_208 @ 0x208;

    reg {
        name = "Word 0x218";
        desc = "Word 0x218. PROVEN: stored byte lanes 0123, cleared bit extents none seen, ORed constants none, written by VPSS_HAL_SetLoadAddr, VPSS_HAL_SetZmeLoadAddr (2 stores). Meaning UNKNOWN.";
        field {
            name = "word";
            desc = "32-bit word.";
            sw = rw;
            hw = r;
        } word[31:0];
    } W_218 @ 0x218;

    reg {
        name = "Word 0x220";
        desc = "Word 0x220. PROVEN: stored byte lanes 0123, cleared bit extents none seen, ORed constants none, written by VPSS_HAL_SetLoadAddr, VPSS_HAL_SetNrCfgLoadAddr (2 stores). Meaning UNKNOWN.";
        field {
            name = "word";
            desc = "32-bit word.";
            sw = rw;
            hw = r;
        } word[31:0];
    } W_220 @ 0x220;

    reg {
        name = "Word 0x2F0";
        desc = "Word 0x2F0. PROVEN: stored byte lanes 0123, cleared bit extents none seen, ORed constants none, written by VPSS_HAL_SetLoadAddr, VPSS_HAL_SetMacLoadAddr (2 stores). Meaning UNKNOWN.";
        field {
            name = "word";
            desc = "32-bit word.";
            sw = rw;
            hw = r;
        } word[31:0];
    } W_2F0 @ 0x2F0;

    reg {
        name = "Word 0x2F8";
        desc = "Word 0x2F8. PROVEN: stored byte lanes 0123, cleared bit extents none seen, ORed constants none, written by VPSS_HAL_SetNext (1 stores). Meaning UNKNOWN.";
        field {
            name = "word";
            desc = "32-bit word.";
            sw = rw;
            hw = r;
        } word[31:0];
    } W_2F8 @ 0x2F8;

    reg {
        name = "Word 0x308";
        desc = "Word 0x308. PROVEN: stored byte lanes 0123, cleared bit extents none seen, ORed constants none, written by VPSS_HAL_SetMode (1 stores). Meaning UNKNOWN.";
        field {
            name = "word";
            desc = "32-bit word.";
            sw = rw;
            hw = r;
        } word[31:0];
    } W_308 @ 0x308;

    reg {
        name = "Word 0x400";
        desc = "Word 0x400. PROVEN: stored byte lanes 0123, cleared bit extents none seen, ORed constants none, written by VPSS_HAL_SetSrcImgType (1 stores). Meaning UNKNOWN.";
        field {
            name = "word";
            desc = "32-bit word.";
            sw = rw;
            hw = r;
        } word[31:0];
    } W_400 @ 0x400;

    reg {
        name = "Word 0x404";
        desc = "Word 0x404. PROVEN: stored byte lanes 0123, cleared bit extents none seen, ORed constants none, written by VPSS_HAL_SetSrcImgSize (1 stores). Meaning UNKNOWN.";
        field {
            name = "word";
            desc = "32-bit word.";
            sw = rw;
            hw = r;
        } word[31:0];
    } W_404 @ 0x404;

    reg {
        name = "Word 0x408";
        desc = "Word 0x408. PROVEN: stored byte lanes 0123, cleared bit extents none seen, ORed constants none, written by VPSS_HAL_SetCurCtrl, VPSS_HAL_SetSrcImgBitwidth (2 stores). Meaning UNKNOWN.";
        field {
            name = "word";
            desc = "32-bit word.";
            sw = rw;
            hw = r;
        } word[31:0];
    } W_408 @ 0x408;

    reg {
        name = "Word 0x40C";
        desc = "Word 0x40C. PROVEN: stored byte lanes 0123, cleared bit extents none seen, ORed constants none, written by VPSS_HAL_SetCurCtrl (1 stores). Meaning UNKNOWN.";
        field {
            name = "word";
            desc = "32-bit word.";
            sw = rw;
            hw = r;
        } word[31:0];
    } W_40C @ 0x40C;

    reg {
        name = "Word 0x410";
        desc = "Word 0x410. PROVEN: stored byte lanes 0123, cleared bit extents none seen, ORed constants none, written by VPSS_HAL_SetCurCtrl (1 stores). Meaning UNKNOWN.";
        field {
            name = "word";
            desc = "32-bit word.";
            sw = rw;
            hw = r;
        } word[31:0];
    } W_410 @ 0x410;

    reg {
        name = "Word 0x418";
        desc = "Word 0x418. PROVEN: stored byte lanes 0123, cleared bit extents none seen, ORed constants none, written by VPSS_HAL_SetCurCtrl (1 stores). Meaning UNKNOWN.";
        field {
            name = "word";
            desc = "32-bit word.";
            sw = rw;
            hw = r;
        } word[31:0];
    } W_418 @ 0x418;

    reg {
        name = "Word 0x420";
        desc = "Word 0x420. PROVEN: stored byte lanes 0123, cleared bit extents none seen, ORed constants none, written by VPSS_HAL_SetCurCtrl (1 stores). Meaning UNKNOWN.";
        field {
            name = "word";
            desc = "32-bit word.";
            sw = rw;
            hw = r;
        } word[31:0];
    } W_420 @ 0x420;

    reg {
        name = "Word 0x424";
        desc = "Word 0x424. PROVEN: stored byte lanes 0123, cleared bit extents none seen, ORed constants none, written by VPSS_HAL_SetCurCtrl (1 stores). Meaning UNKNOWN.";
        field {
            name = "word";
            desc = "32-bit word.";
            sw = rw;
            hw = r;
        } word[31:0];
    } W_424 @ 0x424;

    reg {
        name = "Word 0x42C";
        desc = "Word 0x42C. PROVEN: stored byte lanes 0123, cleared bit extents none seen, ORed constants none, written by VPSS_HAL_SetCurCtrl (1 stores). Meaning UNKNOWN.";
        field {
            name = "word";
            desc = "32-bit word.";
            sw = rw;
            hw = r;
        } word[31:0];
    } W_42C @ 0x42C;

    reg {
        name = "Word 0x434";
        desc = "Word 0x434. PROVEN: stored byte lanes 0123, cleared bit extents none seen, ORed constants none, written by VPSS_HAL_SetCurCtrl (1 stores). Meaning UNKNOWN.";
        field {
            name = "word";
            desc = "32-bit word.";
            sw = rw;
            hw = r;
        } word[31:0];
    } W_434 @ 0x434;

    reg {
        name = "Word 0x44C";
        desc = "Word 0x44C. PROVEN: stored byte lanes 0123, cleared bit extents none seen, ORed constants none, written by VPSS_HAL_SetChnImgSize (1 stores). Meaning UNKNOWN.";
        field {
            name = "word";
            desc = "32-bit word.";
            sw = rw;
            hw = r;
        } word[31:0];
    } W_44C @ 0x44C;

    reg {
        name = "Word 0x450";
        desc = "Word 0x450. PROVEN: stored byte lanes 0123, cleared bit extents none seen, ORed constants none, written by VPSS_HAL_SetChnBufWrap, VPSS_HAL_SetChnCtrl, VPSS_HAL_SetChnEn (3 stores). Meaning UNKNOWN.";
        field {
            name = "word";
            desc = "32-bit word.";
            sw = rw;
            hw = r;
        } word[31:0];
    } W_450 @ 0x450;

    reg {
        name = "Word 0x454";
        desc = "Word 0x454. PROVEN: stored byte lanes 0123, cleared bit extents none seen, ORed constants none, written by VPSS_HAL_SetChnOffset (1 stores). Meaning UNKNOWN.";
        field {
            name = "word";
            desc = "32-bit word.";
            sw = rw;
            hw = r;
        } word[31:0];
    } W_454 @ 0x454;

    reg {
        name = "Word 0x458";
        desc = "Word 0x458. PROVEN: stored byte lanes 0123, cleared bit extents none seen, ORed constants none, written by VPSS_HAL_SetChnBufWrap (1 stores). Meaning UNKNOWN.";
        field {
            name = "word";
            desc = "32-bit word.";
            sw = rw;
            hw = r;
        } word[31:0];
    } W_458 @ 0x458;

    reg {
        name = "Word 0x45C";
        desc = "Word 0x45C. PROVEN: stored byte lanes 0123, cleared bit extents none seen, ORed constants none, written by VPSS_HAL_SetChnBufWrap (1 stores). Meaning UNKNOWN.";
        field {
            name = "word";
            desc = "32-bit word.";
            sw = rw;
            hw = r;
        } word[31:0];
    } W_45C @ 0x45C;

    reg {
        name = "Word 0x460";
        desc = "Word 0x460. PROVEN: stored byte lanes 0123, cleared bit extents none seen, ORed constants none, written by VPSS_HAL_SetChnBufWrap (1 stores). Meaning UNKNOWN.";
        field {
            name = "word";
            desc = "32-bit word.";
            sw = rw;
            hw = r;
        } word[31:0];
    } W_460 @ 0x460;

    reg {
        name = "Word 0x464";
        desc = "Word 0x464. PROVEN: stored byte lanes 0123, cleared bit extents none seen, ORed constants none, written by VPSS_HAL_SetChnBufWrap (1 stores). Meaning UNKNOWN.";
        field {
            name = "word";
            desc = "32-bit word.";
            sw = rw;
            hw = r;
        } word[31:0];
    } W_464 @ 0x464;

    reg {
        name = "Word 0x468";
        desc = "Word 0x468. PROVEN: stored byte lanes 0123, cleared bit extents none seen, ORed constants none, written by VPSS_HAL_SetChnPicAddr (1 stores). Meaning UNKNOWN.";
        field {
            name = "word";
            desc = "32-bit word.";
            sw = rw;
            hw = r;
        } word[31:0];
    } W_468 @ 0x468;

    reg {
        name = "Word 0x470";
        desc = "Word 0x470. PROVEN: stored byte lanes 0123, cleared bit extents none seen, ORed constants none, written by VPSS_HAL_SetChnPicAddr (1 stores). Meaning UNKNOWN.";
        field {
            name = "word";
            desc = "32-bit word.";
            sw = rw;
            hw = r;
        } word[31:0];
    } W_470 @ 0x470;

    reg {
        name = "Word 0x478";
        desc = "Word 0x478. PROVEN: stored byte lanes 0123, cleared bit extents none seen, ORed constants none, written by VPSS_HAL_SetChnPicAddr (1 stores). Meaning UNKNOWN.";
        field {
            name = "word";
            desc = "32-bit word.";
            sw = rw;
            hw = r;
        } word[31:0];
    } W_478 @ 0x478;

    reg {
        name = "Word 0x480";
        desc = "Word 0x480. PROVEN: stored byte lanes 0123, cleared bit extents none seen, ORed constants none, written by VPSS_HAL_SetChnPicAddr (1 stores). Meaning UNKNOWN.";
        field {
            name = "word";
            desc = "32-bit word.";
            sw = rw;
            hw = r;
        } word[31:0];
    } W_480 @ 0x480;

    reg {
        name = "Word 0x488";
        desc = "Word 0x488. PROVEN: stored byte lanes 0123, cleared bit extents none seen, ORed constants none, written by VPSS_HAL_SetChnPicAddr (1 stores). Meaning UNKNOWN.";
        field {
            name = "word";
            desc = "32-bit word.";
            sw = rw;
            hw = r;
        } word[31:0];
    } W_488 @ 0x488;

    reg {
        name = "Word 0x4A0";
        desc = "Word 0x4A0. PROVEN: stored byte lanes 0123, cleared bit extents none seen, ORed constants none, written by VPSS_HAL_SetChnImgSize (1 stores). Meaning UNKNOWN.";
        field {
            name = "word";
            desc = "32-bit word.";
            sw = rw;
            hw = r;
        } word[31:0];
    } W_4A0 @ 0x4A0;

    reg {
        name = "Word 0x4A4";
        desc = "Word 0x4A4. PROVEN: stored byte lanes 0123, cleared bit extents none seen, ORed constants none, written by VPSS_HAL_SetChnCtrl, VPSS_HAL_SetChnEn (2 stores). Meaning UNKNOWN.";
        field {
            name = "word";
            desc = "32-bit word.";
            sw = rw;
            hw = r;
        } word[31:0];
    } W_4A4 @ 0x4A4;

    reg {
        name = "Word 0x4AC";
        desc = "Word 0x4AC. PROVEN: stored byte lanes 0123, cleared bit extents none seen, ORed constants none, written by VPSS_HAL_SetChnOffset (1 stores). Meaning UNKNOWN.";
        field {
            name = "word";
            desc = "32-bit word.";
            sw = rw;
            hw = r;
        } word[31:0];
    } W_4AC @ 0x4AC;

    reg {
        name = "Word 0x4B0";
        desc = "Word 0x4B0. PROVEN: stored byte lanes 0123, cleared bit extents none seen, ORed constants none, written by VPSS_HAL_SetChnPicAddr (1 stores). Meaning UNKNOWN.";
        field {
            name = "word";
            desc = "32-bit word.";
            sw = rw;
            hw = r;
        } word[31:0];
    } W_4B0 @ 0x4B0;

    reg {
        name = "Word 0x4B8";
        desc = "Word 0x4B8. PROVEN: stored byte lanes 0123, cleared bit extents none seen, ORed constants none, written by VPSS_HAL_SetChnPicAddr (1 stores). Meaning UNKNOWN.";
        field {
            name = "word";
            desc = "32-bit word.";
            sw = rw;
            hw = r;
        } word[31:0];
    } W_4B8 @ 0x4B8;

    reg {
        name = "Word 0x4C0";
        desc = "Word 0x4C0. PROVEN: stored byte lanes 0123, cleared bit extents none seen, ORed constants none, written by VPSS_HAL_SetChnPicAddr (1 stores). Meaning UNKNOWN.";
        field {
            name = "word";
            desc = "32-bit word.";
            sw = rw;
            hw = r;
        } word[31:0];
    } W_4C0 @ 0x4C0;

    reg {
        name = "Word 0x4C8";
        desc = "Word 0x4C8. PROVEN: stored byte lanes 0123, cleared bit extents none seen, ORed constants none, written by VPSS_HAL_SetChnPicAddr (1 stores). Meaning UNKNOWN.";
        field {
            name = "word";
            desc = "32-bit word.";
            sw = rw;
            hw = r;
        } word[31:0];
    } W_4C8 @ 0x4C8;

    reg {
        name = "Word 0x4D0";
        desc = "Word 0x4D0. PROVEN: stored byte lanes 0123, cleared bit extents none seen, ORed constants none, written by VPSS_HAL_SetChnPicAddr (1 stores). Meaning UNKNOWN.";
        field {
            name = "word";
            desc = "32-bit word.";
            sw = rw;
            hw = r;
        } word[31:0];
    } W_4D0 @ 0x4D0;

    reg {
        name = "Word 0x4E8";
        desc = "Word 0x4E8. PROVEN: stored byte lanes 0123, cleared bit extents none seen, ORed constants none, written by VPSS_HAL_SetChnImgSize (1 stores). Meaning UNKNOWN.";
        field {
            name = "word";
            desc = "32-bit word.";
            sw = rw;
            hw = r;
        } word[31:0];
    } W_4E8 @ 0x4E8;

    reg {
        name = "Word 0x4EC";
        desc = "Word 0x4EC. PROVEN: stored byte lanes 0123, cleared bit extents none seen, ORed constants none, written by VPSS_HAL_SetChnCtrl, VPSS_HAL_SetChnEn (2 stores). Meaning UNKNOWN.";
        field {
            name = "word";
            desc = "32-bit word.";
            sw = rw;
            hw = r;
        } word[31:0];
    } W_4EC @ 0x4EC;

    reg {
        name = "Word 0x4F0";
        desc = "Word 0x4F0. PROVEN: stored byte lanes 0123, cleared bit extents none seen, ORed constants none, written by VPSS_HAL_SetChnOffset (1 stores). Meaning UNKNOWN.";
        field {
            name = "word";
            desc = "32-bit word.";
            sw = rw;
            hw = r;
        } word[31:0];
    } W_4F0 @ 0x4F0;

    reg {
        name = "Word 0x4F4";
        desc = "Word 0x4F4. PROVEN: stored byte lanes 0123, cleared bit extents none seen, ORed constants none, written by VPSS_HAL_SetChnPicAddr (1 stores). Meaning UNKNOWN.";
        field {
            name = "word";
            desc = "32-bit word.";
            sw = rw;
            hw = r;
        } word[31:0];
    } W_4F4 @ 0x4F4;

    reg {
        name = "Word 0x4FC";
        desc = "Word 0x4FC. PROVEN: stored byte lanes 0123, cleared bit extents none seen, ORed constants none, written by VPSS_HAL_SetChnPicAddr (1 stores). Meaning UNKNOWN.";
        field {
            name = "word";
            desc = "32-bit word.";
            sw = rw;
            hw = r;
        } word[31:0];
    } W_4FC @ 0x4FC;

    reg {
        name = "Word 0x504";
        desc = "Word 0x504. PROVEN: stored byte lanes 0123, cleared bit extents none seen, ORed constants none, written by VPSS_HAL_SetChnPicAddr (1 stores). Meaning UNKNOWN.";
        field {
            name = "word";
            desc = "32-bit word.";
            sw = rw;
            hw = r;
        } word[31:0];
    } W_504 @ 0x504;

    reg {
        name = "Word 0x50C";
        desc = "Word 0x50C. PROVEN: stored byte lanes 0123, cleared bit extents none seen, ORed constants none, written by VPSS_HAL_SetChnPicAddr (1 stores). Meaning UNKNOWN.";
        field {
            name = "word";
            desc = "32-bit word.";
            sw = rw;
            hw = r;
        } word[31:0];
    } W_50C @ 0x50C;

    reg {
        name = "Word 0x514";
        desc = "Word 0x514. PROVEN: stored byte lanes 0123, cleared bit extents none seen, ORed constants none, written by VPSS_HAL_SetChnPicAddr (1 stores). Meaning UNKNOWN.";
        field {
            name = "word";
            desc = "32-bit word.";
            sw = rw;
            hw = r;
        } word[31:0];
    } W_514 @ 0x514;

    reg {
        name = "Word 0x578";
        desc = "Word 0x578. PROVEN: stored byte lanes 0123, cleared bit extents none seen, ORed constants none, written by VPSS_HAL_SetGrpLowDelayAddr (1 stores). Meaning UNKNOWN.";
        field {
            name = "word";
            desc = "32-bit word.";
            sw = rw;
            hw = r;
        } word[31:0];
    } W_578 @ 0x578;

    reg {
        name = "Word 0x584";
        desc = "Word 0x584. PROVEN: stored byte lanes 0123, cleared bit extents none seen, ORed constants none, written by VPSS_HAL_SetChnLowDelayAddr (1 stores). Meaning UNKNOWN.";
        field {
            name = "word";
            desc = "32-bit word.";
            sw = rw;
            hw = r;
        } word[31:0];
    } W_584 @ 0x584;

    reg {
        name = "Word 0x58C";
        desc = "Word 0x58C. PROVEN: stored byte lanes 0123, cleared bit extents none seen, ORed constants none, written by VPSS_HAL_SetChnLowDelayAddr (1 stores). Meaning UNKNOWN.";
        field {
            name = "word";
            desc = "32-bit word.";
            sw = rw;
            hw = r;
        } word[31:0];
    } W_58C @ 0x58C;

    reg {
        name = "Word 0x594";
        desc = "Word 0x594. PROVEN: stored byte lanes 0123, cleared bit extents none seen, ORed constants none, written by VPSS_HAL_SetChnLowDelayAddr (1 stores). Meaning UNKNOWN.";
        field {
            name = "word";
            desc = "32-bit word.";
            sw = rw;
            hw = r;
        } word[31:0];
    } W_594 @ 0x594;

    reg {
        name = "Word 0x59C";
        desc = "Word 0x59C. PROVEN: stored byte lanes 0123, cleared bit extents none seen, ORed constants none, written by VPSS_HAL_SetChnLowDelayAttr (1 stores). Meaning UNKNOWN.";
        field {
            name = "word";
            desc = "32-bit word.";
            sw = rw;
            hw = r;
        } word[31:0];
    } W_59C @ 0x59C;

    reg {
        name = "Word 0x5A0";
        desc = "Word 0x5A0. PROVEN: stored byte lanes 0123, cleared bit extents none seen, ORed constants none, written by VPSS_HAL_SetChnBufWrap, VPSS_HAL_SetChnLowDelayAttr (2 stores). Meaning UNKNOWN.";
        field {
            name = "word";
            desc = "32-bit word.";
            sw = rw;
            hw = r;
        } word[31:0];
    } W_5A0 @ 0x5A0;

    reg {
        name = "Word 0x5A4";
        desc = "Word 0x5A4. PROVEN: stored byte lanes 0123, cleared bit extents none seen, ORed constants none, written by VPSS_HAL_SetRefConfig (1 stores). Meaning UNKNOWN.";
        field {
            name = "word";
            desc = "32-bit word.";
            sw = rw;
            hw = r;
        } word[31:0];
    } W_5A4 @ 0x5A4;

    reg {
        name = "Word 0x5A8";
        desc = "Word 0x5A8. PROVEN: stored byte lanes 0123, cleared bit extents none seen, ORed constants none, written by VPSS_HAL_SetRefConfig (1 stores). Meaning UNKNOWN.";
        field {
            name = "word";
            desc = "32-bit word.";
            sw = rw;
            hw = r;
        } word[31:0];
    } W_5A8 @ 0x5A8;

    reg {
        name = "Word 0x5AC";
        desc = "Word 0x5AC. PROVEN: stored byte lanes 0123, cleared bit extents none seen, ORed constants none, written by VPSS_HAL_SetRefConfig (1 stores). Meaning UNKNOWN.";
        field {
            name = "word";
            desc = "32-bit word.";
            sw = rw;
            hw = r;
        } word[31:0];
    } W_5AC @ 0x5AC;

    reg {
        name = "Word 0x5B0";
        desc = "Word 0x5B0. PROVEN: stored byte lanes 0123, cleared bit extents none seen, ORed constants none, written by VPSS_HAL_SetRefConfig (1 stores). Meaning UNKNOWN.";
        field {
            name = "word";
            desc = "32-bit word.";
            sw = rw;
            hw = r;
        } word[31:0];
    } W_5B0 @ 0x5B0;

    reg {
        name = "Word 0x5B8";
        desc = "Word 0x5B8. PROVEN: stored byte lanes 0123, cleared bit extents none seen, ORed constants none, written by VPSS_HAL_SetRefConfig (1 stores). Meaning UNKNOWN.";
        field {
            name = "word";
            desc = "32-bit word.";
            sw = rw;
            hw = r;
        } word[31:0];
    } W_5B8 @ 0x5B8;

    reg {
        name = "Word 0x5C0";
        desc = "Word 0x5C0. PROVEN: stored byte lanes 0123, cleared bit extents none seen, ORed constants none, written by VPSS_HAL_SetRefConfig (1 stores). Meaning UNKNOWN.";
        field {
            name = "word";
            desc = "32-bit word.";
            sw = rw;
            hw = r;
        } word[31:0];
    } W_5C0 @ 0x5C0;

    reg {
        name = "Word 0x5C8";
        desc = "Word 0x5C8. PROVEN: stored byte lanes 0123, cleared bit extents none seen, ORed constants none, written by VPSS_HAL_SetRefConfig (1 stores). Meaning UNKNOWN.";
        field {
            name = "word";
            desc = "32-bit word.";
            sw = rw;
            hw = r;
        } word[31:0];
    } W_5C8 @ 0x5C8;

    reg {
        name = "Word 0x5D0";
        desc = "Word 0x5D0. PROVEN: stored byte lanes 0123, cleared bit extents none seen, ORed constants none, written by VPSS_HAL_SetRefConfig (1 stores). Meaning UNKNOWN.";
        field {
            name = "word";
            desc = "32-bit word.";
            sw = rw;
            hw = r;
        } word[31:0];
    } W_5D0 @ 0x5D0;

    reg {
        name = "Word 0x5E8";
        desc = "Word 0x5E8. PROVEN: stored byte lanes 0123, cleared bit extents none seen, ORed constants none, written by VPSS_HAL_SetRfrConfig (1 stores). Meaning UNKNOWN.";
        field {
            name = "word";
            desc = "32-bit word.";
            sw = rw;
            hw = r;
        } word[31:0];
    } W_5E8 @ 0x5E8;

    reg {
        name = "Word 0x5EC";
        desc = "Word 0x5EC. PROVEN: stored byte lanes 0123, cleared bit extents none seen, ORed constants none, written by VPSS_HAL_SetRfrConfig (1 stores). Meaning UNKNOWN.";
        field {
            name = "word";
            desc = "32-bit word.";
            sw = rw;
            hw = r;
        } word[31:0];
    } W_5EC @ 0x5EC;

    reg {
        name = "Word 0x5F0";
        desc = "Word 0x5F0. PROVEN: stored byte lanes 0123, cleared bit extents none seen, ORed constants none, written by VPSS_HAL_SetRfrConfig (1 stores). Meaning UNKNOWN.";
        field {
            name = "word";
            desc = "32-bit word.";
            sw = rw;
            hw = r;
        } word[31:0];
    } W_5F0 @ 0x5F0;

    reg {
        name = "Word 0x5F4";
        desc = "Word 0x5F4. PROVEN: stored byte lanes 0123, cleared bit extents none seen, ORed constants none, written by VPSS_HAL_SetRfrConfig (1 stores). Meaning UNKNOWN.";
        field {
            name = "word";
            desc = "32-bit word.";
            sw = rw;
            hw = r;
        } word[31:0];
    } W_5F4 @ 0x5F4;

    reg {
        name = "Word 0x5F8";
        desc = "Word 0x5F8. PROVEN: stored byte lanes 0123, cleared bit extents none seen, ORed constants none, written by VPSS_HAL_SetRfrConfig (1 stores). Meaning UNKNOWN.";
        field {
            name = "word";
            desc = "32-bit word.";
            sw = rw;
            hw = r;
        } word[31:0];
    } W_5F8 @ 0x5F8;

    reg {
        name = "Word 0x5FC";
        desc = "Word 0x5FC. PROVEN: stored byte lanes 0123, cleared bit extents none seen, ORed constants none, written by VPSS_HAL_SetRfrConfig (1 stores). Meaning UNKNOWN.";
        field {
            name = "word";
            desc = "32-bit word.";
            sw = rw;
            hw = r;
        } word[31:0];
    } W_5FC @ 0x5FC;

    reg {
        name = "Word 0x600";
        desc = "Word 0x600. PROVEN: stored byte lanes 0123, cleared bit extents none seen, ORed constants none, written by VPSS_HAL_SetRfrConfig (1 stores). Meaning UNKNOWN.";
        field {
            name = "word";
            desc = "32-bit word.";
            sw = rw;
            hw = r;
        } word[31:0];
    } W_600 @ 0x600;

    reg {
        name = "Word 0x608";
        desc = "Word 0x608. PROVEN: stored byte lanes 0123, cleared bit extents none seen, ORed constants none, written by VPSS_HAL_SetRfrConfig (1 stores). Meaning UNKNOWN.";
        field {
            name = "word";
            desc = "32-bit word.";
            sw = rw;
            hw = r;
        } word[31:0];
    } W_608 @ 0x608;

    reg {
        name = "Word 0x610";
        desc = "Word 0x610. PROVEN: stored byte lanes 0123, cleared bit extents none seen, ORed constants none, written by VPSS_HAL_SetRfrConfig (1 stores). Meaning UNKNOWN.";
        field {
            name = "word";
            desc = "32-bit word.";
            sw = rw;
            hw = r;
        } word[31:0];
    } W_610 @ 0x610;

    reg {
        name = "Word 0x618";
        desc = "Word 0x618. PROVEN: stored byte lanes 0123, cleared bit extents none seen, ORed constants none, written by VPSS_HAL_SetRfrConfig (1 stores). Meaning UNKNOWN.";
        field {
            name = "word";
            desc = "32-bit word.";
            sw = rw;
            hw = r;
        } word[31:0];
    } W_618 @ 0x618;

    reg {
        name = "Word 0x620";
        desc = "Word 0x620. PROVEN: stored byte lanes 0123, cleared bit extents none seen, ORed constants none, written by VPSS_HAL_SetRfrConfig (1 stores). Meaning UNKNOWN.";
        field {
            name = "word";
            desc = "32-bit word.";
            sw = rw;
            hw = r;
        } word[31:0];
    } W_620 @ 0x620;

    reg {
        name = "Word 0x638";
        desc = "Word 0x638. PROVEN: stored byte lanes 0123, cleared bit extents none seen, ORed constants none, written by VPSS_HAL_SetMadConfig (1 stores). Meaning UNKNOWN.";
        field {
            name = "word";
            desc = "32-bit word.";
            sw = rw;
            hw = r;
        } word[31:0];
    } W_638 @ 0x638;

    reg {
        name = "Word 0x63C";
        desc = "Word 0x63C. PROVEN: stored byte lanes 0123, cleared bit extents none seen, ORed constants none, written by VPSS_HAL_SetMadConfig (1 stores). Meaning UNKNOWN.";
        field {
            name = "word";
            desc = "32-bit word.";
            sw = rw;
            hw = r;
        } word[31:0];
    } W_63C @ 0x63C;

    reg {
        name = "Word 0x640";
        desc = "Word 0x640. PROVEN: stored byte lanes 0123, cleared bit extents none seen, ORed constants none, written by VPSS_HAL_SetMadConfig (1 stores). Meaning UNKNOWN.";
        field {
            name = "word";
            desc = "32-bit word.";
            sw = rw;
            hw = r;
        } word[31:0];
    } W_640 @ 0x640;

    reg {
        name = "Word 0x648";
        desc = "Word 0x648. PROVEN: stored byte lanes 0123, cleared bit extents none seen, ORed constants none, written by VPSS_HAL_SetMadConfig (1 stores). Meaning UNKNOWN.";
        field {
            name = "word";
            desc = "32-bit word.";
            sw = rw;
            hw = r;
        } word[31:0];
    } W_648 @ 0x648;

    reg {
        name = "Word 0x64C";
        desc = "Word 0x64C. PROVEN: stored byte lanes 0123, cleared bit extents none seen, ORed constants none, written by VPSS_HAL_SetMadConfig (1 stores). Meaning UNKNOWN.";
        field {
            name = "word";
            desc = "32-bit word.";
            sw = rw;
            hw = r;
        } word[31:0];
    } W_64C @ 0x64C;

    reg {
        name = "Word 0x650";
        desc = "Word 0x650. PROVEN: stored byte lanes 0123, cleared bit extents none seen, ORed constants none, written by VPSS_HAL_SetMadConfig (1 stores). Meaning UNKNOWN.";
        field {
            name = "word";
            desc = "32-bit word.";
            sw = rw;
            hw = r;
        } word[31:0];
    } W_650 @ 0x650;

    reg {
        name = "Word 0x654";
        desc = "Word 0x654. PROVEN: stored byte lanes 0123, cleared bit extents none seen, ORed constants none, written by VPSS_HAL_SetMadConfig (1 stores). Meaning UNKNOWN.";
        field {
            name = "word";
            desc = "32-bit word.";
            sw = rw;
            hw = r;
        } word[31:0];
    } W_654 @ 0x654;

    reg {
        name = "Word 0x65C";
        desc = "Word 0x65C. PROVEN: stored byte lanes 0123, cleared bit extents none seen, ORed constants none, written by VPSS_HAL_SetMadConfig (1 stores). Meaning UNKNOWN.";
        field {
            name = "word";
            desc = "32-bit word.";
            sw = rw;
            hw = r;
        } word[31:0];
    } W_65C @ 0x65C;

    reg {
        name = "Word 0x660";
        desc = "Word 0x660. PROVEN: stored byte lanes 0123, cleared bit extents none seen, ORed constants none, written by VPSS_HAL_SetMadConfig (1 stores). Meaning UNKNOWN.";
        field {
            name = "word";
            desc = "32-bit word.";
            sw = rw;
            hw = r;
        } word[31:0];
    } W_660 @ 0x660;

    reg {
        name = "Word 0x664";
        desc = "Word 0x664. PROVEN: stored byte lanes 0123, cleared bit extents none seen, ORed constants none, written by VPSS_HAL_SetMadConfig (1 stores). Meaning UNKNOWN.";
        field {
            name = "word";
            desc = "32-bit word.";
            sw = rw;
            hw = r;
        } word[31:0];
    } W_664 @ 0x664;

    reg {
        name = "Word 0x668";
        desc = "Word 0x668. PROVEN: stored byte lanes 0123, cleared bit extents none seen, ORed constants none, written by VPSS_HAL_SetMadConfig (1 stores). Meaning UNKNOWN.";
        field {
            name = "word";
            desc = "32-bit word.";
            sw = rw;
            hw = r;
        } word[31:0];
    } W_668 @ 0x668;

    reg {
        name = "Word 0x66C";
        desc = "Word 0x66C. PROVEN: stored byte lanes 0123, cleared bit extents none seen, ORed constants none, written by VPSS_HAL_SetMadConfig (1 stores). Meaning UNKNOWN.";
        field {
            name = "word";
            desc = "32-bit word.";
            sw = rw;
            hw = r;
        } word[31:0];
    } W_66C @ 0x66C;

    reg {
        name = "Word 0x670";
        desc = "Word 0x670. PROVEN: stored byte lanes 0123, cleared bit extents none seen, ORed constants none, written by VPSS_HAL_SetMadConfig (1 stores). Meaning UNKNOWN.";
        field {
            name = "word";
            desc = "32-bit word.";
            sw = rw;
            hw = r;
        } word[31:0];
    } W_670 @ 0x670;

    reg {
        name = "Word 0x678";
        desc = "Word 0x678. PROVEN: stored byte lanes 0123, cleared bit extents none seen, ORed constants none, written by VPSS_HAL_SetMadConfig (1 stores). Meaning UNKNOWN.";
        field {
            name = "word";
            desc = "32-bit word.";
            sw = rw;
            hw = r;
        } word[31:0];
    } W_678 @ 0x678;

    reg {
        name = "Word 0x67C";
        desc = "Word 0x67C. PROVEN: stored byte lanes 0123, cleared bit extents none seen, ORed constants none, written by VPSS_HAL_SetMadConfig (1 stores). Meaning UNKNOWN.";
        field {
            name = "word";
            desc = "32-bit word.";
            sw = rw;
            hw = r;
        } word[31:0];
    } W_67C @ 0x67C;

    reg {
        name = "Word 0x680";
        desc = "Word 0x680. PROVEN: stored byte lanes 0123, cleared bit extents none seen, ORed constants none, written by VPSS_HAL_SetMadConfig (1 stores). Meaning UNKNOWN.";
        field {
            name = "word";
            desc = "32-bit word.";
            sw = rw;
            hw = r;
        } word[31:0];
    } W_680 @ 0x680;

    reg {
        name = "Word 0x684";
        desc = "Word 0x684. PROVEN: stored byte lanes 0123, cleared bit extents none seen, ORed constants none, written by VPSS_HAL_SetMadConfig (1 stores). Meaning UNKNOWN.";
        field {
            name = "word";
            desc = "32-bit word.";
            sw = rw;
            hw = r;
        } word[31:0];
    } W_684 @ 0x684;

    reg {
        name = "Word 0x688";
        desc = "Word 0x688. PROVEN: stored byte lanes 0123, cleared bit extents none seen, ORed constants none, written by VPSS_HAL_SetMadConfig (1 stores). Meaning UNKNOWN.";
        field {
            name = "word";
            desc = "32-bit word.";
            sw = rw;
            hw = r;
        } word[31:0];
    } W_688 @ 0x688;

    reg {
        name = "Word 0x68C";
        desc = "Word 0x68C. PROVEN: stored byte lanes 0123, cleared bit extents none seen, ORed constants none, written by VPSS_HAL_SetMadConfig (1 stores). Meaning UNKNOWN.";
        field {
            name = "word";
            desc = "32-bit word.";
            sw = rw;
            hw = r;
        } word[31:0];
    } W_68C @ 0x68C;

    reg {
        name = "Word 0x694";
        desc = "Word 0x694. PROVEN: stored byte lanes 0123, cleared bit extents none seen, ORed constants none, written by VPSS_HAL_SetMadConfig (1 stores). Meaning UNKNOWN.";
        field {
            name = "word";
            desc = "32-bit word.";
            sw = rw;
            hw = r;
        } word[31:0];
    } W_694 @ 0x694;

    reg {
        name = "Word 0x698";
        desc = "Word 0x698. PROVEN: stored byte lanes 0123, cleared bit extents none seen, ORed constants none, written by VPSS_HAL_SetHeadInfo (2 stores). Meaning UNKNOWN.";
        field {
            name = "word";
            desc = "32-bit word.";
            sw = rw;
            hw = r;
        } word[31:0];
    } W_698 @ 0x698;

    reg {
        name = "Word 0x6A0";
        desc = "Word 0x6A0. PROVEN: stored byte lanes 0123, cleared bit extents none seen, ORed constants none, written by VPSS_HAL_SetHeadInfo (1 stores). Meaning UNKNOWN.";
        field {
            name = "word";
            desc = "32-bit word.";
            sw = rw;
            hw = r;
        } word[31:0];
    } W_6A0 @ 0x6A0;

    reg {
        name = "Word 0x6A4";
        desc = "Word 0x6A4. PROVEN: stored byte lanes 0123, cleared bit extents none seen, ORed constants none, written by VPSS_HAL_SetHeadInfo (3 stores). Meaning UNKNOWN.";
        field {
            name = "word";
            desc = "32-bit word.";
            sw = rw;
            hw = r;
        } word[31:0];
    } W_6A4 @ 0x6A4;

    reg {
        name = "Word 0x6A8";
        desc = "Word 0x6A8. PROVEN: stored byte lanes 0123, cleared bit extents none seen, ORed constants none, written by VPSS_HAL_SetHeadInfo (2 stores). Meaning UNKNOWN.";
        field {
            name = "word";
            desc = "32-bit word.";
            sw = rw;
            hw = r;
        } word[31:0];
    } W_6A8 @ 0x6A8;

    reg {
        name = "Word 0x6AC";
        desc = "Word 0x6AC. PROVEN: stored byte lanes 0123, cleared bit extents none seen, ORed constants none, written by VPSS_HAL_SetHeadInfo (2 stores). Meaning UNKNOWN.";
        field {
            name = "word";
            desc = "32-bit word.";
            sw = rw;
            hw = r;
        } word[31:0];
    } W_6AC @ 0x6AC;

    reg {
        name = "Word 0x6B0";
        desc = "Word 0x6B0. PROVEN: stored byte lanes 0123, cleared bit extents none seen, ORed constants none, written by VPSS_HAL_SetHeadInfo (2 stores). Meaning UNKNOWN.";
        field {
            name = "word";
            desc = "32-bit word.";
            sw = rw;
            hw = r;
        } word[31:0];
    } W_6B0 @ 0x6B0;

    reg {
        name = "Word 0x6B4";
        desc = "Word 0x6B4. PROVEN: stored byte lanes 0123, cleared bit extents none seen, ORed constants none, written by VPSS_HAL_SetHeadInfo (2 stores). Meaning UNKNOWN.";
        field {
            name = "word";
            desc = "32-bit word.";
            sw = rw;
            hw = r;
        } word[31:0];
    } W_6B4 @ 0x6B4;

    reg {
        name = "Word 0x6B8";
        desc = "Word 0x6B8. PROVEN: stored byte lanes 0123, cleared bit extents none seen, ORed constants none, written by VPSS_HAL_SetHeadInfo (2 stores). Meaning UNKNOWN.";
        field {
            name = "word";
            desc = "32-bit word.";
            sw = rw;
            hw = r;
        } word[31:0];
    } W_6B8 @ 0x6B8;

    reg {
        name = "Word 0x6BC";
        desc = "Word 0x6BC. PROVEN: stored byte lanes 0123, cleared bit extents none seen, ORed constants none, written by VPSS_HAL_SetHeadInfo (2 stores). Meaning UNKNOWN.";
        field {
            name = "word";
            desc = "32-bit word.";
            sw = rw;
            hw = r;
        } word[31:0];
    } W_6BC @ 0x6BC;

    reg {
        name = "Word 0x6C0";
        desc = "Word 0x6C0. PROVEN: stored byte lanes 0123, cleared bit extents none seen, ORed constants none, written by VPSS_HAL_SetHeadInfo (2 stores). Meaning UNKNOWN.";
        field {
            name = "word";
            desc = "32-bit word.";
            sw = rw;
            hw = r;
        } word[31:0];
    } W_6C0 @ 0x6C0;

    reg {
        name = "Word 0x6C4";
        desc = "Word 0x6C4. PROVEN: stored byte lanes 0123, cleared bit extents none seen, ORed constants none, written by VPSS_HAL_SetHeadInfo (2 stores). Meaning UNKNOWN.";
        field {
            name = "word";
            desc = "32-bit word.";
            sw = rw;
            hw = r;
        } word[31:0];
    } W_6C4 @ 0x6C4;

    reg {
        name = "Word 0x6C8";
        desc = "Word 0x6C8. PROVEN: stored byte lanes 0123, cleared bit extents none seen, ORed constants none, written by VPSS_HAL_SetOnlineChnScaleCoeff (1 stores). Meaning UNKNOWN.";
        field {
            name = "word";
            desc = "32-bit word.";
            sw = rw;
            hw = r;
        } word[31:0];
    } W_6C8 @ 0x6C8;

    reg {
        name = "Word 0x6CC";
        desc = "Word 0x6CC. PROVEN: stored byte lanes 0123, cleared bit extents none seen, ORed constants none, written by VPSS_HAL_SetOnlineChnScaleCoeff (1 stores). Meaning UNKNOWN.";
        field {
            name = "word";
            desc = "32-bit word.";
            sw = rw;
            hw = r;
        } word[31:0];
    } W_6CC @ 0x6CC;

    reg {
        name = "Word 0x6D0";
        desc = "Word 0x6D0. PROVEN: stored byte lanes 0123, cleared bit extents none seen, ORed constants none, written by VPSS_HAL_SetOnlineChnScaleCoeff (1 stores). Meaning UNKNOWN.";
        field {
            name = "word";
            desc = "32-bit word.";
            sw = rw;
            hw = r;
        } word[31:0];
    } W_6D0 @ 0x6D0;

    reg {
        name = "Word 0x6D4";
        desc = "Word 0x6D4. PROVEN: stored byte lanes 0123, cleared bit extents none seen, ORed constants none, written by VPSS_HAL_SetOnlineChnScaleCoeff (1 stores). Meaning UNKNOWN.";
        field {
            name = "word";
            desc = "32-bit word.";
            sw = rw;
            hw = r;
        } word[31:0];
    } W_6D4 @ 0x6D4;

    reg {
        name = "Word 0x6D8";
        desc = "Word 0x6D8. PROVEN: stored byte lanes 0123, cleared bit extents none seen, ORed constants none, written by VPSS_HAL_SetOnlineChnScaleCoeff (1 stores). Meaning UNKNOWN.";
        field {
            name = "word";
            desc = "32-bit word.";
            sw = rw;
            hw = r;
        } word[31:0];
    } W_6D8 @ 0x6D8;

    reg {
        name = "Word 0x6DC";
        desc = "Word 0x6DC. PROVEN: stored byte lanes 0123, cleared bit extents none seen, ORed constants none, written by VPSS_HAL_SetOnlineChnScaleCoeff (1 stores). Meaning UNKNOWN.";
        field {
            name = "word";
            desc = "32-bit word.";
            sw = rw;
            hw = r;
        } word[31:0];
    } W_6DC @ 0x6DC;

    reg {
        name = "Word 0x6E0";
        desc = "Word 0x6E0. PROVEN: stored byte lanes 0123, cleared bit extents none seen, ORed constants none, written by VPSS_HAL_SetOnlineChnScaleCoeff (1 stores). Meaning UNKNOWN.";
        field {
            name = "word";
            desc = "32-bit word.";
            sw = rw;
            hw = r;
        } word[31:0];
    } W_6E0 @ 0x6E0;

    reg {
        name = "Word 0x6E4";
        desc = "Word 0x6E4. PROVEN: stored byte lanes 0123, cleared bit extents none seen, ORed constants none, written by VPSS_HAL_SetOnlineChnScaleCoeff (1 stores). Meaning UNKNOWN.";
        field {
            name = "word";
            desc = "32-bit word.";
            sw = rw;
            hw = r;
        } word[31:0];
    } W_6E4 @ 0x6E4;

    reg {
        name = "Word 0x6E8";
        desc = "Word 0x6E8. PROVEN: stored byte lanes 0123, cleared bit extents none seen, ORed constants none, written by VPSS_HAL_SetOnlineChnScaleCoeff (1 stores). Meaning UNKNOWN.";
        field {
            name = "word";
            desc = "32-bit word.";
            sw = rw;
            hw = r;
        } word[31:0];
    } W_6E8 @ 0x6E8;

    reg {
        name = "Word 0x6EC";
        desc = "Word 0x6EC. PROVEN: stored byte lanes 0123, cleared bit extents none seen, ORed constants none, written by VPSS_HAL_SetOnlineChnScaleCoeff (1 stores). Meaning UNKNOWN.";
        field {
            name = "word";
            desc = "32-bit word.";
            sw = rw;
            hw = r;
        } word[31:0];
    } W_6EC @ 0x6EC;

    reg {
        name = "Word 0x6F0";
        desc = "Word 0x6F0. PROVEN: stored byte lanes 0123, cleared bit extents none seen, ORed constants none, written by VPSS_HAL_SetOnlineChnScaleCoeff (1 stores). Meaning UNKNOWN.";
        field {
            name = "word";
            desc = "32-bit word.";
            sw = rw;
            hw = r;
        } word[31:0];
    } W_6F0 @ 0x6F0;

    reg {
        name = "Word 0x6F4";
        desc = "Word 0x6F4. PROVEN: stored byte lanes 0123, cleared bit extents none seen, ORed constants none, written by VPSS_HAL_SetOnlineChnScaleCoeff (1 stores). Meaning UNKNOWN.";
        field {
            name = "word";
            desc = "32-bit word.";
            sw = rw;
            hw = r;
        } word[31:0];
    } W_6F4 @ 0x6F4;

    reg {
        name = "Word 0x700";
        desc = "Word 0x700. PROVEN: stored byte lanes 0123, cleared bit extents none seen, ORed constants none, written by VPSS_HAL_SetChnCmpAttr (1 stores). Meaning UNKNOWN.";
        field {
            name = "word";
            desc = "32-bit word.";
            sw = rw;
            hw = r;
        } word[31:0];
    } W_700 @ 0x700;

    reg {
        name = "Word 0x704";
        desc = "Word 0x704. PROVEN: stored byte lanes 0123, cleared bit extents none seen, ORed constants none, written by VPSS_HAL_SetChnCmpAttr (1 stores). Meaning UNKNOWN.";
        field {
            name = "word";
            desc = "32-bit word.";
            sw = rw;
            hw = r;
        } word[31:0];
    } W_704 @ 0x704;

    reg {
        name = "Word 0x708";
        desc = "Word 0x708. PROVEN: stored byte lanes 0123, cleared bit extents none seen, ORed constants none, written by VPSS_HAL_SetChnCmpAttr (1 stores). Meaning UNKNOWN.";
        field {
            name = "word";
            desc = "32-bit word.";
            sw = rw;
            hw = r;
        } word[31:0];
    } W_708 @ 0x708;

    reg {
        name = "Word 0x70C";
        desc = "Word 0x70C. PROVEN: stored byte lanes 0123, cleared bit extents none seen, ORed constants none, written by VPSS_HAL_SetChnCmpAttr (1 stores). Meaning UNKNOWN.";
        field {
            name = "word";
            desc = "32-bit word.";
            sw = rw;
            hw = r;
        } word[31:0];
    } W_70C @ 0x70C;

    reg {
        name = "Word 0x710";
        desc = "Word 0x710. PROVEN: stored byte lanes 0123, cleared bit extents none seen, ORed constants none, written by VPSS_HAL_SetChnCmpAttr (1 stores). Meaning UNKNOWN.";
        field {
            name = "word";
            desc = "32-bit word.";
            sw = rw;
            hw = r;
        } word[31:0];
    } W_710 @ 0x710;

    reg {
        name = "Word 0x714";
        desc = "Word 0x714. PROVEN: stored byte lanes 0123, cleared bit extents none seen, ORed constants none, written by VPSS_HAL_SetChnCmpAttr (1 stores). Meaning UNKNOWN.";
        field {
            name = "word";
            desc = "32-bit word.";
            sw = rw;
            hw = r;
        } word[31:0];
    } W_714 @ 0x714;

    reg {
        name = "Word 0x718";
        desc = "Word 0x718. PROVEN: stored byte lanes 0123, cleared bit extents none seen, ORed constants none, written by VPSS_HAL_SetChnCmpAttr (1 stores). Meaning UNKNOWN.";
        field {
            name = "word";
            desc = "32-bit word.";
            sw = rw;
            hw = r;
        } word[31:0];
    } W_718 @ 0x718;

    reg {
        name = "Word 0x71C";
        desc = "Word 0x71C. PROVEN: stored byte lanes 0123, cleared bit extents none seen, ORed constants none, written by VPSS_HAL_SetChnCmpAttr (1 stores). Meaning UNKNOWN.";
        field {
            name = "word";
            desc = "32-bit word.";
            sw = rw;
            hw = r;
        } word[31:0];
    } W_71C @ 0x71C;

    reg {
        name = "Word 0x720";
        desc = "Word 0x720. PROVEN: stored byte lanes 0123, cleared bit extents none seen, ORed constants none, written by VPSS_HAL_SetChnCmpAttr (1 stores). Meaning UNKNOWN.";
        field {
            name = "word";
            desc = "32-bit word.";
            sw = rw;
            hw = r;
        } word[31:0];
    } W_720 @ 0x720;

    reg {
        name = "Word 0x724";
        desc = "Word 0x724. PROVEN: stored byte lanes 0123, cleared bit extents none seen, ORed constants none, written by VPSS_HAL_SetChnCmpAttr (1 stores). Meaning UNKNOWN.";
        field {
            name = "word";
            desc = "32-bit word.";
            sw = rw;
            hw = r;
        } word[31:0];
    } W_724 @ 0x724;

    reg {
        name = "Word 0x728";
        desc = "Word 0x728. PROVEN: stored byte lanes 0123, cleared bit extents none seen, ORed constants none, written by VPSS_HAL_SetChnCmpAttr (1 stores). Meaning UNKNOWN.";
        field {
            name = "word";
            desc = "32-bit word.";
            sw = rw;
            hw = r;
        } word[31:0];
    } W_728 @ 0x728;

    reg {
        name = "Word 0x72C";
        desc = "Word 0x72C. PROVEN: stored byte lanes 0123, cleared bit extents none seen, ORed constants none, written by VPSS_HAL_SetChnCmpAttr (1 stores). Meaning UNKNOWN.";
        field {
            name = "word";
            desc = "32-bit word.";
            sw = rw;
            hw = r;
        } word[31:0];
    } W_72C @ 0x72C;

    reg {
        name = "Word 0x730";
        desc = "Word 0x730. PROVEN: stored byte lanes 0123, cleared bit extents none seen, ORed constants none, written by VPSS_HAL_SetChnCmpAttr (1 stores). Meaning UNKNOWN.";
        field {
            name = "word";
            desc = "32-bit word.";
            sw = rw;
            hw = r;
        } word[31:0];
    } W_730 @ 0x730;

    reg {
        name = "Word 0x734";
        desc = "Word 0x734. PROVEN: stored byte lanes 0123, cleared bit extents none seen, ORed constants none, written by VPSS_HAL_SetChnCmpAttr (1 stores). Meaning UNKNOWN.";
        field {
            name = "word";
            desc = "32-bit word.";
            sw = rw;
            hw = r;
        } word[31:0];
    } W_734 @ 0x734;

    reg {
        name = "Word 0x738";
        desc = "Word 0x738. PROVEN: stored byte lanes 0123, cleared bit extents none seen, ORed constants none, written by VPSS_HAL_SetChnCmpAttr (1 stores). Meaning UNKNOWN.";
        field {
            name = "word";
            desc = "32-bit word.";
            sw = rw;
            hw = r;
        } word[31:0];
    } W_738 @ 0x738;

    reg {
        name = "Word 0x73C";
        desc = "Word 0x73C. PROVEN: stored byte lanes 0123, cleared bit extents none seen, ORed constants none, written by VPSS_HAL_SetChnCmpAttr (1 stores). Meaning UNKNOWN.";
        field {
            name = "word";
            desc = "32-bit word.";
            sw = rw;
            hw = r;
        } word[31:0];
    } W_73C @ 0x73C;

    reg {
        name = "Word 0x740";
        desc = "Word 0x740. PROVEN: stored byte lanes 0123, cleared bit extents none seen, ORed constants none, written by VPSS_HAL_SetChnCmpAttr (1 stores). Meaning UNKNOWN.";
        field {
            name = "word";
            desc = "32-bit word.";
            sw = rw;
            hw = r;
        } word[31:0];
    } W_740 @ 0x740;

    reg {
        name = "Word 0x744";
        desc = "Word 0x744. PROVEN: stored byte lanes 0123, cleared bit extents none seen, ORed constants none, written by VPSS_HAL_SetChnCmpAttr (1 stores). Meaning UNKNOWN.";
        field {
            name = "word";
            desc = "32-bit word.";
            sw = rw;
            hw = r;
        } word[31:0];
    } W_744 @ 0x744;

    reg {
        name = "Word 0x748";
        desc = "Word 0x748. PROVEN: stored byte lanes 0123, cleared bit extents none seen, ORed constants none, written by VPSS_HAL_SetChnCmpAttr (1 stores). Meaning UNKNOWN.";
        field {
            name = "word";
            desc = "32-bit word.";
            sw = rw;
            hw = r;
        } word[31:0];
    } W_748 @ 0x748;

    reg {
        name = "Word 0x74C";
        desc = "Word 0x74C. PROVEN: stored byte lanes 0123, cleared bit extents none seen, ORed constants none, written by VPSS_HAL_SetChnCmpAttr (1 stores). Meaning UNKNOWN.";
        field {
            name = "word";
            desc = "32-bit word.";
            sw = rw;
            hw = r;
        } word[31:0];
    } W_74C @ 0x74C;

    reg {
        name = "Word 0x750";
        desc = "Word 0x750. PROVEN: stored byte lanes 0123, cleared bit extents none seen, ORed constants none, written by VPSS_HAL_SetChnCmpAttr (1 stores). Meaning UNKNOWN.";
        field {
            name = "word";
            desc = "32-bit word.";
            sw = rw;
            hw = r;
        } word[31:0];
    } W_750 @ 0x750;

    reg {
        name = "Word 0x754";
        desc = "Word 0x754. PROVEN: stored byte lanes 0123, cleared bit extents none seen, ORed constants none, written by VPSS_HAL_SetChnCmpAttr (1 stores). Meaning UNKNOWN.";
        field {
            name = "word";
            desc = "32-bit word.";
            sw = rw;
            hw = r;
        } word[31:0];
    } W_754 @ 0x754;

    reg {
        name = "Word 0x764";
        desc = "Word 0x764. PROVEN: stored byte lanes 0123, cleared bit extents none seen, ORed constants none, written by VPSS_HAL_SetChnCmpAttr (1 stores). Meaning UNKNOWN.";
        field {
            name = "word";
            desc = "32-bit word.";
            sw = rw;
            hw = r;
        } word[31:0];
    } W_764 @ 0x764;

    reg {
        name = "Word 0x768";
        desc = "Word 0x768. PROVEN: stored byte lanes 0123, cleared bit extents none seen, ORed constants none, written by VPSS_HAL_SetChnCmpAttr (1 stores). Meaning UNKNOWN.";
        field {
            name = "word";
            desc = "32-bit word.";
            sw = rw;
            hw = r;
        } word[31:0];
    } W_768 @ 0x768;

    reg {
        name = "Word 0x76C";
        desc = "Word 0x76C. PROVEN: stored byte lanes 0123, cleared bit extents none seen, ORed constants none, written by VPSS_HAL_SetChnCmpAttr (1 stores). Meaning UNKNOWN.";
        field {
            name = "word";
            desc = "32-bit word.";
            sw = rw;
            hw = r;
        } word[31:0];
    } W_76C @ 0x76C;

    reg {
        name = "Word 0x770";
        desc = "Word 0x770. PROVEN: stored byte lanes 0123, cleared bit extents none seen, ORed constants none, written by VPSS_HAL_SetChnCmpAttr (1 stores). Meaning UNKNOWN.";
        field {
            name = "word";
            desc = "32-bit word.";
            sw = rw;
            hw = r;
        } word[31:0];
    } W_770 @ 0x770;

    reg {
        name = "Word 0x774";
        desc = "Word 0x774. PROVEN: stored byte lanes 0123, cleared bit extents none seen, ORed constants none, written by VPSS_HAL_SetChnCmpAttr (1 stores). Meaning UNKNOWN.";
        field {
            name = "word";
            desc = "32-bit word.";
            sw = rw;
            hw = r;
        } word[31:0];
    } W_774 @ 0x774;

    reg {
        name = "Word 0x778";
        desc = "Word 0x778. PROVEN: stored byte lanes 0123, cleared bit extents none seen, ORed constants none, written by VPSS_HAL_SetChnCmpAttr (1 stores). Meaning UNKNOWN.";
        field {
            name = "word";
            desc = "32-bit word.";
            sw = rw;
            hw = r;
        } word[31:0];
    } W_778 @ 0x778;

    reg {
        name = "Word 0x77C";
        desc = "Word 0x77C. PROVEN: stored byte lanes 0123, cleared bit extents none seen, ORed constants none, written by VPSS_HAL_SetChnCmpAttr (1 stores). Meaning UNKNOWN.";
        field {
            name = "word";
            desc = "32-bit word.";
            sw = rw;
            hw = r;
        } word[31:0];
    } W_77C @ 0x77C;

    reg {
        name = "Word 0x780";
        desc = "Word 0x780. PROVEN: stored byte lanes 0123, cleared bit extents none seen, ORed constants none, written by VPSS_HAL_SetChnCmpAttr (1 stores). Meaning UNKNOWN.";
        field {
            name = "word";
            desc = "32-bit word.";
            sw = rw;
            hw = r;
        } word[31:0];
    } W_780 @ 0x780;

    reg {
        name = "Word 0x784";
        desc = "Word 0x784. PROVEN: stored byte lanes 0123, cleared bit extents none seen, ORed constants none, written by VPSS_HAL_SetChnCmpAttr (1 stores). Meaning UNKNOWN.";
        field {
            name = "word";
            desc = "32-bit word.";
            sw = rw;
            hw = r;
        } word[31:0];
    } W_784 @ 0x784;

    reg {
        name = "Word 0x788";
        desc = "Word 0x788. PROVEN: stored byte lanes 0123, cleared bit extents none seen, ORed constants none, written by VPSS_HAL_SetChnCmpAttr (1 stores). Meaning UNKNOWN.";
        field {
            name = "word";
            desc = "32-bit word.";
            sw = rw;
            hw = r;
        } word[31:0];
    } W_788 @ 0x788;

    reg {
        name = "Word 0x78C";
        desc = "Word 0x78C. PROVEN: stored byte lanes 0123, cleared bit extents none seen, ORed constants none, written by VPSS_HAL_SetChnCmpAttr (1 stores). Meaning UNKNOWN.";
        field {
            name = "word";
            desc = "32-bit word.";
            sw = rw;
            hw = r;
        } word[31:0];
    } W_78C @ 0x78C;

    reg {
        name = "Word 0x790";
        desc = "Word 0x790. PROVEN: stored byte lanes 0123, cleared bit extents none seen, ORed constants none, written by VPSS_HAL_SetChnCmpAttr (1 stores). Meaning UNKNOWN.";
        field {
            name = "word";
            desc = "32-bit word.";
            sw = rw;
            hw = r;
        } word[31:0];
    } W_790 @ 0x790;

    reg {
        name = "Word 0x794";
        desc = "Word 0x794. PROVEN: stored byte lanes 0123, cleared bit extents none seen, ORed constants none, written by VPSS_HAL_SetChnCmpAttr (1 stores). Meaning UNKNOWN.";
        field {
            name = "word";
            desc = "32-bit word.";
            sw = rw;
            hw = r;
        } word[31:0];
    } W_794 @ 0x794;

    reg {
        name = "Word 0x798";
        desc = "Word 0x798. PROVEN: stored byte lanes 0123, cleared bit extents none seen, ORed constants none, written by VPSS_HAL_SetChnCmpAttr (1 stores). Meaning UNKNOWN.";
        field {
            name = "word";
            desc = "32-bit word.";
            sw = rw;
            hw = r;
        } word[31:0];
    } W_798 @ 0x798;

    reg {
        name = "Word 0x79C";
        desc = "Word 0x79C. PROVEN: stored byte lanes 0123, cleared bit extents none seen, ORed constants none, written by VPSS_HAL_SetChnCmpAttr (1 stores). Meaning UNKNOWN.";
        field {
            name = "word";
            desc = "32-bit word.";
            sw = rw;
            hw = r;
        } word[31:0];
    } W_79C @ 0x79C;

    reg {
        name = "Word 0x7A0";
        desc = "Word 0x7A0. PROVEN: stored byte lanes 0123, cleared bit extents none seen, ORed constants none, written by VPSS_HAL_SetChnCmpAttr (1 stores). Meaning UNKNOWN.";
        field {
            name = "word";
            desc = "32-bit word.";
            sw = rw;
            hw = r;
        } word[31:0];
    } W_7A0 @ 0x7A0;

    reg {
        name = "Word 0x7A4";
        desc = "Word 0x7A4. PROVEN: stored byte lanes 0123, cleared bit extents none seen, ORed constants none, written by VPSS_HAL_SetChnCmpAttr (1 stores). Meaning UNKNOWN.";
        field {
            name = "word";
            desc = "32-bit word.";
            sw = rw;
            hw = r;
        } word[31:0];
    } W_7A4 @ 0x7A4;

    reg {
        name = "Word 0x7A8";
        desc = "Word 0x7A8. PROVEN: stored byte lanes 0123, cleared bit extents none seen, ORed constants none, written by VPSS_HAL_SetChnCmpAttr (1 stores). Meaning UNKNOWN.";
        field {
            name = "word";
            desc = "32-bit word.";
            sw = rw;
            hw = r;
        } word[31:0];
    } W_7A8 @ 0x7A8;

    reg {
        name = "Word 0x7AC";
        desc = "Word 0x7AC. PROVEN: stored byte lanes 0123, cleared bit extents none seen, ORed constants none, written by VPSS_HAL_SetChnCmpAttr (1 stores). Meaning UNKNOWN.";
        field {
            name = "word";
            desc = "32-bit word.";
            sw = rw;
            hw = r;
        } word[31:0];
    } W_7AC @ 0x7AC;

    reg {
        name = "Word 0x7B0";
        desc = "Word 0x7B0. PROVEN: stored byte lanes 0123, cleared bit extents none seen, ORed constants none, written by VPSS_HAL_SetChnCmpAttr (1 stores). Meaning UNKNOWN.";
        field {
            name = "word";
            desc = "32-bit word.";
            sw = rw;
            hw = r;
        } word[31:0];
    } W_7B0 @ 0x7B0;

    reg {
        name = "Word 0x7B4";
        desc = "Word 0x7B4. PROVEN: stored byte lanes 0123, cleared bit extents none seen, ORed constants none, written by VPSS_HAL_SetChnCmpAttr (1 stores). Meaning UNKNOWN.";
        field {
            name = "word";
            desc = "32-bit word.";
            sw = rw;
            hw = r;
        } word[31:0];
    } W_7B4 @ 0x7B4;

    reg {
        name = "Word 0x7B8";
        desc = "Word 0x7B8. PROVEN: stored byte lanes 0123, cleared bit extents none seen, ORed constants none, written by VPSS_HAL_SetChnCmpAttr (1 stores). Meaning UNKNOWN.";
        field {
            name = "word";
            desc = "32-bit word.";
            sw = rw;
            hw = r;
        } word[31:0];
    } W_7B8 @ 0x7B8;

    reg {
        name = "Word 0x7C8";
        desc = "Word 0x7C8. PROVEN: stored byte lanes 0123, cleared bit extents none seen, ORed constants none, written by VPSS_HAL_SetRfrCmpAttr (1 stores). Meaning UNKNOWN.";
        field {
            name = "word";
            desc = "32-bit word.";
            sw = rw;
            hw = r;
        } word[31:0];
    } W_7C8 @ 0x7C8;

    reg {
        name = "Word 0x7CC";
        desc = "Word 0x7CC. PROVEN: stored byte lanes 0123, cleared bit extents none seen, ORed constants none, written by VPSS_HAL_SetRfrCmpAttr (1 stores). Meaning UNKNOWN.";
        field {
            name = "word";
            desc = "32-bit word.";
            sw = rw;
            hw = r;
        } word[31:0];
    } W_7CC @ 0x7CC;

    reg {
        name = "Word 0x7D0";
        desc = "Word 0x7D0. PROVEN: stored byte lanes 0123, cleared bit extents none seen, ORed constants none, written by VPSS_HAL_SetRfrCmpAttr (1 stores). Meaning UNKNOWN.";
        field {
            name = "word";
            desc = "32-bit word.";
            sw = rw;
            hw = r;
        } word[31:0];
    } W_7D0 @ 0x7D0;

    reg {
        name = "Word 0x7D4";
        desc = "Word 0x7D4. PROVEN: stored byte lanes 0123, cleared bit extents none seen, ORed constants none, written by VPSS_HAL_SetRfrCmpAttr (1 stores). Meaning UNKNOWN.";
        field {
            name = "word";
            desc = "32-bit word.";
            sw = rw;
            hw = r;
        } word[31:0];
    } W_7D4 @ 0x7D4;

    reg {
        name = "Word 0x7D8";
        desc = "Word 0x7D8. PROVEN: stored byte lanes 0123, cleared bit extents none seen, ORed constants none, written by VPSS_HAL_SetRfrCmpAttr (1 stores). Meaning UNKNOWN.";
        field {
            name = "word";
            desc = "32-bit word.";
            sw = rw;
            hw = r;
        } word[31:0];
    } W_7D8 @ 0x7D8;

    reg {
        name = "Word 0x7DC";
        desc = "Word 0x7DC. PROVEN: stored byte lanes 0123, cleared bit extents none seen, ORed constants none, written by VPSS_HAL_SetRfrCmpAttr (1 stores). Meaning UNKNOWN.";
        field {
            name = "word";
            desc = "32-bit word.";
            sw = rw;
            hw = r;
        } word[31:0];
    } W_7DC @ 0x7DC;

    reg {
        name = "Word 0x7E0";
        desc = "Word 0x7E0. PROVEN: stored byte lanes 0123, cleared bit extents none seen, ORed constants none, written by VPSS_HAL_SetRfrCmpAttr (1 stores). Meaning UNKNOWN.";
        field {
            name = "word";
            desc = "32-bit word.";
            sw = rw;
            hw = r;
        } word[31:0];
    } W_7E0 @ 0x7E0;

    reg {
        name = "Word 0x7E4";
        desc = "Word 0x7E4. PROVEN: stored byte lanes 0123, cleared bit extents none seen, ORed constants none, written by VPSS_HAL_SetRfrCmpAttr (1 stores). Meaning UNKNOWN.";
        field {
            name = "word";
            desc = "32-bit word.";
            sw = rw;
            hw = r;
        } word[31:0];
    } W_7E4 @ 0x7E4;

    reg {
        name = "Word 0x7E8";
        desc = "Word 0x7E8. PROVEN: stored byte lanes 0123, cleared bit extents none seen, ORed constants none, written by VPSS_HAL_SetRfrCmpAttr (1 stores). Meaning UNKNOWN.";
        field {
            name = "word";
            desc = "32-bit word.";
            sw = rw;
            hw = r;
        } word[31:0];
    } W_7E8 @ 0x7E8;

    reg {
        name = "Word 0x7EC";
        desc = "Word 0x7EC. PROVEN: stored byte lanes 0123, cleared bit extents none seen, ORed constants none, written by VPSS_HAL_SetRfrCmpAttr (1 stores). Meaning UNKNOWN.";
        field {
            name = "word";
            desc = "32-bit word.";
            sw = rw;
            hw = r;
        } word[31:0];
    } W_7EC @ 0x7EC;

    reg {
        name = "Word 0x7F0";
        desc = "Word 0x7F0. PROVEN: stored byte lanes 0123, cleared bit extents none seen, ORed constants none, written by VPSS_HAL_SetRfrCmpAttr (1 stores). Meaning UNKNOWN.";
        field {
            name = "word";
            desc = "32-bit word.";
            sw = rw;
            hw = r;
        } word[31:0];
    } W_7F0 @ 0x7F0;

    reg {
        name = "Word 0x7F4";
        desc = "Word 0x7F4. PROVEN: stored byte lanes 0123, cleared bit extents none seen, ORed constants none, written by VPSS_HAL_SetRfrCmpAttr (1 stores). Meaning UNKNOWN.";
        field {
            name = "word";
            desc = "32-bit word.";
            sw = rw;
            hw = r;
        } word[31:0];
    } W_7F4 @ 0x7F4;

    reg {
        name = "Word 0x7F8";
        desc = "Word 0x7F8. PROVEN: stored byte lanes 0123, cleared bit extents none seen, ORed constants none, written by VPSS_HAL_SetRfrCmpAttr (1 stores). Meaning UNKNOWN.";
        field {
            name = "word";
            desc = "32-bit word.";
            sw = rw;
            hw = r;
        } word[31:0];
    } W_7F8 @ 0x7F8;

    reg {
        name = "Word 0x7FC";
        desc = "Word 0x7FC. PROVEN: stored byte lanes 0123, cleared bit extents none seen, ORed constants none, written by VPSS_HAL_SetRfrCmpAttr (1 stores). Meaning UNKNOWN.";
        field {
            name = "word";
            desc = "32-bit word.";
            sw = rw;
            hw = r;
        } word[31:0];
    } W_7FC @ 0x7FC;

    reg {
        name = "Word 0x800";
        desc = "Word 0x800. PROVEN: stored byte lanes 0123, cleared bit extents none seen, ORed constants none, written by VPSS_HAL_SetRfrCmpAttr (1 stores). Meaning UNKNOWN.";
        field {
            name = "word";
            desc = "32-bit word.";
            sw = rw;
            hw = r;
        } word[31:0];
    } W_800 @ 0x800;

    reg {
        name = "Word 0x804";
        desc = "Word 0x804. PROVEN: stored byte lanes 0123, cleared bit extents none seen, ORed constants none, written by VPSS_HAL_SetRfrCmpAttr (1 stores). Meaning UNKNOWN.";
        field {
            name = "word";
            desc = "32-bit word.";
            sw = rw;
            hw = r;
        } word[31:0];
    } W_804 @ 0x804;

    reg {
        name = "Word 0x808";
        desc = "Word 0x808. PROVEN: stored byte lanes 0123, cleared bit extents none seen, ORed constants none, written by VPSS_HAL_SetRfrCmpAttr (1 stores). Meaning UNKNOWN.";
        field {
            name = "word";
            desc = "32-bit word.";
            sw = rw;
            hw = r;
        } word[31:0];
    } W_808 @ 0x808;

    reg {
        name = "Word 0x80C";
        desc = "Word 0x80C. PROVEN: stored byte lanes 0123, cleared bit extents none seen, ORed constants none, written by VPSS_HAL_SetRfrCmpAttr (1 stores). Meaning UNKNOWN.";
        field {
            name = "word";
            desc = "32-bit word.";
            sw = rw;
            hw = r;
        } word[31:0];
    } W_80C @ 0x80C;

    reg {
        name = "Word 0x810";
        desc = "Word 0x810. PROVEN: stored byte lanes 0123, cleared bit extents none seen, ORed constants none, written by VPSS_HAL_SetRfrCmpAttr (1 stores). Meaning UNKNOWN.";
        field {
            name = "word";
            desc = "32-bit word.";
            sw = rw;
            hw = r;
        } word[31:0];
    } W_810 @ 0x810;

    reg {
        name = "Word 0x814";
        desc = "Word 0x814. PROVEN: stored byte lanes 0123, cleared bit extents none seen, ORed constants none, written by VPSS_HAL_SetRfrCmpAttr (1 stores). Meaning UNKNOWN.";
        field {
            name = "word";
            desc = "32-bit word.";
            sw = rw;
            hw = r;
        } word[31:0];
    } W_814 @ 0x814;

    reg {
        name = "Word 0x818";
        desc = "Word 0x818. PROVEN: stored byte lanes 0123, cleared bit extents none seen, ORed constants none, written by VPSS_HAL_SetRfrCmpAttr (1 stores). Meaning UNKNOWN.";
        field {
            name = "word";
            desc = "32-bit word.";
            sw = rw;
            hw = r;
        } word[31:0];
    } W_818 @ 0x818;

    reg {
        name = "Word 0x828";
        desc = "Word 0x828. PROVEN: stored byte lanes 0123, cleared bit extents none seen, ORed constants none, written by VPSS_HAL_SetRfrCmpAttr (1 stores). Meaning UNKNOWN.";
        field {
            name = "word";
            desc = "32-bit word.";
            sw = rw;
            hw = r;
        } word[31:0];
    } W_828 @ 0x828;

    reg {
        name = "Word 0x82C";
        desc = "Word 0x82C. PROVEN: stored byte lanes 0123, cleared bit extents none seen, ORed constants none, written by VPSS_HAL_SetRfrCmpAttr (1 stores). Meaning UNKNOWN.";
        field {
            name = "word";
            desc = "32-bit word.";
            sw = rw;
            hw = r;
        } word[31:0];
    } W_82C @ 0x82C;

    reg {
        name = "Word 0x830";
        desc = "Word 0x830. PROVEN: stored byte lanes 0123, cleared bit extents none seen, ORed constants none, written by VPSS_HAL_SetRfrCmpAttr (1 stores). Meaning UNKNOWN.";
        field {
            name = "word";
            desc = "32-bit word.";
            sw = rw;
            hw = r;
        } word[31:0];
    } W_830 @ 0x830;

    reg {
        name = "Word 0x834";
        desc = "Word 0x834. PROVEN: stored byte lanes 0123, cleared bit extents none seen, ORed constants none, written by VPSS_HAL_SetRfrCmpAttr (1 stores). Meaning UNKNOWN.";
        field {
            name = "word";
            desc = "32-bit word.";
            sw = rw;
            hw = r;
        } word[31:0];
    } W_834 @ 0x834;

    reg {
        name = "Word 0x838";
        desc = "Word 0x838. PROVEN: stored byte lanes 0123, cleared bit extents none seen, ORed constants none, written by VPSS_HAL_SetRfrCmpAttr (1 stores). Meaning UNKNOWN.";
        field {
            name = "word";
            desc = "32-bit word.";
            sw = rw;
            hw = r;
        } word[31:0];
    } W_838 @ 0x838;

    reg {
        name = "Word 0x83C";
        desc = "Word 0x83C. PROVEN: stored byte lanes 0123, cleared bit extents none seen, ORed constants none, written by VPSS_HAL_SetRfrCmpAttr (1 stores). Meaning UNKNOWN.";
        field {
            name = "word";
            desc = "32-bit word.";
            sw = rw;
            hw = r;
        } word[31:0];
    } W_83C @ 0x83C;

    reg {
        name = "Word 0x840";
        desc = "Word 0x840. PROVEN: stored byte lanes 0123, cleared bit extents none seen, ORed constants none, written by VPSS_HAL_SetRfrCmpAttr (1 stores). Meaning UNKNOWN.";
        field {
            name = "word";
            desc = "32-bit word.";
            sw = rw;
            hw = r;
        } word[31:0];
    } W_840 @ 0x840;

    reg {
        name = "Word 0x844";
        desc = "Word 0x844. PROVEN: stored byte lanes 0123, cleared bit extents none seen, ORed constants none, written by VPSS_HAL_SetRfrCmpAttr (1 stores). Meaning UNKNOWN.";
        field {
            name = "word";
            desc = "32-bit word.";
            sw = rw;
            hw = r;
        } word[31:0];
    } W_844 @ 0x844;

    reg {
        name = "Word 0x848";
        desc = "Word 0x848. PROVEN: stored byte lanes 0123, cleared bit extents none seen, ORed constants none, written by VPSS_HAL_SetRfrCmpAttr (1 stores). Meaning UNKNOWN.";
        field {
            name = "word";
            desc = "32-bit word.";
            sw = rw;
            hw = r;
        } word[31:0];
    } W_848 @ 0x848;

    reg {
        name = "Word 0x84C";
        desc = "Word 0x84C. PROVEN: stored byte lanes 0123, cleared bit extents none seen, ORed constants none, written by VPSS_HAL_SetRfrCmpAttr (1 stores). Meaning UNKNOWN.";
        field {
            name = "word";
            desc = "32-bit word.";
            sw = rw;
            hw = r;
        } word[31:0];
    } W_84C @ 0x84C;

    reg {
        name = "Word 0x850";
        desc = "Word 0x850. PROVEN: stored byte lanes 0123, cleared bit extents none seen, ORed constants none, written by VPSS_HAL_SetRfrCmpAttr (1 stores). Meaning UNKNOWN.";
        field {
            name = "word";
            desc = "32-bit word.";
            sw = rw;
            hw = r;
        } word[31:0];
    } W_850 @ 0x850;

    reg {
        name = "Word 0x854";
        desc = "Word 0x854. PROVEN: stored byte lanes 0123, cleared bit extents none seen, ORed constants none, written by VPSS_HAL_SetRfrCmpAttr (1 stores). Meaning UNKNOWN.";
        field {
            name = "word";
            desc = "32-bit word.";
            sw = rw;
            hw = r;
        } word[31:0];
    } W_854 @ 0x854;

    reg {
        name = "Word 0x858";
        desc = "Word 0x858. PROVEN: stored byte lanes 0123, cleared bit extents none seen, ORed constants none, written by VPSS_HAL_SetRfrCmpAttr (1 stores). Meaning UNKNOWN.";
        field {
            name = "word";
            desc = "32-bit word.";
            sw = rw;
            hw = r;
        } word[31:0];
    } W_858 @ 0x858;

    reg {
        name = "Word 0x85C";
        desc = "Word 0x85C. PROVEN: stored byte lanes 0123, cleared bit extents none seen, ORed constants none, written by VPSS_HAL_SetRfrCmpAttr (1 stores). Meaning UNKNOWN.";
        field {
            name = "word";
            desc = "32-bit word.";
            sw = rw;
            hw = r;
        } word[31:0];
    } W_85C @ 0x85C;

    reg {
        name = "Word 0x860";
        desc = "Word 0x860. PROVEN: stored byte lanes 0123, cleared bit extents none seen, ORed constants none, written by VPSS_HAL_SetRfrCmpAttr (1 stores). Meaning UNKNOWN.";
        field {
            name = "word";
            desc = "32-bit word.";
            sw = rw;
            hw = r;
        } word[31:0];
    } W_860 @ 0x860;

    reg {
        name = "Word 0x864";
        desc = "Word 0x864. PROVEN: stored byte lanes 0123, cleared bit extents none seen, ORed constants none, written by VPSS_HAL_SetRfrCmpAttr (1 stores). Meaning UNKNOWN.";
        field {
            name = "word";
            desc = "32-bit word.";
            sw = rw;
            hw = r;
        } word[31:0];
    } W_864 @ 0x864;

    reg {
        name = "Word 0x868";
        desc = "Word 0x868. PROVEN: stored byte lanes 0123, cleared bit extents none seen, ORed constants none, written by VPSS_HAL_SetRfrCmpAttr (1 stores). Meaning UNKNOWN.";
        field {
            name = "word";
            desc = "32-bit word.";
            sw = rw;
            hw = r;
        } word[31:0];
    } W_868 @ 0x868;

    reg {
        name = "Word 0x86C";
        desc = "Word 0x86C. PROVEN: stored byte lanes 0123, cleared bit extents none seen, ORed constants none, written by VPSS_HAL_SetRfrCmpAttr (1 stores). Meaning UNKNOWN.";
        field {
            name = "word";
            desc = "32-bit word.";
            sw = rw;
            hw = r;
        } word[31:0];
    } W_86C @ 0x86C;

    reg {
        name = "Word 0x870";
        desc = "Word 0x870. PROVEN: stored byte lanes 0123, cleared bit extents none seen, ORed constants none, written by VPSS_HAL_SetRfrCmpAttr (1 stores). Meaning UNKNOWN.";
        field {
            name = "word";
            desc = "32-bit word.";
            sw = rw;
            hw = r;
        } word[31:0];
    } W_870 @ 0x870;

    reg {
        name = "Word 0x874";
        desc = "Word 0x874. PROVEN: stored byte lanes 0123, cleared bit extents none seen, ORed constants none, written by VPSS_HAL_SetRfrCmpAttr (1 stores). Meaning UNKNOWN.";
        field {
            name = "word";
            desc = "32-bit word.";
            sw = rw;
            hw = r;
        } word[31:0];
    } W_874 @ 0x874;

    reg {
        name = "Word 0x878";
        desc = "Word 0x878. PROVEN: stored byte lanes 0123, cleared bit extents none seen, ORed constants none, written by VPSS_HAL_SetRfrCmpAttr (1 stores). Meaning UNKNOWN.";
        field {
            name = "word";
            desc = "32-bit word.";
            sw = rw;
            hw = r;
        } word[31:0];
    } W_878 @ 0x878;

    reg {
        name = "Word 0x888";
        desc = "Word 0x888. PROVEN: stored byte lanes 0123, cleared bit extents none seen, ORed constants none, written by VPSS_HAL_SetRefDcmpAttr (1 stores). Meaning UNKNOWN.";
        field {
            name = "word";
            desc = "32-bit word.";
            sw = rw;
            hw = r;
        } word[31:0];
    } W_888 @ 0x888;

    reg {
        name = "Word 0x88C";
        desc = "Word 0x88C. PROVEN: stored byte lanes 0123, cleared bit extents none seen, ORed constants none, written by VPSS_HAL_SetRefDcmpAttr (1 stores). Meaning UNKNOWN.";
        field {
            name = "word";
            desc = "32-bit word.";
            sw = rw;
            hw = r;
        } word[31:0];
    } W_88C @ 0x88C;

    reg {
        name = "Word 0x890";
        desc = "Word 0x890. PROVEN: stored byte lanes 0123, cleared bit extents none seen, ORed constants none, written by VPSS_HAL_SetRefDcmpAttr (1 stores). Meaning UNKNOWN.";
        field {
            name = "word";
            desc = "32-bit word.";
            sw = rw;
            hw = r;
        } word[31:0];
    } W_890 @ 0x890;

    reg {
        name = "Word 0x8A0";
        desc = "Word 0x8A0. PROVEN: stored byte lanes 0123, cleared bit extents none seen, ORed constants none, written by VPSS_HAL_SetRefDcmpAttr (1 stores). Meaning UNKNOWN.";
        field {
            name = "word";
            desc = "32-bit word.";
            sw = rw;
            hw = r;
        } word[31:0];
    } W_8A0 @ 0x8A0;

    reg {
        name = "Word 0x8A4";
        desc = "Word 0x8A4. PROVEN: stored byte lanes 0123, cleared bit extents none seen, ORed constants none, written by VPSS_HAL_SetRefDcmpAttr (1 stores). Meaning UNKNOWN.";
        field {
            name = "word";
            desc = "32-bit word.";
            sw = rw;
            hw = r;
        } word[31:0];
    } W_8A4 @ 0x8A4;

    reg {
        name = "Word 0x8A8";
        desc = "Word 0x8A8. PROVEN: stored byte lanes 0123, cleared bit extents none seen, ORed constants none, written by VPSS_HAL_SetRefDcmpAttr (1 stores). Meaning UNKNOWN.";
        field {
            name = "word";
            desc = "32-bit word.";
            sw = rw;
            hw = r;
        } word[31:0];
    } W_8A8 @ 0x8A8;

};

`endif
`ifndef HISI_VGS_NODE_V4_RDL
`define HISI_VGS_NODE_V4_RDL

regfile eVGS_NODE_V4_EV300 {
    name = "VGS node";
    desc = "Hi3516E V200 / V300 (hi3516ev200_vgs.ko, VGS_DRV_Set*Reg* with the node pointer in argument 0, 96 words; argument 1 gives none). The VGS job node is a DDR image, not MMIO (eVGS_V4 registers 0xF0..0x330 share no offset with it). Meaning of every word UNKNOWN unless stated. NOT A REGISTER FILE unless stated: register image / table written by the traced functions. PROVENANCE LABELS: PROVEN = read from the instruction stream (offset, stored byte lanes, cleared bit extents, ORed constants); INFERRED = role deduced from names or sibling chips; UNKNOWN = everything else. Source: symbolic trace of the module disassembly (arm-trace). Branches are linearized, extents are lower bounds. Not hardware verified.";

    reg {
        name = "Word 0x0";
        desc = "Word 0x0. PROVEN: stored byte lanes 0123, cleared bit extents none seen, ORed constants none, written by VGS_DRV_SetReg_ModuleCtrl (1 stores). Meaning UNKNOWN.";
        field {
            name = "word";
            desc = "32-bit word.";
            sw = rw;
            hw = r;
        } word[31:0];
    } W_000 @ 0x0;

    reg {
        name = "Word 0x4";
        desc = "Word 0x4. PROVEN: stored byte lanes 0123, cleared bit extents none seen, ORed constants none, written by VGS_DRV_SetReg_ModuleCtrl (1 stores). Meaning UNKNOWN.";
        field {
            name = "word";
            desc = "32-bit word.";
            sw = rw;
            hw = r;
        } word[31:0];
    } W_004 @ 0x4;

    reg {
        name = "Word 0x8";
        desc = "Word 0x8. PROVEN: stored byte lanes 0123, cleared bit extents none seen, ORed constants none, written by VGS_DRV_SetReg_ModuleCtrl (1 stores). Meaning UNKNOWN.";
        field {
            name = "word";
            desc = "32-bit word.";
            sw = rw;
            hw = r;
        } word[31:0];
    } W_008 @ 0x8;

    reg {
        name = "Word 0x1C";
        desc = "Word 0x1C. PROVEN: stored byte lanes 0123, cleared bit extents none seen, ORed constants none, written by VGS_DRV_SetReg_SCALE (1 stores). Meaning UNKNOWN.";
        field {
            name = "word";
            desc = "32-bit word.";
            sw = rw;
            hw = r;
        } word[31:0];
    } W_01C @ 0x1C;

    reg {
        name = "Word 0x24";
        desc = "Word 0x24. PROVEN: stored byte lanes 0123, cleared bit extents none seen, ORed constants none, written by VGS_DRV_SetReg_SCALE (1 stores). Meaning UNKNOWN.";
        field {
            name = "word";
            desc = "32-bit word.";
            sw = rw;
            hw = r;
        } word[31:0];
    } W_024 @ 0x24;

    reg {
        name = "Word 0x2C";
        desc = "Word 0x2C. PROVEN: stored byte lanes 0123, cleared bit extents none seen, ORed constants none, written by VGS_DRV_SetReg_SCALE (1 stores). Meaning UNKNOWN.";
        field {
            name = "word";
            desc = "32-bit word.";
            sw = rw;
            hw = r;
        } word[31:0];
    } W_02C @ 0x2C;

    reg {
        name = "Word 0x34";
        desc = "Word 0x34. PROVEN: stored byte lanes 0123, cleared bit extents none seen, ORed constants none, written by VGS_DRV_SetReg_SCALE (1 stores). Meaning UNKNOWN.";
        field {
            name = "word";
            desc = "32-bit word.";
            sw = rw;
            hw = r;
        } word[31:0];
    } W_034 @ 0x34;

    reg {
        name = "Word 0x44";
        desc = "Word 0x44. PROVEN: stored byte lanes 0123, cleared bit extents none seen, ORed constants none, written by VGS_DRV_SetReg_OSD (1 stores). Meaning UNKNOWN.";
        field {
            name = "word";
            desc = "32-bit word.";
            sw = rw;
            hw = r;
        } word[31:0];
    } W_044 @ 0x44;

    reg {
        name = "Word 0x4C";
        desc = "Word 0x4C. PROVEN: stored byte lanes 0123, cleared bit extents none seen, ORed constants none, written by VGS_DRV_SetReg_SCALE (1 stores). Meaning UNKNOWN.";
        field {
            name = "word";
            desc = "32-bit word.";
            sw = rw;
            hw = r;
        } word[31:0];
    } W_04C @ 0x4C;

    reg {
        name = "Word 0x50";
        desc = "Word 0x50. PROVEN: stored byte lanes 0123, cleared bit extents none seen, ORed constants none, written by VGS_DRV_SetReg_SCALE, VGS_DRV_SetReg_TDE (2 stores). Meaning UNKNOWN.";
        field {
            name = "word";
            desc = "32-bit word.";
            sw = rw;
            hw = r;
        } word[31:0];
    } W_050 @ 0x50;

    reg {
        name = "Word 0x54";
        desc = "Word 0x54. PROVEN: stored byte lanes 0123, cleared bit extents none seen, ORed constants none, written by VGS_DRV_SetReg_COVER (1 stores). Meaning UNKNOWN.";
        field {
            name = "word";
            desc = "32-bit word.";
            sw = rw;
            hw = r;
        } word[31:0];
    } W_054 @ 0x54;

    reg {
        name = "Word 0x58";
        desc = "Word 0x58. PROVEN: stored byte lanes 0123, cleared bit extents none seen, ORed constants none, written by VGS_DRV_SetReg, VGS_DRV_SetReg_LDC (2 stores). Meaning UNKNOWN.";
        field {
            name = "word";
            desc = "32-bit word.";
            sw = rw;
            hw = r;
        } word[31:0];
    } W_058 @ 0x58;

    reg {
        name = "Word 0x60";
        desc = "Word 0x60. PROVEN: stored byte lanes 0123, cleared bit extents none seen, ORed constants none, written by VGS_DRV_SetReg_DRD (1 stores). Meaning UNKNOWN.";
        field {
            name = "word";
            desc = "32-bit word.";
            sw = rw;
            hw = r;
        } word[31:0];
    } W_060 @ 0x60;

    reg {
        name = "Word 0x64";
        desc = "Word 0x64. PROVEN: stored byte lanes 0123, cleared bit extents none seen, ORed constants none, written by VGS_DRV_SetReg_CSC (1 stores). Meaning UNKNOWN.";
        field {
            name = "word";
            desc = "32-bit word.";
            sw = rw;
            hw = r;
        } word[31:0];
    } W_064 @ 0x64;

    reg {
        name = "Word 0x100";
        desc = "Word 0x100. PROVEN: stored byte lanes 0123, cleared bit extents none seen, ORed constants none, written by VGS_DRV_SetReg_CROP (1 stores). Meaning UNKNOWN.";
        field {
            name = "word";
            desc = "32-bit word.";
            sw = rw;
            hw = r;
        } word[31:0];
    } W_100 @ 0x100;

    reg {
        name = "Word 0x104";
        desc = "Word 0x104. PROVEN: stored byte lanes 0123, cleared bit extents none seen, ORed constants none, written by VGS_DRV_SetReg_CROP (1 stores). Meaning UNKNOWN.";
        field {
            name = "word";
            desc = "32-bit word.";
            sw = rw;
            hw = r;
        } word[31:0];
    } W_104 @ 0x104;

    reg {
        name = "Word 0x110";
        desc = "Word 0x110. PROVEN: stored byte lanes 0123, cleared bit extents none seen, ORed constants none, written by VGS_DRV_SetReg_CROP (1 stores). Meaning UNKNOWN.";
        field {
            name = "word";
            desc = "32-bit word.";
            sw = rw;
            hw = r;
        } word[31:0];
    } W_110 @ 0x110;

    reg {
        name = "Word 0x114";
        desc = "Word 0x114. PROVEN: stored byte lanes 0123, cleared bit extents none seen, ORed constants none, written by VGS_DRV_SetReg_CROP (1 stores). Meaning UNKNOWN.";
        field {
            name = "word";
            desc = "32-bit word.";
            sw = rw;
            hw = r;
        } word[31:0];
    } W_114 @ 0x114;

    reg {
        name = "Word 0x200";
        desc = "Word 0x200. PROVEN: stored byte lanes 0123, cleared bit extents none seen, ORed constants none, written by VGS_DRV_SetReg, VGS_DRV_SetReg_IvePreprocCoef (2 stores). Meaning UNKNOWN.";
        field {
            name = "word";
            desc = "32-bit word.";
            sw = rw;
            hw = r;
        } word[31:0];
    } W_200 @ 0x200;

    reg {
        name = "Word 0x204";
        desc = "Word 0x204. PROVEN: stored byte lanes 0123, cleared bit extents none seen, ORed constants none, written by VGS_DRV_SetReg, VGS_DRV_SetReg_IvePreprocCoef (2 stores). Meaning UNKNOWN.";
        field {
            name = "word";
            desc = "32-bit word.";
            sw = rw;
            hw = r;
        } word[31:0];
    } W_204 @ 0x204;

    reg {
        name = "Word 0x208";
        desc = "Word 0x208. PROVEN: stored byte lanes 0123, cleared bit extents none seen, ORed constants none, written by VGS_DRV_SetReg, VGS_DRV_SetReg_IvePreprocCoef (2 stores). Meaning UNKNOWN.";
        field {
            name = "word";
            desc = "32-bit word.";
            sw = rw;
            hw = r;
        } word[31:0];
    } W_208 @ 0x208;

    reg {
        name = "Word 0x400";
        desc = "Word 0x400. PROVEN: stored byte lanes 0123, cleared bit extents none seen, ORed constants none, written by VGS_DRV_SetReg_ModuleCtrl (3 stores). Meaning UNKNOWN.";
        field {
            name = "word";
            desc = "32-bit word.";
            sw = rw;
            hw = r;
        } word[31:0];
    } W_400 @ 0x400;

    reg {
        name = "Word 0x404";
        desc = "Word 0x404. PROVEN: stored byte lanes 0123, cleared bit extents none seen, ORed constants none, written by VGS_DRV_SetReg_CurImg (1 stores). Meaning UNKNOWN.";
        field {
            name = "word";
            desc = "32-bit word.";
            sw = rw;
            hw = r;
        } word[31:0];
    } W_404 @ 0x404;

    reg {
        name = "Word 0x408";
        desc = "Word 0x408. PROVEN: stored byte lanes 0123, cleared bit extents none seen, ORed constants none, written by VGS_DRV_SetReg_CurImg (1 stores). Meaning UNKNOWN.";
        field {
            name = "word";
            desc = "32-bit word.";
            sw = rw;
            hw = r;
        } word[31:0];
    } W_408 @ 0x408;

    reg {
        name = "Word 0x410";
        desc = "Word 0x410. PROVEN: stored byte lanes 0123, cleared bit extents none seen, ORed constants none, written by VGS_DRV_SetReg_CurImg (1 stores). Meaning UNKNOWN.";
        field {
            name = "word";
            desc = "32-bit word.";
            sw = rw;
            hw = r;
        } word[31:0];
    } W_410 @ 0x410;

    reg {
        name = "Word 0x414";
        desc = "Word 0x414. PROVEN: stored byte lanes 0123, cleared bit extents none seen, ORed constants none, written by VGS_DRV_SetReg_CurImg (1 stores). Meaning UNKNOWN.";
        field {
            name = "word";
            desc = "32-bit word.";
            sw = rw;
            hw = r;
        } word[31:0];
    } W_414 @ 0x414;

    reg {
        name = "Word 0x41C";
        desc = "Word 0x41C. PROVEN: stored byte lanes 0123, cleared bit extents none seen, ORed constants none, written by VGS_DRV_SetReg_CurImg (1 stores). Meaning UNKNOWN.";
        field {
            name = "word";
            desc = "32-bit word.";
            sw = rw;
            hw = r;
        } word[31:0];
    } W_41C @ 0x41C;

    reg {
        name = "Word 0x424";
        desc = "Word 0x424. PROVEN: stored byte lanes 0123, cleared bit extents none seen, ORed constants none, written by VGS_DRV_SetReg_CurImg (1 stores). Meaning UNKNOWN.";
        field {
            name = "word";
            desc = "32-bit word.";
            sw = rw;
            hw = r;
        } word[31:0];
    } W_424 @ 0x424;

    reg {
        name = "Word 0x464";
        desc = "Word 0x464. PROVEN: stored byte lanes 0123, cleared bit extents none seen, ORed constants none, written by VGS_DRV_SetReg_CurImg, VGS_DRV_SetReg_DestImg (3 stores). Meaning UNKNOWN.";
        field {
            name = "word";
            desc = "32-bit word.";
            sw = rw;
            hw = r;
        } word[31:0];
    } W_464 @ 0x464;

    reg {
        name = "Word 0x46C";
        desc = "Word 0x46C. PROVEN: stored byte lanes 0123, cleared bit extents none seen, ORed constants none, written by VGS_DRV_SetReg_CurImg (1 stores). Meaning UNKNOWN.";
        field {
            name = "word";
            desc = "32-bit word.";
            sw = rw;
            hw = r;
        } word[31:0];
    } W_46C @ 0x46C;

    reg {
        name = "Word 0x474";
        desc = "Word 0x474. PROVEN: stored byte lanes 0123, cleared bit extents none seen, ORed constants none, written by VGS_DRV_SetReg_CurImg, VGS_DRV_SetReg_DestImg (2 stores). Meaning UNKNOWN.";
        field {
            name = "word";
            desc = "32-bit word.";
            sw = rw;
            hw = r;
        } word[31:0];
    } W_474 @ 0x474;

    reg {
        name = "Word 0x518";
        desc = "Word 0x518. PROVEN: stored byte lanes 0123, cleared bit extents none seen, ORed constants none, written by VGS_DRV_SetReg_OSD (3 stores). Meaning UNKNOWN.";
        field {
            name = "word";
            desc = "32-bit word.";
            sw = rw;
            hw = r;
        } word[31:0];
    } W_518 @ 0x518;

    reg {
        name = "Word 0x51C";
        desc = "Word 0x51C. PROVEN: stored byte lanes 0123, cleared bit extents none seen, ORed constants none, written by VGS_DRV_SetReg_OSD (2 stores). Meaning UNKNOWN.";
        field {
            name = "word";
            desc = "32-bit word.";
            sw = rw;
            hw = r;
        } word[31:0];
    } W_51C @ 0x51C;

    reg {
        name = "Word 0x528";
        desc = "Word 0x528. PROVEN: stored byte lanes 0123, cleared bit extents none seen, ORed constants none, written by VGS_DRV_SetReg_OSD (2 stores). Meaning UNKNOWN.";
        field {
            name = "word";
            desc = "32-bit word.";
            sw = rw;
            hw = r;
        } word[31:0];
    } W_528 @ 0x528;

    reg {
        name = "Word 0x530";
        desc = "Word 0x530. PROVEN: stored byte lanes 0123, cleared bit extents none seen, ORed constants none, written by VGS_DRV_SetReg_OSD (2 stores). Meaning UNKNOWN.";
        field {
            name = "word";
            desc = "32-bit word.";
            sw = rw;
            hw = r;
        } word[31:0];
    } W_530 @ 0x530;

    reg {
        name = "Word 0x534";
        desc = "Word 0x534. PROVEN: stored byte lanes 0123, cleared bit extents none seen, ORed constants none, written by VGS_DRV_SetReg_OSD (2 stores). Meaning UNKNOWN.";
        field {
            name = "word";
            desc = "32-bit word.";
            sw = rw;
            hw = r;
        } word[31:0];
    } W_534 @ 0x534;

    reg {
        name = "Word 0x538";
        desc = "Word 0x538. PROVEN: stored byte lanes 0123, cleared bit extents none seen, ORed constants none, written by VGS_DRV_SetReg_DestImg (2 stores). Meaning UNKNOWN.";
        field {
            name = "word";
            desc = "32-bit word.";
            sw = rw;
            hw = r;
        } word[31:0];
    } W_538 @ 0x538;

    reg {
        name = "Word 0x53C";
        desc = "Word 0x53C. PROVEN: stored byte lanes 0123, cleared bit extents none seen, ORed constants none, written by VGS_DRV_SetReg_DestImg (2 stores). Meaning UNKNOWN.";
        field {
            name = "word";
            desc = "32-bit word.";
            sw = rw;
            hw = r;
        } word[31:0];
    } W_53C @ 0x53C;

    reg {
        name = "Word 0x540";
        desc = "Word 0x540. PROVEN: stored byte lanes 0123, cleared bit extents none seen, ORed constants none, written by VGS_DRV_SetReg_DestImg (1 stores). Meaning UNKNOWN.";
        field {
            name = "word";
            desc = "32-bit word.";
            sw = rw;
            hw = r;
        } word[31:0];
    } W_540 @ 0x540;

    reg {
        name = "Word 0x544";
        desc = "Word 0x544. PROVEN: stored byte lanes 0123, cleared bit extents none seen, ORed constants none, written by VGS_DRV_SetReg_DestImg (2 stores). Meaning UNKNOWN.";
        field {
            name = "word";
            desc = "32-bit word.";
            sw = rw;
            hw = r;
        } word[31:0];
    } W_544 @ 0x544;

    reg {
        name = "Word 0x54C";
        desc = "Word 0x54C. PROVEN: stored byte lanes 0123, cleared bit extents none seen, ORed constants none, written by VGS_DRV_SetReg_DestImg (2 stores). Meaning UNKNOWN.";
        field {
            name = "word";
            desc = "32-bit word.";
            sw = rw;
            hw = r;
        } word[31:0];
    } W_54C @ 0x54C;

    reg {
        name = "Word 0x554";
        desc = "Word 0x554. PROVEN: stored byte lanes 0123, cleared bit extents none seen, ORed constants none, written by VGS_DRV_SetReg_DestImg (3 stores). Meaning UNKNOWN.";
        field {
            name = "word";
            desc = "32-bit word.";
            sw = rw;
            hw = r;
        } word[31:0];
    } W_554 @ 0x554;

    reg {
        name = "Word 0x55C";
        desc = "Word 0x55C. PROVEN: stored byte lanes 0123, cleared bit extents none seen, ORed constants none, written by VGS_DRV_SetReg_DestImg (2 stores). Meaning UNKNOWN.";
        field {
            name = "word";
            desc = "32-bit word.";
            sw = rw;
            hw = r;
        } word[31:0];
    } W_55C @ 0x55C;

    reg {
        name = "Word 0x564";
        desc = "Word 0x564. PROVEN: stored byte lanes 0123, cleared bit extents none seen, ORed constants none, written by VGS_DRV_SetReg_DestImg (1 stores). Meaning UNKNOWN.";
        field {
            name = "word";
            desc = "32-bit word.";
            sw = rw;
            hw = r;
        } word[31:0];
    } W_564 @ 0x564;

    reg {
        name = "Word 0x57C";
        desc = "Word 0x57C. PROVEN: stored byte lanes 0123, cleared bit extents none seen, ORed constants none, written by VGS_DRV_SetReg_DestImg (1 stores). Meaning UNKNOWN.";
        field {
            name = "word";
            desc = "32-bit word.";
            sw = rw;
            hw = r;
        } word[31:0];
    } W_57C @ 0x57C;

    reg {
        name = "Word 0x584";
        desc = "Word 0x584. PROVEN: stored byte lanes 0123, cleared bit extents none seen, ORed constants none, written by VGS_DRV_SetReg_DestImg (1 stores). Meaning UNKNOWN.";
        field {
            name = "word";
            desc = "32-bit word.";
            sw = rw;
            hw = r;
        } word[31:0];
    } W_584 @ 0x584;

    reg {
        name = "Word 0x588";
        desc = "Word 0x588. PROVEN: stored byte lanes 0123, cleared bit extents none seen, ORed constants none, written by VGS_DRV_SetReg_LumaStat (1 stores). Meaning UNKNOWN.";
        field {
            name = "word";
            desc = "32-bit word.";
            sw = rw;
            hw = r;
        } word[31:0];
    } W_588 @ 0x588;

    reg {
        name = "Word 0x5A0";
        desc = "Word 0x5A0. PROVEN: stored byte lanes 0123, cleared bit extents none seen, ORed constants 0x400000, written by VGS_DRV_SetReg_CurImg (2 stores). Meaning UNKNOWN.";
        field {
            name = "word";
            desc = "32-bit word.";
            sw = rw;
            hw = r;
        } word[31:0];
    } W_5A0 @ 0x5A0;

    reg {
        name = "Word 0x5A4";
        desc = "Word 0x5A4. PROVEN: stored byte lanes 0123, cleared bit extents none seen, ORed constants none, written by VGS_DRV_SetReg_CurImg (1 stores). Meaning UNKNOWN.";
        field {
            name = "word";
            desc = "32-bit word.";
            sw = rw;
            hw = r;
        } word[31:0];
    } W_5A4 @ 0x5A4;

    reg {
        name = "Word 0x5B0";
        desc = "Word 0x5B0. PROVEN: stored byte lanes 0123, cleared bit extents none seen, ORed constants none, written by VGS_DRV_SetReg_OSD (2 stores). Meaning UNKNOWN.";
        field {
            name = "word";
            desc = "32-bit word.";
            sw = rw;
            hw = r;
        } word[31:0];
    } W_5B0 @ 0x5B0;

    reg {
        name = "Word 0x5B4";
        desc = "Word 0x5B4. PROVEN: stored byte lanes 0123, cleared bit extents none seen, ORed constants none, written by VGS_DRV_SetReg_OSD (1 stores). Meaning UNKNOWN.";
        field {
            name = "word";
            desc = "32-bit word.";
            sw = rw;
            hw = r;
        } word[31:0];
    } W_5B4 @ 0x5B4;

    reg {
        name = "Word 0x5B8";
        desc = "Word 0x5B8. PROVEN: stored byte lanes 0123, cleared bit extents none seen, ORed constants none, written by VGS_DRV_SetReg_LumaStat (1 stores). Meaning UNKNOWN.";
        field {
            name = "word";
            desc = "32-bit word.";
            sw = rw;
            hw = r;
        } word[31:0];
    } W_5B8 @ 0x5B8;

    reg {
        name = "Word 0x5BC";
        desc = "Word 0x5BC. PROVEN: stored byte lanes 0123, cleared bit extents none seen, ORed constants none, written by VGS_DRV_SetReg_LumaStat (1 stores). Meaning UNKNOWN.";
        field {
            name = "word";
            desc = "32-bit word.";
            sw = rw;
            hw = r;
        } word[31:0];
    } W_5BC @ 0x5BC;

    reg {
        name = "Word 0x5C0";
        desc = "Word 0x5C0. PROVEN: stored byte lanes 0123, cleared bit extents none seen, ORed constants 0x2, written by VGS_DRV_SetReg_CUS_CDS (2 stores). Meaning UNKNOWN.";
        field {
            name = "word";
            desc = "32-bit word.";
            sw = rw;
            hw = r;
        } word[31:0];
    } W_5C0 @ 0x5C0;

    reg {
        name = "Word 0x5C4";
        desc = "Word 0x5C4. PROVEN: stored byte lanes 0123, cleared bit extents none seen, ORed constants none, written by VGS_DRV_SetReg_CUS_CDS (1 stores). Meaning UNKNOWN.";
        field {
            name = "word";
            desc = "32-bit word.";
            sw = rw;
            hw = r;
        } word[31:0];
    } W_5C4 @ 0x5C4;

    reg {
        name = "Word 0x5C8";
        desc = "Word 0x5C8. PROVEN: stored byte lanes 0123, cleared bit extents none seen, ORed constants none, written by VGS_DRV_SetReg_CSC (1 stores). Meaning UNKNOWN.";
        field {
            name = "word";
            desc = "32-bit word.";
            sw = rw;
            hw = r;
        } word[31:0];
    } W_5C8 @ 0x5C8;

    reg {
        name = "Word 0x5CC";
        desc = "Word 0x5CC. PROVEN: stored byte lanes 0123, cleared bit extents none seen, ORed constants none, written by VGS_DRV_SetReg_CSC (1 stores). Meaning UNKNOWN.";
        field {
            name = "word";
            desc = "32-bit word.";
            sw = rw;
            hw = r;
        } word[31:0];
    } W_5CC @ 0x5CC;

    reg {
        name = "Word 0x5D0";
        desc = "Word 0x5D0. PROVEN: stored byte lanes 0123, cleared bit extents none seen, ORed constants none, written by VGS_DRV_SetReg_CSC (1 stores). Meaning UNKNOWN.";
        field {
            name = "word";
            desc = "32-bit word.";
            sw = rw;
            hw = r;
        } word[31:0];
    } W_5D0 @ 0x5D0;

    reg {
        name = "Word 0x5D4";
        desc = "Word 0x5D4. PROVEN: stored byte lanes 0123, cleared bit extents none seen, ORed constants none, written by VGS_DRV_SetReg_CSC (1 stores). Meaning UNKNOWN.";
        field {
            name = "word";
            desc = "32-bit word.";
            sw = rw;
            hw = r;
        } word[31:0];
    } W_5D4 @ 0x5D4;

    reg {
        name = "Word 0x5D8";
        desc = "Word 0x5D8. PROVEN: stored byte lanes 0123, cleared bit extents none seen, ORed constants none, written by VGS_DRV_SetReg_CSC (1 stores). Meaning UNKNOWN.";
        field {
            name = "word";
            desc = "32-bit word.";
            sw = rw;
            hw = r;
        } word[31:0];
    } W_5D8 @ 0x5D8;

    reg {
        name = "Word 0x5DC";
        desc = "Word 0x5DC. PROVEN: stored byte lanes 0123, cleared bit extents none seen, ORed constants none, written by VGS_DRV_SetReg_CSC (1 stores). Meaning UNKNOWN.";
        field {
            name = "word";
            desc = "32-bit word.";
            sw = rw;
            hw = r;
        } word[31:0];
    } W_5DC @ 0x5DC;

    reg {
        name = "Word 0x5E0";
        desc = "Word 0x5E0. PROVEN: stored byte lanes 0123, cleared bit extents none seen, ORed constants none, written by VGS_DRV_SetReg_CSC (1 stores). Meaning UNKNOWN.";
        field {
            name = "word";
            desc = "32-bit word.";
            sw = rw;
            hw = r;
        } word[31:0];
    } W_5E0 @ 0x5E0;

    reg {
        name = "Word 0x5E4";
        desc = "Word 0x5E4. PROVEN: stored byte lanes 0123, cleared bit extents none seen, ORed constants none, written by VGS_DRV_SetReg_CSC (1 stores). Meaning UNKNOWN.";
        field {
            name = "word";
            desc = "32-bit word.";
            sw = rw;
            hw = r;
        } word[31:0];
    } W_5E4 @ 0x5E4;

    reg {
        name = "Word 0x5E8";
        desc = "Word 0x5E8. PROVEN: stored byte lanes 0123, cleared bit extents none seen, ORed constants none, written by VGS_DRV_SetReg_CSC (1 stores). Meaning UNKNOWN.";
        field {
            name = "word";
            desc = "32-bit word.";
            sw = rw;
            hw = r;
        } word[31:0];
    } W_5E8 @ 0x5E8;

    reg {
        name = "Word 0x5F0";
        desc = "Word 0x5F0. PROVEN: stored byte lanes 0123, cleared bit extents none seen, ORed constants none, written by VGS_DRV_SetReg_Blend, VGS_DRV_SetReg_Rop, VGS_DRV_SetReg_TDE (4 stores). Meaning UNKNOWN.";
        field {
            name = "word";
            desc = "32-bit word.";
            sw = rw;
            hw = r;
        } word[31:0];
    } W_5F0 @ 0x5F0;

    reg {
        name = "Word 0x5F4";
        desc = "Word 0x5F4. PROVEN: stored byte lanes 0123, cleared bit extents none seen, ORed constants none, written by VGS_DRV_SetReg_Colorkey (1 stores). Meaning UNKNOWN.";
        field {
            name = "word";
            desc = "32-bit word.";
            sw = rw;
            hw = r;
        } word[31:0];
    } W_5F4 @ 0x5F4;

    reg {
        name = "Word 0x5F8";
        desc = "Word 0x5F8. PROVEN: stored byte lanes 0123, cleared bit extents none seen, ORed constants none, written by VGS_DRV_SetReg_Colorkey (1 stores). Meaning UNKNOWN.";
        field {
            name = "word";
            desc = "32-bit word.";
            sw = rw;
            hw = r;
        } word[31:0];
    } W_5F8 @ 0x5F8;

    reg {
        name = "Word 0x5FC";
        desc = "Word 0x5FC. PROVEN: stored byte lanes 0123, cleared bit extents none seen, ORed constants none, written by VGS_DRV_SetReg_Colorkey (1 stores). Meaning UNKNOWN.";
        field {
            name = "word";
            desc = "32-bit word.";
            sw = rw;
            hw = r;
        } word[31:0];
    } W_5FC @ 0x5FC;

    reg {
        name = "Word 0x600";
        desc = "Word 0x600. PROVEN: stored byte lanes 0123, cleared bit extents none seen, ORed constants none, written by VGS_DRV_SetReg_Colorkey (1 stores). Meaning UNKNOWN.";
        field {
            name = "word";
            desc = "32-bit word.";
            sw = rw;
            hw = r;
        } word[31:0];
    } W_600 @ 0x600;

    reg {
        name = "Word 0x604";
        desc = "Word 0x604. PROVEN: stored byte lanes 0123, cleared bit extents none seen, ORed constants none, written by VGS_DRV_SetReg_Blend, VGS_DRV_SetReg_SCALE (2 stores). Meaning UNKNOWN.";
        field {
            name = "word";
            desc = "32-bit word.";
            sw = rw;
            hw = r;
        } word[31:0];
    } W_604 @ 0x604;

    reg {
        name = "Word 0x608";
        desc = "Word 0x608. PROVEN: stored byte lanes 0123, cleared bit extents none seen, ORed constants none, written by VGS_DRV_SetReg_COVER (1 stores). Meaning UNKNOWN.";
        field {
            name = "word";
            desc = "32-bit word.";
            sw = rw;
            hw = r;
        } word[31:0];
    } W_608 @ 0x608;

    reg {
        name = "Word 0x60C";
        desc = "Word 0x60C. PROVEN: stored byte lanes 0123, cleared bit extents none seen, ORed constants none, written by VGS_DRV_SetReg_COVER (1 stores). Meaning UNKNOWN.";
        field {
            name = "word";
            desc = "32-bit word.";
            sw = rw;
            hw = r;
        } word[31:0];
    } W_60C @ 0x60C;

    reg {
        name = "Word 0x610";
        desc = "Word 0x610. PROVEN: stored byte lanes 0123, cleared bit extents none seen, ORed constants none, written by VGS_DRV_SetReg_COVER (1 stores). Meaning UNKNOWN.";
        field {
            name = "word";
            desc = "32-bit word.";
            sw = rw;
            hw = r;
        } word[31:0];
    } W_610 @ 0x610;

    reg {
        name = "Word 0x614";
        desc = "Word 0x614. PROVEN: stored byte lanes 0123, cleared bit extents none seen, ORed constants none, written by VGS_DRV_SetReg_COVER (1 stores). Meaning UNKNOWN.";
        field {
            name = "word";
            desc = "32-bit word.";
            sw = rw;
            hw = r;
        } word[31:0];
    } W_614 @ 0x614;

    reg {
        name = "Word 0x628";
        desc = "Word 0x628. PROVEN: stored byte lanes 0123, cleared bit extents none seen, ORed constants none, written by VGS_DRV_SetReg_SCALE (1 stores). Meaning UNKNOWN.";
        field {
            name = "word";
            desc = "32-bit word.";
            sw = rw;
            hw = r;
        } word[31:0];
    } W_628 @ 0x628;

    reg {
        name = "Word 0x62C";
        desc = "Word 0x62C. PROVEN: stored byte lanes 0123, cleared bit extents none seen, ORed constants none, written by VGS_DRV_SetReg_SCALE (1 stores). Meaning UNKNOWN.";
        field {
            name = "word";
            desc = "32-bit word.";
            sw = rw;
            hw = r;
        } word[31:0];
    } W_62C @ 0x62C;

    reg {
        name = "Word 0x630";
        desc = "Word 0x630. PROVEN: stored byte lanes 0123, cleared bit extents none seen, ORed constants none, written by VGS_DRV_SetReg_SCALE (2 stores). Meaning UNKNOWN.";
        field {
            name = "word";
            desc = "32-bit word.";
            sw = rw;
            hw = r;
        } word[31:0];
    } W_630 @ 0x630;

    reg {
        name = "Word 0x634";
        desc = "Word 0x634. PROVEN: stored byte lanes 0123, cleared bit extents none seen, ORed constants none, written by VGS_DRV_SetReg_SCALE (1 stores). Meaning UNKNOWN.";
        field {
            name = "word";
            desc = "32-bit word.";
            sw = rw;
            hw = r;
        } word[31:0];
    } W_634 @ 0x634;

    reg {
        name = "Word 0x638";
        desc = "Word 0x638. PROVEN: stored byte lanes 0123, cleared bit extents none seen, ORed constants none, written by VGS_DRV_SetReg_SCALE (1 stores). Meaning UNKNOWN.";
        field {
            name = "word";
            desc = "32-bit word.";
            sw = rw;
            hw = r;
        } word[31:0];
    } W_638 @ 0x638;

    reg {
        name = "Word 0x63C";
        desc = "Word 0x63C. PROVEN: stored byte lanes 0123, cleared bit extents none seen, ORed constants none, written by VGS_DRV_SetReg_SCALE (1 stores). Meaning UNKNOWN.";
        field {
            name = "word";
            desc = "32-bit word.";
            sw = rw;
            hw = r;
        } word[31:0];
    } W_63C @ 0x63C;

    reg {
        name = "Word 0x640";
        desc = "Word 0x640. PROVEN: stored byte lanes 0123, cleared bit extents none seen, ORed constants none, written by VGS_DRV_SetReg_SCALE (2 stores). Meaning UNKNOWN.";
        field {
            name = "word";
            desc = "32-bit word.";
            sw = rw;
            hw = r;
        } word[31:0];
    } W_640 @ 0x640;

    reg {
        name = "Word 0x644";
        desc = "Word 0x644. PROVEN: stored byte lanes 0123, cleared bit extents none seen, ORed constants none, written by VGS_DRV_SetReg_SCALE (1 stores). Meaning UNKNOWN.";
        field {
            name = "word";
            desc = "32-bit word.";
            sw = rw;
            hw = r;
        } word[31:0];
    } W_644 @ 0x644;

    reg {
        name = "Word 0x648";
        desc = "Word 0x648. PROVEN: stored byte lanes 0123, cleared bit extents none seen, ORed constants none, written by VGS_DRV_SetReg_SCALE (1 stores). Meaning UNKNOWN.";
        field {
            name = "word";
            desc = "32-bit word.";
            sw = rw;
            hw = r;
        } word[31:0];
    } W_648 @ 0x648;

    reg {
        name = "Word 0x650";
        desc = "Word 0x650. PROVEN: stored byte lanes 0123, cleared bit extents none seen, ORed constants 0xF, written by VGS_DRV_SetReg_DRD (1 stores). Meaning UNKNOWN.";
        field {
            name = "word";
            desc = "32-bit word.";
            sw = rw;
            hw = r;
        } word[31:0];
    } W_650 @ 0x650;

    reg {
        name = "Word 0x654";
        desc = "Word 0x654. PROVEN: stored byte lanes 0123, cleared bit extents none seen, ORed constants none, written by VGS_DRV_SetReg_DRD (1 stores). Meaning UNKNOWN.";
        field {
            name = "word";
            desc = "32-bit word.";
            sw = rw;
            hw = r;
        } word[31:0];
    } W_654 @ 0x654;

    reg {
        name = "Word 0x658";
        desc = "Word 0x658. PROVEN: stored byte lanes 0123, cleared bit extents none seen, ORed constants none, written by VGS_DRV_SetReg_DRD (1 stores). Meaning UNKNOWN.";
        field {
            name = "word";
            desc = "32-bit word.";
            sw = rw;
            hw = r;
        } word[31:0];
    } W_658 @ 0x658;

    reg {
        name = "Word 0x65C";
        desc = "Word 0x65C. PROVEN: stored byte lanes 0123, cleared bit extents none seen, ORed constants none, written by VGS_DRV_SetReg_DRD (1 stores). Meaning UNKNOWN.";
        field {
            name = "word";
            desc = "32-bit word.";
            sw = rw;
            hw = r;
        } word[31:0];
    } W_65C @ 0x65C;

    reg {
        name = "Word 0x660";
        desc = "Word 0x660. PROVEN: stored byte lanes 0123, cleared bit extents none seen, ORed constants none, written by VGS_DRV_SetReg_DRD (1 stores). Meaning UNKNOWN.";
        field {
            name = "word";
            desc = "32-bit word.";
            sw = rw;
            hw = r;
        } word[31:0];
    } W_660 @ 0x660;

    reg {
        name = "Word 0x664";
        desc = "Word 0x664. PROVEN: stored byte lanes 0123, cleared bit extents none seen, ORed constants none, written by VGS_DRV_SetReg_DRD (1 stores). Meaning UNKNOWN.";
        field {
            name = "word";
            desc = "32-bit word.";
            sw = rw;
            hw = r;
        } word[31:0];
    } W_664 @ 0x664;

    reg {
        name = "Word 0x668";
        desc = "Word 0x668. PROVEN: stored byte lanes 0123, cleared bit extents none seen, ORed constants none, written by VGS_DRV_SetReg_DRD (1 stores). Meaning UNKNOWN.";
        field {
            name = "word";
            desc = "32-bit word.";
            sw = rw;
            hw = r;
        } word[31:0];
    } W_668 @ 0x668;

    reg {
        name = "Word 0x66C";
        desc = "Word 0x66C. PROVEN: stored byte lanes 0123, cleared bit extents none seen, ORed constants none, written by VGS_DRV_SetReg_DRD (1 stores). Meaning UNKNOWN.";
        field {
            name = "word";
            desc = "32-bit word.";
            sw = rw;
            hw = r;
        } word[31:0];
    } W_66C @ 0x66C;

    reg {
        name = "Word 0x670";
        desc = "Word 0x670. PROVEN: stored byte lanes 0123, cleared bit extents none seen, ORed constants none, written by VGS_DRV_SetReg_DRD (1 stores). Meaning UNKNOWN.";
        field {
            name = "word";
            desc = "32-bit word.";
            sw = rw;
            hw = r;
        } word[31:0];
    } W_670 @ 0x670;

    reg {
        name = "Word 0x674";
        desc = "Word 0x674. PROVEN: stored byte lanes 0123, cleared bit extents none seen, ORed constants none, written by VGS_DRV_SetReg_DRD (1 stores). Meaning UNKNOWN.";
        field {
            name = "word";
            desc = "32-bit word.";
            sw = rw;
            hw = r;
        } word[31:0];
    } W_674 @ 0x674;

    reg {
        name = "Word 0x678";
        desc = "Word 0x678. PROVEN: stored byte lanes 0123, cleared bit extents none seen, ORed constants none, written by VGS_DRV_SetReg_DRD (1 stores). Meaning UNKNOWN.";
        field {
            name = "word";
            desc = "32-bit word.";
            sw = rw;
            hw = r;
        } word[31:0];
    } W_678 @ 0x678;

    reg {
        name = "Word 0x67C";
        desc = "Word 0x67C. PROVEN: stored byte lanes 0123, cleared bit extents none seen, ORed constants none, written by VGS_DRV_SetReg_DRD (1 stores). Meaning UNKNOWN.";
        field {
            name = "word";
            desc = "32-bit word.";
            sw = rw;
            hw = r;
        } word[31:0];
    } W_67C @ 0x67C;

    reg {
        name = "Word 0x680";
        desc = "Word 0x680. PROVEN: stored byte lanes 0123, cleared bit extents none seen, ORed constants none, written by VGS_DRV_SetReg_DRD (1 stores). Meaning UNKNOWN.";
        field {
            name = "word";
            desc = "32-bit word.";
            sw = rw;
            hw = r;
        } word[31:0];
    } W_680 @ 0x680;

};

`endif
`ifndef HISI_VEDU_H264_TABLE_V4_RDL
`define HISI_VEDU_H264_TABLE_V4_RDL

regfile eVEDU_H264_TABLE_V4 {
    name = "VEDU H.264 register image (DDR table)";
    desc = "Hi3516E V200 / V300 (hi3516ev200_h264e.ko, h264e_drv_update_*/cfg_address/init_* with the table pointer loaded from [ctx + 0x428], 171 words). DDR register image fetched by VEDU at START (REG_IMAGE, MMIO 0x58): the offsets 0x104/0x108 source, 0x12C/0x130 ring pointer cells, 0x16C ring base, 0x1F4 strides, 0x4A0 ring size, 0x61C slice QP of the qemu RE match this table (INFERRED roles). Meaning of the other words UNKNOWN. NOT A REGISTER FILE unless stated: register image / table written by the traced functions. PROVENANCE LABELS: PROVEN = read from the instruction stream (offset, stored byte lanes, cleared bit extents, ORed constants); INFERRED = role deduced from names or sibling chips; UNKNOWN = everything else. Source: symbolic trace of the module disassembly (arm-trace). Branches are linearized, extents are lower bounds. Not hardware verified.";

    reg {
        name = "Word 0x0";
        desc = "Word 0x0. PROVEN: stored byte lanes 01, cleared bit extents none seen, ORed constants none, written by h264e_drv_update_row_intra_refresh (1 stores). Meaning UNKNOWN.";
        field {
            name = "word";
            desc = "32-bit word.";
            sw = rw;
            hw = r;
        } word[31:0];
    } W_000 @ 0x0;

    reg {
        name = "Word 0x54";
        desc = "Word 0x54. PROVEN: stored byte lanes 012, cleared bit extents none seen, ORed constants 0x130000, written by h264e_drv_update_base_reg, h264e_drv_update_row_intra_refresh (5 stores). Meaning UNKNOWN.";
        field {
            name = "word";
            desc = "32-bit word.";
            sw = rw;
            hw = r;
        } word[31:0];
    } W_054 @ 0x54;

    reg {
        name = "Word 0x100";
        desc = "Word 0x100. PROVEN: stored byte lanes 0123, cleared bit extents none seen, ORed constants none, written by h264e_drv_cfg_address (1 stores). Meaning UNKNOWN.";
        field {
            name = "word";
            desc = "32-bit word.";
            sw = rw;
            hw = r;
        } word[31:0];
    } W_100 @ 0x100;

    reg {
        name = "Word 0x104";
        desc = "Word 0x104. PROVEN: stored byte lanes 0123, cleared bit extents none seen, ORed constants none, written by h264e_drv_cfg_address (1 stores). Meaning UNKNOWN.";
        field {
            name = "word";
            desc = "32-bit word.";
            sw = rw;
            hw = r;
        } word[31:0];
    } W_104 @ 0x104;

    reg {
        name = "Word 0x108";
        desc = "Word 0x108. PROVEN: stored byte lanes 0123, cleared bit extents none seen, ORed constants none, written by h264e_drv_cfg_address (1 stores). Meaning UNKNOWN.";
        field {
            name = "word";
            desc = "32-bit word.";
            sw = rw;
            hw = r;
        } word[31:0];
    } W_108 @ 0x108;

    reg {
        name = "Word 0x10C";
        desc = "Word 0x10C. PROVEN: stored byte lanes 0123, cleared bit extents none seen, ORed constants none, written by h264e_drv_cfg_address (1 stores). Meaning UNKNOWN.";
        field {
            name = "word";
            desc = "32-bit word.";
            sw = rw;
            hw = r;
        } word[31:0];
    } W_10C @ 0x10C;

    reg {
        name = "Word 0x110";
        desc = "Word 0x110. PROVEN: stored byte lanes 0123, cleared bit extents none seen, ORed constants none, written by h264e_drv_cfg_address (1 stores). Meaning UNKNOWN.";
        field {
            name = "word";
            desc = "32-bit word.";
            sw = rw;
            hw = r;
        } word[31:0];
    } W_110 @ 0x110;

    reg {
        name = "Word 0x12C";
        desc = "Word 0x12C. PROVEN: stored byte lanes 0123, cleared bit extents none seen, ORed constants none, written by h264e_drv_cfg_address (1 stores). Meaning UNKNOWN.";
        field {
            name = "word";
            desc = "32-bit word.";
            sw = rw;
            hw = r;
        } word[31:0];
    } W_12C @ 0x12C;

    reg {
        name = "Word 0x130";
        desc = "Word 0x130. PROVEN: stored byte lanes 0123, cleared bit extents none seen, ORed constants none, written by h264e_drv_cfg_address (1 stores). Meaning UNKNOWN.";
        field {
            name = "word";
            desc = "32-bit word.";
            sw = rw;
            hw = r;
        } word[31:0];
    } W_130 @ 0x130;

    reg {
        name = "Word 0x13C";
        desc = "Word 0x13C. PROVEN: stored byte lanes 0123, cleared bit extents none seen, ORed constants none, written by h264e_drv_cfg_address (1 stores). Meaning UNKNOWN.";
        field {
            name = "word";
            desc = "32-bit word.";
            sw = rw;
            hw = r;
        } word[31:0];
    } W_13C @ 0x13C;

    reg {
        name = "Word 0x140";
        desc = "Word 0x140. PROVEN: stored byte lanes 0123, cleared bit extents none seen, ORed constants none, written by h264e_drv_cfg_address (1 stores). Meaning UNKNOWN.";
        field {
            name = "word";
            desc = "32-bit word.";
            sw = rw;
            hw = r;
        } word[31:0];
    } W_140 @ 0x140;

    reg {
        name = "Word 0x144";
        desc = "Word 0x144. PROVEN: stored byte lanes 0123, cleared bit extents none seen, ORed constants none, written by h264e_drv_cfg_address (1 stores). Meaning UNKNOWN.";
        field {
            name = "word";
            desc = "32-bit word.";
            sw = rw;
            hw = r;
        } word[31:0];
    } W_144 @ 0x144;

    reg {
        name = "Word 0x16C";
        desc = "Word 0x16C. PROVEN: stored byte lanes 0123, cleared bit extents none seen, ORed constants none, written by h264e_drv_cfg_address (1 stores). Meaning UNKNOWN.";
        field {
            name = "word";
            desc = "32-bit word.";
            sw = rw;
            hw = r;
        } word[31:0];
    } W_16C @ 0x16C;

    reg {
        name = "Word 0x1EC";
        desc = "Word 0x1EC. PROVEN: stored byte lanes 0123, cleared bit extents none seen, ORed constants none, written by h264e_drv_cfg_address (2 stores). Meaning UNKNOWN.";
        field {
            name = "word";
            desc = "32-bit word.";
            sw = rw;
            hw = r;
        } word[31:0];
    } W_1EC @ 0x1EC;

    reg {
        name = "Word 0x1F0";
        desc = "Word 0x1F0. PROVEN: stored byte lanes 0123, cleared bit extents none seen, ORed constants none, written by h264e_drv_cfg_address (2 stores). Meaning UNKNOWN.";
        field {
            name = "word";
            desc = "32-bit word.";
            sw = rw;
            hw = r;
        } word[31:0];
    } W_1F0 @ 0x1F0;

    reg {
        name = "Word 0x200";
        desc = "Word 0x200. PROVEN: stored byte lanes 0, cleared bit extents none seen, ORed constants 0x1, written by h264e_drv_update_base_reg (2 stores). Meaning UNKNOWN.";
        field {
            name = "word";
            desc = "32-bit word.";
            sw = rw;
            hw = r;
        } word[31:0];
    } W_200 @ 0x200;

    reg {
        name = "Word 0x204";
        desc = "Word 0x204. PROVEN: stored byte lanes 0123, cleared bit extents none seen, ORed constants none, written by h264e_drv_update_base_reg (2 stores). Meaning UNKNOWN.";
        field {
            name = "word";
            desc = "32-bit word.";
            sw = rw;
            hw = r;
        } word[31:0];
    } W_204 @ 0x204;

    reg {
        name = "Word 0x208";
        desc = "Word 0x208. PROVEN: stored byte lanes 0123, cleared bit extents none seen, ORed constants none, written by h264e_drv_update_base_reg (1 stores). Meaning UNKNOWN.";
        field {
            name = "word";
            desc = "32-bit word.";
            sw = rw;
            hw = r;
        } word[31:0];
    } W_208 @ 0x208;

    reg {
        name = "Word 0x20C";
        desc = "Word 0x20C. PROVEN: stored byte lanes 0123, cleared bit extents none seen, ORed constants 0x3, written by h264e_drv_update_base_reg (1 stores). Meaning UNKNOWN.";
        field {
            name = "word";
            desc = "32-bit word.";
            sw = rw;
            hw = r;
        } word[31:0];
    } W_20C @ 0x20C;

    reg {
        name = "Word 0x210";
        desc = "Word 0x210. PROVEN: stored byte lanes 0123, cleared bit extents none seen, ORed constants none, written by h264e_drv_update_base_reg (1 stores). Meaning UNKNOWN.";
        field {
            name = "word";
            desc = "32-bit word.";
            sw = rw;
            hw = r;
        } word[31:0];
    } W_210 @ 0x210;

    reg {
        name = "Word 0x214";
        desc = "Word 0x214. PROVEN: stored byte lanes 0123, cleared bit extents none seen, ORed constants none, written by h264e_drv_update_base_reg (2 stores). Meaning UNKNOWN.";
        field {
            name = "word";
            desc = "32-bit word.";
            sw = rw;
            hw = r;
        } word[31:0];
    } W_214 @ 0x214;

    reg {
        name = "Word 0x218";
        desc = "Word 0x218. PROVEN: stored byte lanes 0123, cleared bit extents none seen, ORed constants none, written by h264e_drv_update_base_reg (2 stores). Meaning UNKNOWN.";
        field {
            name = "word";
            desc = "32-bit word.";
            sw = rw;
            hw = r;
        } word[31:0];
    } W_218 @ 0x218;

    reg {
        name = "Word 0x21C";
        desc = "Word 0x21C. PROVEN: stored byte lanes 0123, cleared bit extents none seen, ORed constants none, written by h264e_drv_update_base_reg (2 stores). Meaning UNKNOWN.";
        field {
            name = "word";
            desc = "32-bit word.";
            sw = rw;
            hw = r;
        } word[31:0];
    } W_21C @ 0x21C;

    reg {
        name = "Word 0x220";
        desc = "Word 0x220. PROVEN: stored byte lanes 0123, cleared bit extents none seen, ORed constants none, written by h264e_drv_update_base_reg (2 stores). Meaning UNKNOWN.";
        field {
            name = "word";
            desc = "32-bit word.";
            sw = rw;
            hw = r;
        } word[31:0];
    } W_220 @ 0x220;

    reg {
        name = "Word 0x224";
        desc = "Word 0x224. PROVEN: stored byte lanes 0123, cleared bit extents none seen, ORed constants none, written by h264e_drv_update_base_reg (2 stores). Meaning UNKNOWN.";
        field {
            name = "word";
            desc = "32-bit word.";
            sw = rw;
            hw = r;
        } word[31:0];
    } W_224 @ 0x224;

    reg {
        name = "Word 0x234";
        desc = "Word 0x234. PROVEN: stored byte lanes 01, cleared bit extents none seen, ORed constants none, written by h264e_drv_update_base_reg (3 stores). Meaning UNKNOWN.";
        field {
            name = "word";
            desc = "32-bit word.";
            sw = rw;
            hw = r;
        } word[31:0];
    } W_234 @ 0x234;

    reg {
        name = "Word 0x238";
        desc = "Word 0x238. PROVEN: stored byte lanes 0, cleared bit extents none seen, ORed constants none, written by h264e_drv_update_base_reg (1 stores). Meaning UNKNOWN.";
        field {
            name = "word";
            desc = "32-bit word.";
            sw = rw;
            hw = r;
        } word[31:0];
    } W_238 @ 0x238;

    reg {
        name = "Word 0x240";
        desc = "Word 0x240. PROVEN: stored byte lanes 0123, cleared bit extents none seen, ORed constants 0x1, 0x20, 0x4000, written by h264e_drv_update_base_reg (8 stores). Meaning UNKNOWN.";
        field {
            name = "word";
            desc = "32-bit word.";
            sw = rw;
            hw = r;
        } word[31:0];
    } W_240 @ 0x240;

    reg {
        name = "Word 0x244";
        desc = "Word 0x244. PROVEN: stored byte lanes 0123, cleared bit extents none seen, ORed constants none, written by h264e_drv_update_base_reg (1 stores). Meaning UNKNOWN.";
        field {
            name = "word";
            desc = "32-bit word.";
            sw = rw;
            hw = r;
        } word[31:0];
    } W_244 @ 0x244;

    reg {
        name = "Word 0x250";
        desc = "Word 0x250. PROVEN: stored byte lanes 2, cleared bit extents none seen, ORed constants 0x10000, 0x20000, written by h264e_drv_update_columnIntra_refresh, h264e_drv_update_row_intra_refresh (8 stores). Meaning UNKNOWN.";
        field {
            name = "word";
            desc = "32-bit word.";
            sw = rw;
            hw = r;
        } word[31:0];
    } W_250 @ 0x250;

    reg {
        name = "Word 0x254";
        desc = "Word 0x254. PROVEN: stored byte lanes 0, cleared bit extents none seen, ORed constants 0x1, 0x3, written by h264e_drv_update_columnIntra_refresh, h264e_drv_update_row_intra_refresh (4 stores). Meaning UNKNOWN.";
        field {
            name = "word";
            desc = "32-bit word.";
            sw = rw;
            hw = r;
        } word[31:0];
    } W_254 @ 0x254;

    reg {
        name = "Word 0x258";
        desc = "Word 0x258. PROVEN: stored byte lanes 0123, cleared bit extents none seen, ORed constants none, written by h264e_drv_update_columnIntra_refresh, h264e_drv_update_row_intra_refresh (5 stores). Meaning UNKNOWN.";
        field {
            name = "word";
            desc = "32-bit word.";
            sw = rw;
            hw = r;
        } word[31:0];
    } W_258 @ 0x258;

    reg {
        name = "Word 0x25C";
        desc = "Word 0x25C. PROVEN: stored byte lanes 0123, cleared bit extents none seen, ORed constants none, written by h264e_drv_update_base_reg (1 stores). Meaning UNKNOWN.";
        field {
            name = "word";
            desc = "32-bit word.";
            sw = rw;
            hw = r;
        } word[31:0];
    } W_25C @ 0x25C;

    reg {
        name = "Word 0x260";
        desc = "Word 0x260. PROVEN: stored byte lanes 0123, cleared bit extents none seen, ORed constants 0x7, written by h264e_drv_update_base_reg (1 stores). Meaning UNKNOWN.";
        field {
            name = "word";
            desc = "32-bit word.";
            sw = rw;
            hw = r;
        } word[31:0];
    } W_260 @ 0x260;

    reg {
        name = "Word 0x264";
        desc = "Word 0x264. PROVEN: stored byte lanes 0123, cleared bit extents none seen, ORed constants none, written by h264e_drv_update_base_reg (1 stores). Meaning UNKNOWN.";
        field {
            name = "word";
            desc = "32-bit word.";
            sw = rw;
            hw = r;
        } word[31:0];
    } W_264 @ 0x264;

    reg {
        name = "Word 0x268";
        desc = "Word 0x268. PROVEN: stored byte lanes 0123, cleared bit extents none seen, ORed constants 0x7, written by h264e_drv_update_base_reg (1 stores). Meaning UNKNOWN.";
        field {
            name = "word";
            desc = "32-bit word.";
            sw = rw;
            hw = r;
        } word[31:0];
    } W_268 @ 0x268;

    reg {
        name = "Word 0x26C";
        desc = "Word 0x26C. PROVEN: stored byte lanes 0123, cleared bit extents none seen, ORed constants none, written by h264e_drv_update_base_reg (1 stores). Meaning UNKNOWN.";
        field {
            name = "word";
            desc = "32-bit word.";
            sw = rw;
            hw = r;
        } word[31:0];
    } W_26C @ 0x26C;

    reg {
        name = "Word 0x270";
        desc = "Word 0x270. PROVEN: stored byte lanes 0123, cleared bit extents none seen, ORed constants 0x7, written by h264e_drv_update_base_reg (1 stores). Meaning UNKNOWN.";
        field {
            name = "word";
            desc = "32-bit word.";
            sw = rw;
            hw = r;
        } word[31:0];
    } W_270 @ 0x270;

    reg {
        name = "Word 0x274";
        desc = "Word 0x274. PROVEN: stored byte lanes 0123, cleared bit extents none seen, ORed constants none, written by h264e_drv_update_base_reg (1 stores). Meaning UNKNOWN.";
        field {
            name = "word";
            desc = "32-bit word.";
            sw = rw;
            hw = r;
        } word[31:0];
    } W_274 @ 0x274;

    reg {
        name = "Word 0x278";
        desc = "Word 0x278. PROVEN: stored byte lanes 0123, cleared bit extents none seen, ORed constants 0x7, written by h264e_drv_update_base_reg (1 stores). Meaning UNKNOWN.";
        field {
            name = "word";
            desc = "32-bit word.";
            sw = rw;
            hw = r;
        } word[31:0];
    } W_278 @ 0x278;

    reg {
        name = "Word 0x27C";
        desc = "Word 0x27C. PROVEN: stored byte lanes 0, cleared bit extents none seen, ORed constants none, written by h264e_drv_update_base_reg (1 stores). Meaning UNKNOWN.";
        field {
            name = "word";
            desc = "32-bit word.";
            sw = rw;
            hw = r;
        } word[31:0];
    } W_27C @ 0x27C;

    reg {
        name = "Word 0x3A4";
        desc = "Word 0x3A4. PROVEN: stored byte lanes 0123, cleared bit extents none seen, ORed constants none, written by h264e_drv_update_row_intra_refresh (1 stores). Meaning UNKNOWN.";
        field {
            name = "word";
            desc = "32-bit word.";
            sw = rw;
            hw = r;
        } word[31:0];
    } W_3A4 @ 0x3A4;

    reg {
        name = "Word 0x400";
        desc = "Word 0x400. PROVEN: stored byte lanes 01, cleared bit extents none seen, ORed constants none, written by h264e_drv_update_common_reg (3 stores). Meaning UNKNOWN.";
        field {
            name = "word";
            desc = "32-bit word.";
            sw = rw;
            hw = r;
        } word[31:0];
    } W_400 @ 0x400;

    reg {
        name = "Word 0x454";
        desc = "Word 0x454. PROVEN: stored byte lanes 0123, cleared bit extents none seen, ORed constants none, written by h264e_drv_update_common_reg (1 stores). Meaning UNKNOWN.";
        field {
            name = "word";
            desc = "32-bit word.";
            sw = rw;
            hw = r;
        } word[31:0];
    } W_454 @ 0x454;

    reg {
        name = "Word 0x458";
        desc = "Word 0x458. PROVEN: stored byte lanes 0123, cleared bit extents none seen, ORed constants none, written by h264e_drv_update_common_reg (1 stores). Meaning UNKNOWN.";
        field {
            name = "word";
            desc = "32-bit word.";
            sw = rw;
            hw = r;
        } word[31:0];
    } W_458 @ 0x458;

    reg {
        name = "Word 0x45C";
        desc = "Word 0x45C. PROVEN: stored byte lanes 0123, cleared bit extents none seen, ORed constants none, written by h264e_drv_update_common_reg (1 stores). Meaning UNKNOWN.";
        field {
            name = "word";
            desc = "32-bit word.";
            sw = rw;
            hw = r;
        } word[31:0];
    } W_45C @ 0x45C;

    reg {
        name = "Word 0x460";
        desc = "Word 0x460. PROVEN: stored byte lanes 0123, cleared bit extents none seen, ORed constants none, written by h264e_drv_update_common_reg (1 stores). Meaning UNKNOWN.";
        field {
            name = "word";
            desc = "32-bit word.";
            sw = rw;
            hw = r;
        } word[31:0];
    } W_460 @ 0x460;

    reg {
        name = "Word 0x464";
        desc = "Word 0x464. PROVEN: stored byte lanes 0123, cleared bit extents none seen, ORed constants none, written by h264e_drv_update_common_reg (1 stores). Meaning UNKNOWN.";
        field {
            name = "word";
            desc = "32-bit word.";
            sw = rw;
            hw = r;
        } word[31:0];
    } W_464 @ 0x464;

    reg {
        name = "Word 0x468";
        desc = "Word 0x468. PROVEN: stored byte lanes 0123, cleared bit extents none seen, ORed constants none, written by h264e_drv_update_common_reg (1 stores). Meaning UNKNOWN.";
        field {
            name = "word";
            desc = "32-bit word.";
            sw = rw;
            hw = r;
        } word[31:0];
    } W_468 @ 0x468;

    reg {
        name = "Word 0x46C";
        desc = "Word 0x46C. PROVEN: stored byte lanes 0123, cleared bit extents none seen, ORed constants none, written by h264e_drv_update_common_reg (1 stores). Meaning UNKNOWN.";
        field {
            name = "word";
            desc = "32-bit word.";
            sw = rw;
            hw = r;
        } word[31:0];
    } W_46C @ 0x46C;

    reg {
        name = "Word 0x470";
        desc = "Word 0x470. PROVEN: stored byte lanes 0123, cleared bit extents none seen, ORed constants none, written by h264e_drv_update_common_reg (1 stores). Meaning UNKNOWN.";
        field {
            name = "word";
            desc = "32-bit word.";
            sw = rw;
            hw = r;
        } word[31:0];
    } W_470 @ 0x470;

    reg {
        name = "Word 0x474";
        desc = "Word 0x474. PROVEN: stored byte lanes 012, cleared bit extents none seen, ORed constants none, written by h264e_drv_update_common_reg (3 stores). Meaning UNKNOWN.";
        field {
            name = "word";
            desc = "32-bit word.";
            sw = rw;
            hw = r;
        } word[31:0];
    } W_474 @ 0x474;

    reg {
        name = "Word 0x478";
        desc = "Word 0x478. PROVEN: stored byte lanes 0123, cleared bit extents none seen, ORed constants none, written by h264e_drv_update_common_reg (2 stores). Meaning UNKNOWN.";
        field {
            name = "word";
            desc = "32-bit word.";
            sw = rw;
            hw = r;
        } word[31:0];
    } W_478 @ 0x478;

    reg {
        name = "Word 0x47C";
        desc = "Word 0x47C. PROVEN: stored byte lanes 0123, cleared bit extents none seen, ORed constants none, written by h264e_drv_update_common_reg (1 stores). Meaning UNKNOWN.";
        field {
            name = "word";
            desc = "32-bit word.";
            sw = rw;
            hw = r;
        } word[31:0];
    } W_47C @ 0x47C;

    reg {
        name = "Word 0x480";
        desc = "Word 0x480. PROVEN: stored byte lanes 0123, cleared bit extents none seen, ORed constants none, written by h264e_drv_update_common_reg (1 stores). Meaning UNKNOWN.";
        field {
            name = "word";
            desc = "32-bit word.";
            sw = rw;
            hw = r;
        } word[31:0];
    } W_480 @ 0x480;

    reg {
        name = "Word 0x484";
        desc = "Word 0x484. PROVEN: stored byte lanes 0123, cleared bit extents none seen, ORed constants none, written by h264e_drv_update_common_reg (1 stores). Meaning UNKNOWN.";
        field {
            name = "word";
            desc = "32-bit word.";
            sw = rw;
            hw = r;
        } word[31:0];
    } W_484 @ 0x484;

    reg {
        name = "Word 0x488";
        desc = "Word 0x488. PROVEN: stored byte lanes 0123, cleared bit extents none seen, ORed constants none, written by h264e_drv_update_common_reg (1 stores). Meaning UNKNOWN.";
        field {
            name = "word";
            desc = "32-bit word.";
            sw = rw;
            hw = r;
        } word[31:0];
    } W_488 @ 0x488;

    reg {
        name = "Word 0x48C";
        desc = "Word 0x48C. PROVEN: stored byte lanes 0123, cleared bit extents none seen, ORed constants none, written by h264e_drv_update_common_reg (1 stores). Meaning UNKNOWN.";
        field {
            name = "word";
            desc = "32-bit word.";
            sw = rw;
            hw = r;
        } word[31:0];
    } W_48C @ 0x48C;

    reg {
        name = "Word 0x490";
        desc = "Word 0x490. PROVEN: stored byte lanes 0123, cleared bit extents none seen, ORed constants none, written by h264e_drv_update_common_reg (1 stores). Meaning UNKNOWN.";
        field {
            name = "word";
            desc = "32-bit word.";
            sw = rw;
            hw = r;
        } word[31:0];
    } W_490 @ 0x490;

    reg {
        name = "Word 0x494";
        desc = "Word 0x494. PROVEN: stored byte lanes 0123, cleared bit extents none seen, ORed constants none, written by h264e_drv_update_common_reg (1 stores). Meaning UNKNOWN.";
        field {
            name = "word";
            desc = "32-bit word.";
            sw = rw;
            hw = r;
        } word[31:0];
    } W_494 @ 0x494;

    reg {
        name = "Word 0x498";
        desc = "Word 0x498. PROVEN: stored byte lanes 0123, cleared bit extents none seen, ORed constants none, written by h264e_drv_update_common_reg (1 stores). Meaning UNKNOWN.";
        field {
            name = "word";
            desc = "32-bit word.";
            sw = rw;
            hw = r;
        } word[31:0];
    } W_498 @ 0x498;

    reg {
        name = "Word 0x49C";
        desc = "Word 0x49C. PROVEN: stored byte lanes 012, cleared bit extents none seen, ORed constants none, written by h264e_drv_update_common_reg (3 stores). Meaning UNKNOWN.";
        field {
            name = "word";
            desc = "32-bit word.";
            sw = rw;
            hw = r;
        } word[31:0];
    } W_49C @ 0x49C;

    reg {
        name = "Word 0x4A0";
        desc = "Word 0x4A0. PROVEN: stored byte lanes 0123, cleared bit extents none seen, ORed constants none, written by h264e_drv_update_common_reg (1 stores). Meaning UNKNOWN.";
        field {
            name = "word";
            desc = "32-bit word.";
            sw = rw;
            hw = r;
        } word[31:0];
    } W_4A0 @ 0x4A0;

    reg {
        name = "Word 0x4A4";
        desc = "Word 0x4A4. PROVEN: stored byte lanes 0123, cleared bit extents none seen, ORed constants none, written by h264e_drv_update_common_reg (1 stores). Meaning UNKNOWN.";
        field {
            name = "word";
            desc = "32-bit word.";
            sw = rw;
            hw = r;
        } word[31:0];
    } W_4A4 @ 0x4A4;

    reg {
        name = "Word 0x4A8";
        desc = "Word 0x4A8. PROVEN: stored byte lanes 0123, cleared bit extents none seen, ORed constants none, written by h264e_drv_update_common_reg (1 stores). Meaning UNKNOWN.";
        field {
            name = "word";
            desc = "32-bit word.";
            sw = rw;
            hw = r;
        } word[31:0];
    } W_4A8 @ 0x4A8;

    reg {
        name = "Word 0x4AC";
        desc = "Word 0x4AC. PROVEN: stored byte lanes 0123, cleared bit extents none seen, ORed constants none, written by h264e_drv_update_common_reg (1 stores). Meaning UNKNOWN.";
        field {
            name = "word";
            desc = "32-bit word.";
            sw = rw;
            hw = r;
        } word[31:0];
    } W_4AC @ 0x4AC;

    reg {
        name = "Word 0x4B0";
        desc = "Word 0x4B0. PROVEN: stored byte lanes 0123, cleared bit extents none seen, ORed constants none, written by h264e_drv_update_common_reg (1 stores). Meaning UNKNOWN.";
        field {
            name = "word";
            desc = "32-bit word.";
            sw = rw;
            hw = r;
        } word[31:0];
    } W_4B0 @ 0x4B0;

    reg {
        name = "Word 0x504";
        desc = "Word 0x504. PROVEN: stored byte lanes 0, cleared bit extents none seen, ORed constants none, written by h264e_drv_update_lower_power_cfg (2 stores). Meaning UNKNOWN.";
        field {
            name = "word";
            desc = "32-bit word.";
            sw = rw;
            hw = r;
        } word[31:0];
    } W_504 @ 0x504;

    reg {
        name = "Word 0x550";
        desc = "Word 0x550. PROVEN: stored byte lanes 0123, cleared bit extents none seen, ORed constants 0xF, 0x4F, 0x4000000, written by h264e_drv_update_arith_metic_cfg, h264e_drv_update_lower_power_cfg (8 stores). Meaning UNKNOWN.";
        field {
            name = "word";
            desc = "32-bit word.";
            sw = rw;
            hw = r;
        } word[31:0];
    } W_550 @ 0x550;

    reg {
        name = "Word 0x554";
        desc = "Word 0x554. PROVEN: stored byte lanes 0123, cleared bit extents none seen, ORed constants none, written by h264e_drv_update_lower_power_cfg (1 stores). Meaning UNKNOWN.";
        field {
            name = "word";
            desc = "32-bit word.";
            sw = rw;
            hw = r;
        } word[31:0];
    } W_554 @ 0x554;

    reg {
        name = "Word 0x558";
        desc = "Word 0x558. PROVEN: stored byte lanes 0, cleared bit extents none seen, ORed constants none, written by h264e_drv_update_lower_power_cfg (1 stores). Meaning UNKNOWN.";
        field {
            name = "word";
            desc = "32-bit word.";
            sw = rw;
            hw = r;
        } word[31:0];
    } W_558 @ 0x558;

    reg {
        name = "Word 0x580";
        desc = "Word 0x580. PROVEN: stored byte lanes 0, cleared bit extents none seen, ORed constants none, written by h264e_drv_update_pattern_removal_cfg (1 stores). Meaning UNKNOWN.";
        field {
            name = "word";
            desc = "32-bit word.";
            sw = rw;
            hw = r;
        } word[31:0];
    } W_580 @ 0x580;

    reg {
        name = "Word 0x584";
        desc = "Word 0x584. PROVEN: stored byte lanes 0123, cleared bit extents none seen, ORed constants none, written by h264e_drv_update_pattern_removal_cfg (1 stores). Meaning UNKNOWN.";
        field {
            name = "word";
            desc = "32-bit word.";
            sw = rw;
            hw = r;
        } word[31:0];
    } W_584 @ 0x584;

    reg {
        name = "Word 0x588";
        desc = "Word 0x588. PROVEN: stored byte lanes 0123, cleared bit extents none seen, ORed constants none, written by h264e_drv_update_pattern_removal_cfg (1 stores). Meaning UNKNOWN.";
        field {
            name = "word";
            desc = "32-bit word.";
            sw = rw;
            hw = r;
        } word[31:0];
    } W_588 @ 0x588;

    reg {
        name = "Word 0x58C";
        desc = "Word 0x58C. PROVEN: stored byte lanes 0123, cleared bit extents none seen, ORed constants none, written by h264e_drv_update_pattern_removal_cfg (1 stores). Meaning UNKNOWN.";
        field {
            name = "word";
            desc = "32-bit word.";
            sw = rw;
            hw = r;
        } word[31:0];
    } W_58C @ 0x58C;

    reg {
        name = "Word 0x590";
        desc = "Word 0x590. PROVEN: stored byte lanes 0123, cleared bit extents none seen, ORed constants none, written by h264e_drv_update_pattern_removal_cfg (1 stores). Meaning UNKNOWN.";
        field {
            name = "word";
            desc = "32-bit word.";
            sw = rw;
            hw = r;
        } word[31:0];
    } W_590 @ 0x590;

    reg {
        name = "Word 0x594";
        desc = "Word 0x594. PROVEN: stored byte lanes 0123, cleared bit extents none seen, ORed constants none, written by h264e_drv_update_pattern_removal_cfg (1 stores). Meaning UNKNOWN.";
        field {
            name = "word";
            desc = "32-bit word.";
            sw = rw;
            hw = r;
        } word[31:0];
    } W_594 @ 0x594;

    reg {
        name = "Word 0x598";
        desc = "Word 0x598. PROVEN: stored byte lanes 0123, cleared bit extents none seen, ORed constants none, written by h264e_drv_update_pattern_removal_cfg (1 stores). Meaning UNKNOWN.";
        field {
            name = "word";
            desc = "32-bit word.";
            sw = rw;
            hw = r;
        } word[31:0];
    } W_598 @ 0x598;

    reg {
        name = "Word 0x59C";
        desc = "Word 0x59C. PROVEN: stored byte lanes 0123, cleared bit extents none seen, ORed constants none, written by h264e_drv_update_pattern_removal_cfg (1 stores). Meaning UNKNOWN.";
        field {
            name = "word";
            desc = "32-bit word.";
            sw = rw;
            hw = r;
        } word[31:0];
    } W_59C @ 0x59C;

    reg {
        name = "Word 0x5A0";
        desc = "Word 0x5A0. PROVEN: stored byte lanes 0123, cleared bit extents none seen, ORed constants none, written by h264e_drv_update_pattern_removal_cfg (1 stores). Meaning UNKNOWN.";
        field {
            name = "word";
            desc = "32-bit word.";
            sw = rw;
            hw = r;
        } word[31:0];
    } W_5A0 @ 0x5A0;

    reg {
        name = "Word 0x5A4";
        desc = "Word 0x5A4. PROVEN: stored byte lanes 0123, cleared bit extents none seen, ORed constants none, written by h264e_drv_update_pattern_removal_cfg (1 stores). Meaning UNKNOWN.";
        field {
            name = "word";
            desc = "32-bit word.";
            sw = rw;
            hw = r;
        } word[31:0];
    } W_5A4 @ 0x5A4;

    reg {
        name = "Word 0x5A8";
        desc = "Word 0x5A8. PROVEN: stored byte lanes 0123, cleared bit extents none seen, ORed constants none, written by h264e_drv_update_pattern_removal_cfg (1 stores). Meaning UNKNOWN.";
        field {
            name = "word";
            desc = "32-bit word.";
            sw = rw;
            hw = r;
        } word[31:0];
    } W_5A8 @ 0x5A8;

    reg {
        name = "Word 0x5AC";
        desc = "Word 0x5AC. PROVEN: stored byte lanes 0123, cleared bit extents none seen, ORed constants none, written by h264e_drv_update_pattern_removal_cfg (1 stores). Meaning UNKNOWN.";
        field {
            name = "word";
            desc = "32-bit word.";
            sw = rw;
            hw = r;
        } word[31:0];
    } W_5AC @ 0x5AC;

    reg {
        name = "Word 0x5B0";
        desc = "Word 0x5B0. PROVEN: stored byte lanes 0123, cleared bit extents none seen, ORed constants none, written by h264e_drv_update_pattern_removal_cfg (1 stores). Meaning UNKNOWN.";
        field {
            name = "word";
            desc = "32-bit word.";
            sw = rw;
            hw = r;
        } word[31:0];
    } W_5B0 @ 0x5B0;

    reg {
        name = "Word 0x5B4";
        desc = "Word 0x5B4. PROVEN: stored byte lanes 0123, cleared bit extents none seen, ORed constants none, written by h264e_drv_update_pattern_removal_cfg (1 stores). Meaning UNKNOWN.";
        field {
            name = "word";
            desc = "32-bit word.";
            sw = rw;
            hw = r;
        } word[31:0];
    } W_5B4 @ 0x5B4;

    reg {
        name = "Word 0x5B8";
        desc = "Word 0x5B8. PROVEN: stored byte lanes 0123, cleared bit extents none seen, ORed constants none, written by h264e_drv_update_pattern_removal_cfg (1 stores). Meaning UNKNOWN.";
        field {
            name = "word";
            desc = "32-bit word.";
            sw = rw;
            hw = r;
        } word[31:0];
    } W_5B8 @ 0x5B8;

    reg {
        name = "Word 0x5BC";
        desc = "Word 0x5BC. PROVEN: stored byte lanes 0123, cleared bit extents none seen, ORed constants none, written by h264e_drv_update_pattern_removal_cfg (1 stores). Meaning UNKNOWN.";
        field {
            name = "word";
            desc = "32-bit word.";
            sw = rw;
            hw = r;
        } word[31:0];
    } W_5BC @ 0x5BC;

    reg {
        name = "Word 0x5C0";
        desc = "Word 0x5C0. PROVEN: stored byte lanes 0123, cleared bit extents none seen, ORed constants none, written by h264e_drv_update_pattern_removal_cfg (1 stores). Meaning UNKNOWN.";
        field {
            name = "word";
            desc = "32-bit word.";
            sw = rw;
            hw = r;
        } word[31:0];
    } W_5C0 @ 0x5C0;

    reg {
        name = "Word 0x5C4";
        desc = "Word 0x5C4. PROVEN: stored byte lanes 0123, cleared bit extents none seen, ORed constants none, written by h264e_drv_update_pattern_removal_cfg (1 stores). Meaning UNKNOWN.";
        field {
            name = "word";
            desc = "32-bit word.";
            sw = rw;
            hw = r;
        } word[31:0];
    } W_5C4 @ 0x5C4;

    reg {
        name = "Word 0x5C8";
        desc = "Word 0x5C8. PROVEN: stored byte lanes 0123, cleared bit extents none seen, ORed constants none, written by h264e_drv_update_pattern_removal_cfg (1 stores). Meaning UNKNOWN.";
        field {
            name = "word";
            desc = "32-bit word.";
            sw = rw;
            hw = r;
        } word[31:0];
    } W_5C8 @ 0x5C8;

    reg {
        name = "Word 0x5CC";
        desc = "Word 0x5CC. PROVEN: stored byte lanes 0123, cleared bit extents none seen, ORed constants none, written by h264e_drv_update_pattern_removal_cfg (1 stores). Meaning UNKNOWN.";
        field {
            name = "word";
            desc = "32-bit word.";
            sw = rw;
            hw = r;
        } word[31:0];
    } W_5CC @ 0x5CC;

    reg {
        name = "Word 0x5D0";
        desc = "Word 0x5D0. PROVEN: stored byte lanes 0123, cleared bit extents none seen, ORed constants none, written by h264e_drv_update_pattern_removal_cfg (1 stores). Meaning UNKNOWN.";
        field {
            name = "word";
            desc = "32-bit word.";
            sw = rw;
            hw = r;
        } word[31:0];
    } W_5D0 @ 0x5D0;

    reg {
        name = "Word 0x5D4";
        desc = "Word 0x5D4. PROVEN: stored byte lanes 0123, cleared bit extents none seen, ORed constants none, written by h264e_drv_update_pattern_removal_cfg (1 stores). Meaning UNKNOWN.";
        field {
            name = "word";
            desc = "32-bit word.";
            sw = rw;
            hw = r;
        } word[31:0];
    } W_5D4 @ 0x5D4;

    reg {
        name = "Word 0x5D8";
        desc = "Word 0x5D8. PROVEN: stored byte lanes 0123, cleared bit extents none seen, ORed constants none, written by h264e_drv_update_pattern_removal_cfg (1 stores). Meaning UNKNOWN.";
        field {
            name = "word";
            desc = "32-bit word.";
            sw = rw;
            hw = r;
        } word[31:0];
    } W_5D8 @ 0x5D8;

    reg {
        name = "Word 0x5DC";
        desc = "Word 0x5DC. PROVEN: stored byte lanes 0123, cleared bit extents none seen, ORed constants none, written by h264e_drv_update_pattern_removal_cfg (1 stores). Meaning UNKNOWN.";
        field {
            name = "word";
            desc = "32-bit word.";
            sw = rw;
            hw = r;
        } word[31:0];
    } W_5DC @ 0x5DC;

    reg {
        name = "Word 0x604";
        desc = "Word 0x604. PROVEN: stored byte lanes 0, cleared bit extents none seen, ORed constants none, written by h264e_drv_update_lower_power_cfg (1 stores). Meaning UNKNOWN.";
        field {
            name = "word";
            desc = "32-bit word.";
            sw = rw;
            hw = r;
        } word[31:0];
    } W_604 @ 0x604;

    reg {
        name = "Word 0x60C";
        desc = "Word 0x60C. PROVEN: stored byte lanes 012, cleared bit extents none seen, ORed constants none, written by h264e_drv_update_lower_power_cfg (3 stores). Meaning UNKNOWN.";
        field {
            name = "word";
            desc = "32-bit word.";
            sw = rw;
            hw = r;
        } word[31:0];
    } W_60C @ 0x60C;

    reg {
        name = "Word 0x610";
        desc = "Word 0x610. PROVEN: stored byte lanes 013, cleared bit extents none seen, ORed constants 0x8, written by h264e_drv_update_lower_power_cfg (3 stores). Meaning UNKNOWN.";
        field {
            name = "word";
            desc = "32-bit word.";
            sw = rw;
            hw = r;
        } word[31:0];
    } W_610 @ 0x610;

    reg {
        name = "Word 0x614";
        desc = "Word 0x614. PROVEN: stored byte lanes 02, cleared bit extents none seen, ORed constants none, written by h264e_drv_update_lower_power_cfg (2 stores). Meaning UNKNOWN.";
        field {
            name = "word";
            desc = "32-bit word.";
            sw = rw;
            hw = r;
        } word[31:0];
    } W_614 @ 0x614;

    reg {
        name = "Word 0x618";
        desc = "Word 0x618. PROVEN: stored byte lanes 0123, cleared bit extents none seen, ORed constants none, written by h264e_drv_update_lower_power_cfg (1 stores). Meaning UNKNOWN.";
        field {
            name = "word";
            desc = "32-bit word.";
            sw = rw;
            hw = r;
        } word[31:0];
    } W_618 @ 0x618;

    reg {
        name = "Word 0x61C";
        desc = "Word 0x61C. PROVEN: stored byte lanes 01, cleared bit extents none seen, ORed constants none, written by h264e_drv_update_lower_power_cfg (2 stores). Meaning UNKNOWN.";
        field {
            name = "word";
            desc = "32-bit word.";
            sw = rw;
            hw = r;
        } word[31:0];
    } W_61C @ 0x61C;

    reg {
        name = "Word 0x620";
        desc = "Word 0x620. PROVEN: stored byte lanes 02, cleared bit extents none seen, ORed constants none, written by h264e_drv_update_lower_power_cfg (2 stores). Meaning UNKNOWN.";
        field {
            name = "word";
            desc = "32-bit word.";
            sw = rw;
            hw = r;
        } word[31:0];
    } W_620 @ 0x620;

    reg {
        name = "Word 0x624";
        desc = "Word 0x624. PROVEN: stored byte lanes 02, cleared bit extents none seen, ORed constants none, written by h264e_drv_update_lower_power_cfg (2 stores). Meaning UNKNOWN.";
        field {
            name = "word";
            desc = "32-bit word.";
            sw = rw;
            hw = r;
        } word[31:0];
    } W_624 @ 0x624;

    reg {
        name = "Word 0x62C";
        desc = "Word 0x62C. PROVEN: stored byte lanes 012, cleared bit extents none seen, ORed constants none, written by h264e_drv_update_lower_power_cfg (3 stores). Meaning UNKNOWN.";
        field {
            name = "word";
            desc = "32-bit word.";
            sw = rw;
            hw = r;
        } word[31:0];
    } W_62C @ 0x62C;

    reg {
        name = "Word 0x630";
        desc = "Word 0x630. PROVEN: stored byte lanes 0123, cleared bit extents none seen, ORed constants none, written by h264e_drv_update_lower_power_cfg (1 stores). Meaning UNKNOWN.";
        field {
            name = "word";
            desc = "32-bit word.";
            sw = rw;
            hw = r;
        } word[31:0];
    } W_630 @ 0x630;

    reg {
        name = "Word 0x634";
        desc = "Word 0x634. PROVEN: stored byte lanes 0123, cleared bit extents none seen, ORed constants none, written by h264e_drv_update_lower_power_cfg (1 stores). Meaning UNKNOWN.";
        field {
            name = "word";
            desc = "32-bit word.";
            sw = rw;
            hw = r;
        } word[31:0];
    } W_634 @ 0x634;

    reg {
        name = "Word 0x638";
        desc = "Word 0x638. PROVEN: stored byte lanes 0123, cleared bit extents none seen, ORed constants none, written by h264e_drv_update_lower_power_cfg (1 stores). Meaning UNKNOWN.";
        field {
            name = "word";
            desc = "32-bit word.";
            sw = rw;
            hw = r;
        } word[31:0];
    } W_638 @ 0x638;

    reg {
        name = "Word 0x63C";
        desc = "Word 0x63C. PROVEN: stored byte lanes 01, cleared bit extents none seen, ORed constants 0x4, 0x100, written by h264e_drv_update_lower_power_cfg (2 stores). Meaning UNKNOWN.";
        field {
            name = "word";
            desc = "32-bit word.";
            sw = rw;
            hw = r;
        } word[31:0];
    } W_63C @ 0x63C;

    reg {
        name = "Word 0x640";
        desc = "Word 0x640. PROVEN: stored byte lanes 2, cleared bit extents none seen, ORed constants none, written by h264e_drv_update_lower_power_cfg (1 stores). Meaning UNKNOWN.";
        field {
            name = "word";
            desc = "32-bit word.";
            sw = rw;
            hw = r;
        } word[31:0];
    } W_640 @ 0x640;

    reg {
        name = "Word 0x644";
        desc = "Word 0x644. PROVEN: stored byte lanes 02, cleared bit extents none seen, ORed constants none, written by h264e_drv_update_lower_power_cfg (3 stores). Meaning UNKNOWN.";
        field {
            name = "word";
            desc = "32-bit word.";
            sw = rw;
            hw = r;
        } word[31:0];
    } W_644 @ 0x644;

    reg {
        name = "Word 0x648";
        desc = "Word 0x648. PROVEN: stored byte lanes 0123, cleared bit extents none seen, ORed constants none, written by h264e_drv_update_lower_power_cfg (4 stores). Meaning UNKNOWN.";
        field {
            name = "word";
            desc = "32-bit word.";
            sw = rw;
            hw = r;
        } word[31:0];
    } W_648 @ 0x648;

    reg {
        name = "Word 0x64C";
        desc = "Word 0x64C. PROVEN: stored byte lanes 01, cleared bit extents none seen, ORed constants 0x5500, written by h264e_drv_update_lower_power_cfg (2 stores). Meaning UNKNOWN.";
        field {
            name = "word";
            desc = "32-bit word.";
            sw = rw;
            hw = r;
        } word[31:0];
    } W_64C @ 0x64C;

    reg {
        name = "Word 0x654";
        desc = "Word 0x654. PROVEN: stored byte lanes 012, cleared bit extents none seen, ORed constants none, written by h264e_drv_update_lower_power_cfg (3 stores). Meaning UNKNOWN.";
        field {
            name = "word";
            desc = "32-bit word.";
            sw = rw;
            hw = r;
        } word[31:0];
    } W_654 @ 0x654;

    reg {
        name = "Word 0x658";
        desc = "Word 0x658. PROVEN: stored byte lanes 02, cleared bit extents none seen, ORed constants none, written by h264e_drv_update_lower_power_cfg (2 stores). Meaning UNKNOWN.";
        field {
            name = "word";
            desc = "32-bit word.";
            sw = rw;
            hw = r;
        } word[31:0];
    } W_658 @ 0x658;

    reg {
        name = "Word 0x65C";
        desc = "Word 0x65C. PROVEN: stored byte lanes 02, cleared bit extents none seen, ORed constants none, written by h264e_drv_update_lower_power_cfg (2 stores). Meaning UNKNOWN.";
        field {
            name = "word";
            desc = "32-bit word.";
            sw = rw;
            hw = r;
        } word[31:0];
    } W_65C @ 0x65C;

    reg {
        name = "Word 0x680";
        desc = "Word 0x680. PROVEN: stored byte lanes 2, cleared bit extents none seen, ORed constants none, written by h264e_drv_update_osd_roi_config_param (2 stores). Meaning UNKNOWN.";
        field {
            name = "word";
            desc = "32-bit word.";
            sw = rw;
            hw = r;
        } word[31:0];
    } W_680 @ 0x680;

    reg {
        name = "Word 0x700";
        desc = "Word 0x700. PROVEN: stored byte lanes 0123, cleared bit extents none seen, ORed constants 0xD, written by h264e_drv_update_reg_config_config_param_unusual (1 stores). Meaning UNKNOWN.";
        field {
            name = "word";
            desc = "32-bit word.";
            sw = rw;
            hw = r;
        } word[31:0];
    } W_700 @ 0x700;

    reg {
        name = "Word 0x704";
        desc = "Word 0x704. PROVEN: stored byte lanes 0123, cleared bit extents none seen, ORed constants none, written by h264e_drv_update_reg_config_config_param_unusual (1 stores). Meaning UNKNOWN.";
        field {
            name = "word";
            desc = "32-bit word.";
            sw = rw;
            hw = r;
        } word[31:0];
    } W_704 @ 0x704;

    reg {
        name = "Word 0x708";
        desc = "Word 0x708. PROVEN: stored byte lanes 0123, cleared bit extents none seen, ORed constants none, written by h264e_drv_update_reg_config_config_param_unusual (1 stores). Meaning UNKNOWN.";
        field {
            name = "word";
            desc = "32-bit word.";
            sw = rw;
            hw = r;
        } word[31:0];
    } W_708 @ 0x708;

    reg {
        name = "Word 0x70C";
        desc = "Word 0x70C. PROVEN: stored byte lanes 0123, cleared bit extents none seen, ORed constants none, written by h264e_drv_update_reg_config_config_param_unusual (1 stores). Meaning UNKNOWN.";
        field {
            name = "word";
            desc = "32-bit word.";
            sw = rw;
            hw = r;
        } word[31:0];
    } W_70C @ 0x70C;

    reg {
        name = "Word 0x710";
        desc = "Word 0x710. PROVEN: stored byte lanes 0123, cleared bit extents none seen, ORed constants none, written by h264e_drv_update_reg_config_config_param_unusual (1 stores). Meaning UNKNOWN.";
        field {
            name = "word";
            desc = "32-bit word.";
            sw = rw;
            hw = r;
        } word[31:0];
    } W_710 @ 0x710;

    reg {
        name = "Word 0x714";
        desc = "Word 0x714. PROVEN: stored byte lanes 0123, cleared bit extents none seen, ORed constants none, written by h264e_drv_update_reg_config_config_param_unusual (1 stores). Meaning UNKNOWN.";
        field {
            name = "word";
            desc = "32-bit word.";
            sw = rw;
            hw = r;
        } word[31:0];
    } W_714 @ 0x714;

    reg {
        name = "Word 0x718";
        desc = "Word 0x718. PROVEN: stored byte lanes 0123, cleared bit extents none seen, ORed constants none, written by h264e_drv_update_reg_config_config_param_unusual (1 stores). Meaning UNKNOWN.";
        field {
            name = "word";
            desc = "32-bit word.";
            sw = rw;
            hw = r;
        } word[31:0];
    } W_718 @ 0x718;

    reg {
        name = "Word 0x71C";
        desc = "Word 0x71C. PROVEN: stored byte lanes 0123, cleared bit extents none seen, ORed constants none, written by h264e_drv_update_reg_config_config_param_unusual (1 stores). Meaning UNKNOWN.";
        field {
            name = "word";
            desc = "32-bit word.";
            sw = rw;
            hw = r;
        } word[31:0];
    } W_71C @ 0x71C;

    reg {
        name = "Word 0x720";
        desc = "Word 0x720. PROVEN: stored byte lanes 0123, cleared bit extents none seen, ORed constants none, written by h264e_drv_update_reg_config_config_param_unusual (1 stores). Meaning UNKNOWN.";
        field {
            name = "word";
            desc = "32-bit word.";
            sw = rw;
            hw = r;
        } word[31:0];
    } W_720 @ 0x720;

    reg {
        name = "Word 0x724";
        desc = "Word 0x724. PROVEN: stored byte lanes 01, cleared bit extents none seen, ORed constants 0x4, 0x8, 0x1000, written by h264e_drv_update_arith_metic_cfg, h264e_drv_update_reg_config_config_param_unusual (11 stores). Meaning UNKNOWN.";
        field {
            name = "word";
            desc = "32-bit word.";
            sw = rw;
            hw = r;
        } word[31:0];
    } W_724 @ 0x724;

    reg {
        name = "Word 0x728";
        desc = "Word 0x728. PROVEN: stored byte lanes 0123, cleared bit extents none seen, ORed constants none, written by h264e_drv_update_reg_config_config_param_unusual (1 stores). Meaning UNKNOWN.";
        field {
            name = "word";
            desc = "32-bit word.";
            sw = rw;
            hw = r;
        } word[31:0];
    } W_728 @ 0x728;

    reg {
        name = "Word 0x72C";
        desc = "Word 0x72C. PROVEN: stored byte lanes 0123, cleared bit extents none seen, ORed constants 0x1, written by h264e_drv_update_arith_metic_cfg, h264e_drv_update_reg_config_config_param_unusual (9 stores). Meaning UNKNOWN.";
        field {
            name = "word";
            desc = "32-bit word.";
            sw = rw;
            hw = r;
        } word[31:0];
    } W_72C @ 0x72C;

    reg {
        name = "Word 0x730";
        desc = "Word 0x730. PROVEN: stored byte lanes 0123, cleared bit extents none seen, ORed constants none, written by h264e_drv_update_reg_config_config_param_unusual (1 stores). Meaning UNKNOWN.";
        field {
            name = "word";
            desc = "32-bit word.";
            sw = rw;
            hw = r;
        } word[31:0];
    } W_730 @ 0x730;

    reg {
        name = "Word 0x734";
        desc = "Word 0x734. PROVEN: stored byte lanes 0123, cleared bit extents none seen, ORed constants none, written by h264e_drv_update_reg_config_config_param_unusual (1 stores). Meaning UNKNOWN.";
        field {
            name = "word";
            desc = "32-bit word.";
            sw = rw;
            hw = r;
        } word[31:0];
    } W_734 @ 0x734;

    reg {
        name = "Word 0x738";
        desc = "Word 0x738. PROVEN: stored byte lanes 0123, cleared bit extents none seen, ORed constants none, written by h264e_drv_update_reg_config_config_param_unusual (1 stores). Meaning UNKNOWN.";
        field {
            name = "word";
            desc = "32-bit word.";
            sw = rw;
            hw = r;
        } word[31:0];
    } W_738 @ 0x738;

    reg {
        name = "Word 0x73C";
        desc = "Word 0x73C. PROVEN: stored byte lanes 0123, cleared bit extents none seen, ORed constants none, written by h264e_drv_update_reg_config_config_param_unusual (1 stores). Meaning UNKNOWN.";
        field {
            name = "word";
            desc = "32-bit word.";
            sw = rw;
            hw = r;
        } word[31:0];
    } W_73C @ 0x73C;

    reg {
        name = "Word 0x740";
        desc = "Word 0x740. PROVEN: stored byte lanes 0123, cleared bit extents none seen, ORed constants none, written by h264e_drv_update_reg_config_config_param_unusual (1 stores). Meaning UNKNOWN.";
        field {
            name = "word";
            desc = "32-bit word.";
            sw = rw;
            hw = r;
        } word[31:0];
    } W_740 @ 0x740;

    reg {
        name = "Word 0x744";
        desc = "Word 0x744. PROVEN: stored byte lanes 0123, cleared bit extents none seen, ORed constants none, written by h264e_drv_update_reg_config_config_param_unusual (1 stores). Meaning UNKNOWN.";
        field {
            name = "word";
            desc = "32-bit word.";
            sw = rw;
            hw = r;
        } word[31:0];
    } W_744 @ 0x744;

    reg {
        name = "Word 0x748";
        desc = "Word 0x748. PROVEN: stored byte lanes 0123, cleared bit extents none seen, ORed constants none, written by h264e_drv_update_reg_config_config_param_unusual (1 stores). Meaning UNKNOWN.";
        field {
            name = "word";
            desc = "32-bit word.";
            sw = rw;
            hw = r;
        } word[31:0];
    } W_748 @ 0x748;

    reg {
        name = "Word 0x74C";
        desc = "Word 0x74C. PROVEN: stored byte lanes 0123, cleared bit extents none seen, ORed constants none, written by h264e_drv_update_reg_config_config_param_unusual (1 stores). Meaning UNKNOWN.";
        field {
            name = "word";
            desc = "32-bit word.";
            sw = rw;
            hw = r;
        } word[31:0];
    } W_74C @ 0x74C;

    reg {
        name = "Word 0x750";
        desc = "Word 0x750. PROVEN: stored byte lanes 0123, cleared bit extents none seen, ORed constants none, written by h264e_drv_update_reg_config_config_param_unusual (1 stores). Meaning UNKNOWN.";
        field {
            name = "word";
            desc = "32-bit word.";
            sw = rw;
            hw = r;
        } word[31:0];
    } W_750 @ 0x750;

    reg {
        name = "Word 0x754";
        desc = "Word 0x754. PROVEN: stored byte lanes 0123, cleared bit extents none seen, ORed constants none, written by h264e_drv_update_reg_config_config_param_unusual (1 stores). Meaning UNKNOWN.";
        field {
            name = "word";
            desc = "32-bit word.";
            sw = rw;
            hw = r;
        } word[31:0];
    } W_754 @ 0x754;

    reg {
        name = "Word 0x758";
        desc = "Word 0x758. PROVEN: stored byte lanes 0123, cleared bit extents none seen, ORed constants none, written by h264e_drv_update_reg_config_config_param_unusual (1 stores). Meaning UNKNOWN.";
        field {
            name = "word";
            desc = "32-bit word.";
            sw = rw;
            hw = r;
        } word[31:0];
    } W_758 @ 0x758;

    reg {
        name = "Word 0x75C";
        desc = "Word 0x75C. PROVEN: stored byte lanes 0123, cleared bit extents none seen, ORed constants none, written by h264e_drv_update_reg_config_config_param_unusual (1 stores). Meaning UNKNOWN.";
        field {
            name = "word";
            desc = "32-bit word.";
            sw = rw;
            hw = r;
        } word[31:0];
    } W_75C @ 0x75C;

    reg {
        name = "Word 0x764";
        desc = "Word 0x764. PROVEN: stored byte lanes 0123, cleared bit extents none seen, ORed constants none, written by h264e_drv_update_reg_config_config_param_unusual (1 stores). Meaning UNKNOWN.";
        field {
            name = "word";
            desc = "32-bit word.";
            sw = rw;
            hw = r;
        } word[31:0];
    } W_764 @ 0x764;

    reg {
        name = "Word 0x768";
        desc = "Word 0x768. PROVEN: stored byte lanes 0123, cleared bit extents none seen, ORed constants none, written by h264e_drv_update_reg_config_config_param_unusual (1 stores). Meaning UNKNOWN.";
        field {
            name = "word";
            desc = "32-bit word.";
            sw = rw;
            hw = r;
        } word[31:0];
    } W_768 @ 0x768;

    reg {
        name = "Word 0x76C";
        desc = "Word 0x76C. PROVEN: stored byte lanes 3, cleared bit extents none seen, ORed constants none, written by h264e_drv_update_reg_config_config_param_unusual (1 stores). Meaning UNKNOWN.";
        field {
            name = "word";
            desc = "32-bit word.";
            sw = rw;
            hw = r;
        } word[31:0];
    } W_76C @ 0x76C;

    reg {
        name = "Word 0x770";
        desc = "Word 0x770. PROVEN: stored byte lanes 0123, cleared bit extents none seen, ORed constants none, written by h264e_drv_update_reg_config_config_param_unusual (1 stores). Meaning UNKNOWN.";
        field {
            name = "word";
            desc = "32-bit word.";
            sw = rw;
            hw = r;
        } word[31:0];
    } W_770 @ 0x770;

    reg {
        name = "Word 0x774";
        desc = "Word 0x774. PROVEN: stored byte lanes 0123, cleared bit extents none seen, ORed constants none, written by h264e_drv_update_reg_config_config_param_unusual (1 stores). Meaning UNKNOWN.";
        field {
            name = "word";
            desc = "32-bit word.";
            sw = rw;
            hw = r;
        } word[31:0];
    } W_774 @ 0x774;

    reg {
        name = "Word 0x778";
        desc = "Word 0x778. PROVEN: stored byte lanes 0123, cleared bit extents none seen, ORed constants none, written by h264e_drv_update_reg_config_config_param_unusual (1 stores). Meaning UNKNOWN.";
        field {
            name = "word";
            desc = "32-bit word.";
            sw = rw;
            hw = r;
        } word[31:0];
    } W_778 @ 0x778;

    reg {
        name = "Word 0x77C";
        desc = "Word 0x77C. PROVEN: stored byte lanes 0123, cleared bit extents none seen, ORed constants none, written by h264e_drv_update_reg_config_config_param_unusual (1 stores). Meaning UNKNOWN.";
        field {
            name = "word";
            desc = "32-bit word.";
            sw = rw;
            hw = r;
        } word[31:0];
    } W_77C @ 0x77C;

    reg {
        name = "Word 0x780";
        desc = "Word 0x780. PROVEN: stored byte lanes 0123, cleared bit extents none seen, ORed constants 0x7F, 0x6400, written by h264e_drv_update_arith_metic_cfg, h264e_drv_update_pattern_removal_cfg (5 stores). Meaning UNKNOWN.";
        field {
            name = "word";
            desc = "32-bit word.";
            sw = rw;
            hw = r;
        } word[31:0];
    } W_780 @ 0x780;

    reg {
        name = "Word 0x784";
        desc = "Word 0x784. PROVEN: stored byte lanes 0123, cleared bit extents none seen, ORed constants none, written by h264e_drv_update_arith_metic_cfg (2 stores). Meaning UNKNOWN.";
        field {
            name = "word";
            desc = "32-bit word.";
            sw = rw;
            hw = r;
        } word[31:0];
    } W_784 @ 0x784;

    reg {
        name = "Word 0x788";
        desc = "Word 0x788. PROVEN: stored byte lanes 0123, cleared bit extents none seen, ORed constants 0x2, written by h264e_drv_update_arith_metic_cfg, h264e_drv_update_pattern_removal_cfg (3 stores). Meaning UNKNOWN.";
        field {
            name = "word";
            desc = "32-bit word.";
            sw = rw;
            hw = r;
        } word[31:0];
    } W_788 @ 0x788;

    reg {
        name = "Word 0x78C";
        desc = "Word 0x78C. PROVEN: stored byte lanes 012, cleared bit extents none seen, ORed constants none, written by h264e_drv_update_arith_metic_cfg, h264e_drv_update_pattern_removal_cfg (6 stores). Meaning UNKNOWN.";
        field {
            name = "word";
            desc = "32-bit word.";
            sw = rw;
            hw = r;
        } word[31:0];
    } W_78C @ 0x78C;

    reg {
        name = "Word 0x790";
        desc = "Word 0x790. PROVEN: stored byte lanes 012, cleared bit extents none seen, ORed constants 0x8, 0x300, 0x400000, written by h264e_drv_update_arith_metic_cfg (3 stores). Meaning UNKNOWN.";
        field {
            name = "word";
            desc = "32-bit word.";
            sw = rw;
            hw = r;
        } word[31:0];
    } W_790 @ 0x790;

    reg {
        name = "Word 0x794";
        desc = "Word 0x794. PROVEN: stored byte lanes 012, cleared bit extents none seen, ORed constants none, written by h264e_drv_update_arith_metic_cfg (3 stores). Meaning UNKNOWN.";
        field {
            name = "word";
            desc = "32-bit word.";
            sw = rw;
            hw = r;
        } word[31:0];
    } W_794 @ 0x794;

    reg {
        name = "Word 0x798";
        desc = "Word 0x798. PROVEN: stored byte lanes 0123, cleared bit extents none seen, ORed constants 0x3, written by h264e_drv_update_arith_metic_cfg (2 stores). Meaning UNKNOWN.";
        field {
            name = "word";
            desc = "32-bit word.";
            sw = rw;
            hw = r;
        } word[31:0];
    } W_798 @ 0x798;

    reg {
        name = "Word 0x7A0";
        desc = "Word 0x7A0. PROVEN: stored byte lanes 2, cleared bit extents none seen, ORed constants 0x10000, written by h264e_drv_update_arith_metic_cfg (1 stores). Meaning UNKNOWN.";
        field {
            name = "word";
            desc = "32-bit word.";
            sw = rw;
            hw = r;
        } word[31:0];
    } W_7A0 @ 0x7A0;

    reg {
        name = "Word 0x7A4";
        desc = "Word 0x7A4. PROVEN: stored byte lanes 012, cleared bit extents none seen, ORed constants 0x400, 0x3C0000, written by h264e_drv_update_arith_metic_cfg (3 stores). Meaning UNKNOWN.";
        field {
            name = "word";
            desc = "32-bit word.";
            sw = rw;
            hw = r;
        } word[31:0];
    } W_7A4 @ 0x7A4;

    reg {
        name = "Word 0x7A8";
        desc = "Word 0x7A8. PROVEN: stored byte lanes 012, cleared bit extents none seen, ORed constants none, written by h264e_drv_update_arith_metic_cfg (3 stores). Meaning UNKNOWN.";
        field {
            name = "word";
            desc = "32-bit word.";
            sw = rw;
            hw = r;
        } word[31:0];
    } W_7A8 @ 0x7A8;

    reg {
        name = "Word 0x7AC";
        desc = "Word 0x7AC. PROVEN: stored byte lanes 0123, cleared bit extents none seen, ORed constants 0x7B00, 0x7D000000, written by h264e_drv_update_arith_metic_cfg (4 stores). Meaning UNKNOWN.";
        field {
            name = "word";
            desc = "32-bit word.";
            sw = rw;
            hw = r;
        } word[31:0];
    } W_7AC @ 0x7AC;

    reg {
        name = "Word 0x7B0";
        desc = "Word 0x7B0. PROVEN: stored byte lanes 0123, cleared bit extents none seen, ORed constants 0x1, 0x200, 0x280000, 0x64000000, written by h264e_drv_update_arith_metic_cfg (4 stores). Meaning UNKNOWN.";
        field {
            name = "word";
            desc = "32-bit word.";
            sw = rw;
            hw = r;
        } word[31:0];
    } W_7B0 @ 0x7B0;

    reg {
        name = "Word 0x7B4";
        desc = "Word 0x7B4. PROVEN: stored byte lanes 0123, cleared bit extents none seen, ORed constants none, written by h264e_drv_update_arith_metic_cfg (2 stores). Meaning UNKNOWN.";
        field {
            name = "word";
            desc = "32-bit word.";
            sw = rw;
            hw = r;
        } word[31:0];
    } W_7B4 @ 0x7B4;

    reg {
        name = "Word 0x7B8";
        desc = "Word 0x7B8. PROVEN: stored byte lanes 0123, cleared bit extents none seen, ORed constants none, written by h264e_drv_update_arith_metic_cfg (3 stores). Meaning UNKNOWN.";
        field {
            name = "word";
            desc = "32-bit word.";
            sw = rw;
            hw = r;
        } word[31:0];
    } W_7B8 @ 0x7B8;

    reg {
        name = "Word 0x7BC";
        desc = "Word 0x7BC. PROVEN: stored byte lanes 0123, cleared bit extents none seen, ORed constants none, written by h264e_drv_update_arith_metic_cfg (3 stores). Meaning UNKNOWN.";
        field {
            name = "word";
            desc = "32-bit word.";
            sw = rw;
            hw = r;
        } word[31:0];
    } W_7BC @ 0x7BC;

    reg {
        name = "Word 0x7C0";
        desc = "Word 0x7C0. PROVEN: stored byte lanes 0123, cleared bit extents none seen, ORed constants 0x1, 0x30000, written by h264e_drv_update_arith_metic_cfg (4 stores). Meaning UNKNOWN.";
        field {
            name = "word";
            desc = "32-bit word.";
            sw = rw;
            hw = r;
        } word[31:0];
    } W_7C0 @ 0x7C0;

    reg {
        name = "Word 0x7C4";
        desc = "Word 0x7C4. PROVEN: stored byte lanes 01, cleared bit extents none seen, ORed constants 0x4, written by h264e_drv_update_arith_metic_cfg (2 stores). Meaning UNKNOWN.";
        field {
            name = "word";
            desc = "32-bit word.";
            sw = rw;
            hw = r;
        } word[31:0];
    } W_7C4 @ 0x7C4;

    reg {
        name = "Word 0x7C8";
        desc = "Word 0x7C8. PROVEN: stored byte lanes 0123, cleared bit extents none seen, ORed constants 0x64, written by h264e_drv_update_arith_metic_cfg (4 stores). Meaning UNKNOWN.";
        field {
            name = "word";
            desc = "32-bit word.";
            sw = rw;
            hw = r;
        } word[31:0];
    } W_7C8 @ 0x7C8;

    reg {
        name = "Word 0x7CC";
        desc = "Word 0x7CC. PROVEN: stored byte lanes 0123, cleared bit extents none seen, ORed constants 0x74, 0x780000, written by h264e_drv_update_arith_metic_cfg (4 stores). Meaning UNKNOWN.";
        field {
            name = "word";
            desc = "32-bit word.";
            sw = rw;
            hw = r;
        } word[31:0];
    } W_7CC @ 0x7CC;

    reg {
        name = "Word 0x7E0";
        desc = "Word 0x7E0. PROVEN: stored byte lanes 0123, cleared bit extents none seen, ORed constants none, written by h264e_drv_update_arith_metic_cfg (1 stores). Meaning UNKNOWN.";
        field {
            name = "word";
            desc = "32-bit word.";
            sw = rw;
            hw = r;
        } word[31:0];
    } W_7E0 @ 0x7E0;

    reg {
        name = "Word 0x7E4";
        desc = "Word 0x7E4. PROVEN: stored byte lanes 012, cleared bit extents none seen, ORed constants none, written by h264e_drv_update_arith_metic_cfg (3 stores). Meaning UNKNOWN.";
        field {
            name = "word";
            desc = "32-bit word.";
            sw = rw;
            hw = r;
        } word[31:0];
    } W_7E4 @ 0x7E4;

    reg {
        name = "Word 0x7E8";
        desc = "Word 0x7E8. PROVEN: stored byte lanes 0123, cleared bit extents none seen, ORed constants none, written by h264e_drv_update_arith_metic_cfg (1 stores). Meaning UNKNOWN.";
        field {
            name = "word";
            desc = "32-bit word.";
            sw = rw;
            hw = r;
        } word[31:0];
    } W_7E8 @ 0x7E8;

    reg {
        name = "Word 0x7EC";
        desc = "Word 0x7EC. PROVEN: stored byte lanes 0123, cleared bit extents none seen, ORed constants none, written by h264e_drv_update_arith_metic_cfg (1 stores). Meaning UNKNOWN.";
        field {
            name = "word";
            desc = "32-bit word.";
            sw = rw;
            hw = r;
        } word[31:0];
    } W_7EC @ 0x7EC;

    reg {
        name = "Word 0x7F0";
        desc = "Word 0x7F0. PROVEN: stored byte lanes 0123, cleared bit extents none seen, ORed constants none, written by h264e_drv_update_arith_metic_cfg (1 stores). Meaning UNKNOWN.";
        field {
            name = "word";
            desc = "32-bit word.";
            sw = rw;
            hw = r;
        } word[31:0];
    } W_7F0 @ 0x7F0;

};

`endif
`ifndef HISI_VEDU_H265_TABLE_V4_RDL
`define HISI_VEDU_H265_TABLE_V4_RDL

regfile eVEDU_H265_TABLE_V4 {
    name = "VEDU H.265 register image (DDR table)";
    desc = "Hi3516E V200 / V300 (hi3516ev200_h265e.ko, h265e_drv_update_*/cfg_*/init_* with the table pointer loaded from [ctx + 0xE80], 159 words). DDR register image like the H.264 one; loop-built face/pattern tables (0x4200+, 0x5000+) are only partly visible (UNKNOWN extent). Meaning of words UNKNOWN. NOT A REGISTER FILE unless stated: register image / table written by the traced functions. PROVENANCE LABELS: PROVEN = read from the instruction stream (offset, stored byte lanes, cleared bit extents, ORed constants); INFERRED = role deduced from names or sibling chips; UNKNOWN = everything else. Source: symbolic trace of the module disassembly (arm-trace). Branches are linearized, extents are lower bounds. Not hardware verified.";

    reg {
        name = "Word 0x0";
        desc = "Word 0x0. PROVEN: stored byte lanes 01, cleared bit extents none seen, ORed constants none, written by h265e_drv_update_row_intra_refresh (3 stores). Meaning UNKNOWN.";
        field {
            name = "word";
            desc = "32-bit word.";
            sw = rw;
            hw = r;
        } word[31:0];
    } W_000 @ 0x0;

    reg {
        name = "Word 0x54";
        desc = "Word 0x54. PROVEN: stored byte lanes 012, cleared bit extents none seen, ORed constants 0x100000, 0x130000, written by h265e_drv_update_base_reg, h265e_drv_update_row_intra_refresh (11 stores). Meaning UNKNOWN.";
        field {
            name = "word";
            desc = "32-bit word.";
            sw = rw;
            hw = r;
        } word[31:0];
    } W_054 @ 0x54;

    reg {
        name = "Word 0x100";
        desc = "Word 0x100. PROVEN: stored byte lanes 0123, cleared bit extents none seen, ORed constants none, written by h265e_drv_cfg_addr (1 stores). Meaning UNKNOWN.";
        field {
            name = "word";
            desc = "32-bit word.";
            sw = rw;
            hw = r;
        } word[31:0];
    } W_100 @ 0x100;

    reg {
        name = "Word 0x104";
        desc = "Word 0x104. PROVEN: stored byte lanes 0123, cleared bit extents none seen, ORed constants none, written by h265e_drv_cfg_addr (1 stores). Meaning UNKNOWN.";
        field {
            name = "word";
            desc = "32-bit word.";
            sw = rw;
            hw = r;
        } word[31:0];
    } W_104 @ 0x104;

    reg {
        name = "Word 0x108";
        desc = "Word 0x108. PROVEN: stored byte lanes 0123, cleared bit extents none seen, ORed constants none, written by h265e_drv_cfg_addr (1 stores). Meaning UNKNOWN.";
        field {
            name = "word";
            desc = "32-bit word.";
            sw = rw;
            hw = r;
        } word[31:0];
    } W_108 @ 0x108;

    reg {
        name = "Word 0x10C";
        desc = "Word 0x10C. PROVEN: stored byte lanes 0123, cleared bit extents none seen, ORed constants none, written by h265e_drv_cfg_addr (1 stores). Meaning UNKNOWN.";
        field {
            name = "word";
            desc = "32-bit word.";
            sw = rw;
            hw = r;
        } word[31:0];
    } W_10C @ 0x10C;

    reg {
        name = "Word 0x110";
        desc = "Word 0x110. PROVEN: stored byte lanes 0123, cleared bit extents none seen, ORed constants none, written by h265e_drv_cfg_addr (1 stores). Meaning UNKNOWN.";
        field {
            name = "word";
            desc = "32-bit word.";
            sw = rw;
            hw = r;
        } word[31:0];
    } W_110 @ 0x110;

    reg {
        name = "Word 0x12C";
        desc = "Word 0x12C. PROVEN: stored byte lanes 0123, cleared bit extents none seen, ORed constants none, written by h265e_drv_cfg_addr (1 stores). Meaning UNKNOWN.";
        field {
            name = "word";
            desc = "32-bit word.";
            sw = rw;
            hw = r;
        } word[31:0];
    } W_12C @ 0x12C;

    reg {
        name = "Word 0x130";
        desc = "Word 0x130. PROVEN: stored byte lanes 0123, cleared bit extents none seen, ORed constants none, written by h265e_drv_cfg_addr (1 stores). Meaning UNKNOWN.";
        field {
            name = "word";
            desc = "32-bit word.";
            sw = rw;
            hw = r;
        } word[31:0];
    } W_130 @ 0x130;

    reg {
        name = "Word 0x13C";
        desc = "Word 0x13C. PROVEN: stored byte lanes 0123, cleared bit extents none seen, ORed constants none, written by h265e_drv_cfg_addr (1 stores). Meaning UNKNOWN.";
        field {
            name = "word";
            desc = "32-bit word.";
            sw = rw;
            hw = r;
        } word[31:0];
    } W_13C @ 0x13C;

    reg {
        name = "Word 0x140";
        desc = "Word 0x140. PROVEN: stored byte lanes 0123, cleared bit extents none seen, ORed constants none, written by h265e_drv_cfg_addr (1 stores). Meaning UNKNOWN.";
        field {
            name = "word";
            desc = "32-bit word.";
            sw = rw;
            hw = r;
        } word[31:0];
    } W_140 @ 0x140;

    reg {
        name = "Word 0x144";
        desc = "Word 0x144. PROVEN: stored byte lanes 0123, cleared bit extents none seen, ORed constants none, written by h265e_drv_cfg_addr (1 stores). Meaning UNKNOWN.";
        field {
            name = "word";
            desc = "32-bit word.";
            sw = rw;
            hw = r;
        } word[31:0];
    } W_144 @ 0x144;

    reg {
        name = "Word 0x16C";
        desc = "Word 0x16C. PROVEN: stored byte lanes 0123, cleared bit extents none seen, ORed constants none, written by h265e_drv_cfg_addr (1 stores). Meaning UNKNOWN.";
        field {
            name = "word";
            desc = "32-bit word.";
            sw = rw;
            hw = r;
        } word[31:0];
    } W_16C @ 0x16C;

    reg {
        name = "Word 0x1EC";
        desc = "Word 0x1EC. PROVEN: stored byte lanes 0123, cleared bit extents none seen, ORed constants none, written by h265e_drv_cfg_addr (2 stores). Meaning UNKNOWN.";
        field {
            name = "word";
            desc = "32-bit word.";
            sw = rw;
            hw = r;
        } word[31:0];
    } W_1EC @ 0x1EC;

    reg {
        name = "Word 0x1F0";
        desc = "Word 0x1F0. PROVEN: stored byte lanes 0123, cleared bit extents none seen, ORed constants none, written by h265e_drv_cfg_addr (2 stores). Meaning UNKNOWN.";
        field {
            name = "word";
            desc = "32-bit word.";
            sw = rw;
            hw = r;
        } word[31:0];
    } W_1F0 @ 0x1F0;

    reg {
        name = "Word 0x200";
        desc = "Word 0x200. PROVEN: stored byte lanes 0, cleared bit extents none seen, ORed constants 0x1, written by h265e_drv_update_base_reg (2 stores). Meaning UNKNOWN.";
        field {
            name = "word";
            desc = "32-bit word.";
            sw = rw;
            hw = r;
        } word[31:0];
    } W_200 @ 0x200;

    reg {
        name = "Word 0x204";
        desc = "Word 0x204. PROVEN: stored byte lanes 0123, cleared bit extents none seen, ORed constants 0x2, written by h265e_drv_update_base_reg (5 stores). Meaning UNKNOWN.";
        field {
            name = "word";
            desc = "32-bit word.";
            sw = rw;
            hw = r;
        } word[31:0];
    } W_204 @ 0x204;

    reg {
        name = "Word 0x208";
        desc = "Word 0x208. PROVEN: stored byte lanes 0, cleared bit extents none seen, ORed constants none, written by h265e_drv_update_base_reg (1 stores). Meaning UNKNOWN.";
        field {
            name = "word";
            desc = "32-bit word.";
            sw = rw;
            hw = r;
        } word[31:0];
    } W_208 @ 0x208;

    reg {
        name = "Word 0x20C";
        desc = "Word 0x20C. PROVEN: stored byte lanes 0, cleared bit extents none seen, ORed constants none, written by h265e_drv_update_base_reg (1 stores). Meaning UNKNOWN.";
        field {
            name = "word";
            desc = "32-bit word.";
            sw = rw;
            hw = r;
        } word[31:0];
    } W_20C @ 0x20C;

    reg {
        name = "Word 0x210";
        desc = "Word 0x210. PROVEN: stored byte lanes 0123, cleared bit extents none seen, ORed constants none, written by h265e_drv_update_base_reg (1 stores). Meaning UNKNOWN.";
        field {
            name = "word";
            desc = "32-bit word.";
            sw = rw;
            hw = r;
        } word[31:0];
    } W_210 @ 0x210;

    reg {
        name = "Word 0x214";
        desc = "Word 0x214. PROVEN: stored byte lanes 0123, cleared bit extents none seen, ORed constants none, written by h265e_drv_update_base_reg (1 stores). Meaning UNKNOWN.";
        field {
            name = "word";
            desc = "32-bit word.";
            sw = rw;
            hw = r;
        } word[31:0];
    } W_214 @ 0x214;

    reg {
        name = "Word 0x218";
        desc = "Word 0x218. PROVEN: stored byte lanes 0123, cleared bit extents none seen, ORed constants none, written by h265e_drv_update_base_reg (1 stores). Meaning UNKNOWN.";
        field {
            name = "word";
            desc = "32-bit word.";
            sw = rw;
            hw = r;
        } word[31:0];
    } W_218 @ 0x218;

    reg {
        name = "Word 0x21C";
        desc = "Word 0x21C. PROVEN: stored byte lanes 0123, cleared bit extents none seen, ORed constants none, written by h265e_drv_update_base_reg (2 stores). Meaning UNKNOWN.";
        field {
            name = "word";
            desc = "32-bit word.";
            sw = rw;
            hw = r;
        } word[31:0];
    } W_21C @ 0x21C;

    reg {
        name = "Word 0x220";
        desc = "Word 0x220. PROVEN: stored byte lanes 0123, cleared bit extents none seen, ORed constants none, written by h265e_drv_update_base_reg (2 stores). Meaning UNKNOWN.";
        field {
            name = "word";
            desc = "32-bit word.";
            sw = rw;
            hw = r;
        } word[31:0];
    } W_220 @ 0x220;

    reg {
        name = "Word 0x224";
        desc = "Word 0x224. PROVEN: stored byte lanes 0123, cleared bit extents none seen, ORed constants none, written by h265e_drv_update_base_reg (2 stores). Meaning UNKNOWN.";
        field {
            name = "word";
            desc = "32-bit word.";
            sw = rw;
            hw = r;
        } word[31:0];
    } W_224 @ 0x224;

    reg {
        name = "Word 0x228";
        desc = "Word 0x228. PROVEN: stored byte lanes 1, cleared bit extents none seen, ORed constants none, written by h265e_drv_update_base_reg (1 stores). Meaning UNKNOWN.";
        field {
            name = "word";
            desc = "32-bit word.";
            sw = rw;
            hw = r;
        } word[31:0];
    } W_228 @ 0x228;

    reg {
        name = "Word 0x234";
        desc = "Word 0x234. PROVEN: stored byte lanes 01, cleared bit extents none seen, ORed constants none, written by h265e_drv_update_base_reg (3 stores). Meaning UNKNOWN.";
        field {
            name = "word";
            desc = "32-bit word.";
            sw = rw;
            hw = r;
        } word[31:0];
    } W_234 @ 0x234;

    reg {
        name = "Word 0x238";
        desc = "Word 0x238. PROVEN: stored byte lanes 0, cleared bit extents none seen, ORed constants none, written by h265e_drv_update_base_reg (2 stores). Meaning UNKNOWN.";
        field {
            name = "word";
            desc = "32-bit word.";
            sw = rw;
            hw = r;
        } word[31:0];
    } W_238 @ 0x238;

    reg {
        name = "Word 0x240";
        desc = "Word 0x240. PROVEN: stored byte lanes 0123, cleared bit extents none seen, ORed constants 0x1, 0x20, 0x4000, written by h265e_drv_update_base_reg (8 stores). Meaning UNKNOWN.";
        field {
            name = "word";
            desc = "32-bit word.";
            sw = rw;
            hw = r;
        } word[31:0];
    } W_240 @ 0x240;

    reg {
        name = "Word 0x244";
        desc = "Word 0x244. PROVEN: stored byte lanes 0123, cleared bit extents none seen, ORed constants none, written by h265e_drv_update_base_reg (1 stores). Meaning UNKNOWN.";
        field {
            name = "word";
            desc = "32-bit word.";
            sw = rw;
            hw = r;
        } word[31:0];
    } W_244 @ 0x244;

    reg {
        name = "Word 0x250";
        desc = "Word 0x250. PROVEN: stored byte lanes 2, cleared bit extents none seen, ORed constants 0x10000, written by h265e_drv_update_row_intra_refresh (4 stores). Meaning UNKNOWN.";
        field {
            name = "word";
            desc = "32-bit word.";
            sw = rw;
            hw = r;
        } word[31:0];
    } W_250 @ 0x250;

    reg {
        name = "Word 0x254";
        desc = "Word 0x254. PROVEN: stored byte lanes 0, cleared bit extents none seen, ORed constants 0x1, written by h265e_drv_update_row_intra_refresh (2 stores). Meaning UNKNOWN.";
        field {
            name = "word";
            desc = "32-bit word.";
            sw = rw;
            hw = r;
        } word[31:0];
    } W_254 @ 0x254;

    reg {
        name = "Word 0x27C";
        desc = "Word 0x27C. PROVEN: stored byte lanes 0, cleared bit extents none seen, ORed constants none, written by h265e_drv_update_base_reg (1 stores). Meaning UNKNOWN.";
        field {
            name = "word";
            desc = "32-bit word.";
            sw = rw;
            hw = r;
        } word[31:0];
    } W_27C @ 0x27C;

    reg {
        name = "Word 0x400";
        desc = "Word 0x400. PROVEN: stored byte lanes 01, cleared bit extents none seen, ORed constants none, written by h265e_drv_update_common_reg (2 stores). Meaning UNKNOWN.";
        field {
            name = "word";
            desc = "32-bit word.";
            sw = rw;
            hw = r;
        } word[31:0];
    } W_400 @ 0x400;

    reg {
        name = "Word 0x404";
        desc = "Word 0x404. PROVEN: stored byte lanes 0, cleared bit extents none seen, ORed constants none, written by h265e_drv_update_common_reg (1 stores). Meaning UNKNOWN.";
        field {
            name = "word";
            desc = "32-bit word.";
            sw = rw;
            hw = r;
        } word[31:0];
    } W_404 @ 0x404;

    reg {
        name = "Word 0x40C";
        desc = "Word 0x40C. PROVEN: stored byte lanes 0123, cleared bit extents none seen, ORed constants none, written by h265e_drv_update_common_reg (1 stores). Meaning UNKNOWN.";
        field {
            name = "word";
            desc = "32-bit word.";
            sw = rw;
            hw = r;
        } word[31:0];
    } W_40C @ 0x40C;

    reg {
        name = "Word 0x410";
        desc = "Word 0x410. PROVEN: stored byte lanes 0123, cleared bit extents none seen, ORed constants none, written by h265e_drv_update_common_reg (1 stores). Meaning UNKNOWN.";
        field {
            name = "word";
            desc = "32-bit word.";
            sw = rw;
            hw = r;
        } word[31:0];
    } W_410 @ 0x410;

    reg {
        name = "Word 0x414";
        desc = "Word 0x414. PROVEN: stored byte lanes 0123, cleared bit extents none seen, ORed constants none, written by h265e_drv_update_common_reg (1 stores). Meaning UNKNOWN.";
        field {
            name = "word";
            desc = "32-bit word.";
            sw = rw;
            hw = r;
        } word[31:0];
    } W_414 @ 0x414;

    reg {
        name = "Word 0x418";
        desc = "Word 0x418. PROVEN: stored byte lanes 0123, cleared bit extents none seen, ORed constants none, written by h265e_drv_update_common_reg (1 stores). Meaning UNKNOWN.";
        field {
            name = "word";
            desc = "32-bit word.";
            sw = rw;
            hw = r;
        } word[31:0];
    } W_418 @ 0x418;

    reg {
        name = "Word 0x41C";
        desc = "Word 0x41C. PROVEN: stored byte lanes 0123, cleared bit extents none seen, ORed constants none, written by h265e_drv_update_common_reg (1 stores). Meaning UNKNOWN.";
        field {
            name = "word";
            desc = "32-bit word.";
            sw = rw;
            hw = r;
        } word[31:0];
    } W_41C @ 0x41C;

    reg {
        name = "Word 0x420";
        desc = "Word 0x420. PROVEN: stored byte lanes 0123, cleared bit extents none seen, ORed constants none, written by h265e_drv_update_common_reg (1 stores). Meaning UNKNOWN.";
        field {
            name = "word";
            desc = "32-bit word.";
            sw = rw;
            hw = r;
        } word[31:0];
    } W_420 @ 0x420;

    reg {
        name = "Word 0x424";
        desc = "Word 0x424. PROVEN: stored byte lanes 0123, cleared bit extents none seen, ORed constants none, written by h265e_drv_update_common_reg (1 stores). Meaning UNKNOWN.";
        field {
            name = "word";
            desc = "32-bit word.";
            sw = rw;
            hw = r;
        } word[31:0];
    } W_424 @ 0x424;

    reg {
        name = "Word 0x428";
        desc = "Word 0x428. PROVEN: stored byte lanes 0123, cleared bit extents none seen, ORed constants none, written by h265e_drv_update_common_reg (1 stores). Meaning UNKNOWN.";
        field {
            name = "word";
            desc = "32-bit word.";
            sw = rw;
            hw = r;
        } word[31:0];
    } W_428 @ 0x428;

    reg {
        name = "Word 0x42C";
        desc = "Word 0x42C. PROVEN: stored byte lanes 0, cleared bit extents none seen, ORed constants none, written by h265e_drv_update_common_reg (1 stores). Meaning UNKNOWN.";
        field {
            name = "word";
            desc = "32-bit word.";
            sw = rw;
            hw = r;
        } word[31:0];
    } W_42C @ 0x42C;

    reg {
        name = "Word 0x434";
        desc = "Word 0x434. PROVEN: stored byte lanes 0123, cleared bit extents none seen, ORed constants none, written by h265e_drv_update_common_reg (1 stores). Meaning UNKNOWN.";
        field {
            name = "word";
            desc = "32-bit word.";
            sw = rw;
            hw = r;
        } word[31:0];
    } W_434 @ 0x434;

    reg {
        name = "Word 0x438";
        desc = "Word 0x438. PROVEN: stored byte lanes 0123, cleared bit extents none seen, ORed constants none, written by h265e_drv_update_common_reg (1 stores). Meaning UNKNOWN.";
        field {
            name = "word";
            desc = "32-bit word.";
            sw = rw;
            hw = r;
        } word[31:0];
    } W_438 @ 0x438;

    reg {
        name = "Word 0x43C";
        desc = "Word 0x43C. PROVEN: stored byte lanes 0123, cleared bit extents none seen, ORed constants none, written by h265e_drv_update_common_reg (1 stores). Meaning UNKNOWN.";
        field {
            name = "word";
            desc = "32-bit word.";
            sw = rw;
            hw = r;
        } word[31:0];
    } W_43C @ 0x43C;

    reg {
        name = "Word 0x440";
        desc = "Word 0x440. PROVEN: stored byte lanes 0123, cleared bit extents none seen, ORed constants none, written by h265e_drv_update_common_reg (1 stores). Meaning UNKNOWN.";
        field {
            name = "word";
            desc = "32-bit word.";
            sw = rw;
            hw = r;
        } word[31:0];
    } W_440 @ 0x440;

    reg {
        name = "Word 0x444";
        desc = "Word 0x444. PROVEN: stored byte lanes 0123, cleared bit extents none seen, ORed constants none, written by h265e_drv_update_common_reg (1 stores). Meaning UNKNOWN.";
        field {
            name = "word";
            desc = "32-bit word.";
            sw = rw;
            hw = r;
        } word[31:0];
    } W_444 @ 0x444;

    reg {
        name = "Word 0x448";
        desc = "Word 0x448. PROVEN: stored byte lanes 0123, cleared bit extents none seen, ORed constants none, written by h265e_drv_update_common_reg (1 stores). Meaning UNKNOWN.";
        field {
            name = "word";
            desc = "32-bit word.";
            sw = rw;
            hw = r;
        } word[31:0];
    } W_448 @ 0x448;

    reg {
        name = "Word 0x44C";
        desc = "Word 0x44C. PROVEN: stored byte lanes 0123, cleared bit extents none seen, ORed constants none, written by h265e_drv_update_common_reg (1 stores). Meaning UNKNOWN.";
        field {
            name = "word";
            desc = "32-bit word.";
            sw = rw;
            hw = r;
        } word[31:0];
    } W_44C @ 0x44C;

    reg {
        name = "Word 0x450";
        desc = "Word 0x450. PROVEN: stored byte lanes 0123, cleared bit extents none seen, ORed constants none, written by h265e_drv_update_common_reg (1 stores). Meaning UNKNOWN.";
        field {
            name = "word";
            desc = "32-bit word.";
            sw = rw;
            hw = r;
        } word[31:0];
    } W_450 @ 0x450;

    reg {
        name = "Word 0x4A0";
        desc = "Word 0x4A0. PROVEN: stored byte lanes 0123, cleared bit extents none seen, ORed constants none, written by h265e_drv_update_common_reg (1 stores). Meaning UNKNOWN.";
        field {
            name = "word";
            desc = "32-bit word.";
            sw = rw;
            hw = r;
        } word[31:0];
    } W_4A0 @ 0x4A0;

    reg {
        name = "Word 0x4A4";
        desc = "Word 0x4A4. PROVEN: stored byte lanes 0123, cleared bit extents none seen, ORed constants none, written by h265e_drv_update_common_reg (1 stores). Meaning UNKNOWN.";
        field {
            name = "word";
            desc = "32-bit word.";
            sw = rw;
            hw = r;
        } word[31:0];
    } W_4A4 @ 0x4A4;

    reg {
        name = "Word 0x4A8";
        desc = "Word 0x4A8. PROVEN: stored byte lanes 0123, cleared bit extents none seen, ORed constants none, written by h265e_drv_update_common_reg (1 stores). Meaning UNKNOWN.";
        field {
            name = "word";
            desc = "32-bit word.";
            sw = rw;
            hw = r;
        } word[31:0];
    } W_4A8 @ 0x4A8;

    reg {
        name = "Word 0x4AC";
        desc = "Word 0x4AC. PROVEN: stored byte lanes 0123, cleared bit extents none seen, ORed constants none, written by h265e_drv_update_common_reg (1 stores). Meaning UNKNOWN.";
        field {
            name = "word";
            desc = "32-bit word.";
            sw = rw;
            hw = r;
        } word[31:0];
    } W_4AC @ 0x4AC;

    reg {
        name = "Word 0x4B0";
        desc = "Word 0x4B0. PROVEN: stored byte lanes 0123, cleared bit extents none seen, ORed constants none, written by h265e_drv_update_common_reg (1 stores). Meaning UNKNOWN.";
        field {
            name = "word";
            desc = "32-bit word.";
            sw = rw;
            hw = r;
        } word[31:0];
    } W_4B0 @ 0x4B0;

    reg {
        name = "Word 0x504";
        desc = "Word 0x504. PROVEN: stored byte lanes 0, cleared bit extents none seen, ORed constants 0x10, written by h265e_drv_update_base_reg (1 stores). Meaning UNKNOWN.";
        field {
            name = "word";
            desc = "32-bit word.";
            sw = rw;
            hw = r;
        } word[31:0];
    } W_504 @ 0x504;

    reg {
        name = "Word 0x514";
        desc = "Word 0x514. PROVEN: stored byte lanes 0, cleared bit extents none seen, ORed constants none, written by h265e_drv_update_arith_cfg (1 stores). Meaning UNKNOWN.";
        field {
            name = "word";
            desc = "32-bit word.";
            sw = rw;
            hw = r;
        } word[31:0];
    } W_514 @ 0x514;

    reg {
        name = "Word 0x550";
        desc = "Word 0x550. PROVEN: stored byte lanes 03, cleared bit extents none seen, ORed constants none, written by h265e_drv_update_arith_cfg (6 stores). Meaning UNKNOWN.";
        field {
            name = "word";
            desc = "32-bit word.";
            sw = rw;
            hw = r;
        } word[31:0];
    } W_550 @ 0x550;

    reg {
        name = "Word 0x580";
        desc = "Word 0x580. PROVEN: stored byte lanes 0, cleared bit extents none seen, ORed constants none, written by h265e_drv_update_arith_cfg (5 stores). Meaning UNKNOWN.";
        field {
            name = "word";
            desc = "32-bit word.";
            sw = rw;
            hw = r;
        } word[31:0];
    } W_580 @ 0x580;

    reg {
        name = "Word 0x584";
        desc = "Word 0x584. PROVEN: stored byte lanes 0123, cleared bit extents none seen, ORed constants none, written by h265e_drv_update_arith_cfg (1 stores). Meaning UNKNOWN.";
        field {
            name = "word";
            desc = "32-bit word.";
            sw = rw;
            hw = r;
        } word[31:0];
    } W_584 @ 0x584;

    reg {
        name = "Word 0x588";
        desc = "Word 0x588. PROVEN: stored byte lanes 0123, cleared bit extents none seen, ORed constants none, written by h265e_drv_update_arith_cfg (1 stores). Meaning UNKNOWN.";
        field {
            name = "word";
            desc = "32-bit word.";
            sw = rw;
            hw = r;
        } word[31:0];
    } W_588 @ 0x588;

    reg {
        name = "Word 0x58C";
        desc = "Word 0x58C. PROVEN: stored byte lanes 0123, cleared bit extents none seen, ORed constants none, written by h265e_drv_update_arith_cfg (1 stores). Meaning UNKNOWN.";
        field {
            name = "word";
            desc = "32-bit word.";
            sw = rw;
            hw = r;
        } word[31:0];
    } W_58C @ 0x58C;

    reg {
        name = "Word 0x590";
        desc = "Word 0x590. PROVEN: stored byte lanes 0123, cleared bit extents none seen, ORed constants none, written by h265e_drv_update_arith_cfg (1 stores). Meaning UNKNOWN.";
        field {
            name = "word";
            desc = "32-bit word.";
            sw = rw;
            hw = r;
        } word[31:0];
    } W_590 @ 0x590;

    reg {
        name = "Word 0x594";
        desc = "Word 0x594. PROVEN: stored byte lanes 0123, cleared bit extents none seen, ORed constants none, written by h265e_drv_update_arith_cfg (1 stores). Meaning UNKNOWN.";
        field {
            name = "word";
            desc = "32-bit word.";
            sw = rw;
            hw = r;
        } word[31:0];
    } W_594 @ 0x594;

    reg {
        name = "Word 0x598";
        desc = "Word 0x598. PROVEN: stored byte lanes 0123, cleared bit extents none seen, ORed constants none, written by h265e_drv_update_arith_cfg (1 stores). Meaning UNKNOWN.";
        field {
            name = "word";
            desc = "32-bit word.";
            sw = rw;
            hw = r;
        } word[31:0];
    } W_598 @ 0x598;

    reg {
        name = "Word 0x59C";
        desc = "Word 0x59C. PROVEN: stored byte lanes 0123, cleared bit extents none seen, ORed constants none, written by h265e_drv_update_arith_cfg (1 stores). Meaning UNKNOWN.";
        field {
            name = "word";
            desc = "32-bit word.";
            sw = rw;
            hw = r;
        } word[31:0];
    } W_59C @ 0x59C;

    reg {
        name = "Word 0x5A0";
        desc = "Word 0x5A0. PROVEN: stored byte lanes 0123, cleared bit extents none seen, ORed constants none, written by h265e_drv_update_arith_cfg (1 stores). Meaning UNKNOWN.";
        field {
            name = "word";
            desc = "32-bit word.";
            sw = rw;
            hw = r;
        } word[31:0];
    } W_5A0 @ 0x5A0;

    reg {
        name = "Word 0x5A4";
        desc = "Word 0x5A4. PROVEN: stored byte lanes 0123, cleared bit extents none seen, ORed constants none, written by h265e_drv_update_arith_cfg (1 stores). Meaning UNKNOWN.";
        field {
            name = "word";
            desc = "32-bit word.";
            sw = rw;
            hw = r;
        } word[31:0];
    } W_5A4 @ 0x5A4;

    reg {
        name = "Word 0x5A8";
        desc = "Word 0x5A8. PROVEN: stored byte lanes 0123, cleared bit extents none seen, ORed constants none, written by h265e_drv_update_arith_cfg (1 stores). Meaning UNKNOWN.";
        field {
            name = "word";
            desc = "32-bit word.";
            sw = rw;
            hw = r;
        } word[31:0];
    } W_5A8 @ 0x5A8;

    reg {
        name = "Word 0x5AC";
        desc = "Word 0x5AC. PROVEN: stored byte lanes 0123, cleared bit extents none seen, ORed constants none, written by h265e_drv_update_arith_cfg (1 stores). Meaning UNKNOWN.";
        field {
            name = "word";
            desc = "32-bit word.";
            sw = rw;
            hw = r;
        } word[31:0];
    } W_5AC @ 0x5AC;

    reg {
        name = "Word 0x5B0";
        desc = "Word 0x5B0. PROVEN: stored byte lanes 0123, cleared bit extents none seen, ORed constants none, written by h265e_drv_update_arith_cfg (1 stores). Meaning UNKNOWN.";
        field {
            name = "word";
            desc = "32-bit word.";
            sw = rw;
            hw = r;
        } word[31:0];
    } W_5B0 @ 0x5B0;

    reg {
        name = "Word 0x5B4";
        desc = "Word 0x5B4. PROVEN: stored byte lanes 0123, cleared bit extents none seen, ORed constants none, written by h265e_drv_update_arith_cfg (1 stores). Meaning UNKNOWN.";
        field {
            name = "word";
            desc = "32-bit word.";
            sw = rw;
            hw = r;
        } word[31:0];
    } W_5B4 @ 0x5B4;

    reg {
        name = "Word 0x5B8";
        desc = "Word 0x5B8. PROVEN: stored byte lanes 0123, cleared bit extents none seen, ORed constants none, written by h265e_drv_update_arith_cfg (1 stores). Meaning UNKNOWN.";
        field {
            name = "word";
            desc = "32-bit word.";
            sw = rw;
            hw = r;
        } word[31:0];
    } W_5B8 @ 0x5B8;

    reg {
        name = "Word 0x5BC";
        desc = "Word 0x5BC. PROVEN: stored byte lanes 0123, cleared bit extents none seen, ORed constants none, written by h265e_drv_update_arith_cfg (1 stores). Meaning UNKNOWN.";
        field {
            name = "word";
            desc = "32-bit word.";
            sw = rw;
            hw = r;
        } word[31:0];
    } W_5BC @ 0x5BC;

    reg {
        name = "Word 0x5C0";
        desc = "Word 0x5C0. PROVEN: stored byte lanes 0123, cleared bit extents none seen, ORed constants none, written by h265e_drv_update_arith_cfg (1 stores). Meaning UNKNOWN.";
        field {
            name = "word";
            desc = "32-bit word.";
            sw = rw;
            hw = r;
        } word[31:0];
    } W_5C0 @ 0x5C0;

    reg {
        name = "Word 0x5C4";
        desc = "Word 0x5C4. PROVEN: stored byte lanes 0123, cleared bit extents none seen, ORed constants none, written by h265e_drv_update_arith_cfg (1 stores). Meaning UNKNOWN.";
        field {
            name = "word";
            desc = "32-bit word.";
            sw = rw;
            hw = r;
        } word[31:0];
    } W_5C4 @ 0x5C4;

    reg {
        name = "Word 0x5C8";
        desc = "Word 0x5C8. PROVEN: stored byte lanes 0123, cleared bit extents none seen, ORed constants none, written by h265e_drv_update_arith_cfg (1 stores). Meaning UNKNOWN.";
        field {
            name = "word";
            desc = "32-bit word.";
            sw = rw;
            hw = r;
        } word[31:0];
    } W_5C8 @ 0x5C8;

    reg {
        name = "Word 0x5CC";
        desc = "Word 0x5CC. PROVEN: stored byte lanes 0123, cleared bit extents none seen, ORed constants none, written by h265e_drv_update_arith_cfg (1 stores). Meaning UNKNOWN.";
        field {
            name = "word";
            desc = "32-bit word.";
            sw = rw;
            hw = r;
        } word[31:0];
    } W_5CC @ 0x5CC;

    reg {
        name = "Word 0x5D0";
        desc = "Word 0x5D0. PROVEN: stored byte lanes 0123, cleared bit extents none seen, ORed constants none, written by h265e_drv_update_arith_cfg (1 stores). Meaning UNKNOWN.";
        field {
            name = "word";
            desc = "32-bit word.";
            sw = rw;
            hw = r;
        } word[31:0];
    } W_5D0 @ 0x5D0;

    reg {
        name = "Word 0x5D4";
        desc = "Word 0x5D4. PROVEN: stored byte lanes 0123, cleared bit extents none seen, ORed constants none, written by h265e_drv_update_arith_cfg (1 stores). Meaning UNKNOWN.";
        field {
            name = "word";
            desc = "32-bit word.";
            sw = rw;
            hw = r;
        } word[31:0];
    } W_5D4 @ 0x5D4;

    reg {
        name = "Word 0x60C";
        desc = "Word 0x60C. PROVEN: stored byte lanes 012, cleared bit extents none seen, ORed constants 0x100, written by h265e_drv_update_arith_cfg (4 stores). Meaning UNKNOWN.";
        field {
            name = "word";
            desc = "32-bit word.";
            sw = rw;
            hw = r;
        } word[31:0];
    } W_60C @ 0x60C;

    reg {
        name = "Word 0x610";
        desc = "Word 0x610. PROVEN: stored byte lanes 0123, cleared bit extents none seen, ORed constants none, written by h265e_drv_update_arith_cfg (1 stores). Meaning UNKNOWN.";
        field {
            name = "word";
            desc = "32-bit word.";
            sw = rw;
            hw = r;
        } word[31:0];
    } W_610 @ 0x610;

    reg {
        name = "Word 0x614";
        desc = "Word 0x614. PROVEN: stored byte lanes 02, cleared bit extents none seen, ORed constants none, written by h265e_drv_update_arith_cfg (2 stores). Meaning UNKNOWN.";
        field {
            name = "word";
            desc = "32-bit word.";
            sw = rw;
            hw = r;
        } word[31:0];
    } W_614 @ 0x614;

    reg {
        name = "Word 0x618";
        desc = "Word 0x618. PROVEN: stored byte lanes 0123, cleared bit extents none seen, ORed constants none, written by h265e_drv_update_arith_cfg (1 stores). Meaning UNKNOWN.";
        field {
            name = "word";
            desc = "32-bit word.";
            sw = rw;
            hw = r;
        } word[31:0];
    } W_618 @ 0x618;

    reg {
        name = "Word 0x680";
        desc = "Word 0x680. PROVEN: stored byte lanes 2, cleared bit extents none seen, ORed constants none, written by h265e_drv_update_osd_roi_cfg_param (2 stores). Meaning UNKNOWN.";
        field {
            name = "word";
            desc = "32-bit word.";
            sw = rw;
            hw = r;
        } word[31:0];
    } W_680 @ 0x680;

    reg {
        name = "Word 0x700";
        desc = "Word 0x700. PROVEN: stored byte lanes 0123, cleared bit extents none seen, ORed constants 0xD, written by h265e_drv_update_arith_cfg (1 stores). Meaning UNKNOWN.";
        field {
            name = "word";
            desc = "32-bit word.";
            sw = rw;
            hw = r;
        } word[31:0];
    } W_700 @ 0x700;

    reg {
        name = "Word 0x704";
        desc = "Word 0x704. PROVEN: stored byte lanes 0123, cleared bit extents none seen, ORed constants none, written by h265e_drv_update_arith_cfg (1 stores). Meaning UNKNOWN.";
        field {
            name = "word";
            desc = "32-bit word.";
            sw = rw;
            hw = r;
        } word[31:0];
    } W_704 @ 0x704;

    reg {
        name = "Word 0x708";
        desc = "Word 0x708. PROVEN: stored byte lanes 0123, cleared bit extents none seen, ORed constants none, written by h265e_drv_update_arith_cfg (1 stores). Meaning UNKNOWN.";
        field {
            name = "word";
            desc = "32-bit word.";
            sw = rw;
            hw = r;
        } word[31:0];
    } W_708 @ 0x708;

    reg {
        name = "Word 0x70C";
        desc = "Word 0x70C. PROVEN: stored byte lanes 0123, cleared bit extents none seen, ORed constants none, written by h265e_drv_update_arith_cfg (1 stores). Meaning UNKNOWN.";
        field {
            name = "word";
            desc = "32-bit word.";
            sw = rw;
            hw = r;
        } word[31:0];
    } W_70C @ 0x70C;

    reg {
        name = "Word 0x710";
        desc = "Word 0x710. PROVEN: stored byte lanes 0123, cleared bit extents none seen, ORed constants none, written by h265e_drv_update_arith_cfg (1 stores). Meaning UNKNOWN.";
        field {
            name = "word";
            desc = "32-bit word.";
            sw = rw;
            hw = r;
        } word[31:0];
    } W_710 @ 0x710;

    reg {
        name = "Word 0x714";
        desc = "Word 0x714. PROVEN: stored byte lanes 0123, cleared bit extents none seen, ORed constants none, written by h265e_drv_update_arith_cfg (1 stores). Meaning UNKNOWN.";
        field {
            name = "word";
            desc = "32-bit word.";
            sw = rw;
            hw = r;
        } word[31:0];
    } W_714 @ 0x714;

    reg {
        name = "Word 0x718";
        desc = "Word 0x718. PROVEN: stored byte lanes 0123, cleared bit extents none seen, ORed constants none, written by h265e_drv_update_arith_cfg (1 stores). Meaning UNKNOWN.";
        field {
            name = "word";
            desc = "32-bit word.";
            sw = rw;
            hw = r;
        } word[31:0];
    } W_718 @ 0x718;

    reg {
        name = "Word 0x71C";
        desc = "Word 0x71C. PROVEN: stored byte lanes 0123, cleared bit extents none seen, ORed constants none, written by h265e_drv_update_arith_cfg (1 stores). Meaning UNKNOWN.";
        field {
            name = "word";
            desc = "32-bit word.";
            sw = rw;
            hw = r;
        } word[31:0];
    } W_71C @ 0x71C;

    reg {
        name = "Word 0x720";
        desc = "Word 0x720. PROVEN: stored byte lanes 0123, cleared bit extents none seen, ORed constants none, written by h265e_drv_update_arith_cfg (1 stores). Meaning UNKNOWN.";
        field {
            name = "word";
            desc = "32-bit word.";
            sw = rw;
            hw = r;
        } word[31:0];
    } W_720 @ 0x720;

    reg {
        name = "Word 0x724";
        desc = "Word 0x724. PROVEN: stored byte lanes 01, cleared bit extents none seen, ORed constants 0x8, written by h265e_drv_update_arith_cfg (2 stores). Meaning UNKNOWN.";
        field {
            name = "word";
            desc = "32-bit word.";
            sw = rw;
            hw = r;
        } word[31:0];
    } W_724 @ 0x724;

    reg {
        name = "Word 0x728";
        desc = "Word 0x728. PROVEN: stored byte lanes 0123, cleared bit extents none seen, ORed constants none, written by h265e_drv_update_arith_cfg (1 stores). Meaning UNKNOWN.";
        field {
            name = "word";
            desc = "32-bit word.";
            sw = rw;
            hw = r;
        } word[31:0];
    } W_728 @ 0x728;

    reg {
        name = "Word 0x72C";
        desc = "Word 0x72C. PROVEN: stored byte lanes 0123, cleared bit extents none seen, ORed constants none, written by h265e_drv_update_arith_cfg (2 stores). Meaning UNKNOWN.";
        field {
            name = "word";
            desc = "32-bit word.";
            sw = rw;
            hw = r;
        } word[31:0];
    } W_72C @ 0x72C;

    reg {
        name = "Word 0x730";
        desc = "Word 0x730. PROVEN: stored byte lanes 0123, cleared bit extents none seen, ORed constants none, written by h265e_drv_update_arith_cfg (1 stores). Meaning UNKNOWN.";
        field {
            name = "word";
            desc = "32-bit word.";
            sw = rw;
            hw = r;
        } word[31:0];
    } W_730 @ 0x730;

    reg {
        name = "Word 0x734";
        desc = "Word 0x734. PROVEN: stored byte lanes 0123, cleared bit extents none seen, ORed constants none, written by h265e_drv_update_arith_cfg (1 stores). Meaning UNKNOWN.";
        field {
            name = "word";
            desc = "32-bit word.";
            sw = rw;
            hw = r;
        } word[31:0];
    } W_734 @ 0x734;

    reg {
        name = "Word 0x738";
        desc = "Word 0x738. PROVEN: stored byte lanes 0123, cleared bit extents none seen, ORed constants none, written by h265e_drv_update_arith_cfg (1 stores). Meaning UNKNOWN.";
        field {
            name = "word";
            desc = "32-bit word.";
            sw = rw;
            hw = r;
        } word[31:0];
    } W_738 @ 0x738;

    reg {
        name = "Word 0x73C";
        desc = "Word 0x73C. PROVEN: stored byte lanes 0123, cleared bit extents none seen, ORed constants none, written by h265e_drv_update_arith_cfg (1 stores). Meaning UNKNOWN.";
        field {
            name = "word";
            desc = "32-bit word.";
            sw = rw;
            hw = r;
        } word[31:0];
    } W_73C @ 0x73C;

    reg {
        name = "Word 0x740";
        desc = "Word 0x740. PROVEN: stored byte lanes 0123, cleared bit extents none seen, ORed constants none, written by h265e_drv_update_arith_cfg (1 stores). Meaning UNKNOWN.";
        field {
            name = "word";
            desc = "32-bit word.";
            sw = rw;
            hw = r;
        } word[31:0];
    } W_740 @ 0x740;

    reg {
        name = "Word 0x744";
        desc = "Word 0x744. PROVEN: stored byte lanes 0123, cleared bit extents none seen, ORed constants none, written by h265e_drv_update_arith_cfg (1 stores). Meaning UNKNOWN.";
        field {
            name = "word";
            desc = "32-bit word.";
            sw = rw;
            hw = r;
        } word[31:0];
    } W_744 @ 0x744;

    reg {
        name = "Word 0x748";
        desc = "Word 0x748. PROVEN: stored byte lanes 0123, cleared bit extents none seen, ORed constants none, written by h265e_drv_update_arith_cfg (1 stores). Meaning UNKNOWN.";
        field {
            name = "word";
            desc = "32-bit word.";
            sw = rw;
            hw = r;
        } word[31:0];
    } W_748 @ 0x748;

    reg {
        name = "Word 0x74C";
        desc = "Word 0x74C. PROVEN: stored byte lanes 0123, cleared bit extents none seen, ORed constants none, written by h265e_drv_update_arith_cfg (1 stores). Meaning UNKNOWN.";
        field {
            name = "word";
            desc = "32-bit word.";
            sw = rw;
            hw = r;
        } word[31:0];
    } W_74C @ 0x74C;

    reg {
        name = "Word 0x750";
        desc = "Word 0x750. PROVEN: stored byte lanes 0123, cleared bit extents none seen, ORed constants none, written by h265e_drv_update_arith_cfg (1 stores). Meaning UNKNOWN.";
        field {
            name = "word";
            desc = "32-bit word.";
            sw = rw;
            hw = r;
        } word[31:0];
    } W_750 @ 0x750;

    reg {
        name = "Word 0x754";
        desc = "Word 0x754. PROVEN: stored byte lanes 0123, cleared bit extents none seen, ORed constants none, written by h265e_drv_update_arith_cfg (1 stores). Meaning UNKNOWN.";
        field {
            name = "word";
            desc = "32-bit word.";
            sw = rw;
            hw = r;
        } word[31:0];
    } W_754 @ 0x754;

    reg {
        name = "Word 0x758";
        desc = "Word 0x758. PROVEN: stored byte lanes 0123, cleared bit extents none seen, ORed constants none, written by h265e_drv_update_arith_cfg (1 stores). Meaning UNKNOWN.";
        field {
            name = "word";
            desc = "32-bit word.";
            sw = rw;
            hw = r;
        } word[31:0];
    } W_758 @ 0x758;

    reg {
        name = "Word 0x75C";
        desc = "Word 0x75C. PROVEN: stored byte lanes 0123, cleared bit extents none seen, ORed constants none, written by h265e_drv_update_arith_cfg (1 stores). Meaning UNKNOWN.";
        field {
            name = "word";
            desc = "32-bit word.";
            sw = rw;
            hw = r;
        } word[31:0];
    } W_75C @ 0x75C;

    reg {
        name = "Word 0x760";
        desc = "Word 0x760. PROVEN: stored byte lanes 0123, cleared bit extents none seen, ORed constants none, written by h265e_drv_update_arith_cfg (1 stores). Meaning UNKNOWN.";
        field {
            name = "word";
            desc = "32-bit word.";
            sw = rw;
            hw = r;
        } word[31:0];
    } W_760 @ 0x760;

    reg {
        name = "Word 0x764";
        desc = "Word 0x764. PROVEN: stored byte lanes 0123, cleared bit extents none seen, ORed constants none, written by h265e_drv_update_arith_cfg (1 stores). Meaning UNKNOWN.";
        field {
            name = "word";
            desc = "32-bit word.";
            sw = rw;
            hw = r;
        } word[31:0];
    } W_764 @ 0x764;

    reg {
        name = "Word 0x768";
        desc = "Word 0x768. PROVEN: stored byte lanes 0123, cleared bit extents none seen, ORed constants none, written by h265e_drv_update_arith_cfg (1 stores). Meaning UNKNOWN.";
        field {
            name = "word";
            desc = "32-bit word.";
            sw = rw;
            hw = r;
        } word[31:0];
    } W_768 @ 0x768;

    reg {
        name = "Word 0x76C";
        desc = "Word 0x76C. PROVEN: stored byte lanes 3, cleared bit extents none seen, ORed constants none, written by h265e_drv_update_arith_cfg (1 stores). Meaning UNKNOWN.";
        field {
            name = "word";
            desc = "32-bit word.";
            sw = rw;
            hw = r;
        } word[31:0];
    } W_76C @ 0x76C;

    reg {
        name = "Word 0x770";
        desc = "Word 0x770. PROVEN: stored byte lanes 0123, cleared bit extents none seen, ORed constants none, written by h265e_drv_update_arith_cfg (1 stores). Meaning UNKNOWN.";
        field {
            name = "word";
            desc = "32-bit word.";
            sw = rw;
            hw = r;
        } word[31:0];
    } W_770 @ 0x770;

    reg {
        name = "Word 0x774";
        desc = "Word 0x774. PROVEN: stored byte lanes 0123, cleared bit extents none seen, ORed constants none, written by h265e_drv_update_arith_cfg (1 stores). Meaning UNKNOWN.";
        field {
            name = "word";
            desc = "32-bit word.";
            sw = rw;
            hw = r;
        } word[31:0];
    } W_774 @ 0x774;

    reg {
        name = "Word 0x778";
        desc = "Word 0x778. PROVEN: stored byte lanes 0123, cleared bit extents none seen, ORed constants none, written by h265e_drv_update_arith_cfg (1 stores). Meaning UNKNOWN.";
        field {
            name = "word";
            desc = "32-bit word.";
            sw = rw;
            hw = r;
        } word[31:0];
    } W_778 @ 0x778;

    reg {
        name = "Word 0x77C";
        desc = "Word 0x77C. PROVEN: stored byte lanes 0123, cleared bit extents none seen, ORed constants none, written by h265e_drv_update_arith_cfg (1 stores). Meaning UNKNOWN.";
        field {
            name = "word";
            desc = "32-bit word.";
            sw = rw;
            hw = r;
        } word[31:0];
    } W_77C @ 0x77C;

    reg {
        name = "Word 0x780";
        desc = "Word 0x780. PROVEN: stored byte lanes 0123, cleared bit extents none seen, ORed constants none, written by h265e_drv_update_arith_cfg (1 stores). Meaning UNKNOWN.";
        field {
            name = "word";
            desc = "32-bit word.";
            sw = rw;
            hw = r;
        } word[31:0];
    } W_780 @ 0x780;

    reg {
        name = "Word 0x784";
        desc = "Word 0x784. PROVEN: stored byte lanes 0123, cleared bit extents none seen, ORed constants none, written by h265e_drv_update_arith_cfg (1 stores). Meaning UNKNOWN.";
        field {
            name = "word";
            desc = "32-bit word.";
            sw = rw;
            hw = r;
        } word[31:0];
    } W_784 @ 0x784;

    reg {
        name = "Word 0x788";
        desc = "Word 0x788. PROVEN: stored byte lanes 0123, cleared bit extents none seen, ORed constants none, written by h265e_drv_update_arith_cfg (1 stores). Meaning UNKNOWN.";
        field {
            name = "word";
            desc = "32-bit word.";
            sw = rw;
            hw = r;
        } word[31:0];
    } W_788 @ 0x788;

    reg {
        name = "Word 0x78C";
        desc = "Word 0x78C. PROVEN: stored byte lanes 0123, cleared bit extents none seen, ORed constants none, written by h265e_drv_update_arith_cfg (1 stores). Meaning UNKNOWN.";
        field {
            name = "word";
            desc = "32-bit word.";
            sw = rw;
            hw = r;
        } word[31:0];
    } W_78C @ 0x78C;

    reg {
        name = "Word 0x790";
        desc = "Word 0x790. PROVEN: stored byte lanes 0123, cleared bit extents none seen, ORed constants none, written by h265e_drv_update_arith_cfg (1 stores). Meaning UNKNOWN.";
        field {
            name = "word";
            desc = "32-bit word.";
            sw = rw;
            hw = r;
        } word[31:0];
    } W_790 @ 0x790;

    reg {
        name = "Word 0x794";
        desc = "Word 0x794. PROVEN: stored byte lanes 0123, cleared bit extents none seen, ORed constants none, written by h265e_drv_update_arith_cfg (1 stores). Meaning UNKNOWN.";
        field {
            name = "word";
            desc = "32-bit word.";
            sw = rw;
            hw = r;
        } word[31:0];
    } W_794 @ 0x794;

    reg {
        name = "Word 0x798";
        desc = "Word 0x798. PROVEN: stored byte lanes 0123, cleared bit extents none seen, ORed constants none, written by h265e_drv_update_arith_cfg (1 stores). Meaning UNKNOWN.";
        field {
            name = "word";
            desc = "32-bit word.";
            sw = rw;
            hw = r;
        } word[31:0];
    } W_798 @ 0x798;

    reg {
        name = "Word 0x79C";
        desc = "Word 0x79C. PROVEN: stored byte lanes 0123, cleared bit extents none seen, ORed constants none, written by h265e_drv_update_arith_cfg (1 stores). Meaning UNKNOWN.";
        field {
            name = "word";
            desc = "32-bit word.";
            sw = rw;
            hw = r;
        } word[31:0];
    } W_79C @ 0x79C;

    reg {
        name = "Word 0x7A0";
        desc = "Word 0x7A0. PROVEN: stored byte lanes 2, cleared bit extents none seen, ORed constants 0x10000, written by h265e_drv_update_arith_cfg (1 stores). Meaning UNKNOWN.";
        field {
            name = "word";
            desc = "32-bit word.";
            sw = rw;
            hw = r;
        } word[31:0];
    } W_7A0 @ 0x7A0;

    reg {
        name = "Word 0x7A4";
        desc = "Word 0x7A4. PROVEN: stored byte lanes 012, cleared bit extents none seen, ORed constants 0x400, 0x3C0000, written by h265e_drv_update_arith_cfg (3 stores). Meaning UNKNOWN.";
        field {
            name = "word";
            desc = "32-bit word.";
            sw = rw;
            hw = r;
        } word[31:0];
    } W_7A4 @ 0x7A4;

    reg {
        name = "Word 0x7A8";
        desc = "Word 0x7A8. PROVEN: stored byte lanes 012, cleared bit extents none seen, ORed constants none, written by h265e_drv_update_arith_cfg (3 stores). Meaning UNKNOWN.";
        field {
            name = "word";
            desc = "32-bit word.";
            sw = rw;
            hw = r;
        } word[31:0];
    } W_7A8 @ 0x7A8;

    reg {
        name = "Word 0x7AC";
        desc = "Word 0x7AC. PROVEN: stored byte lanes 0123, cleared bit extents none seen, ORed constants 0x7B00, 0x7D000000, written by h265e_drv_update_arith_cfg (4 stores). Meaning UNKNOWN.";
        field {
            name = "word";
            desc = "32-bit word.";
            sw = rw;
            hw = r;
        } word[31:0];
    } W_7AC @ 0x7AC;

    reg {
        name = "Word 0x7B0";
        desc = "Word 0x7B0. PROVEN: stored byte lanes 0123, cleared bit extents none seen, ORed constants 0x1, 0x200, 0x280000, 0x64000000, written by h265e_drv_update_arith_cfg (4 stores). Meaning UNKNOWN.";
        field {
            name = "word";
            desc = "32-bit word.";
            sw = rw;
            hw = r;
        } word[31:0];
    } W_7B0 @ 0x7B0;

    reg {
        name = "Word 0x7B4";
        desc = "Word 0x7B4. PROVEN: stored byte lanes 0123, cleared bit extents none seen, ORed constants none, written by h265e_drv_update_arith_cfg (2 stores). Meaning UNKNOWN.";
        field {
            name = "word";
            desc = "32-bit word.";
            sw = rw;
            hw = r;
        } word[31:0];
    } W_7B4 @ 0x7B4;

    reg {
        name = "Word 0x7B8";
        desc = "Word 0x7B8. PROVEN: stored byte lanes 0123, cleared bit extents none seen, ORed constants none, written by h265e_drv_update_arith_cfg (3 stores). Meaning UNKNOWN.";
        field {
            name = "word";
            desc = "32-bit word.";
            sw = rw;
            hw = r;
        } word[31:0];
    } W_7B8 @ 0x7B8;

    reg {
        name = "Word 0x7BC";
        desc = "Word 0x7BC. PROVEN: stored byte lanes 0123, cleared bit extents none seen, ORed constants none, written by h265e_drv_update_arith_cfg (3 stores). Meaning UNKNOWN.";
        field {
            name = "word";
            desc = "32-bit word.";
            sw = rw;
            hw = r;
        } word[31:0];
    } W_7BC @ 0x7BC;

    reg {
        name = "Word 0x7C0";
        desc = "Word 0x7C0. PROVEN: stored byte lanes 0123, cleared bit extents none seen, ORed constants 0x1, 0x10000, written by h265e_drv_update_arith_cfg (4 stores). Meaning UNKNOWN.";
        field {
            name = "word";
            desc = "32-bit word.";
            sw = rw;
            hw = r;
        } word[31:0];
    } W_7C0 @ 0x7C0;

    reg {
        name = "Word 0x7C4";
        desc = "Word 0x7C4. PROVEN: stored byte lanes 01, cleared bit extents none seen, ORed constants 0x4, written by h265e_drv_update_arith_cfg (2 stores). Meaning UNKNOWN.";
        field {
            name = "word";
            desc = "32-bit word.";
            sw = rw;
            hw = r;
        } word[31:0];
    } W_7C4 @ 0x7C4;

    reg {
        name = "Word 0x7C8";
        desc = "Word 0x7C8. PROVEN: stored byte lanes 0123, cleared bit extents none seen, ORed constants 0x64, written by h265e_drv_update_arith_cfg (4 stores). Meaning UNKNOWN.";
        field {
            name = "word";
            desc = "32-bit word.";
            sw = rw;
            hw = r;
        } word[31:0];
    } W_7C8 @ 0x7C8;

    reg {
        name = "Word 0x7CC";
        desc = "Word 0x7CC. PROVEN: stored byte lanes 0123, cleared bit extents none seen, ORed constants 0x74, 0x780000, written by h265e_drv_update_arith_cfg (4 stores). Meaning UNKNOWN.";
        field {
            name = "word";
            desc = "32-bit word.";
            sw = rw;
            hw = r;
        } word[31:0];
    } W_7CC @ 0x7CC;

    reg {
        name = "Word 0x7E0";
        desc = "Word 0x7E0. PROVEN: stored byte lanes 0123, cleared bit extents none seen, ORed constants none, written by h265e_drv_update_arith_cfg (1 stores). Meaning UNKNOWN.";
        field {
            name = "word";
            desc = "32-bit word.";
            sw = rw;
            hw = r;
        } word[31:0];
    } W_7E0 @ 0x7E0;

    reg {
        name = "Word 0x7E4";
        desc = "Word 0x7E4. PROVEN: stored byte lanes 012, cleared bit extents none seen, ORed constants none, written by h265e_drv_update_arith_cfg (3 stores). Meaning UNKNOWN.";
        field {
            name = "word";
            desc = "32-bit word.";
            sw = rw;
            hw = r;
        } word[31:0];
    } W_7E4 @ 0x7E4;

    reg {
        name = "Word 0x7E8";
        desc = "Word 0x7E8. PROVEN: stored byte lanes 0123, cleared bit extents none seen, ORed constants 0xF00, written by h265e_drv_update_arith_cfg (3 stores). Meaning UNKNOWN.";
        field {
            name = "word";
            desc = "32-bit word.";
            sw = rw;
            hw = r;
        } word[31:0];
    } W_7E8 @ 0x7E8;

    reg {
        name = "Word 0x7F0";
        desc = "Word 0x7F0. PROVEN: stored byte lanes 0123, cleared bit extents none seen, ORed constants 0x5, 0x1400, 0x1E0000, 0x28000000, written by h265e_drv_update_arith_cfg (4 stores). Meaning UNKNOWN.";
        field {
            name = "word";
            desc = "32-bit word.";
            sw = rw;
            hw = r;
        } word[31:0];
    } W_7F0 @ 0x7F0;

    reg {
        name = "Word 0x9C0";
        desc = "Word 0x9C0. PROVEN: stored byte lanes 0123, cleared bit extents none seen, ORed constants none, written by h265e_drv_update_sse_cfg_param (1 stores). Meaning UNKNOWN.";
        field {
            name = "word";
            desc = "32-bit word.";
            sw = rw;
            hw = r;
        } word[31:0];
    } W_9C0 @ 0x9C0;

    reg {
        name = "Word 0x9C4";
        desc = "Word 0x9C4. PROVEN: stored byte lanes 0123, cleared bit extents none seen, ORed constants none, written by h265e_drv_update_sse_cfg_param (1 stores). Meaning UNKNOWN.";
        field {
            name = "word";
            desc = "32-bit word.";
            sw = rw;
            hw = r;
        } word[31:0];
    } W_9C4 @ 0x9C4;

    reg {
        name = "Word 0x9C8";
        desc = "Word 0x9C8. PROVEN: stored byte lanes 0123, cleared bit extents none seen, ORed constants none, written by h265e_drv_update_sse_cfg_param (1 stores). Meaning UNKNOWN.";
        field {
            name = "word";
            desc = "32-bit word.";
            sw = rw;
            hw = r;
        } word[31:0];
    } W_9C8 @ 0x9C8;

    reg {
        name = "Word 0x9CC";
        desc = "Word 0x9CC. PROVEN: stored byte lanes 0123, cleared bit extents none seen, ORed constants none, written by h265e_drv_update_sse_cfg_param (1 stores). Meaning UNKNOWN.";
        field {
            name = "word";
            desc = "32-bit word.";
            sw = rw;
            hw = r;
        } word[31:0];
    } W_9CC @ 0x9CC;

    reg {
        name = "Word 0x9D0";
        desc = "Word 0x9D0. PROVEN: stored byte lanes 0123, cleared bit extents none seen, ORed constants none, written by h265e_drv_update_sse_cfg_param (1 stores). Meaning UNKNOWN.";
        field {
            name = "word";
            desc = "32-bit word.";
            sw = rw;
            hw = r;
        } word[31:0];
    } W_9D0 @ 0x9D0;

    reg {
        name = "Word 0x9D4";
        desc = "Word 0x9D4. PROVEN: stored byte lanes 0123, cleared bit extents none seen, ORed constants none, written by h265e_drv_update_sse_cfg_param (1 stores). Meaning UNKNOWN.";
        field {
            name = "word";
            desc = "32-bit word.";
            sw = rw;
            hw = r;
        } word[31:0];
    } W_9D4 @ 0x9D4;

    reg {
        name = "Word 0x9D8";
        desc = "Word 0x9D8. PROVEN: stored byte lanes 0123, cleared bit extents none seen, ORed constants none, written by h265e_drv_update_sse_cfg_param (1 stores). Meaning UNKNOWN.";
        field {
            name = "word";
            desc = "32-bit word.";
            sw = rw;
            hw = r;
        } word[31:0];
    } W_9D8 @ 0x9D8;

    reg {
        name = "Word 0x9DC";
        desc = "Word 0x9DC. PROVEN: stored byte lanes 0123, cleared bit extents none seen, ORed constants none, written by h265e_drv_update_sse_cfg_param (1 stores). Meaning UNKNOWN.";
        field {
            name = "word";
            desc = "32-bit word.";
            sw = rw;
            hw = r;
        } word[31:0];
    } W_9DC @ 0x9DC;

    reg {
        name = "Word 0x9E0";
        desc = "Word 0x9E0. PROVEN: stored byte lanes 0123, cleared bit extents none seen, ORed constants none, written by h265e_drv_update_sse_cfg_param (1 stores). Meaning UNKNOWN.";
        field {
            name = "word";
            desc = "32-bit word.";
            sw = rw;
            hw = r;
        } word[31:0];
    } W_9E0 @ 0x9E0;

    reg {
        name = "Word 0x9E4";
        desc = "Word 0x9E4. PROVEN: stored byte lanes 0123, cleared bit extents none seen, ORed constants none, written by h265e_drv_update_sse_cfg_param (1 stores). Meaning UNKNOWN.";
        field {
            name = "word";
            desc = "32-bit word.";
            sw = rw;
            hw = r;
        } word[31:0];
    } W_9E4 @ 0x9E4;

    reg {
        name = "Word 0x9E8";
        desc = "Word 0x9E8. PROVEN: stored byte lanes 0123, cleared bit extents none seen, ORed constants none, written by h265e_drv_update_sse_cfg_param (1 stores). Meaning UNKNOWN.";
        field {
            name = "word";
            desc = "32-bit word.";
            sw = rw;
            hw = r;
        } word[31:0];
    } W_9E8 @ 0x9E8;

    reg {
        name = "Word 0x9EC";
        desc = "Word 0x9EC. PROVEN: stored byte lanes 0123, cleared bit extents none seen, ORed constants none, written by h265e_drv_update_sse_cfg_param (1 stores). Meaning UNKNOWN.";
        field {
            name = "word";
            desc = "32-bit word.";
            sw = rw;
            hw = r;
        } word[31:0];
    } W_9EC @ 0x9EC;

    reg {
        name = "Word 0x9F0";
        desc = "Word 0x9F0. PROVEN: stored byte lanes 0123, cleared bit extents none seen, ORed constants none, written by h265e_drv_update_sse_cfg_param (1 stores). Meaning UNKNOWN.";
        field {
            name = "word";
            desc = "32-bit word.";
            sw = rw;
            hw = r;
        } word[31:0];
    } W_9F0 @ 0x9F0;

    reg {
        name = "Word 0x9F4";
        desc = "Word 0x9F4. PROVEN: stored byte lanes 0123, cleared bit extents none seen, ORed constants none, written by h265e_drv_update_sse_cfg_param (1 stores). Meaning UNKNOWN.";
        field {
            name = "word";
            desc = "32-bit word.";
            sw = rw;
            hw = r;
        } word[31:0];
    } W_9F4 @ 0x9F4;

    reg {
        name = "Word 0x9F8";
        desc = "Word 0x9F8. PROVEN: stored byte lanes 0123, cleared bit extents none seen, ORed constants none, written by h265e_drv_update_sse_cfg_param (1 stores). Meaning UNKNOWN.";
        field {
            name = "word";
            desc = "32-bit word.";
            sw = rw;
            hw = r;
        } word[31:0];
    } W_9F8 @ 0x9F8;

    reg {
        name = "Word 0x9FC";
        desc = "Word 0x9FC. PROVEN: stored byte lanes 0123, cleared bit extents none seen, ORed constants none, written by h265e_drv_update_sse_cfg_param (1 stores). Meaning UNKNOWN.";
        field {
            name = "word";
            desc = "32-bit word.";
            sw = rw;
            hw = r;
        } word[31:0];
    } W_9FC @ 0x9FC;

};

`endif
