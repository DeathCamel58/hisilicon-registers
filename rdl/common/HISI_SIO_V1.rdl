`ifndef HISI_SIO_V1_RDL
`define HISI_SIO_V1_RDL

// SIO V1: the first edition of the FIFO based I2S/PCM audio interface, found on the Hi3511 / Hi3512 (2009). The Hi3515 / Hi3520 V100 edition
// (eHISI_SIO in HISI_SIO.rdl) keeps the data registers at the same offsets but replaces the control block: separate I2S and PCM control set/clear
// pairs (I2S_CT_SET/I2S_CT_CLR at 0x5C/0x60, PCM_CT_SET/PCM_CT_CLR at 0x70/0x74), an own clock divider (I2S_ICD 0x64), 8-entry FIFOs with 3-bit
// thresholds and 4-bit depth counters plus overflow flags in SIO_RX_STA/SIO_TX_STA, a two-bit width register (I2S_LENGTH_CF 0x78) and only the two
// threshold interrupts (no SIO_VERSION, SIO_INTMASK, SIO_PCM_XD/RD aliases, merge-into-32-bit bits or multi-channel receive mode).
// Transcribed from the Hi3511/Hi3512 Chinese data sheet issue 06 chapter 7 (`hi3511v100--Hi3511-Datasheet.txt` lines 26790-27780; SIO0 0x8008_0000
// VIC interrupt 27, SIO1 0x900A_0000 VIC interrupt 18; DMAC requests 2/3 = SIO0 RX/TX, 4 = SIO1 RX). Not hardware verified; no vendor source code.
regfile eHISI_SIO_V1 {
    name = "HiSilicon SIO V1 (I2S/PCM audio interface, Hi3511/Hi3512)";
    desc = "
    Serial audio interface (SIO) of the Hi3511 / Hi3512: one I2S (8/16/20/24/32-bit, MSB first, left + right FIFOs) or PCM (16-bit linear, one FIFO,
    short-pulse frame sync) transmit path and one receive path, each with an 8 x 32-bit FIFO per channel and an adjustable threshold. The CPU (or the
    DMAC) writes samples to SIO_I2S_LEFT_XD / SIO_I2S_RIGHT_XD (PCM uses the right register) and reads them from SIO_I2S_LEFT_RD / SIO_I2S_RIGHT_RD;
    with SIO_I2S_POS_MERGE_EN.merge_en both channels go through the single SIO_I2S_DUAL_RX_CHN / SIO_I2S_DUAL_TX_CHN address so one DMA channel serves
    both. The control bits live in set/clear pairs, one for I2S mode (I2S_CT_SET 0x5C / I2S_CT_CLR 0x60) and one for PCM mode (PCM_CT_SET 0x70 /
    PCM_CT_CLR 0x74): writing 1 to a bit of the set register sets it, writing 1 to the clear register clears it, writing 0 has no effect.

    Clocking (data sheet 7.5.3): the bit clock and frame sync are either input from the pins (SC_PERCTRL4.sioNclk_sel = 0 and xx_CT_SET[3:2] = 0b11,
    the recommended slave mode), generated by the CRG divider (SC_PERCTRL4.sioNclk_sel = 1, divider in SC_PERCTRL3, master mode) or generated inside the
    SIO from I2S_ICD (xx_CT_SET[3:2] = 0b00, not recommended). The CRG cannot generate a PCM frame sync, so in PCM mode the codec should be the master.
    The master clock output ACKOUT for the codec comes from the system controller. Pin multiplexing: SC_PERCTRL1 (SIO0XFS/SIO0XCK on GPIO6_2/6_3,
    SIO1DI/RFS/RCK on GPIO0_4/0_2/0_3); clock gating SC_PERDIS.sioNclkdis; soft reset SC_PERCTRL0.sioN_srst (all registers return to their reset values).

    Registers from the Hi3511/Hi3512 data sheet issue 06 chapter 7.6/7.7 (`hi3511v100--Hi3511-Datasheet.txt` lines 26790-27780). The overview table
    names the control registers I2S_CT_SET/I2S_CT_CLR while their own tables are headed SIO_CT_SET/SIO_CT_CLR; the overview names are used here. The
    initialisation text refers to a SIO_MODE[pcm_mode] timing select that the SIO_MODE table does not list (bits [31:1] reserved); the Hi3515 edition
    has it at bit 1. Not hardware verified.
    ";

    reg {
        name = "SIO mode register";
        desc = "SIO_MODE is the SIO mode register: I2S or PCM mode. (The data sheet's initialisation sequence also mentions SIO_MODE[pcm_mode], the PCM standard/customized timing select, which the register table leaves reserved; the Hi3515 edition documents it at bit 1.)

Data sheet 7.7 SIO_MODE (offset 0x40, printed page 7-12, `hi3511v100--Hi3511-Datasheet.txt` line 26880).";

        enum SIO_MODE_sio_mode_enum {
            I2S = 0 { name = "I2S"; desc = "I2S mode."; };
            PCM = 1 { name = "PCM"; desc = "PCM mode."; };
        };

        field {
            name = "sio_mode";
            desc = "PCM/I2S mode select.";
            sw = rw;
            hw = r;
            encode = SIO_MODE_sio_mode_enum;
            reset = 0x0;
        } sio_mode[0:0];
    } SIO_MODE @ 0x40;

    reg {
        name = "SIO interrupt status register";
        desc = "SIO_INTSTATUS is the SIO interrupt status register. A threshold condition (RX_FIFO above / TX_FIFO below the threshold) is latched again in the next clock cycle after a clear as long as it persists. Recommended handling: read SIO_INTSTATUS, service the sources, then write 1 to the SIO_INTCLR bits. Bits [5:2] are reserved on this edition (the Hi3515 edition adds the FIFO overflow/underflow interrupts there; here the overflow flags are in SIO_RX_STA/SIO_TX_STA).

Data sheet 7.7 SIO_INTSTATUS (offset 0x44, printed page 7-13, `hi3511v100--Hi3511-Datasheet.txt` line 26924).";

        field {
            name = "tx_intr";
            desc = "Interrupt status when the TX_FIFO level is below the threshold (xx_CT_SET.tx_fifo_threshold). 0: no interrupt, 1: interrupt.";
            sw = r;
            hw = w;
            reset = 0x0;
        } tx_intr[1:1];

        field {
            name = "rx_intr";
            desc = "Interrupt status when the RX_FIFO level is above the threshold (xx_CT_SET.rx_fifo_threshold). 0: no interrupt, 1: interrupt.";
            sw = r;
            hw = w;
            reset = 0x0;
        } rx_intr[0:0];
    } SIO_INTSTATUS @ 0x44;

    reg {
        name = "SIO interrupt clear register";
        desc = "SIO_INTCLR is the SIO interrupt clear register; each bit clears the SIO_INTSTATUS bit of the same position when written with 1 (writing 0 has no effect).

Data sheet 7.7 SIO_INTCLR (offset 0x48, printed page 7-14, `hi3511v100--Hi3511-Datasheet.txt` line 26962).";

        field {
            name = "tx_intr";
            desc = "Clear the TX_FIFO level below threshold interrupt.";
            sw = w;
            hw = r;
            onwrite = woclr;
        } tx_intr[1:1];

        field {
            name = "rx_intr";
            desc = "Clear the RX_FIFO level above threshold interrupt.";
            sw = w;
            hw = r;
            onwrite = woclr;
        } rx_intr[0:0];
    } SIO_INTCLR @ 0x48;

    reg {
        name = "I2S left channel data transmit register";
        desc = "SIO_I2S_LEFT_XD is the I2S left channel data transmit register (write into the left TX_FIFO). The valid data sits in the low bits (8-bit width: [7:0], 16-bit: [15:0], ...); the SIO forces the bits above the configured width to 0.

Data sheet 7.7 SIO_I2S_LEFT_XD (offset 0x4C, printed page 7-14, `hi3511v100--Hi3511-Datasheet.txt` line 26995).";

        field {
            name = "tx_left_data";
            desc = "Left channel transmit data.";
            sw = w;
            hw = r;
            reset = 0x0;
        } tx_left_data[31:0];
    } SIO_I2S_LEFT_XD @ 0x4C;

    reg {
        name = "I2S right channel / PCM data transmit register";
        desc = "SIO_I2S_RIGHT_XD is the I2S right channel data transmit register; in PCM mode it is the PCM data transmit register. The valid data sits in the low bits of the configured width.

Data sheet 7.7 SIO_I2S_RIGHT_XD (offset 0x50, printed page 7-15, `hi3511v100--Hi3511-Datasheet.txt` line 27026).";

        field {
            name = "tx_right_data";
            desc = "Right channel transmit data (I2S mode) or PCM transmit data (PCM mode).";
            sw = w;
            hw = r;
            reset = 0x0;
        } tx_right_data[31:0];
    } SIO_I2S_RIGHT_XD @ 0x50;

    reg {
        name = "I2S left channel data receive register";
        desc = "SIO_I2S_LEFT_RD is the I2S left channel data receive register (read from the left RX_FIFO). The received data sits in the low bits of the configured width, the bits above are 0 (or the sign extension when SIO_SIGNED_EXT.signed_ext_en = 1). Note: when data receive is disabled in I2S mode the right channel sample may not have been written into its FIFO yet, so the left FIFO can hold one entry more than the right one; read both FIFOs empty before starting the next receive.

Data sheet 7.7 SIO_I2S_LEFT_RD (offset 0x54, printed page 7-15, `hi3511v100--Hi3511-Datasheet.txt` line 27049).";

        field {
            name = "rx_left_data";
            desc = "I2S left channel receive data.";
            sw = r;
            hw = w;
            reset = 0x0;
        } rx_left_data[31:0];
    } SIO_I2S_LEFT_RD @ 0x54;

    reg {
        name = "I2S right channel / PCM data receive register";
        desc = "SIO_I2S_RIGHT_RD is the I2S right channel data receive register; in PCM mode it is the PCM data receive register.

Data sheet 7.7 SIO_I2S_RIGHT_RD (offset 0x58, printed page 7-16, `hi3511v100--Hi3511-Datasheet.txt` line 27079).";

        field {
            name = "rx_right_data";
            desc = "I2S right channel receive data (I2S mode) or PCM receive data (PCM mode).";
            sw = r;
            hw = w;
            reset = 0x0;
        } rx_right_data[31:0];
    } SIO_I2S_RIGHT_RD @ 0x58;

    reg {
        name = "I2S control set register";
        desc = "I2S_CT_SET is the I2S control register in its set view: writing 1 to a bit sets it, writing 0 has no effect, reads return the control register. The same bits are cleared through I2S_CT_CLR (0x60, write-only). Total reset value 0x0000_800C: rst_n = 1 (channel not in reset), tx_clk_sel = tx_ws_sel = 1 (bit clock and frame sync from the CRG or the pins). The register table in the data sheet is headed 'SIO_CT_SET'.

Data sheet 7.7 I2S_CT_SET (offset 0x5C, printed page 7-16, `hi3511v100--Hi3511-Datasheet.txt` line 27105).";

        field {
            name = "rst_n";
            desc = "I2S/PCM channel reset, active low. Resets the receive and transmit modules including the FIFOs (clears them); does not reset the CPU interface registers.";
            sw = rw;
            hw = r;
            onwrite = woset;
            reset = 0x1;
        } rst_n[15:15];

        field {
            name = "rx_enable";
            desc = "Receive channel enable. 0: disabled, 1: enabled.";
            sw = rw;
            hw = r;
            onwrite = woset;
            reset = 0x0;
        } rx_enable[13:13];

        field {
            name = "tx_enable";
            desc = "Transmit channel enable. 0: disabled, 1: enabled.";
            sw = rw;
            hw = r;
            onwrite = woset;
            reset = 0x0;
        } tx_enable[12:12];

        field {
            name = "rx_fifo_disable";
            desc = "RX_FIFO disable. 0: FIFO enabled, 1: FIFO disabled (data is buffered in an internal register instead).";
            sw = rw;
            hw = r;
            onwrite = woset;
            reset = 0x0;
        } rx_fifo_disable[11:11];

        field {
            name = "tx_fifo_disable";
            desc = "TX_FIFO disable. 0: FIFO enabled, 1: FIFO disabled. The data sheet's playback sequence clears residual TX data by writing this bit 0 and then 1.";
            sw = rw;
            hw = r;
            onwrite = woset;
            reset = 0x0;
        } tx_fifo_disable[10:10];

        field {
            name = "rx_fifo_threshold";
            desc = "RX_FIFO threshold: when rx_right_depth >= rx_fifo_threshold + 1 the receive interrupt and DMA request are raised (FIFO depth 8).";
            sw = rw;
            hw = r;
            onwrite = woset;
            reset = 0x0;
        } rx_fifo_threshold[9:7];

        field {
            name = "tx_fifo_threshold";
            desc = "TX_FIFO threshold: when tx_right_depth < tx_fifo_threshold + 1 the transmit interrupt and DMA request are raised (FIFO depth 8).";
            sw = rw;
            hw = r;
            onwrite = woset;
            reset = 0x0;
        } tx_fifo_threshold[6:4];

        enum I2S_CT_SET_clk_sel_enum {
            INTERNAL = 0 { name = "Internal"; desc = "Generated inside the SIO (I2S_ICD divider)."; };
            EXTERNAL = 1 { name = "CRG/External"; desc = "From the CRG divider or the external input (selected by SC_PERCTRL4.sioNclk_sel)."; };
        };

        field {
            name = "tx_clk_sel";
            desc = "Transmit bit clock source select. Slave mode: tx_clk_sel = tx_ws_sel = 1 with SC_PERCTRL4.sioNclk_sel = 0.";
            sw = rw;
            hw = r;
            onwrite = woset;
            encode = I2S_CT_SET_clk_sel_enum;
            reset = 0x1;
        } tx_clk_sel[3:3];

        field {
            name = "tx_ws_sel";
            desc = "Transmit frame sync (word select) source select.";
            sw = rw;
            hw = r;
            onwrite = woset;
            encode = I2S_CT_SET_clk_sel_enum;
            reset = 0x1;
        } tx_ws_sel[2:2];
    } I2S_CT_SET @ 0x5C;

    reg {
        name = "I2S control clear register";
        desc = "I2S_CT_CLR is the clear view of the I2S control register: writing 1 to a bit clears the control bit of the same position in I2S_CT_SET, writing 0 has no effect; write-only. The data sheet prints the same total reset value 0x0000_800C as for the set view and heads the table 'SIO_CT_CLR'.

Data sheet 7.7 I2S_CT_CLR (offset 0x60, printed page 7-17, `hi3511v100--Hi3511-Datasheet.txt` line 27185).";

        field { name = "rst_n"; desc = "Write 1 to clear rst_n (put the I2S/PCM channel and its FIFOs in reset)."; sw = w; hw = r; onwrite = woclr; } rst_n[15:15];
        field { name = "rx_enable"; desc = "Write 1 to disable the receive channel."; sw = w; hw = r; onwrite = woclr; } rx_enable[13:13];
        field { name = "tx_enable"; desc = "Write 1 to disable the transmit channel."; sw = w; hw = r; onwrite = woclr; } tx_enable[12:12];
        field { name = "rx_fifo_disable"; desc = "Write 1 to clear rx_fifo_disable (enable the RX_FIFO)."; sw = w; hw = r; onwrite = woclr; } rx_fifo_disable[11:11];
        field { name = "tx_fifo_disable"; desc = "Write 1 to clear tx_fifo_disable (enable the TX_FIFO)."; sw = w; hw = r; onwrite = woclr; } tx_fifo_disable[10:10];
        field { name = "rx_fifo_threshold"; desc = "Write 1 to clear the corresponding bits of rx_fifo_threshold."; sw = w; hw = r; onwrite = woclr; } rx_fifo_threshold[9:7];
        field { name = "tx_fifo_threshold"; desc = "Write 1 to clear the corresponding bits of tx_fifo_threshold."; sw = w; hw = r; onwrite = woclr; } tx_fifo_threshold[6:4];
        field { name = "tx_clk_sel"; desc = "Write 1 to clear tx_clk_sel (internal bit clock)."; sw = w; hw = r; onwrite = woclr; } tx_clk_sel[3:3];
        field { name = "tx_ws_sel"; desc = "Write 1 to clear tx_ws_sel (internal frame sync)."; sw = w; hw = r; onwrite = woclr; } tx_ws_sel[2:2];
    } I2S_CT_CLR @ 0x60;

    reg {
        name = "I2S clock divider register";
        desc = "I2S_ICD is the I2S clock divider register for the bit clock generated inside the SIO (xx_CT_SET.tx_clk_sel = 0): divide ratio = i2s_icd + 1.

Data sheet 7.7 I2S_ICD (offset 0x64, printed page 7-18, `hi3511v100--Hi3511-Datasheet.txt` line 27247).";

        field {
            name = "i2s_icd";
            desc = "SIO clock divider coefficient; the divide ratio is the value + 1.";
            sw = rw;
            hw = r;
            reset = 0x1;
        } i2s_icd[15:0];
    } I2S_ICD @ 0x64;

    reg {
        name = "SIO receive status register";
        desc = "SIO_RX_STA is the SIO receive status register: RX_FIFO fill levels (0-8) and overflow flags.

Data sheet 7.7 SIO_RX_STA (offset 0x68, printed page 7-19, `hi3511v100--Hi3511-Datasheet.txt` line 27276).";

        field {
            name = "rx_left_depth";
            desc = "Left channel RX_FIFO depth indicator (I2S mode).";
            sw = r;
            hw = w;
            reset = 0x0;
        } rx_left_depth[9:6];

        field {
            name = "rx_right_depth";
            desc = "Right channel RX_FIFO depth indicator (I2S mode) / PCM RX_FIFO depth indicator (PCM mode).";
            sw = r;
            hw = w;
            reset = 0x0;
        } rx_right_depth[5:2];

        field {
            name = "rx_left_fifo_over";
            desc = "Left channel RX_FIFO overflow indicator. 0: no overflow, 1: overflow.";
            sw = r;
            hw = w;
            reset = 0x0;
        } rx_left_fifo_over[1:1];

        field {
            name = "rx_right_fifo_over";
            desc = "Right channel / PCM RX_FIFO overflow indicator. 0: no overflow, 1: overflow.";
            sw = r;
            hw = w;
            reset = 0x0;
        } rx_right_fifo_over[0:0];
    } SIO_RX_STA @ 0x68;

    reg {
        name = "SIO transmit status register";
        desc = "SIO_TX_STA is the SIO transmit status register: TX_FIFO fill levels (0-8) and overflow flags.

Data sheet 7.7 SIO_TX_STA (offset 0x6C, printed page 7-19, `hi3511v100--Hi3511-Datasheet.txt` line 27314).";

        field {
            name = "tx_left_depth";
            desc = "Left channel TX_FIFO depth indicator (I2S mode).";
            sw = r;
            hw = w;
            reset = 0x0;
        } tx_left_depth[9:6];

        field {
            name = "tx_right_depth";
            desc = "Right channel TX_FIFO depth indicator (I2S mode) / PCM TX_FIFO depth indicator (PCM mode).";
            sw = r;
            hw = w;
            reset = 0x0;
        } tx_right_depth[5:2];

        field {
            name = "tx_left_fifo_over";
            desc = "Left channel TX_FIFO overflow indicator. 0: no overflow, 1: overflow.";
            sw = r;
            hw = w;
            reset = 0x0;
        } tx_left_fifo_over[1:1];

        field {
            name = "tx_right_fifo_over";
            desc = "Right channel / PCM TX_FIFO overflow indicator. 0: no overflow, 1: overflow.";
            sw = r;
            hw = w;
            reset = 0x0;
        } tx_right_fifo_over[0:0];
    } SIO_TX_STA @ 0x6C;

    reg {
        name = "PCM control set register";
        desc = "PCM_CT_SET is the PCM control register in its set view: writing 1 to a bit sets it, writing 0 has no effect, reads return the control register. The same bits are cleared through PCM_CT_CLR (0x74, write-only). Same layout as I2S_CT_SET without rst_n (bit 15 reserved) and with the transmit clock edge select at bit 14; total reset value 0x0000_0000 (so tx_clk_sel/tx_ws_sel default to internal generation here, unlike the I2S register).

Data sheet 7.7 PCM_CT_SET (offset 0x70, printed page 7-20, `hi3511v100--Hi3511-Datasheet.txt` line 27362).";

        field {
            name = "reserved_b15";
            desc = "Reserved (read/write).";
            sw = rw;
            hw = r;
            onwrite = woset;
            reset = 0x0;
        } reserved_b15[15:15];

        enum PCM_CT_SET_edge_sel_enum {
            FALLING = 0 { name = "Falling"; desc = "Transmit on the falling clock edge."; };
            RISING = 1 { name = "Rising"; desc = "Transmit on the rising clock edge."; };
        };

        field {
            name = "edge_sel";
            desc = "Transmit clock edge select.";
            sw = rw;
            hw = r;
            onwrite = woset;
            encode = PCM_CT_SET_edge_sel_enum;
            reset = 0x0;
        } edge_sel[14:14];

        field {
            name = "rx_enable";
            desc = "Receive channel enable. 0: disabled, 1: enabled.";
            sw = rw;
            hw = r;
            onwrite = woset;
            reset = 0x0;
        } rx_enable[13:13];

        field {
            name = "tx_enable";
            desc = "Transmit channel enable. 0: disabled, 1: enabled.";
            sw = rw;
            hw = r;
            onwrite = woset;
            reset = 0x0;
        } tx_enable[12:12];

        field {
            name = "rx_fifo_disable";
            desc = "RX_FIFO disable. 0: FIFO enabled, 1: FIFO disabled.";
            sw = rw;
            hw = r;
            onwrite = woset;
            reset = 0x0;
        } rx_fifo_disable[11:11];

        field {
            name = "tx_fifo_disable";
            desc = "TX_FIFO disable. 0: FIFO enabled, 1: FIFO disabled.";
            sw = rw;
            hw = r;
            onwrite = woset;
            reset = 0x0;
        } tx_fifo_disable[10:10];

        field {
            name = "rx_fifo_threshold";
            desc = "RX_FIFO threshold: when rx_right_depth >= rx_fifo_threshold + 1 the receive interrupt and DMA request are raised.";
            sw = rw;
            hw = r;
            onwrite = woset;
            reset = 0x0;
        } rx_fifo_threshold[9:7];

        field {
            name = "tx_fifo_threshold";
            desc = "TX_FIFO threshold: when tx_right_depth < tx_fifo_threshold + 1 the transmit interrupt and DMA request are raised.";
            sw = rw;
            hw = r;
            onwrite = woset;
            reset = 0x0;
        } tx_fifo_threshold[6:4];

        enum PCM_CT_SET_clk_sel_enum {
            INTERNAL = 0 { name = "Internal"; desc = "Generated inside the SIO."; };
            EXTERNAL = 1 { name = "External"; desc = "External input (the CRG cannot generate a PCM frame sync; the codec should be the master)."; };
        };

        field {
            name = "tx_clk_sel";
            desc = "Transmit bit clock source select.";
            sw = rw;
            hw = r;
            onwrite = woset;
            encode = PCM_CT_SET_clk_sel_enum;
            reset = 0x0;
        } tx_clk_sel[3:3];

        field {
            name = "tx_ws_sel";
            desc = "Transmit frame sync source select.";
            sw = rw;
            hw = r;
            onwrite = woset;
            encode = PCM_CT_SET_clk_sel_enum;
            reset = 0x0;
        } tx_ws_sel[2:2];
    } PCM_CT_SET @ 0x70;

    reg {
        name = "PCM control clear register";
        desc = "PCM_CT_CLR is the clear view of the PCM control register: writing 1 to a bit clears the control bit of the same position in PCM_CT_SET, writing 0 has no effect; write-only.

Data sheet 7.7 PCM_CT_CLR (offset 0x74, printed page 7-21, `hi3511v100--Hi3511-Datasheet.txt` line 27452).";

        field { name = "reserved_b15"; desc = "Reserved (write-only)."; sw = w; hw = r; onwrite = woclr; } reserved_b15[15:15];
        field { name = "edge_sel"; desc = "Write 1 to clear edge_sel (transmit on the falling edge)."; sw = w; hw = r; onwrite = woclr; } edge_sel[14:14];
        field { name = "rx_enable"; desc = "Write 1 to disable the receive channel."; sw = w; hw = r; onwrite = woclr; } rx_enable[13:13];
        field { name = "tx_enable"; desc = "Write 1 to disable the transmit channel."; sw = w; hw = r; onwrite = woclr; } tx_enable[12:12];
        field { name = "rx_fifo_disable"; desc = "Write 1 to clear rx_fifo_disable (enable the RX_FIFO)."; sw = w; hw = r; onwrite = woclr; } rx_fifo_disable[11:11];
        field { name = "tx_fifo_disable"; desc = "Write 1 to clear tx_fifo_disable (enable the TX_FIFO)."; sw = w; hw = r; onwrite = woclr; } tx_fifo_disable[10:10];
        field { name = "rx_fifo_threshold"; desc = "Write 1 to clear the corresponding bits of rx_fifo_threshold."; sw = w; hw = r; onwrite = woclr; } rx_fifo_threshold[9:7];
        field { name = "tx_fifo_threshold"; desc = "Write 1 to clear the corresponding bits of tx_fifo_threshold."; sw = w; hw = r; onwrite = woclr; } tx_fifo_threshold[6:4];
        field { name = "tx_clk_sel"; desc = "Write 1 to clear tx_clk_sel (internal bit clock)."; sw = w; hw = r; onwrite = woclr; } tx_clk_sel[3:3];
        field { name = "tx_ws_sel"; desc = "Write 1 to clear tx_ws_sel (internal frame sync)."; sw = w; hw = r; onwrite = woclr; } tx_ws_sel[2:2];
    } PCM_CT_CLR @ 0x74;

    reg {
        name = "I2S/PCM data length configuration register";
        desc = "I2S_LENGTH_CF is the data width register for the I2S and PCM modes: two bits per direction and mode (the Hi3515 edition replaces it with the 3-bit SIO_DATA_WIDTH_SET). The data sheet names all four fields rx_mode/tx_mode; they are prefixed here with the mode. Total reset value 0 = 16 bits everywhere. The feature list also mentions an 8-bit I2S width that this register cannot select.

Data sheet 7.7 I2S_LENGTH_CF (offset 0x78, printed page 7-22, `hi3511v100--Hi3511-Datasheet.txt` line 27510).";

        enum I2S_LENGTH_CF_width_enum {
            W_16 = 0 { name = "16 Bits"; desc = "16 bits"; };
            W_20 = 1 { name = "20 Bits"; desc = "20 bits"; };
            W_24 = 2 { name = "24 Bits"; desc = "24 bits"; };
            W_32 = 3 { name = "32 Bits"; desc = "32 bits"; };
        };

        field {
            name = "pcm_rx_mode";
            desc = "PCM receive data length.";
            sw = rw;
            hw = r;
            encode = I2S_LENGTH_CF_width_enum;
            reset = 0x0;
        } pcm_rx_mode[7:6];

        field {
            name = "pcm_tx_mode";
            desc = "PCM transmit data length.";
            sw = rw;
            hw = r;
            encode = I2S_LENGTH_CF_width_enum;
            reset = 0x0;
        } pcm_tx_mode[5:4];

        field {
            name = "i2s_rx_mode";
            desc = "I2S receive data length.";
            sw = rw;
            hw = r;
            encode = I2S_LENGTH_CF_width_enum;
            reset = 0x0;
        } i2s_rx_mode[3:2];

        field {
            name = "i2s_tx_mode";
            desc = "I2S transmit data length.";
            sw = rw;
            hw = r;
            encode = I2S_LENGTH_CF_width_enum;
            reset = 0x0;
        } i2s_tx_mode[1:0];
    } I2S_LENGTH_CF @ 0x78;

    reg {
        name = "I2S left/right channel access start position register";
        desc = "SIO_I2S_START_POS controls whether the first access starts from the left or the right channel after the left/right data access address merging (SIO_I2S_POS_MERGE_EN) is enabled.

Data sheet 7.7 SIO_I2S_START_POS (offset 0x7C, printed page 7-23, `hi3511v100--Hi3511-Datasheet.txt` line 27568).";

        enum SIO_I2S_START_POS_pos_enum {
            LEFT = 0 { name = "Left"; desc = "Start the access from the left channel."; };
            RIGHT = 1 { name = "Right"; desc = "Start the access from the right channel."; };
        };

        field {
            name = "start_pos_write";
            desc = "Start channel when writing data into the TX_FIFO through SIO_I2S_DUAL_TX_CHN.";
            sw = rw;
            hw = r;
            encode = SIO_I2S_START_POS_pos_enum;
            reset = 0x0;
        } start_pos_write[1:1];

        field {
            name = "start_pos_read";
            desc = "Start channel when reading data from the RX_FIFO through SIO_I2S_DUAL_RX_CHN.";
            sw = rw;
            hw = r;
            encode = SIO_I2S_START_POS_pos_enum;
            reset = 0x0;
        } start_pos_read[0:0];
    } SIO_I2S_START_POS @ 0x7C;

    reg {
        name = "I2S left/right channel current position register";
        desc = "I2S_POS_FLAG is the current position status register of the I2S left and right channels: which channel the next merged access (SIO_I2S_DUAL_RX_CHN / SIO_I2S_DUAL_TX_CHN) will address.

Data sheet 7.7 I2S_POS_FLAG (offset 0x80, printed page 7-24, `hi3511v100--Hi3511-Datasheet.txt` line 27603).";

        enum I2S_POS_FLAG_pos_enum {
            LEFT = 0 { name = "Left"; desc = "The next access starts from the left channel."; };
            RIGHT = 1 { name = "Right"; desc = "The next access starts from the right channel."; };
        };

        field {
            name = "start_pos_write";
            desc = "Channel of the next write into the TX_FIFO.";
            sw = r;
            hw = w;
            encode = I2S_POS_FLAG_pos_enum;
            reset = 0x0;
        } start_pos_write[1:1];

        field {
            name = "start_pos_read";
            desc = "Channel of the next read from the RX_FIFO.";
            sw = r;
            hw = w;
            encode = I2S_POS_FLAG_pos_enum;
            reset = 0x0;
        } start_pos_read[0:0];
    } I2S_POS_FLAG @ 0x80;

    reg {
        name = "Upper-bit sign extend enable register";
        desc = "SIO_SIGNED_EXT enables sign extension of the received data (PCM and I2S modes, receive only): with a valid width of 8, 16, 18, 20 or 24 bits the invalid upper bits of the 32-bit word written into the RX_FIFO are filled with the MSB of the sample (e.g. 16 bits: data_rx[31:16] = data_rx[15] ? 0xFFFF : 0x0000).

Data sheet 7.7 SIO_SIGNED_EXT (offset 0x84, printed page 7-25, `hi3511v100--Hi3511-Datasheet.txt` line 27658).";

        field {
            name = "signed_ext_en";
            desc = "Upper-bit sign extend enable. 0: disabled, 1: enabled.";
            sw = rw;
            hw = r;
            reset = 0x0;
        } signed_ext_en[0:0];
    } SIO_SIGNED_EXT @ 0x84;

    reg {
        name = "I2S left/right channel access position merging enable register";
        desc = "SIO_I2S_POS_MERGE_EN enables the access position merging of the I2S left and right channels: when enabled, both channels are read through SIO_I2S_DUAL_RX_CHN and written through SIO_I2S_DUAL_TX_CHN (alternating channel, start channel from SIO_I2S_START_POS), so a DMA transfer needs a single address.

Data sheet 7.7 SIO_I2S_POS_MERGE_EN (offset 0x88, printed page 7-25, `hi3511v100--Hi3511-Datasheet.txt` line 27703).";

        field {
            name = "merge_en";
            desc = "Data access position merging enable of the I2S left and right channels. 0: disabled, 1: enabled.";
            sw = rw;
            hw = r;
            reset = 0x0;
        } merge_en[0:0];
    } SIO_I2S_POS_MERGE_EN @ 0x88;

    reg {
        name = "I2S merged data receive register";
        desc = "SIO_I2S_DUAL_RX_CHN is the data receive register used when the left/right access position merging (SIO_I2S_POS_MERGE_EN) is enabled: successive reads alternate between the left and the right RX_FIFO.

Data sheet 7.7 SIO_I2S_DUAL_RX_CHN (offset 0xA0, printed page 7-26, `hi3511v100--Hi3511-Datasheet.txt` line 27731).";

        field {
            name = "rx_data";
            desc = "Received data.";
            sw = r;
            hw = w;
            reset = 0x0;
        } rx_data[31:0];
    } SIO_I2S_DUAL_RX_CHN @ 0xA0;

    reg {
        name = "I2S merged data transmit register";
        desc = "SIO_I2S_DUAL_TX_CHN is the data transmit register used when the left/right access position merging (SIO_I2S_POS_MERGE_EN) is enabled: successive writes alternate between the left and the right TX_FIFO.

Data sheet 7.7 SIO_I2S_DUAL_TX_CHN (offset 0xC0, printed page 7-26, `hi3511v100--Hi3511-Datasheet.txt` line 27759).";

        field {
            name = "tx_data";
            desc = "Transmitted data.";
            sw = w;
            hw = r;
            reset = 0x0;
        } tx_data[31:0];
    } SIO_I2S_DUAL_TX_CHN @ 0xC0;
};

`endif
