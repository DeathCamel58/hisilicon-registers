`ifndef HISI_VDH_RDL
`define HISI_VDH_RDL

regfile eHISI_VDH {
    name = "HiSilicon VDH video decoder (UNVERIFIED, vendor-derived)";
    desc = "UNVERIFIED, vendor-derived: HiSilicon video decoder hardware (VDH), the H.264 slice-data decoder of the Hi3520D. Existence on the Hi3520D V100 die is doubtful (2026-11-11, English documents): the HiMPP reference Issue 14 Table 10-1 lists VDH only for Hi3531, Hi3521 and Hi3520A and gives the Hi3520D family the VEDU (plus JPEG decoder) as its decoding modules, and data sheet Issue 02 section 6.2.3 (Figure 6-2, pp. 6-3/6-4) says the VEDU hardware decodes the H.264 slice data; data sheet chapter 7.1 names a VDH but gives no register, base, interrupt or clock/reset bit. The window also reads 0 on the board after every known gate. Two instances exist in vendor code: VDH0 at 0x20630000 (data sheet memory map: 'reserved 64 KB') and VDH1 at 0x206A0000 (inside the data sheet's reserved 0x20680000-0x206AFFFF); each uses a 64 KB window. The data sheet (chapter 7.1) only describes the decoder as software VFMW running on the ARM (slice header and above) plus the hardware VDH (slice data and below, exchanging a message pool in DDR with VFMW) and has no register table, base address, interrupt or clock gate for it. Clock and reset (CORRECTED 2026-11-11): PERI_CRG20/21 (0x20030050/54), which the vendor driver writes (bit 1 clock, bit 0 reset), DO NOT EXIST on the Hi3520D (board read-back: read-only zero; inherited Hi3520A code, no-ops here). The real enable is UNKNOWN. Hypothesis 'PERI_CRG16 SED/VEDU releases the VDH' was REJECTED on the board 2026-11-11 (source: U-Boot register probes, confidence HIGH): with CRG16 = 0x0c03, 0x803 and 0x802 (the vendor script value, at which the VEDU window itself comes alive) the window 0x20630000..0x206300F0 reads all zero without a hang and STREAM_BASE_ADDR (0x18) does not latch a write; none of the 13 undocumented CRG registers latches a bit; reserved and gated windows also read zero without a bus error, so a zero read does not tell a gated block from an absent one. Second static pass (docs/vdh-enable-research2.md, 2026-11-11, confidence MEDIUM): the board's own stock firmware (Juan WNVR-20B-4, Hi3520D_MPP_V1.0.4.0) loads hi3520D_vdec/vfmw with only the documented CRG gates released and writes the same dead PERI_CRG20/21; no Hi3520D script has a DDRC port, outstanding or CRG entry for the VDH (the Hi3520A script has all three). Either the VDH is present and a boot state we do not reproduce is missing (PERI_CRG16 bits [9:4] set by the vendor VEDU init, other media gates, module-load order) or the die has no VDH; undecided, about 60 % present. VDH1 (0x206A0000) is dead vendor code (never mapped, never started: VdhId 0 only) and probably does not exist on the Hi3520D; the first sentence of this description about 'two instances' describes the code, not the silicon. The previous text was: 'Clock and reset: PERI_CRG20 at 0x20030050 (VDH0) / PERI_CRG21 at 0x20030054 (VDH1): bit 1 = clock enable, bit 0 = soft reset (1 = reset), both from the vendor driver (not in the data sheet).' Interrupt (second pass 2026-11-10, vendor code, confidence HIGH that none is requested): none of the three Hi3520D vfmw builds (XM NBD7804T-F, XM NBD7008T-PL, OpenIPC Hi3520D V200) calls request_threaded_irq for the VDH; the only IRQ they request is GIC ID 75 for the SCD. The handlers VCTRL_Isr_0/VCTRL_Isr_1 (-> VDMDRV_VdmIntServProc: CheckInt reads INT_STATE and tests bit 0, BackupInfo, ClearIntState writes 0xFFFFFFFF to INT_STATE, AfterDec) exist but are unreachable (not registered, not exported), and the busy-wait function VDMDRV_WaitVdmReadyIfNoIsr (polls VDH_STATE bit 17, 400 iterations) has no caller in this build; how the vendor driver notices the end of a decode is therefore NOT determined statically. The VDH GIC ID is unknown; neighbor chips that do register VDH handlers (Hi3535: IDs 67 and 72 for VDH0/VDH1, 78 for the SCD; Hi3536: 65, 66, 123 and 69 for the SCD) have a different interrupt map and give no usable number for the Hi3520D (data sheet reserved IDs: 48, 49, 51, 58, 59, 78, 88, 90-95; 75 is the SCD). INT_MASK/INT_STATE bit 0 is the vendor's completion interrupt bit. A driver can poll VDH_STATE bit 17 and look for the IRQ with the GIC pending registers. Previously: 'No interrupt is registered by the vendor driver (it polls VDH_STATE bit 17); the GIC ID is unknown.' (the 'polls' part is wrong for this build: the poll function exists but is never called). Source for the statement: vendor module hi3520D_vfmw.ko (OpenDrivers, CloseDrivers, VCTRL_Isr_0, VDMDRV_WaitVdmReadyIfNoIsr, VDMDRV_CheckDevice), neighbor modules hi3535_vfmw.ko and hi3536_vfmw.ko (OpenDrivers), word-checked: yes. Not verified on hardware.

Slice message layout (second pass): the Hi3520D H264HAL_V200R001_SetSliceMsg was word-checked and matches the V400R004 layout for words 0-5 (two stream segments: byte offset from STREAM_BASE_ADDR & ~0xF, bit offset & 0x7F, valid bit length), D4 (word 6: slice_qp << 26 | (cabac_init_idc & 3) << 24 | first_mb[19:0]), D5 (word 7: num_ref_idx_l1_active-1 << 21 | num_ref_idx_l0_active-1 << 16 | direct_spatial << 15 | direct_8x8_inference << 14 | list1 size << 8 | list0 size << 2 | slice type), D8 (word 10: weight flag << 16 | chroma_qp_index_offset << 5 | second_chroma_qp_index_offset), D9 (word 11: alpha_c0_offset_div2 << 16 | beta_offset_div2 << 8 | disable_deblocking_filter_idc), the reference-list words 12-13 / 16-17 (4 bits per entry: long-term flag << 3 | structure) and 20-23 / 28-31 (5 bits per entry: picture index << 1), the apc-to-ref-index words 36-43 (5 bits x 32), the optional weight tables at +256/+512/+768 bytes and word 63 (next slice message address & ~0xF, 0 terminates the chain). Correction: the Hi3520D code does NOT write word 44 (last macroblock of the slice, written by V400R004); previously this block said D44 = last macroblock. Confidence HIGH, word-checked: yes, not verified on hardware.

Certainty convention in this file: every register states its source (data sheet / vendor module / GPL V400R004), confidence and whether it was word-checked against the Hi3520D disassembly; none of it was ever read or written on the board. Capabilities (data sheet 7.1.2): H.264 Baseline/Main/High @ L4.2, CABAC/CAVLC, 8x8 transform, deblocking, I_PCM, 80x64 to 1920x2048; NO B slices, NO field/MBAFF, NO weighted prediction, NO ASO/FMO. No firmware/microcode is loaded (the vendor VFMW is plain ARM code; the CABAC init table is built by software into a DDR buffer). Registers listed are only those the Hi3520D vendor module touches (offsets and values read from its machine code); names/bit layouts come from the GPL Huawei VDH V400R004 header where the same offset is used. Message formats (picture message D0..D59 + scaling matrices, slice messages with stream byte/bit offsets, reference lists, next-slice pointer) are in docs/rdl-campaign/vdh-scd.md. Probe first: VDH_STATE (0x1C), EMAR_ID (0x30) with the SED/VEDU reset released (PERI_CRG16 = 0x803 / 0x802, see docs/vdh-enable-research.md S2/S3); register offsets and layouts below are vendor-derived and UNVERIFIED, none of them could be read on the board yet.";

    reg {
        name = "Decode start";
        desc = "The vendor code pulses the register 0, 1, 0 (VDMHAL_V200R001_StartHwDecode) after all other registers and the message memory are written; writing 1 starts the decode of one slice batch (one frame in the vendor driver).

Sequence: BASIC_CFG0 |= 0x300000 (bits 21:20), then write 0, 1, 0 to this register. Name: V400R004.

Source: vendor module hi3520D_vfmw.ko (VDMHAL_V200R001_StartHwDecode, last step of H264HAL_V200R001_StartDec/VDMDRV_StartDec), confidence HIGH, word-checked against the Hi3520D disassembly: yes. Name and field layout: vendor-derived from the GPL Huawei VDH V400R004 header (vdm_hal_local.h, a later generation), inferred, confidence LOW. Not verified on hardware (nothing in this block has been read or written on the board); no reset value is known; not in the data sheet. Details: docs/rdl-campaign/vdh-scd.md.";

        field {
            name = "dec_start";
            desc = "Pulse 0 -> 1 -> 0 to start decoding (name from V400R004 `VDH_START.dec_start`).";
            sw = rw;
            hw = r;
        } dec_start[0:0];

    } VDH_START @ 0x0;

    reg {
        name = "Repair (error concealment copy) start";
        desc = "Pulsed 0, 1, 0 by VDMHAL_V200R001_StartHwRepair; starts the hardware repair copy described by the repair message (CfgRpMsg/CfgRpReg).

Write 0, 1, 0. Only used for the hardware error-repair pass (VDMDRV_StartRepair); a minimal decoder does not need it.

Source: vendor module hi3520D_vfmw.ko (VDMHAL_V200R001_StartHwRepair), confidence HIGH, word-checked against the Hi3520D disassembly: yes. Name and field layout: vendor-derived from the GPL Huawei VDH V400R004 header (vdm_hal_local.h, a later generation), inferred, confidence LOW. Not verified on hardware (nothing in this block has been read or written on the board); no reset value is known; not in the data sheet. Details: docs/rdl-campaign/vdh-scd.md.";

        field {
            name = "repair_start";
            desc = "Pulse 0 -> 1 -> 0 to start the repair job (V400R004 `VDH_REPAIR.repair_start`).";
            sw = rw;
            hw = r;
        } repair_start[0:0];

    } VDH_REPAIR @ 0x4;

    reg {
        name = "Basic configuration 0";
        desc = "H.264 path of the vendor code: mbamt_to_dec = (macroblocks to decode - 1), clamped to 0x16AFF; bit 30 always 1; bit 31 always 0; StartHwDecode additionally ORs 0x300000 (bits 20/21) just before the start pulse. Bit names are the V400R004 names (H.264 sets load_qmatrix_flag = 1 there, which is bit 30 of that layout): UNVERIFIED for this revision.

Values: [19:0] = macroblocks - 1 with clamp 0x16AFF (= 352 x 264 MBs - 1; StartDec rejects width > 352 MBs or height > 264 MBs); bit 30 = 1, bit 31 = 0; bits 21:20 set by StartHwDecode.

Source: vendor module hi3520D_vfmw.ko (H264HAL_V200R001_StartDec, VDMHAL_V200R001_StartHwDecode), confidence HIGH for the values written, LOW for the field names, word-checked against the Hi3520D disassembly: yes. Name and field layout: vendor-derived from the GPL Huawei VDH V400R004 header (vdm_hal_local.h, a later generation), inferred, confidence LOW. Not verified on hardware (nothing in this block has been read or written on the board); no reset value is known; not in the data sheet. Details: docs/rdl-campaign/vdh-scd.md.";

        field {
            name = "mbamt_to_dec";
            desc = "Number of macroblocks to decode minus 1 (picture MBs; max 0x16AFF in the vendor clamp).";
            sw = rw;
            hw = r;
        } mbamt_to_dec[19:0];

        field {
            name = "memory_clock_gating_en";
            desc = "Set by StartHwDecode (V400R004 name).";
            sw = rw;
            hw = r;
        } memory_clock_gating_en[20:20];

        field {
            name = "module_clock_gating_en";
            desc = "Set by StartHwDecode (V400R004 name).";
            sw = rw;
            hw = r;
        } module_clock_gating_en[21:21];

        field {
            name = "load_qmatrix_flag";
            desc = "Written 1 by the H.264 path (V400R004 name; the picture message carries the scaling matrices).";
            sw = rw;
            hw = r;
        } load_qmatrix_flag[30:30];

        field {
            name = "sec_mode_en";
            desc = "Written 0 (V400R004 name: secure mode).";
            sw = rw;
            hw = r;
        } sec_mode_en[31:31];

    } BASIC_CFG0 @ 0x8;

    reg {
        name = "Basic configuration 1";
        desc = "H.264 path of the vendor code: video_standard 0 (the MPEG-4 path passes 2), ddr_stride = frame stride in bytes / 64 (the vendor code masks (stride >> 2) with 0x3FF0, i.e. a 10-bit field here; V400R004 has 9 bits plus a uv_order bit), fst_slc_grp = new-picture flag, mv_output_en = 0, max_slcgrp_num = 1, vdh_2d_en = 1, ppfd_en = 1 (top nibble 0xA). Field boundaries beyond bit 13 are the V400R004 layout (UNVERIFIED).

Source: vendor module hi3520D_vfmw.ko (H264HAL_V200R001_StartDec), confidence MEDIUM (composition read from the instructions: bit 14 insert, bit 15 clear, 12-bit field at [27:16], top nibble 0xA), word-checked against the Hi3520D disassembly: yes. Name and field layout: vendor-derived from the GPL Huawei VDH V400R004 header (vdm_hal_local.h, a later generation), inferred, confidence LOW. Not verified on hardware (nothing in this block has been read or written on the board); no reset value is known; not in the data sheet. Details: docs/rdl-campaign/vdh-scd.md.";

        field {
            name = "video_standard";
            desc = "0 = H.264, 2 = MPEG-4 (values the vendor code writes; others unknown).";
            sw = rw;
            hw = r;
        } video_standard[3:0];

        field {
            name = "ddr_stride";
            desc = "Frame stride in units of 64 bytes (Y and chroma share the stride).";
            sw = rw;
            hw = r;
        } ddr_stride[13:4];

        field {
            name = "fst_slc_grp";
            desc = "First slice group of a new picture (new-picture flag).";
            sw = rw;
            hw = r;
        } fst_slc_grp[14:14];

        field {
            name = "mv_output_en";
            desc = "Motion vector (PMV) output enable; written 0 by the Hi3520D H.264 path, set to nal_ref_idc != 0 in V400R004.";
            sw = rw;
            hw = r;
        } mv_output_en[15:15];

        field {
            name = "max_slcgrp_num";
            desc = "Maximum slice groups per batch (1 on Hi3520D, 2 in V400R004).";
            sw = rw;
            hw = r;
        } max_slcgrp_num[27:16];

        field {
            name = "line_num_output_en";
            desc = "Line-number output (low delay), V400R004 name; written 0.";
            sw = rw;
            hw = r;
        } line_num_output_en[28:28];

        field {
            name = "vdh_2d_en";
            desc = "2D (tiled) output enable (V400R004 name); written 1.";
            sw = rw;
            hw = r;
        } vdh_2d_en[29:29];

        field {
            name = "compress_en";
            desc = "Frame compression enable (V400R004 name); written 0.";
            sw = rw;
            hw = r;
        } compress_en[30:30];

        field {
            name = "ppfd_en";
            desc = "PPFD (pre-parse FIFO/bitstream fetch) enable; written 1 on Hi3520D.";
            sw = rw;
            hw = r;
        } ppfd_en[31:31];

    } BASIC_CFG1 @ 0xC;

    reg {
        name = "ARM-to-VDH message address (down message)";
        desc = "Physical address of the message slot the VDH reads: the picture message followed by the slice message chain (vendor: DN message slot, 16-byte aligned, DDR).

Down message = picture message (slot DN_MSG_SLOT_INDEX) followed by the slice message chain; physical address & ~0xF.

Source: vendor module hi3520D_vfmw.ko (H264HAL_V200R001_StartDec (str to offset 0x10)), confidence HIGH, word-checked against the Hi3520D disassembly: yes. Name and field layout: vendor-derived from the GPL Huawei VDH V400R004 header (vdm_hal_local.h, a later generation), inferred, confidence LOW. Not verified on hardware (nothing in this block has been read or written on the board); no reset value is known; not in the data sheet. Details: docs/rdl-campaign/vdh-scd.md.";

        field {
            name = "av_msg_addr";
            desc = "Physical DDR address & ~0xF.";
            sw = rw;
            hw = r;
        } av_msg_addr[31:0];

    } AVM_ADDR @ 0x10;

    reg {
        name = "VDH-to-ARM message address (up message)";
        desc = "Physical address of the message slot the VDH writes back (decode report; vendor: UP message slot, 16-byte aligned).

Up message: 4 words per decoded slice, written by the VDH: word 1 = first macroblock, word 2 = last macroblock of the slice (low 16 bits in the Hi3520D reader; 20 bits in V400R004). Number of entries = VDH_STATE[16:0] (VDMHAL_V200R001_MakeDecReport, word-checked).

Source: vendor module hi3520D_vfmw.ko (H264HAL_V200R001_StartDec (str to offset 0x14)), confidence HIGH, word-checked against the Hi3520D disassembly: yes. Name and field layout: vendor-derived from the GPL Huawei VDH V400R004 header (vdm_hal_local.h, a later generation), inferred, confidence LOW. Not verified on hardware (nothing in this block has been read or written on the board); no reset value is known; not in the data sheet. Details: docs/rdl-campaign/vdh-scd.md.";

        field {
            name = "va_msg_addr";
            desc = "Physical DDR address & ~0xF.";
            sw = rw;
            hw = r;
        } va_msg_addr[31:0];

    } VAM_ADDR @ 0x14;

    reg {
        name = "Stream buffer base address";
        desc = "Physical base of the bitstream buffer; slice messages give each slice as an offset from this base plus bit offset and bit length.

Slice-message segment offsets are relative to this address aligned down to 16 bytes.

Source: vendor module hi3520D_vfmw.ko (H264HAL_V200R001_StartDec (str to offset 0x18); also VDMHAL_V200R001_CfgRpReg), confidence HIGH, word-checked against the Hi3520D disassembly: yes. Name and field layout: vendor-derived from the GPL Huawei VDH V400R004 header (vdm_hal_local.h, a later generation), inferred, confidence LOW. Not verified on hardware (nothing in this block has been read or written on the board); no reset value is known; not in the data sheet. Details: docs/rdl-campaign/vdh-scd.md.";

        field {
            name = "stream_base_addr";
            desc = "Physical DDR address & ~0xF.";
            sw = rw;
            hw = r;
        } stream_base_addr[31:0];

    } STREAM_BASE_ADDR @ 0x18;

    reg {
        name = "VDH state";
        desc = "Polled by the vendor driver: bit 17 = decode over (VDMHAL_V200R001_IsVdmReady), ResetVdm waits for bit 20 to read 0 after asserting the soft reset (up to 10000 reads), BackupInfo reads the whole register. In V400R004 bits [16:0] are the decoded slice count and bits [26:19] a version id (UNVERIFIED here; the version id would help to identify the revision).

Bit 17 = decode over (ubfx #17,#1 in IsVdmReady). MakeDecReport: bits [18:17] == 0b01 means success, anything else is an error report; bits [16:0] = number of decoded slices (clamped to 128, then used as the up-message entry count). Bit 20 is polled by ResetVdm (up to 10000 reads) until it reads 0.

Source: vendor module hi3520D_vfmw.ko (VDMHAL_V200R001_IsVdmReady, ResetVdm, BackupInfo, MakeDecReport), confidence HIGH for bit 17, bit 20 and [18:17], MEDIUM for [16:0], word-checked against the Hi3520D disassembly: yes. Name and field layout: vendor-derived from the GPL Huawei VDH V400R004 header (vdm_hal_local.h, a later generation), inferred, confidence LOW. Not verified on hardware (nothing in this block has been read or written on the board); no reset value is known; not in the data sheet. Details: docs/rdl-campaign/vdh-scd.md.";

        field {
            name = "decoded_slice_num";
            desc = "Decoded slice count (V400R004 name).";
            sw = r;
            hw = w;
        } decoded_slice_num[16:0];

        field {
            name = "dec_over";
            desc = "Decode over: bit tested by VDMHAL_V200R001_IsVdmReady (previously: 'polled by vendor code; there is no VDH interrupt registered'; the poll function is never called in the shipped builds, see the block description). Vendor-observed, confidence HIGH, not verified on hardware.";
            sw = r;
            hw = w;
        } dec_over[17:17];

        field {
            name = "dec_err";
            desc = "Decode error (V400R004 name).";
            sw = r;
            hw = w;
        } dec_err[18:18];

    } VDH_STATE @ 0x1C;

    reg {
        name = "Interrupt state";
        desc = "ClearIntState writes 0xFFFFFFFF; CheckInt reads it. Whether the bits are write-1-to-clear is not confirmed.

The never-registered ISR (VCTRL_Isr_0 -> VDMDRV_VdmIntServProc) tests bit 0 of the value returned by CheckInt, then BackupInfo, ClearInt, AfterDec.

Source: vendor module hi3520D_vfmw.ko (VDMHAL_V200R001_CheckInt (read), ClearIntState (write 0xFFFFFFFF)), confidence HIGH for the accesses, LOW for polarity and write-1-to-clear, word-checked against the Hi3520D disassembly: yes. Name and field layout: vendor-derived from the GPL Huawei VDH V400R004 header (vdm_hal_local.h, a later generation), inferred, confidence LOW. Not verified on hardware (nothing in this block has been read or written on the board); no reset value is known; not in the data sheet. Details: docs/rdl-campaign/vdh-scd.md.";

        field {
            name = "dec_over";
            desc = "Decode over interrupt state (V400R004 name).";
            sw = rw;
            hw = r;
        } dec_over[0:0];

        field {
            name = "dec_err";
            desc = "Decode error interrupt state (V400R004 name).";
            sw = rw;
            hw = r;
        } dec_err[1:1];

    } INT_STATE @ 0x20;

    reg {
        name = "Interrupt mask";
        desc = "EnableInt writes 0xFFFFFFFE (bit 0 = 0 enables the decode-over interrupt, everything else masked), MaskInt writes 0xFFFFFFFF; ResetVdm saves and restores it. Polarity 0 = enabled is inferred from those two values.

VCTRL_RunProcess masks (MaskInt) and re-enables (EnableInt) around its processing loop.

Source: vendor module hi3520D_vfmw.ko (VDMHAL_V200R001_EnableInt (0xFFFFFFFE), MaskInt (0xFFFFFFFF), ResetVdm (save/restore)), confidence HIGH, word-checked against the Hi3520D disassembly: yes. Name and field layout: vendor-derived from the GPL Huawei VDH V400R004 header (vdm_hal_local.h, a later generation), inferred, confidence LOW. Not verified on hardware (nothing in this block has been read or written on the board); no reset value is known; not in the data sheet. Details: docs/rdl-campaign/vdh-scd.md.";

        field {
            name = "dec_over";
            desc = "0 = decode-over interrupt enabled (inferred).";
            sw = rw;
            hw = r;
        } dec_over[0:0];

        field {
            name = "dec_err";
            desc = "0 = decode-error interrupt enabled (inferred).";
            sw = rw;
            hw = r;
        } dec_err[1:1];

    } INT_MASK @ 0x24;

    reg {
        name = "VCTRL state";
        desc = "VDMHAL_V200R001_IsVdmRun reports 'running' when the value is not 1, i.e. 1 means idle.

Value 1 = not running; any other value = running.

Source: vendor module hi3520D_vfmw.ko (VDMHAL_V200R001_IsVdmRun), confidence HIGH for the access, MEDIUM for the meaning (the GPL V400R004 IsVdmRun has the identical test), word-checked against the Hi3520D disassembly: yes. Name and field layout: vendor-derived from the GPL Huawei VDH V400R004 header (vdm_hal_local.h, a later generation), inferred, confidence LOW. Not verified on hardware (nothing in this block has been read or written on the board); no reset value is known; not in the data sheet. Details: docs/rdl-campaign/vdh-scd.md.";

        field {
            name = "state";
            desc = "1 = idle (inferred from IsVdmRun).";
            sw = rw;
            hw = r;
        } state[31:0];

    } VCTRL_STATE @ 0x28;

    reg {
        name = "EMAR ID / on-chip RAM selection";
        desc = "H.264 path writes 0x00013300 for pictures up to 120 macroblocks wide and 0x00003300 for wider ones (V400R004 default 0x161F7; its header comment says 0x0001xxxx = all RAM on chip). The vendor repair path writes 0x3300. Meaning of the fields unknown.

0x13300 when the picture is <= 120 MBs wide (cmp #120), else 0x3300.

Source: vendor module hi3520D_vfmw.ko (H264HAL_V200R001_StartDec (str to offset 0x30)), confidence HIGH, word-checked against the Hi3520D disassembly: yes. Name and field layout: vendor-derived from the GPL Huawei VDH V400R004 header (vdm_hal_local.h, a later generation), inferred, confidence LOW. Not verified on hardware (nothing in this block has been read or written on the board); no reset value is known; not in the data sheet. Details: docs/rdl-campaign/vdh-scd.md.";

        field {
            name = "emar_id";
            desc = "Written values 0x13300 / 0x3300 (vendor).";
            sw = rw;
            hw = r;
        } emar_id[31:0];

    } EMAR_ID @ 0x30;

    reg {
        name = "SED timeout";
        desc = "Written 0x00300C03 for all seven timeout registers 0x3C-0x54.

Seven registers written back to back with the same constant; neighbors: 0x3C-0x54.

Source: vendor module hi3520D_vfmw.ko (H264HAL_V200R001_StartDec (str to offsets 0x3C-0x54; same value also in VDMHAL_V200R001_CfgRpReg)), confidence HIGH for the value 0x00300C03 (movw 3075 / movt 48), LOW for the meaning (a per-unit timeout counter), word-checked against the Hi3520D disassembly: yes. Name and field layout: vendor-derived from the GPL Huawei VDH V400R004 header (vdm_hal_local.h, a later generation), inferred, confidence LOW. Not verified on hardware (nothing in this block has been read or written on the board); no reset value is known; not in the data sheet. Details: docs/rdl-campaign/vdh-scd.md.";

        field {
            name = "timeout";
            desc = "Vendor value 0x00300C03.";
            sw = rw;
            hw = r;
        } timeout[31:0];

    } SED_TO @ 0x3C;

    reg {
        name = "ITRANS timeout";
        desc = "See SED_TO.

Seven registers written back to back with the same constant; neighbors: 0x3C-0x54.

Source: vendor module hi3520D_vfmw.ko (H264HAL_V200R001_StartDec (str to offsets 0x3C-0x54; same value also in VDMHAL_V200R001_CfgRpReg)), confidence HIGH for the value 0x00300C03 (movw 3075 / movt 48), LOW for the meaning (a per-unit timeout counter), word-checked against the Hi3520D disassembly: yes. Name and field layout: vendor-derived from the GPL Huawei VDH V400R004 header (vdm_hal_local.h, a later generation), inferred, confidence LOW. Not verified on hardware (nothing in this block has been read or written on the board); no reset value is known; not in the data sheet. Details: docs/rdl-campaign/vdh-scd.md.";

        field {
            name = "timeout";
            desc = "Vendor value 0x00300C03.";
            sw = rw;
            hw = r;
        } timeout[31:0];

    } ITRANS_TO @ 0x40;

    reg {
        name = "PMV timeout";
        desc = "See SED_TO.

Seven registers written back to back with the same constant; neighbors: 0x3C-0x54.

Source: vendor module hi3520D_vfmw.ko (H264HAL_V200R001_StartDec (str to offsets 0x3C-0x54; same value also in VDMHAL_V200R001_CfgRpReg)), confidence HIGH for the value 0x00300C03 (movw 3075 / movt 48), LOW for the meaning (a per-unit timeout counter), word-checked against the Hi3520D disassembly: yes. Name and field layout: vendor-derived from the GPL Huawei VDH V400R004 header (vdm_hal_local.h, a later generation), inferred, confidence LOW. Not verified on hardware (nothing in this block has been read or written on the board); no reset value is known; not in the data sheet. Details: docs/rdl-campaign/vdh-scd.md.";

        field {
            name = "timeout";
            desc = "Vendor value 0x00300C03.";
            sw = rw;
            hw = r;
        } timeout[31:0];

    } PMV_TO @ 0x44;

    reg {
        name = "PRC timeout";
        desc = "See SED_TO.

Seven registers written back to back with the same constant; neighbors: 0x3C-0x54.

Source: vendor module hi3520D_vfmw.ko (H264HAL_V200R001_StartDec (str to offsets 0x3C-0x54; same value also in VDMHAL_V200R001_CfgRpReg)), confidence HIGH for the value 0x00300C03 (movw 3075 / movt 48), LOW for the meaning (a per-unit timeout counter), word-checked against the Hi3520D disassembly: yes. Name and field layout: vendor-derived from the GPL Huawei VDH V400R004 header (vdm_hal_local.h, a later generation), inferred, confidence LOW. Not verified on hardware (nothing in this block has been read or written on the board); no reset value is known; not in the data sheet. Details: docs/rdl-campaign/vdh-scd.md.";

        field {
            name = "timeout";
            desc = "Vendor value 0x00300C03.";
            sw = rw;
            hw = r;
        } timeout[31:0];

    } PRC_TO @ 0x48;

    reg {
        name = "RCN timeout";
        desc = "See SED_TO.

Seven registers written back to back with the same constant; neighbors: 0x3C-0x54.

Source: vendor module hi3520D_vfmw.ko (H264HAL_V200R001_StartDec (str to offsets 0x3C-0x54; same value also in VDMHAL_V200R001_CfgRpReg)), confidence HIGH for the value 0x00300C03 (movw 3075 / movt 48), LOW for the meaning (a per-unit timeout counter), word-checked against the Hi3520D disassembly: yes. Name and field layout: vendor-derived from the GPL Huawei VDH V400R004 header (vdm_hal_local.h, a later generation), inferred, confidence LOW. Not verified on hardware (nothing in this block has been read or written on the board); no reset value is known; not in the data sheet. Details: docs/rdl-campaign/vdh-scd.md.";

        field {
            name = "timeout";
            desc = "Vendor value 0x00300C03.";
            sw = rw;
            hw = r;
        } timeout[31:0];

    } RCN_TO @ 0x4C;

    reg {
        name = "DBLK timeout";
        desc = "See SED_TO.

Seven registers written back to back with the same constant; neighbors: 0x3C-0x54.

Source: vendor module hi3520D_vfmw.ko (H264HAL_V200R001_StartDec (str to offsets 0x3C-0x54; same value also in VDMHAL_V200R001_CfgRpReg)), confidence HIGH for the value 0x00300C03 (movw 3075 / movt 48), LOW for the meaning (a per-unit timeout counter), word-checked against the Hi3520D disassembly: yes. Name and field layout: vendor-derived from the GPL Huawei VDH V400R004 header (vdm_hal_local.h, a later generation), inferred, confidence LOW. Not verified on hardware (nothing in this block has been read or written on the board); no reset value is known; not in the data sheet. Details: docs/rdl-campaign/vdh-scd.md.";

        field {
            name = "timeout";
            desc = "Vendor value 0x00300C03.";
            sw = rw;
            hw = r;
        } timeout[31:0];

    } DBLK_TO @ 0x50;

    reg {
        name = "PPFD timeout";
        desc = "See SED_TO.

Seven registers written back to back with the same constant; neighbors: 0x3C-0x54.

Source: vendor module hi3520D_vfmw.ko (H264HAL_V200R001_StartDec (str to offsets 0x3C-0x54; same value also in VDMHAL_V200R001_CfgRpReg)), confidence HIGH for the value 0x00300C03 (movw 3075 / movt 48), LOW for the meaning (a per-unit timeout counter), word-checked against the Hi3520D disassembly: yes. Name and field layout: vendor-derived from the GPL Huawei VDH V400R004 header (vdm_hal_local.h, a later generation), inferred, confidence LOW. Not verified on hardware (nothing in this block has been read or written on the board); no reset value is known; not in the data sheet. Details: docs/rdl-campaign/vdh-scd.md.";

        field {
            name = "timeout";
            desc = "Vendor value 0x00300C03.";
            sw = rw;
            hw = r;
        } timeout[31:0];

    } PPFD_TO @ 0x54;

    reg {
        name = "1D (linear) luma output address";
        desc = "Physical address of the linear (raster) luma plane of the picture being decoded, 256-byte aligned in the vendor code (& ~0xFF); the same buffers are the reference pictures listed in the picture message.

Source: vendor module hi3520D_vfmw.ko (VDMHAL_V200R001_CfgRpReg / H264HAL_V200R001_StartDec (str to offset 0x60)), confidence MEDIUM, word-checked against the Hi3520D disassembly: yes. Name and field layout: vendor-derived from the GPL Huawei VDH V400R004 header (vdm_hal_local.h, a later generation), inferred, confidence LOW. Not verified on hardware (nothing in this block has been read or written on the board); no reset value is known; not in the data sheet. Details: docs/rdl-campaign/vdh-scd.md.";

        field {
            name = "ystaddr_1d";
            desc = "Physical DDR address & ~0xFF.";
            sw = rw;
            hw = r;
        } ystaddr_1d[31:0];

    } YSTADDR_1D @ 0x60;

    reg {
        name = "1D output stride";
        desc = "Frame stride in bytes / 16.

Source: vendor module hi3520D_vfmw.ko (H264HAL_V200R001_StartDec (str to offset 0x64)), confidence MEDIUM, word-checked against the Hi3520D disassembly: yes. Name and field layout: vendor-derived from the GPL Huawei VDH V400R004 header (vdm_hal_local.h, a later generation), inferred, confidence LOW. Not verified on hardware (nothing in this block has been read or written on the board); no reset value is known; not in the data sheet. Details: docs/rdl-campaign/vdh-scd.md.";

        field {
            name = "ystride_1d";
            desc = "Stride in bytes >> 4.";
            sw = rw;
            hw = r;
        } ystride_1d[31:0];

    } YSTRIDE_1D @ 0x64;

    reg {
        name = "1D chroma offset";
        desc = "Byte offset of the interleaved chroma plane from the luma base: stride x picture height rounded to 16 lines (semi-planar layout).

Source: vendor module hi3520D_vfmw.ko (H264HAL_V200R001_StartDec (str to offset 0x68)), confidence MEDIUM, word-checked against the Hi3520D disassembly: yes. Name and field layout: vendor-derived from the GPL Huawei VDH V400R004 header (vdm_hal_local.h, a later generation), inferred, confidence LOW. Not verified on hardware (nothing in this block has been read or written on the board); no reset value is known; not in the data sheet. Details: docs/rdl-campaign/vdh-scd.md.";

        field {
            name = "uvoffset_1d";
            desc = "Chroma plane offset in bytes.";
            sw = rw;
            hw = r;
        } uvoffset_1d[31:0];

    } UVOFFSET_1D @ 0x68;

    reg {
        name = "Head information offset / PRC count";
        desc = "Written 0x18 by the H.264 path (V400R004 writes 0 and names it HEAD_INF_OFFSET / PRCNUM_1D_CNT).

Source: vendor module hi3520D_vfmw.ko (H264HAL_V200R001_StartDec (str to offset 0x6C)), confidence HIGH for the value 0x18, LOW for the meaning, word-checked against the Hi3520D disassembly: yes. Name and field layout: vendor-derived from the GPL Huawei VDH V400R004 header (vdm_hal_local.h, a later generation), inferred, confidence LOW. Not verified on hardware (nothing in this block has been read or written on the board); no reset value is known; not in the data sheet. Details: docs/rdl-campaign/vdh-scd.md.";

        field {
            name = "value";
            desc = "Vendor value 0x18.";
            sw = rw;
            hw = r;
        } value[31:0];

    } HEAD_INF_OFFSET @ 0x6C;

    reg {
        name = "PRC memory 1 count (constant)";
        desc = "Written the constant 0x7F3CFC3C on every decode (V400R004 names the offset PRCMEM1_1D_CNT / LINE_NUM_STADDR).

Unexplained constant; written together with 0x74.

Source: vendor module hi3520D_vfmw.ko (H264HAL_V200R001_StartDec (str to offset 0x70)), confidence HIGH for the value 0x7F3CFC3C (movw 64572 / movt 32572), LOW for the meaning, word-checked against the Hi3520D disassembly: yes. Name and field layout: vendor-derived from the GPL Huawei VDH V400R004 header (vdm_hal_local.h, a later generation), inferred, confidence LOW. Not verified on hardware (nothing in this block has been read or written on the board); no reset value is known; not in the data sheet. Details: docs/rdl-campaign/vdh-scd.md.";

        field {
            name = "value";
            desc = "Vendor value 0x7F3CFC3C.";
            sw = rw;
            hw = r;
        } value[31:0];

    } PRCMEM1_1D_CNT @ 0x70;

    reg {
        name = "PRC memory 2 count (constant)";
        desc = "Written the constant 0xFF3FFF12 on every decode.

Unexplained constant; written together with 0x70.

Source: vendor module hi3520D_vfmw.ko (H264HAL_V200R001_StartDec (str to offset 0x74)), confidence HIGH for the value 0xFF3FFF12 (movw 65298 / movt 65343), LOW for the meaning, word-checked against the Hi3520D disassembly: yes. Name and field layout: vendor-derived from the GPL Huawei VDH V400R004 header (vdm_hal_local.h, a later generation), inferred, confidence LOW. Not verified on hardware (nothing in this block has been read or written on the board); no reset value is known; not in the data sheet. Details: docs/rdl-campaign/vdh-scd.md.";

        field {
            name = "value";
            desc = "Vendor value 0xFF3FFF12.";
            sw = rw;
            hw = r;
        } value[31:0];

    } PRCMEM2_1D_CNT @ 0x74;

    reg {
        name = "PPFD buffer address";
        desc = "Physical address of the 100 KB (64*4*400 bytes) pre-parse buffer in the vendor memory arrangement; 16-byte aligned.

Scratch buffer of 64 x 4 x 400 = 102400 bytes (HwMem offset 0x30000), aligned 16.

Source: vendor module hi3520D_vfmw.ko (H264HAL_V200R001_StartDec (str to offset 0x80)), confidence MEDIUM, word-checked against the Hi3520D disassembly: yes. Name and field layout: vendor-derived from the GPL Huawei VDH V400R004 header (vdm_hal_local.h, a later generation), inferred, confidence LOW. Not verified on hardware (nothing in this block has been read or written on the board); no reset value is known; not in the data sheet. Details: docs/rdl-campaign/vdh-scd.md.";

        field {
            name = "ppfd_buf_addr";
            desc = "Physical DDR address & ~0xF.";
            sw = rw;
            hw = r;
        } ppfd_buf_addr[31:0];

    } PPFD_BUF_ADDR @ 0x80;

    reg {
        name = "PPFD buffer length";
        desc = "16-bit length (vendor writes 0x31F).

Source: vendor module hi3520D_vfmw.ko (H264HAL_V200R001_StartDec (str to offset 0x84)), confidence MEDIUM, word-checked against the Hi3520D disassembly: yes. Name and field layout: vendor-derived from the GPL Huawei VDH V400R004 header (vdm_hal_local.h, a later generation), inferred, confidence LOW. Not verified on hardware (nothing in this block has been read or written on the board); no reset value is known; not in the data sheet. Details: docs/rdl-campaign/vdh-scd.md.";

        field {
            name = "ppfd_buf_len";
            desc = "Buffer length (units unknown; vendor value 0x31F).";
            sw = rw;
            hw = r;
        } ppfd_buf_len[15:0];

    } PPFD_BUF_LEN @ 0x84;

    reg {
        name = "Reference picture structure types";
        desc = "Sixteen 2-bit entries, one per reference slot (frame/top/bottom structure), packed from slot 0 at bit 1:0 (V400R004 `REF_PIC_TYPE`).

Built from 16 two-bit fields (orr ... lsl #2 ... #30) = structure of the 16 reference pictures (frame/top/bottom).

Source: vendor module hi3520D_vfmw.ko (H264HAL_V200R001_StartDec (str to offset 0x94)), confidence MEDIUM, word-checked against the Hi3520D disassembly: yes. Name and field layout: vendor-derived from the GPL Huawei VDH V400R004 header (vdm_hal_local.h, a later generation), inferred, confidence LOW. Not verified on hardware (nothing in this block has been read or written on the board); no reset value is known; not in the data sheet. Details: docs/rdl-campaign/vdh-scd.md.";

        field {
            name = "ref_pic_type";
            desc = "16 x 2-bit reference structure types.";
            sw = rw;
            hw = r;
        } ref_pic_type[31:0];

    } REF_PIC_TYPE @ 0x94;

    reg {
        name = "Frame/adaptive storage mode";
        desc = "Written once per picture (0x2 for frame pictures in V400R004).

Source: vendor module hi3520D_vfmw.ko (H264HAL_V200R001_StartDec (str to offset 0x98)), confidence LOW (value assembled conditionally, meaning from V400R004 only), word-checked against the Hi3520D disassembly: yes. Name and field layout: vendor-derived from the GPL Huawei VDH V400R004 header (vdm_hal_local.h, a later generation), inferred, confidence LOW. Not verified on hardware (nothing in this block has been read or written on the board); no reset value is known; not in the data sheet. Details: docs/rdl-campaign/vdh-scd.md.";

        field {
            name = "value";
            desc = "Frame/adaptive store select.";
            sw = rw;
            hw = r;
        } value[31:0];

    } FF_APT_EN @ 0x98;

    reg {
        name = "Decode cycles per picture";
        desc = "Read by BackupInfo (performance counter).

Read together with 0xB4-0xC0 and 0xD0 in BackupInfo right after the decode finished.

Source: vendor module hi3520D_vfmw.ko (VDMHAL_V200R001_BackupInfo (read)), confidence HIGH for the read access, LOW for the meaning, word-checked against the Hi3520D disassembly: yes. Name and field layout: vendor-derived from the GPL Huawei VDH V400R004 header (vdm_hal_local.h, a later generation), inferred, confidence LOW. Not verified on hardware (nothing in this block has been read or written on the board); no reset value is known; not in the data sheet. Details: docs/rdl-campaign/vdh-scd.md.";

        field {
            name = "cycles";
            desc = "Cycles spent on the last picture.";
            sw = r;
            hw = w;
        } cycles[31:0];

    } DEC_CYCLEPERPIC @ 0xB0;

    reg {
        name = "UNK_0B4 (RD_BDWIDTH_PERPIC)";
        desc = "Read once per decoded picture by VDMHAL_V200R001_BackupInfo (read access only, offset 0xB4), together with DEC_CYCLEPERPIC (0xB0), the other three of 0xB4-0xC0 and MB0_QP_IN_CURR_PIC (0xD0), right after the decode finished; the value is stored in the backup record and not otherwise used by the Hi3520D code. Name: vendor-derived name RD_BDWIDTH_PERPIC from the GPL Huawei VDH V400R004 header (a later generation; there it is a per-picture memory bandwidth/request statistic), inferred, confidence LOW.

Unknown purpose, vendor-observed only, confidence LOW, not verified on hardware. Source: vendor module hi3520D_vfmw.ko (VDMHAL_V200R001_BackupInfo), word-checked against the Hi3520D disassembly: yes (offset only).";

        field {
            name = "unk_0b4";
            sw = r;
            hw = w;
        } unk_0b4[31:0];

    } UNK_0B4 @ 0xB4;

    reg {
        name = "UNK_0B8 (WR_BDWIDTH_PERPIC)";
        desc = "Read once per decoded picture by VDMHAL_V200R001_BackupInfo (read access only, offset 0xB8), together with DEC_CYCLEPERPIC (0xB0), the other three of 0xB4-0xC0 and MB0_QP_IN_CURR_PIC (0xD0), right after the decode finished; the value is stored in the backup record and not otherwise used by the Hi3520D code. Name: vendor-derived name WR_BDWIDTH_PERPIC from the GPL Huawei VDH V400R004 header (a later generation; there it is a per-picture memory bandwidth/request statistic), inferred, confidence LOW.

Unknown purpose, vendor-observed only, confidence LOW, not verified on hardware. Source: vendor module hi3520D_vfmw.ko (VDMHAL_V200R001_BackupInfo), word-checked against the Hi3520D disassembly: yes (offset only).";

        field {
            name = "unk_0b8";
            sw = r;
            hw = w;
        } unk_0b8[31:0];

    } UNK_0B8 @ 0xB8;

    reg {
        name = "UNK_0BC (RD_REQ_PERPIC)";
        desc = "Read once per decoded picture by VDMHAL_V200R001_BackupInfo (read access only, offset 0xBC), together with DEC_CYCLEPERPIC (0xB0), the other three of 0xB4-0xC0 and MB0_QP_IN_CURR_PIC (0xD0), right after the decode finished; the value is stored in the backup record and not otherwise used by the Hi3520D code. Name: vendor-derived name RD_REQ_PERPIC from the GPL Huawei VDH V400R004 header (a later generation; there it is a per-picture memory bandwidth/request statistic), inferred, confidence LOW.

Unknown purpose, vendor-observed only, confidence LOW, not verified on hardware. Source: vendor module hi3520D_vfmw.ko (VDMHAL_V200R001_BackupInfo), word-checked against the Hi3520D disassembly: yes (offset only).";

        field {
            name = "unk_0bc";
            sw = r;
            hw = w;
        } unk_0bc[31:0];

    } UNK_0BC @ 0xBC;

    reg {
        name = "UNK_0C0 (WR_REQ_PERPIC)";
        desc = "Read once per decoded picture by VDMHAL_V200R001_BackupInfo (read access only, offset 0xC0), together with DEC_CYCLEPERPIC (0xB0), the other three of 0xB4-0xC0 and MB0_QP_IN_CURR_PIC (0xD0), right after the decode finished; the value is stored in the backup record and not otherwise used by the Hi3520D code. Name: vendor-derived name WR_REQ_PERPIC from the GPL Huawei VDH V400R004 header (a later generation; there it is a per-picture memory bandwidth/request statistic), inferred, confidence LOW.

Unknown purpose, vendor-observed only, confidence LOW, not verified on hardware. Source: vendor module hi3520D_vfmw.ko (VDMHAL_V200R001_BackupInfo), word-checked against the Hi3520D disassembly: yes (offset only).";

        field {
            name = "unk_0c0";
            sw = r;
            hw = w;
        } unk_0c0[31:0];

    } UNK_0C0 @ 0xC0;

    reg {
        name = "QP of macroblock 0 in the current picture";
        desc = "Read by BackupInfo.

Source: vendor module hi3520D_vfmw.ko (VDMHAL_V200R001_BackupInfo (read, value & 31)), confidence HIGH for the read access, LOW for the meaning, word-checked against the Hi3520D disassembly: yes. Name and field layout: vendor-derived from the GPL Huawei VDH V400R004 header (vdm_hal_local.h, a later generation), inferred, confidence LOW. Not verified on hardware (nothing in this block has been read or written on the board); no reset value is known; not in the data sheet. Details: docs/rdl-campaign/vdh-scd.md.";

        field {
            name = "qp";
            desc = "Value of the QP statistics register.";
            sw = r;
            hw = w;
        } qp[31:0];

    } MB0_QP_IN_CURR_PIC @ 0xD0;

};

`endif
