`ifndef HISI_RTC_RDL
`define HISI_RTC_RDL

regfile eHISI_RTC {
    name = "RTC Registers";
    desc = "TODO: Determine if this is a hisi IP, or a ARM IP.";

    /* Fields */

    enum RTC_one_enable_enum {
        ENABLE  = 0x0 { desc = "Enable"; };
        DISABLE = 0x1 { desc = "Disable"; };
    };

    reg {
        name = "Current Count Value Register";
        desc = "Used to read the current count value of the internal counter of the RTC.";

        field {
            name = "rtc_data";
            desc = "Current count value of the RTC.";
            counter;
            decrvalue = 1;
            sw = r;
        } rtc_data[0:31];

    } RTC_DR @ 0x000;

    reg {
        name = "RTC Match Register";
        desc = "Used to set the match value of the RTC.";

        field {
            name = "rtc_match";
            desc = "Sets the match value of the RTC.";
        } rtc_match[0:31];

    } RTC_MR @ 0x04;

    reg {
        name = "RTC Load Register";
        desc = "Used to set the initial count value of the RTC.";

        field {
            name = "rtc_load";
            desc = "Sets the initial count value of the RTC.";
        } rtc_load[0:31];

    } RTC_LR @ 0x08;

    reg {
        name = "RTC Enable Register";
        desc = "Used to enable the RTC. If the RTC is enabled, this register can be cleared only when the system is reset. Writing this register has no effect and reading this register returns the current value.";

        field {
            name = "rtc_start";
            desc = "RTC enable.";
            encode = RTC_one_enable_enum;
        } rtc_start[0:0];

    } RTC_CR @ 0x0C;

    reg {
        name = "Interrupt Mask Register";
        desc = "Used to show the interrupt mask status of the RTC.";

        enum rtc_imsc_enum {
            MASKED     = 0x0 { desc = "Masked"; };
            NOT_MASKED = 0x1 { desc = "Not Masked"; };
        };

        field {
            name = "rtc_imsc";
            desc = "RTC interrupt mask control.";
            encode = rtc_imsc_enum;
        } rtc_imsc[0:0];

    } RTC_IMSC @ 0x10;

    reg {
        name = "Raw Interrupt Status Register";
        desc = "Used to show the status of the raw interrupts of the RTC.";

        enum rtc_ris_enum {
            NO_INTERRUPT = 0x0 { desc = "No interrupt is generated"; };
            INTERRUPT    = 0x1 { desc = "An interrupt is generated"; };
        };

        field {
            name = "rtc_ris";
            desc = "Current count value of the timer.";
            encode = rtc_ris_enum;
            sw = r;
        } rtc_ris[0:0];

    } RTC_RIS @ 0x14;

    reg {
        name = "Masked Interrupt Status Register";
        desc = "Used to show the status of the masked interrupts of the RTC.";

        enum rtc_mis_enum {
            NO_INTERRUPT = 0x0 { desc = "No interrupt is generated, or the interrupt is masked"; };
            INTERRUPT    = 0x1 { desc = "An interrupt is generated"; };
        };

        field {
            name = "rtc_mis";
            desc = "Status of the masked interrupts of the RTC.";
            encode = rtc_mis_enum;
            sw = r;
        } rtc_mis[0:0];

    } RTC_MIS @ 0x18;

    reg {
        name = "Interrupt Clear Register";
        desc = "Used to clear RTC interrupts.";

        enum rtc_icr_enum {
            NO_EFFECT = 0x0 { desc = "No effect"; };
            CLEAR     = 0x1 { desc = "Interrupt is cleared"; };
        };

        field {
            name = "rtc_icr";
            desc = "RTC interrupt clear.";
            encode = rtc_icr_enum;
            sw = w;
        } rtc_icr[0:0];

    } RTC_ICR @ 0x1C;

};
`endif
