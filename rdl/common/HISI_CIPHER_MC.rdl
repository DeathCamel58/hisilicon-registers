`ifndef HISI_CIPHER_MC_RDL
`define HISI_CIPHER_MC_RDL

// 8-channel linked-list CIPHER. The same 25 data sheet registers (CHAN0_*, CIPHER_KEY, CHANn_* at 0x1000 + n x 0x80, INT_*, RST_STATUS, CHAN0_CFG) with the same
// fields, bit positions and reset values appear in the data sheets of:
//   Hi3520D / Hi3515A / Hi3515C (Chinese original, section 3.5; base 0x100C0000, VIC interrupt 55)   - hardware verified on the Hi3520D, see the notes below
//   Hi3516A / Hi3516D V100 (section 3.7; 0x100C0000, interrupt 58), Hi3516C V100 (3.6; 0x100C0000, interrupt 13), Hi3516 V100 (Chinese, 3.6; 0x100C0000, interrupt 61)
//   Hi3518A / Hi3518C V100 (3.6; 0x100C0000, interrupt 13), Hi3518E V100 (3.6; 0x100C0000, interrupt 13)
//   Hi3518E V20X / Hi3516C V200 (issue 02 section 13.1; 0x100C0000, interrupt 13)
//   Hi3516A V200, Hi3519 V101, Hi3516C V300 / Hi3516E V100 (section 13.1; base 0x10080000, interrupt 58 on the AV200/V101, 13 on the CV300): these add the AES GCM
//   registers at 0x0840-0x093C, enabled with `define CIPHER_MC_GCM in the chip's defines.rdl, and the vendor U-Boot product/cipher driver (drv_cipher_reg.h, base
//   0x10080000) is written against this generation.
// Differences between the data sheets, all recorded in the register descriptions: RST_STATUS total reset value (0 or 1), CHANn_CIPHER_CTRL.weight access type
// ('-', RW or RO) and the input/output naming of INT_STATUS / INT_EN bits [15:9] / [7:1].
// Not the single-channel CIPHER of the Hi3511 / Hi3515 / Hi3520 V100 generation (HISI_CIPHER.rdl).
// The IAGE_CNT / *_LST_RADDR / *_ADDR / *_LENGTH / *_LEFT_* / BRAM_ST0 / IN_ST* / OUT_ST* debug registers are in no data sheet, only in the vendor driver header.
regfile eHISI_CIPHER_MC {
    name = "CIPHER (8 channels)";
    desc = "
        The CIPHER module encrypts and decrypts with DES, 3DES and AES (ECB/CBC/CFB/OFB/CTR modes) and has eight channels:

        * Channel 0 is a single-block channel: the CPU writes the key, the IV (CHAN0_CIPHER_IVIN) and one 128-bit block (CHAN0_CIPHER_DIN), starts it with CHAN0_CFG.ch0_start and reads the result from CHAN0_CIPHER_DOUT / CHAN0_CIPHER_IVOUT.
        * Channels 1-7 are linked-list DMA channels with an input queue and an output queue each (registers CHANn_* in the `CHAN1` .. `CHAN7` groups).
        * Eight CPU-configured keys (CIPHER_KEY, 8 words each) are shared by all channels; every channel selects one with key_adder.

        **Multi-packet queue node (channels 1-7).** The input queue (start address CHANn_SRC_LST_SADDR) and the output queue (CHANn_DEST_LST_SADDR) are arrays of 16-byte nodes in DDR, four 32-bit words each (data sheet Figure 3-17 and Table 3-18; the vendor code of the sibling SoC does not contain the word order or the flag bit numbers). HARDWARE VERIFIED (Hi3520D board, channel 1, 2026-11-09): input node = word0 data addr, word1 cas (last_lst bit 22, iv_set bit 21) | buf_len[15:0], word2 data_len[15:0], word3 iv_start_addr; output node = word0 addr, word1 = last_lst (bit 22) | buf_len[15:0], word2 data_len. AES-128 ECB of one 16-byte block with last_lst set on both nodes gave the correct FIPS-197 ciphertext. After one packet: IBUF_CNT 0, IEMPTY_CNT 1, OBUF_CNT N-1, OFULL_CNT 1, as the data sheet describes:

        | Word | Offset | Bits | Field | Meaning |
        |------|--------|------|-------|---------|
        | 0 | 0x0 | [31:0] | addr | First address of the buffer this node points to; may be a byte address. |
        | 1 | 0x4 | [31:16] | cas | Cipher control flags, flags only in bits 31..20: bit 22 last_lst, bit 21 iv_set, bits 31:23 and 20 reserved (bits 19:16 not described). |
        | 1 | 0x4 | [15:0] | buf_len | Hatched in the figure: length of the output buffer (output queue nodes). |
        | 2 | 0x8 | [31:16] | reserved | |
        | 2 | 0x8 | [15:0] | data_len | Length of the valid data this node indicates (input queue nodes). |
        | 3 | 0xC | [31:0] | iv_start_addr | Word aligned DDR address of the IV to load when iv_set is 1. |

        * `iv_set` (cas bit 21): the data of this node needs a new initial vector, taken from iv_start_addr.
        * `last_lst` (cas bit 22): this node is the last list node of a data block; if the hardware finds less than one cipher block left when it finishes the node, it writes the remaining data straight to the output buffer without encrypting it.
        * The vendor code names the fields u32DataAddr / U32DataLen / u32IVStartAddr / u32Flags with the flag bits IVSET and EOL (same meaning as iv_set / last_lst).
        * The input node and the output node of one task use the same index in the two queues; software wraps the index at ibuf_num / obuf_num.

        **Queue programming and completion (data sheet 3.5.4 steps 1-6 and the vendor drv_cipher.c).**

        1. Program CHANn_SRC_LST_SADDR / CHANn_DEST_LST_SADDR (word aligned), CHANn_IBUF_NUM = CHANn_OBUF_NUM = N, CHANn_IBUF_CNT = 0 and CHANn_OBUF_CNT = N (all output buffers available), plus the interrupt thresholds, aging timers and CHANn_CIPHER_CTRL.
        2. For each task fill the input node and the output node (same index), set CTRL and the key, then write the number of added nodes K to CHANn_IBUF_CNT (the logic adds it).
        3. On the output queue interrupt read CHANn_OFULL_CNT = F, process F output nodes, then write F to CHANn_IEMPTY_CNT and CHANn_OFULL_CNT (both subtract it) and to CHANn_OBUF_CNT (adds the F buffers back).
        4. All counters are 16 bits.

        !!! NOTE
            Verified on hardware (hardware verified 2026-11-09, Hi3520D, linux driver hi3520d-cipher.c; passes the kernel randomized crypto self-tests CRYPTO_SELFTESTS_FULL for ecb/cbc/ctr(aes), ecb/cbc(des), ecb/cbc(des3_ede) on the DMA channels):

            * Counters: after a request of K nodes the driver writes K to IEMPTY_CNT, OFULL_CNT (subtracts) and OBUF_CNT (adds back); writing K to IBUF_CNT starts the request.
            * Ring: IBUF_NUM = OBUF_NUM = 128 with OBUF_CNT preloaded with 128 works; the hardware wraps its read pointer at NUM. Both nodes of a pair (same index in the input and output queue) carry the same data_len. The maximum data_len used is 0xFFF0 per node.
            * IV: the IV of a request is taken from iv_start_addr of the node with iv_set (the driver sets iv_set only on the first node of a request, and ivin_sel = 1 for CBC/CTR). After completion the chaining IV is read from CHAN_CIPHER_IVOUT.
            * Node splitting: every node except the last of a request must hold whole cipher blocks (16 bytes AES, 8 bytes DES). A cipher block split across nodes worked only in simple cases (one ECB 16-byte block split 5 + 11 gave the right ciphertext) but gave wrong data, a wrong output IV or hangs in the chained modes (CBC, CTR, DES) in the self-tests. Treat a split inside a cipher block as unsupported.
            * Throughput (informational, AES-128, any mode, 4 KiB blocks): about 30 MB/s for a single request and about 40 MB/s with 8 requests in flight; about 10 us CPU cost per request. The rate is fixed (PERI_CRG31 has only a clock gate and a reset). Channel 0 (register mode) measured about 3.6 MB/s.

        !!! NOTE
            Interrupt bit assignment: [7:1] are the INPUT queue interrupts and [15:9] the OUTPUT queue interrupts (hardware verified), the opposite of the data sheet text and as in the vendor code of the sibling SoC. See INT_STATUS.

        !!! NOTE
            The data sheet summary table (Table 3-18) prints the per-channel addresses as `0x1000 + n x 0x128 + ...`, while every register description says `n x 128`. 0x128 cannot be right: channel 7 would sit at 0x1818, beyond INT_STATUS at 0x1400. The channel stride is 128 bytes (0x80): channel n (n = 1..7) registers are at 0x1000 + n x 0x80 + offset, and channel 0 uses the 0x1000-0x1020 slot.
    ";

    enum CIPHER_MC_key_adder_enum {
        HOST_KEY0 = 0x0 { desc = "host_key0 (CIPHER_KEY words at 0x0090-0x00AC)"; };
        HOST_KEY1 = 0x1 { desc = "host_key1 (0x00B0-0x00CC)"; };
        HOST_KEY2 = 0x2 { desc = "host_key2 (0x00D0-0x00EC)"; };
        HOST_KEY3 = 0x3 { desc = "host_key3 (0x00F0-0x010C)"; };
        HOST_KEY4 = 0x4 { desc = "host_key4 (0x0110-0x012C)"; };
        HOST_KEY5 = 0x5 { desc = "host_key5 (0x0130-0x014C)"; };
        HOST_KEY6 = 0x6 { desc = "host_key6 (0x0150-0x016C)"; };
        HOST_KEY7 = 0x7 { desc = "host_key7 (0x0170-0x018C)"; };
    };

    enum CIPHER_MC_key_sel_enum {
        CPU         = 0x0 { desc = "Keys configured by the CPU (CIPHER_KEY)."; };
        KEY_MANAGER = 0x1 { desc = "Keys generated by the key management module."; };
    };

    enum CIPHER_MC_key_length_enum {
        AES_128_DES_3KEY_0 = 0x0 { desc = "AES: 128 bits. DES/3DES: 3 keys."; };
        AES_192_DES_3KEY_1 = 0x1 { desc = "AES: 192 bits. DES/3DES: 3 keys."; };
        AES_256_DES_3KEY_2 = 0x2 { desc = "AES: 256 bits. DES/3DES: 3 keys."; };
        AES_128_DES_2KEY   = 0x3 { desc = "AES: 128 bits. DES/3DES: 2 keys."; };
    };

    enum CIPHER_MC_ivin_sel_enum {
        NOT_CONFIGURED = 0x0 { desc = "Do not configure CIPHER_IVIN."; };
        CONFIGURED     = 0x1 { desc = "Configure CIPHER_IVIN."; };
    };

    enum CIPHER_MC_width_enum {
        FULL_0 = 0x0 { desc = "DES/3DES: 64 bits. AES: 128 bits."; };
        BIT_8  = 0x1 { desc = "8 bits (AES: CFB mode only; DES/3DES: CFB and OFB modes only)."; };
        BIT_1  = 0x2 { desc = "1 bit (AES: CFB mode only; DES/3DES: CFB and OFB modes only)."; };
        FULL_3 = 0x3 { desc = "DES/3DES: 64 bits. AES: 128 bits."; };
    };

    enum CIPHER_MC_alg_sel_enum {
        DES     = 0x0 { desc = "DES algorithm."; };
        TDES    = 0x1 { desc = "3DES algorithm."; };
        AES     = 0x2 { desc = "AES algorithm."; };
        DES_ALT = 0x3 { desc = "DES algorithm."; };
    };

    enum CIPHER_MC_mode_enum {
        ECB = 0x0 { desc = "ECB mode."; };
        CBC = 0x1 { desc = "CBC mode."; };
        CFB = 0x2 { desc = "CFB mode."; };
        OFB = 0x3 { desc = "OFB mode."; };
        CTR = 0x4 { desc = "CTR mode (AES only). Other values (5-7, and 4 for DES/3DES) select ECB mode."; };
    };

    enum CIPHER_MC_decrypt_enum {
        ENCRYPT = 0x0 { desc = "Encryption."; };
        DECRYPT = 0x1 { desc = "Decryption."; };
    };

    enum CIPHER_MC_enabled_enum {
        DISABLE = 0x0 { desc = "Disabled."; };
        ENABLE  = 0x1 { desc = "Enabled."; };
    };

    /* Block output, IV output and key registers (channel 0 and the shared key store) */

    reg {
        name = "CHAN0_CIPHER_DOUT";
        desc = "
            CIPHER output register for channel 0 (single-block encryption/decryption): the 128-bit block result, one 32-bit segment per address (DOUT[31:0] at 0x0000 ... DOUT[127:96] at 0x000C).

            AES: with 1-CFB only bit[0] is valid, with 8-CFB bit[7:0], with 128-CFB and all other modes all 128 bits. DES/3DES: with 1-CFB/1-OFB only bit[0], with 8-CFB/8-OFB bit[7:0], in the other modes the lower 64 bits.
        ";
        field {
            name = "chan0_cipher_dout";
            desc = "128-bit block output of the CIPHER module. Each address maps to a 32-bit data segment.";
            sw = r;
            hw = w;
            reset = 0x0;
        } chan0_cipher_dout[31:0];
    } CHAN0_CIPHER_DOUT[4] @ 0x0000 += 0x4;

    reg {
        name = "CHAN0_CIPHER_IVOUT";
        desc = "
            Operation-complete IV output register of channel 0 (can be ignored in ECB and CTR mode). After a single-block operation it holds the vector output of the block (usable as the IV input for the next block of the same packet). AES: 128 bits valid; DES/3DES: lower 64 bits valid.
        ";
        field {
            name = "chan0_cipher_ivout";
            desc = "Vector output after the operation of the CIPHER module is complete. Each address maps to a 32-bit data segment (IVOUT[31:0] at 0x0010 ... IVOUT[127:96] at 0x001C).";
            sw = r;
            hw = w;
            reset = 0x0;
        } chan0_cipher_ivout[31:0];
    } CHAN0_CIPHER_IVOUT[4] @ 0x0010 += 0x4;

    reg {
        name = "CHAN_CIPHER_IVOUT";
        desc = "
            IV output registers for channels 1-7, four words per channel:

            * 0x0020-0x002C: channel 1
            * 0x0030-0x003C: channel 2
            * 0x0040-0x004C: channel 3
            * 0x0050-0x005C: channel 4
            * 0x0060-0x006C: channel 5
            * 0x0070-0x007C: channel 6
            * 0x0080-0x008C: channel 7

            !!! NOTE
                Channel n (n = 1..7) is at 0x0020 + (n-1) x 0x10, as in the data sheet. The vendor header macro CIPHER_REG_CHAN_CIPHER_IVOUT(id) = base + 0x0010 + id x 32 does not match this (channel 1 would be at 0x0030 and the stride is 0x20); the vendor macro is wrong (hardware verified 2026-11-09, Hi3520D, linux driver hi3520d-cipher.c): the Linux driver chains CBC/CTR requests by reading the next IV from 0x0020 + (n-1) x 0x10 (4 words, little endian) and passes the kernel randomized chained-request self-tests, so the data sheet layout is correct. For CTR the hardware increments the counter as a 128-bit big-endian value (counter wrap cases pass) and IVOUT returns the next counter.
        ";
        field {
            name = "chan_cipher_ivout";
            desc = "Vector output of the channel after the operation is complete.";
            sw = r;
            hw = w;
            reset = 0x0;
        } chan_cipher_ivout[31:0];
    } CHAN_CIPHER_IVOUT[28] @ 0x0020 += 0x4;

    reg {
        name = "CIPHER_KEY";
        desc = "
            CPU configuration key registers: eight keys (host_key0..host_key7) of eight 32-bit words each. Each channel uses one key (selected by key_adder); several channels can share a key.

            hardware verified 2026-11-09, Hi3520D, linux driver hi3520d-cipher.c: channel n (n = 1..7) can use host key slot n with key_adder = n (CTRL[16:14]); the driver loads key slot = channel id. This works for AES-128/192/256 and DES/3DES. Key words are written as plain little-endian 32-bit words in natural byte order (word i = key bytes [4i..4i+3], little endian) for AES, DES (8 bytes) and 3DES (24 bytes, key_length = 0 = three keys). The same word order applies to CHAN0_CIPHER_DIN / IVIN / DOUT.

            DES: CIPHER_KEY[63:0] valid. 3DES, 3 keys: [191:0] (key 1 = [63:0], key 2 = [127:64], key 3 = [191:128]); 2 keys: [127:0]. AES: 128-bit key [127:0], 192-bit [191:0], 256-bit [255:0].
        ";
        field {
            name = "cipher_key";
            desc = "Key input of the CIPHER module. Each address maps to a 32-bit data segment: host_key0 is at 0x0090-0x00AC, host_key1 at 0x00B0-0x00CC, ... host_key7 at 0x0170-0x018C.";
            reset = 0x0;
        } cipher_key[31:0];
    } CIPHER_KEY[64] @ 0x0090 += 0x4;

`ifdef CIPHER_MC_GCM
    /* AES GCM extension of the Hi3516A V200 / Hi3519 V101 / Hi3516C V300 generation, 0x0840 - 0x093C (data sheet 13.1.6). The GCM mode is AES CTR plus GHASH
       (data sheet 13.1.3 Figure 13-14); the data sheet does not say how a channel is switched into GCM mode (CHANn_CIPHER_CTRL.mode lists ECB/CBC/CFB/OFB/CTR only) and the
       local vendor driver does not use these registers. */
    regfile eHISI_CIPHER_MC_GCM_A_LEN {
        name = "CHANn_GCM_A_LEN (n = 0..7)";
        desc = "A (additional authenticated data) length of the AES GCM of channel n, 8 bytes per channel at 0x0840 + 0x8 x n (CHAN0 at 0x0840/0x0844 ... CHAN7 at 0x0878/0x087C).";
        reg { name = "CHANn_GCM_A_LEN_0"; desc = "A length lower 32 bits register for the AES GCM of channel n."; field { name = "chann_gcm_a_len_0"; desc = "Lower 32 bits of the A length for the AES GCM of channel n (unit: 8 bits)."; reset = 0x0; } chann_gcm_a_len_0[31:0]; } CHANn_GCM_A_LEN_0 @ 0x0;
        reg { name = "CHANn_GCM_A_LEN_1"; desc = "A length upper 32 bits register for the AES GCM of channel n."; field { name = "chann_gcm_a_len_1"; desc = "Upper 32 bits of the A length for the AES GCM of channel n (unit: 8 bits)."; reset = 0x0; } chann_gcm_a_len_1[31:0]; } CHANn_GCM_A_LEN_1 @ 0x4;
    };
    eHISI_CIPHER_MC_GCM_A_LEN GCM_A_LEN[8] @ 0x0840 += 0x8;

    regfile eHISI_CIPHER_MC_GCM_PC_LEN {
        name = "CHANn_GCM_PC_LEN (n = 0..7)";
        desc = "Payload length of the AES GCM of channel n, 8 bytes per channel at 0x0880 + 0x8 x n (CHAN0 at 0x0880/0x0884 ... CHAN7 at 0x08B8/0x08BC).";
        reg { name = "CHANn_GCM_PC_LEN_0"; desc = "Payload length lower 32 bits register for the AES GCM of channel n."; field { name = "chann_gcm_pc_len_0"; desc = "Lower 32 bits of the payload length for the AES GCM of channel n (unit: 8 bits)."; reset = 0x0; } chann_gcm_pc_len_0[31:0]; } CHANn_GCM_PC_LEN_0 @ 0x0;
        reg { name = "CHANn_GCM_PC_LEN_1"; desc = "Payload length upper 32 bits register for the AES GCM of channel n."; field { name = "chann_gcm_pc_len_1"; desc = "Upper 32 bits of the payload length for the AES GCM of channel n (unit: 8 bits)."; reset = 0x0; } chann_gcm_pc_len_1[31:0]; } CHANn_GCM_PC_LEN_1 @ 0x4;
    };
    eHISI_CIPHER_MC_GCM_PC_LEN GCM_PC_LEN[8] @ 0x0880 += 0x8;

    reg {
        name = "CHAN0_3_GCM_IV_LEN";
        desc = "IV length register for the AES GCM of channels 0-3.";
        field { name = "chan3_gcm_iv_len"; desc = "IV length of channel 3."; reset = 0x0; } chan3_gcm_iv_len[28:24];
        field { name = "chan2_gcm_iv_len"; desc = "IV length of channel 2."; reset = 0x0; } chan2_gcm_iv_len[20:16];
        field { name = "chan1_gcm_iv_len"; desc = "IV length of channel 1."; reset = 0x0; } chan1_gcm_iv_len[12:8];
        field { name = "chan0_gcm_iv_len"; desc = "IV length of channel 0."; reset = 0x0; } chan0_gcm_iv_len[4:0];
    } CHAN0_3_GCM_IV_LEN @ 0x08C0;

    reg {
        name = "CHAN4_7_GCM_IV_LEN";
        desc = "IV length register for the AES GCM of channels 4-7.";
        field { name = "chan7_gcm_iv_len"; desc = "IV length of channel 7."; reset = 0x0; } chan7_gcm_iv_len[28:24];
        field { name = "chan6_gcm_iv_len"; desc = "IV length of channel 6."; reset = 0x0; } chan6_gcm_iv_len[20:16];
        field { name = "chan5_gcm_iv_len"; desc = "IV length of channel 5."; reset = 0x0; } chan5_gcm_iv_len[12:8];
        field { name = "chan4_gcm_iv_len"; desc = "IV length of channel 4."; reset = 0x0; } chan4_gcm_iv_len[4:0];
    } CHAN4_7_GCM_IV_LEN @ 0x08C4;

    reg {
        name = "CHANn_GCM_IV_LEN_VLD";
        desc = "GCM IV length validity signal register.";
        field { name = "chann_gcm_iv_len_vld"; desc = "Whether the IV length of channel n (bit n) is valid after the operation is started in AES GCM mode. 0: invalid (the channel length is 0 or greater than 16 bytes); 1: valid."; sw = r; hw = w; reset = 0x0; } chann_gcm_iv_len_vld[7:0];
    } CHANn_GCM_IV_LEN_VLD @ 0x08CC;

    reg {
        name = "CHANn_GCM_TAG_VLD";
        desc = "GCM tag validity signal register.";
        field { name = "chann_gcm_tag_vld"; desc = "Whether the tag of channel n (bit n) is valid in AES GCM mode. 0: invalid; 1: valid. Writing 1 clears the bit (data sheet access RWC)."; sw = rw; hw = w; onwrite = woclr; reset = 0x0; } chann_gcm_tag_vld[7:0];
    } CHANn_GCM_TAG_VLD @ 0x08D0;

    reg {
        name = "CHANn_GCM_GHASH_A_END";
        desc = "GCM A calculation end signal register.";
        field { name = "chann_gcm_ghash_a_end"; desc = "Whether the GHASH of channel n (bit n) over A is finished when the A length is not 0 in AES GCM mode. 0: not finished; 1: finished. Writing 1 clears the bit (data sheet access RWC)."; sw = rw; hw = w; onwrite = woclr; reset = 0x0; } chann_gcm_ghash_a_end[7:0];
    } CHANn_GCM_GHASH_A_END @ 0x08D4;

    regfile eHISI_CIPHER_MC_GCM_TAG {
        name = "CHANn_GCM_TAG (n = 0..7)";
        desc = "GCM tag registers of one channel, 16 bytes per channel at 0x0900 + 0x10 x n.

        !!! NOTE
            The data sheet prints the offset of CHANn_GCM_TAG_3 as `0x0900 + 0x10 x n + 0x04` (the same as TAG_1); 0x0C is the only consistent value and is used here.";
        reg { name = "CHANn_GCM_TAG_0"; desc = "GCM tag register 0 for channel n."; field { name = "chann_gcm_tag_0"; desc = "GCM tag[31:0] for channel n."; sw = r; hw = w; reset = 0x0; } chann_gcm_tag_0[31:0]; } CHANn_GCM_TAG_0 @ 0x0;
        reg { name = "CHANn_GCM_TAG_1"; desc = "GCM tag register 1 for channel n."; field { name = "chann_gcm_tag_1"; desc = "GCM tag[63:32] for channel n."; sw = r; hw = w; reset = 0x0; } chann_gcm_tag_1[31:0]; } CHANn_GCM_TAG_1 @ 0x4;
        reg { name = "CHANn_GCM_TAG_2"; desc = "GCM tag register 2 for channel n."; field { name = "chann_gcm_tag_2"; desc = "GCM tag[95:64] for channel n."; sw = r; hw = w; reset = 0x0; } chann_gcm_tag_2[31:0]; } CHANn_GCM_TAG_2 @ 0x8;
        reg { name = "CHANn_GCM_TAG_3"; desc = "GCM tag register 3 for channel n."; field { name = "chann_gcm_tag_3"; desc = "GCM tag[127:96] for channel n."; sw = r; hw = w; reset = 0x0; } chann_gcm_tag_3[31:0]; } CHANn_GCM_TAG_3 @ 0xC;
    };
    eHISI_CIPHER_MC_GCM_TAG GCM_TAG[8] @ 0x0900 += 0x10;
`endif

    /* Channel 0 (single block), 0x1000 - 0x1020 */

    reg {
        name = "CHAN0_CIPHER_CTRL";
        desc = "
            Encryption/decryption control register of channel 0 (single-block channel). Configure it before the other registers of the CIPHER module. In the modes other than AES-CFB (DES/3DES: other than CFB and OFB), width must not be 0b01 or 0b10.

            !!! NOTE
                The data sheet bit diagram labels one of the reserved bits 12:11 `byte_seq`; the bit table calls both reserved.
        ";
        field { name = "key_adder"; desc = "ID of the key used by the current channel."; encode = CIPHER_MC_key_adder_enum; reset = 0x0; } key_adder[16:14];
        field { name = "key_sel"; desc = "Key select."; encode = CIPHER_MC_key_sel_enum; reset = 0x0; } key_sel[13:13];
        field { name = "key_length"; desc = "Key length select (AES / DES differ, see the values)."; encode = CIPHER_MC_key_length_enum; reset = 0x0; } key_length[10:9];
        field { name = "ivin_sel"; desc = "Input select of CIPHER_IVIN."; encode = CIPHER_MC_ivin_sel_enum; reset = 0x0; } ivin_sel[8:8];
        field { name = "width"; desc = "Bit width control (DES/3DES and AES differ, see the values)."; encode = CIPHER_MC_width_enum; reset = 0x0; } width[7:6];
        field { name = "alg_sel"; desc = "Algorithm select."; encode = CIPHER_MC_alg_sel_enum; reset = 0x0; } alg_sel[5:4];
        field { name = "mode"; desc = "Operating mode select. AES: ECB, CBC, CFB, OFB, CTR; DES/3DES: ECB, CBC, CFB, OFB; other values select ECB."; encode = CIPHER_MC_mode_enum; reset = 0x0; } mode[3:1];
        field { name = "decrypt"; desc = "Encryption/decryption select."; encode = CIPHER_MC_decrypt_enum; reset = 0x0; } decrypt[0:0];
    } CHAN0_CIPHER_CTRL @ 0x1000;

    reg {
        name = "CHAN0_CIPHER_IVIN";
        desc = "
            IV / counter input register of channel 0. Needed when the mode is not ECB and CHAN0_CIPHER_CTRL.ivin_sel = 1 (ignored with ivin_sel = 0). AES: IVIN[127:0] valid; DES/3DES: IVIN[63:0] valid.
        ";
        field {
            name = "chan0_cipher_ivin";
            desc = "128-bit IV of the CIPHER module for channel 0, or the data input from the counter. Each address maps to a 32-bit data segment (IVIN[31:0] at 0x1004 ... IVIN[127:96] at 0x1010).";
            reset = 0x0;
        } chan0_cipher_ivin[31:0];
    } CHAN0_CIPHER_IVIN[4] @ 0x1004 += 0x4;

    reg {
        name = "CHAN0_CIPHER_DIN";
        desc = "
            128-bit block input register for channel 0 (single-block operation). AES: with 1-CFB only bit[0] is valid, with 8-CFB bit[7:0], otherwise 128 bits. DES/3DES: with 1-CFB/1-OFB bit[0], with 8-CFB/8-OFB bit[7:0], otherwise the lower 64 bits.
        ";
        field {
            name = "chan0_cipher_din";
            desc = "128-bit block input of the CIPHER module for channel 0. Each address maps to a 32-bit data segment (DIN[31:0] at 0x1014 ... DIN[127:96] at 0x1020).";
            reset = 0x0;
        } chan0_cipher_din[31:0];
    } CHAN0_CIPHER_DIN[4] @ 0x1014 += 0x4;

    /* Channels 1-7: linked-list queues. One group per channel, base = 0x1000 + n x 0x80. */

    regfile eHISI_CIPHER_MC_CHAN {
        name = "CIPHER channel n queue registers (n = 1..7)";
        desc = "Registers of one linked-list channel; instantiated as CHAN1..CHAN7 at 0x1000 + n x 0x80.";

        reg {
            name = "CHANn_IBUF_NUM";
            desc = "Input queue total depth register: the count of linked list headers configured for the channel.";
            field { name = "ibuf_num"; desc = "Input queue depth, that is, the count of linked list headers configured for each channel."; reset = 0x0; } ibuf_num[15:0];
        } CHANn_IBUF_NUM @ 0x00;

        reg {
            name = "CHANn_IBUF_CNT";
            desc = "Pending data buffer count register of the input queue. When software writes it, the logic adds the written value to the register; after the logic processes a buffer the value is decremented by 1.";
            field { name = "ibuf_cnt"; desc = "Count of buffers to be processed in the input queue."; reset = 0x0; } ibuf_cnt[15:0];
        } CHANn_IBUF_CNT @ 0x04;

        reg {
            name = "CHANn_IEMPTY_CNT";
            desc = "Processed buffer count register of the input queue. When software writes it, the logic subtracts the written value; after the logic processes a buffer the value is incremented by 1.";
            field { name = "iempty_cnt"; desc = "Count of processed buffers in the input queue."; reset = 0x0; } iempty_cnt[15:0];
        } CHANn_IEMPTY_CNT @ 0x08;

        reg {
            name = "CHANn_INT_ICNTCFG";
            desc = "Input queue multi-packet interrupt threshold register. When the count of buffers processed from the input queue reaches the threshold (greater than or equal to it, data sheet wording '大于等于'), an input queue interrupt is reported. hardware verified 2026-11-09, Hi3520D, linux driver hi3520d-cipher.c: with a threshold of 0 or 1 one processed packet raises the interrupt, with 100 it does not; the driver sets the threshold to the number of nodes of a request to get one interrupt per request.";
            field { name = "int_icnt_cfg"; desc = "Input queue multi-packet interrupt threshold."; reset = 0x0; } int_icnt_cfg[15:0];
        } CHANn_INT_ICNTCFG @ 0x0C;

        reg {
            name = "CHANn_CIPHER_CTRL";
            desc = "
                Encryption/decryption control register of channel n. Configure it before using the channel. In the modes other than AES-CFB (DES/3DES: other than CFB and OFB), width must not be 0b01 or 0b10.

                !!! NOTE
                    The Hi3520D data sheet gives the weight field no access type ('-'), the Hi3516A V100 data sheet says RW and the Hi3518E V200 / Hi3516A V200 data sheets say RO ('weighted value of the current channel, in units of 64 bytes'; the AV200 feature list says the weight of the multi-block channels is configurable). It is modelled read/write.

                !!! NOTE
                    The data sheet bit table lists bit 8 as reserved (the bit diagram also labels bits 12:11 `byte_seq` / `ts_vld`; the table calls them reserved). ivin_sel[8] is NOT IN THE DATA SHEET for channels 1-7: it is modelled from the vendor driver (sources/u-boot-vendor-2010.06 product/cipher/hal_cipher.c, HAL_Cipher_Config, ~line 712-775), which writes bit 8 of CHANn_CIPHER_CTRL as it does for channel 0 (set together with iv_set in the queue node).
            ";
            field { name = "weight"; desc = "Weighted value of the current channel, in units of 64 bytes."; reset = 0x0; } weight[31:22];
            field { name = "key_adder"; desc = "ID of the key used by the current channel; any of the keys 0-7."; encode = CIPHER_MC_key_adder_enum; reset = 0x0; } key_adder[16:14];
            field { name = "key_sel"; desc = "Key select."; encode = CIPHER_MC_key_sel_enum; reset = 0x0; } key_sel[13:13];
            field { name = "key_length"; desc = "Key length select (AES / DES differ, see the values)."; encode = CIPHER_MC_key_length_enum; reset = 0x0; } key_length[10:9];
            field { name = "ivin_sel"; desc = "NOT IN THE DATA SHEET (bit 8 is reserved there): vendor driver bit, new IV select as in CHAN0_CIPHER_CTRL (0 = no new IV, 1 = new IV). Meaning inferred from the vendor code; hardware verified 2026-11-09, Hi3520D, linux driver hi3520d-cipher.c: the driver sets it for CBC/CTR so the IV is taken from iv_start_addr of the node with iv_set."; encode = CIPHER_MC_ivin_sel_enum; reset = 0x0; } ivin_sel[8:8];
            field { name = "width"; desc = "Bit width control (DES/3DES and AES differ, see the values)."; encode = CIPHER_MC_width_enum; reset = 0x0; } width[7:6];
            field { name = "alg_sel"; desc = "Algorithm select."; encode = CIPHER_MC_alg_sel_enum; reset = 0x0; } alg_sel[5:4];
            field { name = "mode"; desc = "Operating mode select. AES: ECB, CBC, CFB, OFB, CTR; DES/3DES: ECB, CBC, CFB, OFB; other values select ECB."; encode = CIPHER_MC_mode_enum; reset = 0x0; } mode[3:1];
            field { name = "decrypt"; desc = "Encryption/decryption select."; encode = CIPHER_MC_decrypt_enum; reset = 0x0; } decrypt[0:0];
        } CHANn_CIPHER_CTRL @ 0x10;

        reg {
            name = "CHANn_SRC_LST_SADDR";
            desc = "Input queue start address register. The address must be word aligned.";
            field { name = "src_lst_saddr"; desc = "Start address of the input queue."; reset = 0x0; } src_lst_saddr[31:0];
        } CHANn_SRC_LST_SADDR @ 0x14;

        reg {
            name = "CHANn_IAGE_TIMER";
            desc = "Input queue interrupt aging time configuration register. If the aging time counter overflows and the count of processed buffers in the input queue is greater than 0, an input queue processing-complete interrupt is reported.";
            field { name = "iage_timer"; desc = "Aging interrupt timer."; reset = 0x0; } iage_timer[15:0];
        } CHANn_IAGE_TIMER @ 0x18;

        reg {
            name = "CHANn_IAGE_CNT (vendor)";
            desc = "Input queue aging counter register (vendor).

NOT IN THE DATA SHEET: register defined only in the vendor driver header product/cipher/drv_cipher_reg.h (sources/u-boot-vendor-2010.06, a sibling SoC with base 0x10080000 and the same channel layout). Offset from that header; layout and reset unknown, meaning inferred from the name. The vendor HAL_Cipher_SetAGEThreshold (hal_cipher.c ~line 787-805) writes the aging threshold here (16-bit value, 0 by default), while the data sheet names the aging time register CHANn_IAGE_TIMER at 0x18: which of the two is the real aging timer is uncertain.";
            field { name = "iage_cnt"; desc = "Layout unknown (modelled as one 32-bit field)."; sw = rw; hw = r; } iage_cnt[31:0];
        } CHANn_IAGE_CNT @ 0x1C;

        reg {
            name = "CHANn_SRC_LST_RADDR (vendor)";
            desc = "Input queue hardware read address (read-only status).

NOT IN THE DATA SHEET: register defined only in the vendor driver header product/cipher/drv_cipher_reg.h (sources/u-boot-vendor-2010.06, a sibling SoC with base 0x10080000 and the same channel layout). Offset from that header; layout and reset unknown, meaning inferred from the name.";
            field { name = "src_lst_raddr"; desc = "Layout unknown (modelled as one 32-bit field)."; sw = r; hw = w; } src_lst_raddr[31:0];
        } CHANn_SRC_LST_RADDR @ 0x20;

        reg {
            name = "CHANn_SRC_ADDR (vendor)";
            desc = "Input data address being processed (read-only status).

NOT IN THE DATA SHEET: register defined only in the vendor driver header product/cipher/drv_cipher_reg.h (sources/u-boot-vendor-2010.06, a sibling SoC with base 0x10080000 and the same channel layout). Offset from that header; layout and reset unknown, meaning inferred from the name.";
            field { name = "src_addr"; desc = "Layout unknown (modelled as one 32-bit field)."; sw = r; hw = w; } src_addr[31:0];
        } CHANn_SRC_ADDR @ 0x24;

        reg {
            name = "CHANn_SRC_LENGTH (vendor)";
            desc = "Input data length being processed (read-only status).

NOT IN THE DATA SHEET: register defined only in the vendor driver header product/cipher/drv_cipher_reg.h (sources/u-boot-vendor-2010.06, a sibling SoC with base 0x10080000 and the same channel layout). Offset from that header; layout and reset unknown, meaning inferred from the name.";
            field { name = "src_length"; desc = "Layout unknown (modelled as one 32-bit field)."; sw = r; hw = w; } src_length[31:0];
        } CHANn_SRC_LENGTH @ 0x28;

        reg {
            name = "CHANn_IN_LEFT_BYTE0 (vendor)";
            desc = "Input side leftover bytes (read-only status).

NOT IN THE DATA SHEET: register defined only in the vendor driver header product/cipher/drv_cipher_reg.h (sources/u-boot-vendor-2010.06, a sibling SoC with base 0x10080000 and the same channel layout). Offset from that header; layout and reset unknown, meaning inferred from the name.";
            field { name = "in_left_byte0"; desc = "Layout unknown (modelled as one 32-bit field)."; sw = r; hw = w; } in_left_byte0[31:0];
        } CHANn_IN_LEFT_BYTE0 @ 0x2C;

        reg {
            name = "CHANn_IN_LEFT_WORD0 (vendor)";
            desc = "Input side leftover word 0 (read-only status).

NOT IN THE DATA SHEET: register defined only in the vendor driver header product/cipher/drv_cipher_reg.h (sources/u-boot-vendor-2010.06, a sibling SoC with base 0x10080000 and the same channel layout). Offset from that header; layout and reset unknown, meaning inferred from the name.";
            field { name = "in_left_word0"; desc = "Layout unknown (modelled as one 32-bit field)."; sw = r; hw = w; } in_left_word0[31:0];
        } CHANn_IN_LEFT_WORD0 @ 0x30;

        reg {
            name = "CHANn_IN_LEFT_WORD1 (vendor)";
            desc = "Input side leftover word 1 (read-only status).

NOT IN THE DATA SHEET: register defined only in the vendor driver header product/cipher/drv_cipher_reg.h (sources/u-boot-vendor-2010.06, a sibling SoC with base 0x10080000 and the same channel layout). Offset from that header; layout and reset unknown, meaning inferred from the name.";
            field { name = "in_left_word1"; desc = "Layout unknown (modelled as one 32-bit field)."; sw = r; hw = w; } in_left_word1[31:0];
        } CHANn_IN_LEFT_WORD1 @ 0x34;

        reg {
            name = "CHANn_IN_LEFT_WORD2 (vendor)";
            desc = "Input side leftover word 2 (read-only status).

NOT IN THE DATA SHEET: register defined only in the vendor driver header product/cipher/drv_cipher_reg.h (sources/u-boot-vendor-2010.06, a sibling SoC with base 0x10080000 and the same channel layout). Offset from that header; layout and reset unknown, meaning inferred from the name.";
            field { name = "in_left_word2"; desc = "Layout unknown (modelled as one 32-bit field)."; sw = r; hw = w; } in_left_word2[31:0];
        } CHANn_IN_LEFT_WORD2 @ 0x38;

        reg {
            name = "CHANn_OBUF_NUM";
            desc = "Output queue total depth register: the count of linked list headers configured for the channel.";
            field { name = "obuf_num"; desc = "Total depth of the output queue."; reset = 0x0; } obuf_num[15:0];
        } CHANn_OBUF_NUM @ 0x3C;

        reg {
            name = "CHANn_OBUF_CNT";
            desc = "Pending data buffer count register of the output queue. When software writes it, the logic adds the written value; after the logic processes a buffer the value is decremented by 1.";
            field { name = "obuf_cnt"; desc = "Count of buffers to be processed in the output queue."; reset = 0x0; } obuf_cnt[15:0];
        } CHANn_OBUF_CNT @ 0x40;

        reg {
            name = "CHANn_OFULL_CNT";
            desc = "Processed buffer count register of the output queue. When software writes it, the logic subtracts the written value; after the logic processes a buffer the value is incremented by 1.";
            field { name = "ofull_cnt"; desc = "Count of processed buffers in the output queue."; reset = 0x0; } ofull_cnt[15:0];
        } CHANn_OFULL_CNT @ 0x44;

        reg {
            name = "CHANn_INT_OCNTCFG";
            desc = "Output queue multi-packet interrupt threshold register. When the count of buffers processed in the output queue reaches the threshold (greater than or equal to it, data sheet wording '大于等于'), an output queue interrupt is reported. hardware verified 2026-11-09, Hi3520D, linux driver hi3520d-cipher.c: OCNTCFG 0 and 1 both fire for one processed packet, 100 does not; the driver sets the threshold to the number of nodes of a request to get one interrupt per request.";
            field { name = "int_ocnt_cfg"; desc = "Output queue multi-packet interrupt threshold."; reset = 0x0; } int_ocnt_cfg[15:0];
        } CHANn_INT_OCNTCFG @ 0x48;

        reg {
            name = "CHANn_DEST_LST_SADDR";
            desc = "Output queue start address register. The address must be word aligned.";
            field { name = "dest_lst_saddr"; desc = "Start address of the output queue."; reset = 0x0; } dest_lst_saddr[31:0];
        } CHANn_DEST_LST_SADDR @ 0x4C;

        reg {
            name = "CHANn_OAGE_TIMER";
            desc = "Output queue interrupt aging time configuration register. If the aging time counter overflows and the count of processed buffers in the output queue is greater than 0, an output queue processing-complete interrupt is reported.";
            field { name = "oage_timer"; desc = "Aging interrupt timer."; reset = 0x0; } oage_timer[15:0];
        } CHANn_OAGE_TIMER @ 0x50;

        reg {
            name = "CHANn_OAGE_CNT (vendor)";
            desc = "Output queue aging counter register (vendor).

NOT IN THE DATA SHEET: register defined only in the vendor driver header product/cipher/drv_cipher_reg.h (sources/u-boot-vendor-2010.06, a sibling SoC with base 0x10080000 and the same channel layout). Offset from that header; layout and reset unknown, meaning inferred from the name. The vendor HAL_Cipher_SetAGEThreshold (hal_cipher.c ~line 787-805) writes the aging threshold here (16-bit value, 0 by default), while the data sheet names the aging time register CHANn_OAGE_TIMER at 0x50: which of the two is the real aging timer is uncertain.";
            field { name = "oage_cnt"; desc = "Layout unknown (modelled as one 32-bit field)."; sw = rw; hw = r; } oage_cnt[31:0];
        } CHANn_OAGE_CNT @ 0x54;

        reg {
            name = "CHANn_DEST_LST_RADDR (vendor)";
            desc = "Output queue hardware read address (read-only status).

NOT IN THE DATA SHEET: register defined only in the vendor driver header product/cipher/drv_cipher_reg.h (sources/u-boot-vendor-2010.06, a sibling SoC with base 0x10080000 and the same channel layout). Offset from that header; layout and reset unknown, meaning inferred from the name.";
            field { name = "dest_lst_raddr"; desc = "Layout unknown (modelled as one 32-bit field)."; sw = r; hw = w; } dest_lst_raddr[31:0];
        } CHANn_DEST_LST_RADDR @ 0x58;

        reg {
            name = "CHANn_DEST_ADDR (vendor)";
            desc = "Output data address being written (read-only status).

NOT IN THE DATA SHEET: register defined only in the vendor driver header product/cipher/drv_cipher_reg.h (sources/u-boot-vendor-2010.06, a sibling SoC with base 0x10080000 and the same channel layout). Offset from that header; layout and reset unknown, meaning inferred from the name.";
            field { name = "dest_addr"; desc = "Layout unknown (modelled as one 32-bit field)."; sw = r; hw = w; } dest_addr[31:0];
        } CHANn_DEST_ADDR @ 0x5C;

        reg {
            name = "CHANn_DEST_LENGTH (vendor)";
            desc = "Output data length being written (read-only status).

NOT IN THE DATA SHEET: register defined only in the vendor driver header product/cipher/drv_cipher_reg.h (sources/u-boot-vendor-2010.06, a sibling SoC with base 0x10080000 and the same channel layout). Offset from that header; layout and reset unknown, meaning inferred from the name.";
            field { name = "dest_length"; desc = "Layout unknown (modelled as one 32-bit field)."; sw = r; hw = w; } dest_length[31:0];
        } CHANn_DEST_LENGTH @ 0x60;

        reg {
            name = "CHANn_OUT_LEFT_BYTE (vendor)";
            desc = "Output side leftover bytes (read-only status).

NOT IN THE DATA SHEET: register defined only in the vendor driver header product/cipher/drv_cipher_reg.h (sources/u-boot-vendor-2010.06, a sibling SoC with base 0x10080000 and the same channel layout). Offset from that header; layout and reset unknown, meaning inferred from the name.";
            field { name = "out_left_byte"; desc = "Layout unknown (modelled as one 32-bit field)."; sw = r; hw = w; } out_left_byte[31:0];
        } CHANn_OUT_LEFT_BYTE @ 0x64;
    };

    eHISI_CIPHER_MC_CHAN CHAN1 @ 0x1080;
    eHISI_CIPHER_MC_CHAN CHAN2 @ 0x1100;
    eHISI_CIPHER_MC_CHAN CHAN3 @ 0x1180;
    eHISI_CIPHER_MC_CHAN CHAN4 @ 0x1200;
    eHISI_CIPHER_MC_CHAN CHAN5 @ 0x1280;
    eHISI_CIPHER_MC_CHAN CHAN6 @ 0x1300;
    eHISI_CIPHER_MC_CHAN CHAN7 @ 0x1380;

    /* Interrupt and status block, 0x1400 - 0x1410 */
    reg {
        name = "INT_STATUS";
        desc = "Interrupt status register. Bit 0 is reserved (channel 0 has no output queue).

        !!! NOTE
            Input/output bit assignment: HARDWARE VERIFIED on the Hi3520D (channel 1, AES-ECB through the queue, 2026-11-09), contradicting the Hi3520D data sheet text (it puts the input queue bits at [15:9] and the output queue bits at [7:1] in INT_STATUS, INT_EN and INT_RAW; the English Hi3516A V100, Hi3518E V200 and Hi3516A V200 data sheets do the same in INT_STATUS and INT_EN but name [15:9] the output queue bits in INT_RAW). Bits [7:1] are the INPUT queue interrupts (channel 7..1), bits [15:9] the OUTPUT queue interrupts (channel 7..1), bit 8 is channel 0 done (as in the data sheet). Evidence: with CHAN1_INT_OCNTCFG = 100 and CHAN1_INT_ICNTCFG = 0 one processed packet raised only INT_RAW bit 1 (INT_RAW = 0x2); with both thresholds low INT_RAW = 0x202; the masked INT_STATUS follows INT_EN exactly. This matches the vendor code of the sibling SoC (hal_cipher.c:866-935, HAL_Cipher_EnableInt: `1 << (8 + chnId)` for output, `1 << (0 + chnId)` for input) and the field names here follow it, not the data sheet.";
        field { name = "ch7_obuf_int"; desc = "Output queue data interrupt for channel 7."; sw = r; hw = w; reset = 0x0; } ch7_obuf_int[15:15];
        field { name = "ch6_obuf_int"; desc = "Output queue data interrupt for channel 6."; sw = r; hw = w; reset = 0x0; } ch6_obuf_int[14:14];
        field { name = "ch5_obuf_int"; desc = "Output queue data interrupt for channel 5."; sw = r; hw = w; reset = 0x0; } ch5_obuf_int[13:13];
        field { name = "ch4_obuf_int"; desc = "Output queue data interrupt for channel 4."; sw = r; hw = w; reset = 0x0; } ch4_obuf_int[12:12];
        field { name = "ch3_obuf_int"; desc = "Output queue data interrupt for channel 3."; sw = r; hw = w; reset = 0x0; } ch3_obuf_int[11:11];
        field { name = "ch2_obuf_int"; desc = "Output queue data interrupt for channel 2."; sw = r; hw = w; reset = 0x0; } ch2_obuf_int[10:10];
        field { name = "ch1_obuf_int"; desc = "Output queue data interrupt for channel 1."; sw = r; hw = w; reset = 0x0; } ch1_obuf_int[9:9];
        field { name = "ch0_ibuf_int"; desc = "Data processing complete interrupt for channel 0."; sw = r; hw = w; reset = 0x0; } ch0_ibuf_int[8:8];
        field { name = "ch7_ibuf_int"; desc = "Input queue data interrupt for channel 7."; sw = r; hw = w; reset = 0x0; } ch7_ibuf_int[7:7];
        field { name = "ch6_ibuf_int"; desc = "Input queue data interrupt for channel 6."; sw = r; hw = w; reset = 0x0; } ch6_ibuf_int[6:6];
        field { name = "ch5_ibuf_int"; desc = "Input queue data interrupt for channel 5."; sw = r; hw = w; reset = 0x0; } ch5_ibuf_int[5:5];
        field { name = "ch4_ibuf_int"; desc = "Input queue data interrupt for channel 4."; sw = r; hw = w; reset = 0x0; } ch4_ibuf_int[4:4];
        field { name = "ch3_ibuf_int"; desc = "Input queue data interrupt for channel 3."; sw = r; hw = w; reset = 0x0; } ch3_ibuf_int[3:3];
        field { name = "ch2_ibuf_int"; desc = "Input queue data interrupt for channel 2."; sw = r; hw = w; reset = 0x0; } ch2_ibuf_int[2:2];
        field { name = "ch1_ibuf_int"; desc = "Input queue data interrupt for channel 1."; sw = r; hw = w; reset = 0x0; } ch1_ibuf_int[1:1];
    } INT_STATUS @ 0x1400;

    reg {
        name = "INT_EN";
        desc = "Interrupt enable register. Bit 0 is reserved. Bit 31 (int_en) is the master enable of the module: the vendor HAL_Cipher_EnableInt sets it whenever it enables a channel interrupt and HAL_Cipher_DisableInt clears it when no other enable bit is left (hal_cipher.c:874, 927). hardware verified 2026-11-09, Hi3520D, linux driver hi3520d-cipher.c: bit 31 must be set for the IRQ line (SPI 23, GIC 55) to fire; the masked INT_STATUS follows INT_EN.

        !!! NOTE
            Input/output bit assignment: HARDWARE VERIFIED on the Hi3520D (channel 1, AES-ECB through the queue, 2026-11-09), contradicting the Hi3520D data sheet text (it puts the input queue bits at [15:9] and the output queue bits at [7:1] in INT_STATUS, INT_EN and INT_RAW; the English Hi3516A V100, Hi3518E V200 and Hi3516A V200 data sheets do the same in INT_STATUS and INT_EN but name [15:9] the output queue bits in INT_RAW). Bits [7:1] are the INPUT queue interrupts (channel 7..1), bits [15:9] the OUTPUT queue interrupts (channel 7..1), bit 8 is channel 0 done (as in the data sheet). Evidence: with CHAN1_INT_OCNTCFG = 100 and CHAN1_INT_ICNTCFG = 0 one processed packet raised only INT_RAW bit 1 (INT_RAW = 0x2); with both thresholds low INT_RAW = 0x202; the masked INT_STATUS follows INT_EN exactly. This matches the vendor code of the sibling SoC (hal_cipher.c:866-935, HAL_Cipher_EnableInt: `1 << (8 + chnId)` for output, `1 << (0 + chnId)` for input) and the field names here follow it, not the data sheet.";
        field { name = "int_en"; desc = "Total interrupt enable for the CIPHER module."; encode = CIPHER_MC_enabled_enum; sw = rw; hw = r; reset = 0x0; } int_en[31:31];
        field { name = "ch7_obuf_en"; desc = "Output queue data interrupt enable for channel 7."; encode = CIPHER_MC_enabled_enum; sw = rw; hw = r; reset = 0x0; } ch7_obuf_en[15:15];
        field { name = "ch6_obuf_en"; desc = "Output queue data interrupt enable for channel 6."; encode = CIPHER_MC_enabled_enum; sw = rw; hw = r; reset = 0x0; } ch6_obuf_en[14:14];
        field { name = "ch5_obuf_en"; desc = "Output queue data interrupt enable for channel 5."; encode = CIPHER_MC_enabled_enum; sw = rw; hw = r; reset = 0x0; } ch5_obuf_en[13:13];
        field { name = "ch4_obuf_en"; desc = "Output queue data interrupt enable for channel 4."; encode = CIPHER_MC_enabled_enum; sw = rw; hw = r; reset = 0x0; } ch4_obuf_en[12:12];
        field { name = "ch3_obuf_en"; desc = "Output queue data interrupt enable for channel 3."; encode = CIPHER_MC_enabled_enum; sw = rw; hw = r; reset = 0x0; } ch3_obuf_en[11:11];
        field { name = "ch2_obuf_en"; desc = "Output queue data interrupt enable for channel 2."; encode = CIPHER_MC_enabled_enum; sw = rw; hw = r; reset = 0x0; } ch2_obuf_en[10:10];
        field { name = "ch1_obuf_en"; desc = "Output queue data interrupt enable for channel 1."; encode = CIPHER_MC_enabled_enum; sw = rw; hw = r; reset = 0x0; } ch1_obuf_en[9:9];
        field { name = "ch0_ibuf_en"; desc = "Data processing complete interrupt enable for channel 0."; encode = CIPHER_MC_enabled_enum; sw = rw; hw = r; reset = 0x0; } ch0_ibuf_en[8:8];
        field { name = "ch7_ibuf_en"; desc = "Input queue data interrupt enable for channel 7."; encode = CIPHER_MC_enabled_enum; sw = rw; hw = r; reset = 0x0; } ch7_ibuf_en[7:7];
        field { name = "ch6_ibuf_en"; desc = "Input queue data interrupt enable for channel 6."; encode = CIPHER_MC_enabled_enum; sw = rw; hw = r; reset = 0x0; } ch6_ibuf_en[6:6];
        field { name = "ch5_ibuf_en"; desc = "Input queue data interrupt enable for channel 5."; encode = CIPHER_MC_enabled_enum; sw = rw; hw = r; reset = 0x0; } ch5_ibuf_en[5:5];
        field { name = "ch4_ibuf_en"; desc = "Input queue data interrupt enable for channel 4."; encode = CIPHER_MC_enabled_enum; sw = rw; hw = r; reset = 0x0; } ch4_ibuf_en[4:4];
        field { name = "ch3_ibuf_en"; desc = "Input queue data interrupt enable for channel 3."; encode = CIPHER_MC_enabled_enum; sw = rw; hw = r; reset = 0x0; } ch3_ibuf_en[3:3];
        field { name = "ch2_ibuf_en"; desc = "Input queue data interrupt enable for channel 2."; encode = CIPHER_MC_enabled_enum; sw = rw; hw = r; reset = 0x0; } ch2_ibuf_en[2:2];
        field { name = "ch1_ibuf_en"; desc = "Input queue data interrupt enable for channel 1."; encode = CIPHER_MC_enabled_enum; sw = rw; hw = r; reset = 0x0; } ch1_ibuf_en[1:1];
    } INT_EN @ 0x1404;

    reg {
        name = "INT_RAW";
        desc = "Raw interrupt status register. The data sheet access type is RWC (read, write to clear); the clear polarity is not stated and is modelled as write-1-to-clear. The vendor HAL_Cipher_ClrIntState (hal_cipher.c:1003) clears pending bits by writing 1s to this register (drv_cipher.c:878 writes 0xffffffff to clear everything), which supports write-1-to-clear. hardware verified 2026-11-09, Hi3520D, linux driver hi3520d-cipher.c: INT_RAW is cleared by writing 1s to the bits (the driver clears with writel(status)). Bit 0 is reserved.

        !!! NOTE
            Input/output bit assignment: HARDWARE VERIFIED on the Hi3520D (channel 1, AES-ECB through the queue, 2026-11-09), contradicting the Hi3520D data sheet text (it puts the input queue bits at [15:9] and the output queue bits at [7:1] in INT_STATUS, INT_EN and INT_RAW; the English Hi3516A V100, Hi3518E V200 and Hi3516A V200 data sheets do the same in INT_STATUS and INT_EN but name [15:9] the output queue bits in INT_RAW). Bits [7:1] are the INPUT queue interrupts (channel 7..1), bits [15:9] the OUTPUT queue interrupts (channel 7..1), bit 8 is channel 0 done (as in the data sheet). Evidence: with CHAN1_INT_OCNTCFG = 100 and CHAN1_INT_ICNTCFG = 0 one processed packet raised only INT_RAW bit 1 (INT_RAW = 0x2); with both thresholds low INT_RAW = 0x202; the masked INT_STATUS follows INT_EN exactly. This matches the vendor code of the sibling SoC (hal_cipher.c:866-935, HAL_Cipher_EnableInt: `1 << (8 + chnId)` for output, `1 << (0 + chnId)` for input) and the field names here follow it, not the data sheet.";
        field { name = "ch7_obuf_raw"; desc = "Raw output queue data interrupt for channel 7."; sw = rw; onwrite = woclr; hw = w; reset = 0x0; } ch7_obuf_raw[15:15];
        field { name = "ch6_obuf_raw"; desc = "Raw output queue data interrupt for channel 6."; sw = rw; onwrite = woclr; hw = w; reset = 0x0; } ch6_obuf_raw[14:14];
        field { name = "ch5_obuf_raw"; desc = "Raw output queue data interrupt for channel 5."; sw = rw; onwrite = woclr; hw = w; reset = 0x0; } ch5_obuf_raw[13:13];
        field { name = "ch4_obuf_raw"; desc = "Raw output queue data interrupt for channel 4."; sw = rw; onwrite = woclr; hw = w; reset = 0x0; } ch4_obuf_raw[12:12];
        field { name = "ch3_obuf_raw"; desc = "Raw output queue data interrupt for channel 3."; sw = rw; onwrite = woclr; hw = w; reset = 0x0; } ch3_obuf_raw[11:11];
        field { name = "ch2_obuf_raw"; desc = "Raw output queue data interrupt for channel 2."; sw = rw; onwrite = woclr; hw = w; reset = 0x0; } ch2_obuf_raw[10:10];
        field { name = "ch1_obuf_raw"; desc = "Raw output queue data interrupt for channel 1."; sw = rw; onwrite = woclr; hw = w; reset = 0x0; } ch1_obuf_raw[9:9];
        field { name = "ch0_ibuf_raw"; desc = "Raw data processing complete interrupt for channel 0."; sw = rw; onwrite = woclr; hw = w; reset = 0x0; } ch0_ibuf_raw[8:8];
        field { name = "ch7_ibuf_raw"; desc = "Raw input queue data interrupt for channel 7."; sw = rw; onwrite = woclr; hw = w; reset = 0x0; } ch7_ibuf_raw[7:7];
        field { name = "ch6_ibuf_raw"; desc = "Raw input queue data interrupt for channel 6."; sw = rw; onwrite = woclr; hw = w; reset = 0x0; } ch6_ibuf_raw[6:6];
        field { name = "ch5_ibuf_raw"; desc = "Raw input queue data interrupt for channel 5."; sw = rw; onwrite = woclr; hw = w; reset = 0x0; } ch5_ibuf_raw[5:5];
        field { name = "ch4_ibuf_raw"; desc = "Raw input queue data interrupt for channel 4."; sw = rw; onwrite = woclr; hw = w; reset = 0x0; } ch4_ibuf_raw[4:4];
        field { name = "ch3_ibuf_raw"; desc = "Raw input queue data interrupt for channel 3."; sw = rw; onwrite = woclr; hw = w; reset = 0x0; } ch3_ibuf_raw[3:3];
        field { name = "ch2_ibuf_raw"; desc = "Raw input queue data interrupt for channel 2."; sw = rw; onwrite = woclr; hw = w; reset = 0x0; } ch2_ibuf_raw[2:2];
        field { name = "ch1_ibuf_raw"; desc = "Raw input queue data interrupt for channel 1."; sw = rw; onwrite = woclr; hw = w; reset = 0x0; } ch1_ibuf_raw[1:1];
    } INT_RAW @ 0x1408;

    enum CIPHER_MC_rst_status_enum {
        RESETTING = 0x0 { desc = "The CIPHER module is being reset."; };
        WORKING   = 0x1 { desc = "The CIPHER module is working properly."; };
    };

    reg {
        name = "RST_STATUS";
        desc = "Reset status indicator register. Total reset value 0x0 in the Hi3520D (Chinese original), Hi3516A V100, Hi3518E V200 and Hi3516A V200 data sheets, 0x1 in the Hi3516C V100, Hi3518A/C V100 and Hi3518E V100 data sheets (same bit table). On the Hi3520D the register reads 1 while the module is running (hardware read 2026-11-09); the value during reset is not observable from software, so 0 is kept.";
        field {
            name = "rst_status";
            desc = "Reset status indicator of the CIPHER module.";
            encode = CIPHER_MC_rst_status_enum;
            sw = r;
            hw = w;
            reset = 0x0;
        } rst_status[0:0];
    } RST_STATUS @ 0x140C;

    reg {
        name = "CHAN0_CFG";
        desc = "Channel 0 configuration register.";
        field {
            name = "ch0_busy";
            desc = "Status signal of channel 0 (1 = busy).";
            sw = r;
            hw = w;
            reset = 0x0;
        } ch0_busy[1:1];

        field {
            name = "ch0_start";
            desc = "Encryption/decryption start signal of channel 0.";
            reset = 0x0;
        } ch0_start[0:0];
    } CHAN0_CFG @ 0x1410;

    reg {
        name = "BRAM_ST0 (vendor)";
        desc = "Debug state register of the buffer RAM (read-only status).

NOT IN THE DATA SHEET: register defined only in the vendor driver header product/cipher/drv_cipher_reg.h (sources/u-boot-vendor-2010.06, a sibling SoC with base 0x10080000; macro CIPHER_REG_BRAM_ST0). Offset from that header; layout and reset unknown, meaning inferred from the name.";
        field { name = "bram_st0"; desc = "Layout unknown (modelled as one 32-bit field)."; sw = r; hw = w; } bram_st0[31:0];
    } BRAM_ST0 @ 0x1420;

    reg {
        name = "IN_ST0 (vendor)";
        desc = "Debug state register of the input path (read-only status).

NOT IN THE DATA SHEET: register defined only in the vendor driver header product/cipher/drv_cipher_reg.h (sources/u-boot-vendor-2010.06, a sibling SoC with base 0x10080000; macro CIPHER_REG_IN_ST0). Offset from that header; layout and reset unknown, meaning inferred from the name.";
        field { name = "in_st0"; desc = "Layout unknown (modelled as one 32-bit field)."; sw = r; hw = w; } in_st0[31:0];
    } IN_ST0 @ 0x1424;

    reg {
        name = "IN_ST1 (vendor)";
        desc = "Debug state register of the input path (read-only status).

NOT IN THE DATA SHEET: register defined only in the vendor driver header product/cipher/drv_cipher_reg.h (sources/u-boot-vendor-2010.06, a sibling SoC with base 0x10080000; macro CIPHER_REG_IN_ST1). Offset from that header; layout and reset unknown, meaning inferred from the name.";
        field { name = "in_st1"; desc = "Layout unknown (modelled as one 32-bit field)."; sw = r; hw = w; } in_st1[31:0];
    } IN_ST1 @ 0x1428;

    reg {
        name = "IN_ST2 (vendor)";
        desc = "Debug state register of the input path (read-only status).

NOT IN THE DATA SHEET: register defined only in the vendor driver header product/cipher/drv_cipher_reg.h (sources/u-boot-vendor-2010.06, a sibling SoC with base 0x10080000; macro CIPHER_REG_IN_ST2). Offset from that header; layout and reset unknown, meaning inferred from the name.";
        field { name = "in_st2"; desc = "Layout unknown (modelled as one 32-bit field)."; sw = r; hw = w; } in_st2[31:0];
    } IN_ST2 @ 0x142C;

    reg {
        name = "IN_ST3 (vendor)";
        desc = "Debug state register of the input path (read-only status).

NOT IN THE DATA SHEET: register defined only in the vendor driver header product/cipher/drv_cipher_reg.h (sources/u-boot-vendor-2010.06, a sibling SoC with base 0x10080000; macro CIPHER_REG_IN_ST3). Offset from that header; layout and reset unknown, meaning inferred from the name.";
        field { name = "in_st3"; desc = "Layout unknown (modelled as one 32-bit field)."; sw = r; hw = w; } in_st3[31:0];
    } IN_ST3 @ 0x1430;

    reg {
        name = "OUT_ST0 (vendor)";
        desc = "Debug state register of the output path (read-only status).

NOT IN THE DATA SHEET: register defined only in the vendor driver header product/cipher/drv_cipher_reg.h (sources/u-boot-vendor-2010.06, a sibling SoC with base 0x10080000; macro CIPHER_REG_OUT_ST0). Offset from that header; layout and reset unknown, meaning inferred from the name.";
        field { name = "out_st0"; desc = "Layout unknown (modelled as one 32-bit field)."; sw = r; hw = w; } out_st0[31:0];
    } OUT_ST0 @ 0x1434;

    reg {
        name = "OUT_ST1 (vendor)";
        desc = "Debug state register of the output path (read-only status).

NOT IN THE DATA SHEET: register defined only in the vendor driver header product/cipher/drv_cipher_reg.h (sources/u-boot-vendor-2010.06, a sibling SoC with base 0x10080000; macro CIPHER_REG_OUT_ST1). Offset from that header; layout and reset unknown, meaning inferred from the name.";
        field { name = "out_st1"; desc = "Layout unknown (modelled as one 32-bit field)."; sw = r; hw = w; } out_st1[31:0];
    } OUT_ST1 @ 0x1438;

    reg {
        name = "OUT_ST2 (vendor)";
        desc = "Debug state register of the output path (read-only status).

NOT IN THE DATA SHEET: register defined only in the vendor driver header product/cipher/drv_cipher_reg.h (sources/u-boot-vendor-2010.06, a sibling SoC with base 0x10080000; macro CIPHER_REG_OUT_ST2). Offset from that header; layout and reset unknown, meaning inferred from the name.";
        field { name = "out_st2"; desc = "Layout unknown (modelled as one 32-bit field)."; sw = r; hw = w; } out_st2[31:0];
    } OUT_ST2 @ 0x143C;
};
`endif
