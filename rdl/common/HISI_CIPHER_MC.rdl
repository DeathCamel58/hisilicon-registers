`ifndef HISI_CIPHER_MC_RDL
`define HISI_CIPHER_MC_RDL

// 8-channel CIPHER of the Hi3520D / Hi3515A / Hi3515C (Hi3520D data sheet section 3.5, DS-3520D-EN:12690-14360).
// Not the single-channel CIPHER of the Hi3511 / Hi3515V100 generation (HISI_CIPHER.rdl).
regfile eHISI_CIPHER_MC {
    name = "CIPHER (8 channels)";
    desc = "
        The CIPHER module encrypts and decrypts with DES, 3DES and AES (ECB/CBC/CFB/OFB/CTR modes) and has eight channels:

        * Channel 0 is a single-block channel: the CPU writes the key, the IV (CHAN0_CIPHER_IVIN) and one 128-bit block (CHAN0_CIPHER_DIN), starts it with CHAN0_CFG.ch0_start and reads the result from CHAN0_CIPHER_DOUT / CHAN0_CIPHER_IVOUT.
        * Channels 1-7 are linked-list DMA channels with an input queue and an output queue each (registers CHANn_* in the `CHAN1` .. `CHAN7` groups).
        * Eight CPU-configured keys (CIPHER_KEY, 8 words each) are shared by all channels; every channel selects one with key_adder.

        !!! NOTE
            The data sheet summary table (Table 3-18) prints the per-channel addresses as `0x1000 + n x 0x128 + ...`, while every register description says `n x 128`. 0x128 cannot be right: channel 7 would sit at 0x1818, beyond INT_STATUS at 0x1400. The channel stride is 128 bytes (0x80): channel n (n = 1..7) registers are at 0x1000 + n x 0x80 + offset, and channel 0 uses the 0x1000-0x1020 slot.
    ";

    enum CIPHER_MC_key_adder_enum {
        HOST_KEY0 = 0x0 { desc = "host_key0 (CIPHER_KEY words at 0x0090-0x00AC)"; };
        HOST_KEY1 = 0x1 { desc = "host_key1 (0x00B0-0x00CC)"; };
        HOST_KEY2 = 0x2 { desc = "host_key2 (0x00D0-0x00EC)"; };
        HOST_KEY3 = 0x3 { desc = "host_key3 (0x00F0-0x010C)"; };
        HOST_KEY4 = 0x4 { desc = "host_key4 (0x0110-0x012C)"; };
        HOST_KEY5 = 0x5 { desc = "host_key5 (0x0130-0x014C)"; };
        HOST_KEY6 = 0x6 { desc = "host_key6 (0x0150-0x016C)"; };
        HOST_KEY7 = 0x7 { desc = "host_key7 (0x0170-0x018C)"; };
    };

    enum CIPHER_MC_key_sel_enum {
        CPU         = 0x0 { desc = "Keys configured by the CPU (CIPHER_KEY)."; };
        KEY_MANAGER = 0x1 { desc = "Keys generated by the key management module."; };
    };

    enum CIPHER_MC_key_length_enum {
        AES_128_DES_3KEY_0 = 0x0 { desc = "AES: 128 bits. DES/3DES: 3 keys."; };
        AES_192_DES_3KEY_1 = 0x1 { desc = "AES: 192 bits. DES/3DES: 3 keys."; };
        AES_256_DES_3KEY_2 = 0x2 { desc = "AES: 256 bits. DES/3DES: 3 keys."; };
        AES_128_DES_2KEY   = 0x3 { desc = "AES: 128 bits. DES/3DES: 2 keys."; };
    };

    enum CIPHER_MC_ivin_sel_enum {
        NOT_CONFIGURED = 0x0 { desc = "Do not configure CIPHER_IVIN."; };
        CONFIGURED     = 0x1 { desc = "Configure CIPHER_IVIN."; };
    };

    enum CIPHER_MC_width_enum {
        FULL_0 = 0x0 { desc = "DES/3DES: 64 bits. AES: 128 bits."; };
        BIT_8  = 0x1 { desc = "8 bits (AES: CFB mode only; DES/3DES: CFB and OFB modes only)."; };
        BIT_1  = 0x2 { desc = "1 bit (AES: CFB mode only; DES/3DES: CFB and OFB modes only)."; };
        FULL_3 = 0x3 { desc = "DES/3DES: 64 bits. AES: 128 bits."; };
    };

    enum CIPHER_MC_alg_sel_enum {
        DES     = 0x0 { desc = "DES algorithm."; };
        TDES    = 0x1 { desc = "3DES algorithm."; };
        AES     = 0x2 { desc = "AES algorithm."; };
        DES_ALT = 0x3 { desc = "DES algorithm."; };
    };

    enum CIPHER_MC_mode_enum {
        ECB = 0x0 { desc = "ECB mode."; };
        CBC = 0x1 { desc = "CBC mode."; };
        CFB = 0x2 { desc = "CFB mode."; };
        OFB = 0x3 { desc = "OFB mode."; };
        CTR = 0x4 { desc = "CTR mode (AES only). Other values (5-7, and 4 for DES/3DES) select ECB mode."; };
    };

    enum CIPHER_MC_decrypt_enum {
        ENCRYPT = 0x0 { desc = "Encryption."; };
        DECRYPT = 0x1 { desc = "Decryption."; };
    };

    enum CIPHER_MC_enabled_enum {
        DISABLE = 0x0 { desc = "Disabled."; };
        ENABLE  = 0x1 { desc = "Enabled."; };
    };

    /* Block output, IV output and key registers (channel 0 and the shared key store) */

    reg {
        name = "CHAN0_CIPHER_DOUT";
        desc = "
            CIPHER output register for channel 0 (single-block encryption/decryption): the 128-bit block result, one 32-bit segment per address (DOUT[31:0] at 0x0000 ... DOUT[127:96] at 0x000C).

            AES: with 1-CFB only bit[0] is valid, with 8-CFB bit[7:0], with 128-CFB and all other modes all 128 bits. DES/3DES: with 1-CFB/1-OFB only bit[0], with 8-CFB/8-OFB bit[7:0], in the other modes the lower 64 bits.
        ";
        field {
            name = "chan0_cipher_dout";
            desc = "128-bit block output of the CIPHER module. Each address maps to a 32-bit data segment.";
            sw = r;
            hw = w;
            reset = 0x0;
        } chan0_cipher_dout[31:0];
    } CHAN0_CIPHER_DOUT[4] @ 0x0000 += 0x4;

    reg {
        name = "CHAN0_CIPHER_IVOUT";
        desc = "
            Operation-complete IV output register of channel 0 (can be ignored in ECB and CTR mode). After a single-block operation it holds the vector output of the block (usable as the IV input for the next block of the same packet). AES: 128 bits valid; DES/3DES: lower 64 bits valid.
        ";
        field {
            name = "chan0_cipher_ivout";
            desc = "Vector output after the operation of the CIPHER module is complete. Each address maps to a 32-bit data segment (IVOUT[31:0] at 0x0010 ... IVOUT[127:96] at 0x001C).";
            sw = r;
            hw = w;
            reset = 0x0;
        } chan0_cipher_ivout[31:0];
    } CHAN0_CIPHER_IVOUT[4] @ 0x0010 += 0x4;

    reg {
        name = "CHAN_CIPHER_IVOUT";
        desc = "
            IV output registers for channels 1-7, four words per channel:

            * 0x0020-0x002C: channel 1
            * 0x0030-0x003C: channel 2
            * 0x0040-0x004C: channel 3
            * 0x0050-0x005C: channel 4
            * 0x0060-0x006C: channel 5
            * 0x0070-0x007C: channel 6
            * 0x0080-0x008C: channel 7
        ";
        field {
            name = "chan_cipher_ivout";
            desc = "Vector output of the channel after the operation is complete.";
            sw = r;
            hw = w;
            reset = 0x0;
        } chan_cipher_ivout[31:0];
    } CHAN_CIPHER_IVOUT[28] @ 0x0020 += 0x4;

    reg {
        name = "CIPHER_KEY";
        desc = "
            CPU configuration key registers: eight keys (host_key0..host_key7) of eight 32-bit words each. Each channel uses one key (selected by key_adder); several channels can share a key.

            DES: CIPHER_KEY[63:0] valid. 3DES, 3 keys: [191:0] (key 1 = [63:0], key 2 = [127:64], key 3 = [191:128]); 2 keys: [127:0]. AES: 128-bit key [127:0], 192-bit [191:0], 256-bit [255:0].
        ";
        field {
            name = "cipher_key";
            desc = "Key input of the CIPHER module. Each address maps to a 32-bit data segment: host_key0 is at 0x0090-0x00AC, host_key1 at 0x00B0-0x00CC, ... host_key7 at 0x0170-0x018C.";
            reset = 0x0;
        } cipher_key[31:0];
    } CIPHER_KEY[64] @ 0x0090 += 0x4;

    /* Channel 0 (single block), 0x1000 - 0x1020 */

    reg {
        name = "CHAN0_CIPHER_CTRL";
        desc = "
            Encryption/decryption control register of channel 0 (single-block channel). Configure it before the other registers of the CIPHER module. In the modes other than AES-CFB (DES/3DES: other than CFB and OFB), width must not be 0b01 or 0b10.

            !!! NOTE
                The data sheet bit diagram labels one of the reserved bits 12:11 `byte_seq`; the bit table calls both reserved.
        ";
        field { name = "key_adder"; desc = "ID of the key used by the current channel."; encode = CIPHER_MC_key_adder_enum; reset = 0x0; } key_adder[16:14];
        field { name = "key_sel"; desc = "Key select."; encode = CIPHER_MC_key_sel_enum; reset = 0x0; } key_sel[13:13];
        field { name = "key_length"; desc = "Key length select (AES / DES differ, see the values)."; encode = CIPHER_MC_key_length_enum; reset = 0x0; } key_length[10:9];
        field { name = "ivin_sel"; desc = "Input select of CIPHER_IVIN."; encode = CIPHER_MC_ivin_sel_enum; reset = 0x0; } ivin_sel[8:8];
        field { name = "width"; desc = "Bit width control (DES/3DES and AES differ, see the values)."; encode = CIPHER_MC_width_enum; reset = 0x0; } width[7:6];
        field { name = "alg_sel"; desc = "Algorithm select."; encode = CIPHER_MC_alg_sel_enum; reset = 0x0; } alg_sel[5:4];
        field { name = "mode"; desc = "Operating mode select. AES: ECB, CBC, CFB, OFB, CTR; DES/3DES: ECB, CBC, CFB, OFB; other values select ECB."; encode = CIPHER_MC_mode_enum; reset = 0x0; } mode[3:1];
        field { name = "decrypt"; desc = "Encryption/decryption select."; encode = CIPHER_MC_decrypt_enum; reset = 0x0; } decrypt[0:0];
    } CHAN0_CIPHER_CTRL @ 0x1000;

    reg {
        name = "CHAN0_CIPHER_IVIN";
        desc = "
            IV / counter input register of channel 0. Needed when the mode is not ECB and CHAN0_CIPHER_CTRL.ivin_sel = 1 (ignored with ivin_sel = 0). AES: IVIN[127:0] valid; DES/3DES: IVIN[63:0] valid.
        ";
        field {
            name = "chan0_cipher_ivin";
            desc = "128-bit IV of the CIPHER module for channel 0, or the data input from the counter. Each address maps to a 32-bit data segment (IVIN[31:0] at 0x1004 ... IVIN[127:96] at 0x1010).";
            reset = 0x0;
        } chan0_cipher_ivin[31:0];
    } CHAN0_CIPHER_IVIN[4] @ 0x1004 += 0x4;

    reg {
        name = "CHAN0_CIPHER_DIN";
        desc = "
            128-bit block input register for channel 0 (single-block operation). AES: with 1-CFB only bit[0] is valid, with 8-CFB bit[7:0], otherwise 128 bits. DES/3DES: with 1-CFB/1-OFB bit[0], with 8-CFB/8-OFB bit[7:0], otherwise the lower 64 bits.
        ";
        field {
            name = "chan0_cipher_din";
            desc = "128-bit block input of the CIPHER module for channel 0. Each address maps to a 32-bit data segment (DIN[31:0] at 0x1014 ... DIN[127:96] at 0x1020).";
            reset = 0x0;
        } chan0_cipher_din[31:0];
    } CHAN0_CIPHER_DIN[4] @ 0x1014 += 0x4;

    /* Channels 1-7: linked-list queues. One group per channel, base = 0x1000 + n x 0x80. */

    regfile eHISI_CIPHER_MC_CHAN {
        name = "CIPHER channel n queue registers (n = 1..7)";
        desc = "Registers of one linked-list channel; instantiated as CHAN1..CHAN7 at 0x1000 + n x 0x80.";

        reg {
            name = "CHANn_IBUF_NUM";
            desc = "Input queue total depth register: the count of linked list headers configured for the channel.";
            field { name = "ibuf_num"; desc = "Input queue depth, that is, the count of linked list headers configured for each channel."; reset = 0x0; } ibuf_num[15:0];
        } CHANn_IBUF_NUM @ 0x00;

        reg {
            name = "CHANn_IBUF_CNT";
            desc = "Pending data buffer count register of the input queue. When software writes it, the logic adds the written value to the register; after the logic processes a buffer the value is decremented by 1.";
            field { name = "ibuf_cnt"; desc = "Count of buffers to be processed in the input queue."; reset = 0x0; } ibuf_cnt[15:0];
        } CHANn_IBUF_CNT @ 0x04;

        reg {
            name = "CHANn_IEMPTY_CNT";
            desc = "Processed buffer count register of the input queue. When software writes it, the logic subtracts the written value; after the logic processes a buffer the value is incremented by 1.";
            field { name = "iempty_cnt"; desc = "Count of processed buffers in the input queue."; reset = 0x0; } iempty_cnt[15:0];
        } CHANn_IEMPTY_CNT @ 0x08;

        reg {
            name = "CHANn_INT_ICNTCFG";
            desc = "Input queue multi-packet interrupt threshold register. When the count of buffers processed from the input queue is above the threshold, an input queue interrupt is reported.";
            field { name = "int_icnt_cfg"; desc = "Input queue multi-packet interrupt threshold."; reset = 0x0; } int_icnt_cfg[15:0];
        } CHANn_INT_ICNTCFG @ 0x0C;

        reg {
            name = "CHANn_CIPHER_CTRL";
            desc = "
                Encryption/decryption control register of channel n. Configure it before using the channel. In the modes other than AES-CFB (DES/3DES: other than CFB and OFB), width must not be 0b01 or 0b10.

                !!! NOTE
                    The data sheet gives the weight field no access type ('-'); it is modelled read/write.
            ";
            field { name = "weight"; desc = "Weighted value of the current channel, in units of 64 bytes."; reset = 0x0; } weight[31:22];
            field { name = "key_adder"; desc = "ID of the key used by the current channel; any of the keys 0-7."; encode = CIPHER_MC_key_adder_enum; reset = 0x0; } key_adder[16:14];
            field { name = "key_sel"; desc = "Key select."; encode = CIPHER_MC_key_sel_enum; reset = 0x0; } key_sel[13:13];
            field { name = "key_length"; desc = "Key length select (AES / DES differ, see the values)."; encode = CIPHER_MC_key_length_enum; reset = 0x0; } key_length[10:9];
            field { name = "width"; desc = "Bit width control (DES/3DES and AES differ, see the values)."; encode = CIPHER_MC_width_enum; reset = 0x0; } width[7:6];
            field { name = "alg_sel"; desc = "Algorithm select."; encode = CIPHER_MC_alg_sel_enum; reset = 0x0; } alg_sel[5:4];
            field { name = "mode"; desc = "Operating mode select. AES: ECB, CBC, CFB, OFB, CTR; DES/3DES: ECB, CBC, CFB, OFB; other values select ECB."; encode = CIPHER_MC_mode_enum; reset = 0x0; } mode[3:1];
            field { name = "decrypt"; desc = "Encryption/decryption select."; encode = CIPHER_MC_decrypt_enum; reset = 0x0; } decrypt[0:0];
        } CHANn_CIPHER_CTRL @ 0x10;

        reg {
            name = "CHANn_SRC_LST_SADDR";
            desc = "Input queue start address register. The address must be word aligned.";
            field { name = "src_lst_saddr"; desc = "Start address of the input queue."; reset = 0x0; } src_lst_saddr[31:0];
        } CHANn_SRC_LST_SADDR @ 0x14;

        reg {
            name = "CHANn_IAGE_TIMER";
            desc = "Input queue interrupt aging time configuration register. If the aging time counter overflows and the count of processed buffers in the input queue is greater than 0, an input queue processing-complete interrupt is reported.";
            field { name = "iage_timer"; desc = "Aging interrupt timer."; reset = 0x0; } iage_timer[15:0];
        } CHANn_IAGE_TIMER @ 0x18;

        reg {
            name = "CHANn_OBUF_NUM";
            desc = "Output queue total depth register: the count of linked list headers configured for the channel.";
            field { name = "obuf_num"; desc = "Total depth of the output queue."; reset = 0x0; } obuf_num[15:0];
        } CHANn_OBUF_NUM @ 0x3C;

        reg {
            name = "CHANn_OBUF_CNT";
            desc = "Pending data buffer count register of the output queue. When software writes it, the logic adds the written value; after the logic processes a buffer the value is decremented by 1.";
            field { name = "obuf_cnt"; desc = "Count of buffers to be processed in the output queue."; reset = 0x0; } obuf_cnt[15:0];
        } CHANn_OBUF_CNT @ 0x40;

        reg {
            name = "CHANn_OFULL_CNT";
            desc = "Processed buffer count register of the output queue. When software writes it, the logic subtracts the written value; after the logic processes a buffer the value is incremented by 1.";
            field { name = "ofull_cnt"; desc = "Count of processed buffers in the output queue."; reset = 0x0; } ofull_cnt[15:0];
        } CHANn_OFULL_CNT @ 0x44;

        reg {
            name = "CHANn_INT_OCNTCFG";
            desc = "Output queue multi-packet interrupt threshold register. When the count of buffers processed in the output queue is above the threshold, an output queue interrupt is reported.";
            field { name = "int_ocnt_cfg"; desc = "Output queue multi-packet interrupt threshold."; reset = 0x0; } int_ocnt_cfg[15:0];
        } CHANn_INT_OCNTCFG @ 0x48;

        reg {
            name = "CHANn_DEST_LST_SADDR";
            desc = "Output queue start address register. The address must be word aligned.";
            field { name = "dest_lst_saddr"; desc = "Start address of the output queue."; reset = 0x0; } dest_lst_saddr[31:0];
        } CHANn_DEST_LST_SADDR @ 0x4C;

        reg {
            name = "CHANn_OAGE_TIMER";
            desc = "Output queue interrupt aging time configuration register. If the aging time counter overflows and the count of processed buffers in the output queue is greater than 0, an output queue processing-complete interrupt is reported.";
            field { name = "oage_timer"; desc = "Aging interrupt timer."; reset = 0x0; } oage_timer[15:0];
        } CHANn_OAGE_TIMER @ 0x50;
    };

    eHISI_CIPHER_MC_CHAN CHAN1 @ 0x1080;
    eHISI_CIPHER_MC_CHAN CHAN2 @ 0x1100;
    eHISI_CIPHER_MC_CHAN CHAN3 @ 0x1180;
    eHISI_CIPHER_MC_CHAN CHAN4 @ 0x1200;
    eHISI_CIPHER_MC_CHAN CHAN5 @ 0x1280;
    eHISI_CIPHER_MC_CHAN CHAN6 @ 0x1300;
    eHISI_CIPHER_MC_CHAN CHAN7 @ 0x1380;

    /* Interrupt and status block, 0x1400 - 0x1410 */
    reg {
        name = "INT_STATUS";
        desc = "Interrupt status register. Bit 0 is reserved (channel 0 has no output queue).";
        field { name = "ch7_ibuf_int"; desc = "Input queue data interrupt for channel 7."; sw = r; hw = w; reset = 0x0; } ch7_ibuf_int[15:15];
        field { name = "ch6_ibuf_int"; desc = "Input queue data interrupt for channel 6."; sw = r; hw = w; reset = 0x0; } ch6_ibuf_int[14:14];
        field { name = "ch5_ibuf_int"; desc = "Input queue data interrupt for channel 5."; sw = r; hw = w; reset = 0x0; } ch5_ibuf_int[13:13];
        field { name = "ch4_ibuf_int"; desc = "Input queue data interrupt for channel 4."; sw = r; hw = w; reset = 0x0; } ch4_ibuf_int[12:12];
        field { name = "ch3_ibuf_int"; desc = "Input queue data interrupt for channel 3."; sw = r; hw = w; reset = 0x0; } ch3_ibuf_int[11:11];
        field { name = "ch2_ibuf_int"; desc = "Input queue data interrupt for channel 2."; sw = r; hw = w; reset = 0x0; } ch2_ibuf_int[10:10];
        field { name = "ch1_ibuf_int"; desc = "Input queue data interrupt for channel 1."; sw = r; hw = w; reset = 0x0; } ch1_ibuf_int[9:9];
        field { name = "ch0_ibuf_int"; desc = "Data processing complete interrupt for channel 0."; sw = r; hw = w; reset = 0x0; } ch0_ibuf_int[8:8];
        field { name = "ch7_obuf_int"; desc = "Output queue data interrupt for channel 7."; sw = r; hw = w; reset = 0x0; } ch7_obuf_int[7:7];
        field { name = "ch6_obuf_int"; desc = "Output queue data interrupt for channel 6."; sw = r; hw = w; reset = 0x0; } ch6_obuf_int[6:6];
        field { name = "ch5_obuf_int"; desc = "Output queue data interrupt for channel 5."; sw = r; hw = w; reset = 0x0; } ch5_obuf_int[5:5];
        field { name = "ch4_obuf_int"; desc = "Output queue data interrupt for channel 4."; sw = r; hw = w; reset = 0x0; } ch4_obuf_int[4:4];
        field { name = "ch3_obuf_int"; desc = "Output queue data interrupt for channel 3."; sw = r; hw = w; reset = 0x0; } ch3_obuf_int[3:3];
        field { name = "ch2_obuf_int"; desc = "Output queue data interrupt for channel 2."; sw = r; hw = w; reset = 0x0; } ch2_obuf_int[2:2];
        field { name = "ch1_obuf_int"; desc = "Output queue data interrupt for channel 1."; sw = r; hw = w; reset = 0x0; } ch1_obuf_int[1:1];
    } INT_STATUS @ 0x1400;

    reg {
        name = "INT_EN";
        desc = "Interrupt enable register. Bit 0 is reserved.";
        field { name = "int_en"; desc = "Total interrupt enable for the CIPHER module."; encode = CIPHER_MC_enabled_enum; sw = rw; hw = r; reset = 0x0; } int_en[31:31];
        field { name = "ch7_ibuf_en"; desc = "Input queue data interrupt enable for channel 7."; encode = CIPHER_MC_enabled_enum; sw = rw; hw = r; reset = 0x0; } ch7_ibuf_en[15:15];
        field { name = "ch6_ibuf_en"; desc = "Input queue data interrupt enable for channel 6."; encode = CIPHER_MC_enabled_enum; sw = rw; hw = r; reset = 0x0; } ch6_ibuf_en[14:14];
        field { name = "ch5_ibuf_en"; desc = "Input queue data interrupt enable for channel 5."; encode = CIPHER_MC_enabled_enum; sw = rw; hw = r; reset = 0x0; } ch5_ibuf_en[13:13];
        field { name = "ch4_ibuf_en"; desc = "Input queue data interrupt enable for channel 4."; encode = CIPHER_MC_enabled_enum; sw = rw; hw = r; reset = 0x0; } ch4_ibuf_en[12:12];
        field { name = "ch3_ibuf_en"; desc = "Input queue data interrupt enable for channel 3."; encode = CIPHER_MC_enabled_enum; sw = rw; hw = r; reset = 0x0; } ch3_ibuf_en[11:11];
        field { name = "ch2_ibuf_en"; desc = "Input queue data interrupt enable for channel 2."; encode = CIPHER_MC_enabled_enum; sw = rw; hw = r; reset = 0x0; } ch2_ibuf_en[10:10];
        field { name = "ch1_ibuf_en"; desc = "Input queue data interrupt enable for channel 1."; encode = CIPHER_MC_enabled_enum; sw = rw; hw = r; reset = 0x0; } ch1_ibuf_en[9:9];
        field { name = "ch0_ibuf_en"; desc = "Data processing complete interrupt enable for channel 0."; encode = CIPHER_MC_enabled_enum; sw = rw; hw = r; reset = 0x0; } ch0_ibuf_en[8:8];
        field { name = "ch7_obuf_en"; desc = "Output queue data interrupt enable for channel 7."; encode = CIPHER_MC_enabled_enum; sw = rw; hw = r; reset = 0x0; } ch7_obuf_en[7:7];
        field { name = "ch6_obuf_en"; desc = "Output queue data interrupt enable for channel 6."; encode = CIPHER_MC_enabled_enum; sw = rw; hw = r; reset = 0x0; } ch6_obuf_en[6:6];
        field { name = "ch5_obuf_en"; desc = "Output queue data interrupt enable for channel 5."; encode = CIPHER_MC_enabled_enum; sw = rw; hw = r; reset = 0x0; } ch5_obuf_en[5:5];
        field { name = "ch4_obuf_en"; desc = "Output queue data interrupt enable for channel 4."; encode = CIPHER_MC_enabled_enum; sw = rw; hw = r; reset = 0x0; } ch4_obuf_en[4:4];
        field { name = "ch3_obuf_en"; desc = "Output queue data interrupt enable for channel 3."; encode = CIPHER_MC_enabled_enum; sw = rw; hw = r; reset = 0x0; } ch3_obuf_en[3:3];
        field { name = "ch2_obuf_en"; desc = "Output queue data interrupt enable for channel 2."; encode = CIPHER_MC_enabled_enum; sw = rw; hw = r; reset = 0x0; } ch2_obuf_en[2:2];
        field { name = "ch1_obuf_en"; desc = "Output queue data interrupt enable for channel 1."; encode = CIPHER_MC_enabled_enum; sw = rw; hw = r; reset = 0x0; } ch1_obuf_en[1:1];
    } INT_EN @ 0x1404;

    reg {
        name = "INT_RAW";
        desc = "Raw interrupt status register. The data sheet access type is RWC (read, write to clear); the clear polarity is not stated and is modelled as write-1-to-clear. Bit 0 is reserved.";
        field { name = "ch7_ibuf_raw"; desc = "Raw input queue data interrupt for channel 7."; sw = rw; onwrite = woclr; hw = w; reset = 0x0; } ch7_ibuf_raw[15:15];
        field { name = "ch6_ibuf_raw"; desc = "Raw input queue data interrupt for channel 6."; sw = rw; onwrite = woclr; hw = w; reset = 0x0; } ch6_ibuf_raw[14:14];
        field { name = "ch5_ibuf_raw"; desc = "Raw input queue data interrupt for channel 5."; sw = rw; onwrite = woclr; hw = w; reset = 0x0; } ch5_ibuf_raw[13:13];
        field { name = "ch4_ibuf_raw"; desc = "Raw input queue data interrupt for channel 4."; sw = rw; onwrite = woclr; hw = w; reset = 0x0; } ch4_ibuf_raw[12:12];
        field { name = "ch3_ibuf_raw"; desc = "Raw input queue data interrupt for channel 3."; sw = rw; onwrite = woclr; hw = w; reset = 0x0; } ch3_ibuf_raw[11:11];
        field { name = "ch2_ibuf_raw"; desc = "Raw input queue data interrupt for channel 2."; sw = rw; onwrite = woclr; hw = w; reset = 0x0; } ch2_ibuf_raw[10:10];
        field { name = "ch1_ibuf_raw"; desc = "Raw input queue data interrupt for channel 1."; sw = rw; onwrite = woclr; hw = w; reset = 0x0; } ch1_ibuf_raw[9:9];
        field { name = "ch0_ibuf_raw"; desc = "Raw data processing complete interrupt for channel 0."; sw = rw; onwrite = woclr; hw = w; reset = 0x0; } ch0_ibuf_raw[8:8];
        field { name = "ch7_obuf_raw"; desc = "Raw output queue data interrupt for channel 7."; sw = rw; onwrite = woclr; hw = w; reset = 0x0; } ch7_obuf_raw[7:7];
        field { name = "ch6_obuf_raw"; desc = "Raw output queue data interrupt for channel 6."; sw = rw; onwrite = woclr; hw = w; reset = 0x0; } ch6_obuf_raw[6:6];
        field { name = "ch5_obuf_raw"; desc = "Raw output queue data interrupt for channel 5."; sw = rw; onwrite = woclr; hw = w; reset = 0x0; } ch5_obuf_raw[5:5];
        field { name = "ch4_obuf_raw"; desc = "Raw output queue data interrupt for channel 4."; sw = rw; onwrite = woclr; hw = w; reset = 0x0; } ch4_obuf_raw[4:4];
        field { name = "ch3_obuf_raw"; desc = "Raw output queue data interrupt for channel 3."; sw = rw; onwrite = woclr; hw = w; reset = 0x0; } ch3_obuf_raw[3:3];
        field { name = "ch2_obuf_raw"; desc = "Raw output queue data interrupt for channel 2."; sw = rw; onwrite = woclr; hw = w; reset = 0x0; } ch2_obuf_raw[2:2];
        field { name = "ch1_obuf_raw"; desc = "Raw output queue data interrupt for channel 1."; sw = rw; onwrite = woclr; hw = w; reset = 0x0; } ch1_obuf_raw[1:1];
    } INT_RAW @ 0x1408;

    enum CIPHER_MC_rst_status_enum {
        RESETTING = 0x0 { desc = "The CIPHER module is being reset."; };
        WORKING   = 0x1 { desc = "The CIPHER module is working properly."; };
    };

    reg {
        name = "RST_STATUS";
        desc = "Reset status indicator register.";
        field {
            name = "rst_status";
            desc = "Reset status indicator of the CIPHER module.";
            encode = CIPHER_MC_rst_status_enum;
            sw = r;
            hw = w;
            reset = 0x0;
        } rst_status[0:0];
    } RST_STATUS @ 0x140C;

    reg {
        name = "CHAN0_CFG";
        desc = "Channel 0 configuration register.";
        field {
            name = "ch0_busy";
            desc = "Status signal of channel 0 (1 = busy).";
            sw = r;
            hw = w;
            reset = 0x0;
        } ch0_busy[1:1];

        field {
            name = "ch0_start";
            desc = "Encryption/decryption start signal of channel 0.";
            reset = 0x0;
        } ch0_start[0:0];
    } CHAN0_CFG @ 0x1410;
};
`endif
