`ifndef HISI_PWM_RDL
`define HISI_PWM_RDL

// Width of the period/duty counters: 26 bits (bit 25) on Hi3520D/Hi3515A/C, Hi3516C/Hi3518 V100, Hi3516A/D V100, Hi3518E V200, Hi3516C V300;
// 32 bits (bit 31) on Hi3516A V200, Hi3516A V300 and Hi3519 V101: define HISI_PWM_32BIT (the chip's defines.rdl) before including this file.
`ifdef HISI_PWM_32BIT
`define HISI_PWM_HI 31
`else
`define HISI_PWM_HI 25
`endif

// Number of PWM channels of one eHISI_PWM_GRP group (channel stride 0x20): 4 by default; the chip's defines.rdl may set it before the include.
`ifndef HISI_PWM_NCH
`define HISI_PWM_NCH 4
`endif


regfile eHISI_PWM {
    name = "HiSilicon PWM";
    desc = "
    HiSilicon PWM module at 0x20120000 (one instance, one independent output channel PWM0; the vendor platform headers list this address as DDRC1 for other chips, the Hi3520D data sheet Table 1-1 says PWM).
    Clock source selectable between 3 MHz and 24 MHz (PERI_CRG14); 26-bit period counter and 26-bit high-level counter; 10-bit pulse counter (max 1023 pulses, or infinite mode).
    Programming sequence (DS 14.8.3): select the clock in PERI_CRG14, wait until PWM0_STATE2[10] is 0 (idle), write PWM0_CFG0 (period), PWM0_CFG1 (high-level count), PWM0_CFG2 (pulse count), then set PWM0_CTRL[0]. Registers are from Hi3520D/Hi3515A/Hi3515C data sheet issue 07, chapter 14.8
    (`datasheet.txt` lines 59404-60060). No vendor driver source exists in the repo trees for this module; not hardware verified.

    One regfile describes one channel (offsets 0x00-0x18); the register and field names carry the channel number 0 whatever the channel (the data sheets print PWMn_* for channel n at base + n*0x20). eHISI_PWM_GRP below is an array of HISI_PWM_NCH such channels at stride 0x20 (instance it as PWM[n]); the Hi3520D/Hi3515 V100 chip files instance eHISI_PWM directly (one channel), the Hi3518E V200/Hi3516C V200 files four times.

    Cross-chip check (2026-11): the 7-register channel (CFG0..2, CTRL, STATE0..2: offsets, fields, access, resets, enums) was compared with the data sheets of Hi3516C V100 (13.9), Hi3518 V100 (13.9), Hi3516A/D V100 (13.9), Hi3516A V200 (12.12), Hi3516A V300 (Chinese, 12.10, watermarked), Hi3516C V300/Hi3516E V100 (12.10) and Hi3519 V101 (12.12) and with the vendor `pwm.c` register maps (openhisilicon): identical except the width of CFG0.pwm0_period, CFG1.pwm0_duty, STATE0.pwm0_period_st and STATE1.pwm0_duty_st, which is 32 bits on Hi3516A V200, Hi3516A V300 and Hi3519 V101 (macro HISI_PWM_32BIT; the Hi3516A V300 sheet feature list still says 26 bit but its register tables say [31:0]; low confidence) and 26 bits elsewhere; the Hi3516C V100 sheet words the duty as `equal to the number of cycles` (always high). Channels, base address and clock select per chip: Hi3516C V100 and Hi3518 V100 3 channels @0x20130000 (clock 3 MHz fixed); Hi3516A/D V100 8 channels, PWM0-3 @0x20130000 and PWM4-7 @0x20131000 (3/24/50 MHz via PERI_CRG14 and PERI_CRG65[10]); Hi3516A V200 and Hi3519 V101 8 channels @0x12130000 (3/24/50 MHz, PERI_CRG55); Hi3516C V300 4 channels @0x12130000 (PERI_CRG14); Hi3516A V300 2 channels @0x12070000 (PERI_CRG111[9:8]). No data sheet gives the PWM an interrupt. Hi3511, Hi3515 V100 and Hi3520 V100 have no PWM chapter. Hi3516 V100 has a different, older PWM (16-bit CFG, stride 0x10): see HISI_PWM_V1.rdl.

    Second pass (2026-11-11, scripted): 12 data-sheet editions against the RDL of all 15 chip roots that instantiate eHISI_PWM / eHISI_PWM_GRP / eHISI_PWM_V1_GRP (register offsets, total and per-bit resets, bit ranges, access, field names, PWMn at + n x 0x20, channel counts and base addresses): 0 differences. Data-sheet quirk kept as documented: the Hi3516A V300 guide lists 3 PWM interfaces in its feature list but 1 group of 2 channels in the PWM chapter (RDL: 2); Hi3516A/D print only PWM0 and give PWM4-7 as the second 4 KB window 0x20131000.
    ";

    reg {
        name = "PWM0 configuration 0 register";
        desc = "PWM0_CFG0 is PWM0 configuration 0 register.

Data sheet 14.8.4 PWM0_CFG0 (offset 0x0, printed page 14-138, `datasheet.txt` line 59489).";

        field {
            name = "pwm0_period";
            desc = "Number of cycles for PWM0. This field cannot be set to 0 or 1. Otherwise, the output level is high.";
            sw = rw;
            hw = r;
            reset = 0x18F;
        } pwm0_period[`HISI_PWM_HI:0];
    } PWM0_CFG0 @ 0x0;

    reg {
        name = "PWM0 configuration 1 register";
        desc = "PWM0_CFG1 is PWM0 configuration 1 register.

Data sheet 14.8.4 PWM0_CFG1 (offset 0x4, printed page 14-139, `datasheet.txt` line 59520).";

        field {
            name = "pwm0_duty";
            desc = "Number of level beats for PWM0. If the field value is greater than or equal to the number of cycles, the output level is always high (Hi3520D data sheet).";
            sw = rw;
            hw = r;
            reset = 0xC7;
        } pwm0_duty[`HISI_PWM_HI:0];
    } PWM0_CFG1 @ 0x4;

    reg {
        name = "PWM0 configuration 2 register";
        desc = "PWM0_CFG2 is PWM0 configuration 2 register.

Data sheet 14.8.4 PWM0_CFG2 (offset 0x8, printed page 14-139, `datasheet.txt` line 59542).";

        field {
            name = "pwm0_num";
            desc = "Number of square waves output by PWM0.";
            sw = rw;
            hw = r;
            reset = 0x0;
        } pwm0_num[9:0];
    } PWM0_CFG2 @ 0x8;

    reg {
        name = "PWM0 control register";
        desc = "PWM0_CTRL is PWM0 control register.

Data sheet 14.8.4 PWM0_CTRL (offset 0xC, printed page 14-140, `datasheet.txt` line 59570).";

        enum PWM0_CTRL_pwm0_keep_enum {
            NUMBER_SQUARE_WAVES = 0 { name = "Number Square Waves"; desc = "The number of square waves output by PWM0 is fixed."; };
            PWM0_ALWAYS_OUTPUTS = 1 { name = "Pwm0 Always Outputs"; desc = "PWM0 always outputs square waves."; };
        };

        field {
            name = "pwm0_keep";
            desc = "PWM output mode.";
            sw = rw;
            hw = r;
            encode = PWM0_CTRL_pwm0_keep_enum;
            reset = 0x0;
        } pwm0_keep[2:2];

        enum PWM0_CTRL_pwm0_inv_enum {
            PWM0_OUTPUTS_SQUARE = 0 { name = "Pwm0 Outputs Square"; desc = "PWM0 outputs square waves in normal mode."; };
            PWM0_OUTPUTS_SQUARE_2 = 1 { name = "Pwm0 Outputs Square 2"; desc = "PWM0 outputs square waves in inverted mode."; };
        };

        field {
            name = "pwm0_inv";
            desc = "PWM output control.";
            sw = rw;
            hw = r;
            encode = PWM0_CTRL_pwm0_inv_enum;
            reset = 0x0;
        } pwm0_inv[1:1];

        enum PWM0_CTRL_pwm0_enable_enum {
            DISABLED = 0 { name = "Disabled"; desc = "disabled"; };
            ENABLED = 1 { name = "Enabled"; desc = "enabled"; };
        };

        field {
            name = "pwm0_enable";
            desc = "PWM0 enable.";
            sw = rw;
            hw = r;
            encode = PWM0_CTRL_pwm0_enable_enum;
            reset = 0x0;
        } pwm0_enable[0:0];
    } PWM0_CTRL @ 0xC;

    reg {
        name = "PWM0 status 0 register";
        desc = "PWM0_STATE0 is PWM0 status 0 register.

Data sheet 14.8.4 PWM0_STATE0 (offset 0x10, printed page 14-140, `datasheet.txt` line 59605).";

        field {
            name = "pwm0_period_st";
            desc = "Number of count cycles for the internal module of PWM0.";
            sw = r;
            hw = w;
            reset = 0x0;
        } pwm0_period_st[`HISI_PWM_HI:0];
    } PWM0_STATE0 @ 0x10;

    reg {
        name = "PWM0 status 1 register";
        desc = "PWM0_STATE1 is PWM0 status 1 register.

Data sheet 14.8.4 PWM0_STATE1 (offset 0x14, printed page 14-141, `datasheet.txt` line 59632).";

        field {
            name = "pwm0_duty_st";
            desc = "Number of high level beats for the internal module of PWM0.";
            sw = r;
            hw = w;
            reset = 0x0;
        } pwm0_duty_st[`HISI_PWM_HI:0];
    } PWM0_STATE1 @ 0x14;

    reg {
        name = "PWM0 status 2 register";
        desc = "PWM0_STATE2 is PWM0 status 2 register.

Data sheet 14.8.4 PWM0_STATE2 (offset 0x18, printed page 14-141, `datasheet.txt` line 59651).";

        field {
            name = "pwm0_cnt_st";
            desc = "Number of remaining square waves output by PWM0. This field is valid only when the following conditions are met: pwm0_busy == 1, pwm0_keep_st == 0";
            sw = r;
            hw = w;
            reset = 0x0;
        } pwm0_cnt_st[21:12];

        enum PWM0_STATE2_pwm0_keep_st_enum {
            NUMBER_OUTPUT_SQUARE = 0 { name = "Number Output Square"; desc = "The number of output square waves is fixed."; };
            SQUARE_WAVES_ALWAYS = 1 { name = "Square Waves Always"; desc = "Square waves are always output."; };
        };

        field {
            name = "pwm0_keep_st";
            desc = "Square wave output mode for the internal module of PWM0.";
            sw = r;
            hw = w;
            encode = PWM0_STATE2_pwm0_keep_st_enum;
            reset = 0x0;
        } pwm0_keep_st[11:11];

        enum PWM0_STATE2_pwm0_busy_enum {
            WAVE_OUTPUT_COMPLETE = 0 { name = "Wave Output Complete"; desc = "Wave output is complete and PWM0 is idle."; };
            PWM0_OUTPUTTING_SQUARE = 1 { name = "Pwm0 Outputting Square"; desc = "PWM0 is outputting square waves."; };
        };

        field {
            name = "pwm0_busy";
            desc = "Working status of PWM0.";
            sw = r;
            hw = w;
            encode = PWM0_STATE2_pwm0_busy_enum;
            reset = 0x0;
        } pwm0_busy[10:10];

        field {
            name = "pwm0_period_st";
            desc = "Number of output square waves for the internal module of PWM0.";
            sw = r;
            hw = w;
            reset = 0x0;
        } pwm0_period_st[9:0];
    } PWM0_STATE2 @ 0x18;

};

// Group of HISI_PWM_NCH channels, stride 0x20 (data sheet PWMn base = group base + n * 0x20).
regfile eHISI_PWM_GRP {
    name = "HiSilicon PWM group";
    desc = "HISI_PWM_NCH (default 4) PWM channels, each an eHISI_PWM at base + n * 0x20; see eHISI_PWM.";

    eHISI_PWM PWM[`HISI_PWM_NCH] @ 0x0 += 0x20;
};

`endif
