`ifndef SYS_CTRL_RDL
`define SYS_CTRL_RDL

regfile eSYS_CTRL {
    name = "System Controller Registers";

    /* Useful enums to keep from having to keep copying them */
    enum SYSCTL_zero_enable_enum {
        ENABLE  = 0x0 { desc = "Enable"; };
        DISABLE = 0x1 { desc = "Disable"; };
    };

    enum SYSCTL_one_enable_enum {
        DISABLE = 0x0 { desc = "Disable"; };
        ENABLE  = 0x1 { desc = "Enable"; };
    };

    /* Fields */

    reg {
        name = "System control register";
        desc = "It is used to specify the operations to be performed by the system. Hardware (Hi3520D V100 board, read on hardware 2026-11-08, stock U-Boot prompt after a cold boot): reads 0x00150124: modectrl = 4 and modestatus = 4 (NORMAL), remapstat = 0 (remap cleared), bits 20:16 = 0x15 (timer clock selects); reset here 0x212 (SLOW, remap active). Boot value (the BootROM and the boot code switch the system to normal mode and clear the remap), not a reset value.";

`ifdef SYS_CTRL_timeren7ov_31_FIELD
        enum SC_CTRL_timeren7ov_enum {
            REF_CLK = 0x0 { desc = "The enable signal is obtained by using the reference clock, and the selection of the reference clock is specified by [timeren7sel]"; };
            BUS_CLK = 0x1 { desc = "Counting by the bus clock."; };
        };

        field {
            name = "timeren7ov";
            desc = "Timer7 count clock selection.";
            encode = SC_CTRL_timeren7ov_enum;
            reset = 0x0;
        } timeren7ov[31:31];
`endif
        enum SC_CTRL_timerenNsel_enum {
            MHz3 = 0x0 { desc = "Use 3MHz clock for counting"; };
            // RESERVED = 0x1 { desc = "Reserved"; };
        };

`ifdef SYS_CTRL_timeren7sel_30_FIELD
        field {
            name = "timeren7sel";
            desc = " Timer7 counting clock frequency selection. Must be configured as 0. ";
            encode = SC_CTRL_timerenNsel_enum;
            reset = 0x0;
        } timeren7sel[30:30];
`endif

`ifdef SYS_CTRL_timeren6ov_29_FIELD
        enum SC_CTRL_timeren6ov_enum {
            REF_CLK = 0x0 { desc = "The enable signal is obtained by using the reference clock, and the selection of the reference clock is specified by [timeren6sel]"; };
            BUS_CLK = 0x1 { desc = "Counting by the bus clock."; };
        };

        field {
            name = "timeren6ov";
            desc = "Timer6 count clock selection.";
            encode = SC_CTRL_timeren6ov_enum;
            reset = 0x0;
        } timeren6ov[29:29];
`endif

`ifdef SYS_CTRL_timeren6sel_28_FIELD
        field {
            name = "timeren6sel";
            desc = "Timer6 counting clock frequency selection. Must be configured as 0.";
            encode = SC_CTRL_timerenNsel_enum;
            reset = 0x0;
        } timeren6sel[28:28];
`endif

`ifdef SYS_CTRL_timeren5ov_27_FIELD
        enum SC_CTRL_timeren5ov_enum {
            REF_CLK = 0x0 { desc = "The enable signal is obtained by using the reference clock, and the selection of the reference clock is specified by [timeren5sel]"; };
            BUS_CLK = 0x1 { desc = "Counting by the bus clock."; };
        };

        field {
            name = "timeren5ov";
            desc = " Timer5 count clock selection.";
            encode = SC_CTRL_timeren5ov_enum;
            reset = 0x0;
        } timeren5ov[27:27];
`endif

`ifdef SYS_CTRL_timeren5sel_26_FIELD
        enum SC_CTRL_timeren5sel_enum {
            MHz3 = 0x0 { desc = "Use 3MHz clock for counting"; };
            // RESERVED = 0x1 { desc = "Reserved"; };
        };

        field {
            name = "timeren5sel";
            desc = "Timer5 counting clock frequency selection. Must be configured as 0.";
            encode = SC_CTRL_timerenNsel_enum;
            reset = 0x0;
        } timeren5sel[26:26];
`endif

`ifdef SYS_CTRL_timeren4ov_25_FIELD
        enum SC_CTRL_timeren4ov_enum {
            REF_CLK = 0x0 { desc = "The enable signal is obtained by using the reference clock, and the selection of the reference clock is specified by [timeren4sel]"; };
            BUS_CLK = 0x1 { desc = "Counting by the bus clock."; };
        };

        field {
            name = "timeren4ov";
            desc = "Timer4 count clock selection.";
            encode = SC_CTRL_timeren4ov_enum;
            reset = 0x0;
        } timeren4ov[25:25];
`endif

`ifdef SYS_CTRL_timeren4sel_24_FIELD
        field {
            name = "timeren4sel";
            desc = "Timer4 counting clock frequency selection. Must be configured as 0.";
            encode = SC_CTRL_timerenNsel_enum;
            reset = 0x0;
        } timeren4sel[24:24];
`endif

`ifdef SYS_CTRL_wdogenov_23_FIELD
        enum SC_CTRL_wdogenov_enum {
            MHz3    = 0x0 { desc = "WDG uses 3MHz clock for counting."; };
            BUS_CLK = 0x1 { desc = "WDG uses the bus clock for counting."; };
        };

        field {
            name = "wdogenov";
            desc = "WDG count clock selection.";
            encode = SC_CTRL_wdogenov_enum;
            reset = 0x0;
        } wdogenov[23:23];
`endif

`ifdef SYS_CTRL_timeren7ov_23_FIELD
        enum SC_CTRL_timeren7ov_enum {
            REF_CLK = 0x0 { desc = "The enable signal is obtained by using the reference clock, and the selection of the reference clock is specified by [timeren7sel]"; };
            BUS_CLK = 0x1 { desc = "Counting by the bus clock."; };
        };

        field {
            name = "timeren7ov";
            desc = "Timer7 count clock selection.";
            encode = SC_CTRL_timeren7ov_enum;
            reset = 0x0;
        } timeren7ov[23:23];
`endif

`ifdef SYS_CTRL_timeren3ov_22_FIELD
        enum SC_CTRL_timeren3ov_enum {
            REF_CLK = 0x0 { desc = "The enable signal is obtained by using the reference clock, and the selection of the reference clock is specified by [timeren3sel]"; };
            BUS_CLK = 0x1 { desc = "Counting by the bus clock."; };
        };

        field {
            name = "timeren3ov";
            desc = "Timer3 count clock selection.";
            encode = SC_CTRL_timeren3ov_enum;
            reset = 0x0;
        } timeren3ov[22:22];
`endif

`ifdef SYS_CTRL_timeren6ov_22_FIELD
        enum SC_CTRL_timeren6ov_enum {
            REF_CLK = 0x0 { desc = "The enable signal is obtained by using the reference clock, and the selection of the reference clock is specified by [timeren6sel]"; };
            BUS_CLK = 0x1 { desc = "Counting by the bus clock."; };
        };

        field {
            name = "timeren6ov";
            desc = "Timer6 count clock selection.";
            encode = SC_CTRL_timeren6ov_enum;
            reset = 0x0;
        } timeren6ov[22:22];
`endif

`ifdef SYS_CTRL_timeren3sel_21_FIELD
        field {
            name = "timeren3sel";
            desc = "Timer3 counting clock frequency selection. Must be configured as 0.";
            encode = SC_CTRL_timerenNsel_enum;
            reset = 0x0;
        } timeren3sel[21:21];
`endif

`ifdef SYS_CTRL_timeren5ov_21_FIELD
        enum SC_CTRL_timeren5ov_enum {
            REF_CLK = 0x0 { desc = "The enable signal is obtained by using the reference clock, and the selection of the reference clock is specified by [timeren5sel]"; };
            BUS_CLK = 0x1 { desc = "Counting by the bus clock."; };
        };

        field {
            name = "timeren5ov";
            desc = "Timer5 count clock selection.";
            encode = SC_CTRL_timeren5ov_enum;
            reset = 0x0;
        } timeren5ov[21:21];
`endif

`ifdef SYS_CTRL_timeren2ov_20_FIELD
        enum SC_CTRL_timeren2ov_enum {
            REF_CLK = 0x0 { desc = "The enable signal is obtained by using the reference clock, and the selection of the reference clock is specified by [timeren2sel]"; };
            BUS_CLK = 0x1 { desc = "Counting by the bus clock."; };
        };

        field {
            name = "timeren2ov";
            desc = "Timer2 count clock selection.";
            encode = SC_CTRL_timeren2ov_enum;
            reset = 0x0;
        } timeren2ov[20:20];
`endif

`ifdef SYS_CTRL_timeren4ov_20_FIELD
        enum SC_CTRL_timeren4ov_enum {
            REF_CLK = 0x0 { desc = "The enable signal is obtained by using the reference clock, and the selection of the reference clock is specified by [timeren4sel]"; };
            BUS_CLK = 0x1 { desc = "Counting by the bus clock."; };
        };

        field {
            name = "timeren4ov";
            desc = "Timer4 count clock selection.";
            encode = SC_CTRL_timeren4ov_enum;
            reset = 0x0;
        } timeren4ov[20:20];
`endif

`ifdef SYS_CTRL_timeren2sel_19_FIELD
        field {
            name = "timeren2sel";
            desc = "Timer2 counting clock frequency selection. Must be configured as 0.";
            encode = SC_CTRL_timerenNsel_enum;
            reset = 0x0;
        } timeren2sel[19:19];
`endif

`ifdef SYS_CTRL_timeren3ov_19_FIELD
        enum SC_CTRL_timeren3ov_enum {
            REF_CLK = 0x0 { desc = "The enable signal is obtained by using the reference clock, and the selection of the reference clock is specified by [timeren3sel]"; };
            BUS_CLK = 0x1 { desc = "Counting by the bus clock."; };
        };

        field {
            name = "timeren3ov";
            desc = "Timer3 count clock selection.";
            encode = SC_CTRL_timeren3ov_enum;
            reset = 0x0;
        } timeren3ov[19:19];
`endif

`ifdef SYS_CTRL_timeren1ov_18_FIELD
        enum SC_CTRL_timeren1ov_enum {
            REF_CLK = 0x0 { desc = "The enable signal is obtained by using the reference clock, and the selection of the reference clock is specified by [timeren1sel]"; };
            BUS_CLK = 0x1 { desc = "Counting by the bus clock."; };
        };

        field {
            name = "timeren1ov";
            desc = "Timer1 count clock selection.";
            encode = SC_CTRL_timeren1ov_enum;
            reset = 0x0;
        } timeren1ov[18:18];
`endif

`ifdef SYS_CTRL_timeren2ov_18_FIELD
        enum SC_CTRL_timeren2ov_enum {
            REF_CLK = 0x0 { desc = "The enable signal is obtained by using the reference clock, and the selection of the reference clock is specified by [timeren2sel]"; };
            BUS_CLK = 0x1 { desc = "Counting by the bus clock."; };
        };

        field {
            name = "timeren2ov";
            desc = "Timer2 count clock selection.";
            encode = SC_CTRL_timeren2ov_enum;
            reset = 0x0;
        } timeren2ov[18:18];
`endif

`ifdef SYS_CTRL_timeren1sel_17_FIELD
        field {
            name = "timeren1sel";
            desc = "Timer1 counting clock frequency selection. Must be configured as 0.";
            encode = SC_CTRL_timerenNsel_enum;
            reset = 0x0;
        } timeren1sel[17:17];
`endif

`ifdef SYS_CTRL_timeren1ov_17_FIELD
        enum SC_CTRL_timeren1ov_enum {
            REF_CLK = 0x0 { desc = "The enable signal is obtained by using the reference clock, and the selection of the reference clock is specified by [timeren1sel]"; };
            BUS_CLK = 0x1 { desc = "Counting by the bus clock."; };
        };

        field {
            name = "timeren1ov";
            desc = "Timer1 count clock selection.";
            encode = SC_CTRL_timeren1ov_enum;
            reset = 0x0;
        } timeren1ov[17:17];
`endif

`ifdef SYS_CTRL_timeren0ov_16_FIELD
        enum SC_CTRL_timeren0ov_enum {
            REF_CLK = 0x0 { desc = "The enable signal is obtained by using the reference clock, and the selection of the reference clock is specified by [timeren0sel]"; };
            BUS_CLK = 0x1 { desc = "Counting by the bus clock."; };
        };

        field {
            name = "timeren0ov";
            desc = "Timer0 count clock selection.";
            encode = SC_CTRL_timeren0ov_enum;
            reset = 0x0;
        } timeren0ov[16:16];
`endif

`ifdef SYS_CTRL_timeren0sel_15_FIELD
        field {
            name = "timeren0sel";
            desc = "Timer0 counting clock frequency selection. Must be configured as 0.";
            encode = SC_CTRL_timerenNsel_enum;
            reset = 0x0;
        } timeren0sel[15:15];
`endif

        enum SC_CTRL_remapstat_enum {
            NO_REMAP = 0x0 { desc = "No address remapping."; };
            REMAP    = 0x1 { desc = "Perform address remapping. bootrom or SFC CS1 is remapped to address 0."; };
        };

        field {
            name = "remapstat";
            desc = "Status of address remapping.";
            encode = SC_CTRL_remapstat_enum;
            sw=r;
            hw=w;
            reset = 0x1;
        } remapstat[9:9];

        enum SC_CTRL_remapclear_enum {
            KEEP  = 0x0 { desc = "Keep Remap status."; };
            CLEAR = 0x1 { desc = "Clear Remap."; };
        };

        field {
            name = "remapclear";
            desc = "
                Address remapping clears the selection.
                For the address mapping relationship before and after Clear Remap, see Address Allocation.
            ";
            encode = SC_CTRL_remapclear_enum;
            reset = 0x0;
        } remapclear[8:8];

`ifdef SYS_CTRL_modestatus_FIELD
        enum SC_CTRL_modestatus_enum {
            // Reserved       = 0x0 { desc = "Reserved"; };
            DOZE            = 0x1 { desc = "DOZE"; };
            SLOW            = 0x2 { desc = "SLOW"; };
            XTAL_CTL        = 0x3 { desc = "XTAL CTL"; };
            NORMAL          = 0x4 { desc = "NORMAL"; };
            // Reserved       = 0x5 { desc = "Reserved"; };
            PLL_CTL         = 0x6 { desc = "PLL CTL"; };
            // Reserved       = 0x7 { desc = "Reserved"; };
            // Reserved       = 0x8 { desc = "Reserved"; };
            SW_from_XTAL    = 0x9 { desc = "SW from XTAL"; };
            SW_from_PLL     = 0xA { desc = "SW from PLL"; };
            SW_to_XTAL      = 0xB { desc = "SW to XTAL"; };
            // Reserved       = 0xC { desc = "Reserved"; };
            // Reserved       = 0xD { desc = "Reserved"; };
            SW_to_PLL       = 0xE { desc = "SW to PLL"; };
            // Reserved       = 0xF { desc = "Reserved"; };
        };

        field {
            name = "modestatus";
            desc = "Mode status bits. Indicates the current operating mode of the system. Read-only.";
            encode = SC_CTRL_modestatus_enum;
            sw = r;
            hw = w;
            reset = 0x2;
        } modestatus[6:3];
`endif

`ifdef SYS_CTRL_modectrl_FIELD
        enum SC_CTRL_modectrl_enum {
            // Reserved   = 0x0 { desc = "Reserved"; };
            DOZE        = 0x1 { desc = "DOZE"; };
            // The data sheets give ranges: 01X = slow, 1XX = normal
            SLOW        = 0x2 { desc = "SLOW (01X)"; };
            SLOW_1      = 0x3 { desc = "SLOW (01X)"; };
            NORMAL      = 0x4 { desc = "NORMAL (1XX)"; };
            NORMAL_1    = 0x5 { desc = "NORMAL (1XX)"; };
            NORMAL_2    = 0x6 { desc = "NORMAL (1XX)"; };
            NORMAL_3    = 0x7 { desc = "NORMAL (1XX)"; };
        };

        field {
            name = "modectrl";
            desc = "Mode control bit. Defines the operating modes that the system controller is required to enter.";
            encode = SC_CTRL_modectrl_enum;
            reset = 0x2;
        } modectrl[2:0];
`endif

    } CTRL @ 0x0000;

    reg {
        name = "System soft reset register";
        desc = "
            When a value is written to this register, the system controller
            sends a system soft reset request to the reset module.
            Then the reset module resets the system.

            !!! Caution
                Write protection for this register can be enabled by configuring
                SC_LOCKEN. This register can be written only when write protection
                is disabled.
         Hardware (Hi3520D V100 board, read on hardware 2026-11-08, stock U-Boot prompt after a cold boot): reads 0x00000002; the register is write-any-value (software reset), so the value read back says nothing about its reset.";

        field {
            name = "softresreq";
            desc = "Any write operation to this register will cause a soft reset of the system.";
            sw=w;
`ifdef SYS_CTRL_RESET_G2
            reset = 0x2;    // Hi3520D: original data sheet total reset value 0x0000_0002; the hardware reads 0x2
`endif
`ifdef SYS_CTRL_RESET_G3
            reset = 0x2;
`endif
        } softresreq[31:0];

    } SYSRES @ 0x0004;

`ifdef SYS_CTRL_IMCTRL_REG
    reg {
        name = "Interrupt mode control register";
        desc = "The interrupt mode control register. Used to control the system mode when an interrupt occurs.";

        enum itmdctrl_inmdtype_enum {
            FIQ_ONLY    = 0x0 { desc = "Only FIQ interrupt can make the system enter interrupt mode."; };
            FIQ_AND_IRQ = 0x1 { desc = "Both FIQ interrupt and IRQ interrupt can make the system enter interrupt mode."; };
        };

        field {
            name = "inmdtype";
            desc = "The type of interrupt that triggers the system to enter interrupt mode.";
            encode = itmdctrl_inmdtype_enum;
            reset = 0x0;
        } inmdtype[7:7];

        enum itmdctrl_modectrl_enum {
            SLEEP    = 0x0 { desc = "SLEEP"; };
            DOZE     = 0x1 { desc = "DOZE"; };
            // The data sheets give ranges: 01X = slow, 1XX = normal
            SLOW     = 0x2 { desc = "SLOW (01X)"; };
            SLOW_1   = 0x3 { desc = "SLOW (01X)"; };
            NORMAL   = 0x4 { desc = "NORMAL (1XX)"; };
            NORMAL_1 = 0x5 { desc = "NORMAL (1XX)"; };
            NORMAL_2 = 0x6 { desc = "NORMAL (1XX)"; };
            NORMAL_3 = 0x7 { desc = "NORMAL (1XX)"; };
        };

        field {
            name = "itmdctrl";
            desc = "The lowest working mode of the system in interrupt mode, the value of this register is ORed with the value of SC_CTRL[modectrl] as the working mode of the system after the interrupt occurs.";
            encode = itmdctrl_modectrl_enum;
            reset = 0x0;
        } itmdctrl[3:1];

        enum itmdctrl_itm_enum {
            FORBIDDEN = 0x0 { desc = "Forbidden."; };
            ENABLE    = 0x1 { desc = "Enable (enter interrupt mode when interrupt occurs)."; };
        };

        field {
            name = "itm";
            desc = "Interrupt mode enable.";
            encode = itmdctrl_itm_enum;
            reset = 0x0;
        } itmden[0:0];

    } IMCTRL @ 0x0008;
`endif

`ifdef SYS_CTRL_IMSTAT_REG
    reg {
        name = "Interrupt mode status register";
        desc = "
            The interrupt mode status register. It is used to monitor whether the system is in the interrupt mode, and the system can also be forced to enter the interrupt mode by configuring this register.

            !!! Caution
                The interrupt mode must be cleared manually when the interrupt service routine is finished.
        ";

        field {
            name = "itmdstat";
            desc = "
                Interrupt mode status. Can be used for software control to directly enter interrupt mode.

                When reading this register:
                0: Not currently in interrupt mode.
                1: Currently in interrupt mode.

                When writing this register:
                0: Software does not control to enter interrupt mode.
                1: Software controls to enter interrupt mode.
            ";
            reset = 0x0;
        } itmdstat[0:0];

    } IMSTAT @ 0x000C;
`endif

`ifdef SYS_CTRL_XTALCTRL_REG
    reg {
        name = "Crystal oscillator control register";
        desc = "The crystal oscillator control register. It is used to control the stable waiting time of the initialization clock module, that is, the waiting time for jumping from the XTAL CTL intermediate state to the SW to XTAL intermediate state.";

        field {
            name = "xtaltime";
            desc = "
                Crystal switching wait time.
                The value of this field is used to specify the waiting time for switching from XTAL CTL state to SW to XTAL state when the system mode is switched. The number of waiting cycles can be calculated (T46.8K is a 46.8KHz low-frequency clock cycle): (65536 – xtaltime)xT46.8K.
            ";
            reset = 0x0;
        } xtaltime[18:3];

    } XTALCTRL @ 0x0010;
`endif

`ifdef SYS_CTRL_PLLCTRL_REG
    reg {
        name = "PLL control register";
        desc = "
            The PLL control register. It is used to control the enable control of the on-chip ARM phase-locked loop (ARMPLL), which is enabled by software control or by system mode switching. In addition, this register is also used to set the ARMPLL PLL stabilization wait time.

            !!! Caution
                This register can be write-protected by the register SC_LOCKEN, and the write operation to this register is valid only when the write protection is disabled.

            When it is in the 'Enable ARMPLL phase-locked loop controlled by system mode switching' (controlled by SC_PLLCTRL[pllover]), ARMPLL is automatically turned off when the system is in non-NORMAL mode. The clock frequency of ARMPLL is controlled by CRG registers PERI_CRG0 and PERI_CRG1. The system requires the PLL to wait for 0.5ms to output a stable clock when changing the frequency configuration. Therefore, the plltime configuration of this register must meet this requirement.
         Hardware (Hi3520D V100 board, read on hardware 2026-11-08, stock U-Boot prompt after a cold boot): reads 0x0FFF8000, reset here 0. Boot value (written by the boot table), not taken as the reset value.";

        field {
            name = "plltime";
            desc = "
                ARMPLL PLL stabilization wait time. This period of time is used to wait for the PLL to start and the PLL output to reach a stable state, which is to specify the waiting time for switching from the PLL CTL state to the SW to PLL state when switching from the system mode. The timeout value is calculated by the following formula (TXIN is the clock cycle of the external crystal oscillator): (33554432 - plltime)xTXIN.
            ";
            reset = 0x0;
        } plltime[27:3];

        enum SC_PLLCTRL_pllover_enum {
            MODE_SWITCHING = 0x0 { desc = "ARMPLL is enabled by system mode switching (hardware controlled)."; };
            RESERVED       = 0x1 { desc = "Reserved. The bit must be configured as 0."; };
        };

        field {
            name = "pllover";
            desc = "ARMPLL enable control. Must be configured as 0: ARMPLL is enabled through system mode switching.";
            encode = SC_PLLCTRL_pllover_enum;
            reset = 0x0;
        } pllover[0:0];

    } PLLCTRL @ 0x0014;
`endif

`ifdef SYS_CTRL_PLLFCTRL_REG
    reg {
        name = "PLL Frequency Control Register";
        desc = "
            Used to control the frequency of ARMPLL and enable the bypass function. When ARMPLL needs to be bypassed, set the SC_PLLFCTRL[armpll_bypass] bit to 1. At this time, ARMPLL outputs and external crystal oscillator clock.

            The phase locked loop output clock frequency is calculated by this formula: `Fpll = Fxin * M/(N*2^OD)`

            Where:

                * `M` >= 2
                * `N` >= 2
                * 1MHz <= `Fxin/N` <= 25MHz
                * 200MHz <= `Fpll*2^OD` <= 1GHz

            * `Fxin` is the clock frequency of the external crystal oscillator
            * `Fpll` is the PLL output clock
            * `M`, `N`, and `OD` are configured with the corresponding bits in the register
        ";

        enum SC_PLLCTRL_armpll_bypass_enum {
            NO_BYPASS = 0x0 { desc = "Don't bypass"; };
            BYPASS    = 0x1 { desc = "Bypass"; };
        };

        field {
            name = "armpll_bypass";
            desc = "ARMPLL clock divider bypass control.";
            encode = SC_PLLCTRL_armpll_bypass_enum;
`ifdef SYS_CTRL_RESET_G1
            reset = 0x0;
`endif
        } armpll_bypass[14:14];

        field {
            name = "armpll_od";
            desc = "ARM clock frequency division control, OD, output frequency division coefficient";
`ifdef SYS_CTRL_RESET_G1
            reset = 0x0;
`endif
        } armpll_od[13:12];

        field {
            name = "armpll_m";
            desc = "ARM clock frequency division control, M, multiplication factor";
`ifdef SYS_CTRL_RESET_G1
            reset = 0x90;
`endif
        } armpll_m[11:4];

        field {
            name = "armpll_n";
            desc = "ARM clock frequency division control, N, frequency division coefficient";
`ifdef SYS_CTRL_RESET_G1
            reset = 0x9;
`endif
        } armpll_n[3:0];

    } PLLFCTRL @ 0x0018;
`endif

`ifdef SYS_CTRL_PERIPHCTRL0_REG
    reg {
        name = "Peripheral control register 0";
        desc = "
            The peripheral control register 0.

            !!! Caution
                This register can be write-protected by the register SC_LOCKEN, and the write operation to this register is valid only when the write protection is disabled.
        ";
`ifdef SYS_CTRL_PERIPHCTRL0_VAR1
        field {
            name = "i2c_srst";
            reset = 0x0;
        } i2c_srst[25:25];

        field {
            name = "uart2_srst";
            reset = 0x0;
        } uart2_srst[24:24];

        field {
            name = "rtc_srst";
            reset = 0x0;
        } rtc_srst[23:23];

        field {
            name = "usb_srst";
            reset = 0x0;
        } usb_srst[22:22];

        field {
            name = "otg_srst";
            reset = 0x0;
        } otg_srst[21:21];

        field {
            name = "armcore_srst";
            reset = 0x0;
        } armcore_srst[20:20];

        field {
            name = "vo_srst";
            reset = 0x0;
        } vo_srst[19:19];

        field {
            name = "vi3_srst";
            reset = 0x0;
        } vi3_srst[18:18];

        field {
            name = "vi2_srst";
            reset = 0x0;
        } vi2_srst[17:17];

        field {
            name = "vi1_srst";
            reset = 0x0;
        } vi1_srst[16:16];

        field {
            name = "vi0_srst";
            reset = 0x0;
        } vi0_srst[15:15];

        field {
            name = "vi_srst";
            reset = 0x0;
        } vi_srst[14:14];

        field {
            name = "smi_srst";
            reset = 0x0;
        } smi_srst[13:13];

        field {
            name = "eth_srst";
            reset = 0x0;
        } eth_srst[12:12];

        field {
            name = "sio1_srst";
            reset = 0x0;
        } sio1_srst[11:11];

        field {
            name = "sio0_srst";
            reset = 0x0;
        } sio0_srst[10:10];

        field {
            name = "mmc_srst";
            reset = 0x0;
        } mmc_srst[9:9];

        field {
            name = "pci_srst";
            reset = 0x0;
        } pci_srst[8:8];

        field {
            name = "ir_srst";
            reset = 0x0;
        } ir_srst[7:7];

        field {
            name = "ssp_srst";
            reset = 0x0;
        } ssp_srst[6:6];

        field {
            name = "uart1_srst";
            reset = 0x0;
        } uart1_srst[5:5];

        field {
            name = "uart0_srst";
            reset = 0x0;
        } uart0_srst[4:4];

        field {
            name = "dsu_srst";
            reset = 0x0;
        } dsu_srst[3:3];

        field {
            name = "cipher_srst";
            reset = 0x0;
        } cipher_srst[2:2];

        field {
            name = "vedu_srst";
            reset = 0x0;
        } vedu_srst[0:0];
`endif
`ifdef SYS_CTRL_PERIPHCTRL0_VAR2
        field {
            name = "apll_dsmpd";
            reset = 0x0;
        } apll_dsmpd[31:31];

        field {
            name = "apll_bypass";
            reset = 0x0;
        } apll_bypass[30:30];

        field {
            name = "apll_postdiv2";
            reset = 0x0;
        } apll_postdiv2[29:27];

        field {
            name = "apll_postdiv1";
            reset = 0x0;
        } apll_postdiv1[26:24];

        field {
            name = "apll_frac";
            reset = 0x0;
        } apll_frac[23:0];
`endif
`ifdef SYS_CTRL_PERIPHCTRL0_VAR3
        field {
            name = "ddr_odis_datah";
            reset = 0x0;
        } ddr_odis_datah[9:9];

        field {
            name = "ddr_odis_datal";
            reset = 0x0;
        } ddr_odis_datal[8:8];

        field {
            name = "cpu_set";
            reset = 0x0;
        } cpu_set[2:0];
`endif
`ifdef SYS_CTRL_PERIPHCTRL0_VAR4
        field {
            name = "arm_tcm_gate_en";
            reset = 0x0;
        } arm_tcm_gate_en[22:22];

        field {
            name = "arm_mem_adjust";
            reset = 0x22;
        } arm_mem_adjust[21:16];

        field {
            name = "global_software_int";
            reset = 0x0;
        } global_software_int[14:14];

        field {
            name = "ddrc_apb_gt_en";
        } ddrc_apb_gt_en[12:12];
`endif
`ifdef SYS_CTRL_PERIPHCTRL0_VAR5
        enum PERIPHCTRL0_ddrc_apb_gt_en_enum {
            DISABLE = 0x0 { desc = "disabled"; };
            ENABLE = 0x1 { desc = "enabled"; };
        };

        field {
            name = "ddrc_apb_gt_en";
            encode = PERIPHCTRL0_ddrc_apb_gt_en_enum;
            reset = 0x1;
        } ddrc_apb_gt_en[12:12];

        enum PERIPHCTRL0_cfgsdisable_enum {
            DISABLE = 0x0 { desc = "disabled"; };
            ENABLE = 0x1 { desc = "enabled"; };
        };

        field {
            name = "cfgsdisable";
            encode = PERIPHCTRL0_cfgsdisable_enum;
            reset = 0x0;
        } cfgsdisable[4:4];

        enum PERIPHCTRL0_cfgnmfi_enum {
            DISABLE = 0x0 { desc = "disabled"; };
            SET_FIQS_CPU = 0x1 { desc = "set the FIQs of CPU to NMIs"; };
        };

        field {
            name = "cfgnmfi";
            encode = PERIPHCTRL0_cfgnmfi_enum;
            reset = 0x0;
        } cfgnmfi[2:2];

        enum PERIPHCTRL0_cp15sdisable_enum {
            DISABLE = 0x0 { desc = "disabled"; };
            ENABLE = 0x1 { desc = "enable"; };
        };

        field {
            name = "cp15sdisable";
            encode = PERIPHCTRL0_cp15sdisable_enum;
            reset = 0x0;
        } cp15sdisable[0:0];
`endif
    } PERIPHCTRL0 @ 0x001C;
`endif

`ifdef SYS_CTRL_SOFT_INT_REG
    reg {
        name = "Software Interrupt Register";

        enum SOFT_INT_software_int_enum {
            NO_INTERRUPT = 0x0 { desc = "No interrupt is generated."; };
            INTERRUPT    = 0x1 { desc = "An interrupt is generated."; };
        };

        field {
            name = "software_int";
            desc = "Software Interrupt";
            encode = SOFT_INT_software_int_enum;
            reset = 0x0;
        } software_int[0:0];

    } SOFT_INT @ 0x001C;
`endif

`ifdef SYS_CTRL_PERIPHCTRL1_REG
    reg {
        name = "Peripheral control register 1";
        desc = "Soft interrupt register";
`ifdef SYS_CTRL_PERIPHCTRL1_VAR1
        field {
            name = "pinmuxctrl31";
            reset = 0x0;
        } pinmuxctrl31[31:31];

        field {
            name = "pinmuxctrl30";
            reset = 0x0;
        } pinmuxctrl30[30:30];

        field {
            name = "pinmuxctrl24";
            reset = 0x0;
        } pinmuxctrl24[24:24];

        field {
            name = "pinmuxctrl23";
            reset = 0x0;
        } pinmuxctrl23[23:23];

        field {
            name = "pinmuxctrl21";
            reset = 0x0;
        } pinmuxctrl21[21:21];

        field {
            name = "pinmuxctrl20";
            reset = 0x0;
        } pinmuxctrl20[20:20];

        field {
            name = "pinmuxctrl19";
            reset = 0x0;
        } pinmuxctrl19[19:19];

        field {
            name = "pinmuxctrl18";
            reset = 0x0;
        } pinmuxctrl18[18:18];

        field {
            name = "pinmuxctrl17";
            reset = 0x0;
        } pinmuxctrl17[17:17];

        field {
            name = "pinmuxctrl16";
            reset = 0x0;
        } pinmuxctrl16[16:16];

        field {
            name = "pinmuxctrl15";
            reset = 0x0;
        } pinmuxctrl15[15:15];

        field {
            name = "pinmuxctrl14";
            reset = 0x0;
        } pinmuxctrl14[14:14];

        field {
            name = "pinmuxctrl13";
            reset = 0x0;
        } pinmuxctrl13[13:13];

        field {
            name = "pinmuxctrl12";
            reset = 0x0;
        } pinmuxctrl12[12:12];

        field {
            name = "pinmuxctrl11";
            reset = 0x0;
        } pinmuxctrl11[11:11];

        field {
            name = "pinmuxctrl10";
            reset = 0x0;
        } pinmuxctrl10[10:10];

        field {
            name = "pinmuxctrl9";
            reset = 0x0;
        } pinmuxctrl9[9:9];

        field {
            name = "pinmuxctrl8-7";
            reset = 0x0;
        } pinmuxctrl8_7[8:7];

        field {
            name = "pinmuxctrl6";
            reset = 0x0;
        } pinmuxctrl6[6:6];

        field {
            name = "pinmuxctrl5";
            reset = 0x0;
        } pinmuxctrl5[5:5];

        field {
            name = "pinmuxctrl4";
            reset = 0x0;
        } pinmuxctrl4[4:4];

        field {
            name = "pinmuxctrl3";
            reset = 0x0;
        } pinmuxctrl3[3:3];

        field {
            name = "pinmuxctrl2";
            reset = 0x0;
        } pinmuxctrl2[2:2];

        field {
            name = "pinmuxctrl1-0";
            reset = 0x0;
        } pinmuxctrl1_0[1:0];
`endif
`ifdef SYS_CTRL_PERIPHCTRL1_VAR2
        field {
            name = "apll_reset";
            reset = 0x0;
        } apll_reset[22:22];

        field {
            name = "apll_pd";
            reset = 0x0;
        } apll_pd[21:21];

        field {
            name = "apll_foutvcopd";
            reset = 0x0;
        } apll_foutvcopd[20:20];

        field {
            name = "apll_postdivpd";
            reset = 0x0;
        } apll_postdivpd[19:19];

        field {
            name = "apll_fout4phasepd";
            reset = 0x0;
        } apll_fout4phasepd[18:18];

        field {
            name = "apll_refdiv";
            reset = 0x0;
        } apll_refdiv[17:12];

        field {
            name = "apll_fbdiv";
            reset = 0x0;
        } apll_fbdiv[11:0];
`endif
`ifdef SYS_CTRL_PERIPHCTRL1_VAR3
        field {
            name = "ephy_clk_sl";
            reset = 0x3;
        } ephy_clk_sl[31:30];

        field {
            name = "ephy_clk_drive";
            reset = 0x7;
        } ephy_clk_drive[29:24];

        field {
            name = "rgmii_txclkout_sl";
            reset = 0x3;
        } rgmii_txclkout_sl[23:22];

        field {
            name = "rgmii_txclkout_drive";
            reset = 0xF;
        } rgmii_txclkout_drive[21:16];

        field {
            name = "rgmii_dat_sl";
            reset = 0x3;
        } rgmii_dat_sl[15:14];

        field {
            name = "rgmii_dat_drive";
            reset = 0xF;
        } rgmii_dat_drive[13:8];

        field {
            name = "rgmii_txen_sl";
            reset = 0x3;
        } rgmii_txen_sl[7:6];

        field {
            name = "rgmii_txen_drive";
            reset = 0xF;
        } rgmii_txen_drive[5:0];
`endif
`ifdef SYS_CTRL_PERIPHCTRL1_VAR4
        field {
            name = "software_int";
        } software_int[0:0];
`endif
`ifdef SYS_CTRL_PERIPHCTRL1_VAR5
        enum PERIPHCTRL1_software_int_enum {
            NO_INTERRUPT_GENERATED = 0x0 { desc = "no interrupt generated"; };
            INTERRUPT_GENERATED = 0x1 { desc = "interrupt generated"; };
        };

        field {
            name = "software_int";
            encode = PERIPHCTRL1_software_int_enum;
            reset = 0x0;
        } software_int[0:0];
`endif
    } PERIPHCTRL1 @ 0x0020;
`endif

`ifdef SYS_CTRL_SOLFTYPE_REG
    reg {
        name = "Software Interrupt Vector Register";
        desc = "Soft interrupt register";
        field {
            name = "software_int_vector";
            desc = "Software interrupt vector.";
            sw = r;
            reset = 0x0;
        } software_int_vector[31:0];
    } SOLFTYPE @ 0x0020;
`endif

`ifdef SYS_CTRL_PEREN_REG
    reg {
        name = "Peripheral Clock Enable Register";
        desc = "Soft interrupt register";
`ifdef SYS_CTRL_PEREN_VAR1
        field {
            name = "uart2clken";
            sw = w;
            hw = r;
            reset = 0x1;
        } uart2clken[22:22];

        field {
            name = "usbclken";
            sw = w;
            hw = r;
            reset = 0x1;
        } usbclken[21:21];

        field {
            name = "otgclken";
            sw = w;
            hw = r;
            reset = 0x1;
        } otgclken[20:20];

        field {
            name = "sio1clken";
            sw = w;
            hw = r;
            reset = 0x1;
        } sio1clken[19:19];

        field {
            name = "sio0clken";
            sw = w;
            hw = r;
            reset = 0x1;
        } sio0clken[18:18];

        field {
            name = "ethclken";
            sw = w;
            hw = r;
            reset = 0x1;
        } ethclken[17:17];

        field {
            name = "vi3clken";
            sw = w;
            hw = r;
            reset = 0x1;
        } vi3clken[16:16];

        field {
            name = "vi2clken";
            sw = w;
            hw = r;
            reset = 0x1;
        } vi2clken[15:15];

        field {
            name = "vi1clken";
            sw = w;
            hw = r;
            reset = 0x1;
        } vi1clken[14:14];

        field {
            name = "vi0clken";
            sw = w;
            hw = r;
            reset = 0x1;
        } vi0clken[13:13];

        field {
            name = "vihclken";
            sw = w;
            hw = r;
            reset = 0x1;
        } vihclken[12:12];

        field {
            name = "voclken";
            sw = w;
            hw = r;
            reset = 0x1;
        } voclken[11:11];

        field {
            name = "mmcclken";
            sw = w;
            hw = r;
            reset = 0x1;
        } mmcclken[10:10];

        field {
            name = "pciclken";
            sw = w;
            hw = r;
            reset = 0x1;
        } pciclken[9:9];

        field {
            name = "irclken";
            sw = w;
            hw = r;
            reset = 0x1;
        } irclken[8:8];

        field {
            name = "sspclken";
            sw = w;
            hw = r;
            reset = 0x1;
        } sspclken[7:7];

        field {
            name = "uart1clken";
            sw = w;
            hw = r;
            reset = 0x1;
        } uart1clken[6:6];

        field {
            name = "uart0clken";
            sw = w;
            hw = r;
            reset = 0x1;
        } uart0clken[5:5];

        field {
            name = "smiclken";
            sw = w;
            hw = r;
            reset = 0x1;
        } smiclken[4:4];

        field {
            name = "dsuclken";
            sw = w;
            hw = r;
            reset = 0x1;
        } dsuclken[3:3];

        field {
            name = "cipherclken";
            sw = w;
            hw = r;
        } cipherclken[2:2];

        field {
            name = "veduclken";
            sw = w;
            hw = r;
            reset = 0x1;
        } veduclken[0:0];
`endif
`ifdef SYS_CTRL_PEREN_VAR2
        field {
            name = "vdac1clken";
            sw = w;
            hw = r;
        } vdac1clken[31:31];

        field {
            name = "vdac0clken";
            sw = w;
            hw = r;
        } vdac0clken[30:30];

        field {
            name = "sspclken";
            sw = w;
            hw = r;
        } sspclken[29:29];

        field {
            name = "nandcclken";
            sw = w;
            hw = r;
        } nandcclken[27:27];

        field {
            name = "vohdclken";
            sw = w;
            hw = r;
        } vohdclken[25:25];

        field {
            name = "vosdclken";
            sw = w;
            hw = r;
        } vosdclken[24:24];

        field {
            name = "vobusclken";
            sw = w;
            hw = r;
        } vobusclken[23:23];

        field {
            name = "usbclken";
            sw = w;
            hw = r;
        } usbclken[22:22];

        field {
            name = "ethclken";
            sw = w;
            hw = r;
        } ethclken[21:21];

        field {
            name = "vi3clken";
            sw = w;
            hw = r;
        } vi3clken[20:20];

        field {
            name = "vi2clken";
            sw = w;
            hw = r;
        } vi2clken[19:19];

        field {
            name = "vi1clken";
            sw = w;
            hw = r;
        } vi1clken[18:18];

        field {
            name = "vi0clken";
            sw = w;
            hw = r;
        } vi0clken[17:17];

        field {
            name = "vibusclken";
            sw = w;
            hw = r;
        } vibusclken[16:16];

        field {
            name = "tdeclken";
            sw = w;
            hw = r;
        } tdeclken[15:15];

        field {
            name = "mmcclken";
            sw = w;
            hw = r;
        } mmcclken[14:14];

        field {
            name = "irclken";
            sw = w;
            hw = r;
        } irclken[11:11];

        field {
            name = "sio1clken";
            sw = w;
            hw = r;
        } sio1clken[9:9];

        field {
            name = "sio0clken";
            sw = w;
            hw = r;
        } sio0clken[8:8];

        field {
            name = "uart3clken";
            sw = w;
            hw = r;
        } uart3clken[7:7];

        field {
            name = "uart2clken";
            sw = w;
            hw = r;
        } uart2clken[6:6];

        field {
            name = "uart1clken";
            sw = w;
            hw = r;
        } uart1clken[5:5];

        field {
            name = "uart0clken";
            sw = w;
            hw = r;
        } uart0clken[4:4];

        field {
            name = "smiclken";
            sw = w;
            hw = r;
        } smiclken[3:3];

        field {
            name = "cipherclken";
            sw = w;
            hw = r;
        } cipherclken[2:2];

        field {
            name = "sataclkgate";
            sw = w;
            hw = r;
            reset = 0x1;
        } sataclkgate[1:1];
`endif
`ifdef SYS_CTRL_PEREN_VAR3
        field {
            name = "vdac1clken";
            sw = w;
            hw = r;
        } vdac1clken[31:31];

        field {
            name = "vdac0clken";
            sw = w;
            hw = r;
        } vdac0clken[30:30];

        field {
            name = "sspclken";
            sw = w;
            hw = r;
        } sspclken[29:29];

        field {
            name = "arm9clken";
            sw = w;
            hw = r;
            reset = 0x1;
        } arm9clken[28:28];

        field {
            name = "nandcclken";
            sw = w;
            hw = r;
        } nandcclken[27:27];

        field {
            name = "voadclken";
            sw = w;
            hw = r;
            reset = 0x1;
        } voadclken[26:26];

        field {
            name = "vohdclken";
            sw = w;
            hw = r;
        } vohdclken[25:25];

        field {
            name = "vosdclken";
            sw = w;
            hw = r;
        } vosdclken[24:24];

        field {
            name = "vobusclken";
            sw = w;
            hw = r;
        } vobusclken[23:23];

        field {
            name = "usbclken";
            sw = w;
            hw = r;
        } usbclken[22:22];

        field {
            name = "ethclken";
            sw = w;
            hw = r;
        } ethclken[21:21];

        field {
            name = "vi3clken";
            sw = w;
            hw = r;
        } vi3clken[20:20];

        field {
            name = "vi2clken";
            sw = w;
            hw = r;
        } vi2clken[19:19];

        field {
            name = "vi1clken";
            sw = w;
            hw = r;
        } vi1clken[18:18];

        field {
            name = "vi0clken";
            sw = w;
            hw = r;
        } vi0clken[17:17];

        field {
            name = "vibusclken";
            sw = w;
            hw = r;
        } vibusclken[16:16];

        field {
            name = "tdeclken";
            sw = w;
            hw = r;
        } tdeclken[15:15];

        field {
            name = "mmcclken";
            sw = w;
            hw = r;
        } mmcclken[14:14];

        field {
            name = "pciclken";
            sw = w;
            hw = r;
            reset = 0x1;
        } pciclken[13:13];

        field {
            name = "ipcmclken";
            sw = w;
            hw = r;
            reset = 0x1;
        } ipcmclken[12:12];

        field {
            name = "irclken";
            sw = w;
            hw = r;
        } irclken[11:11];

        field {
            name = "sio2clken";
            sw = w;
            hw = r;
            reset = 0x1;
        } sio2clken[10:10];

        field {
            name = "sio1clken";
            sw = w;
            hw = r;
        } sio1clken[9:9];

        field {
            name = "sio0clken";
            sw = w;
            hw = r;
        } sio0clken[8:8];

        field {
            name = "uart3clken";
            sw = w;
            hw = r;
        } uart3clken[7:7];

        field {
            name = "uart2clken";
            sw = w;
            hw = r;
        } uart2clken[6:6];

        field {
            name = "uart1clken";
            sw = w;
            hw = r;
        } uart1clken[5:5];

        field {
            name = "uart0clken";
            sw = w;
            hw = r;
        } uart0clken[4:4];

        field {
            name = "smiclken";
            sw = w;
            hw = r;
        } smiclken[3:3];

        field {
            name = "cipherclken";
            sw = w;
            hw = r;
        } cipherclken[2:2];
`endif
    } PEREN @ 0x0024;
`endif

`ifdef SYS_CTRL_PERDIS_REG
    reg {
        name = "Peripheral Clock Disable Register";
        desc = "Soft interrupt register";
`ifdef SYS_CTRL_PERDIS_VAR1
        field {
            name = "uart2clkdis";
            sw = w;
            hw = r;
            reset = 0x0;
        } uart2clkdis[22:22];

        field {
            name = "usbclkdis";
            sw = w;
            hw = r;
            reset = 0x0;
        } usbclkdis[21:21];

        field {
            name = "otgclkdis";
            sw = w;
            hw = r;
            reset = 0x0;
        } otgclkdis[20:20];

        field {
            name = "sio1clkdis";
            sw = w;
            hw = r;
            reset = 0x0;
        } sio1clkdis[19:19];

        field {
            name = "sio0clkdis";
            sw = w;
            hw = r;
            reset = 0x0;
        } sio0clkdis[18:18];

        field {
            name = "ethclkdis";
            sw = w;
            hw = r;
            reset = 0x0;
        } ethclkdis[17:17];

        field {
            name = "vi3clkdis";
            sw = w;
            hw = r;
            reset = 0x0;
        } vi3clkdis[16:16];

        field {
            name = "vi2clkdis";
            sw = w;
            hw = r;
            reset = 0x0;
        } vi2clkdis[15:15];

        field {
            name = "vi1clkdis";
            sw = w;
            hw = r;
            reset = 0x0;
        } vi1clkdis[14:14];

        field {
            name = "vi0clkdis";
            sw = w;
            hw = r;
            reset = 0x0;
        } vi0clkdis[13:13];

        field {
            name = "vihclkdis";
            sw = w;
            hw = r;
            reset = 0x0;
        } vihclkdis[12:12];

        field {
            name = "voclkdis";
            sw = w;
            hw = r;
            reset = 0x0;
        } voclkdis[11:11];

        field {
            name = "mmcclkdis";
            sw = w;
            hw = r;
            reset = 0x0;
        } mmcclkdis[10:10];

        field {
            name = "pciclkdis";
            sw = w;
            hw = r;
            reset = 0x0;
        } pciclkdis[9:9];

        field {
            name = "irclkdis";
            sw = w;
            hw = r;
            reset = 0x0;
        } irclkdis[8:8];

        field {
            name = "sspclkdis";
            sw = w;
            hw = r;
            reset = 0x0;
        } sspclkdis[7:7];

        field {
            name = "uart1clkdis";
            sw = w;
            hw = r;
            reset = 0x0;
        } uart1clkdis[6:6];

        field {
            name = "uart0clkdis";
            sw = w;
            hw = r;
            reset = 0x0;
        } uart0clkdis[5:5];

        field {
            name = "smiclkdis";
            sw = w;
            hw = r;
            reset = 0x0;
        } smiclkdis[4:4];

        field {
            name = "dsuclkdis";
            sw = w;
            hw = r;
            reset = 0x0;
        } dsuclkdis[3:3];

        field {
            name = "cipherclkdis";
            sw = w;
            hw = r;
        } cipherclkdis[2:2];

        field {
            name = "veduclkdis";
            sw = w;
            hw = r;
            reset = 0x0;
        } veduclkdis[0:0];
`endif
`ifdef SYS_CTRL_PERDIS_VAR2
        field {
            name = "vdac1clkdis";
            sw = w;
            hw = r;
        } vdac1clkdis[31:31];

        field {
            name = "vdac0clkdis";
            sw = w;
            hw = r;
        } vdac0clkdis[30:30];

        field {
            name = "sspclkdis";
            sw = w;
            hw = r;
        } sspclkdis[29:29];

        field {
            name = "nandcclkdis";
            sw = w;
            hw = r;
        } nandcclkdis[27:27];

        field {
            name = "vohdclkdis";
            sw = w;
            hw = r;
        } vohdclkdis[25:25];

        field {
            name = "vosdclkdis";
            sw = w;
            hw = r;
        } vosdclkdis[24:24];

        field {
            name = "vobusclkdis";
            sw = w;
            hw = r;
        } vobusclkdis[23:23];

        field {
            name = "usbclkdis";
            sw = w;
            hw = r;
        } usbclkdis[22:22];

        field {
            name = "ethclkdis";
            sw = w;
            hw = r;
        } ethclkdis[21:21];

        field {
            name = "vi3clkdis";
            sw = w;
            hw = r;
        } vi3clkdis[20:20];

        field {
            name = "vi2clkdis";
            sw = w;
            hw = r;
        } vi2clkdis[19:19];

        field {
            name = "vi1clkdis";
            sw = w;
            hw = r;
        } vi1clkdis[18:18];

        field {
            name = "vi0clkdis";
            sw = w;
            hw = r;
        } vi0clkdis[17:17];

        field {
            name = "vibusclkdis";
            sw = w;
            hw = r;
        } vibusclkdis[16:16];

        field {
            name = "tdeclkdis";
            sw = w;
            hw = r;
        } tdeclkdis[15:15];

        field {
            name = "mmcclkdis";
            sw = w;
            hw = r;
        } mmcclkdis[14:14];

        field {
            name = "irclkdis";
            sw = w;
            hw = r;
        } irclkdis[11:11];

        field {
            name = "sio1clkdis";
            sw = w;
            hw = r;
        } sio1clkdis[9:9];

        field {
            name = "sio0clkdis";
            sw = w;
            hw = r;
        } sio0clkdis[8:8];

        field {
            name = "uart3clkdis";
            sw = w;
            hw = r;
        } uart3clkdis[7:7];

        field {
            name = "uart2clkdis";
            sw = w;
            hw = r;
        } uart2clkdis[6:6];

        field {
            name = "uart1clkdis";
            sw = w;
            hw = r;
        } uart1clkdis[5:5];

        field {
            name = "uart0clkdis";
            sw = w;
            hw = r;
        } uart0clkdis[4:4];

        field {
            name = "smiclkdis";
            sw = w;
            hw = r;
        } smiclkdis[3:3];

        field {
            name = "cipherclkdis";
            sw = w;
            hw = r;
        } cipherclkdis[2:2];

        field {
            name = "sataclkdis";
            sw = w;
            hw = r;
            reset = 0x1;
        } sataclkdis[1:1];
`endif
`ifdef SYS_CTRL_PERDIS_VAR3
        field {
            name = "vdac1clkdis";
            sw = w;
            hw = r;
        } vdac1clkdis[31:31];

        field {
            name = "vdac0clkdis";
            sw = w;
            hw = r;
        } vdac0clkdis[30:30];

        field {
            name = "sspclkdis";
            sw = w;
            hw = r;
        } sspclkdis[29:29];

        field {
            name = "arm9clkdis";
            sw = w;
            hw = r;
            reset = 0x0;
        } arm9clkdis[28:28];

        field {
            name = "nandcclkdis";
            sw = w;
            hw = r;
        } nandcclkdis[27:27];

        field {
            name = "voadclkdis";
            sw = w;
            hw = r;
            reset = 0x0;
        } voadclkdis[26:26];

        field {
            name = "vohdclkdis";
            sw = w;
            hw = r;
        } vohdclkdis[25:25];

        field {
            name = "vosdclkdis";
            sw = w;
            hw = r;
        } vosdclkdis[24:24];

        field {
            name = "vobusclkdis";
            sw = w;
            hw = r;
        } vobusclkdis[23:23];

        field {
            name = "usbclkdis";
            sw = w;
            hw = r;
        } usbclkdis[22:22];

        field {
            name = "ethclkdis";
            sw = w;
            hw = r;
        } ethclkdis[21:21];

        field {
            name = "vi3clkdis";
            sw = w;
            hw = r;
        } vi3clkdis[20:20];

        field {
            name = "vi2clkdis";
            sw = w;
            hw = r;
        } vi2clkdis[19:19];

        field {
            name = "vi1clkdis";
            sw = w;
            hw = r;
        } vi1clkdis[18:18];

        field {
            name = "vi0clkdis";
            sw = w;
            hw = r;
        } vi0clkdis[17:17];

        field {
            name = "vibusclkdis";
            sw = w;
            hw = r;
        } vibusclkdis[16:16];

        field {
            name = "tdeclkdis";
            sw = w;
            hw = r;
        } tdeclkdis[15:15];

        field {
            name = "mmcclkdis";
            sw = w;
            hw = r;
        } mmcclkdis[14:14];

        field {
            name = "pciclkdis";
            sw = w;
            hw = r;
            reset = 0x0;
        } pciclkdis[13:13];

        field {
            name = "ipcmclkdis";
            sw = w;
            hw = r;
            reset = 0x0;
        } ipcmclkdis[12:12];

        field {
            name = "irclkdis";
            sw = w;
            hw = r;
        } irclkdis[11:11];

        field {
            name = "sio2clkdis";
            sw = w;
            hw = r;
            reset = 0x0;
        } sio2clkdis[10:10];

        field {
            name = "sio1clkdis";
            sw = w;
            hw = r;
        } sio1clkdis[9:9];

        field {
            name = "sio0clkdis";
            sw = w;
            hw = r;
        } sio0clkdis[8:8];

        field {
            name = "uart3clkdis";
            sw = w;
            hw = r;
        } uart3clkdis[7:7];

        field {
            name = "uart2clkdis";
            sw = w;
            hw = r;
        } uart2clkdis[6:6];

        field {
            name = "uart1clkdis";
            sw = w;
            hw = r;
        } uart1clkdis[5:5];

        field {
            name = "uart0clkdis";
            sw = w;
            hw = r;
        } uart0clkdis[4:4];

        field {
            name = "smiclkdis";
            sw = w;
            hw = r;
        } smiclkdis[3:3];

        field {
            name = "cipherclkdis";
            sw = w;
            hw = r;
        } cipherclkdis[2:2];
`endif
    } PERDIS @ 0x0028;
`endif

`ifdef SYS_CTRL_PERCLKEN_REG
    reg {
        name = "Peripheral Clock Status Register";
        desc = "Soft interrupt register";
`ifdef SYS_CTRL_PERCLKEN_VAR1
        field {
            name = "uart2clken";
            sw = r;
            hw = w;
            reset = 0x1;
        } uart2clken[22:22];

        field {
            name = "usbclkden";
            sw = r;
            hw = w;
            reset = 0x1;
        } usbclkden[21:21];

        field {
            name = "otgclken";
            sw = r;
            hw = w;
            reset = 0x1;
        } otgclken[20:20];

        field {
            name = "sio1clken";
            sw = r;
            hw = w;
            reset = 0x1;
        } sio1clken[19:19];

        field {
            name = "sio0clken";
            sw = r;
            hw = w;
            reset = 0x1;
        } sio0clken[18:18];

        field {
            name = "ethclken";
            sw = r;
            hw = w;
            reset = 0x1;
        } ethclken[17:17];

        field {
            name = "vi3clken";
            sw = r;
            hw = w;
            reset = 0x1;
        } vi3clken[16:16];

        field {
            name = "vi2clken";
            sw = r;
            hw = w;
            reset = 0x1;
        } vi2clken[15:15];

        field {
            name = "vi1clken";
            sw = r;
            hw = w;
            reset = 0x1;
        } vi1clken[14:14];

        field {
            name = "vi0clken";
            sw = r;
            hw = w;
            reset = 0x1;
        } vi0clken[13:13];

        field {
            name = "vihclken";
            sw = r;
            hw = w;
            reset = 0x1;
        } vihclken[12:12];

        field {
            name = "voclken";
            sw = r;
            hw = w;
            reset = 0x1;
        } voclken[11:11];

        field {
            name = "mmcclken";
            sw = r;
            hw = w;
            reset = 0x1;
        } mmcclken[10:10];

        field {
            name = "pciclken";
            sw = r;
            hw = w;
            reset = 0x1;
        } pciclken[9:9];

        field {
            name = "irclken";
            sw = r;
            hw = w;
            reset = 0x1;
        } irclken[8:8];

        field {
            name = "sspclken";
            sw = r;
            hw = w;
            reset = 0x1;
        } sspclken[7:7];

        field {
            name = "uart1clken";
            sw = r;
            hw = w;
            reset = 0x1;
        } uart1clken[6:6];

        field {
            name = "uart0clken";
            sw = r;
            hw = w;
            reset = 0x1;
        } uart0clken[5:5];

        field {
            name = "smiclken";
            sw = r;
            hw = w;
            reset = 0x1;
        } smiclken[4:4];

        field {
            name = "dsuclken";
            sw = r;
            hw = w;
            reset = 0x1;
        } dsuclken[3:3];

        field {
            name = "cipherclken";
            sw = r;
            hw = w;
            reset = 0x1;
        } cipherclken[2:2];

        field {
            name = "veduclken";
            sw = r;
            hw = w;
            reset = 0x1;
        } veduclken[0:0];
`endif
`ifdef SYS_CTRL_PERCLKEN_VAR2
        field {
            name = "vdac1clkstat";
            sw = r;
            hw = w;
        } vdac1clkstat[31:31];

        field {
            name = "vdac0clkstat";
            sw = r;
            hw = w;
        } vdac0clkstat[30:30];

        field {
            name = "sspclkstat";
            sw = r;
            hw = w;
        } sspclkstat[29:29];

        field {
            name = "nandcclkstat";
            sw = r;
            hw = w;
        } nandcclkstat[27:27];

        field {
            name = "vohdclkstat";
            sw = r;
            hw = w;
        } vohdclkstat[25:25];

        field {
            name = "vosdclkstat";
            sw = r;
            hw = w;
        } vosdclkstat[24:24];

        field {
            name = "vobusclkstat";
            sw = r;
            hw = w;
        } vobusclkstat[23:23];

        field {
            name = "usbclkstat";
            sw = r;
            hw = w;
        } usbclkstat[22:22];

        field {
            name = "ethclkstat";
            sw = r;
            hw = w;
        } ethclkstat[21:21];

        field {
            name = "vi3clkstat";
            sw = r;
            hw = w;
        } vi3clkstat[20:20];

        field {
            name = "vi2clkstat";
            sw = r;
            hw = w;
        } vi2clkstat[19:19];

        field {
            name = "vi1clkstat";
            sw = r;
            hw = w;
        } vi1clkstat[18:18];

        field {
            name = "vi0clkstat";
            sw = r;
            hw = w;
        } vi0clkstat[17:17];

        field {
            name = "vibusclkstat";
            sw = r;
            hw = w;
        } vibusclkstat[16:16];

        field {
            name = "tdeclkstat";
            sw = r;
            hw = w;
        } tdeclkstat[15:15];

        field {
            name = "mmcclkstat";
            sw = r;
            hw = w;
        } mmcclkstat[14:14];

        field {
            name = "irclkstat";
            sw = r;
            hw = w;
        } irclkstat[11:11];

        field {
            name = "sio2clkstat";
            sw = r;
            hw = w;
        } sio2clkstat[10:10];

        field {
            name = "sio1clkstat";
            sw = r;
            hw = w;
        } sio1clkstat[9:9];

        field {
            name = "sio0clkstat";
            sw = r;
            hw = w;
        } sio0clkstat[8:8];

        field {
            name = "uart3clkstat";
            sw = r;
            hw = w;
        } uart3clkstat[7:7];

        field {
            name = "uart2clkstat";
            sw = r;
            hw = w;
        } uart2clkstat[6:6];

        field {
            name = "uart1clkstat";
            sw = r;
            hw = w;
        } uart1clkstat[5:5];

        field {
            name = "uart0clkstat";
            sw = r;
            hw = w;
        } uart0clkstat[4:4];

        field {
            name = "smiclkstat";
            sw = r;
            hw = w;
        } smiclkstat[3:3];

        field {
            name = "cipherclkstat";
            sw = r;
            hw = w;
        } cipherclkstat[2:2];

        field {
            name = "sataclkstat";
            sw = r;
            hw = w;
            reset = 0x1;
        } sataclkstat[1:1];
`endif
`ifdef SYS_CTRL_PERCLKEN_VAR3
        field {
            name = "vdac1clkstat";
            sw = r;
            hw = w;
        } vdac1clkstat[31:31];

        field {
            name = "vdac0clkstat";
            sw = r;
            hw = w;
        } vdac0clkstat[30:30];

        field {
            name = "sspclkstat";
            sw = r;
            hw = w;
        } sspclkstat[29:29];

        field {
            name = "arm9clkstat";
            sw = r;
            hw = w;
            reset = 0x1;
        } arm9clkstat[28:28];

        field {
            name = "nandcclkstat";
            sw = r;
            hw = w;
        } nandcclkstat[27:27];

        field {
            name = "voadclkstat";
            sw = r;
            hw = w;
            reset = 0x1;
        } voadclkstat[26:26];

        field {
            name = "vohdclkstat";
            sw = r;
            hw = w;
        } vohdclkstat[25:25];

        field {
            name = "vosdclkstat";
            sw = r;
            hw = w;
        } vosdclkstat[24:24];

        field {
            name = "vobusclkstat";
            sw = r;
            hw = w;
        } vobusclkstat[23:23];

        field {
            name = "usbclkstat";
            sw = r;
            hw = w;
        } usbclkstat[22:22];

        field {
            name = "ethclkstat";
            sw = r;
            hw = w;
        } ethclkstat[21:21];

        field {
            name = "vi3clkstat";
            sw = r;
            hw = w;
        } vi3clkstat[20:20];

        field {
            name = "vi2clkstat";
            sw = r;
            hw = w;
        } vi2clkstat[19:19];

        field {
            name = "vi1clkstat";
            sw = r;
            hw = w;
        } vi1clkstat[18:18];

        field {
            name = "vi0clkstat";
            sw = r;
            hw = w;
        } vi0clkstat[17:17];

        field {
            name = "vibusclkstat";
            sw = r;
            hw = w;
        } vibusclkstat[16:16];

        field {
            name = "tdeclkstat";
            sw = r;
            hw = w;
        } tdeclkstat[15:15];

        field {
            name = "mmcclkstat";
            sw = r;
            hw = w;
        } mmcclkstat[14:14];

        field {
            name = "pciclkstat";
            sw = r;
            hw = w;
            reset = 0x1;
        } pciclkstat[13:13];

        field {
            name = "ipcmclkstat";
            sw = r;
            hw = w;
            reset = 0x1;
        } ipcmclkstat[12:12];

        field {
            name = "irclkstat";
            sw = r;
            hw = w;
        } irclkstat[11:11];

        field {
            name = "sio2clkstat";
            sw = r;
            hw = w;
        } sio2clkstat[10:10];

        field {
            name = "sio1clkstat";
            sw = r;
            hw = w;
        } sio1clkstat[9:9];

        field {
            name = "sio0clkstat";
            sw = r;
            hw = w;
        } sio0clkstat[8:8];

        field {
            name = "uart3clkstat";
            sw = r;
            hw = w;
        } uart3clkstat[7:7];

        field {
            name = "uart2clkstat";
            sw = r;
            hw = w;
        } uart2clkstat[6:6];

        field {
            name = "uart1clkstat";
            sw = r;
            hw = w;
        } uart1clkstat[5:5];

        field {
            name = "uart0clkstat";
            sw = r;
            hw = w;
        } uart0clkstat[4:4];

        field {
            name = "smiclkstat";
            sw = r;
            hw = w;
        } smiclkstat[3:3];

        field {
            name = "cipherclkstat";
            sw = r;
            hw = w;
        } cipherclkstat[2:2];
`endif
    } PERCLKEN @ 0x002C;
`endif

`ifdef SYS_CTRL_PERISTAT_REG
    reg {
        name = "Peripheral Status Register";
        field {
            name = "usb2_update_delay_time";
            sw = r;
            hw = w;
            reset = 0x0;
        } usb2_update_delay_time[18:17];

        field {
            name = "emmc_poweron_delay_time";
            sw = r;
            hw = w;
            reset = 0x0;
        } emmc_poweron_delay_time[16:15];

        field {
            name = "emmc_pad_pu_disable";
            sw = r;
            hw = w;
            reset = 0x0;
        } emmc_pad_pu_disable[13:13];

        field {
            name = "sdio_pad_pu_disable";
            sw = r;
            hw = w;
            reset = 0x0;
        } sdio_pad_pu_disable[12:12];

        field {
            name = "boot_backup_enable";
            sw = r;
            hw = w;
            reset = 0x0;
        } boot_backup_enable[11:11];

        field {
            name = "emmc_boot_cksel";
            sw = r;
            hw = w;
            reset = 0x0;
        } emmc_boot_cksel[10:8];

        field {
            name = "usb_phy_para_sel";
            sw = r;
            hw = w;
            reset = 0x0;
        } usb_phy_para_sel[7:6];

        field {
            name = "update_from_usb_disable";
            sw = r;
            hw = w;
            reset = 0x0;
        } update_from_usb_disable[5:5];

        field {
            name = "update_from_sdio_disable";
            sw = r;
            hw = w;
            reset = 0x0;
        } update_from_sdio_disable[4:4];

        field {
            name = "jtag_ca_en";
            sw = r;
            hw = w;
            reset = 0x0;
        } jtag_ca_en[3:3];

        field {
            name = "ddrca_en";
            sw = r;
            hw = w;
            reset = 0x0;
        } ddrca_en[1:1];

        field {
            name = "sec_boot_mode";
            sw = r;
            hw = w;
            reset = 0x0;
        } sec_boot_mode[0:0];
    } PERISTAT @ 0x0030;
`endif

`ifdef SYS_CTRL_PERIPHCTRL2_REG
    reg {
        name = "Peripheral control register 2";
`ifdef SYS_CTRL_PERIPHCTRL2_VAR1
        field {
            name = "vedu_power_mode";
            reset = 0x0;
        } vedu_power_mode[26:26];

        field {
            name = "otg24_sel";
            reset = 0x0;
        } otg24_sel[25:25];

        field {
            name = "smiclk_sel";
            reset = 0x0;
        } smiclk_sel[24:24];

        field {
            name = "pciclk_sel";
            reset = 0x0;
        } pciclk_sel[23:20];

        field {
            name = "vi3div_sel";
            reset = 0x0;
        } vi3div_sel[19:18];

        field {
            name = "vi2div_sel";
            reset = 0x0;
        } vi2div_sel[17:16];

        field {
            name = "vi1div_sel";
            reset = 0x0;
        } vi1div_sel[15:14];

        field {
            name = "vi0div_sel";
            reset = 0x0;
        } vi0div_sel[13:12];

        field {
            name = "usb48clk_sel";
            reset = 0x0;
        } usb48clk_sel[9:8];

        field {
            name = "arm_hclk_sel";
            reset = 0x0;
        } arm_hclk_sel[7:7];

        field {
            name = "mmcsap_sel";
            reset = 0x0;
        } mmcsap_sel[6:6];

        field {
            name = "mmcclk_sel";
            reset = 0x0;
        } mmcclk_sel[5:4];

        field {
            name = "vi3_vi2_sel";
            reset = 0x0;
        } vi3_vi2_sel[3:3];

        field {
            name = "vi2_vi0_sel";
            reset = 0x0;
        } vi2_vi0_sel[2:2];

        field {
            name = "vi1_vi0_sel";
            reset = 0x0;
        } vi1_vi0_sel[1:1];

        field {
            name = "voout_sel";
            reset = 0x0;
        } voout_sel[0:0];
`endif
`ifdef SYS_CTRL_PERIPHCTRL2_VAR2
        field {
            name = "vpll0_dsmpd";
            reset = 0x0;
        } vpll0_dsmpd[31:31];

        field {
            name = "vpll0_bypass";
            reset = 0x0;
        } vpll0_bypass[30:30];

        field {
            name = "vpll0_postdiv2";
            reset = 0x0;
        } vpll0_postdiv2[29:27];

        field {
            name = "vpll0_postdiv1";
            reset = 0x0;
        } vpll0_postdiv1[26:24];

        field {
            name = "vpll0_frac";
            reset = 0x0;
        } vpll0_frac[23:0];
`endif
`ifdef SYS_CTRL_PERIPHCTRL2_VAR3
        enum PERIPHCTRL2_rom_pgen_enum {
            ENABLE = 0x0 { desc = "enabled"; };
            DISABLE = 0x1 { desc = "disabled"; };
        };

        field {
            name = "rom_pgen";
            encode = PERIPHCTRL2_rom_pgen_enum;
            reset = 0x0;
        } rom_pgen[0:0];
`endif
    } PERIPHCTRL2 @ 0x0034;
`endif

`ifdef SYS_CTRL_PERIPHCTRL3_REG
    reg {
        name = "Peripheral control register 3";
        desc = "SATA PHY control register device. On the Hi3520D (DS 3.4.5, `datasheet.txt` line 10979) it holds the MPLL reference offset (`sata_phy0_ref_clk_sel`, 0 = no offset) and the spread-spectrum select (`sata_phy0_mpll_ss_sel`, must be 0); the vendor SATA driver never writes it. The DS total reset 0x5D75F000 has non-zero bits in the reserved field [31:10] (not modelled). PHY clocks/resets: PERI_CRG45; PHY test options: PERIPHCTRL25. Hardware (Hi3520D V100 board, read on hardware 2026-11-08, stock U-Boot prompt after a cold boot): reads 0x5D75F000, which equals the data sheet total reset; the RDL reset was 0 because the reserved bits [31:10] were not modelled (now the field reserved_nz). The value may be set by the BootROM before the prompt (it is the value at the stock U-Boot prompt after a cold boot; stock U-Boot does not touch SATA).";
`ifdef SYS_CTRL_PERIPHCTRL3_VAR1
        field {
            name = "siolrclk_sel";
            reset = 0x0;
        } siolrclk_sel[29:27];

        field {
            name = "siobclk_sel";
            reset = 0x0;
        } siobclk_sel[26:24];

        field {
            name = "sioclk_sel";
            reset = 0x0;
        } sioclk_sel[23:0];
`endif
`ifdef SYS_CTRL_PERIPHCTRL3_VAR2
        field {
            name = "vpll0_reset";
            reset = 0x0;
        } vpll0_reset[22:22];

        field {
            name = "vpll0_pd";
            reset = 0x0;
        } vpll0_pd[21:21];

        field {
            name = "vpll0_foutvcopd";
            reset = 0x0;
        } vpll0_foutvcopd[20:20];

        field {
            name = "vpll0_postdivpd";
            reset = 0x0;
        } vpll0_postdivpd[19:19];

        field {
            name = "vpll0_fout4phasepd";
            reset = 0x0;
        } vpll0_fout4phasepd[18:18];

        field {
            name = "vpll0_refdiv";
            reset = 0x0;
        } vpll0_refdiv[17:12];

        field {
            name = "vpll0_fbdiv";
            reset = 0x0;
        } vpll0_fbdiv[11:0];
`endif
`ifdef SYS_CTRL_PERIPHCTRL3_VAR3
        field {
            name = "ive_ctrl";
            reset = 0x0;
        } ive_ctrl[17:17];

        field {
            name = "mdu_ddrt_ctrl";
            reset = 0x0;
        } mdu_ddrt_ctrl[7:7];

        field {
            name = "jpge_ctrl";
            reset = 0x0;
        } jpge_ctrl[6:6];

        field {
            name = "tde_ctrl";
            reset = 0x0;
        } tde_ctrl[5:5];

        field {
            name = "vpss_ctrl";
            reset = 0x0;
        } vpss_ctrl[4:4];

        field {
            name = "venc_ctrl";
            reset = 0x0;
        } venc_ctrl[3:3];

        field {
            name = "vicap_ctrl";
            reset = 0x0;
        } vicap_ctrl[1:1];

        field {
            name = "vou_ctrl";
            reset = 0x0;
        } vou_ctrl[0:0];
`endif
`ifdef SYS_CTRL_PERIPHCTRL3_VAR4
        field {
            name = "sata_phy0_mpll_ss_sel";
            reset = 0x0;
        } sata_phy0_mpll_ss_sel[9:8];

        enum PERIPHCTRL3_sata_phy0_ref_clk_sel_enum {
            NO_OFFSET = 0x0 { desc = "no offset (default)"; };
        };

        field {
            name = "sata_phy0_ref_clk_sel";
            encode = PERIPHCTRL3_sata_phy0_ref_clk_sel_enum;
            reset = 0x0;
        } sata_phy0_ref_clk_sel[7:0];

        field {
            name = "reserved_nz";
            desc = "Reserved in the data sheet, but the data sheet total reset 0x5D75F000 and the value read on hardware (2026-11-08, stock U-Boot prompt after a cold boot, twice) both have these bits non-zero. Possibly set by the BootROM before the prompt; the value is that at the stock U-Boot prompt after a cold boot. Keep the value when writing the register (the vendor SATA driver never writes it).";
            reset = 0x175D7C;
        } reserved_nz[31:10];
`endif
    } PERIPHCTRL3 @ 0x0038;
`endif

`ifdef SYS_CTRL_PERIPHCTRL4_REG
    reg {
        name = "Peripheral control register 4";
        desc = "Hardware (Hi3520D V100 board, read on hardware 2026-11-08, stock U-Boot prompt after a cold boot): reads 0x00008000 (bit 15, `mdu_ddrt_mst_sel` on the Hi3520D, is set), reset here 0. Boot value (DDR training uses the DDR tester as bus master), not taken as the reset value.";
`ifdef SYS_CTRL_PERIPHCTRL4_VAR1
        field {
            name = "cs1_mode";
            reset = 0x0;
        } cs1_mode[28:28];

        field {
            name = "cs0_mode";
            reset = 0x0;
        } cs0_mode[27:27];

        field {
            name = "rts_mode";
            reset = 0x0;
        } rts_mode[26:26];

        field {
            name = "otg_for_srp";
            reset = 0x0;
        } otg_for_srp[24:24];

        field {
            name = "otg_for_glitch";
            reset = 0x0;
        } otg_for_glitch[23:21];

        field {
            name = "pciclk_mode";
            reset = 0x0;
        } pciclk_mode[20:20];

        field {
            name = "pci_bridge_mode";
            reset = 0x0;
        } pci_bridge_mode[17:17];

        field {
            name = "pci_sim_fast";
            reset = 0x0;
        } pci_sim_fast[16:16];

        field {
            name = "uart1_mode";
            reset = 0x0;
        } uart1_mode[15:15];

        field {
            name = "sio1_clksel";
            reset = 0x0;
        } sio1_clksel[9:9];

        field {
            name = "sio0_clksel";
            reset = 0x0;
        } sio0_clksel[7:7];

        field {
            name = "sm_cancel_wait";
            reset = 0x0;
        } sm_cancel_wait[6:6];

        field {
            name = "otg_tx_tune";
            reset = 0x0;
        } otg_tx_tune[4:1];

        field {
            name = "i2c_delay_bypass";
            reset = 0x0;
        } i2c_delay_bypass[0:0];
`endif
`ifdef SYS_CTRL_PERIPHCTRL4_VAR2
        field {
            name = "vpll1_dsmpd";
            reset = 0x0;
        } vpll1_dsmpd[31:31];

        field {
            name = "vpll1_bypass";
            reset = 0x0;
        } vpll1_bypass[30:30];

        field {
            name = "vpll1_postdiv2";
            reset = 0x0;
        } vpll1_postdiv2[29:27];

        field {
            name = "vpll1_postdiv1";
            reset = 0x0;
        } vpll1_postdiv1[26:24];

        field {
            name = "vpll1_frac";
            reset = 0x0;
        } vpll1_frac[23:0];
`endif
`ifdef SYS_CTRL_PERIPHCTRL4_VAR3
        field {
            name = "cbar_en";
        } cbar_en[16:16];

        field {
            name = "sdio1_det_mode";
            reset = 0x0;
        } sdio1_det_mode[3:3];

        field {
            name = "sdio0_det_mode";
            reset = 0x0;
        } sdio0_det_mode[2:2];

        field {
            name = "uart1_rts_ctrl";
        } uart1_rts_ctrl[1:1];

        field {
            name = "ssp0_cs_sel";
            reset = 0x0;
        } ssp0_cs_sel[0:0];
`endif
`ifdef SYS_CTRL_PERIPHCTRL4_VAR4
        field {
            name = "cbar_en";
        } cbar_en[16:16];

        field {
            name = "mdu_ddrt_sel";
            reset = 0x0;
        } mdu_ddrt_sel[15:15];

        field {
            name = "ssp_cs_sel";
        } ssp_cs_sel[13:12];

        field {
            name = "vdac_ctrl_sl";
            reset = 0x1;
        } vdac_ctrl_sl[8:8];

        field {
            name = "vdac_ctrl_slc";
            reset = 0x1;
        } vdac_ctrl_slc[7:7];

        field {
            name = "vdac_ctrl_slcd";
            reset = 0x1;
        } vdac_ctrl_slcd[6:6];

        field {
            name = "vdac_ctrl_s";
            reset = 0x2;
        } vdac_ctrl_s[5:4];

        field {
            name = "sdio_det_mode";
            reset = 0x0;
        } sdio_det_mode[2:2];

        field {
            name = "uart1_rts_ctrl";
        } uart1_rts_ctrl[1:1];
`endif
`ifdef SYS_CTRL_PERIPHCTRL4_VAR5
        field {
            name = "vdac_ctrl_sl";
            desc = "Other values: bit25 (vdac_ctrl_sl[0]): 0 R channel enabled, 1 powered off Other values: bit26 ([1]): 0 G channel enabled, 1 powered off Other values: bit27 ([2]): 0 B channel enabled, 1 powered off Other values: bit28 ([3]): 0 CVBS0 enabled, 1 powered off Other values: bit29 ([4]): 0 CVBS1 enabled, 1 powered off Other values: bit30 ([5]): 0 CVBS0 and CVBS1 enabled, 1 both powered off Other values: bit31 ([6]): 0 RGB enabled, 1 RGB powered off";
            reset = 0x0;
        } vdac_ctrl_sl[31:25];

        enum PERIPHCTRL4_ram2_ck_gt_en_enum {
            DISABLE = 0x0 { desc = "disabled"; };
            ENABLE = 0x1 { desc = "enabled"; };
        };

        field {
            name = "ram2_ck_gt_en";
            encode = PERIPHCTRL4_ram2_ck_gt_en_enum;
            reset = 0x0;
        } ram2_ck_gt_en[19:19];

        enum PERIPHCTRL4_ram1_ck_gt_en_enum {
            DISABLE = 0x0 { desc = "disabled"; };
            ENABLE = 0x1 { desc = "enabled"; };
        };

        field {
            name = "ram1_ck_gt_en";
            encode = PERIPHCTRL4_ram1_ck_gt_en_enum;
            reset = 0x0;
        } ram1_ck_gt_en[18:18];

        enum PERIPHCTRL4_ram0_ck_gt_en_enum {
            DISABLE = 0x0 { desc = "disabled"; };
            ENABLE = 0x1 { desc = "enabled"; };
        };

        field {
            name = "ram0_ck_gt_en";
            encode = PERIPHCTRL4_ram0_ck_gt_en_enum;
            reset = 0x0;
        } ram0_ck_gt_en[17:17];

        enum PERIPHCTRL4_cbar_en_enum {
            DISABLE = 0x0 { desc = "disabled"; };
            ENABLE = 0x1 { desc = "enabled"; };
        };

        field {
            name = "cbar_en";
            encode = PERIPHCTRL4_cbar_en_enum;
            reset = 0x0;
        } cbar_en[16:16];

        enum PERIPHCTRL4_mdu_ddrt_mst_sel_enum {
            ONLY_MDU_ENABLED = 0x0 { desc = "only the MDU is enabled"; };
            ONLY_DDRT_ENABLED = 0x1 { desc = "only the DDRT is enabled"; };
        };

        field {
            name = "mdu_ddrt_mst_sel";
            encode = PERIPHCTRL4_mdu_ddrt_mst_sel_enum;
            reset = 0x0;
        } mdu_ddrt_mst_sel[15:15];

        enum PERIPHCTRL4_ssp_cs_sel_enum {
            CS_0 = 0x0 { desc = "CS 0"; };
            CS_1 = 0x1 { desc = "CS 1"; };
        };

        field {
            name = "ssp_cs_sel";
            encode = PERIPHCTRL4_ssp_cs_sel_enum;
            reset = 0x0;
        } ssp_cs_sel[13:12];

        enum PERIPHCTRL4_uart1_rts_ctrl_enum {
            NORMAL_OUTPUT = 0x0 { desc = "normal output"; };
            REVERSE_OUTPUT = 0x1 { desc = "reverse output"; };
        };

        field {
            name = "uart1_rts_ctrl";
            encode = PERIPHCTRL4_uart1_rts_ctrl_enum;
            reset = 0x0;
        } uart1_rts_ctrl[1:1];
`endif
    } PERIPHCTRL4 @ 0x003C;
`endif

`ifdef SYS_CTRL_PERIPHCTRL5_REG
    reg {
        name = "Peripheral control register 5";
        desc = "MEDIA0 bus master port timeout control register 0";
`ifdef SYS_CTRL_PERIPHCTRL5_VAR1
        field {
            name = "vpll1_reset";
            reset = 0x0;
        } vpll1_reset[22:22];

        field {
            name = "vpll1_pd";
            reset = 0x0;
        } vpll1_pd[21:21];

        field {
            name = "vpll1_foutvcopd";
            reset = 0x0;
        } vpll1_foutvcopd[20:20];

        field {
            name = "vpll1_postdivpd";
            reset = 0x0;
        } vpll1_postdivpd[19:19];

        field {
            name = "vpll1_fout4phasepd";
            reset = 0x0;
        } vpll1_fout4phasepd[18:18];

        field {
            name = "vpll1_refdiv";
            reset = 0x0;
        } vpll1_refdiv[17:12];

        field {
            name = "vpll1_fbdiv";
            reset = 0x0;
        } vpll1_fbdiv[11:0];
`endif
`ifdef SYS_CTRL_PERIPHCTRL5_VAR2
        field {
            name = "count_en_media0_port1";
        } count_en_media0_port1[31:31];

        field {
            name = "over_value_media0_port1";
        } over_value_media0_port1[30:16];

        field {
            name = "count_en_media0_port0";
        } count_en_media0_port0[15:15];

        field {
            name = "over_value_media0_port0";
        } over_value_media0_port0[14:0];
`endif
`ifdef SYS_CTRL_PERIPHCTRL5_VAR3
        enum PERIPHCTRL5_count_en_media0_port1_enum {
            DISABLE = 0x0 { desc = "disabled"; };
            ENABLE = 0x1 { desc = "enabled"; };
        };

        field {
            name = "count_en_media0_port1";
            encode = PERIPHCTRL5_count_en_media0_port1_enum;
            reset = 0x0;
        } count_en_media0_port1[31:31];

        field {
            name = "over_value_media0_port1";
            reset = 0x0;
        } over_value_media0_port1[30:16];

        enum PERIPHCTRL5_count_en_media0_port0_enum {
            DISABLE = 0x0 { desc = "disabled"; };
            ENABLE = 0x1 { desc = "enabled"; };
        };

        field {
            name = "count_en_media0_port0";
            encode = PERIPHCTRL5_count_en_media0_port0_enum;
            reset = 0x0;
        } count_en_media0_port0[15:15];

        field {
            name = "over_value_media0_port0";
            reset = 0x0;
        } over_value_media0_port0[14:0];
`endif
    } PERIPHCTRL5 @ 0x0040;
`endif

    reg {
        name = "Lock register of the critical system control register";
`ifdef SYS_CTRL_LOCK_VAR1
        field {
            name = "scper_lockl";
        } scper_lockl[31:0];
`endif
`ifdef SYS_CTRL_LOCK_VAR2
        field {
            name = "scper_lock";
            reset = 0x0;
        } scper_lock[31:0];
`endif
`ifdef SYS_CTRL_LOCK_VAR3
        field {
            name = "scper_lockl";
            desc = "Other values: write 0x1ACCE551: unlock (write permission enabled) Other values: write other: lock Other values: read 0x00000000: unlocked Other values: read 0x00000001: locked";
            reset = 0x0;
        } scper_lockl[31:0];
`endif
    } LOCK @ 0x0044;

`ifdef SYS_CTRL_PERIPHCTRL6_REG
    reg {
        name = "Peripheral control register 6";
        desc = "MEDIA0 bus master port timeout control register 1";
`ifdef SYS_CTRL_PERIPHCTRL6_VAR1
        field {
            name = "epll_dsmpd";
            reset = 0x0;
        } epll_dsmpd[31:31];

        field {
            name = "epll_bypass";
            reset = 0x0;
        } epll_bypass[30:30];

        field {
            name = "epll_postdiv2";
            reset = 0x0;
        } epll_postdiv2[29:27];

        field {
            name = "epll_postdiv1";
            reset = 0x0;
        } epll_postdiv1[26:24];

        field {
            name = "epll_frac";
            reset = 0x0;
        } epll_frac[23:0];
`endif
`ifdef SYS_CTRL_PERIPHCTRL6_VAR2
        field {
            name = "count_en_media0_port3";
        } count_en_media0_port3[31:31];

        field {
            name = "over_value_media0_port3";
        } over_value_media0_port3[30:16];

        field {
            name = "count_en_media0_port2";
        } count_en_media0_port2[15:15];

        field {
            name = "over_value_media0_port2";
        } over_value_media0_port2[14:0];
`endif
`ifdef SYS_CTRL_PERIPHCTRL6_VAR3
        enum PERIPHCTRL6_count_en_media0_port3_enum {
            DISABLE = 0x0 { desc = "disabled"; };
            ENABLE = 0x1 { desc = "enabled"; };
        };

        field {
            name = "count_en_media0_port3";
            encode = PERIPHCTRL6_count_en_media0_port3_enum;
            reset = 0x0;
        } count_en_media0_port3[31:31];

        field {
            name = "over_value_media0_port3";
            reset = 0x0;
        } over_value_media0_port3[30:16];

        enum PERIPHCTRL6_count_en_media0_port2_enum {
            DISABLE = 0x0 { desc = "disabled"; };
            ENABLE = 0x1 { desc = "enabled"; };
        };

        field {
            name = "count_en_media0_port2";
            encode = PERIPHCTRL6_count_en_media0_port2_enum;
            reset = 0x0;
        } count_en_media0_port2[15:15];

        field {
            name = "over_value_media0_port2";
            reset = 0x0;
        } over_value_media0_port2[14:0];
`endif
    } PERIPHCTRL6 @ 0x0048;
`endif

`ifdef SYS_CTRL_PERIPHCTRL7_REG
    reg {
        name = "Peripheral control register 7";
`ifdef SYS_CTRL_PERIPHCTRL7_VAR1
        field {
            name = "epll_reset";
            reset = 0x0;
        } epll_reset[22:22];

        field {
            name = "epll_pd";
            reset = 0x0;
        } epll_pd[21:21];

        field {
            name = "epll_foutvcopd";
            reset = 0x0;
        } epll_foutvcopd[20:20];

        field {
            name = "epll_postdivpd";
            reset = 0x0;
        } epll_postdivpd[19:19];

        field {
            name = "epll_fout4phasepd";
            reset = 0x0;
        } epll_fout4phasepd[18:18];

        field {
            name = "epll_refdiv";
            reset = 0x0;
        } epll_refdiv[17:12];

        field {
            name = "epll_fbdiv";
            reset = 0x0;
        } epll_fbdiv[11:0];
`endif
`ifdef SYS_CTRL_PERIPHCTRL7_VAR2
        field {
            name = "count_en_media0_port4";
            reset = 0x0;
        } count_en_media0_port4[15:15];

        field {
            name = "over_value_media0_port4";
            reset = 0x0;
        } over_value_media0_port4[14:0];
`endif
    } PERIPHCTRL7 @ 0x004C;
`endif

`ifdef SYS_CTRL_PERIPHCTRL8_REG
    reg {
        name = "Peripheral control register 8";
        field {
            name = "usb_srst";
            reset = 0x0;
        } usb_srst[31:31];

        field {
            name = "usb_hrst";
            reset = 0x0;
        } usb_hrst[30:30];

        field {
            name = "vohd_srst";
            reset = 0x0;
        } vohd_srst[29:29];

        field {
            name = "vosd_srst";
            reset = 0x0;
        } vosd_srst[28:28];

        field {
            name = "voad_srst";
            reset = 0x0;
        } voad_srst[27:27];

        field {
            name = "vo_srst";
            reset = 0x0;
        } vo_srst[26:26];

        field {
            name = "vi3_srst";
            reset = 0x0;
        } vi3_srst[25:25];

        field {
            name = "vi2_srst";
            reset = 0x0;
        } vi2_srst[24:24];

        field {
            name = "vi1_srst";
            reset = 0x0;
        } vi1_srst[23:23];

        field {
            name = "vi0_srst";
            reset = 0x0;
        } vi0_srst[22:22];

        field {
            name = "vi_srst";
            reset = 0x0;
        } vi_srst[21:21];

        field {
            name = "gmac_srst";
            reset = 0x0;
        } gmac_srst[20:20];

        field {
            name = "mdio_srst";
            reset = 0x0;
        } mdio_srst[19:19];

        field {
            name = "eth_srst";
            reset = 0x0;
        } eth_srst[18:18];

        field {
            name = "sio2_srst";
            reset = 0x0;
        } sio2_srst[17:17];

        field {
            name = "sio1_srst";
            reset = 0x0;
        } sio1_srst[16:16];

        field {
            name = "sio0_srst";
            reset = 0x0;
        } sio0_srst[15:15];

        field {
            name = "mmc_srst";
            reset = 0x0;
        } mmc_srst[14:14];

        field {
            name = "pci_srst";
            reset = 0x0;
        } pci_srst[13:13];

        field {
            name = "i2c_srst";
            reset = 0x0;
        } i2c_srst[12:12];

        field {
            name = "rtc_srst";
            reset = 0x0;
        } rtc_srst[11:11];

        field {
            name = "ir_srst";
            reset = 0x0;
        } ir_srst[10:10];

        field {
            name = "uart3_srst";
            reset = 0x0;
        } uart3_srst[9:9];

        field {
            name = "uart2_srst";
            reset = 0x0;
        } uart2_srst[8:8];

        field {
            name = "uart1_srst";
            reset = 0x0;
        } uart1_srst[7:7];

        field {
            name = "uart0_srst";
            reset = 0x0;
        } uart0_srst[6:6];

        field {
            name = "cipher_srst";
            reset = 0x0;
        } cipher_srst[5:5];

        field {
            name = "ssmc_srst";
            reset = 0x0;
        } ssmc_srst[4:4];

        field {
            name = "arm9_srst";
            reset = 0x0;
        } arm9_srst[1:1];

        field {
            name = "arm11_srst";
            reset = 0x0;
        } arm11_srst[0:0];
    } PERIPHCTRL8 @ 0x0050;
`endif

`ifdef SYS_CTRL_PERIPHCTRL9_REG
    reg {
        name = "Peripheral control register 9";
        desc = "MEDIA0 bus master port priority control register";
`ifdef SYS_CTRL_PERIPHCTRL9_VAR1
        field {
            name = "aclkout_sel";
        } aclkout_sel[25:25];

        field {
            name = "mmcsap_sel";
        } mmcsap_sel[22:22];

        field {
            name = "mmcclk_sel";
        } mmcclk_sel[21:20];

        field {
            name = "vo1out_sel";
            sw = r;
            hw = w;
        } vo1out_sel[19:19];

        field {
            name = "vo0out_sel";
        } vo0out_sel[18:18];

        field {
            name = "vi3div_sel";
        } vi3div_sel[13:12];

        field {
            name = "vi2div_sel";
        } vi2div_sel[11:10];

        field {
            name = "vi1div_sel";
        } vi1div_sel[9:8];

        field {
            name = "vi0div_sel";
        } vi0div_sel[7:6];

        field {
            name = "vi3_vi2_sel";
        } vi3_vi2_sel[5:5];

        field {
            name = "vi1_vi0_sel";
        } vi1_vi0_sel[4:4];

        field {
            name = "ssmcclk_sel";
        } ssmcclk_sel[3:3];

        field {
            name = "vo0out_clk_sel";
            reset = 0x0;
        } vo0out_clk_sel[2:2];

        field {
            name = "sata_clk_sel";
            reset = 0x0;
        } sata_clk_sel[1:1];

        field {
            name = "tde_clk_sel";
            reset = 0x0;
        } tde_clk_sel[0:0];
`endif
`ifdef SYS_CTRL_PERIPHCTRL9_VAR2
        field {
            name = "media0_port4_pri";
            reset = 0x1;
        } media0_port4_pri[18:16];

        field {
            name = "media0_port3_pri";
        } media0_port3_pri[14:12];

        field {
            name = "media0_port2_pri";
        } media0_port2_pri[10:8];

        field {
            name = "media0_port1_pri";
        } media0_port1_pri[6:4];

        field {
            name = "media0_port0_pri";
        } media0_port0_pri[2:0];
`endif
`ifdef SYS_CTRL_PERIPHCTRL9_VAR3
        field {
            name = "ethtclk_sel";
            reset = 0x0;
        } ethtclk_sel[29:29];

        field {
            name = "ethmac_mode";
            reset = 0x0;
        } ethmac_mode[28:26];

        field {
            name = "aclkout_sel";
        } aclkout_sel[25:25];

        field {
            name = "pciclk_sel";
            reset = 0x0;
        } pciclk_sel[24:23];

        field {
            name = "mmcsap_sel";
        } mmcsap_sel[22:22];

        field {
            name = "mmcclk_sel";
        } mmcclk_sel[21:20];

        field {
            name = "vo1out_sel";
        } vo1out_sel[19:19];

        field {
            name = "vo0out_sel";
        } vo0out_sel[18:18];

        field {
            name = "vohd_sel";
            reset = 0x0;
        } vohd_sel[17:16];

        field {
            name = "vosd_sel";
            reset = 0x0;
        } vosd_sel[15:14];

        field {
            name = "vi3div_sel";
        } vi3div_sel[13:12];

        field {
            name = "vi2div_sel";
        } vi2div_sel[11:10];

        field {
            name = "vi1div_sel";
        } vi1div_sel[9:8];

        field {
            name = "vi0div_sel";
        } vi0div_sel[7:6];

        field {
            name = "vi3_vi2_sel";
        } vi3_vi2_sel[5:5];

        field {
            name = "vi1_vi0_sel";
        } vi1_vi0_sel[4:4];

        field {
            name = "ssmcclk_sel";
        } ssmcclk_sel[3:3];

        field {
            name = "arm1freq_sel";
            reset = 0x0;
        } arm1freq_sel[2:2];

        field {
            name = "arm0freq_sel";
            reset = 0x0;
        } arm0freq_sel[1:0];
`endif
`ifdef SYS_CTRL_PERIPHCTRL9_VAR4
        field {
            name = "media0_port3_pri";
            reset = 0x0;
        } media0_port3_pri[14:12];

        field {
            name = "media0_port2_pri";
            reset = 0x1;
        } media0_port2_pri[10:8];

        field {
            name = "media0_port1_pri";
            reset = 0x2;
        } media0_port1_pri[6:4];

        field {
            name = "media0_port0_pri";
            reset = 0x3;
        } media0_port0_pri[2:0];
`endif
    } PERIPHCTRL9 @ 0x0054;
`endif

`ifdef SYS_CTRL_PERIPHCTRL10_REG
    reg {
        name = "Peripheral control register 10";
        desc = "System bus master port timeout control register 0";
`ifdef SYS_CTRL_PERIPHCTRL10_VAR1
        field {
            name = "sata_alive_rst";
            reset = 0x0;
        } sata_alive_rst[24:24];

        field {
            name = "sata_rx1_rst";
            reset = 0x0;
        } sata_rx1_rst[23:23];

        field {
            name = "sata_rx0_rst";
            reset = 0x0;
        } sata_rx0_rst[22:22];

        field {
            name = "sata_tx1_rst";
            reset = 0x0;
        } sata_tx1_rst[21:21];

        field {
            name = "sata_tx0_rst";
            reset = 0x0;
        } sata_tx0_rst[20:20];

        field {
            name = "sata_phyrst";
            reset = 0x0;
        } sata_phyrst[19:19];

        field {
            name = "sata_hrst";
            reset = 0x0;
        } sata_hrst[18:18];

        field {
            name = "sata_rst";
            reset = 0x0;
        } sata_rst[17:17];

        field {
            name = "vedu0_stdmod_p1";
            reset = 0x0;
        } vedu0_stdmod_p1[16:11];

        field {
            name = "dma_hrst";
            reset = 0x0;
        } dma_hrst[6:6];

        field {
            name = "ddr_hrst";
            reset = 0x0;
        } ddr_hrst[5:5];

        field {
            name = "spi_hrst";
            reset = 0x0;
        } spi_hrst[4:4];

        field {
            name = "nadc_hrst";
            reset = 0x0;
        } nadc_hrst[2:2];

        field {
            name = "tde_srst";
            reset = 0x0;
        } tde_srst[1:1];

        field {
            name = "tde_hrst";
            reset = 0x0;
        } tde_hrst[0:0];
`endif
`ifdef SYS_CTRL_PERIPHCTRL10_VAR2
        field {
            name = "count_en_port2";
            reset = 0x0;
        } count_en_port2[31:31];

        field {
            name = "over_value_port2";
            reset = 0x0;
        } over_value_port2[30:16];

        field {
            name = "count_en_port1";
            reset = 0x0;
        } count_en_port1[15:15];

        field {
            name = "over_value_port1";
            reset = 0x0;
        } over_value_port1[14:0];
`endif
`ifdef SYS_CTRL_PERIPHCTRL10_VAR3
        field {
            name = "count_en_port1";
        } count_en_port1[31:31];

        field {
            name = "over_value_port1";
        } over_value_port1[30:16];

        field {
            name = "count_en_port0";
        } count_en_port0[15:15];

        field {
            name = "over_value_port0";
        } over_value_port0[14:0];
`endif
`ifdef SYS_CTRL_PERIPHCTRL10_VAR4
        field {
            name = "dma_srst";
            reset = 0x0;
        } dma_srst[6:6];

        field {
            name = "ddrphy_srst";
            reset = 0x0;
        } ddrphy_srst[5:5];

        field {
            name = "spi_srst";
            reset = 0x0;
        } spi_srst[4:4];

        field {
            name = "ipcm_srst";
            reset = 0x0;
        } ipcm_srst[3:3];

        field {
            name = "nadc_srst";
            reset = 0x0;
        } nadc_srst[2:2];

        field {
            name = "tde_rst";
            reset = 0x0;
        } tde_rst[1:1];

        field {
            name = "tde_srst";
            reset = 0x0;
        } tde_srst[0:0];
`endif
`ifdef SYS_CTRL_PERIPHCTRL10_VAR5
        enum PERIPHCTRL10_count_en_port1_enum {
            DISABLE = 0x0 { desc = "disabled"; };
            ENABLE = 0x1 { desc = "enabled"; };
        };

        field {
            name = "count_en_port1";
            encode = PERIPHCTRL10_count_en_port1_enum;
            reset = 0x0;
        } count_en_port1[31:31];

        field {
            name = "over_value_port1";
            reset = 0x0;
        } over_value_port1[30:16];

        enum PERIPHCTRL10_count_en_port0_enum {
            DISABLE = 0x0 { desc = "disabled"; };
            ENABLE = 0x1 { desc = "enabled"; };
        };

        field {
            name = "count_en_port0";
            encode = PERIPHCTRL10_count_en_port0_enum;
            reset = 0x0;
        } count_en_port0[15:15];

        field {
            name = "over_value_port0";
            reset = 0x0;
        } over_value_port0[14:0];
`endif
    } PERIPHCTRL10 @ 0x0058;
`endif

`ifdef SYS_CTRL_PERIPHCTRL11_REG
    reg {
        name = "Peripheral control register 11";
        desc = "System bus master port timeout control register 1";
`ifdef SYS_CTRL_PERIPHCTRL11_VAR1
        field {
            name = "uart1_rtsmode";
        } uart1_rtsmode[31:31];

        field {
            name = "spi_port";
        } spi_port[30:30];

        field {
            name = "smi_canclewait";
        } smi_canclewait[29:29];

        field {
            name = "ebinandc_time_out";
        } ebinandc_time_out[28:19];

        field {
            name = "ebismi_time_out";
        } ebismi_time_out[18:9];

        field {
            name = "ebi_arb_delay";
        } ebi_arb_delay[8:7];

        field {
            name = "ebi_mormal_mode";
        } ebi_mormal_mode[6:6];

        field {
            name = "i2c_delay_bypass";
        } i2c_delay_bypass[5:5];
`endif
`ifdef SYS_CTRL_PERIPHCTRL11_VAR2
        field {
            name = "count_en_port4";
            reset = 0x0;
        } count_en_port4[31:31];

        field {
            name = "over_value_port4";
            reset = 0x0;
        } over_value_port4[30:16];

        field {
            name = "count_en_port3";
            reset = 0x0;
        } count_en_port3[15:15];

        field {
            name = "over_value_port3";
            reset = 0x0;
        } over_value_port3[14:0];
`endif
`ifdef SYS_CTRL_PERIPHCTRL11_VAR3
        field {
            name = "count_en_port3";
        } count_en_port3[31:31];

        field {
            name = "over_value_port3";
        } over_value_port3[30:16];

        field {
            name = "count_en_port2";
        } count_en_port2[15:15];

        field {
            name = "over_value_port2";
        } over_value_port2[14:0];
`endif
`ifdef SYS_CTRL_PERIPHCTRL11_VAR4
        field {
            name = "uart1_rtsmode";
        } uart1_rtsmode[31:31];

        field {
            name = "spi_port";
        } spi_port[30:30];

        field {
            name = "smi_canclewait";
        } smi_canclewait[29:29];

        field {
            name = "ebinandc_time_out";
        } ebinandc_time_out[28:19];

        field {
            name = "ebismi_time_out";
        } ebismi_time_out[18:9];

        field {
            name = "ebi_arb_delay";
        } ebi_arb_delay[8:7];

        field {
            name = "ebi_mormal_mode";
        } ebi_mormal_mode[6:6];

        field {
            name = "i2c_delay_bypass";
        } i2c_delay_bypass[5:5];

        field {
            name = "pci_sim_fast";
            reset = 0x0;
        } pci_sim_fast[4:4];

        field {
            name = "pci_type";
            reset = 0x0;
        } pci_type[3:2];

        field {
            name = "pci_clkmode";
            reset = 0x0;
        } pci_clkmode[1:1];

        field {
            name = "pci_mode";
            reset = 0x0;
        } pci_mode[0:0];
`endif
`ifdef SYS_CTRL_PERIPHCTRL11_VAR5
        enum PERIPHCTRL11_count_en_port3_enum {
            DISABLE = 0x0 { desc = "disabled"; };
            ENABLE = 0x1 { desc = "enabled"; };
        };

        field {
            name = "count_en_port3";
            encode = PERIPHCTRL11_count_en_port3_enum;
            reset = 0x0;
        } count_en_port3[31:31];

        field {
            name = "over_value_port3";
            reset = 0x0;
        } over_value_port3[30:16];

        enum PERIPHCTRL11_count_en_port2_enum {
            DISABLE = 0x0 { desc = "disabled"; };
            ENABLE = 0x1 { desc = "enabled"; };
        };

        field {
            name = "count_en_port2";
            encode = PERIPHCTRL11_count_en_port2_enum;
            reset = 0x0;
        } count_en_port2[15:15];

        field {
            name = "over_value_port2";
            reset = 0x0;
        } over_value_port2[14:0];
`endif
    } PERIPHCTRL11 @ 0x005C;
`endif

`ifdef SYS_CTRL_PERIPHCTRL12_REG
    reg {
        name = "Peripheral control register 12";
`ifdef SYS_CTRL_PERIPHCTRL12_VAR1
        field {
            name = "usb_start_clk";
        } usb_start_clk[19:19];

        field {
            name = "usb_susp_lgcy";
        } usb_susp_lgcy[18:18];

        field {
            name = "usb_tune1";
        } usb_tune1[13:12];

        field {
            name = "usb_tune0";
        } usb_tune0[11:10];

        field {
            name = "dac1_powredown";
        } dac1_powredown[9:9];

        field {
            name = "dac0_powredown";
        } dac0_powredown[8:8];

        field {
            name = "vou_test_en";
        } vou_test_en[7:7];

        field {
            name = "sio1_master";
        } sio1_master[3:3];

        field {
            name = "sio0_xfs";
        } sio0_xfs[2:2];

        field {
            name = "sio0_xck";
        } sio0_xck[1:1];

        field {
            name = "sio0_master";
        } sio0_master[0:0];
`endif
`ifdef SYS_CTRL_PERIPHCTRL12_VAR2
        field {
            name = "count_en_port5";
            reset = 0x0;
        } count_en_port5[15:15];

        field {
            name = "over_value_port5";
            reset = 0x0;
        } over_value_port5[14:0];
`endif
`ifdef SYS_CTRL_PERIPHCTRL12_VAR3
        field {
            name = "mst_pri3";
            reset = 0x1;
        } mst_pri3[14:12];

        field {
            name = "mst_pri2";
            reset = 0x2;
        } mst_pri2[10:8];

        field {
            name = "mst_pri1";
            reset = 0x3;
        } mst_pri1[6:4];

        field {
            name = "mst_pri0";
            reset = 0x4;
        } mst_pri0[2:0];
`endif
`ifdef SYS_CTRL_PERIPHCTRL12_VAR4
        field {
            name = "usb_start_clk";
        } usb_start_clk[19:19];

        field {
            name = "usb_susp_lgcy";
        } usb_susp_lgcy[18:18];

        field {
            name = "ddrck2_dis";
            reset = 0x0;
        } ddrck2_dis[17:17];

        field {
            name = "ddrck1_dis";
            reset = 0x0;
        } ddrck1_dis[16:16];

        field {
            name = "ddrck0_dis";
            reset = 0x0;
        } ddrck0_dis[15:15];

        field {
            name = "ddr_clksel";
            reset = 0x0;
        } ddr_clksel[14:14];

        field {
            name = "usb_tune1";
        } usb_tune1[13:12];

        field {
            name = "usb_tune0";
        } usb_tune0[11:10];

        field {
            name = "dac1_powredown";
        } dac1_powredown[9:9];

        field {
            name = "dac0_powredown";
        } dac0_powredown[8:8];

        field {
            name = "vou_test_en";
        } vou_test_en[7:7];

        field {
            name = "sio2_master";
            reset = 0x0;
        } sio2_master[6:6];

        field {
            name = "sio1_xfs";
            reset = 0x0;
        } sio1_xfs[5:5];

        field {
            name = "sio1_xck";
            reset = 0x0;
        } sio1_xck[4:4];

        field {
            name = "sio1_master";
        } sio1_master[3:3];

        field {
            name = "sio0_xfs";
        } sio0_xfs[2:2];

        field {
            name = "sio0_xck";
        } sio0_xck[1:1];

        field {
            name = "sio0_master";
        } sio0_master[0:0];
`endif
    } PERIPHCTRL12 @ 0x0060;
`endif

`ifdef SYS_CTRL_PERIPHCTRL13_REG
    reg {
        name = "Peripheral control register 13";
        desc = "System bus master port timeout control register 1";
`ifdef SYS_CTRL_PERIPHCTRL13_VAR1
        field {
            name = "sio0_lrclk_sel";
            reset = 0x0;
        } sio0_lrclk_sel[31:28];

        field {
            name = "sio0_bclk_sel";
            reset = 0x0;
        } sio0_bclk_sel[27:24];

        field {
            name = "sio0clk_sel";
            reset = 0x0;
        } sio0clk_sel[23:0];
`endif
`ifdef SYS_CTRL_PERIPHCTRL13_VAR2
        field {
            name = "mst_pri5";
            reset = 0x1;
        } mst_pri5[18:16];

        field {
            name = "mst_pri4";
            reset = 0x2;
        } mst_pri4[14:12];

        field {
            name = "mst_pri3";
            reset = 0x3;
        } mst_pri3[10:8];

        field {
            name = "mst_pri2";
            reset = 0x4;
        } mst_pri2[6:4];

        field {
            name = "mst_pri1";
            reset = 0x5;
        } mst_pri1[2:0];
`endif
`ifdef SYS_CTRL_PERIPHCTRL13_VAR3
        field {
            name = "slave_priority_s4";
            reset = 0x1;
        } slave_priority_s4[14:12];

        field {
            name = "slave_priority_s3";
            reset = 0x2;
        } slave_priority_s3[10:8];

        field {
            name = "slave_priority_s2";
            reset = 0x3;
        } slave_priority_s2[6:4];

        field {
            name = "slave_priority_s1";
            reset = 0x4;
        } slave_priority_s1[2:0];
`endif
`ifdef SYS_CTRL_PERIPHCTRL13_VAR4
        field {
            name = "mst_pri3";
            reset = 0x0;
        } mst_pri3[14:12];

        field {
            name = "mst_pri2";
            reset = 0x1;
        } mst_pri2[10:8];

        field {
            name = "mst_pri1";
            reset = 0x2;
        } mst_pri1[6:4];

        field {
            name = "mst_pri0";
            reset = 0x3;
        } mst_pri0[2:0];
`endif
    } PERIPHCTRL13 @ 0x0064;
`endif

`ifdef SYS_CTRL_PERIPHCTRL14_REG
    reg {
        name = "Peripheral control register 14";
        desc = "System bus slave end port priority control register Hardware (Hi3520D V100 board, read on hardware 2026-11-08, stock U-Boot prompt after a cold boot): reads 0x00000123, the data sheet total reset is 0x00123456 (modelled fields 0x00003456). Left at the data sheet value: 0x123 looks like a value written by the boot table; open question.";
`ifdef SYS_CTRL_PERIPHCTRL14_VAR1
        field {
            name = "sio1_bclk_sel";
        } sio1_bclk_sel[27:24];

        field {
            name = "sio12clk_sel";
        } sio12clk_sel[23:0];
`endif
`ifdef SYS_CTRL_PERIPHCTRL14_VAR2
        field {
            name = "slave_priority_s6";
            reset = 0x6;
        } slave_priority_s6[22:20];

        field {
            name = "slave_priority_s5";
            reset = 0x5;
        } slave_priority_s5[18:16];

        field {
            name = "slave_priority_s4";
        } slave_priority_s4[14:12];

        field {
            name = "slave_priority_s3";
        } slave_priority_s3[10:8];

        field {
            name = "slave_priority_s2";
        } slave_priority_s2[6:4];

        field {
            name = "slave_priority_s1";
        } slave_priority_s1[2:0];
`endif
`ifdef SYS_CTRL_PERIPHCTRL14_VAR3
        field {
            name = "pd_adcl";
            reset = 0x0;
        } pd_adcl[31:31];

        field {
            name = "pd_adcr";
            reset = 0x0;
        } pd_adcr[30:30];

        field {
            name = "pd_dacl";
            reset = 0x0;
        } pd_dacl[29:29];

        field {
            name = "pd_dacr";
            reset = 0x0;
        } pd_dacr[28:28];

        field {
            name = "pd_micbias";
            reset = 0x0;
        } pd_micbias[27:27];

        field {
            name = "pd_vref";
            reset = 0x0;
        } pd_vref[26:26];

        field {
            name = "fstarup";
            reset = 0x0;
        } fstarup[25:25];

        field {
            name = "ana_loop";
            reset = 0x0;
        } ana_loop[24:24];

        field {
            name = "mute_dacl";
            reset = 0x0;
        } mute_dacl[23:23];

        field {
            name = "mute_dacr";
            reset = 0x0;
        } mute_dacr[22:22];

        field {
            name = "popfreel";
            reset = 0x0;
        } popfreel[21:21];

        field {
            name = "popfreer";
            reset = 0x0;
        } popfreer[20:20];

        field {
            name = "mute_micl";
            reset = 0x0;
        } mute_micl[19:19];

        field {
            name = "mute_micr";
            reset = 0x0;
        } mute_micr[18:18];

        field {
            name = "mclk_ana_sel";
            reset = 0x0;
        } mclk_ana_sel[17:17];

        field {
            name = "dacclk_sel";
            reset = 0x0;
        } dacclk_sel[16:16];

        field {
            name = "lineinl_sel";
            reset = 0x0;
        } lineinl_sel[15:15];

        field {
            name = "gain_micl";
            reset = 0x0;
        } gain_micl[14:10];

        field {
            name = "gainboostl";
            reset = 0x0;
        } gainboostl[9:9];

        field {
            name = "clk_timing_sel";
            reset = 0x0;
        } clk_timing_sel[8:8];

        field {
            name = "lineinr_sel";
            reset = 0x0;
        } lineinr_sel[7:7];

        field {
            name = "gain_micr";
            reset = 0x0;
        } gain_micr[6:2];

        field {
            name = "gainboostr";
            reset = 0x0;
        } gainboostr[1:1];

        field {
            name = "clk_delay_sel";
            reset = 0x0;
        } clk_delay_sel[0:0];
`endif
`ifdef SYS_CTRL_PERIPHCTRL14_VAR4
        field {
            name = "sio1_lrclk_sel";
            reset = 0x0;
        } sio1_lrclk_sel[31:28];

        field {
            name = "sio1_bclk_sel";
        } sio1_bclk_sel[27:24];

        field {
            name = "sio12clk_sel";
        } sio12clk_sel[23:0];
`endif
`ifdef SYS_CTRL_PERIPHCTRL14_VAR5
        field {
            name = "slave_priority_s4";
            reset = 0x3;
        } slave_priority_s4[14:12];

        field {
            name = "slave_priority_s3";
            reset = 0x4;
        } slave_priority_s3[10:8];

        field {
            name = "slave_priority_s2";
            reset = 0x5;
        } slave_priority_s2[6:4];

        field {
            name = "slave_priority_s1";
            reset = 0x6;
        } slave_priority_s1[2:0];

        field {
            name = "reserved_nz";
            desc = "Reserved in the data sheet (bits [31:15] listed as reserved, RO), but the data sheet total reset is 0x0012_3456, so bits [20:16] reset to 0x12 (the four slave_priority fields account for 0x3456). Keep the reset value when writing the register.";
            reset = 0x12;
        } reserved_nz[20:16];
`endif
    } PERIPHCTRL14 @ 0x0068;
`endif

`ifdef SYS_CTRL_PERIPHCTRL15_REG
    reg {
        name = "Peripheral control register 15";
        desc = "Hardware (Hi3520D V100 board, read on hardware 2026-11-08, stock U-Boot prompt after a cold boot): reads 0x00000003; the data sheet gives no reset. May be a boot-table write, therefore not applied as a reset.";
`ifdef SYS_CTRL_PERIPHCTRL15_VAR1
        field {
            name = "dacl_rst_n";
            reset = 0x0;
        } dacl_rst_n[31:31];

        field {
            name = "dacr_rst_n";
            reset = 0x0;
        } dacr_rst_n[30:30];

        field {
            name = "adcl_rst_n";
            reset = 0x0;
        } adcl_rst_n[29:29];

        field {
            name = "adcr_rst_n";
            reset = 0x0;
        } adcr_rst_n[28:28];

        field {
            name = "dacl_en";
            reset = 0x0;
        } dacl_en[27:27];

        field {
            name = "dacr_en";
            reset = 0x0;
        } dacr_en[26:26];

        field {
            name = "adcl_en";
            reset = 0x0;
        } adcl_en[25:25];

        field {
            name = "adcr_en";
            reset = 0x0;
        } adcr_en[24:24];

        field {
            name = "i2s1_data_bits";
            reset = 0x3;
        } i2s1_data_bits[23:22];

        field {
            name = "i2s2_data_bits";
            reset = 0x3;
        } i2s2_data_bits[21:20];

        field {
            name = "dig_bypass";
            reset = 0x0;
        } dig_bypass[19:19];

        field {
            name = "dig_loop";
            reset = 0x0;
        } dig_loop[18:18];

        field {
            name = "i2s1_fs_sel";
            reset = 0x1E;
        } i2s1_fs_sel[17:13];

        field {
            name = "i2s2_fs_sel";
            reset = 0x1E;
        } i2s2_fs_sel[12:8];

        field {
            name = "ibadj_adc";
            reset = 0x1;
        } ibadj_adc[7:6];

        field {
            name = "ibadj_dac";
            reset = 0x1;
        } ibadj_dac[5:5];

        field {
            name = "ibadj_ctcm";
            sw = w;
            hw = r;
            reset = 0x1;
        } ibadj_ctcm[4:4];

        field {
            name = "adc_adatn";
            reset = 0x1;
        } adc_adatn[3:2];

        field {
            name = "adc_flstn";
            reset = 0x0;
        } adc_flstn[1:1];

        field {
            name = "rst";
            reset = 0x1;
        } rst[0:0];
`endif
`ifdef SYS_CTRL_PERIPHCTRL15_VAR2
        enum PERIPHCTRL15_chipid_enum {
            HI3515A = 0x1 { desc = "Hi3515A"; };
            HI3515C = 0xA { desc = "Hi3515C"; };
            HI3520D = 0xB { desc = "Hi3520D"; };
        };

        field {
            name = "chipid";
            sw = r;
            hw = w;
            encode = PERIPHCTRL15_chipid_enum;
        } chipid[11:0];
`endif
    } PERIPHCTRL15 @ 0x006C;
`endif

`ifdef SYS_CTRL_PERIPHCTRL16_REG
    reg {
        name = "Peripheral control register 16";
        desc = "MEDIA1 bus master port timeout control register 0";
`ifdef SYS_CTRL_PERIPHCTRL16_VAR1
        field {
            name = "sio1_bclk_edge";
            reset = 0x0;
        } sio1_bclk_edge[9:9];

        field {
            name = "sio0_bclk_edge";
            reset = 0x0;
        } sio0_bclk_edge[8:8];
`endif
`ifdef SYS_CTRL_PERIPHCTRL16_VAR2
        field {
            name = "count_en_port2_media";
            reset = 0x0;
        } count_en_port2_media[31:31];

        field {
            name = "over_value_port2_media";
            reset = 0x0;
        } over_value_port2_media[30:16];

        field {
            name = "count_en_port1_media";
            reset = 0x0;
        } count_en_port1_media[15:15];

        field {
            name = "over_value_port1_media";
            reset = 0x0;
        } over_value_port1_media[14:0];
`endif
`ifdef SYS_CTRL_PERIPHCTRL16_VAR3
        field {
            name = "smutel";
            reset = 0x0;
        } smutel[31:31];

        field {
            name = "smuter";
            reset = 0x0;
        } smuter[30:30];

        field {
            name = "sunmutel";
            reset = 0x0;
        } sunmutel[29:29];

        field {
            name = "sunmuter";
            reset = 0x0;
        } sunmuter[28:28];

        field {
            name = "dacvu";
            reset = 0x0;
        } dacvu[27:27];

        field {
            name = "mutel_rate";
            reset = 0x0;
        } mutel_rate[26:25];

        field {
            name = "muter_rate";
            reset = 0x0;
        } muter_rate[24:23];

        field {
            name = "dacl_deemph";
            reset = 0x0;
        } dacl_deemph[22:21];

        field {
            name = "dacr_deemph";
            reset = 0x0;
        } dacr_deemph[20:19];

        field {
            name = "dacl_i2ssel";
            reset = 0x0;
        } dacl_i2ssel[3:3];

        field {
            name = "dacl_lrsel";
            reset = 0x0;
        } dacl_lrsel[2:2];

        field {
            name = "dacr_i2ssel";
            reset = 0x0;
        } dacr_i2ssel[1:1];

        field {
            name = "dacr_lrsel";
            reset = 0x1;
        } dacr_lrsel[0:0];
`endif
`ifdef SYS_CTRL_PERIPHCTRL16_VAR4
        field {
            name = "mddrc1_gate";
            reset = 0x0;
        } mddrc1_gate[31:31];

        field {
            name = "sio2_blk_edge";
            reset = 0x0;
        } sio2_blk_edge[10:10];

        field {
            name = "sio1_blk_edge";
            reset = 0x0;
        } sio1_blk_edge[9:9];

        field {
            name = "sio0_blk_edge";
            reset = 0x0;
        } sio0_blk_edge[8:8];

        field {
            name = "sio2_lrclk_sel";
            reset = 0x0;
        } sio2_lrclk_sel[7:4];

        field {
            name = "sio2_bclk_sel";
            reset = 0x0;
        } sio2_bclk_sel[3:0];
`endif
`ifdef SYS_CTRL_PERIPHCTRL16_VAR5
        enum PERIPHCTRL16_count_en_media1_port1_enum {
            DISABLE = 0x0 { desc = "disabled"; };
            ENABLE = 0x1 { desc = "enabled"; };
        };

        field {
            name = "count_en_media1_port1";
            encode = PERIPHCTRL16_count_en_media1_port1_enum;
            reset = 0x0;
        } count_en_media1_port1[31:31];

        field {
            name = "over_value_media1_port1";
            reset = 0x0;
        } over_value_media1_port1[30:16];

        enum PERIPHCTRL16_count_en_media1_port0_enum {
            DISABLE = 0x0 { desc = "disabled"; };
            ENABLE = 0x1 { desc = "enabled"; };
        };

        field {
            name = "count_en_media1_port0";
            encode = PERIPHCTRL16_count_en_media1_port0_enum;
            reset = 0x0;
        } count_en_media1_port0[15:15];

        field {
            name = "over_value_media1_port0";
            reset = 0x0;
        } over_value_media1_port0[14:0];
`endif
    } PERIPHCTRL16 @ 0x0070;
`endif

`ifdef SYS_CTRL_PERIPHCTRL17_REG
    reg {
        name = "Peripheral control register 17";
        desc = "MEDIA1 bus master port timeout control register 1";
`ifdef SYS_CTRL_PERIPHCTRL17_VAR1
        field {
            name = "count_en_port4_media";
            reset = 0x0;
        } count_en_port4_media[31:31];

        field {
            name = "over_value_port4_media";
            reset = 0x0;
        } over_value_port4_media[30:16];

        field {
            name = "count_en_port3_media";
            reset = 0x0;
        } count_en_port3_media[15:15];

        field {
            name = "over_value_port3_media";
            reset = 0x0;
        } over_value_port3_media[14:0];
`endif
`ifdef SYS_CTRL_PERIPHCTRL17_VAR2
        field {
            name = "dacl_mute";
            reset = 0x0;
        } dacl_mute[31:31];

        field {
            name = "dacl_vol";
            reset = 0x6;
        } dacl_vol[30:24];

        field {
            name = "dacr_mute";
            reset = 0x0;
        } dacr_mute[23:23];

        field {
            name = "dacr_vol";
            reset = 0x6;
        } dacr_vol[22:16];

        field {
            name = "dacr2dacl_en";
            reset = 0x0;
        } dacr2dacl_en[15:15];

        field {
            name = "dacr2dacl_vol";
            reset = 0x24;
        } dacr2dacl_vol[14:8];

        field {
            name = "dacl2dacr_en";
            reset = 0x0;
        } dacl2dacr_en[7:7];

        field {
            name = "dacl2dacr_vol";
            reset = 0x24;
        } dacl2dacr_vol[6:0];
`endif
`ifdef SYS_CTRL_PERIPHCTRL17_VAR3
        field {
            name = "arm9_bootaddr";
            reset = 0x0;
        } arm9_bootaddr[7:0];
`endif
`ifdef SYS_CTRL_PERIPHCTRL17_VAR4
        enum PERIPHCTRL17_count_en_media1_port3_enum {
            DISABLE = 0x0 { desc = "disabled"; };
            ENABLE = 0x1 { desc = "enabled"; };
        };

        field {
            name = "count_en_media1_port3";
            encode = PERIPHCTRL17_count_en_media1_port3_enum;
            reset = 0x0;
        } count_en_media1_port3[31:31];

        field {
            name = "over_value_media1_port3";
            reset = 0x0;
        } over_value_media1_port3[30:16];

        enum PERIPHCTRL17_count_en_media1_port2_enum {
            DISABLE = 0x0 { desc = "disabled"; };
            ENABLE = 0x1 { desc = "enabled"; };
        };

        field {
            name = "count_en_media1_port2";
            encode = PERIPHCTRL17_count_en_media1_port2_enum;
            reset = 0x0;
        } count_en_media1_port2[15:15];

        field {
            name = "over_value_media1_port2";
            reset = 0x0;
        } over_value_media1_port2[14:0];
`endif
    } PERIPHCTRL17 @ 0x0074;
`endif

`ifdef SYS_CTRL_PERIPHCTRL18_REG
    reg {
        name = "Peripheral control register 18";
        desc = "MEDIA1 bus master port timeout control register 2";
`ifdef SYS_CTRL_PERIPHCTRL18_VAR1
        field {
            name = "mst_pri3_media";
            reset = 0x1;
        } mst_pri3_media[14:12];

        field {
            name = "mst_pri2_media";
            reset = 0x2;
        } mst_pri2_media[10:8];

        field {
            name = "mst_pri1_media";
            reset = 0x3;
        } mst_pri1_media[6:4];

        field {
            name = "mst_pri0_media";
            reset = 0x4;
        } mst_pri0_media[2:0];
`endif
`ifdef SYS_CTRL_PERIPHCTRL18_VAR2
        field {
            name = "adcl_mute";
            reset = 0x0;
        } adcl_mute[31:31];

        field {
            name = "adcl_vol";
            reset = 0x1E;
        } adcl_vol[30:24];

        field {
            name = "adcr_mute";
            reset = 0x0;
        } adcr_mute[23:23];

        field {
            name = "adcr_vol";
            reset = 0x1E;
        } adcr_vol[22:16];

        field {
            name = "adcl_hpf_en";
            reset = 0x0;
        } adcl_hpf_en[15:15];

        field {
            name = "adcr_hpf_en";
            reset = 0x0;
        } adcr_hpf_en[14:14];

        field {
            name = "adcl_i2ssel";
            reset = 0x0;
        } adcl_i2ssel[3:3];

        field {
            name = "adcl_lrsel";
            reset = 0x0;
        } adcl_lrsel[2:2];

        field {
            name = "adcr_i2ssel";
            reset = 0x0;
        } adcr_i2ssel[1:1];

        field {
            name = "adcr_lrsel";
            reset = 0x1;
        } adcr_lrsel[0:0];
`endif
`ifdef SYS_CTRL_PERIPHCTRL18_VAR3
        field {
            name = "count_en_port1";
            reset = 0x0;
        } count_en_port1[31:31];

        field {
            name = "over_value_port1";
            reset = 0x0;
        } over_value_port1[30:16];

        field {
            name = "count_en_port0";
            reset = 0x0;
        } count_en_port0[15:15];

        field {
            name = "over_value_port0";
            reset = 0x0;
        } over_value_port0[14:0];
`endif
`ifdef SYS_CTRL_PERIPHCTRL18_VAR4
        enum PERIPHCTRL18_count_en_media1_port4_enum {
            DISABLE = 0x0 { desc = "disabled"; };
            ENABLE = 0x1 { desc = "enabled"; };
        };

        field {
            name = "count_en_media1_port4";
            encode = PERIPHCTRL18_count_en_media1_port4_enum;
            reset = 0x0;
        } count_en_media1_port4[15:15];

        field {
            name = "over_value_media1_port4";
            reset = 0x0;
        } over_value_media1_port4[14:0];
`endif
    } PERIPHCTRL18 @ 0x0078;
`endif

`ifdef SYS_CTRL_PERIPHCTRL19_REG
    reg {
        name = "Peripheral control register 19";
        desc = "MEDIA1 bus master port priority control register";
`ifdef SYS_CTRL_PERIPHCTRL19_VAR1
        field {
            name = "ive_ctrl";
            reset = 0x0;
        } ive_ctrl[7:7];

        field {
            name = "jpge_ctrl";
            reset = 0x0;
        } jpge_ctrl[6:6];

        field {
            name = "md_ctrl";
            reset = 0x0;
        } md_ctrl[5:5];

        field {
            name = "vedu_ctrl";
            reset = 0x0;
        } vedu_ctrl[4:4];

        field {
            name = "tde_ctrl";
            reset = 0x0;
        } tde_ctrl[3:3];

        field {
            name = "vou_ctrl";
            reset = 0x1;
        } vou_ctrl[2:2];

        field {
            name = "vicapid1_ctrl";
            reset = 0x1;
        } vicapid1_ctrl[1:1];

        field {
            name = "vicapid0_ctrl";
            reset = 0x1;
        } vicapid0_ctrl[0:0];
`endif
`ifdef SYS_CTRL_PERIPHCTRL19_VAR2
        field {
            name = "adcl2dacl_en";
            reset = 0x0;
        } adcl2dacl_en[31:31];

        field {
            name = "adcl2dacl_vol";
            reset = 0x24;
        } adcl2dacl_vol[30:24];

        field {
            name = "adcr2dacl_en";
            reset = 0x0;
        } adcr2dacl_en[23:23];

        field {
            name = "adcr2dacl_vol";
            reset = 0x24;
        } adcr2dacl_vol[22:16];

        field {
            name = "adcl2dacr_en";
            reset = 0x0;
        } adcl2dacr_en[15:15];

        field {
            name = "adcl2dacr_vol";
            reset = 0x24;
        } adcl2dacr_vol[14:8];

        field {
            name = "adcr2dacr_en";
            reset = 0x0;
        } adcr2dacr_en[7:7];

        field {
            name = "adcr2dacr_vol";
            reset = 0x24;
        } adcr2dacr_vol[6:0];
`endif
`ifdef SYS_CTRL_PERIPHCTRL19_VAR3
        field {
            name = "count_en_port3";
            reset = 0x0;
        } count_en_port3[31:31];

        field {
            name = "over_value_port3";
            reset = 0x0;
        } over_value_port3[30:16];

        field {
            name = "count_en_port2";
            reset = 0x0;
        } count_en_port2[15:15];

        field {
            name = "over_value_port2";
            reset = 0x0;
        } over_value_port2[14:0];
`endif
`ifdef SYS_CTRL_PERIPHCTRL19_VAR4
        field {
            name = "mst_pri4_media1";
            reset = 0x0;
        } mst_pri4_media1[18:16];

        field {
            name = "mst_pri3_media1";
            reset = 0x1;
        } mst_pri3_media1[14:12];

        field {
            name = "mst_pri2_media1";
            reset = 0x2;
        } mst_pri2_media1[10:8];

        field {
            name = "mst_pri1_media1";
            reset = 0x3;
        } mst_pri1_media1[6:4];

        field {
            name = "mst_pri0_media1";
            reset = 0x4;
        } mst_pri0_media1[2:0];
`endif
    } PERIPHCTRL19 @ 0x007C;
`endif

`ifdef SYS_CTRL_PERIPHCTRL20_REG
    reg {
        name = "Peripheral control register 20";
        desc = "USB control register. On the Hi3520D: configuration of the USB 2.0 host controllers at 0x100B0000 (EHCI) / 0x100A0000 (OHCI): AHB burst enables, UTMI/ULPI bypass, port power and over-current polarity, OHCI suspend clocking (DS 3.4.5, `datasheet.txt` lines 11721-11835). The vendor driver `hiusb-hi3520d.c` (`PERI_USB` = SYS_CTRL + 0x80) on start sets `ulpi_bypass_en` (bit 3, UTMI mode) and clears `wordinterface` (bit 0, 8-bit UTMI), `ss_ena_incr16_i` (bit 9, EHCI burst16 off) and `usbovr_p_ctrl` (bit 17, over-current active low); on stop it undoes all four. Hardware (Hi3520D V100 board, read on hardware 2026-11-08, stock U-Boot prompt after a cold boot): reads 0x000333A8 (phy1_pwr_en bit 13 set) at the stock U-Boot prompt after a cold boot, equal to the reset here. A value of 0x000111A8 seen once under Linux was a hand write that survived a soft reboot (SYS_CTRL registers are not reset by SC_SYSRES).";
`ifdef SYS_CTRL_PERIPHCTRL20_VAR1
        field {
            name = "preamble_sel";
        } preamble_sel[20:20];

        field {
            name = "ovr_merge_en";
        } ovr_merge_en[19:19];

        field {
            name = "pwr_merge_en";
        } pwr_merge_en[18:18];

        field {
            name = "usbovr_p_ctrl";
        } usbovr_p_ctrl[17:17];

        field {
            name = "usbpwr_p_ctrl";
        } usbpwr_p_ctrl[16:16];

        field {
            name = "phy1_ovrcur_en";
        } phy1_ovrcur_en[15:15];

        field {
            name = "phy0_ovrcur_en";
        } phy0_ovrcur_en[14:14];

        field {
            name = "phy1_pwr_en";
        } phy1_pwr_en[13:13];

        field {
            name = "phy0_pwr_en";
        } phy0_pwr_en[12:12];

        field {
            name = "ss_ena_incr16_i";
        } ss_ena_incr16_i[9:9];

        field {
            name = "ss_ena_incr8_i";
        } ss_ena_incr8_i[8:8];

        field {
            name = "ss_ena_incr4_i";
        } ss_ena_incr4_i[7:7];

        field {
            name = "ss_ena_incrx_align_i";
        } ss_ena_incrx_align_i[6:6];

        field {
            name = "ss_autoppd_on_overcur_en_i";
        } ss_autoppd_on_overcur_en_i[5:5];

        field {
            name = "ulpi_bypass_en";
        } ulpi_bypass_en[3:3];

        field {
            name = "app_start_clk_i";
        } app_start_clk_i[2:2];

        field {
            name = "ohci_susp_lgcy_i";
        } ohci_susp_lgcy_i[1:1];

        field {
            name = "wordinterface";
        } wordinterface[0:0];
`endif
`ifdef SYS_CTRL_PERIPHCTRL20_VAR2
        field {
            name = "usbovr_p_ctrl";
        } usbovr_p_ctrl[17:17];

        field {
            name = "usbpwr_p_ctrl";
        } usbpwr_p_ctrl[16:16];

        field {
            name = "phy0_ovrcur_en";
        } phy0_ovrcur_en[14:14];

        field {
            name = "phy0_pwr_en";
        } phy0_pwr_en[12:12];

        field {
            name = "ss_ena_incr16_i";
        } ss_ena_incr16_i[9:9];

        field {
            name = "ss_ena_incr8_i";
        } ss_ena_incr8_i[8:8];

        field {
            name = "ss_ena_incr4_i";
        } ss_ena_incr4_i[7:7];

        field {
            name = "ss_ena_incrx_align_i";
        } ss_ena_incrx_align_i[6:6];

        field {
            name = "ss_autoppd_on_overcur_en_i";
        } ss_autoppd_on_overcur_en_i[5:5];

        field {
            name = "ulpi_bypass_en";
        } ulpi_bypass_en[3:3];

        field {
            name = "app_start_clk_i";
        } app_start_clk_i[2:2];

        field {
            name = "ohci_susp_lgcy_i";
        } ohci_susp_lgcy_i[1:1];

        field {
            name = "wordinterface";
        } wordinterface[0:0];
`endif
`ifdef SYS_CTRL_PERIPHCTRL20_VAR3
        enum PERIPHCTRL20_preamble_sel_enum {
            FIVE_FULL_SPEED = 0x0 { desc = "five full-speed idle cycles"; };
            FOUR_FULL_SPEED = 0x1 { desc = "four full-speed idle cycles"; };
        };

        field {
            name = "preamble_sel";
            encode = PERIPHCTRL20_preamble_sel_enum;
            reset = 0x0;
        } preamble_sel[20:20];

        enum PERIPHCTRL20_ovr_merge_en_enum {
            DISABLE = 0x0 { desc = "disabled"; };
            ENABLE = 0x1 { desc = "enabled"; };
        };

        field {
            name = "ovr_merge_en";
            encode = PERIPHCTRL20_ovr_merge_en_enum;
            reset = 0x0;
        } ovr_merge_en[19:19];

        enum PERIPHCTRL20_pwr_merge_en_enum {
            DISABLE = 0x0 { desc = "disabled"; };
            ENABLE = 0x1 { desc = "enabled"; };
        };

        field {
            name = "pwr_merge_en";
            encode = PERIPHCTRL20_pwr_merge_en_enum;
            reset = 0x0;
        } pwr_merge_en[18:18];

        enum PERIPHCTRL20_usbovr_p_ctrl_enum {
            ACTIVE_LOW = 0x0 { desc = "active low"; };
            ACTIVE_HIGH = 0x1 { desc = "active high"; };
        };

        field {
            name = "usbovr_p_ctrl";
            encode = PERIPHCTRL20_usbovr_p_ctrl_enum;
            reset = 0x1;
        } usbovr_p_ctrl[17:17];

        enum PERIPHCTRL20_usbpwr_p_ctrl_enum {
            ACTIVE_LOW = 0x0 { desc = "active low"; };
            ACTIVE_HIGH = 0x1 { desc = "active high"; };
        };

        field {
            name = "usbpwr_p_ctrl";
            encode = PERIPHCTRL20_usbpwr_p_ctrl_enum;
            reset = 0x1;
        } usbpwr_p_ctrl[16:16];

        enum PERIPHCTRL20_phy1_ovrcur_en_enum {
            DISABLE = 0x0 { desc = "disabled"; };
            ENABLE = 0x1 { desc = "enabled"; };
        };

        field {
            name = "phy1_ovrcur_en";
            encode = PERIPHCTRL20_phy1_ovrcur_en_enum;
            reset = 0x0;
        } phy1_ovrcur_en[15:15];

        enum PERIPHCTRL20_phy0_ovrcur_en_enum {
            DISABLE = 0x0 { desc = "disabled"; };
            ENABLE = 0x1 { desc = "enabled"; };
        };

        field {
            name = "phy0_ovrcur_en";
            encode = PERIPHCTRL20_phy0_ovrcur_en_enum;
            reset = 0x0;
        } phy0_ovrcur_en[14:14];

        enum PERIPHCTRL20_phy1_pwr_en_enum {
            POWERED_OFF = 0x0 { desc = "powered off"; };
            ENABLE_POWER_OUTPUT = 0x1 { desc = "enable the power output of the controller"; };
        };

        field {
            name = "phy1_pwr_en";
            encode = PERIPHCTRL20_phy1_pwr_en_enum;
            reset = 0x1;
        } phy1_pwr_en[13:13];

        enum PERIPHCTRL20_phy0_pwr_en_enum {
            POWERED_OFF = 0x0 { desc = "powered off"; };
            ENABLE_POWER_OUTPUT = 0x1 { desc = "enable the power output of the controller"; };
        };

        field {
            name = "phy0_pwr_en";
            encode = PERIPHCTRL20_phy0_pwr_en_enum;
            reset = 0x1;
        } phy0_pwr_en[12:12];

        enum PERIPHCTRL20_ss_ena_incr16_i_enum {
            DISABLE = 0x0 { desc = "disabled"; };
            ENABLE = 0x1 { desc = "enabled"; };
        };

        field {
            name = "ss_ena_incr16_i";
            encode = PERIPHCTRL20_ss_ena_incr16_i_enum;
            reset = 0x1;
        } ss_ena_incr16_i[9:9];

        enum PERIPHCTRL20_ss_ena_incr8_i_enum {
            DISABLE = 0x0 { desc = "disabled"; };
            ENABLE = 0x1 { desc = "enabled"; };
        };

        field {
            name = "ss_ena_incr8_i";
            encode = PERIPHCTRL20_ss_ena_incr8_i_enum;
            reset = 0x1;
        } ss_ena_incr8_i[8:8];

        enum PERIPHCTRL20_ss_ena_incr4_i_enum {
            DISABLE = 0x0 { desc = "disabled"; };
            ENABLE = 0x1 { desc = "enabled"; };
        };

        field {
            name = "ss_ena_incr4_i";
            encode = PERIPHCTRL20_ss_ena_incr4_i_enum;
            reset = 0x1;
        } ss_ena_incr4_i[7:7];

        enum PERIPHCTRL20_ss_ena_incrx_align_i_enum {
            DISABLE = 0x0 { desc = "disabled"; };
            ENABLE = 0x1 { desc = "enabled"; };
        };

        field {
            name = "ss_ena_incrx_align_i";
            encode = PERIPHCTRL20_ss_ena_incrx_align_i_enum;
            reset = 0x0;
        } ss_ena_incrx_align_i[6:6];

        enum PERIPHCTRL20_ss_autoppd_on_overcur_en_i_enum {
            DISABLE = 0x0 { desc = "disabled"; };
            ENABLE = 0x1 { desc = "enabled"; };
        };

        field {
            name = "ss_autoppd_on_overcur_en_i";
            encode = PERIPHCTRL20_ss_autoppd_on_overcur_en_i_enum;
            reset = 0x1;
        } ss_autoppd_on_overcur_en_i[5:5];

        enum PERIPHCTRL20_ulpi_bypass_en_enum {
            ULPI_MODE = 0x0 { desc = "ULPI mode"; };
            UTMI_MODE = 0x1 { desc = "UTMI mode (bit must be set to 1)"; };
        };

        field {
            name = "ulpi_bypass_en";
            encode = PERIPHCTRL20_ulpi_bypass_en_enum;
            reset = 0x1;
        } ulpi_bypass_en[3:3];

        enum PERIPHCTRL20_app_start_clk_i_enum {
            OHCI_WORKS_PROPERLY = 0x0 { desc = "OHCI works properly"; };
            OHCI_CLOCK_ENABLED = 0x1 { desc = "OHCI clock enabled in suspend mode"; };
        };

        field {
            name = "app_start_clk_i";
            encode = PERIPHCTRL20_app_start_clk_i_enum;
            reset = 0x0;
        } app_start_clk_i[2:2];

        field {
            name = "ohci_susp_lgcy_i";
            reset = 0x0;
        } ohci_susp_lgcy_i[1:1];

        enum PERIPHCTRL20_wordinterface_enum {
            V_8_BITS = 0x0 { desc = "8 bits"; };
            V_16_BITS = 0x1 { desc = "16 bits"; };
        };

        field {
            name = "wordinterface";
            encode = PERIPHCTRL20_wordinterface_enum;
            reset = 0x0;
        } wordinterface[0:0];
`endif
    } PERIPHCTRL20 @ 0x0080;
`endif

`ifdef SYS_CTRL_PERIPHCTRL21_REG
    reg {
        name = "Peripheral control register 21";
        desc = "USB PHY control register 0";
`ifdef SYS_CTRL_PERIPHCTRL21_VAR1
        field {
            name = "siddq";
        } siddq[22:22];

        field {
            name = "commononn";
        } commononn[21:21];

        field {
            name = "phy0_txhsxvtune";
        } phy0_txhsxvtune[20:19];

        field {
            name = "phy0_sleepm";
        } phy0_sleepm[18:18];

        field {
            name = "phy0_loopbackenb";
        } phy0_loopbackenb[17:17];

        field {
            name = "phy0_compdistune";
        } phy0_compdistune[16:14];

        field {
            name = "phy0_sqrxtune";
        } phy0_sqrxtune[13:11];

        field {
            name = "phy0_txfslstune";
        } phy0_txfslstune[10:7];

        field {
            name = "phy0_txpreemphasistune";
        } phy0_txpreemphasistune[6:6];

        field {
            name = "rev0";
            reset = 0x0;
        } rev0[5:5];

        field {
            name = "phy0_txrisetune";
        } phy0_txrisetune[4:4];

        field {
            name = "phy0_txverftune";
        } phy0_txverftune[3:0];
`endif
`ifdef SYS_CTRL_PERIPHCTRL21_VAR2
        field {
            name = "siddq";
        } siddq[22:22];

        field {
            name = "commononn";
        } commononn[21:21];

        field {
            name = "phy0_txhsxvtune";
        } phy0_txhsxvtune[20:19];

        field {
            name = "phy0_sleepm";
        } phy0_sleepm[18:18];

        field {
            name = "phy0_loopbackenb";
        } phy0_loopbackenb[17:17];

        field {
            name = "phy0_compdistune";
        } phy0_compdistune[16:14];

        field {
            name = "phy0_sqrxtune";
        } phy0_sqrxtune[13:11];

        field {
            name = "phy0_txfslstune";
        } phy0_txfslstune[10:7];

        field {
            name = "phy0_txpreemphasistune";
        } phy0_txpreemphasistune[6:6];

        field {
            name = "phy0_txrisetune";
        } phy0_txrisetune[4:4];

        field {
            name = "phy0_txverftune";
        } phy0_txverftune[3:0];
`endif
`ifdef SYS_CTRL_PERIPHCTRL21_VAR3
        enum PERIPHCTRL21_siddq_enum {
            DO_NOT_POWER = 0x0 { desc = "do not power off the analog power"; };
            POWER_OFF_ANALOG = 0x1 { desc = "power off the analog power"; };
        };

        field {
            name = "siddq";
            encode = PERIPHCTRL21_siddq_enum;
            reset = 0x0;
        } siddq[22:22];

        enum PERIPHCTRL21_commononn_enum {
            CLK48M_OHCI_ALWAYS = 0x0 { desc = "clk48m_ohci always valid even when the PHY is suspended"; };
            CLK48M_OHCI_VALID = 0x1 { desc = "clk48m_ohci valid except when the PHY is suspended"; };
        };

        field {
            name = "commononn";
            encode = PERIPHCTRL21_commononn_enum;
            reset = 0x0;
        } commononn[21:21];

        enum PERIPHCTRL21_phy0_txhsxvtune_enum {
            V_15_MV = 0x1 { desc = "-15 mV"; };
            PLUS_15_MV = 0x2 { desc = "+15 mV (00 and 11 reserved)"; };
        };

        field {
            name = "phy0_txhsxvtune";
            encode = PERIPHCTRL21_phy0_txhsxvtune_enum;
            reset = 0x3;
        } phy0_txhsxvtune[20:19];

        enum PERIPHCTRL21_phy0_sleepm_enum {
            SLEEP_MODE = 0x0 { desc = "sleep mode"; };
            NORMAL_MODE = 0x1 { desc = "normal mode"; };
        };

        field {
            name = "phy0_sleepm";
            encode = PERIPHCTRL21_phy0_sleepm_enum;
            reset = 0x1;
        } phy0_sleepm[18:18];

        field {
            name = "phy0_loopbackenb";
            reset = 0x0;
        } phy0_loopbackenb[17:17];

        enum PERIPHCTRL21_phy0_compdistune_enum {
            V_6 = 0x0 { desc = "-6%"; };
            V_4_5 = 0x1 { desc = "-4.5%"; };
            V_3 = 0x2 { desc = "-3%"; };
            DEFAULT = 0x4 { desc = "default"; };
            PLUS_1_5 = 0x5 { desc = "+1.5%"; };
            PLUS_3 = 0x6 { desc = "+3%"; };
            PLUS_4_5 = 0x7 { desc = "+4.5% (011 reserved)"; };
        };

        field {
            name = "phy0_compdistune";
            encode = PERIPHCTRL21_phy0_compdistune_enum;
            reset = 0x4;
        } phy0_compdistune[16:14];

        enum PERIPHCTRL21_phy0_sqrxtune_enum {
            V_20 = 0x0 { desc = "+20%"; };
            V_15 = 0x1 { desc = "+15%"; };
            V_10 = 0x2 { desc = "+10%"; };
            V_5 = 0x3 { desc = "+5%"; };
            DEFAULT = 0x4 { desc = "default"; };
            MINUS_5 = 0x5 { desc = "-5%"; };
            MINUS_10 = 0x6 { desc = "-10%"; };
            MINUS_15 = 0x7 { desc = "-15%"; };
        };

        field {
            name = "phy0_sqrxtune";
            encode = PERIPHCTRL21_phy0_sqrxtune_enum;
            reset = 0x4;
        } phy0_sqrxtune[13:11];

        enum PERIPHCTRL21_phy0_txfslstune_enum {
            V_5 = 0x0 { desc = "+5%"; };
            V_2_5 = 0x1 { desc = "+2.5%"; };
            DEFAULT = 0x3 { desc = "default"; };
            V_2_5_7 = 0x7 { desc = "-2.5%"; };
            V_5_F = 0xF { desc = "-5%"; };
        };

        field {
            name = "phy0_txfslstune";
            encode = PERIPHCTRL21_phy0_txfslstune_enum;
            reset = 0x3;
        } phy0_txfslstune[10:7];

        enum PERIPHCTRL21_phy0_txpreemphasistune_enum {
            DISABLE = 0x0 { desc = "disabled"; };
            ENABLE = 0x1 { desc = "enabled"; };
        };

        field {
            name = "phy0_txpreemphasistune";
            encode = PERIPHCTRL21_phy0_txpreemphasistune_enum;
            reset = 0x0;
        } phy0_txpreemphasistune[6:6];

        enum PERIPHCTRL21_phy0_txrisetune_enum {
            DEFAULT_VALUE = 0x0 { desc = "default value"; };
            V_8 = 0x1 { desc = "-8%"; };
        };

        field {
            name = "phy0_txrisetune";
            encode = PERIPHCTRL21_phy0_txrisetune_enum;
            reset = 0x0;
        } phy0_txrisetune[4:4];

        enum PERIPHCTRL21_phy0_txverftune_enum {
            V_10 = 0x0 { desc = "-10%"; };
            V_8_75 = 0x1 { desc = "-8.75%"; };
            V_7_5 = 0x2 { desc = "-7.5%"; };
            V_6_25 = 0x3 { desc = "-6.25%"; };
            V_5 = 0x4 { desc = "-5%"; };
            V_3_75 = 0x5 { desc = "-3.75%"; };
            V_2_5 = 0x6 { desc = "-2.5%"; };
            V_1_25 = 0x7 { desc = "-1.25%"; };
            DEFAULT = 0x8 { desc = "default"; };
            V_1_25_9 = 0x9 { desc = "+1.25%"; };
            V_2_5_A = 0xA { desc = "+2.5%"; };
            V_3_7 = 0xB { desc = "+3.7%"; };
            V_5_C = 0xC { desc = "+5%"; };
            V_6_25_D = 0xD { desc = "+6.25%"; };
            V_7_5_E = 0xE { desc = "+7.5%"; };
            V_8_75_F = 0xF { desc = "+8.75%"; };
        };

        field {
            name = "phy0_txverftune";
            encode = PERIPHCTRL21_phy0_txverftune_enum;
            reset = 0x8;
        } phy0_txverftune[3:0];
`endif
    } PERIPHCTRL21 @ 0x0084;
`endif

`ifdef SYS_CTRL_PERIPHCTRL22_REG
    reg {
        name = "Peripheral control register 22";
        desc = "USB PHY control register 1 Hardware (Hi3520D V100 board, read on hardware 2026-11-08, stock U-Boot prompt after a cold boot): reads 0x701D2188, which equals the data sheet total reset; the RDL reset lacked the reserved bits 30:28 (now the field reserved_nz).";
`ifdef SYS_CTRL_PERIPHCTRL22_VAR1
        field {
            name = "phy1_txhsxvtune";
        } phy1_txhsxvtune[20:19];

        field {
            name = "phy1_sleepm";
        } phy1_sleepm[18:18];

        field {
            name = "phy1_loopbackenb";
        } phy1_loopbackenb[17:17];

        field {
            name = "phy1_compdistune";
        } phy1_compdistune[16:14];

        field {
            name = "phy1_sqrxtune";
        } phy1_sqrxtune[13:11];

        field {
            name = "phy1_txfslstune";
        } phy1_txfslstune[10:7];

        field {
            name = "phy1_txpreemphasistune";
        } phy1_txpreemphasistune[6:6];

        field {
            name = "rsv";
            reset = 0x0;
        } rsv[5:5];

        field {
            name = "phy1_txrisetune";
        } phy1_txrisetune[4:4];

        field {
            name = "phy1_txvreftune";
        } phy1_txvreftune[3:0];
`endif
`ifdef SYS_CTRL_PERIPHCTRL22_VAR2
        field {
            name = "pri_port3";
            reset = 0x3;
        } pri_port3[11:9];

        field {
            name = "pri_port2";
            reset = 0x4;
        } pri_port2[8:6];

        field {
            name = "pri_port1";
            reset = 0x5;
        } pri_port1[5:3];

        field {
            name = "pri_port0";
            reset = 0x6;
        } pri_port0[2:0];
`endif
`ifdef SYS_CTRL_PERIPHCTRL22_VAR3
        field {
            name = "reserved_nz";
            desc = "Reserved in the data sheet, but the data sheet total reset 0x701D2188 and the value read on hardware (2026-11-08, stock U-Boot prompt after a cold boot) both have bits 30:28 set. Keep the value when writing the register.";
            reset = 0x7;
        } reserved_nz[30:28];

        enum PERIPHCTRL22_phy1_txhsxvtune_enum {
            V_15_MV = 0x1 { desc = "-15 mV"; };
            PLUS_15_MV = 0x2 { desc = "+15 mV (00 and 11 reserved)"; };
        };

        field {
            name = "phy1_txhsxvtune";
            encode = PERIPHCTRL22_phy1_txhsxvtune_enum;
            reset = 0x3;
        } phy1_txhsxvtune[20:19];

        enum PERIPHCTRL22_phy1_sleepm_enum {
            SLEEP_MODE = 0x0 { desc = "sleep mode"; };
            NORMAL_MODE = 0x1 { desc = "normal mode"; };
        };

        field {
            name = "phy1_sleepm";
            encode = PERIPHCTRL22_phy1_sleepm_enum;
            reset = 0x1;
        } phy1_sleepm[18:18];

        field {
            name = "phy1_loopbackenb";
            reset = 0x0;
        } phy1_loopbackenb[17:17];

        enum PERIPHCTRL22_phy1_compdistune_enum {
            V_6 = 0x0 { desc = "-6%"; };
            V_4_5 = 0x1 { desc = "-4.5%"; };
            V_3 = 0x2 { desc = "-3%"; };
            DEFAULT = 0x4 { desc = "default"; };
            PLUS_1_5 = 0x5 { desc = "+1.5%"; };
            PLUS_3 = 0x6 { desc = "+3%"; };
            PLUS_4_5 = 0x7 { desc = "+4.5% (011 reserved)"; };
        };

        field {
            name = "phy1_compdistune";
            encode = PERIPHCTRL22_phy1_compdistune_enum;
            reset = 0x4;
        } phy1_compdistune[16:14];

        enum PERIPHCTRL22_phy1_sqrxtune_enum {
            V_20 = 0x0 { desc = "+20%"; };
            V_15 = 0x1 { desc = "+15%"; };
            V_10 = 0x2 { desc = "+10%"; };
            V_5 = 0x3 { desc = "+5%"; };
            DEFAULT = 0x4 { desc = "default"; };
            MINUS_5 = 0x5 { desc = "-5%"; };
            MINUS_10 = 0x6 { desc = "-10%"; };
            MINUS_15 = 0x7 { desc = "-15%"; };
        };

        field {
            name = "phy1_sqrxtune";
            encode = PERIPHCTRL22_phy1_sqrxtune_enum;
            reset = 0x4;
        } phy1_sqrxtune[13:11];

        enum PERIPHCTRL22_phy1_txfslstune_enum {
            V_5 = 0x0 { desc = "+5%"; };
            V_2_5 = 0x1 { desc = "+2.5%"; };
            DEFAULT = 0x3 { desc = "default"; };
            V_2_5_7 = 0x7 { desc = "-2.5%"; };
            V_5_F = 0xF { desc = "-5%"; };
        };

        field {
            name = "phy1_txfslstune";
            encode = PERIPHCTRL22_phy1_txfslstune_enum;
            reset = 0x3;
        } phy1_txfslstune[10:7];

        enum PERIPHCTRL22_phy1_txpreemphasistune_enum {
            DISABLE = 0x0 { desc = "disabled"; };
            ENABLE = 0x1 { desc = "enabled"; };
        };

        field {
            name = "phy1_txpreemphasistune";
            encode = PERIPHCTRL22_phy1_txpreemphasistune_enum;
            reset = 0x0;
        } phy1_txpreemphasistune[6:6];

        enum PERIPHCTRL22_phy1_txrisetune_enum {
            DEFAULT_VALUE = 0x0 { desc = "default value"; };
            V_8 = 0x1 { desc = "-8%"; };
        };

        field {
            name = "phy1_txrisetune";
            encode = PERIPHCTRL22_phy1_txrisetune_enum;
            reset = 0x0;
        } phy1_txrisetune[4:4];

        enum PERIPHCTRL22_phy1_txvreftune_enum {
            V_10 = 0x0 { desc = "-10%"; };
            V_8_75 = 0x1 { desc = "-8.75%"; };
            V_7_5 = 0x2 { desc = "-7.5%"; };
            V_6_25 = 0x3 { desc = "-6.25%"; };
            V_5 = 0x4 { desc = "-5%"; };
            V_3_75 = 0x5 { desc = "-3.75%"; };
            V_2_5 = 0x6 { desc = "-2.5%"; };
            V_1_25 = 0x7 { desc = "-1.25%"; };
            DEFAULT = 0x8 { desc = "default"; };
            V_1_25_9 = 0x9 { desc = "+1.25%"; };
            V_2_5_A = 0xA { desc = "+2.5%"; };
            V_3_7 = 0xB { desc = "+3.7%"; };
            V_5_C = 0xC { desc = "+5%"; };
            V_6_25_D = 0xD { desc = "+6.25%"; };
            V_7_5_E = 0xE { desc = "+7.5%"; };
            V_8_75_F = 0xF { desc = "+8.75%"; };
        };

        field {
            name = "phy1_txvreftune";
            encode = PERIPHCTRL22_phy1_txvreftune_enum;
            reset = 0x8;
        } phy1_txvreftune[3:0];
`endif
    } PERIPHCTRL22 @ 0x0088;
`endif

`ifdef SYS_CTRL_SYSSTAT_REG
    reg {
        name = "System status register";
        desc = "PLL_LOCK Hardware (Hi3520D V100 board, read on hardware 2026-11-08, stock U-Boot prompt after a cold boot): reads 0x90000000 (status, depends on the boot mode pins and the state of the chip), not a reset value.";
`ifdef SYS_CTRL_SYSSTAT_VAR1
        field {
            name = "a9_l2_idle";
            sw = r;
            hw = w;
        } a9_l2_idle[28:28];

        field {
            name = "a9_smp_namp";
            sw = r;
            hw = w;
        } a9_smp_namp[27:27];

        field {
            name = "a9_dflags0";
            sw = r;
            hw = w;
            reset = 0x0;
        } a9_dflags0[26:20];

        field {
            name = "a9_standbywfe";
            sw = r;
            hw = w;
        } a9_standbywfe[19:19];

        field {
            name = "a9_standbywfi";
            sw = r;
            hw = w;
        } a9_standbywfi[18:18];

        field {
            name = "a9_pmupriv";
            sw = r;
            hw = w;
        } a9_pmupriv[17:17];

        field {
            name = "a9_secure";
            sw = r;
            hw = w;
        } a9_secure[16:16];

        field {
            name = "nf_ecc_type";
            sw = r;
            hw = w;
        } nf_ecc_type[14:12];

        field {
            name = "nf_block_size";
            sw = r;
            hw = w;
        } nf_block_size[11:11];

        field {
            name = "nf_addr_num";
            sw = r;
            hw = w;
        } nf_addr_num[10:10];

        field {
            name = "nf_page_size";
            sw = r;
            hw = w;
        } nf_page_size[9:8];

        field {
            name = "jtag_sel";
            sw = r;
            hw = w;
        } jtag_sel[7:6];

        field {
            name = "boot_mode";
            sw = r;
            hw = w;
        } boot_mode[5:4];
`endif
`ifdef SYS_CTRL_SYSSTAT_VAR2
        field {
            name = "bootrom_sel_in";
            sw = r;
            hw = w;
        } bootrom_sel_in[31:31];

        field {
            name = "a7_standbywfe";
            sw = r;
            hw = w;
            reset = 0x0;
        } a7_standbywfe[28:28];

        field {
            name = "a7_standbywfi";
            sw = r;
            hw = w;
            reset = 0x0;
        } a7_standbywfi[26:26];

        field {
            name = "a7_smpnamp";
            sw = r;
            hw = w;
            reset = 0x0;
        } a7_smpnamp[20:20];

        field {
            name = "sfc_boot_mode";
            sw = r;
            hw = w;
            reset = 0x0;
        } sfc_boot_mode[7:7];

        field {
            name = "a7_standbywfil2";
            sw = r;
            hw = w;
            reset = 0x0;
        } a7_standbywfil2[6:6];

        field {
            name = "boot_mode";
            sw = r;
            hw = w;
        } boot_mode[5:5];

        field {
            name = "sfc_device_mode";
            sw = r;
            hw = w;
        } sfc_device_mode[3:3];

        field {
            name = "sfc_nand_ecc_type";
            sw = r;
            hw = w;
            reset = 0x0;
        } sfc_nand_ecc_type[2:1];

        field {
            name = "sfc_nand_page_size";
            sw = r;
            hw = w;
            reset = 0x0;
        } sfc_nand_page_size[0:0];
`endif
`ifdef SYS_CTRL_SYSSTAT_VAR3
        field {
            name = "bootrom_sel";
            sw = r;
            hw = w;
            reset = 0x0;
        } bootrom_sel[31:31];

        field {
            name = "a17_standybywfil2";
            sw = r;
            hw = w;
            reset = 0x0;
        } a17_standybywfil2[30:30];

        field {
            name = "a17_standybywfe";
            sw = r;
            hw = w;
            reset = 0x0;
        } a17_standybywfe[29:29];

        field {
            name = "a17_standybywfi";
            sw = r;
            hw = w;
            reset = 0x0;
        } a17_standybywfi[28:28];

        field {
            name = "a7_standybywfil2";
            sw = r;
            hw = w;
            reset = 0x0;
        } a7_standybywfil2[27:27];

        field {
            name = "a7_standybywfe";
            sw = r;
            hw = w;
            reset = 0x0;
        } a7_standybywfe[26:26];

        field {
            name = "a7_standybywfi";
            sw = r;
            hw = w;
            reset = 0x0;
        } a7_standybywfi[25:25];

        field {
            name = "update_from_sdio0";
            sw = r;
            hw = w;
            reset = 0x0;
        } update_from_sdio0[23:23];

        field {
            name = "pcie_ref_clk_sel";
            sw = r;
            hw = w;
            reset = 0x0;
        } pcie_ref_clk_sel[22:22];

        field {
            name = "combo_phy_mode_sel";
            sw = r;
            hw = w;
            reset = 0x0;
        } combo_phy_mode_sel[21:20];

        field {
            name = "sfc_emmc_boot_mode";
            sw = r;
            hw = w;
            reset = 0x0;
        } sfc_emmc_boot_mode[7:7];

        field {
            name = "boot_mode";
            sw = r;
            hw = w;
        } boot_mode[5:4];

        field {
            name = "sfc_device_mode";
            sw = r;
            hw = w;
        } sfc_device_mode[3:3];

        field {
            name = "spi_nand_sel";
            sw = r;
            hw = w;
            reset = 0x0;
        } spi_nand_sel[2:2];
`endif
`ifdef SYS_CTRL_SYSSTAT_VAR4
        field {
            name = "sfc_addr_mode";
            sw = r;
            hw = w;
        } sfc_addr_mode[7:7];

        field {
            name = "sfc_device_mode";
            sw = r;
            hw = w;
        } sfc_device_mode[6:6];

        field {
            name = "boot_sel";
            sw = r;
            hw = w;
            reset = 0x0;
        } boot_sel[5:4];
`endif
`ifdef SYS_CTRL_SYSSTAT_VAR5
        field {
            name = "arm_standbywfi";
            sw = r;
            hw = w;
            reset = 0x0;
        } arm_standbywfi[18:18];

        field {
            name = "sfc_addr_mode";
            sw = r;
            hw = w;
            reset = 0x0;
        } sfc_addr_mode[16:16];

        field {
            name = "nf_ecc_type";
            sw = r;
            hw = w;
        } nf_ecc_type[14:12];

        field {
            name = "nf_block_size";
            sw = r;
            hw = w;
        } nf_block_size[11:11];

        field {
            name = "nf_addr_num";
            sw = r;
            hw = w;
        } nf_addr_num[10:10];

        field {
            name = "nf_page_size";
            sw = r;
            hw = w;
        } nf_page_size[9:8];

        field {
            name = "jtag_sel";
            sw = r;
            hw = w;
        } jtag_sel[7:6];

        field {
            name = "boot_mode";
            sw = r;
            hw = w;
        } boot_mode[5:5];
`endif
`ifdef SYS_CTRL_SYSSTAT_VAR6
        field {
            name = "arm9_standbywfi";
            sw = r;
            hw = w;
            reset = 0x0;
        } arm9_standbywfi[26:26];

        field {
            name = "update_mode";
            sw = r;
            hw = w;
            reset = 0x0;
        } update_mode[9:9];

        field {
            name = "secure_boot_mode";
            sw = r;
            hw = w;
            reset = 0x0;
        } secure_boot_mode[8:8];

        field {
            name = "sfc_addr_mode";
            sw = r;
            hw = w;
        } sfc_addr_mode[7:7];

        field {
            name = "sfc_device_mode";
            sw = r;
            hw = w;
        } sfc_device_mode[6:6];

        field {
            name = "boot_mode";
            sw = r;
            hw = w;
        } boot_mode[5:4];
`endif
`ifdef SYS_CTRL_SYSSTAT_VAR7
        enum SYSSTAT_bootrom_sel_in_enum {
            NO = 0x0 { desc = "no (not booted from BOOTROM)"; };
            YES = 0x1 { desc = "yes"; };
        };

        field {
            name = "bootrom_sel_in";
            sw = r;
            hw = w;
            encode = SYSSTAT_bootrom_sel_in_enum;
            reset = 0x0;
        } bootrom_sel_in[31:31];

        enum SYSSTAT_a9_l2_idle_enum {
            NON_IDLE = 0x0 { desc = "non-idle"; };
            IDLE = 0x1 { desc = "idle"; };
        };

        field {
            name = "a9_l2_idle";
            sw = r;
            hw = w;
            encode = SYSSTAT_a9_l2_idle_enum;
            reset = 0x0;
        } a9_l2_idle[28:28];

        enum SYSSTAT_a9_smp_namp_enum {
            NON_EQUALIZATION_MODE = 0x0 { desc = "non-equalization mode"; };
            EQUALIZATION_MODE = 0x1 { desc = "equalization mode"; };
        };

        field {
            name = "a9_smp_namp";
            sw = r;
            hw = w;
            encode = SYSSTAT_a9_smp_namp_enum;
            reset = 0x0;
        } a9_smp_namp[27:27];

        enum SYSSTAT_a9_standbywfe_enum {
            NON_WFE_STATUS = 0x0 { desc = "non-WFE status"; };
            WFE_STATUS = 0x1 { desc = "WFE status"; };
        };

        field {
            name = "a9_standbywfe";
            sw = r;
            hw = w;
            encode = SYSSTAT_a9_standbywfe_enum;
            reset = 0x0;
        } a9_standbywfe[19:19];

        enum SYSSTAT_a9_standbywfi_enum {
            NON_WFI_STATUS = 0x0 { desc = "non-WFI status"; };
            WFI_STATUS = 0x1 { desc = "WFI status"; };
        };

        field {
            name = "a9_standbywfi";
            sw = r;
            hw = w;
            encode = SYSSTAT_a9_standbywfi_enum;
            reset = 0x0;
        } a9_standbywfi[18:18];

        enum SYSSTAT_a9_pmupriv_enum {
            USER_MODE = 0x0 { desc = "user mode"; };
            PRIVILEGED_MODE = 0x1 { desc = "privileged mode"; };
        };

        field {
            name = "a9_pmupriv";
            sw = r;
            hw = w;
            encode = SYSSTAT_a9_pmupriv_enum;
            reset = 0x0;
        } a9_pmupriv[17:17];

        enum SYSSTAT_a9_secure_enum {
            NON_SECURE = 0x0 { desc = "non-secure"; };
            SECURE = 0x1 { desc = "secure"; };
        };

        field {
            name = "a9_secure";
            sw = r;
            hw = w;
            encode = SYSSTAT_a9_secure_enum;
            reset = 0x0;
        } a9_secure[16:16];

        enum SYSSTAT_sfc_addr_mode_enum {
            V_3_BYTE_ADDRESS = 0x0 { desc = "3-byte address mode"; };
            V_4_BYTE_ADDRESS = 0x1 { desc = "4-byte address mode"; };
        };

        field {
            name = "sfc_addr_mode";
            sw = r;
            hw = w;
            encode = SYSSTAT_sfc_addr_mode_enum;
            reset = 0x0;
        } sfc_addr_mode[15:15];

        enum SYSSTAT_jtag_sel_enum {
            DEBUG_A9 = 0x0 { desc = "debug A9"; };
            DEBUG_SATA_PHY = 0x1 { desc = "debug SATA PHY"; };
        };

        field {
            name = "jtag_sel";
            sw = r;
            hw = w;
            encode = SYSSTAT_jtag_sel_enum;
            reset = 0x0;
        } jtag_sel[6:6];

        enum SYSSTAT_boot_mode_enum {
            BOOT_SPI_FLASH = 0x0 { desc = "boot from the SPI flash"; };
        };

        field {
            name = "boot_mode";
            sw = r;
            hw = w;
            encode = SYSSTAT_boot_mode_enum;
            reset = 0x0;
        } boot_mode[5:4];
`endif
    } SYSSTAT @ 0x008C;
`endif

`ifdef SYS_CTRL_PERIPHCTRL23_0x8C_REG
    reg {
        name = "Peripheral control register 23";
        desc = "MDDRC out-of-order configuration outtodr_ctrl register";
`ifdef SYS_CTRL_PERIPHCTRL23_VAR1
        field {
            name = "nf_ecc_type";
            sw = r;
            hw = w;
        } nf_ecc_type[14:13];

        field {
            name = "nf_addr_num";
            sw = r;
            hw = w;
        } nf_addr_num[12:11];

        field {
            name = "nf_page_size";
            sw = r;
            hw = w;
        } nf_page_size[10:9];

        field {
            name = "debug_sel";
            sw = r;
            hw = w;
            reset = 0x0;
        } debug_sel[8:8];

        field {
            name = "boot_mode";
            sw = r;
            hw = w;
            reset = 0x0;
        } boot_mode[6:6];

        field {
            name = "epll_lock";
            sw = r;
            hw = w;
        } epll_lock[3:3];

        field {
            name = "vpll1_lock";
            sw = r;
            hw = w;
        } vpll1_lock[2:2];

        field {
            name = "vpll0_lock";
            sw = r;
            hw = w;
        } vpll0_lock[1:1];

        field {
            name = "apll_lock";
            sw = r;
            hw = w;
        } apll_lock[0:0];
`endif
`ifdef SYS_CTRL_PERIPHCTRL23_VAR2
        field {
            name = "pcie0_slv_device_type";
        } pcie0_slv_device_type[31:28];

        field {
            name = "pcie0_slv_resp_err_map";
        } pcie0_slv_resp_err_map[27:22];

        field {
            name = "pcie0_slv_awmisc_info";
        } pcie0_slv_awmisc_info[21:0];
`endif
`ifdef SYS_CTRL_PERIPHCTRL23_VAR3
        field {
            name = "nf_ecc_type";
            sw = r;
            hw = w;
        } nf_ecc_type[14:13];

        field {
            name = "nf_addr_num";
            sw = r;
            hw = w;
        } nf_addr_num[12:11];

        field {
            name = "nf_page_size";
            sw = r;
            hw = w;
        } nf_page_size[10:9];

        field {
            name = "debug_sel";
            sw = r;
            hw = w;
            reset = 0x0;
        } debug_sel[8:7];

        field {
            name = "boot_mode";
            sw = r;
            hw = w;
            reset = 0x0;
        } boot_mode[6:5];

        field {
            name = "arm0_pmuirq";
            sw = r;
            hw = w;
            reset = 0x0;
        } arm0_pmuirq[4:4];

        field {
            name = "epll_lock";
            sw = r;
            hw = w;
        } epll_lock[3:3];

        field {
            name = "vpll1_lock";
            sw = r;
            hw = w;
        } vpll1_lock[2:2];

        field {
            name = "vpll0_lock";
            sw = r;
            hw = w;
        } vpll0_lock[1:1];

        field {
            name = "apll_lock";
            sw = r;
            hw = w;
        } apll_lock[0:0];
`endif
    } PERIPHCTRL23 @ 0x008C;
`endif

`ifdef SYS_CTRL_PERIPHCTRL23_0x90_REG
    reg {
        name = "Peripheral control register 23";
        desc = "MDDRC out-of-order configuration outtodr_ctrl register";
`ifdef SYS_CTRL_PERIPHCTRL23_VAR4
        enum PERIPHCTRL23_a9_ctrl_enum {
            OUT_ORDER_NOT = 0x0 { desc = "out-of-order not allowed"; };
            OUT_ORDER_ALLOWED = 0x1 { desc = "out-of-order allowed"; };
        };

        field {
            name = "a9_ctrl";
            encode = PERIPHCTRL23_a9_ctrl_enum;
            reset = 0x0;
        } a9_ctrl[20:20];

        enum PERIPHCTRL23_ive_ctrl_enum {
            OUT_ORDER_NOT = 0x0 { desc = "out-of-order not allowed"; };
            OUT_ORDER_ALLOWED = 0x1 { desc = "out-of-order allowed"; };
        };

        field {
            name = "ive_ctrl";
            encode = PERIPHCTRL23_ive_ctrl_enum;
            reset = 0x0;
        } ive_ctrl[17:17];

        enum PERIPHCTRL23_ddrtest_ctrl_enum {
            OUT_ORDER_NOT = 0x0 { desc = "out-of-order not allowed"; };
            OUT_ORDER_ALLOWED = 0x1 { desc = "out-of-order allowed"; };
        };

        field {
            name = "ddrtest_ctrl";
            desc = "Data sheet bit table names this bit ddrtest_ctrl, but its description and the bit diagram say AIO (out-of-order when the AIO accesses DDR, diagram aio_ctrl). Name kept as printed in the Name column.";
            encode = PERIPHCTRL23_ddrtest_ctrl_enum;
            reset = 0x0;
        } ddrtest_ctrl[15:15];

        enum PERIPHCTRL23_voie_ctrl_enum {
            OUT_ORDER_NOT = 0x0 { desc = "out-of-order not allowed"; };
            OUT_ORDER_ALLOWED = 0x1 { desc = "out-of-order allowed"; };
        };

        field {
            name = "voie_ctrl";
            encode = PERIPHCTRL23_voie_ctrl_enum;
            reset = 0x0;
        } voie_ctrl[14:14];

        enum PERIPHCTRL23_vcmp_ctrl_enum {
            OUT_ORDER_NOT = 0x0 { desc = "out-of-order not allowed"; };
            OUT_ORDER_ALLOWED = 0x1 { desc = "out-of-order allowed"; };
        };

        field {
            name = "vcmp_ctrl";
            encode = PERIPHCTRL23_vcmp_ctrl_enum;
            reset = 0x0;
        } vcmp_ctrl[13:13];

        enum PERIPHCTRL23_tde_ctrl_enum {
            OUT_ORDER_NOT = 0x0 { desc = "out-of-order not allowed"; };
            OUT_ORDER_ALLOWED = 0x1 { desc = "out-of-order allowed"; };
        };

        field {
            name = "tde_ctrl";
            encode = PERIPHCTRL23_tde_ctrl_enum;
            reset = 0x0;
        } tde_ctrl[11:11];

        enum PERIPHCTRL23_vpss_ctrl_enum {
            OUT_ORDER_NOT = 0x0 { desc = "out-of-order not allowed"; };
            OUT_ORDER_ALLOWED = 0x1 { desc = "out-of-order allowed"; };
        };

        field {
            name = "vpss_ctrl";
            encode = PERIPHCTRL23_vpss_ctrl_enum;
            reset = 0x0;
        } vpss_ctrl[10:10];

        enum PERIPHCTRL23_mdu_ctrl_enum {
            OUT_ORDER_NOT = 0x0 { desc = "out-of-order not allowed"; };
            OUT_ORDER_ALLOWED = 0x1 { desc = "out-of-order allowed"; };
        };

        field {
            name = "mdu_ctrl";
            encode = PERIPHCTRL23_mdu_ctrl_enum;
            reset = 0x0;
        } mdu_ctrl[7:7];

        enum PERIPHCTRL23_jpgd_ctrl_enum {
            OUT_ORDER_NOT = 0x0 { desc = "out-of-order not allowed"; };
            OUT_ORDER_ALLOWED = 0x1 { desc = "out-of-order allowed"; };
        };

        field {
            name = "jpgd_ctrl";
            encode = PERIPHCTRL23_jpgd_ctrl_enum;
            reset = 0x0;
        } jpgd_ctrl[6:6];

        enum PERIPHCTRL23_jpge_ctrl_enum {
            OUT_ORDER_NOT = 0x0 { desc = "out-of-order not allowed"; };
            OUT_ORDER_ALLOWED = 0x1 { desc = "out-of-order allowed"; };
        };

        field {
            name = "jpge_ctrl";
            encode = PERIPHCTRL23_jpge_ctrl_enum;
            reset = 0x0;
        } jpge_ctrl[5:5];

        enum PERIPHCTRL23_vedu_ctrl_enum {
            OUT_ORDER_NOT = 0x0 { desc = "out-of-order not allowed"; };
            OUT_ORDER_ALLOWED = 0x1 { desc = "out-of-order allowed"; };
        };

        field {
            name = "vedu_ctrl";
            encode = PERIPHCTRL23_vedu_ctrl_enum;
            reset = 0x0;
        } vedu_ctrl[3:3];

        enum PERIPHCTRL23_vicap_ctrl_enum {
            OUT_ORDER_NOT = 0x0 { desc = "out-of-order not allowed"; };
            OUT_ORDER_ALLOWED = 0x1 { desc = "out-of-order allowed"; };
        };

        field {
            name = "vicap_ctrl";
            encode = PERIPHCTRL23_vicap_ctrl_enum;
            reset = 0x0;
        } vicap_ctrl[1:1];

        enum PERIPHCTRL23_vou_ctrl_enum {
            OUT_ORDER_NOT = 0x0 { desc = "out-of-order not allowed"; };
            OUT_ORDER_ALLOWED = 0x1 { desc = "out-of-order allowed"; };
        };

        field {
            name = "vou_ctrl";
            encode = PERIPHCTRL23_vou_ctrl_enum;
            reset = 0x0;
        } vou_ctrl[0:0];
`else
        field {
            desc = "TODO";
        } todo = 0;
`endif
    } PERIPHCTRL23 @ 0x0090;
`endif

`ifdef SYS_CTRL_DDRT0_0x90_REG
    reg {
        name = "DDR Training Register 0";
        desc = "
        !!! CAUTION
            This register is not reset when the system is soft-reset
        ";
        field {
            name = "ddrt0";
            desc = "DDR training register 0";
            reset = 0x0;
        } ddrt0[31:0];
    } DDRT0 @ 0x0090;
`endif

`ifdef SYS_CTRL_PERIPHCTRL24_REG
    reg {
        name = "Peripheral control register 24";
        desc = "The peripheral control register 24 (FE PHY address configuration register). Hardware (Hi3520D V100 board, read on hardware 2026-11-08, stock U-Boot prompt after a cold boot): reads 0x00000000, reset here 0x1000 (data sheet). Possible boot value; left at the data sheet value, open question.";

        enum PERIPHCTRL24_fephy_led_ctrl_enum {
            NOT_REVERSED = 0x0 { desc = "Polarity is not reversed."; };
            REVERSED     = 0x1 { desc = "Polarity is reversed."; };
        };

        field {
            name = "fephy_led_ctrl";
            desc = "FE PHY led light polarity control.";
            encode = PERIPHCTRL24_fephy_led_ctrl_enum;
            reset = 0x1;
        } fephy_led_ctrl[12:12];

        enum PERIPHCTRL24_fephy_sel_enum {
            INTERNAL = 0x0 { desc = "Select the internally integrated FE PHY."; };
            EXTERNAL = 0x1 { desc = "Select external FE PHY."; };
        };

        field {
            name = "fephy_sel";
            desc = "FE PHY selection.";
            encode = PERIPHCTRL24_fephy_sel_enum;
            reset = 0x0;
        } fephy_sel[8:8];

        field {
            name = "fephy_ad";
            desc = "PHY address of internally integrated FE PHY.";
            reset = 0x0;
        } fephy_ad[4:0];

    } PERIPHCTRL24 @ 0x0094;
`endif

`ifdef SYS_CTRL_DDRT1_0x94_REG
    reg {
        name = "DDR Training Register 1";
        desc = "
        !!! CAUTION
            This register is not reset when the system is soft-reset
        ";
        field {
            name = "ddrt1";
            desc = "DDR training register 1";
            reset = 0x0;
        } ddrt1[31:0];
    } DDRT1 @ 0x0094;
`endif

`ifdef SYS_CTRL_PERIPHCTRL25_REG
    reg {
        name = "Peripheral control register 25";
        desc = "The Peripheral Control Register 25 (SATA PHY Control Register 1).";

        field {
            name = "sata_test_byp_mode";
            desc = "All the input interfaces of SATA in the enable ASIC are connected to the output terminals through pure combinational logic to improve the interface test coverage.";
            encode = SYSCTL_one_enable_enum;
            reset = 0x0;
        } sata_test_byp_mode[21:21];

        field {
            name = "sata_test_burnin_mode";
            desc = "
                SATA burn-in test mode is enabled.

                Note: Enable as many internal logic flips as possible, use with [sata_test_byp_mode] signal during burn-in test.
            ";
            encode = SYSCTL_one_enable_enum;
            reset = 0x0;
        } sata_test_burnin_mode[20:20];

        enum PERIPHCTRL25_sata_test_pddq_enum {
            NO_POWER_OFF = 0x0 { desc = "No Power Off"; };
            POWER_OFF    = 0x1 { desc = "Power Off"; };
        };

        field {
            name = "sata_test_pddq";
            desc = "SATA PHY power on and off control.";
            encode = PERIPHCTRL25_sata_test_pddq_enum;
            reset = 0x0;
        } sata_test_pddq[2:2];

    } PERIPHCTRL25 @ 0x0098;
`endif

`ifdef SYS_CTRL_PERIPHCTRL26_REG
    reg {
        name = "Peripheral control register 26";
        desc = "The peripheral control register 26 (PCIe controller control register 3). Bits [31:30] are reserved.";

        field {
            name = "pcie0_ven_msg_tag";
            desc = "PCIe vendor-defined message tag.";
            reset = 0x0;
        } pcie0_ven_msg_tag[22:29];

        field {
            name = "pcie0_ven_msg_len";
            desc = "PCIe vendor-defined message length.";
            reset = 0x0;
        } pcie0_ven_msg_len[12:21];

        field {
            name = "pcie0_ven_msg_attr";
            desc = "PCIe vendor-defined message attributes.";
            reset = 0x0;
        } pcie0_ven_msg_attr[10:11];

        field {
            name = "pcie0_ven_msg_ep";
            desc = "PCIe vendor-defined message EP bit.";
            reset = 0x0;
        } pcie0_ven_msg_ep[9:9];

        field {
            name = "pcie0_ven_msg_td";
            desc = "PCIe vendor-defined message TD bit.";
            reset = 0x0;
        } pcie0_ven_msg_td[8:8];

        field {
            name = "pcie0_ven_msg_type";
            desc = "PCIe vendor-defined message type.";
            reset = 0x0;
        } pcie0_ven_msg_type[3:7];

        field {
            name = "pcie0_ven_msg_fmt";
            desc = "PCIe vendor-defined message format.";
            reset = 0x0;
        } pcie0_ven_msg_fmt[1:2];

        field {
            name = "pcie0_ven_msg_req";
            desc = "PCIe vendor-defined message request.";
            reset = 0x0;
        } pcie0_ven_msg_req[0:0];

    } PERIPHCTRL26 @ 0x009C;
`endif

`ifdef SYS_CTRL_PERIPHCTRL27_REG
    reg {
        name = "Peripheral control register 27";
        desc = "The peripheral control register 27 (PCIe controller control register 4). The data sheet spells the field name `pice0_ven_msg_data_low` (sic).";

        field {
            name = "pice0_ven_msg_data_low";
            desc = "Low 32 bits of the PCIe vendor-defined message data.";
            reset = 0x0;
        } pcie0_ven_msg_data_low[31:0];

    } PERIPHCTRL27 @ 0x00A0;
`endif

`ifdef SYS_CTRL_DDRT2_0x98_REG
    reg {
        name = "DDR Training Register 2";
        desc = "
        !!! CAUTION
            This register is not reset when the system is soft-reset
        ";
        field {
            name = "ddrt2";
            desc = "DDR training register 2";
            reset = 0x0;
        } ddrt2[31:0];
    } DDRT2 @ 0x0098;
`endif

`ifdef SYS_CTRL_DDRT3_0x9C_REG
    reg {
        name = "DDR Training Register 3";
        desc = "
        !!! CAUTION
            This register is not reset when the system is soft-reset
        ";
        field {
            name = "ddrt3";
            desc = "DDR training register 3";
            reset = 0x0;
        } ddrt3[31:0];
    } DDRT3 @ 0x009C;
`endif

`ifdef SYS_CTRL_DDRT4_0xA0_REG
    reg {
        name = "DDR Training Register 4";
        desc = "
        !!! CAUTION
            This register is not reset when the system is soft-reset
        ";
        field {
            name = "ddrt4";
            desc = "DDR training register 4";
            reset = 0x0;
        } ddrt4[31:0];
    } DDRT4 @ 0x00A0;
`endif

`ifdef SYS_CTRL_PERIPHCTRL27_0xA0_REG
    reg {
        name = "Peripheral control register 27 (undocumented)";
        desc = "Undocumented: not in the Hi3520D data sheet (other chips have a DDR training register DDRT4 at this offset, which is not known to apply here). Seen in the vendor boot register table (decoded from the OEM boot image; its comment calls it SC_PERIPHCTRL27, 'undocumented on Hi3520D, kept as the SDK table has it'): after the PLLs are locked and the CPU is switched to PLL mode the boot clears bit 0 (read-modify-write, bit 0 only), before the DDR PHY setup. Partial meaning from the Hi3520D V200 vendor U-Boot (`arch/arm/cpu/hi3520d/start.S`, `product/hiddrtv200/ddrtraining.c`, `platform.h`: DDRT_OPTION_REG2 = 0x200500a0, with DDRT_OPTION_REG1 = 0x2005009c): this is the DDR-training option/result register; start.S runs the DDR gate training only if bit 0 is 1 and afterwards stores 0xF (training failed) or 0xA (success) in it, so the vendor boot table clearing bit 0 disables the gate training (meaning unverified on a V100 chip). Field layout otherwise unknown (modelled as one 32-bit field); no reset value known. Other chips call this offset DDRT4 (`DDR Training Register 4`, not reset by a soft reset) which fits.";
        field {
            name = "value";
            desc = "Undocumented: whole register; the vendor boot clears bit 0.";
            sw = rw;
        } value[31:0];
    } PERIPHCTRL27 @ 0x00A0;
`endif

`ifdef SYS_CTRL_PERIPHCTRL28_REG
    reg {
        name = "Peripheral control register 28";
        desc = "Peripheral control register 28 (IO control register 0). Hardware (Hi3520D V100 board, read on hardware 2026-11-08, stock U-Boot prompt after a cold boot): reads 0x62727727, reset here 0x22222222 (data sheet). Possible boot value (pin or drive-strength table written by the boot code); left at the data sheet value, open question.";

        enum PERIPHCTRL28_spi_sclk_ioctrl_ds_enum {
            mA0         = 0x0 { desc = "0mA (High Z)"; };
            mA3         = 0x1 { desc = "3mA"; };
            mA4         = 0x2 { desc = "4mA"; };
            // RESERVED   = 0x3 { desc = "RESERVED"; };
            // RESERVED   = 0x4 { desc = "RESERVED"; };
            // RESERVED   = 0x5 { desc = "RESERVED"; };
            mA8         = 0x6 { desc = "8mA"; };
            mA11        = 0x7 { desc = "11mA"; };
        };

        field {
            name = "spi_sclk_ioctrl_ds";
            desc = "spi_sclk Output drive capability selection.";
            encode = PERIPHCTRL28_spi_sclk_ioctrl_ds_enum;
            reset = 0x2;
        } spi_sclk_ioctrl_ds[30:28];

        enum PERIPHCTRL28_aio_ws_tx_ioctrl_ds_enum {
            mA0         = 0x0 { desc = "0mA (High Z)"; };
            mA3         = 0x1 { desc = "3mA"; };
            mA4         = 0x2 { desc = "4mA"; };
            // RESERVED   = 0x3 { desc = "RESERVED"; };
            // RESERVED   = 0x4 { desc = "RESERVED"; };
            // RESERVED   = 0x5 { desc = "RESERVED"; };
            mA8         = 0x6 { desc = "8mA"; };
            mA11        = 0x7 { desc = "11mA"; };
        };

        field {
            name = "aio_ws_tx_ioctrl_ds";
            desc = "aio_ws_tx output drive capability selection.";
            encode = PERIPHCTRL28_aio_ws_tx_ioctrl_ds_enum;
            reset = 0x2;
        } aio_ws_tx_ioctrl_ds[26:24];

        enum PERIPHCTRL28_aio_bclk_tx_ioctrl_ds_enum {
            mA0     = 0x0 { desc = "0mA (High Z)"; };
            mA3     = 0x1 { desc = "3mA"; };
            mA4     = 0x2 { desc = "4mA"; };
            // RESERVED = 0x3 { desc = "Reserved"; };
            // RESERVED = 0x4 { desc = "Reserved"; };
            // RESERVED = 0x5 { desc = "Reserved"; };
            mA8     = 0x6 { desc = "8mA"; };
            mA11    = 0x7 { desc = "11mA"; };
        };

        field {
            name = "aio_bclk_tx_ioctrl_ds";
            desc = "aio_bclk_tx output drive capability selection.";
            encode = PERIPHCTRL28_aio_bclk_tx_ioctrl_ds_enum;
            reset = 0x2;
        } aio_bclk_tx_ioctrl_ds[22:20];

        enum PERIPHCTRL28_aio_ws_rx_ioctrl_ds_enum {
            mA0         = 0x0 { desc = "0mA (High Z)"; };
            mA3         = 0x1 { desc = "3mA"; };
            mA4         = 0x2 { desc = "4mA"; };
            // RESERVED   = 0x3 { desc = "RESERVED"; };
            // RESERVED   = 0x4 { desc = "RESERVED"; };
            // RESERVED   = 0x5 { desc = "RESERVED"; };
            mA8         = 0x6 { desc = "8mA"; };
            mA11        = 0x7 { desc = "11mA"; };
        };

        field {
            name = "aio_ws_rx_ioctrl_ds";
            desc = "aio_ws_rx_ioctrl_ds Output drive capability selection.";
            encode = PERIPHCTRL28_aio_ws_rx_ioctrl_ds_enum;
            reset = 0x2;
        } aio_ws_rx_ioctrl_ds[18:16];

        enum PERIPHCTRL28_aio_bclk_rx_ioctrl_ds_enum {
            mA0         = 0x0 { desc = "0mA (High Z)"; };
            mA3         = 0x1 { desc = "3mA"; };
            mA4         = 0x2 { desc = "4mA"; };
            // RESERVED   = 0x3 { desc = "RESERVED"; };
            // RESERVED   = 0x4 { desc = "RESERVED"; };
            // RESERVED   = 0x5 { desc = "RESERVED"; };
            mA8         = 0x6 { desc = "8mA"; };
            mA11        = 0x7 { desc = "11mA"; };
        };

        field {
            name = "aio_bclk_rx_ioctrl_ds";
            desc = "aio_bclk_rx Output drive capability selection.";
            encode = PERIPHCTRL28_aio_bclk_rx_ioctrl_ds_enum;
            reset = 0x2;
        } aio_bclk_rx_ioctrl_ds[14:12];

        enum PERIPHCTRL28_aio_mclk_ioctrl_ds_enum {
            mA0         = 0x0 { desc = "0mA (High Z)"; };
            mA3         = 0x1 { desc = "3mA"; };
            mA4         = 0x2 { desc = "4mA"; };
            // RESERVED   = 0x3 { desc = "RESERVED"; };
            // RESERVED   = 0x4 { desc = "RESERVED"; };
            // RESERVED   = 0x5 { desc = "RESERVED"; };
            mA8         = 0x6 { desc = "8mA"; };
            mA11        = 0x7 { desc = "11mA"; };
        };

        field {
            name = "aio_mclk_ioctrl_ds";
            desc = "aio_mclk Output drive capability selection.";
            encode = PERIPHCTRL28_aio_mclk_ioctrl_ds_enum;
            reset = 0x2;
        } aio_mclk_ioctrl_ds[10:8];

        enum PERIPHCTRL28_vga_hs_vs_ioctrl_ds_enum {
            mA0     = 0x0 { desc = "0mA (High Z)"; };
            mA4     = 0x1 { desc = "4mA"; };
            mA8     = 0x2 { desc = "8mA"; };
            mA12_0  = 0x3 { desc = "12mA"; };
            mA12_1  = 0x4 { desc = "12mA"; };
            mA16    = 0x5 { desc = "16mA"; };
            mA20    = 0x6 { desc = "20mA"; };
            mA24    = 0x7 { desc = "24mA"; };
        };

        field {
            name = "vga_hs_vs_ioctrl_ds";
            desc = "Output drive current selection of vga_hs and vga_vs.";
            encode = PERIPHCTRL28_vga_hs_vs_ioctrl_ds_enum;
            reset = 0x2;
        } vga_hs_vs_ioctrl_ds[6:4];

        enum PERIPHCTRL28_vi_adc_clk_ioctrl_ds_enum {
            mA0         = 0x0 { desc = "0mA (High Z)"; };
            mA3         = 0x1 { desc = "3mA"; };
            mA4         = 0x2 { desc = "4mA"; };
            // RESERVED   = 0x3 { desc = "RESERVED"; };
            // RESERVED   = 0x4 { desc = "RESERVED"; };
            // RESERVED   = 0x5 { desc = "RESERVED"; };
            mA8         = 0x6 { desc = "8mA"; };
            mA11        = 0x7 { desc = "11mA"; };
        };

        field {
            name = "aio_mclk_ioctrl_ds";
            desc = "vi_adc_clk Output drive capability selection.";
            encode = PERIPHCTRL28_vi_adc_clk_ioctrl_ds_enum;
            reset = 0x2;
        } vi_adc_clk_ioctrl_ds[2:0];

    } PERIPHCTRL28 @ 0x00A4;
`endif

`ifdef SYS_CTRL_DDRT5_0xA4_REG
    reg {
        name = "DDR Training Register 5";
        desc = "
        !!! CAUTION
            This register is not reset when the system is soft-reset
        ";
        field {
            name = "ddrt5";
            desc = "DDR training register 5";
            reset = 0x0;
        } ddrt5[31:0];
    } DDRT5 @ 0x00A4;
`endif

`ifdef SYS_CTRL_PERIPHCTRL29_REG
    reg {
        name = "Peripheral control register 29";
        desc = "Peripheral control register 29 (IO control register 1).";

        enum PERIPHCTRL29_sfc_ioctrl_ds_enum {
            mA0         = 0x0 { desc = "0mA (High Z)"; };
            mA3         = 0x1 { desc = "3mA"; };
            mA4         = 0x2 { desc = "4mA"; };
            // RESERVED   = 0x3 { desc = "RESERVED"; };
            // RESERVED   = 0x4 { desc = "RESERVED"; };
            // RESERVED   = 0x5 { desc = "RESERVED"; };
            mA8         = 0x6 { desc = "8mA"; };
            mA11        = 0x7 { desc = "11mA"; };
        };

        field {
            name = "sfc_ioctrl_ds";
            desc = "SFC data pad output drive capability.";
            encode = PERIPHCTRL29_sfc_ioctrl_ds_enum;
            reset = 0x2;
        } sfc_ioctrl_ds[6:4];

        enum PERIPHCTRL29_spi_sdo_ioctrl_ds_enum {
            mA0         = 0x0 { desc = "0mA (High Z)"; };
            mA3         = 0x1 { desc = "3mA"; };
            mA4         = 0x2 { desc = "4mA"; };
            // RESERVED   = 0x3 { desc = "RESERVED"; };
            // RESERVED   = 0x4 { desc = "RESERVED"; };
            // RESERVED   = 0x5 { desc = "RESERVED"; };
            mA8         = 0x6 { desc = "8mA"; };
            mA11        = 0x7 { desc = "11mA"; };
        };

        field {
            name = "spi_sdo_ioctrl_ds";
            desc = "spi_sdo output drive capability.";
            encode = PERIPHCTRL29_spi_sdo_ioctrl_ds_enum;
            reset = 0x2;
        } spi_sdo_ioctrl_ds[2:0];

    } PERIPHCTRL29 @ 0x00A8;
`endif

`ifdef SYS_CTRL_DDRT6_0xA8_REG
    reg {
        name = "DDR Training Register 6";
        desc = "
        !!! CAUTION
            This register is not reset when the system is soft-reset
        ";
        field {
            name = "ddrt6";
            desc = "DDR training register 6";
            reset = 0x0;
        } ddrt6[31:0];
    } DDRT6 @ 0x00A8;
`endif

`ifdef SYS_CTRL_PERIPHCTRL30_0xAC_REG
    reg {
        name = "Peripheral control register 30";
        field {
            name = "pcie0_cfg_l2_clk_removal_en";
            reset = 0x0;
        } pcie0_cfg_l2_clk_removal_en[20:20];

        field {
            name = "pcie0_sys_cmd_cpled_int";
            reset = 0x0;
        } pcie0_sys_cmd_cpled_int[18:18];

        field {
            name = "pcie0_sys_pre_det_chged";
            reset = 0x0;
        } pcie0_sys_pre_det_chged[17:17];

        field {
            name = "pcie0_sys_mrl_sensor_chged";
            reset = 0x0;
        } pcie0_sys_mrl_sensor_chged[16:16];

        field {
            name = "pcie0_sys_pwr_fault_det";
            reset = 0x0;
        } pcie0_sys_pwr_fault_det[15:15];

        field {
            name = "pcie0_sys_mrl_sensor_state";
            reset = 0x0;
        } pcie0_sys_mrl_sensor_state[14:14];

        field {
            name = "pcie0_sys_pre_det_state";
            reset = 0x0;
        } pcie0_sys_pre_det_state[13:13];

        field {
            name = "pcie0_cfg_pwr_ctrler_ctrl_pol";
            reset = 0x0;
        } pcie0_cfg_pwr_ctrler_ctrl_pol[12:12];

        field {
            name = "pcie0_app_ltssm_enable";
            reset = 0x1;
        } pcie0_app_ltssm_enable[11:11];

        field {
            name = "pcie0_sys_aux_pwr_det";
            reset = 0x0;
        } pcie0_sys_aux_pwr_det[10:10];

        field {
            name = "pcie0_apps_pm_xmt_pme";
            reset = 0x0;
        } pcie0_apps_pm_xmt_pme[9:9];

        field {
            name = "pcie0_apps_pm_xmt_turnoff";
            reset = 0x0;
        } pcie0_apps_pm_xmt_turnoff[8:8];

        field {
            name = "pcie0_app_unlock_msg";
            reset = 0x0;
        } pcie0_app_unlock_msg[7:7];

        field {
            name = "pcie0_outband_pwrup_cmd";
            reset = 0x0;
        } pcie0_outband_pwrup_cmd[6:6];

        field {
            name = "pcie0_sys_int";
            reset = 0x0;
        } pcie0_sys_int[5:5];

        field {
            name = "pcie0_app_req_retry_en";
            reset = 0x0;
        } pcie0_app_req_retry_en[4:4];

        field {
            name = "pcie0_app_req_exit_l1";
            reset = 0x0;
        } pcie0_app_req_exit_l1[3:3];

        field {
            name = "pcie0_app_ready_entr_l23";
            reset = 0x0;
        } pcie0_app_ready_entr_l23[2:2];

        field {
            name = "pcie0_app_req_entr_l1";
            reset = 0x0;
        } pcie0_app_req_entr_l1[1:1];

        field {
            name = "pcie0_app_init_rst";
            reset = 0x0;
        } pcie0_app_init_rst[0:0];
    } PERIPHCTRL30 @ 0x00AC;
`endif

`ifdef SYS_CTRL_DDRT7_0xAC_REG
    reg {
        name = "DDR Training Register 7";
        desc = "
        !!! CAUTION
            This register is not reset when the system is soft-reset
        ";
        field {
            name = "ddrt7";
            desc = "DDR training register 7";
            reset = 0x0;
        } ddrt7[31:0];
    } DDRT7 @ 0x00AC;
`endif

`ifdef SYS_CTRL_PERIPHCTRL31_0xB0_REG
    reg {
        name = "Peripheral control register 31";
        field {
            name = "mpll_ncy";
            reset = 0x5;
        } mpll_ncy[28:24];

        field {
            name = "mpll_ncy5";
            reset = 0x1;
        } mpll_ncy5[23:22];

        field {
            name = "mpll_prescale";
            reset = 0x2;
        } mpll_prescale[21:20];

        field {
            name = "mpll_ss_en";
            reset = 0x0;
        } mpll_ss_en[19:19];

        field {
            name = "mpll_ss_sel";
            reset = 0x0;
        } mpll_ss_sel[18:17];

        field {
            name = "cko_alive_con";
            reset = 0x0;
        } cko_alive_con[16:15];

        field {
            name = "los_lvl";
            reset = 0x14;
        } los_lvl[14:10];

        field {
            name = "ref_clk_sel";
            reset = 0x0;
        } ref_clk_sel[9:2];

        field {
            name = "rtune_do_tune";
            reset = 0x0;
        } rtune_do_tune[1:1];

        field {
            name = "use_refclk_alt";
            reset = 0x0;
        } use_refclk_alt[0:0];
    } PERIPHCTRL31 @ 0x00B0;
`endif

`ifdef SYS_CTRL_PERIPHCTRL32_0xB4_REG
    reg {
        name = "Peripheral control register 32";
        field {
            name = "rx_eq_val_0";
            reset = 0x2;
        } rx_eq_val_0[30:28];

        field {
            name = "tx_atten_0";
            reset = 0x0;
        } tx_atten_0[24:22];

        field {
            name = "tx_boost_0";
            reset = 0xA;
        } tx_boost_0[18:15];

        field {
            name = "tx_clk_align";
            reset = 0x0;
        } tx_clk_align[10:9];

        field {
            name = "tx_edgerate_0";
            reset = 0x0;
        } tx_edgerate_0[8:7];

        field {
            name = "tx_lvl";
            reset = 0x6;
        } tx_lvl[4:0];
    } PERIPHCTRL32 @ 0x00B4;
`endif

`ifdef SYS_CTRL_PERIPHCTRL33_0xB8_REG
    reg {
        name = "Peripheral control register 33";
        field {
            name = "pd_adcl";
            sw = w;
            hw = r;
            reset = 0x1;
        } pd_adcl[31:31];

        field {
            name = "pd_adcr";
            sw = w;
            hw = r;
            reset = 0x1;
        } pd_adcr[30:30];

        field {
            name = "pd_dacl";
            sw = w;
            hw = r;
            reset = 0x1;
        } pd_dacl[29:29];

        field {
            name = "pd_dacr";
            sw = w;
            hw = r;
            reset = 0x1;
        } pd_dacr[28:28];

        field {
            name = "pd_micbias";
            sw = w;
            hw = r;
            reset = 0x1;
        } pd_micbias[27:27];

        field {
            name = "pd_vref";
            sw = w;
            hw = r;
            reset = 0x1;
        } pd_vref[26:26];

        field {
            name = "fstarup";
            sw = w;
            hw = r;
            reset = 0x0;
        } fstarup[25:25];

        field {
            name = "analog_loop";
            sw = w;
            hw = r;
            reset = 0x0;
        } analog_loop[24:24];

        field {
            name = "mute_dacl";
            sw = w;
            hw = r;
            reset = 0x1;
        } mute_dacl[23:23];

        field {
            name = "mute_dacr";
            sw = w;
            hw = r;
            reset = 0x1;
        } mute_dacr[22:22];

        field {
            name = "popfreel";
            sw = w;
            hw = r;
            reset = 0x0;
        } popfreel[21:21];

        field {
            name = "popfreer";
            sw = w;
            hw = r;
            reset = 0x0;
        } popfreer[20:20];

        field {
            name = "mute_micl";
            sw = w;
            hw = r;
            reset = 0x1;
        } mute_micl[19:19];

        field {
            name = "mute_micr";
            sw = w;
            hw = r;
            reset = 0x1;
        } mute_micr[18:18];

        field {
            name = "mclk_ana_sel";
            sw = w;
            hw = r;
            reset = 0x0;
        } mclk_ana_sel[17:17];

        field {
            name = "dacclk_sel";
            sw = w;
            hw = r;
            reset = 0x0;
        } dacclk_sel[16:16];

        field {
            name = "mixer_micl";
            sw = w;
            hw = r;
            reset = 0x0;
        } mixer_micl[15:14];

        field {
            name = "gain_micl";
            sw = w;
            hw = r;
            reset = 0x0;
        } gain_micl[13:9];

        field {
            name = "adc_vref_sel1";
            sw = w;
            hw = r;
            reset = 0x0;
        } adc_vref_sel1[8:8];

        field {
            name = "mixer_micr";
            sw = w;
            hw = r;
            reset = 0x0;
        } mixer_micr[7:6];

        field {
            name = "gain_micr";
            sw = w;
            hw = r;
            reset = 0x0;
        } gain_micr[5:1];

        field {
            name = "adc_vref_sel2";
            sw = w;
            hw = r;
            reset = 0x0;
        } adc_vref_sel2[0:0];
    } PERIPHCTRL33 @ 0x00B8;
`endif

`ifdef SYS_CTRL_PERIPHCTRL34_0xBC_REG
    reg {
        name = "Peripheral control register 34";
        field {
            name = "dacl_rst_n";
            sw = w;
            hw = r;
            reset = 0x0;
        } dacl_rst_n[31:31];

        field {
            name = "dacr_rst_n";
            sw = w;
            hw = r;
            reset = 0x0;
        } dacr_rst_n[30:30];

        field {
            name = "adcl_rst_n";
            sw = w;
            hw = r;
            reset = 0x0;
        } adcl_rst_n[29:29];

        field {
            name = "adcr_rst_n";
            sw = w;
            hw = r;
            reset = 0x0;
        } adcr_rst_n[28:28];

        field {
            name = "dacl_en";
            sw = w;
            hw = r;
            reset = 0x0;
        } dacl_en[27:27];

        field {
            name = "dacr_en";
            sw = w;
            hw = r;
            reset = 0x0;
        } dacr_en[26:26];

        field {
            name = "adcl_en";
            sw = w;
            hw = r;
            reset = 0x0;
        } adcl_en[25:25];

        field {
            name = "adcr_en";
            sw = w;
            hw = r;
            reset = 0x0;
        } adcr_en[24:24];

        field {
            name = "i2s1_data_bits";
            sw = w;
            hw = r;
            reset = 0x3;
        } i2s1_data_bits[23:22];

        field {
            name = "dig_bypass";
            sw = w;
            hw = r;
            reset = 0x0;
        } dig_bypass[19:19];

        field {
            name = "dig_loop";
            sw = w;
            hw = r;
            reset = 0x0;
        } dig_loop[18:18];

        field {
            name = "i2s1_fs_sel";
            sw = w;
            hw = r;
            reset = 0x1E;
        } i2s1_fs_sel[17:13];

        field {
            name = "ibadj_vrefbf";
            sw = w;
            hw = r;
            reset = 0x1;
        } ibadj_vrefbf[7:6];

        field {
            name = "ibadj_micbias";
            sw = w;
            hw = r;
            reset = 0x1;
        } ibadj_micbias[5:5];

        field {
            name = "ibadj_micpga";
            sw = w;
            hw = r;
            reset = 0x1;
        } ibadj_micpga[4:4];

        field {
            name = "ibadj_dac";
            sw = w;
            hw = r;
            reset = 0x1;
        } ibadj_dac[3:2];

        field {
            name = "ibadj_adc";
            sw = w;
            hw = r;
            reset = 0x1;
        } ibadj_adc[1:0];
    } PERIPHCTRL34 @ 0x00BC;
`endif

`ifdef SYS_CTRL_PERIPHCTRL35_0xC0_REG
    reg {
        name = "Peripheral control register 35";
        field {
            name = "smutel";
            sw = w;
            hw = r;
            reset = 0x0;
        } smutel[31:31];

        field {
            name = "smuter";
            sw = w;
            hw = r;
            reset = 0x0;
        } smuter[30:30];

        field {
            name = "sunmutel";
            sw = w;
            hw = r;
            reset = 0x0;
        } sunmutel[29:29];

        field {
            name = "sunmuter";
            sw = w;
            hw = r;
            reset = 0x0;
        } sunmuter[28:28];

        field {
            name = "dacvu";
            sw = w;
            hw = r;
            reset = 0x0;
        } dacvu[27:27];

        field {
            name = "mutel_rate";
            sw = w;
            hw = r;
            reset = 0x0;
        } mutel_rate[26:25];

        field {
            name = "muter_rate";
            sw = w;
            hw = r;
            reset = 0x0;
        } muter_rate[24:23];

        field {
            name = "dacl_deemph";
            sw = w;
            hw = r;
            reset = 0x0;
        } dacl_deemph[22:21];

        field {
            name = "dacr_deemph";
            sw = w;
            hw = r;
            reset = 0x0;
        } dacr_deemph[20:19];

        field {
            name = "dacl_i2ssel";
            sw = w;
            hw = r;
            reset = 0x0;
        } dacl_i2ssel[3:3];

        field {
            name = "dacl_lrsel";
            sw = w;
            hw = r;
            reset = 0x0;
        } dacl_lrsel[2:2];

        field {
            name = "dacr_i2ssel";
            sw = w;
            hw = r;
            reset = 0x0;
        } dacr_i2ssel[1:1];

        field {
            name = "dacr_lrsel";
            sw = w;
            hw = r;
            reset = 0x1;
        } dacr_lrsel[0:0];
    } PERIPHCTRL35 @ 0x00C0;
`endif

`ifdef SYS_CTRL_PERIPHCTRL36_0xC4_REG
    reg {
        name = "Peripheral control register 36";
        field {
            name = "dacl_mute";
            reset = 0x0;
        } dacl_mute[31:31];

        field {
            name = "dacl_vol";
            sw = w;
            hw = r;
            reset = 0x6;
        } dacl_vol[30:24];

        field {
            name = "dacr_mute";
            sw = w;
            hw = r;
            reset = 0x0;
        } dacr_mute[23:23];

        field {
            name = "dacr_vol";
            sw = w;
            hw = r;
            reset = 0x6;
        } dacr_vol[22:16];

        field {
            name = "dacr2dacl_en";
            sw = w;
            hw = r;
            reset = 0x0;
        } dacr2dacl_en[15:15];

        field {
            name = "dacr2dacl_vol";
            sw = w;
            hw = r;
            reset = 0x24;
        } dacr2dacl_vol[14:8];

        field {
            name = "dacl2dacr_en";
            sw = w;
            hw = r;
            reset = 0x0;
        } dacl2dacr_en[7:7];

        field {
            name = "dacl2dacr_vol";
            sw = w;
            hw = r;
            reset = 0x24;
        } dacl2dacr_vol[6:0];
    } PERIPHCTRL36 @ 0x00C4;
`endif

`ifdef SYS_CTRL_PERIPHCTRL37_0xC8_REG
    reg {
        name = "Peripheral control register 37";
        field {
            name = "adcl_mute";
            sw = w;
            hw = r;
            reset = 0x0;
        } adcl_mute[31:31];

        field {
            name = "adcl_vol";
            sw = w;
            hw = r;
            reset = 0x1E;
        } adcl_vol[30:24];

        field {
            name = "adcr_mute";
            sw = w;
            hw = r;
            reset = 0x0;
        } adcr_mute[23:23];

        field {
            name = "adcr_vol";
            sw = w;
            hw = r;
            reset = 0x1E;
        } adcr_vol[22:16];

        field {
            name = "adcl_hpf_en";
            sw = w;
            hw = r;
            reset = 0x0;
        } adcl_hpf_en[15:15];

        field {
            name = "adcr_hpf_en";
            sw = w;
            hw = r;
            reset = 0x0;
        } adcr_hpf_en[14:14];

        field {
            name = "adcl_i2ssel";
            sw = w;
            hw = r;
            reset = 0x0;
        } adcl_i2ssel[3:3];

        field {
            name = "adcl_lrsel";
            sw = w;
            hw = r;
            reset = 0x0;
        } adcl_lrsel[2:2];

        field {
            name = "adcr_i2ssel";
            sw = w;
            hw = r;
            reset = 0x0;
        } adcr_i2ssel[1:1];

        field {
            name = "adcr_lrsel";
            sw = w;
            hw = r;
            reset = 0x1;
        } adcr_lrsel[0:0];
    } PERIPHCTRL37 @ 0x00C8;
`endif

`ifdef SYS_CTRL_PERIPHCTRL38_0xCC_REG
    reg {
        name = "Peripheral control register 38";
        field {
            name = "adcl2dacl_en";
            sw = w;
            hw = r;
            reset = 0x0;
        } adcl2dacl_en[31:31];

        field {
            name = "adcl2dacl_vol";
            sw = w;
            hw = r;
            reset = 0x24;
        } adcl2dacl_vol[30:24];

        field {
            name = "adcr2dacl_en";
            sw = w;
            hw = r;
            reset = 0x0;
        } adcr2dacl_en[23:23];

        field {
            name = "adcr2dacl_vol";
            sw = w;
            hw = r;
            reset = 0x24;
        } adcr2dacl_vol[22:16];

        field {
            name = "adcl2dacr_en";
            sw = w;
            hw = r;
            reset = 0x0;
        } adcl2dacr_en[15:15];

        field {
            name = "adcl2dacr_vol";
            sw = w;
            hw = r;
            reset = 0x24;
        } adcl2dacr_vol[14:8];

        field {
            name = "adcr2dacr_en";
            sw = w;
            hw = r;
            reset = 0x0;
        } adcr2dacr_en[7:7];

        field {
            name = "adcr2dacr_vol";
            sw = w;
            hw = r;
            reset = 0x24;
        } adcr2dacr_vol[6:0];
    } PERIPHCTRL38 @ 0x00CC;
`endif

`ifdef SYS_CTRL_PERIPHCTRL39_0xD0_REG
    reg {
        name = "Peripheral control register 39";
        field {
            name = "pcie0_ref_clk_req_n";
            sw = r;
            hw = w;
            reset = 0x0;
        } pcie0_ref_clk_req_n[29:29];

        field {
            name = "pcie0_pm_status";
            sw = r;
            hw = w;
            reset = 0x0;
        } pcie0_pm_status[28:28];

        field {
            name = "pcie0_hp_msi";
            sw = r;
            hw = w;
            reset = 0x0;
        } pcie0_hp_msi[27:27];

        field {
            name = "pcie0_hp_int";
            sw = r;
            hw = w;
            reset = 0x0;
        } pcie0_hp_int[26:26];

        field {
            name = "pcie0_hp_pme";
            sw = r;
            hw = w;
            reset = 0x0;
        } pcie0_hp_pme[25:25];

        field {
            name = "pcie0_wake";
            sw = r;
            hw = w;
            reset = 0x0;
        } pcie0_wake[23:23];

        field {
            name = "pcie0_xmlh_link_up";
            sw = r;
            hw = w;
            reset = 0x0;
        } pcie0_xmlh_link_up[22:22];

        field {
            name = "pcie0_cfg_sys_err_rc";
            sw = r;
            hw = w;
            reset = 0x0;
        } pcie0_cfg_sys_err_rc[21:21];

        field {
            name = "pcie0_cfg_aer_int_msg_num";
            sw = r;
            hw = w;
            reset = 0x0;
        } pcie0_cfg_aer_int_msg_num[20:16];

        field {
            name = "pcie0_cfg_aer_rc_err_msi";
            sw = r;
            hw = w;
            reset = 0x0;
        } pcie0_cfg_aer_rc_err_msi[15:15];

        field {
            name = "pcie0_cfg_aer_rc_err_int";
            sw = r;
            hw = w;
            reset = 0x0;
        } pcie0_cfg_aer_rc_err_int[14:14];

        field {
            name = "pcie0_pm_curnt_state";
            sw = r;
            hw = w;
            reset = 0x0;
        } pcie0_pm_curnt_state[13:11];

        field {
            name = "pcie0_rdlh_link_up";
            sw = r;
            hw = w;
            reset = 0x0;
        } pcie0_rdlh_link_up[10:10];

        field {
            name = "pcie0_cfg_rcb";
            sw = r;
            hw = w;
            reset = 0x0;
        } pcie0_cfg_rcb[9:9];

        field {
            name = "pcie0_cfg_mem_space_en";
            sw = r;
            hw = w;
            reset = 0x0;
        } pcie0_cfg_mem_space_en[8:8];

        field {
            name = "pcie0_pm_xtlh_block_tlp";
            sw = r;
            hw = w;
            reset = 0x0;
        } pcie0_pm_xtlh_block_tlp[7:7];

        field {
            name = "pcie0_cfg_pwr_ctrler_ctrl";
            sw = r;
            hw = w;
            reset = 0x0;
        } pcie0_cfg_pwr_ctrler_ctrl[6:6];

        field {
            name = "pcie0_cfg_atten_ind";
            sw = r;
            hw = w;
            reset = 0x0;
        } pcie0_cfg_atten_ind[5:4];

        field {
            name = "pcie0_cfg_pwr_ind";
            sw = r;
            hw = w;
            reset = 0x0;
        } pcie0_cfg_pwr_ind[3:2];
    } PERIPHCTRL39 @ 0x00D0;
`endif

`ifdef SYS_CTRL_SYSBOOT0_REG
    reg {
        name = "System Boot Register 0";
        field {
            name = "sysboot0";
            desc = "System boot register 0";
            reset = 0x0;
        } sysboot0[31:0];
    } SYSBOOT0 @ 0x0130;
`endif

`ifdef SYS_CTRL_SYSBOOT1_REG
    reg {
        name = "System Boot Register 1";
        field {
            name = "sysboot1";
            desc = "System boot register 1";
            reset = 0x0;
        } sysboot1[31:0];
    } SYSBOOT1 @ 0x0134;
`endif

`ifdef SYS_CTRL_SYSBOOT2_REG
    reg {
        name = "System Boot Register 2";
        field {
            name = "sysboot2";
            desc = "System boot register 2";
            reset = 0x0;
        } sysboot2[31:0];
    } SYSBOOT2 @ 0x0138;
`endif

`ifdef SYS_CTRL_SYSBOOT3_REG
    reg {
        name = "System Boot Register 3";
        field {
            name = "sysboot3";
            desc = "System boot register 3";
            reset = 0x0;
        } sysboot3[31:0];
    } SYSBOOT3 @ 0x013C;
`endif

`ifdef SYS_CTRL_SYSBOOT4_REG
    reg {
        name = "System Boot Register 4";
        field {
            name = "sysboot4";
            desc = "System boot register 4";
            reset = 0x0;
        } sysboot4[31:0];
    } SYSBOOT4 @ 0x0140;
`endif

`ifdef SYS_CTRL_SYSBOOT5_REG
    reg {
        name = "System Boot Register 5";
        field {
            name = "sysboot5";
            desc = "System boot register 5";
            reset = 0x0;
        } sysboot5[31:0];
    } SYSBOOT5 @ 0x0144;
`endif

`ifdef SYS_CTRL_SYSBOOT6_REG
    reg {
        name = "System Boot Register 6";
        field {
            name = "sysboot6";
            desc = "System boot register 6";
            reset = 0x0;
        } sysboot6[31:0];
    } SYSBOOT6 @ 0x0148;
`endif

`ifdef SYS_CTRL_SYSBOOT7_REG
    reg {
        name = "System Boot Register 7";
        field {
            name = "sysboot7";
            desc = "System boot register 7";
            reset = 0x0;
        } sysboot7[31:0];
    } SYSBOOT7 @ 0x014C;
`endif

`ifdef SYS_CTRL_SYSBOOT8_REG
    reg {
        name = "System Boot Register 8";
        field {
            name = "sysboot8";
            desc = "System boot register 8";
            reset = 0x0;
        } sysboot8[31:0];
    } SYSBOOT8 @ 0x0150;
`endif

`ifdef SYS_CTRL_SYSBOOT9_REG
    reg {
        name = "System Boot Register 9";
        field {
            name = "sysboot9";
            desc = "System boot register 9";
            reset = 0x0;
        } sysboot9[31:0];
    } SYSBOOT9 @ 0x0154;
`endif

`ifdef SYS_CTRL_SYSBOOT10_REG
    reg {
        name = "System Boot Register 10";
        field {
            name = "sysboot10";
            desc = "System boot register 10";
            reset = 0x0;
        } sysboot10[31:0];
    } SYSBOOT10 @ 0x0158;
`endif

`ifdef SYS_CTRL_SYSBOOT11_REG
    reg {
        name = "System Boot Register 11";
        field {
            name = "sysboot11";
            desc = "System boot register 11";
            reset = 0x0;
        } sysboot11[31:0];
    } SYSBOOT11 @ 0x015C;
`endif

`ifdef SYS_CTRL_DIE_ID0_REG
    reg {
        name = "Die ID 0 register";

        field {
            name = "die_id0";
            sw = r;
            hw = na;
            reset = 0x0;
        } die_id0[31:0];

    } DIE_ID0 @ 0x0400;
`endif

`ifdef SYS_CTRL_DIE_ID1_REG
    reg {
        name = "Die ID 1 register";

        field {
            name = "die_id1";
            sw = r;
            hw = na;
            reset = 0x0;
        } die_id1[31:0];

    } DIE_ID1 @ 0x0404;
`endif

`ifdef SYS_CTRL_DIE_ID2_REG
    reg {
        name = "Die ID 2 register";

        field {
            name = "die_id2";
            sw = r;
            hw = na;
            reset = 0x0;
        } die_id2[31:0];

    } DIE_ID2 @ 0x0408;
`endif

`ifdef SYS_CTRL_DIE_ID3_REG
    reg {
        name = "Die ID 3 register";

        field {
            name = "die_id3";
            sw = r;
            hw = na;
            reset = 0x0;
        } die_id3[31:0];

    } DIE_ID3 @ 0x040C;
`endif

`ifdef SYS_CTRL_DIE_ID4_REG
    reg {
        name = "Die ID 4 register";

        field {
            name = "die_id4";
            sw = r;
            hw = na;
            reset = 0x0;
        } die_id4[31:0];

    } DIE_ID4 @ 0x0410;
`endif

`ifdef SYS_CTRL_DIE_ID5_REG
    reg {
        name = "Die ID 5 register";

        field {
            name = "die_id5";
            sw = r;
            hw = na;
            reset = 0x0;
        } die_id5[31:0];

    } DIE_ID5 @ 0x0414;
`endif

`ifdef SYS_CTRL_SYSID_REG
    reg {
        name = "Chip ID register";
        desc = "
        The chip model and version number

        !!! NOTE
            A working U-Boot driver can be downloaded here: [`sys-ctrl-chipid-driver.c`](assets/sys-ctrl-chipid-driver.c)

            To implement this driver in a device tree, use this:

                chipid@20050ee0 {
                    compatible = \"hisilicon,hi35xx-chipid\"; // Use the chipid driver
                    reg = <0x20050ee0 0x10>;
                    bootph-pre-ram; // This device should be available before relocation
                };

            This device can also be a subnode of the sys_ctrl device:

                sysctl: system-controller@20050000 {
                    compatible = \"hisilicon,hi3520d-sysctrl\", \"syscon\", \"simple-mfd\";
                    reg = <0x20050000 0x1000>;
                    #address-cells = <1>;
                    #size-cells = <1>;
                    ranges = <0x0 0x20050000 0x1000>;
                    bootph-pre-ram; // This device should be available before relocation

                    chipid@ee0 {
                        compatible = \"hisilicon,hi35xx-chipid\"; // Use the chipid driver
                        reg = <0xee0 0x10>;
                        bootph-pre-ram; // This device should be available before relocation
                    };
                };
        ";

        enum SYSID_enum {
            HI3516AV200 = 0x06000001 { desc = "Hi3516A V200"; };
            HI3516AV300 = 0x3516A300 { desc = "Hi3516A V300"; };
            // TODO: Add other SYSID values as I run across them
        };

        field {
            name = "sysid";
            encode = SYSID_enum;
            sw = r;
            hw = na;
            reset = `SYS_CTRL_SYSID_RESET;
        } sysid[31:0];

    } SYSID @ 0x0EE0;
`endif

`ifdef SYS_CTRL_SYSID0_REG
    reg {
        name = "Chip ID register 0";
`ifdef SYS_CTRL_SYSID_REGWIDTH8
        regwidth = 8; // the Hi3520D data sheet shows SYSID0..3 as 8-bit registers (stride stays 4)
`endif
        desc = "
        The last two characters of the chip version number

        ![SYS_ID](assets/sys-ctrl-system-id.png)

        !!! NOTE
            A working U-Boot driver can be downloaded here: [`sys-ctrl-chipid-driver.c`](assets/sys-ctrl-chipid-driver.c)

            To implement this driver in a device tree, use this:

                chipid@20050ee0 {
                    compatible = \"hisilicon,hi35xx-chipid\"; // Use the chipid driver
                    reg = <0x20050ee0 0x10>;
                    all-sys-id; // Use individual sysid registers
                    bootph-pre-ram; // This device should be available before relocation
                };

            This device can also be a subnode of the sys_ctrl device:

                sysctl: system-controller@20050000 {
                    compatible = \"hisilicon,hi3520d-sysctrl\", \"syscon\", \"simple-mfd\";
                    reg = <0x20050000 0x1000>;
                    #address-cells = <1>;
                    #size-cells = <1>;
                    ranges = <0x0 0x20050000 0x1000>;
                    bootph-pre-ram; // This device should be available before relocation

                    chipid@ee0 {
                        compatible = \"hisilicon,hi35xx-chipid\"; // Use the chipid driver
                        reg = <0xee0 0x10>;
                        all-sys-id; // Use individual sysid registers
                        bootph-pre-ram; // This device should be available before relocation
                    };
                };
        ";

        // The reset value of sysid0..sysid3 is the chip ID of the SoC, taken from the `SYS_CTRL_SYSIDn_RESET`
        // macros that each rdl/<chip>/defines.rdl must define (SYS_CTRL_SYSID_RESET for the single 32-bit register).
        enum SYSID0_enum {
            HIXXXX_VX00     = 0x0 { desc = "Version ending in `00`"; };
            HIXXXX_VX01     = 0x1 { desc = "Version ending in `01`"; };
            // TODO: Add other SYSID values as I run across them
        };

        field {
            name = "sysid0";
            desc = "Least significant byte of the chip ID (the chip version number digits, `HIXXXX VYXX`, where `XX` is this field). The value is SoC-specific.";
            encode = SYSID0_enum;
            sw = r;
            hw = na;
            reset = `SYS_CTRL_SYSID0_RESET;
        } sysid0[7:0];

    } SYSID0 @ 0x0EE0;
`endif

`ifdef SYS_CTRL_SYSID1_REG
    reg {
        name = "Chip ID register 1";
`ifdef SYS_CTRL_SYSID_REGWIDTH8
        regwidth = 8; // the Hi3520D data sheet shows SYSID0..3 as 8-bit registers (stride stays 4)
`endif
        desc = "The last character of the chip model, and first character of the version number";

        enum SYSID1_enum {
            HIXXXX_V1XX     = 0x1 { desc = "Chip `HIXXXX V1XX`"; };
            HIXXXXA_V1XX     = 0xA1 { desc = "Chip `HIXXXXA V1XX`"; };
            HIXXXXC_V3XX     = 0xC3 { desc = "Chip `HIXXXXC V3XX`"; };
            HIXXXXD_V1XX     = 0xD1 { desc = "Chip `HIXXXXD V1XX`"; };
            // TODO: Add other SYSID values as I run across them
        };

        field {
            name = "sysid1";
            desc = "Chip ID byte 1: the last character of the chip model and the first character of the version number (`HIXXXX VYXX`, where `X VY` is this field). The value is SoC-specific.";
            encode = SYSID1_enum;
            sw = r;
            hw = na;
            reset = `SYS_CTRL_SYSID1_RESET;
        } sysid1[7:0];

    } SYSID1 @ 0x0EE4;
`endif

`ifdef SYS_CTRL_SYSID2_REG
    reg {
        name = "Chip ID register 2";
`ifdef SYS_CTRL_SYSID_REGWIDTH8
        regwidth = 8; // the Hi3520D data sheet shows SYSID0..3 as 8-bit registers (stride stays 4)
`endif
        desc = "The third and fourth characters of the chip model.";

        enum SYSID2_enum {
            HIXX11 = 0x11 { desc = "Chip `HIXX11`"; };
            HIXX15 = 0x15 { desc = "Chip `HIXX15`"; };
            HIXX16 = 0x16 { desc = "Chip `HIXX16`"; };
            HIXX18 = 0x18 { desc = "Chip `HIXX18`"; };
            HIXX19 = 0x19 { desc = "Chip `HIXX19`"; };
            HIXX20 = 0x20 { desc = "Chip `HIXX20`"; };
            HIXX31 = 0x31 { desc = "Chip `HIXX31`"; };
            HIXX35 = 0x35 { desc = "Chip `HIXX35`"; };
            // TODO: Add other SYSID values as I run across them
        };

        field {
            name = "sysid2";
            desc = "Chip ID byte 2: the third and fourth characters of the chip model (`HI35XX...`, where `XX` is this field). The value is SoC-specific.";
            encode = SYSID2_enum;
            sw = r;
            hw = na;
            reset = `SYS_CTRL_SYSID2_RESET;
        } sysid2[7:0];

    } SYSID2 @ 0x0EE8;
`endif

`ifdef SYS_CTRL_SYSID3_REG
    reg {
        name = "Chip ID register 3";
`ifdef SYS_CTRL_SYSID_REGWIDTH8
        regwidth = 8; // the Hi3520D data sheet shows SYSID0..3 as 8-bit registers (stride stays 4)
`endif
        desc = "The first and second characters of the chip model.";

        enum SYSID3_enum {
            HI35XX = 0x35 { desc = "Chip `HI35XX`"; };
            // TODO: Add other SYSID values as I run across them
        };

        field {
            name = "sysid3";
            desc = "Chip ID byte 3: the first and second characters of the chip model (`HIXX...`, where `XX` is this field).";
            encode = SYSID3_enum;
            sw = r;
            hw = na;
            reset = `SYS_CTRL_SYSID3_RESET;
        } sysid3[7:0];

    } SYSID3 @ 0x0EEC;
`endif

};
`endif
