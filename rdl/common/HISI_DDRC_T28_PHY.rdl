`ifndef HISI_DDRC_T28_PHY_RDL
`define HISI_DDRC_T28_PHY_RDL

regfile eHISI_DDRC_T28_PHY_LANE {
    name = "DDR PHY (T28) byte-lane registers";
    desc = "One byte lane of the 28 nm T28 DDR PHY (offsets relative to PHY + 0x200 + lane x 0x80). PROVENANCE: PROVEN names and offsets from DDR_PHY_DXN*(n) in drivers/ddr/ddr_phy_t28.h of the vendor U-Boot (formulas 0x210 + (n << 7) etc.); meanings INFERRED from the names; field layout UNKNOWN except the masks listed in the header (bit delay line [6:0], RDQS bit delay [8:0], RDQSG phase [14:9], WDQS phase mask 0xF, WDQ phase mask 0x1F, VREF status DVREF [5:0] and HVREF [4:0]). Not hardware verified.";

    reg {
        name = "DXNWDQNBDL0";
        desc = "DXNWDQNBDL0. PROVENANCE: PROVEN name/offset: DDR_PHY_DXNWDQNBDL0(n) at 0x210 + (n << 7) with the lane window at PHY + 0x200 (ddr_phy_t28.h); the lane window is also written at a few offsets by the CV300 init table (listed in the PHY description).";
        field {
            name = "value";
            desc = "32-bit register value (field layout not described by any source I have: UNKNOWN).";
            sw = rw;
            hw = r;
        } value[31:0];
    } DXNWDQNBDL0 @ 0x10;

    reg {
        name = "DXNWDQNBDL1";
        desc = "DXNWDQNBDL1. PROVENANCE: PROVEN name/offset: DDR_PHY_DXNWDQNBDL1(n) at 0x214 + (n << 7) with the lane window at PHY + 0x200 (ddr_phy_t28.h); the lane window is also written at a few offsets by the CV300 init table (listed in the PHY description).";
        field {
            name = "value";
            desc = "32-bit register value (field layout not described by any source I have: UNKNOWN).";
            sw = rw;
            hw = r;
        } value[31:0];
    } DXNWDQNBDL1 @ 0x14;

    reg {
        name = "DXNWDQNBDL2";
        desc = "DXNWDQNBDL2. PROVENANCE: PROVEN name/offset: DDR_PHY_DXNWDQNBDL2(n) at 0x218 + (n << 7) with the lane window at PHY + 0x200 (ddr_phy_t28.h); the lane window is also written at a few offsets by the CV300 init table (listed in the PHY description).";
        field {
            name = "value";
            desc = "32-bit register value (field layout not described by any source I have: UNKNOWN).";
            sw = rw;
            hw = r;
        } value[31:0];
    } DXNWDQNBDL2 @ 0x18;

    reg {
        name = "DXNRDQNBDL0";
        desc = "DXNRDQNBDL0. PROVENANCE: PROVEN name/offset: DDR_PHY_DXNRDQNBDL0(n) at 0x21C + (n << 7) with the lane window at PHY + 0x200 (ddr_phy_t28.h); the lane window is also written at a few offsets by the CV300 init table (listed in the PHY description).";
        field {
            name = "value";
            desc = "32-bit register value (field layout not described by any source I have: UNKNOWN).";
            sw = rw;
            hw = r;
        } value[31:0];
    } DXNRDQNBDL0 @ 0x1C;

    reg {
        name = "DXNRDQNBDL1";
        desc = "DXNRDQNBDL1. PROVENANCE: PROVEN name/offset: DDR_PHY_DXNRDQNBDL1(n) at 0x220 + (n << 7) with the lane window at PHY + 0x200 (ddr_phy_t28.h); the lane window is also written at a few offsets by the CV300 init table (listed in the PHY description).";
        field {
            name = "value";
            desc = "32-bit register value (field layout not described by any source I have: UNKNOWN).";
            sw = rw;
            hw = r;
        } value[31:0];
    } DXNRDQNBDL1 @ 0x20;

    reg {
        name = "DXNRDQNBDL2";
        desc = "DXNRDQNBDL2. PROVENANCE: PROVEN name/offset: DDR_PHY_DXNRDQNBDL2(n) at 0x224 + (n << 7) with the lane window at PHY + 0x200 (ddr_phy_t28.h); the lane window is also written at a few offsets by the CV300 init table (listed in the PHY description).";
        field {
            name = "value";
            desc = "32-bit register value (field layout not described by any source I have: UNKNOWN).";
            sw = rw;
            hw = r;
        } value[31:0];
    } DXNRDQNBDL2 @ 0x24;

    reg {
        name = "DXNOEBDL";
        desc = "DXNOEBDL. PROVENANCE: PROVEN name/offset: DDR_PHY_DXNOEBDL(n) at 0x228 + (n << 7) with the lane window at PHY + 0x200 (ddr_phy_t28.h); the lane window is also written at a few offsets by the CV300 init table (listed in the PHY description).";
        field {
            name = "value";
            desc = "32-bit register value (field layout not described by any source I have: UNKNOWN).";
            sw = rw;
            hw = r;
        } value[31:0];
    } DXNOEBDL @ 0x28;

    reg {
        name = "DXNRDQSDLY";
        desc = "DXNRDQSDLY. PROVENANCE: PROVEN name/offset: DDR_PHY_DXNRDQSDLY(n) at 0x22C + (n << 7) with the lane window at PHY + 0x200 (ddr_phy_t28.h); the lane window is also written at a few offsets by the CV300 init table (listed in the PHY description).";
        field {
            name = "value";
            desc = "32-bit register value (field layout not described by any source I have: UNKNOWN).";
            sw = rw;
            hw = r;
        } value[31:0];
    } DXNRDQSDLY @ 0x2C;

    reg {
        name = "DXNWDQSDLY";
        desc = "DXNWDQSDLY. PROVENANCE: PROVEN name/offset: DDR_PHY_DXNWDQSDLY(n) at 0x230 + (n << 7) with the lane window at PHY + 0x200 (ddr_phy_t28.h); the lane window is also written at a few offsets by the CV300 init table (listed in the PHY description).";
        field {
            name = "value";
            desc = "32-bit register value (field layout not described by any source I have: UNKNOWN).";
            sw = rw;
            hw = r;
        } value[31:0];
    } DXNWDQSDLY @ 0x30;

    reg {
        name = "DXNWDQDLY";
        desc = "DXNWDQDLY. PROVENANCE: PROVEN name/offset: DDR_PHY_DXNWDQDLY(n) at 0x234 + (n << 7) with the lane window at PHY + 0x200 (ddr_phy_t28.h); the lane window is also written at a few offsets by the CV300 init table (listed in the PHY description).";
        field {
            name = "value";
            desc = "32-bit register value (field layout not described by any source I have: UNKNOWN).";
            sw = rw;
            hw = r;
        } value[31:0];
    } DXNWDQDLY @ 0x34;

    reg {
        name = "DXNRDQSGDLY";
        desc = "DXNRDQSGDLY. PROVENANCE: PROVEN name/offset: DDR_PHY_DXNRDQSGDLY(n) at 0x240 + (n << 7) with the lane window at PHY + 0x200 (ddr_phy_t28.h); the lane window is also written at a few offsets by the CV300 init table (listed in the PHY description).";
        field {
            name = "value";
            desc = "32-bit register value (field layout not described by any source I have: UNKNOWN).";
            sw = rw;
            hw = r;
        } value[31:0];
    } DXNRDQSGDLY @ 0x40;

    reg {
        name = "DXNRDBOUND";
        desc = "DXNRDBOUND. PROVENANCE: PROVEN name/offset: DDR_PHY_DXNRDBOUND(n) at 0x250 + (n << 7) with the lane window at PHY + 0x200 (ddr_phy_t28.h); the lane window is also written at a few offsets by the CV300 init table (listed in the PHY description).";
        field {
            name = "value";
            desc = "32-bit register value (field layout not described by any source I have: UNKNOWN).";
            sw = rw;
            hw = r;
        } value[31:0];
    } DXNRDBOUND @ 0x50;

    reg {
        name = "DXNWDBOUND";
        desc = "DXNWDBOUND. PROVENANCE: PROVEN name/offset: DDR_PHY_DXNWDBOUND(n) at 0x254 + (n << 7) with the lane window at PHY + 0x200 (ddr_phy_t28.h); the lane window is also written at a few offsets by the CV300 init table (listed in the PHY description).";
        field {
            name = "value";
            desc = "32-bit register value (field layout not described by any source I have: UNKNOWN).";
            sw = rw;
            hw = r;
        } value[31:0];
    } DXNWDBOUND @ 0x54;

    reg {
        name = "DXNDVREFT_STATUS";
        desc = "DXNDVREFT_STATUS. PROVENANCE: PROVEN name/offset: DDR_PHY_DXNDVREFT_STATUS(n) at 0x270 + (n << 7) with the lane window at PHY + 0x200 (ddr_phy_t28.h); the lane window is also written at a few offsets by the CV300 init table (listed in the PHY description).";
        field {
            name = "value";
            desc = "32-bit register value (field layout not described by any source I have: UNKNOWN).";
            sw = rw;
            hw = r;
        } value[31:0];
    } DXNDVREFT_STATUS @ 0x70;

    reg {
        name = "DXNHVREFT_STATUS";
        desc = "DXNHVREFT_STATUS. PROVENANCE: PROVEN name/offset: DDR_PHY_DXNHVREFT_STATUS(n) at 0x274 + (n << 7) with the lane window at PHY + 0x200 (ddr_phy_t28.h); the lane window is also written at a few offsets by the CV300 init table (listed in the PHY description).";
        field {
            name = "value";
            desc = "32-bit register value (field layout not described by any source I have: UNKNOWN).";
            sw = rw;
            hw = r;
        } value[31:0];
    } DXNHVREFT_STATUS @ 0x74;

};

regfile eHISI_DDRC_T28_PHY {
    name = "DDR PHY, 28 nm T28 generation (Hi3516C V300 / Hi3516E V100)";
    desc = "
    28 nm DDR PHY at DDRC0 + 0x8000 = 0x12068000 on the Hi3516C V300 / Hi3516E V100 (vendor U-Boot arch/arm/cpu/hi3516cv300/ddr_training_custom.h: DDR_PHY_T28_CONFIG, DDR_REG_BASE_PHY0 = DDRC0_REG_BASE + 0x8000). The data sheets have NO PHY chapter, and the layout is NOT the S40 one of eHISI_DDRC_V2_PHY (AC block at 0x1040+ instead of 0x128+, 7-bit bit-delay lines, lane window shifted).
    PROVENANCE (stated per register): PROVEN = name and offset from the vendor U-Boot header drivers/ddr/ddr_phy_t28.h (same file in openipc-u-boot-hi3516cv100 and -cv300, GPL-2.0) and/or the vendor init table reg_info_hi3516cv300.bin; INFERRED = register name borrowed from the S40/V2 PHY at the same offset where the CV300 init table writes a value with the same shape (DRAMTIMER, PLLTIMER, ...: the names are the V2 PHY names at these offsets (INFERRED, not verified on a T28 part), a T28 header does not name them); UNKNOWN = field layout (every register is one 32-bit value here unless the header gives masks, listed in the description). Not hardware verified.
    Other CV300 init-table writes to this PHY that have no name in any source (offset: value, GUESS role): 0x0BC: 0x6; 0x114: 0x28032100; 0x118: 0x02040200; 0x11C: 0x03000090; 0x128: 0xA (name ACCMDBDL2 on S40); 0x208: 0xF80000; 0x288: 0xF80000; 0x274 and 0x2F4: 0x8 (these two are HVREFT_STATUS of lanes 0 and 1 in the header); 0x1018: 0x03DC0000; 0x1020/0x1024/0x1028/0x101C: lane/AC words (0xA, 0x0, 0x0003CF03, 0x08C00000); the 0x12069xxx window at PHY + 0x1000 holds the AC block (0x1040, 0x1064, 0x1070 named by the header) and further registers written by the table at 0x1204, 0x1208, 0x1210, 0x1218, 0x121C, 0x1234, 0x1248, 0x1258, 0x1304, 0x1308, 0x1048/0x104C and 0x1050..0x10C4 (values in build/tmp/cv300-reginfo.txt): not modeled.
    ";

    reg {
        name = "PHYINITCTRL";
        desc = "PHYINITCTRL. PROVENANCE: PROVEN name/offset: DDR_PHY_PHYINITCTRL in ddr_phy_t28.h (vendor U-Boot drivers/ddr). Bits seen in the header: INIT_EN 0x1, DLYMEAS_EN 0x4, RDET_EN 0x100, DVREFT_SYNC 0x40000, low 16 bits are status/handshake (mask 0xFFFF: PHY_PHYINITCTRL_MASK).";
        field {
            name = "value";
            desc = "32-bit register value (field layout not described by any source I have: UNKNOWN).";
            sw = rw;
            hw = r;
        } value[31:0];
    } PHYINITCTRL @ 0x4;

    reg {
        name = "PHYINITSTATUS";
        desc = "PHYINITSTATUS. PROVENANCE: PROVEN name/offset (ddr_phy_t28.h). Bit 0x20 = gate training status (PHY_INITSTATUS_GT_MASK), bit 0x100 = read data eye calibration error (PHY_PHYINITSTATUS_RDET_ERR).";
        field {
            name = "value";
            desc = "32-bit register value (field layout not described by any source I have: UNKNOWN).";
            sw = rw;
            hw = r;
        } value[31:0];
    } PHYINITSTATUS @ 0x8;

    reg {
        name = "DRAMCFG";
        desc = "DRAMCFG. PROVENANCE: PROVEN name/offset (ddr_phy_t28.h); table write 0x40022 (CV300 reg_info record at 0x1206802C, DDR3). [2:0] DRAM type (5 = LPDDR3, PHY_DRAMCFG_TYPE_LPDDR3), bit 5 = 2T mode (PHY_DRAMCFG_MA2T 0x20).";
        field {
            name = "value";
            desc = "32-bit register value (field layout not described by any source I have: UNKNOWN).";
            sw = rw;
            hw = r;
        } value[31:0];
    } DRAMCFG @ 0x2C;

    reg {
        name = "MODEREG01";
        desc = "MODEREG01. PROVENANCE: PROVEN name/offset (ddr_phy_t28.h); table write 0x00401A40.";
        field {
            name = "value";
            desc = "32-bit register value (field layout not described by any source I have: UNKNOWN).";
            sw = rw;
            hw = r;
        } value[31:0];
    } MODEREG01 @ 0x64;

    reg {
        name = "MODEREG23";
        desc = "MODEREG23. PROVENANCE: PROVEN name/offset (ddr_phy_t28.h); table write 0x00000008.";
        field {
            name = "value";
            desc = "32-bit register value (field layout not described by any source I have: UNKNOWN).";
            sw = rw;
            hw = r;
        } value[31:0];
    } MODEREG23 @ 0x68;

    reg {
        name = "MISC";
        desc = "MISC. PROVENANCE: PROVEN name/offset (ddr_phy_t28.h); table write 0x406. Bit 19 = delay-config update (PHY_MISC_UPDATE_BIT 19 on T28; the lowlevel_init_v300.c 2T workaround sets and clears 0x80000 = bit 19 here); bit 16 = scrambler (PHY_MISC_SCRAMB_DIS clears it).";
        field {
            name = "value";
            desc = "32-bit register value (field layout not described by any source I have: UNKNOWN).";
            sw = rw;
            hw = r;
        } value[31:0];
    } MISC @ 0x70;

    reg {
        name = "DMSEL";
        desc = "DMSEL. PROVENANCE: PROVEN name/offset (ddr_phy_t28.h); table write 0x0010400A. Bits [26:24] = DFI byte swap (PHY_DMSEL_SWAPDFIBYTE masks them).";
        field {
            name = "value";
            desc = "32-bit register value (field layout not described by any source I have: UNKNOWN).";
            sw = rw;
            hw = r;
        } value[31:0];
    } DMSEL @ 0x84;

    reg {
        name = "SWTMODE";
        desc = "SWTMODE. PROVENANCE: PROVEN name/offset (ddr_phy_t28.h): software training mode.";
        field {
            name = "value";
            desc = "32-bit register value (field layout not described by any source I have: UNKNOWN).";
            sw = rw;
            hw = r;
        } value[31:0];
    } SWTMODE @ 0xA0;

    reg {
        name = "SWTWLDQS";
        desc = "SWTWLDQS. PROVENANCE: PROVEN name/offset (ddr_phy_t28.h).";
        field {
            name = "value";
            desc = "32-bit register value (field layout not described by any source I have: UNKNOWN).";
            sw = rw;
            hw = r;
        } value[31:0];
    } SWTWLDQS @ 0xA4;

    reg {
        name = "SWTRLT";
        desc = "SWTRLT. PROVENANCE: PROVEN name/offset (ddr_phy_t28.h): software training result; WL and gate result nibbles (masks 0xF).";
        field {
            name = "value";
            desc = "32-bit register value (field layout not described by any source I have: UNKNOWN).";
            sw = rw;
            hw = r;
        } value[31:0];
    } SWTRLT @ 0xA8;

    reg {
        name = "IOCTL2";
        desc = "IOCTL2. PROVENANCE: PROVEN name/offset (ddr_phy_t28.h).";
        field {
            name = "value";
            desc = "32-bit register value (field layout not described by any source I have: UNKNOWN).";
            sw = rw;
            hw = r;
        } value[31:0];
    } IOCTL2 @ 0xB4;

    reg {
        name = "DVRFTCTRL";
        desc = "DVRFTCTRL. PROVENANCE: PROVEN name/offset (ddr_phy_t28.h): DRAM VREF training control, bit 31 = PDA enable (PHY_DVRFTCTRL_PDAEN_EN).";
        field {
            name = "value";
            desc = "32-bit register value (field layout not described by any source I have: UNKNOWN).";
            sw = rw;
            hw = r;
        } value[31:0];
    } DVRFTCTRL @ 0xC4;

    reg {
        name = "CATSWAPINDEX";
        desc = "CATSWAPINDEX. PROVENANCE: PROVEN name/offset (ddr_phy_t28.h): CA swap index.";
        field {
            name = "value";
            desc = "32-bit register value (field layout not described by any source I have: UNKNOWN).";
            sw = rw;
            hw = r;
        } value[31:0];
    } CATSWAPINDEX @ 0x1B8;

    reg {
        name = "CATSWAPSEL";
        desc = "CATSWAPSEL. PROVENANCE: PROVEN name/offset (ddr_phy_t28.h): CA swap select, 8-bit mask.";
        field {
            name = "value";
            desc = "32-bit register value (field layout not described by any source I have: UNKNOWN).";
            sw = rw;
            hw = r;
        } value[31:0];
    } CATSWAPSEL @ 0x1BC;

    reg {
        name = "CATCONFIG";
        desc = "CATCONFIG. PROVENANCE: PROVEN name/offset (ddr_phy_t28.h): CA training configuration.";
        field {
            name = "value";
            desc = "32-bit register value (field layout not described by any source I have: UNKNOWN).";
            sw = rw;
            hw = r;
        } value[31:0];
    } CATCONFIG @ 0x1C8;

    reg {
        name = "PHYDQRESULT";
        desc = "PHYDQRESULT. PROVENANCE: PROVEN name/offset (ddr_phy_t28.h): SW CA training DQ result from the PHY.";
        field {
            name = "value";
            desc = "32-bit register value (field layout not described by any source I have: UNKNOWN).";
            sw = rw;
            hw = r;
        } value[31:0];
    } PHYDQRESULT @ 0x1D0;

    reg {
        name = "ADDRPHBOUND";
        desc = "ADDRPHBOUND. PROVENANCE: PROVEN name/offset (ddr_phy_t28.h): CA training address phase boundary, [20:16] phase (mask 0x1F); table write 0 (CV300).";
        field {
            name = "value";
            desc = "32-bit register value (field layout not described by any source I have: UNKNOWN).";
            sw = rw;
            hw = r;
        } value[31:0];
    } ADDRPHBOUND @ 0x1D4;

    reg {
        name = "SWCATPATTERN_P";
        desc = "SWCATPATTERN_P. PROVENANCE: PROVEN name/offset (ddr_phy_t28.h): pattern for the positive CK edge (10-bit mask).";
        field {
            name = "value";
            desc = "32-bit register value (field layout not described by any source I have: UNKNOWN).";
            sw = rw;
            hw = r;
        } value[31:0];
    } SWCATPATTERN_P @ 0x1D8;

    reg {
        name = "SWCATPATTERN_N";
        desc = "SWCATPATTERN_N. PROVENANCE: PROVEN name/offset (ddr_phy_t28.h): pattern for the negative CK edge.";
        field {
            name = "value";
            desc = "32-bit register value (field layout not described by any source I have: UNKNOWN).";
            sw = rw;
            hw = r;
        } value[31:0];
    } SWCATPATTERN_N @ 0x1DC;

    reg {
        name = "ACCMDBDL2";
        desc = "ACCMDBDL2. PROVENANCE: PROVEN name/offset (ddr_phy_t28.h; on S40 the same name is at 0x128). AC block command bit delay line.";
        field {
            name = "value";
            desc = "32-bit register value (field layout not described by any source I have: UNKNOWN).";
            sw = rw;
            hw = r;
        } value[31:0];
    } ACCMDBDL2 @ 0x1040;

    reg {
        name = "ACPHYCTL4";
        desc = "ACPHYCTL4. PROVENANCE: PROVEN name/offset (ddr_phy_t28.h): AC block PHY control; table write 0xFFFF0770.";
        field {
            name = "value";
            desc = "32-bit register value (field layout not described by any source I have: UNKNOWN).";
            sw = rw;
            hw = r;
        } value[31:0];
    } ACPHYCTL4 @ 0x1064;

    reg {
        name = "ACPHYCTL7";
        desc = "ACPHYCTL7. PROVENANCE: PROVEN name/offset (ddr_phy_t28.h).";
        field {
            name = "value";
            desc = "32-bit register value (field layout not described by any source I have: UNKNOWN).";
            sw = rw;
            hw = r;
        } value[31:0];
    } ACPHYCTL7 @ 0x1070;

    reg {
        name = "PHYTIMER0";
        desc = "PHYTIMER0. PROVENANCE: INFERRED name (borrowed from the S40/V2 PHY at the same offset; ddr_phy_t28.h does not name it); PROVEN access: the CV300 init table writes 0x000A00FF to PHY+0x10.";
        field {
            name = "value";
            desc = "32-bit register value (field layout not described by any source I have: UNKNOWN).";
            sw = rw;
            hw = r;
        } value[31:0];
    } PHYTIMER0 @ 0x10;

    reg {
        name = "PHYTIMER1";
        desc = "PHYTIMER1. PROVENANCE: INFERRED name (borrowed from the S40/V2 PHY at the same offset; ddr_phy_t28.h does not name it); PROVEN access: the CV300 init table writes 0xF000F000 to PHY+0x14.";
        field {
            name = "value";
            desc = "32-bit register value (field layout not described by any source I have: UNKNOWN).";
            sw = rw;
            hw = r;
        } value[31:0];
    } PHYTIMER1 @ 0x14;

    reg {
        name = "PLLTIMER";
        desc = "PLLTIMER. PROVENANCE: INFERRED name (borrowed from the S40/V2 PHY at the same offset; ddr_phy_t28.h does not name it); PROVEN access: the CV300 init table writes 0x5DC00080 to PHY+0x1C.";
        field {
            name = "value";
            desc = "32-bit register value (field layout not described by any source I have: UNKNOWN).";
            sw = rw;
            hw = r;
        } value[31:0];
    } PLLTIMER @ 0x1C;

    reg {
        name = "DRAMTIMER0";
        desc = "DRAMTIMER0. PROVENANCE: INFERRED name (borrowed from the S40/V2 PHY at the same offset; ddr_phy_t28.h does not name it); PROVEN access: the CV300 init table writes 0x20862221 to PHY+0x30.";
        field {
            name = "value";
            desc = "32-bit register value (field layout not described by any source I have: UNKNOWN).";
            sw = rw;
            hw = r;
        } value[31:0];
    } DRAMTIMER0 @ 0x30;

    reg {
        name = "DRAMTIMER1";
        desc = "DRAMTIMER1. PROVENANCE: INFERRED name (borrowed from the S40/V2 PHY at the same offset; ddr_phy_t28.h does not name it); PROVEN access: the CV300 init table writes 0x182C0E75 to PHY+0x34.";
        field {
            name = "value";
            desc = "32-bit register value (field layout not described by any source I have: UNKNOWN).";
            sw = rw;
            hw = r;
        } value[31:0];
    } DRAMTIMER1 @ 0x34;

    reg {
        name = "DRAMTIMER2";
        desc = "DRAMTIMER2. PROVENANCE: INFERRED name (borrowed from the S40/V2 PHY at the same offset; ddr_phy_t28.h does not name it); PROVEN access: the CV300 init table writes 0x20051608 to PHY+0x38.";
        field {
            name = "value";
            desc = "32-bit register value (field layout not described by any source I have: UNKNOWN).";
            sw = rw;
            hw = r;
        } value[31:0];
    } DRAMTIMER2 @ 0x38;

    reg {
        name = "DRAMTIMER3";
        desc = "DRAMTIMER3. PROVENANCE: INFERRED name (borrowed from the S40/V2 PHY at the same offset; ddr_phy_t28.h does not name it); PROVEN access: the CV300 init table writes 0xA0000501 to PHY+0x3C.";
        field {
            name = "value";
            desc = "32-bit register value (field layout not described by any source I have: UNKNOWN).";
            sw = rw;
            hw = r;
        } value[31:0];
    } DRAMTIMER3 @ 0x3C;

    reg {
        name = "DRAMTIMER4";
        desc = "DRAMTIMER4. PROVENANCE: INFERRED name (borrowed from the S40/V2 PHY at the same offset; ddr_phy_t28.h does not name it); PROVEN access: the CV300 init table writes 0x403464BC to PHY+0x40.";
        field {
            name = "value";
            desc = "32-bit register value (field layout not described by any source I have: UNKNOWN).";
            sw = rw;
            hw = r;
        } value[31:0];
    } DRAMTIMER4 @ 0x40;

    reg {
        name = "ODTCR";
        desc = "ODTCR. PROVENANCE: INFERRED name (borrowed from the S40/V2 PHY at the same offset; ddr_phy_t28.h does not name it); PROVEN access: the CV300 init table writes 0x00000001 to PHY+0x44.";
        field {
            name = "value";
            desc = "32-bit register value (field layout not described by any source I have: UNKNOWN).";
            sw = rw;
            hw = r;
        } value[31:0];
    } ODTCR @ 0x44;

    reg {
        name = "PHYCTRL0";
        desc = "PHYCTRL0. PROVENANCE: INFERRED name (borrowed from the S40/V2 PHY at the same offset; ddr_phy_t28.h does not name it); PROVEN access: the CV300 init table writes 0x00003184 to PHY+0x78.";
        field {
            name = "value";
            desc = "32-bit register value (field layout not described by any source I have: UNKNOWN).";
            sw = rw;
            hw = r;
        } value[31:0];
    } PHYCTRL0 @ 0x78;

    reg {
        name = "RETCTRL0";
        desc = "RETCTRL0. PROVENANCE: INFERRED name (borrowed from the S40/V2 PHY at the same offset; ddr_phy_t28.h does not name it); PROVEN access: the CV300 init table writes 0x00010400 to PHY+0x80.";
        field {
            name = "value";
            desc = "32-bit register value (field layout not described by any source I have: UNKNOWN).";
            sw = rw;
            hw = r;
        } value[31:0];
    } RETCTRL0 @ 0x80;

    reg {
        name = "IOCTL1";
        desc = "IOCTL1. PROVENANCE: INFERRED name (borrowed from the S40/V2 PHY at the same offset; ddr_phy_t28.h does not name it); PROVEN access: the CV300 init table writes 0x00000000 to PHY+0xB0.";
        field {
            name = "value";
            desc = "32-bit register value (field layout not described by any source I have: UNKNOWN).";
            sw = rw;
            hw = r;
        } value[31:0];
    } IOCTL1 @ 0xB0;

    reg {
        name = "TRAINCTRL1";
        desc = "TRAINCTRL1. PROVENANCE: INFERRED name (borrowed from the S40/V2 PHY at the same offset; ddr_phy_t28.h does not name it); PROVEN access: the CV300 init table writes 0xF806FB06 to PHY+0xD0.";
        field {
            name = "value";
            desc = "32-bit register value (field layout not described by any source I have: UNKNOWN).";
            sw = rw;
            hw = r;
        } value[31:0];
    } TRAINCTRL1 @ 0xD0;

    reg {
        name = "TRAINCTRL3";
        desc = "TRAINCTRL3. PROVENANCE: INFERRED name (borrowed from the S40/V2 PHY at the same offset; ddr_phy_t28.h does not name it); PROVEN access: the CV300 init table writes 0xCA620000 to PHY+0xDC.";
        field {
            name = "value";
            desc = "32-bit register value (field layout not described by any source I have: UNKNOWN).";
            sw = rw;
            hw = r;
        } value[31:0];
    } TRAINCTRL3 @ 0xDC;

    eHISI_DDRC_T28_PHY_LANE LANE[4] @ 0x200 += 0x80;

};

`endif
