`ifndef HISI_VEDU_V2_H265_TABLE_RDL
`define HISI_VEDU_V2_H265_TABLE_RDL

regfile eHISI_VEDU_V2_H265_TABLE {
    name = "H.265 register table (NOT A REGISTER FILE)";
    desc = "NOT A REGISTER FILE and NOT INSTANTIATED: the per-frame DDR register table of the H.265 encoder of the Hi3516C V300 / E V100 (vendor module hi3516cv300_h265e.ko, Xiongmai V4.02.R12). The module keeps a pointer to the table in its channel context (offset 0xDC8) and fills it in HH265E_DRV_UpdateRegConfigParam, InitRegConfigParam, UpdateLowerPowerCfg and UpdateOsdRoiConfigParam; only a few registers are written to MMIO directly by HH265E_DRV_WriteRegs (0x04 interrupt mask, 0x14 mode, 0x30 clock/power, 0x20, 0x3C, 0x160, 0x188, 0x1B8, 0xC28 and others). Offsets are table (byte) offsets, assumed equal to the MMIO register offsets of the same register file (INFERRED from the 0x4/0x14/0x30 words that both paths write and from the same scheme on the Hi3520D and Hi3518E V200, docs/rdl-campaign/vedu-vendor.md and docs/research/hi3518ev200-blocks.md section 15). Produced by a scripted symbolic trace over the ARM instruction stream (build/tmp/cv300-xm/symtrace.py, tablemap.py): per word the PROVEN facts are the offset, which bytes are stored (strb/strh/str) and the bit extents cleared with bic masks; the constants listed are values ORed in by the code; the meaning of every field is UNKNOWN (the source values come from module-private structs without names; no header exists in any corpus). Branches are linearized, so a word may show alternative writes of different code paths. Not hardware verified.";

    reg {
        name = "Table word 0x0";
        desc = "Word 0x0 of the H.265 register table. PROVENANCE: PROVEN offset; PROVEN stored byte lanes 0123 (lane 0 = bits [7:0]); PROVEN cleared bit extents [11:6] (lower bound of the fields); constants ORed in: none; written by UpdateLowerPowerCfg, UpdateRegConfigParam (5 stores). Field meanings UNKNOWN.";
        field {
            name = "word";
            desc = "32-bit table word.";
            sw = rw;
            hw = r;
        } word[31:0];
    } TBL_000 @ 0x0;

    reg {
        name = "Table word 0x4";
        desc = "Word 0x4 of the H.265 register table. PROVENANCE: PROVEN offset; PROVEN stored byte lanes 0123 (lane 0 = bits [7:0]); PROVEN cleared bit extents [9:6] [13:11] (lower bound of the fields); constants ORed in: 0x280, 0x400, 0x4000; written by UpdateLowerPowerCfg, UpdateRegConfigParam (5 stores). Field meanings UNKNOWN.";
        field {
            name = "word";
            desc = "32-bit table word.";
            sw = rw;
            hw = r;
        } word[31:0];
    } TBL_004 @ 0x4;

    reg {
        name = "Table word 0x8";
        desc = "Word 0x8 of the H.265 register table. PROVENANCE: PROVEN offset; PROVEN stored byte lanes 0123 (lane 0 = bits [7:0]); PROVEN cleared bit extents [14:14] [28:20] [30:30] (lower bound of the fields); constants ORed in: 0x4000, 0x3300000, 0x10000000; written by UpdateLowerPowerCfg, UpdateRegConfigParam (12 stores). Field meanings UNKNOWN.";
        field {
            name = "word";
            desc = "32-bit table word.";
            sw = rw;
            hw = r;
        } word[31:0];
    } TBL_008 @ 0x8;

    reg {
        name = "Table word 0xC";
        desc = "Word 0xC of the H.265 register table. PROVENANCE: PROVEN offset; PROVEN stored byte lanes 01 (lane 0 = bits [7:0]); PROVEN cleared bit extents none seen (lower bound of the fields); constants ORed in: none; written by UpdateLowerPowerCfg (1 stores). Field meanings UNKNOWN.";
        field {
            name = "word";
            desc = "32-bit table word.";
            sw = rw;
            hw = r;
        } word[31:0];
    } TBL_00C @ 0xC;

    reg {
        name = "Table word 0x10";
        desc = "Word 0x10 of the H.265 register table. PROVENANCE: PROVEN offset; PROVEN stored byte lanes 02 (lane 0 = bits [7:0]); PROVEN cleared bit extents [3:2] [6:5] [18:18] [21:20] (lower bound of the fields); constants ORed in: 0x13, 0xB0000; written by UpdateRegConfigParam (2 stores). Field meanings UNKNOWN.";
        field {
            name = "word";
            desc = "32-bit table word.";
            sw = rw;
            hw = r;
        } word[31:0];
    } TBL_010 @ 0x10;

    reg {
        name = "Table word 0x14";
        desc = "Word 0x14 of the H.265 register table. PROVENANCE: PROVEN offset; PROVEN stored byte lanes 0123 (lane 0 = bits [7:0]); PROVEN cleared bit extents none seen (lower bound of the fields); constants ORed in: 0x3; written by UpdateRegConfigParam (1 stores). Field meanings UNKNOWN.";
        field {
            name = "word";
            desc = "32-bit table word.";
            sw = rw;
            hw = r;
        } word[31:0];
    } TBL_014 @ 0x14;

    reg {
        name = "Table word 0x18";
        desc = "Word 0x18 of the H.265 register table. PROVENANCE: PROVEN offset; PROVEN stored byte lanes 012 (lane 0 = bits [7:0]); PROVEN cleared bit extents [8:5] [20:20] (lower bound of the fields); constants ORed in: 0x10, 0x200, 0x100000; written by UpdateRegConfigParam (5 stores). Field meanings UNKNOWN.";
        field {
            name = "word";
            desc = "32-bit table word.";
            sw = rw;
            hw = r;
        } word[31:0];
    } TBL_018 @ 0x18;

    reg {
        name = "Table word 0x1C";
        desc = "Word 0x1C of the H.265 register table. PROVENANCE: PROVEN offset; PROVEN stored byte lanes 01 (lane 0 = bits [7:0]); PROVEN cleared bit extents none seen (lower bound of the fields); constants ORed in: 0x5500; written by UpdateRegConfigParam (2 stores). Field meanings UNKNOWN.";
        field {
            name = "word";
            desc = "32-bit table word.";
            sw = rw;
            hw = r;
        } word[31:0];
    } TBL_01C @ 0x1C;

    reg {
        name = "Table word 0x20";
        desc = "Word 0x20 of the H.265 register table. PROVENANCE: PROVEN offset; PROVEN stored byte lanes 01 (lane 0 = bits [7:0]); PROVEN cleared bit extents [8:1] (lower bound of the fields); constants ORed in: none; written by UpdateRegConfigParam (2 stores). Field meanings UNKNOWN.";
        field {
            name = "word";
            desc = "32-bit table word.";
            sw = rw;
            hw = r;
        } word[31:0];
    } TBL_020 @ 0x20;

    reg {
        name = "Table word 0x24";
        desc = "Word 0x24 of the H.265 register table. PROVENANCE: PROVEN offset; PROVEN stored byte lanes 0123 (lane 0 = bits [7:0]); PROVEN cleared bit extents none seen (lower bound of the fields); constants ORed in: none; written by UpdateRegConfigParam (1 stores). Field meanings UNKNOWN.";
        field {
            name = "word";
            desc = "32-bit table word.";
            sw = rw;
            hw = r;
        } word[31:0];
    } TBL_024 @ 0x24;

    reg {
        name = "Table word 0x28";
        desc = "Word 0x28 of the H.265 register table. PROVENANCE: PROVEN offset; PROVEN stored byte lanes 0123 (lane 0 = bits [7:0]); PROVEN cleared bit extents none seen (lower bound of the fields); constants ORed in: none; written by UpdateRegConfigParam (1 stores). Field meanings UNKNOWN.";
        field {
            name = "word";
            desc = "32-bit table word.";
            sw = rw;
            hw = r;
        } word[31:0];
    } TBL_028 @ 0x28;

    reg {
        name = "Table word 0x2C";
        desc = "Word 0x2C of the H.265 register table. PROVENANCE: PROVEN offset; PROVEN stored byte lanes 0123 (lane 0 = bits [7:0]); PROVEN cleared bit extents none seen (lower bound of the fields); constants ORed in: none; written by UpdateRegConfigParam (1 stores). Field meanings UNKNOWN.";
        field {
            name = "word";
            desc = "32-bit table word.";
            sw = rw;
            hw = r;
        } word[31:0];
    } TBL_02C @ 0x2C;

    reg {
        name = "Table word 0x30";
        desc = "Word 0x30 of the H.265 register table. PROVENANCE: PROVEN offset; PROVEN stored byte lanes 0123 (lane 0 = bits [7:0]); PROVEN cleared bit extents none seen (lower bound of the fields); constants ORed in: none; written by UpdateRegConfigParam (1 stores). Field meanings UNKNOWN.";
        field {
            name = "word";
            desc = "32-bit table word.";
            sw = rw;
            hw = r;
        } word[31:0];
    } TBL_030 @ 0x30;

    reg {
        name = "Table word 0x34";
        desc = "Word 0x34 of the H.265 register table. PROVENANCE: PROVEN offset; PROVEN stored byte lanes 0123 (lane 0 = bits [7:0]); PROVEN cleared bit extents none seen (lower bound of the fields); constants ORed in: none; written by UpdateRegConfigParam (1 stores). Field meanings UNKNOWN.";
        field {
            name = "word";
            desc = "32-bit table word.";
            sw = rw;
            hw = r;
        } word[31:0];
    } TBL_034 @ 0x34;

    reg {
        name = "Table word 0x38";
        desc = "Word 0x38 of the H.265 register table. PROVENANCE: PROVEN offset; PROVEN stored byte lanes 0123 (lane 0 = bits [7:0]); PROVEN cleared bit extents none seen (lower bound of the fields); constants ORed in: none; written by InitRegConfigParam (1 stores). Field meanings UNKNOWN.";
        field {
            name = "word";
            desc = "32-bit table word.";
            sw = rw;
            hw = r;
        } word[31:0];
    } TBL_038 @ 0x38;

    reg {
        name = "Table word 0x3C";
        desc = "Word 0x3C of the H.265 register table. PROVENANCE: PROVEN offset; PROVEN stored byte lanes 0123 (lane 0 = bits [7:0]); PROVEN cleared bit extents none seen (lower bound of the fields); constants ORed in: none; written by InitRegConfigParam (1 stores). Field meanings UNKNOWN.";
        field {
            name = "word";
            desc = "32-bit table word.";
            sw = rw;
            hw = r;
        } word[31:0];
    } TBL_03C @ 0x3C;

    reg {
        name = "Table word 0x40";
        desc = "Word 0x40 of the H.265 register table. PROVENANCE: PROVEN offset; PROVEN stored byte lanes 0123 (lane 0 = bits [7:0]); PROVEN cleared bit extents none seen (lower bound of the fields); constants ORed in: none; written by InitRegConfigParam (1 stores). Field meanings UNKNOWN.";
        field {
            name = "word";
            desc = "32-bit table word.";
            sw = rw;
            hw = r;
        } word[31:0];
    } TBL_040 @ 0x40;

    reg {
        name = "Table word 0x44";
        desc = "Word 0x44 of the H.265 register table. PROVENANCE: PROVEN offset; PROVEN stored byte lanes 0123 (lane 0 = bits [7:0]); PROVEN cleared bit extents none seen (lower bound of the fields); constants ORed in: none; written by InitRegConfigParam (1 stores). Field meanings UNKNOWN.";
        field {
            name = "word";
            desc = "32-bit table word.";
            sw = rw;
            hw = r;
        } word[31:0];
    } TBL_044 @ 0x44;

    reg {
        name = "Table word 0x48";
        desc = "Word 0x48 of the H.265 register table. PROVENANCE: PROVEN offset; PROVEN stored byte lanes 01 (lane 0 = bits [7:0]); PROVEN cleared bit extents [1:0] [5:4] [12:12] (lower bound of the fields); constants ORed in: none; written by UpdateRegConfigParam (2 stores). Field meanings UNKNOWN.";
        field {
            name = "word";
            desc = "32-bit table word.";
            sw = rw;
            hw = r;
        } word[31:0];
    } TBL_048 @ 0x48;

    reg {
        name = "Table word 0x4C";
        desc = "Word 0x4C of the H.265 register table. PROVENANCE: PROVEN offset; PROVEN stored byte lanes 02 (lane 0 = bits [7:0]); PROVEN cleared bit extents [0:0] (lower bound of the fields); constants ORed in: 0x1; written by UpdateRegConfigParam (4 stores). Field meanings UNKNOWN.";
        field {
            name = "word";
            desc = "32-bit table word.";
            sw = rw;
            hw = r;
        } word[31:0];
    } TBL_04C @ 0x4C;

    reg {
        name = "Table word 0x50";
        desc = "Word 0x50 of the H.265 register table. PROVENANCE: PROVEN offset; PROVEN stored byte lanes 0123 (lane 0 = bits [7:0]); PROVEN cleared bit extents none seen (lower bound of the fields); constants ORed in: none; written by UpdateRegConfigParam (1 stores). Field meanings UNKNOWN.";
        field {
            name = "word";
            desc = "32-bit table word.";
            sw = rw;
            hw = r;
        } word[31:0];
    } TBL_050 @ 0x50;

    reg {
        name = "Table word 0x54";
        desc = "Word 0x54 of the H.265 register table. PROVENANCE: PROVEN offset; PROVEN stored byte lanes 0123 (lane 0 = bits [7:0]); PROVEN cleared bit extents none seen (lower bound of the fields); constants ORed in: none; written by UpdateRegConfigParam (1 stores). Field meanings UNKNOWN.";
        field {
            name = "word";
            desc = "32-bit table word.";
            sw = rw;
            hw = r;
        } word[31:0];
    } TBL_054 @ 0x54;

    reg {
        name = "Table word 0x58";
        desc = "Word 0x58 of the H.265 register table. PROVENANCE: PROVEN offset; PROVEN stored byte lanes 0123 (lane 0 = bits [7:0]); PROVEN cleared bit extents none seen (lower bound of the fields); constants ORed in: none; written by UpdateRegConfigParam (1 stores). Field meanings UNKNOWN.";
        field {
            name = "word";
            desc = "32-bit table word.";
            sw = rw;
            hw = r;
        } word[31:0];
    } TBL_058 @ 0x58;

    reg {
        name = "Table word 0x5C";
        desc = "Word 0x5C of the H.265 register table. PROVENANCE: PROVEN offset; PROVEN stored byte lanes 0123 (lane 0 = bits [7:0]); PROVEN cleared bit extents none seen (lower bound of the fields); constants ORed in: none; written by UpdateRegConfigParam (1 stores). Field meanings UNKNOWN.";
        field {
            name = "word";
            desc = "32-bit table word.";
            sw = rw;
            hw = r;
        } word[31:0];
    } TBL_05C @ 0x5C;

    reg {
        name = "Table word 0x60";
        desc = "Word 0x60 of the H.265 register table. PROVENANCE: PROVEN offset; PROVEN stored byte lanes 0123 (lane 0 = bits [7:0]); PROVEN cleared bit extents none seen (lower bound of the fields); constants ORed in: none; written by UpdateRegConfigParam (1 stores). Field meanings UNKNOWN.";
        field {
            name = "word";
            desc = "32-bit table word.";
            sw = rw;
            hw = r;
        } word[31:0];
    } TBL_060 @ 0x60;

    reg {
        name = "Table word 0x64";
        desc = "Word 0x64 of the H.265 register table. PROVENANCE: PROVEN offset; PROVEN stored byte lanes 0123 (lane 0 = bits [7:0]); PROVEN cleared bit extents none seen (lower bound of the fields); constants ORed in: none; written by UpdateRegConfigParam (1 stores). Field meanings UNKNOWN.";
        field {
            name = "word";
            desc = "32-bit table word.";
            sw = rw;
            hw = r;
        } word[31:0];
    } TBL_064 @ 0x64;

    reg {
        name = "Table word 0x68";
        desc = "Word 0x68 of the H.265 register table. PROVENANCE: PROVEN offset; PROVEN stored byte lanes 0123 (lane 0 = bits [7:0]); PROVEN cleared bit extents none seen (lower bound of the fields); constants ORed in: none; written by UpdateRegConfigParam (1 stores). Field meanings UNKNOWN.";
        field {
            name = "word";
            desc = "32-bit table word.";
            sw = rw;
            hw = r;
        } word[31:0];
    } TBL_068 @ 0x68;

    reg {
        name = "Table word 0x6C";
        desc = "Word 0x6C of the H.265 register table. PROVENANCE: PROVEN offset; PROVEN stored byte lanes 0123 (lane 0 = bits [7:0]); PROVEN cleared bit extents none seen (lower bound of the fields); constants ORed in: none; written by UpdateRegConfigParam (1 stores). Field meanings UNKNOWN.";
        field {
            name = "word";
            desc = "32-bit table word.";
            sw = rw;
            hw = r;
        } word[31:0];
    } TBL_06C @ 0x6C;

    reg {
        name = "Table word 0x70";
        desc = "Word 0x70 of the H.265 register table. PROVENANCE: PROVEN offset; PROVEN stored byte lanes 0123 (lane 0 = bits [7:0]); PROVEN cleared bit extents none seen (lower bound of the fields); constants ORed in: none; written by UpdateRegConfigParam (1 stores). Field meanings UNKNOWN.";
        field {
            name = "word";
            desc = "32-bit table word.";
            sw = rw;
            hw = r;
        } word[31:0];
    } TBL_070 @ 0x70;

    reg {
        name = "Table word 0x74";
        desc = "Word 0x74 of the H.265 register table. PROVENANCE: PROVEN offset; PROVEN stored byte lanes 0123 (lane 0 = bits [7:0]); PROVEN cleared bit extents none seen (lower bound of the fields); constants ORed in: none; written by UpdateRegConfigParam (1 stores). Field meanings UNKNOWN.";
        field {
            name = "word";
            desc = "32-bit table word.";
            sw = rw;
            hw = r;
        } word[31:0];
    } TBL_074 @ 0x74;

    reg {
        name = "Table word 0x78";
        desc = "Word 0x78 of the H.265 register table. PROVENANCE: PROVEN offset; PROVEN stored byte lanes 0 (lane 0 = bits [7:0]); PROVEN cleared bit extents [0:0] (lower bound of the fields); constants ORed in: none; written by UpdateRegConfigParam (1 stores). Field meanings UNKNOWN.";
        field {
            name = "word";
            desc = "32-bit table word.";
            sw = rw;
            hw = r;
        } word[31:0];
    } TBL_078 @ 0x78;

    reg {
        name = "Table word 0x7C";
        desc = "Word 0x7C of the H.265 register table. PROVENANCE: PROVEN offset; PROVEN stored byte lanes 0 (lane 0 = bits [7:0]); PROVEN cleared bit extents [7:2] (lower bound of the fields); constants ORed in: 0x2, 0x80; written by UpdateRegConfigParam (12 stores). Field meanings UNKNOWN.";
        field {
            name = "word";
            desc = "32-bit table word.";
            sw = rw;
            hw = r;
        } word[31:0];
    } TBL_07C @ 0x7C;

    reg {
        name = "Table word 0x80";
        desc = "Word 0x80 of the H.265 register table. PROVENANCE: PROVEN offset; PROVEN stored byte lanes 0123 (lane 0 = bits [7:0]); PROVEN cleared bit extents none seen (lower bound of the fields); constants ORed in: none; written by UpdateRegConfigParam (2 stores). Field meanings UNKNOWN.";
        field {
            name = "word";
            desc = "32-bit table word.";
            sw = rw;
            hw = r;
        } word[31:0];
    } TBL_080 @ 0x80;

    reg {
        name = "Table word 0x84";
        desc = "Word 0x84 of the H.265 register table. PROVENANCE: PROVEN offset; PROVEN stored byte lanes 0123 (lane 0 = bits [7:0]); PROVEN cleared bit extents none seen (lower bound of the fields); constants ORed in: none; written by UpdateRegConfigParam (1 stores). Field meanings UNKNOWN.";
        field {
            name = "word";
            desc = "32-bit table word.";
            sw = rw;
            hw = r;
        } word[31:0];
    } TBL_084 @ 0x84;

    reg {
        name = "Table word 0x88";
        desc = "Word 0x88 of the H.265 register table. PROVENANCE: PROVEN offset; PROVEN stored byte lanes 0123 (lane 0 = bits [7:0]); PROVEN cleared bit extents none seen (lower bound of the fields); constants ORed in: none; written by UpdateRegConfigParam (1 stores). Field meanings UNKNOWN.";
        field {
            name = "word";
            desc = "32-bit table word.";
            sw = rw;
            hw = r;
        } word[31:0];
    } TBL_088 @ 0x88;

    reg {
        name = "Table word 0x90";
        desc = "Word 0x90 of the H.265 register table. PROVENANCE: PROVEN offset; PROVEN stored byte lanes 0123 (lane 0 = bits [7:0]); PROVEN cleared bit extents none seen (lower bound of the fields); constants ORed in: none; written by UpdateRegConfigParam (2 stores). Field meanings UNKNOWN.";
        field {
            name = "word";
            desc = "32-bit table word.";
            sw = rw;
            hw = r;
        } word[31:0];
    } TBL_090 @ 0x90;

    reg {
        name = "Table word 0x94";
        desc = "Word 0x94 of the H.265 register table. PROVENANCE: PROVEN offset; PROVEN stored byte lanes 0123 (lane 0 = bits [7:0]); PROVEN cleared bit extents none seen (lower bound of the fields); constants ORed in: none; written by UpdateRegConfigParam (1 stores). Field meanings UNKNOWN.";
        field {
            name = "word";
            desc = "32-bit table word.";
            sw = rw;
            hw = r;
        } word[31:0];
    } TBL_094 @ 0x94;

    reg {
        name = "Table word 0x98";
        desc = "Word 0x98 of the H.265 register table. PROVENANCE: PROVEN offset; PROVEN stored byte lanes 0123 (lane 0 = bits [7:0]); PROVEN cleared bit extents none seen (lower bound of the fields); constants ORed in: none; written by UpdateRegConfigParam (2 stores). Field meanings UNKNOWN.";
        field {
            name = "word";
            desc = "32-bit table word.";
            sw = rw;
            hw = r;
        } word[31:0];
    } TBL_098 @ 0x98;

    reg {
        name = "Table word 0x9C";
        desc = "Word 0x9C of the H.265 register table. PROVENANCE: PROVEN offset; PROVEN stored byte lanes 0123 (lane 0 = bits [7:0]); PROVEN cleared bit extents none seen (lower bound of the fields); constants ORed in: none; written by UpdateRegConfigParam (1 stores). Field meanings UNKNOWN.";
        field {
            name = "word";
            desc = "32-bit table word.";
            sw = rw;
            hw = r;
        } word[31:0];
    } TBL_09C @ 0x9C;

    reg {
        name = "Table word 0xA0";
        desc = "Word 0xA0 of the H.265 register table. PROVENANCE: PROVEN offset; PROVEN stored byte lanes 0123 (lane 0 = bits [7:0]); PROVEN cleared bit extents none seen (lower bound of the fields); constants ORed in: none; written by UpdateRegConfigParam (1 stores). Field meanings UNKNOWN.";
        field {
            name = "word";
            desc = "32-bit table word.";
            sw = rw;
            hw = r;
        } word[31:0];
    } TBL_0A0 @ 0xA0;

    reg {
        name = "Table word 0xA4";
        desc = "Word 0xA4 of the H.265 register table. PROVENANCE: PROVEN offset; PROVEN stored byte lanes 0123 (lane 0 = bits [7:0]); PROVEN cleared bit extents none seen (lower bound of the fields); constants ORed in: none; written by UpdateRegConfigParam (1 stores). Field meanings UNKNOWN.";
        field {
            name = "word";
            desc = "32-bit table word.";
            sw = rw;
            hw = r;
        } word[31:0];
    } TBL_0A4 @ 0xA4;

    reg {
        name = "Table word 0xA8";
        desc = "Word 0xA8 of the H.265 register table. PROVENANCE: PROVEN offset; PROVEN stored byte lanes 0123 (lane 0 = bits [7:0]); PROVEN cleared bit extents none seen (lower bound of the fields); constants ORed in: none; written by UpdateRegConfigParam (2 stores). Field meanings UNKNOWN.";
        field {
            name = "word";
            desc = "32-bit table word.";
            sw = rw;
            hw = r;
        } word[31:0];
    } TBL_0A8 @ 0xA8;

    reg {
        name = "Table word 0xAC";
        desc = "Word 0xAC of the H.265 register table. PROVENANCE: PROVEN offset; PROVEN stored byte lanes 0123 (lane 0 = bits [7:0]); PROVEN cleared bit extents none seen (lower bound of the fields); constants ORed in: none; written by UpdateRegConfigParam (1 stores). Field meanings UNKNOWN.";
        field {
            name = "word";
            desc = "32-bit table word.";
            sw = rw;
            hw = r;
        } word[31:0];
    } TBL_0AC @ 0xAC;

    reg {
        name = "Table word 0xB0";
        desc = "Word 0xB0 of the H.265 register table. PROVENANCE: PROVEN offset; PROVEN stored byte lanes 0123 (lane 0 = bits [7:0]); PROVEN cleared bit extents none seen (lower bound of the fields); constants ORed in: none; written by UpdateRegConfigParam (1 stores). Field meanings UNKNOWN.";
        field {
            name = "word";
            desc = "32-bit table word.";
            sw = rw;
            hw = r;
        } word[31:0];
    } TBL_0B0 @ 0xB0;

    reg {
        name = "Table word 0xB4";
        desc = "Word 0xB4 of the H.265 register table. PROVENANCE: PROVEN offset; PROVEN stored byte lanes 01 (lane 0 = bits [7:0]); PROVEN cleared bit extents none seen (lower bound of the fields); constants ORed in: none; written by UpdateRegConfigParam (1 stores). Field meanings UNKNOWN.";
        field {
            name = "word";
            desc = "32-bit table word.";
            sw = rw;
            hw = r;
        } word[31:0];
    } TBL_0B4 @ 0xB4;

    reg {
        name = "Table word 0xB8";
        desc = "Word 0xB8 of the H.265 register table. PROVENANCE: PROVEN offset; PROVEN stored byte lanes 0123 (lane 0 = bits [7:0]); PROVEN cleared bit extents none seen (lower bound of the fields); constants ORed in: none; written by UpdateRegConfigParam (2 stores). Field meanings UNKNOWN.";
        field {
            name = "word";
            desc = "32-bit table word.";
            sw = rw;
            hw = r;
        } word[31:0];
    } TBL_0B8 @ 0xB8;

    reg {
        name = "Table word 0xBC";
        desc = "Word 0xBC of the H.265 register table. PROVENANCE: PROVEN offset; PROVEN stored byte lanes 0123 (lane 0 = bits [7:0]); PROVEN cleared bit extents none seen (lower bound of the fields); constants ORed in: none; written by UpdateRegConfigParam (2 stores). Field meanings UNKNOWN.";
        field {
            name = "word";
            desc = "32-bit table word.";
            sw = rw;
            hw = r;
        } word[31:0];
    } TBL_0BC @ 0xBC;

    reg {
        name = "Table word 0xC0";
        desc = "Word 0xC0 of the H.265 register table. PROVENANCE: PROVEN offset; PROVEN stored byte lanes 0123 (lane 0 = bits [7:0]); PROVEN cleared bit extents none seen (lower bound of the fields); constants ORed in: none; written by UpdateRegConfigParam (2 stores). Field meanings UNKNOWN.";
        field {
            name = "word";
            desc = "32-bit table word.";
            sw = rw;
            hw = r;
        } word[31:0];
    } TBL_0C0 @ 0xC0;

    reg {
        name = "Table word 0xC4";
        desc = "Word 0xC4 of the H.265 register table. PROVENANCE: PROVEN offset; PROVEN stored byte lanes 0123 (lane 0 = bits [7:0]); PROVEN cleared bit extents none seen (lower bound of the fields); constants ORed in: none; written by UpdateRegConfigParam (2 stores). Field meanings UNKNOWN.";
        field {
            name = "word";
            desc = "32-bit table word.";
            sw = rw;
            hw = r;
        } word[31:0];
    } TBL_0C4 @ 0xC4;

    reg {
        name = "Table word 0xC8";
        desc = "Word 0xC8 of the H.265 register table. PROVENANCE: PROVEN offset; PROVEN stored byte lanes 0123 (lane 0 = bits [7:0]); PROVEN cleared bit extents none seen (lower bound of the fields); constants ORed in: none; written by UpdateRegConfigParam (2 stores). Field meanings UNKNOWN.";
        field {
            name = "word";
            desc = "32-bit table word.";
            sw = rw;
            hw = r;
        } word[31:0];
    } TBL_0C8 @ 0xC8;

    reg {
        name = "Table word 0xCC";
        desc = "Word 0xCC of the H.265 register table. PROVENANCE: PROVEN offset; PROVEN stored byte lanes 0123 (lane 0 = bits [7:0]); PROVEN cleared bit extents none seen (lower bound of the fields); constants ORed in: none; written by UpdateRegConfigParam (3 stores). Field meanings UNKNOWN.";
        field {
            name = "word";
            desc = "32-bit table word.";
            sw = rw;
            hw = r;
        } word[31:0];
    } TBL_0CC @ 0xCC;

    reg {
        name = "Table word 0xD0";
        desc = "Word 0xD0 of the H.265 register table. PROVENANCE: PROVEN offset; PROVEN stored byte lanes 0123 (lane 0 = bits [7:0]); PROVEN cleared bit extents none seen (lower bound of the fields); constants ORed in: none; written by UpdateRegConfigParam (1 stores). Field meanings UNKNOWN.";
        field {
            name = "word";
            desc = "32-bit table word.";
            sw = rw;
            hw = r;
        } word[31:0];
    } TBL_0D0 @ 0xD0;

    reg {
        name = "Table word 0xD4";
        desc = "Word 0xD4 of the H.265 register table. PROVENANCE: PROVEN offset; PROVEN stored byte lanes 0123 (lane 0 = bits [7:0]); PROVEN cleared bit extents none seen (lower bound of the fields); constants ORed in: none; written by UpdateRegConfigParam (1 stores). Field meanings UNKNOWN.";
        field {
            name = "word";
            desc = "32-bit table word.";
            sw = rw;
            hw = r;
        } word[31:0];
    } TBL_0D4 @ 0xD4;

    reg {
        name = "Table word 0xD8";
        desc = "Word 0xD8 of the H.265 register table. PROVENANCE: PROVEN offset; PROVEN stored byte lanes 0123 (lane 0 = bits [7:0]); PROVEN cleared bit extents none seen (lower bound of the fields); constants ORed in: none; written by UpdateRegConfigParam (1 stores). Field meanings UNKNOWN.";
        field {
            name = "word";
            desc = "32-bit table word.";
            sw = rw;
            hw = r;
        } word[31:0];
    } TBL_0D8 @ 0xD8;

    reg {
        name = "Table word 0xDC";
        desc = "Word 0xDC of the H.265 register table. PROVENANCE: PROVEN offset; PROVEN stored byte lanes 0123 (lane 0 = bits [7:0]); PROVEN cleared bit extents none seen (lower bound of the fields); constants ORed in: none; written by UpdateRegConfigParam (6 stores). Field meanings UNKNOWN.";
        field {
            name = "word";
            desc = "32-bit table word.";
            sw = rw;
            hw = r;
        } word[31:0];
    } TBL_0DC @ 0xDC;

    reg {
        name = "Table word 0xE4";
        desc = "Word 0xE4 of the H.265 register table. PROVENANCE: PROVEN offset; PROVEN stored byte lanes 0123 (lane 0 = bits [7:0]); PROVEN cleared bit extents none seen (lower bound of the fields); constants ORed in: none; written by UpdateRegConfigParam (4 stores). Field meanings UNKNOWN.";
        field {
            name = "word";
            desc = "32-bit table word.";
            sw = rw;
            hw = r;
        } word[31:0];
    } TBL_0E4 @ 0xE4;

    reg {
        name = "Table word 0xE8";
        desc = "Word 0xE8 of the H.265 register table. PROVENANCE: PROVEN offset; PROVEN stored byte lanes 0123 (lane 0 = bits [7:0]); PROVEN cleared bit extents none seen (lower bound of the fields); constants ORed in: none; written by UpdateRegConfigParam (2 stores). Field meanings UNKNOWN.";
        field {
            name = "word";
            desc = "32-bit table word.";
            sw = rw;
            hw = r;
        } word[31:0];
    } TBL_0E8 @ 0xE8;

    reg {
        name = "Table word 0xEC";
        desc = "Word 0xEC of the H.265 register table. PROVENANCE: PROVEN offset; PROVEN stored byte lanes 0123 (lane 0 = bits [7:0]); PROVEN cleared bit extents none seen (lower bound of the fields); constants ORed in: none; written by UpdateRegConfigParam (2 stores). Field meanings UNKNOWN.";
        field {
            name = "word";
            desc = "32-bit table word.";
            sw = rw;
            hw = r;
        } word[31:0];
    } TBL_0EC @ 0xEC;

    reg {
        name = "Table word 0xF0";
        desc = "Word 0xF0 of the H.265 register table. PROVENANCE: PROVEN offset; PROVEN stored byte lanes 0123 (lane 0 = bits [7:0]); PROVEN cleared bit extents none seen (lower bound of the fields); constants ORed in: none; written by UpdateRegConfigParam (2 stores). Field meanings UNKNOWN.";
        field {
            name = "word";
            desc = "32-bit table word.";
            sw = rw;
            hw = r;
        } word[31:0];
    } TBL_0F0 @ 0xF0;

    reg {
        name = "Table word 0xF4";
        desc = "Word 0xF4 of the H.265 register table. PROVENANCE: PROVEN offset; PROVEN stored byte lanes 0123 (lane 0 = bits [7:0]); PROVEN cleared bit extents none seen (lower bound of the fields); constants ORed in: none; written by UpdateRegConfigParam (2 stores). Field meanings UNKNOWN.";
        field {
            name = "word";
            desc = "32-bit table word.";
            sw = rw;
            hw = r;
        } word[31:0];
    } TBL_0F4 @ 0xF4;

    reg {
        name = "Table word 0xF8";
        desc = "Word 0xF8 of the H.265 register table. PROVENANCE: PROVEN offset; PROVEN stored byte lanes 0123 (lane 0 = bits [7:0]); PROVEN cleared bit extents none seen (lower bound of the fields); constants ORed in: none; written by UpdateRegConfigParam (3 stores). Field meanings UNKNOWN.";
        field {
            name = "word";
            desc = "32-bit table word.";
            sw = rw;
            hw = r;
        } word[31:0];
    } TBL_0F8 @ 0xF8;

    reg {
        name = "Table word 0xFC";
        desc = "Word 0xFC of the H.265 register table. PROVENANCE: PROVEN offset; PROVEN stored byte lanes 0123 (lane 0 = bits [7:0]); PROVEN cleared bit extents none seen (lower bound of the fields); constants ORed in: none; written by UpdateRegConfigParam (1 stores). Field meanings UNKNOWN.";
        field {
            name = "word";
            desc = "32-bit table word.";
            sw = rw;
            hw = r;
        } word[31:0];
    } TBL_0FC @ 0xFC;

    reg {
        name = "Table word 0x100";
        desc = "Word 0x100 of the H.265 register table. PROVENANCE: PROVEN offset; PROVEN stored byte lanes 1 (lane 0 = bits [7:0]); PROVEN cleared bit extents [10:8] (lower bound of the fields); constants ORed in: none; written by UpdateRegConfigParam (1 stores). Field meanings UNKNOWN.";
        field {
            name = "word";
            desc = "32-bit table word.";
            sw = rw;
            hw = r;
        } word[31:0];
    } TBL_100 @ 0x100;

    reg {
        name = "Table word 0x10C";
        desc = "Word 0x10C of the H.265 register table. PROVENANCE: PROVEN offset; PROVEN stored byte lanes 0123 (lane 0 = bits [7:0]); PROVEN cleared bit extents none seen (lower bound of the fields); constants ORed in: none; written by UpdateRegConfigParam (1 stores). Field meanings UNKNOWN.";
        field {
            name = "word";
            desc = "32-bit table word.";
            sw = rw;
            hw = r;
        } word[31:0];
    } TBL_10C @ 0x10C;

    reg {
        name = "Table word 0x110";
        desc = "Word 0x110 of the H.265 register table. PROVENANCE: PROVEN offset; PROVEN stored byte lanes 0123 (lane 0 = bits [7:0]); PROVEN cleared bit extents none seen (lower bound of the fields); constants ORed in: none; written by UpdateRegConfigParam (1 stores). Field meanings UNKNOWN.";
        field {
            name = "word";
            desc = "32-bit table word.";
            sw = rw;
            hw = r;
        } word[31:0];
    } TBL_110 @ 0x110;

    reg {
        name = "Table word 0x114";
        desc = "Word 0x114 of the H.265 register table. PROVENANCE: PROVEN offset; PROVEN stored byte lanes 0123 (lane 0 = bits [7:0]); PROVEN cleared bit extents none seen (lower bound of the fields); constants ORed in: none; written by UpdateRegConfigParam (1 stores). Field meanings UNKNOWN.";
        field {
            name = "word";
            desc = "32-bit table word.";
            sw = rw;
            hw = r;
        } word[31:0];
    } TBL_114 @ 0x114;

    reg {
        name = "Table word 0x118";
        desc = "Word 0x118 of the H.265 register table. PROVENANCE: PROVEN offset; PROVEN stored byte lanes 0123 (lane 0 = bits [7:0]); PROVEN cleared bit extents none seen (lower bound of the fields); constants ORed in: none; written by UpdateRegConfigParam (1 stores). Field meanings UNKNOWN.";
        field {
            name = "word";
            desc = "32-bit table word.";
            sw = rw;
            hw = r;
        } word[31:0];
    } TBL_118 @ 0x118;

    reg {
        name = "Table word 0x11C";
        desc = "Word 0x11C of the H.265 register table. PROVENANCE: PROVEN offset; PROVEN stored byte lanes 0123 (lane 0 = bits [7:0]); PROVEN cleared bit extents none seen (lower bound of the fields); constants ORed in: none; written by UpdateRegConfigParam (1 stores). Field meanings UNKNOWN.";
        field {
            name = "word";
            desc = "32-bit table word.";
            sw = rw;
            hw = r;
        } word[31:0];
    } TBL_11C @ 0x11C;

    reg {
        name = "Table word 0x120";
        desc = "Word 0x120 of the H.265 register table. PROVENANCE: PROVEN offset; PROVEN stored byte lanes 0123 (lane 0 = bits [7:0]); PROVEN cleared bit extents none seen (lower bound of the fields); constants ORed in: none; written by UpdateRegConfigParam (1 stores). Field meanings UNKNOWN.";
        field {
            name = "word";
            desc = "32-bit table word.";
            sw = rw;
            hw = r;
        } word[31:0];
    } TBL_120 @ 0x120;

    reg {
        name = "Table word 0x124";
        desc = "Word 0x124 of the H.265 register table. PROVENANCE: PROVEN offset; PROVEN stored byte lanes 0123 (lane 0 = bits [7:0]); PROVEN cleared bit extents none seen (lower bound of the fields); constants ORed in: none; written by UpdateRegConfigParam (1 stores). Field meanings UNKNOWN.";
        field {
            name = "word";
            desc = "32-bit table word.";
            sw = rw;
            hw = r;
        } word[31:0];
    } TBL_124 @ 0x124;

    reg {
        name = "Table word 0x128";
        desc = "Word 0x128 of the H.265 register table. PROVENANCE: PROVEN offset; PROVEN stored byte lanes 0123 (lane 0 = bits [7:0]); PROVEN cleared bit extents none seen (lower bound of the fields); constants ORed in: none; written by UpdateRegConfigParam (1 stores). Field meanings UNKNOWN.";
        field {
            name = "word";
            desc = "32-bit table word.";
            sw = rw;
            hw = r;
        } word[31:0];
    } TBL_128 @ 0x128;

    reg {
        name = "Table word 0x134";
        desc = "Word 0x134 of the H.265 register table. PROVENANCE: PROVEN offset; PROVEN stored byte lanes 0123 (lane 0 = bits [7:0]); PROVEN cleared bit extents none seen (lower bound of the fields); constants ORed in: none; written by UpdateRegConfigParam (1 stores). Field meanings UNKNOWN.";
        field {
            name = "word";
            desc = "32-bit table word.";
            sw = rw;
            hw = r;
        } word[31:0];
    } TBL_134 @ 0x134;

    reg {
        name = "Table word 0x138";
        desc = "Word 0x138 of the H.265 register table. PROVENANCE: PROVEN offset; PROVEN stored byte lanes 0123 (lane 0 = bits [7:0]); PROVEN cleared bit extents none seen (lower bound of the fields); constants ORed in: none; written by UpdateRegConfigParam (1 stores). Field meanings UNKNOWN.";
        field {
            name = "word";
            desc = "32-bit table word.";
            sw = rw;
            hw = r;
        } word[31:0];
    } TBL_138 @ 0x138;

    reg {
        name = "Table word 0x13C";
        desc = "Word 0x13C of the H.265 register table. PROVENANCE: PROVEN offset; PROVEN stored byte lanes 0123 (lane 0 = bits [7:0]); PROVEN cleared bit extents none seen (lower bound of the fields); constants ORed in: none; written by UpdateRegConfigParam (1 stores). Field meanings UNKNOWN.";
        field {
            name = "word";
            desc = "32-bit table word.";
            sw = rw;
            hw = r;
        } word[31:0];
    } TBL_13C @ 0x13C;

    reg {
        name = "Table word 0x140";
        desc = "Word 0x140 of the H.265 register table. PROVENANCE: PROVEN offset; PROVEN stored byte lanes 0123 (lane 0 = bits [7:0]); PROVEN cleared bit extents none seen (lower bound of the fields); constants ORed in: none; written by UpdateRegConfigParam (1 stores). Field meanings UNKNOWN.";
        field {
            name = "word";
            desc = "32-bit table word.";
            sw = rw;
            hw = r;
        } word[31:0];
    } TBL_140 @ 0x140;

    reg {
        name = "Table word 0x144";
        desc = "Word 0x144 of the H.265 register table. PROVENANCE: PROVEN offset; PROVEN stored byte lanes 0123 (lane 0 = bits [7:0]); PROVEN cleared bit extents none seen (lower bound of the fields); constants ORed in: none; written by UpdateRegConfigParam (1 stores). Field meanings UNKNOWN.";
        field {
            name = "word";
            desc = "32-bit table word.";
            sw = rw;
            hw = r;
        } word[31:0];
    } TBL_144 @ 0x144;

    reg {
        name = "Table word 0x148";
        desc = "Word 0x148 of the H.265 register table. PROVENANCE: PROVEN offset; PROVEN stored byte lanes 0123 (lane 0 = bits [7:0]); PROVEN cleared bit extents none seen (lower bound of the fields); constants ORed in: none; written by UpdateRegConfigParam (1 stores). Field meanings UNKNOWN.";
        field {
            name = "word";
            desc = "32-bit table word.";
            sw = rw;
            hw = r;
        } word[31:0];
    } TBL_148 @ 0x148;

    reg {
        name = "Table word 0x14C";
        desc = "Word 0x14C of the H.265 register table. PROVENANCE: PROVEN offset; PROVEN stored byte lanes 0123 (lane 0 = bits [7:0]); PROVEN cleared bit extents none seen (lower bound of the fields); constants ORed in: none; written by UpdateRegConfigParam (1 stores). Field meanings UNKNOWN.";
        field {
            name = "word";
            desc = "32-bit table word.";
            sw = rw;
            hw = r;
        } word[31:0];
    } TBL_14C @ 0x14C;

    reg {
        name = "Table word 0x150";
        desc = "Word 0x150 of the H.265 register table. PROVENANCE: PROVEN offset; PROVEN stored byte lanes 0123 (lane 0 = bits [7:0]); PROVEN cleared bit extents none seen (lower bound of the fields); constants ORed in: none; written by UpdateRegConfigParam (1 stores). Field meanings UNKNOWN.";
        field {
            name = "word";
            desc = "32-bit table word.";
            sw = rw;
            hw = r;
        } word[31:0];
    } TBL_150 @ 0x150;

    reg {
        name = "Table word 0x204";
        desc = "Word 0x204 of the H.265 register table. PROVENANCE: PROVEN offset; PROVEN stored byte lanes 2 (lane 0 = bits [7:0]); PROVEN cleared bit extents [17:16] (lower bound of the fields); constants ORed in: none; written by UpdateRegConfigParam (2 stores). Field meanings UNKNOWN.";
        field {
            name = "word";
            desc = "32-bit table word.";
            sw = rw;
            hw = r;
        } word[31:0];
    } TBL_204 @ 0x204;

    reg {
        name = "Table word 0x214";
        desc = "Word 0x214 of the H.265 register table. PROVENANCE: PROVEN offset; PROVEN stored byte lanes 0 (lane 0 = bits [7:0]); PROVEN cleared bit extents [1:0] (lower bound of the fields); constants ORed in: none; written by UpdateLowerPowerCfg (2 stores). Field meanings UNKNOWN.";
        field {
            name = "word";
            desc = "32-bit table word.";
            sw = rw;
            hw = r;
        } word[31:0];
    } TBL_214 @ 0x214;

    reg {
        name = "Table word 0x21C";
        desc = "Word 0x21C of the H.265 register table. PROVENANCE: PROVEN offset; PROVEN stored byte lanes 23 (lane 0 = bits [7:0]); PROVEN cleared bit extents none seen (lower bound of the fields); constants ORed in: none; written by UpdateLowerPowerCfg (2 stores). Field meanings UNKNOWN.";
        field {
            name = "word";
            desc = "32-bit table word.";
            sw = rw;
            hw = r;
        } word[31:0];
    } TBL_21C @ 0x21C;

    reg {
        name = "Table word 0x220";
        desc = "Word 0x220 of the H.265 register table. PROVENANCE: PROVEN offset; PROVEN stored byte lanes 0123 (lane 0 = bits [7:0]); PROVEN cleared bit extents none seen (lower bound of the fields); constants ORed in: none; written by UpdateLowerPowerCfg (4 stores). Field meanings UNKNOWN.";
        field {
            name = "word";
            desc = "32-bit table word.";
            sw = rw;
            hw = r;
        } word[31:0];
    } TBL_220 @ 0x220;

    reg {
        name = "Table word 0x224";
        desc = "Word 0x224 of the H.265 register table. PROVENANCE: PROVEN offset; PROVEN stored byte lanes 0 (lane 0 = bits [7:0]); PROVEN cleared bit extents none seen (lower bound of the fields); constants ORed in: 0x20; written by UpdateRegConfigParam (1 stores). Field meanings UNKNOWN.";
        field {
            name = "word";
            desc = "32-bit table word.";
            sw = rw;
            hw = r;
        } word[31:0];
    } TBL_224 @ 0x224;

    reg {
        name = "Table word 0x240";
        desc = "Word 0x240 of the H.265 register table. PROVENANCE: PROVEN offset; PROVEN stored byte lanes 0 (lane 0 = bits [7:0]); PROVEN cleared bit extents [0:0] (lower bound of the fields); constants ORed in: none; written by UpdateRegConfigParam (1 stores). Field meanings UNKNOWN.";
        field {
            name = "word";
            desc = "32-bit table word.";
            sw = rw;
            hw = r;
        } word[31:0];
    } TBL_240 @ 0x240;

    reg {
        name = "Table word 0x400";
        desc = "Word 0x400 of the H.265 register table. PROVENANCE: PROVEN offset; PROVEN stored byte lanes 2 (lane 0 = bits [7:0]); PROVEN cleared bit extents none seen (lower bound of the fields); constants ORed in: 0xFF0000; written by UpdateOsdRoiConfigParam (3 stores). Field meanings UNKNOWN.";
        field {
            name = "word";
            desc = "32-bit table word.";
            sw = rw;
            hw = r;
        } word[31:0];
    } TBL_400 @ 0x400;

    reg {
        name = "Table word 0x7E0";
        desc = "Word 0x7E0 of the H.265 register table. PROVENANCE: PROVEN offset; PROVEN stored byte lanes 0123 (lane 0 = bits [7:0]); PROVEN cleared bit extents none seen (lower bound of the fields); constants ORed in: none; written by InitRegConfigParam (1 stores). Field meanings UNKNOWN.";
        field {
            name = "word";
            desc = "32-bit table word.";
            sw = rw;
            hw = r;
        } word[31:0];
    } TBL_7E0 @ 0x7E0;

    reg {
        name = "Table word 0x7E4";
        desc = "Word 0x7E4 of the H.265 register table. PROVENANCE: PROVEN offset; PROVEN stored byte lanes 0123 (lane 0 = bits [7:0]); PROVEN cleared bit extents none seen (lower bound of the fields); constants ORed in: none; written by InitRegConfigParam (1 stores). Field meanings UNKNOWN.";
        field {
            name = "word";
            desc = "32-bit table word.";
            sw = rw;
            hw = r;
        } word[31:0];
    } TBL_7E4 @ 0x7E4;

    reg {
        name = "Table word 0x7E8";
        desc = "Word 0x7E8 of the H.265 register table. PROVENANCE: PROVEN offset; PROVEN stored byte lanes 0123 (lane 0 = bits [7:0]); PROVEN cleared bit extents [19:10] (lower bound of the fields); constants ORed in: none; written by UpdateLowerPowerCfg (1 stores). Field meanings UNKNOWN.";
        field {
            name = "word";
            desc = "32-bit table word.";
            sw = rw;
            hw = r;
        } word[31:0];
    } TBL_7E8 @ 0x7E8;

    reg {
        name = "Table word 0x810";
        desc = "Word 0x810 of the H.265 register table. PROVENANCE: PROVEN offset; PROVEN stored byte lanes 2 (lane 0 = bits [7:0]); PROVEN cleared bit extents [16:16] (lower bound of the fields); constants ORed in: none; written by UpdateLowerPowerCfg (1 stores). Field meanings UNKNOWN.";
        field {
            name = "word";
            desc = "32-bit table word.";
            sw = rw;
            hw = r;
        } word[31:0];
    } TBL_810 @ 0x810;

    reg {
        name = "Table word 0x814";
        desc = "Word 0x814 of the H.265 register table. PROVENANCE: PROVEN offset; PROVEN stored byte lanes 0123 (lane 0 = bits [7:0]); PROVEN cleared bit extents [17:9] (lower bound of the fields); constants ORed in: none; written by UpdateLowerPowerCfg (1 stores). Field meanings UNKNOWN.";
        field {
            name = "word";
            desc = "32-bit table word.";
            sw = rw;
            hw = r;
        } word[31:0];
    } TBL_814 @ 0x814;

    reg {
        name = "Table word 0x818";
        desc = "Word 0x818 of the H.265 register table. PROVENANCE: PROVEN offset; PROVEN stored byte lanes 012 (lane 0 = bits [7:0]); PROVEN cleared bit extents none seen (lower bound of the fields); constants ORed in: none; written by UpdateLowerPowerCfg (3 stores). Field meanings UNKNOWN.";
        field {
            name = "word";
            desc = "32-bit table word.";
            sw = rw;
            hw = r;
        } word[31:0];
    } TBL_818 @ 0x818;

    reg {
        name = "Table word 0x81C";
        desc = "Word 0x81C of the H.265 register table. PROVENANCE: PROVEN offset; PROVEN stored byte lanes 0123 (lane 0 = bits [7:0]); PROVEN cleared bit extents [13:0] [15:15] [19:17] (lower bound of the fields); constants ORed in: 0x14000; written by InitRegConfigParam, UpdateLowerPowerCfg (4 stores). Field meanings UNKNOWN.";
        field {
            name = "word";
            desc = "32-bit table word.";
            sw = rw;
            hw = r;
        } word[31:0];
    } TBL_81C @ 0x81C;

    reg {
        name = "Table word 0x820";
        desc = "Word 0x820 of the H.265 register table. PROVENANCE: PROVEN offset; PROVEN stored byte lanes 23 (lane 0 = bits [7:0]); PROVEN cleared bit extents none seen (lower bound of the fields); constants ORed in: none; written by InitRegConfigParam (2 stores). Field meanings UNKNOWN.";
        field {
            name = "word";
            desc = "32-bit table word.";
            sw = rw;
            hw = r;
        } word[31:0];
    } TBL_820 @ 0x820;

    reg {
        name = "Table word 0x824";
        desc = "Word 0x824 of the H.265 register table. PROVENANCE: PROVEN offset; PROVEN stored byte lanes 0123 (lane 0 = bits [7:0]); PROVEN cleared bit extents none seen (lower bound of the fields); constants ORed in: none; written by InitRegConfigParam (1 stores). Field meanings UNKNOWN.";
        field {
            name = "word";
            desc = "32-bit table word.";
            sw = rw;
            hw = r;
        } word[31:0];
    } TBL_824 @ 0x824;

    reg {
        name = "Table word 0x830";
        desc = "Word 0x830 of the H.265 register table. PROVENANCE: PROVEN offset; PROVEN stored byte lanes 0123 (lane 0 = bits [7:0]); PROVEN cleared bit extents none seen (lower bound of the fields); constants ORed in: none; written by InitRegConfigParam (1 stores). Field meanings UNKNOWN.";
        field {
            name = "word";
            desc = "32-bit table word.";
            sw = rw;
            hw = r;
        } word[31:0];
    } TBL_830 @ 0x830;

    reg {
        name = "Table word 0x834";
        desc = "Word 0x834 of the H.265 register table. PROVENANCE: PROVEN offset; PROVEN stored byte lanes 012 (lane 0 = bits [7:0]); PROVEN cleared bit extents [16:16] (lower bound of the fields); constants ORed in: none; written by UpdateLowerPowerCfg (3 stores). Field meanings UNKNOWN.";
        field {
            name = "word";
            desc = "32-bit table word.";
            sw = rw;
            hw = r;
        } word[31:0];
    } TBL_834 @ 0x834;

    reg {
        name = "Table word 0x838";
        desc = "Word 0x838 of the H.265 register table. PROVENANCE: PROVEN offset; PROVEN stored byte lanes 0123 (lane 0 = bits [7:0]); PROVEN cleared bit extents none seen (lower bound of the fields); constants ORed in: none; written by InitRegConfigParam (1 stores). Field meanings UNKNOWN.";
        field {
            name = "word";
            desc = "32-bit table word.";
            sw = rw;
            hw = r;
        } word[31:0];
    } TBL_838 @ 0x838;

    reg {
        name = "Table word 0x83C";
        desc = "Word 0x83C of the H.265 register table. PROVENANCE: PROVEN offset; PROVEN stored byte lanes 0123 (lane 0 = bits [7:0]); PROVEN cleared bit extents none seen (lower bound of the fields); constants ORed in: none; written by InitRegConfigParam (1 stores). Field meanings UNKNOWN.";
        field {
            name = "word";
            desc = "32-bit table word.";
            sw = rw;
            hw = r;
        } word[31:0];
    } TBL_83C @ 0x83C;

    reg {
        name = "Table word 0x840";
        desc = "Word 0x840 of the H.265 register table. PROVENANCE: PROVEN offset; PROVEN stored byte lanes 0123 (lane 0 = bits [7:0]); PROVEN cleared bit extents [16:8] [21:18] (lower bound of the fields); constants ORed in: 0x3, 0x20000; written by InitRegConfigParam (2 stores). Field meanings UNKNOWN.";
        field {
            name = "word";
            desc = "32-bit table word.";
            sw = rw;
            hw = r;
        } word[31:0];
    } TBL_840 @ 0x840;

    reg {
        name = "Table word 0x848";
        desc = "Word 0x848 of the H.265 register table. PROVENANCE: PROVEN offset; PROVEN stored byte lanes 0123 (lane 0 = bits [7:0]); PROVEN cleared bit extents none seen (lower bound of the fields); constants ORed in: none; written by InitRegConfigParam (1 stores). Field meanings UNKNOWN.";
        field {
            name = "word";
            desc = "32-bit table word.";
            sw = rw;
            hw = r;
        } word[31:0];
    } TBL_848 @ 0x848;

    reg {
        name = "Table word 0x84C";
        desc = "Word 0x84C of the H.265 register table. PROVENANCE: PROVEN offset; PROVEN stored byte lanes 0123 (lane 0 = bits [7:0]); PROVEN cleared bit extents none seen (lower bound of the fields); constants ORed in: none; written by InitRegConfigParam (1 stores). Field meanings UNKNOWN.";
        field {
            name = "word";
            desc = "32-bit table word.";
            sw = rw;
            hw = r;
        } word[31:0];
    } TBL_84C @ 0x84C;

    reg {
        name = "Table word 0x870";
        desc = "Word 0x870 of the H.265 register table. PROVENANCE: PROVEN offset; PROVEN stored byte lanes 01 (lane 0 = bits [7:0]); PROVEN cleared bit extents none seen (lower bound of the fields); constants ORed in: none; written by UpdateLowerPowerCfg (2 stores). Field meanings UNKNOWN.";
        field {
            name = "word";
            desc = "32-bit table word.";
            sw = rw;
            hw = r;
        } word[31:0];
    } TBL_870 @ 0x870;

};

`endif
