`ifndef HISI_JPGE_RDL
`define HISI_JPGE_RDL


regfile eHISI_JPGE {
    name = "HiSilicon JPEG encoder (JPGE, r004 register layout)";
    desc = "
    LAYOUT PARTLY CONFIRMED ON THE Hi3520D BOARD (2026-11-10): the registers used by the Linux hisi-jpge driver (interrupts, PICFG, IMGSIZE, source addresses and strides for semi-planar input, stream address/length, QPT writes, START, OUTSTD, VERSION) produced correct JPEG files on the board, so offsets and the main field positions are confirmed; each register description below states its own source and confidence in the fixed forms 'Source: data sheet', 'Source: HiSTB driver (register semantics only), confidence HIGH|MEDIUM|LOW', 'Source: Hi3520D board read-back 2026-11-10' and 'Not verified on hardware'. Hi3536D V100 instance (2026-11-22, data sheet Issue 00B04 chapter 6.2 and static analysis of the vendor module hi3536dv100_jpege.ko; no register table in the data sheet): window 0x13120000, interrupt table bit 62 (SPI 30), PERI_CRG39 (0x9C) bit 1 jpge_cken and bit 0 jpge_srst_req (reset value 0x2: clock on, reset released); features: ISO/IEC 10918-1 baseline, semi-planar YCbCr 4:2:0 and 4:2:2 input only, 1080p@30, 32x32 to 8192x8192 in steps of 4, independent Y/Cb/Cr quantization tables, a color-to-gray function (PICFG col2grayEn, semantics unknown). The VERSION word and the VPP/QPT windows of this chip were not read on silicon. Previously: CANDIDATE LAYOUT, LOW-MEDIUM CONFIDENCE, NOT HARDWARE VERIFIED. JPEG encoder (JPGE) of the Hi3520D SDK generation: 40 registers transcribed from the header `jpge_reg(r004).h` (file `product/hiosd/dec/jpeg_reg.h`, Huawei copyright 2012-05-16, version 2.0) that ships unused inside the Hi3520D vendor U-Boot 2010.06 uploads (https://github.com/Axl-zhang/hisilicon-hi3520d-uboot, https://github.com/hi35xx/hi35xx-buildroot `boot/uboot/u-boot-2010.06`; GPL-2.0 U-Boot tree). The header names no chip and gives no base address; the Hi3520D data sheet (Table 1-1) places the JPGE window at 0x20660000 (GIC interrupt 73) and its 6.3 feature list (baseline JPEG, 4:2:0/4:2:2/4:4:4, planar/semi-planar/packed input, 8192x8192, 8-region OSD, separate Y/Cb/Cr quantization tables) matches this register set (8 VPP_OSD regions, 48-word quantization table). Layout: interrupt set 0x0-0xC (end of picture, buffer full, time-out, config error), picture config 0x10-0x24, source addresses/strides 0x30-0x3C, stream buffer 0x40-0x4C (start, read/write pointers, length), PTS 0x70-0x7C, time-out/timer 0x80/0x84, OUTSTD 0xA4, VERSION 0xFC, VPP overlay 0x500-0x5D0 (8 OSD regions: alpha, position, size, address, stride, layer order, colour inversion), quantization table JPGE_QPT[48] at 0x1000. Reset values and access types are unknown (no data sheet register description; modelled RW, no reset). Hardware probe to confirm the layout before relying on it: read 0x20660000 + 0xFC (JPGE_VERSION, expect a non-zero version word), + 0x0 / + 0x8 (JPGE_INTSTAT / JPGE_RAWINT, expect 0) and + 0x1000.. (JPGE_QPT, read/write test) with the JPGE clock enabled (PERI_CRG). The HiSTB SDK `source/msp/drv/jpge/src/jpge_reg.h` is a later revision of the same register family (same names, extra registers) and was not used. Every register and field desc below is marked `[inferred]` (names from the header, meanings inferred from the names).

    CROSS-CHIP USE (2026-11-11, docs/rdl-campaign/jpge-crosschip.md): this same register file is instantiated on the other Hi3516/Hi3518/Hi3519 chips whose vendor MPP JPEG encoder module programs the same offsets: Hi3518 V100 / Hi3516C V100 (hi3518_jpege.ko), Hi3518E V200 / Hi3516C V200 (hi3518e_jpege.ko), Hi3516A/D V100 (hi3516a_jpege.ko), Hi3516A V200 / Hi3519 V101 (hi3519v101_jpege.ko), Hi3516C V300 / Hi3516E V100 (hi3516cv300_jpege.ko). Evidence for those chips is STATIC ANALYSIS of the vendor modules only (Source: vendor module <name>, confidence HIGH for the offsets and bit positions that the module's register-write and HAL functions access, word-checked against the Hi3520D module; no data sheet register table exists for any chip; not verified on hardware on any chip except the Hi3520D). Where a chip's module differs from the Hi3520D one the difference is named in the field text (PICFG bits 19 and 29). Registers that the Hi3520D RDL carries only from the HiSTB driver or the U-Boot header (VERSION, TIMEOUT, TIMER, PTS, CLIP_THR, SRCVADDR, SRPTR/SWPTR use by the module) were not compared on the other chips unless stated per register; for those the layout is INFERRED from the Hi3520D layout (confidence LOW-MEDIUM). Every chip's base address, interrupt number and clock/reset bits come from its own data sheet memory map, interrupt table and PERI_CRG register (never from the vendor module): Hi3516A/D 0x20660000 IRQ 73, Hi3518/Hi3516C V100 and Hi3518E V200/Hi3516C V200 0x20660000 IRQ 26, Hi3516A V200/Hi3519 0x11200000 IRQ 70, Hi3516C V300/Hi3516E V100 0x11220000 IRQ 26; clock gate/reset PERI_CRG24 [1]/[0] on all of them. The Hi3516A V300 (0x11220000, IRQ 68, PERI_CRG44) uses a DIFFERENT layout (eHISI_JPGE_AV300 in HISI_JPGE_AV300.rdl); the Hi3516 V100 (0x20610000, IRQ 54, PERI_CRG19) has no vendor module in the local corpus and is only a window (aHISI_JPGE stub below), although its data sheet 6.3 feature list is identical to the Hi3520D one.

    Generated 2026-11-10 by build/rdl-audit/video-rdl-scratch/gen_blocks.py: mechanical transcription of the data sheet register tables (ds_extract2 + description extraction from the PDF) merged with the vendor header; not hardware verified.

    Register sources: 0 registers from the data sheet (-, section -); 40 registers (5 of them arrays) and 0 fields from vendor U-Boot 2010.06 upload `product/hiosd/dec/jpeg_reg.h` = `jpge_reg(r004).h` (GPL-2.0 U-Boot tree, Huawei copyright 2012; github.com/Axl-zhang/hisilicon-hi3520d-uboot) (GPL-2.0; same SDK generation as the Hi3520D, chip not named in the file), each marked `[inferred]` in its desc (names from the header, meanings inferred from the names, reset/access unknown). ";

    reg {
        name = "JPGE INTSTAT";
        desc = "Interrupt status (masked by INTMASK). Bit 0 end of picture, 1 stream buffer full, 2 time-out, 3 configuration error. Layout: vendor header jpge_reg(r004).h (Hi3520D U-Boot 2010.06 upload), not in the data sheet. Reads 0 when idle; the end-of-picture bit is delivered as the interrupt of every encode (Source: Hi3520D board read-back 2026-11-10). Meaning of bits 1..3: Source: HiSTB driver (register semantics only), confidence MEDIUM. Not verified on hardware: the buffer-full, time-out and configuration-error interrupts were never raised in the board test. Access type (read-only) not verified.";

        field {
            name = "cfgErr";
            desc = "[inferred] Configuration error interrupt. (vendor header `jpeg_reg.h` (JPGE r004) field `cfgErr`; access and reset unknown, modelled RW)";
            sw = rw;
            hw = r;
        } cfgErr[3:3];

        field {
            name = "JpgeTimeout";
            desc = "[inferred] Encoder time-out interrupt (see JPGE_TIMEOUT/JPGE_TIMER). (vendor header `jpeg_reg.h` (JPGE r004) field `JpgeTimeout`; access and reset unknown, modelled RW)";
            sw = rw;
            hw = r;
        } JpgeTimeout[2:2];

        field {
            name = "VencBufFull";
            desc = "[inferred] Stream buffer full interrupt. (vendor header `jpeg_reg.h` (JPGE r004) field `VencBufFull`; access and reset unknown, modelled RW)";
            sw = rw;
            hw = r;
        } VencBufFull[1:1];

        field {
            name = "VencEndOfPic";
            desc = "[inferred] End-of-picture (frame encoded) interrupt. (vendor header `jpeg_reg.h` (JPGE r004) field `VencEndOfPic`; access and reset unknown, modelled RW)";
            sw = rw;
            hw = r;
        } VencEndOfPic[0:0];
    } JPGE_INTSTAT @ 0x0;

    reg {
        name = "JPGE INTMASK";
        desc = "Interrupt mask/enable: 1 = interrupt enabled (the Linux driver writes bits 0, 1 and 3 and gets the end-of-picture interrupt: Source: Hi3520D board read-back 2026-11-10). Layout: vendor header jpge_reg(r004).h (Hi3520D U-Boot 2010.06 upload), not in the data sheet. Reset value not read. Bit 2 (time-out) enable: Source: HiSTB driver (register semantics only), confidence MEDIUM, Not verified on hardware. Hi3536D vendor module (Hi3536D V100 vendor module hi3536dv100_jpege.ko (SDK V1.0.1.0): static analysis plus execution of its register writer under qemu-arm on a RAM window, 2026-11-22 (shows what the vendor PROGRAMS, not what the silicon does)): the HAL init writes 0x3 (end of picture and buffer full; bit 2 is explicitly cleared, bit 3 never set), JPEGE_DRV_WriteRegs writes 0x3 again on every picture, JPEGU_SetIntMask writes 0. The Linux driver also enables bit 3 (configuration error).";

        field {
            name = "cfgErrMask";
            desc = "[inferred] Mask of the configuration-error interrupt. (vendor header `jpeg_reg.h` (JPGE r004) field `cfgErrMask`; access and reset unknown, modelled RW)";
            sw = rw;
            hw = r;
        } cfgErrMask[3:3];

        field {
            name = "JpgeTimeoutMask";
            desc = "[inferred] Mask of the time-out interrupt. (vendor header `jpeg_reg.h` (JPGE r004) field `JpgeTimeoutMask`; access and reset unknown, modelled RW)";
            sw = rw;
            hw = r;
        } JpgeTimeoutMask[2:2];

        field {
            name = "VencBufFullMask";
            desc = "[inferred] Mask of the buffer-full interrupt. (vendor header `jpeg_reg.h` (JPGE r004) field `VencBufFullMask`; access and reset unknown, modelled RW)";
            sw = rw;
            hw = r;
        } VencBufFullMask[1:1];

        field {
            name = "VencEndOfPicMask";
            desc = "[inferred] Mask of the end-of-picture interrupt. (vendor header `jpeg_reg.h` (JPGE r004) field `VencEndOfPicMask`; access and reset unknown, modelled RW)";
            sw = rw;
            hw = r;
        } VencEndOfPicMask[0:0];
    } JPGE_INTMASK @ 0x4;

    reg {
        name = "JPGE RAWINT";
        desc = "Raw (unmasked) interrupt status, same bits as INTSTAT. Reads 0 when idle (Source: Hi3520D board read-back 2026-11-10). Layout: vendor header jpge_reg(r004).h (Hi3520D U-Boot 2010.06 upload), not in the data sheet. Not verified on hardware: behavior while an interrupt is masked.";

        field {
            name = "cfgErr";
            desc = "[inferred] Configuration error interrupt. (vendor header `jpeg_reg.h` (JPGE r004) field `cfgErr`; access and reset unknown, modelled RW)";
            sw = rw;
            hw = r;
        } cfgErr[3:3];

        field {
            name = "JpgeTimeout";
            desc = "[inferred] Encoder time-out interrupt (see JPGE_TIMEOUT/JPGE_TIMER). (vendor header `jpeg_reg.h` (JPGE r004) field `JpgeTimeout`; access and reset unknown, modelled RW)";
            sw = rw;
            hw = r;
        } JpgeTimeout[2:2];

        field {
            name = "VencBufFull";
            desc = "[inferred] Stream buffer full interrupt. (vendor header `jpeg_reg.h` (JPGE r004) field `VencBufFull`; access and reset unknown, modelled RW)";
            sw = rw;
            hw = r;
        } VencBufFull[1:1];

        field {
            name = "VencEndOfPic";
            desc = "[inferred] End-of-picture (frame encoded) interrupt. (vendor header `jpeg_reg.h` (JPGE r004) field `VencEndOfPic`; access and reset unknown, modelled RW)";
            sw = rw;
            hw = r;
        } VencEndOfPic[0:0];
    } JPGE_RAWINT @ 0x8;

    reg {
        name = "JPGE INTCLR";
        desc = "Interrupt clear: write 1 to clear the matching bit. The Linux driver writes the status it read and the interrupt deasserts (Source: Hi3520D board read-back 2026-11-10, encode loops of 3000 frames). The HiSTB ISR path (jpge_hal.c Jpge_ReadReg, after reading INTSTAT) writes 0xFFFFFFFF to clear every bit (Source: HiSTB driver (register semantics only), confidence MEDIUM). Layout: vendor header jpge_reg(r004).h (Hi3520D U-Boot 2010.06 upload), not in the data sheet. Hi3536D vendor module (Hi3536D V100 vendor module hi3536dv100_jpege.ko (SDK V1.0.1.0): static analysis plus execution of its register writer under qemu-arm on a RAM window, 2026-11-22 (shows what the vendor PROGRAMS, not what the silicon does)): JPEGU_ClearInt writes 0xFFFFFFFF, JPEGU_ClearErrInt writes 0xFFFFFFFC (everything except the two normal bits); the vendor interrupt test reads INTSTAT bit 0 (end of picture) or bit 1 (buffer full).";

        field {
            name = "cfgErrClr";
            desc = "[inferred] Clear the configuration-error interrupt. (vendor header `jpeg_reg.h` (JPGE r004) field `cfgErrClr`; access and reset unknown, modelled RW)";
            sw = rw;
            hw = r;
        } cfgErrClr[3:3];

        field {
            name = "JpgeTimeoutClr";
            desc = "[inferred] Clear the time-out interrupt. (vendor header `jpeg_reg.h` (JPGE r004) field `JpgeTimeoutClr`; access and reset unknown, modelled RW)";
            sw = rw;
            hw = r;
        } JpgeTimeoutClr[2:2];

        field {
            name = "VencBufFullClr";
            desc = "[inferred] Clear the buffer-full interrupt. (vendor header `jpeg_reg.h` (JPGE r004) field `VencBufFullClr`; access and reset unknown, modelled RW)";
            sw = rw;
            hw = r;
        } VencBufFullClr[1:1];

        field {
            name = "VencEndOfPicClr";
            desc = "[inferred] Clear the end-of-picture interrupt. (vendor header `jpeg_reg.h` (JPGE r004) field `VencEndOfPicClr`; access and reset unknown, modelled RW)";
            sw = rw;
            hw = r;
        } VencEndOfPicClr[0:0];
    } JPGE_INTCLR @ 0xC;

    reg {
        name = "JPGE PICFG";
        desc = "Picture configuration. Reset value 0x0D880000 (Source: Hi3520D board read-back 2026-11-10): roundEn = 1, packageSel = 0xD8 (YUYV), everything else 0. Layout: vendor header jpge_reg(r004).h (Hi3520D U-Boot 2010.06 upload), not in the data sheet. The Linux driver writes the whole register per job with roundEn = 0 (as the HiSTB driver does) and the encodes work on the board. Fields not covered by the encode test are marked per field. Vendor programming (Hi3536D V100 vendor module hi3536dv100_jpege.ko (SDK V1.0.1.0): static analysis plus execution of its register writer under qemu-arm on a RAM window, 2026-11-22 (shows what the vendor PROGRAMS, not what the silicon does)): the module writes PICFG as a read-modify-write on every picture, setting strFmt = 0, yuvFmt (4:2:0 = 0, 4:2:2 = 1; the 400 pixel format 29 gives yuvFmt 0 plus col2grayEn), chnId = channel, rotationAngle = 0, roundEn = 0, col2grayEn = (colour-to-grey flag or 400 input); the HAL init (run at reset and probe) sets timeoutEn = 1, clkGateEn = 2 and memClkGateEn = 1 (default module parameter), and nothing touches bit 17, clip_en and packageSel. The resulting value for a 640x480 4:2:0 picture on channel 0 is 0x0D858000 (reset value 0x0D880000 as read on the Hi3536D board). Confidence PROVEN for the programmed values.";

        field {
            name = "col2grayEn";
            desc = "Color to gray conversion (name only). Source: HiSTB driver (register semantics only), confidence LOW. Reset 0 (Source: Hi3520D board read-back 2026-11-10). The data sheet lists no 4:0:0 encoding. Effect measured on the Hi3536D V100 board (2026-11-22, source: board, confidence HIGH): with the bit set the block still encodes all three components and the software-written header (3 components, 4:2:0) stays valid, but Cb and Cr are coded as the neutral value (the decoded picture has Cb = Cr = 128 everywhere, Y unchanged; stream 22 percent smaller for a colour-bar picture): it does NOT produce a one-component scan. Other chips (static analysis of the vendor modules, 2026-11-11): hi3518e_jpege, hi3516a_jpege, hi3516cv300_jpege and hi3519v101_jpege write this bit in every register-write call, as 1 when an input flag of the channel structure (offset 0x104 of the write argument, name unknown, probably a 4:0:0/gray pixel-format flag) equals 1, otherwise 0 (Source: vendor module, bit position HIGH, meaning LOW); the Hi3520D and Hi3518 V100 modules never touch it. Hi3536D vendor module (Hi3536D V100 vendor module hi3536dv100_jpege.ko (SDK V1.0.1.0): static analysis plus execution of its register writer under qemu-arm on a RAM window, 2026-11-22 (shows what the vendor PROGRAMS, not what the silicon does)): col2grayEn is set when the colour-to-grey flag of the channel is 1 (HI_MPI_VENC_SetColor2Grey) or when the input pixel format is the 400 semi-planar one (value 29, then yuvFmt is cleared to 0), and cleared otherwise. The vendor header template is always the 3-component JFIF header (DQT x3, SOF0 with 3 components, DHT x4, DRI, SOS with 3 components; only the SOF sampling byte is patched for 4:2:2): the vendor stack has NO one-component (grey) mode, its grey output is the 3-component stream with neutral chroma that the Hi3536D board measured. No register or PICFG field other than this bit is programmed for grey. INFERRED (no other grey control is known): the block cannot emit a one-component scan. Whether the chroma plane is still read with the bit set is unknown (board experiment E-G2 in docs/research/jpge-open-questions-2026-11-22.md). Board 2026-11-23 (Hi3536D V100, NBD80XXS, source: board, confidence HIGH): bit 29 col2grayEn = 1 makes the block ignore the chroma input: the output file is byte-identical whatever the chroma plane holds (0x00, 0x80, 0xFF or the test pattern), Y is unchanged and the decoded Cb and Cr are 128 everywhere, for 4:2:0 and 4:2:2 input; the stream still has three components. Reset value read back 0x0D880000 as on the Hi3520D. Board 2026-11-23 (Hi3520D V100, NVR0408, source: board, confidence HIGH): NOT the same on the Hi3520D: with the bit set and the chroma source registers pointing into the Y plane (a grey input) the file keeps the chroma it read (decoded Cb and Cr range 0..255, the file is not smaller than the colour encode), i.e. the Hi3520D block does not code the neutral value; the Linux driver therefore offers the grey input on the Hi3536D only.";
            sw = rw;
            hw = r;
            reset = 0;
        } col2grayEn[29:29];

        field {
            name = "jcpi_clip_en";
            desc = "Enable clipping with JPGE_CLIP_THR. Source: HiSTB driver (register semantics only), confidence LOW. Reset 0 (Source: Hi3520D board read-back 2026-11-10). Not verified on hardware.";
            sw = rw;
            hw = r;
            reset = 0;
        } jcpi_clip_en[28:28];

        field {
            name = "packageSel";
            desc = "Component byte order of packed input, four 2 bit fields = byte position (0..3) in a 4 byte Y0 Cb/Cr Y1 Cr/Cb group: [1:0] Y0, [3:2] Y1, [5:4] Cb, [7:6] Cr. Reset 0xD8 = YUYV (Source: Hi3520D board read-back 2026-11-10; YUYV is the packed format the data sheet lists, Source: data sheet 6.3.2). The rule is derived from three vendor constants: UYVY 0x8D, YUYV 0xD8, YVYU 0x78 (Source: HiSTB driver (register semantics only), confidence MEDIUM; constants from the HiSTB VENC code, same field name); VYUY 0x2D follows from the rule (LOW). Not verified on hardware for non-default values and for any effect on planar or semi-planar input.";
            sw = rw;
            hw = r;
            reset = 0xD8;
        } packageSel[27:20];

        field {
            name = "roundEn";
            desc = "Rounding control. Reset 1 (Source: Hi3520D board read-back 2026-11-10, Hi3536D V100 board read-back 2026-11-22). Effect measured on the Hi3536D V100 board (NBD80XXS, 2026-11-22, source: board, confidence HIGH): roundEn = 0 (what the HiSTB driver and the Linux driver write) makes the quantizer truncate toward zero (output 12 to 34 percent smaller than libjpeg at the same quality, PSNR 0.2 to 2.7 dB lower, worst at quality 1 and 90); roundEn = 1 makes it round like libjpeg (size ratio 0.99 to 1.02 against libjpeg at quality 1/25/50/75/90, PSNR equal to or up to 0.85 dB above libjpeg at the same quality; no difference at quality 100 where every divisor is 1; the input is YCbCr data so the comparison is statistical, not byte-exact). The decoder side is unaffected (both streams decode). Other chips (static analysis 2026-11-11): the hi3518e, hi3516a, hi3516cv300 and hi3519v101 modules write this bit as 0 in every register-write call (like the Linux driver); the Hi3520D and Hi3518 V100 modules leave it at its reset value. Hi3536D vendor module (Hi3536D V100 vendor module hi3536dv100_jpege.ko (SDK V1.0.1.0): static analysis plus execution of its register writer under qemu-arm on a RAM window, 2026-11-22 (shows what the vendor PROGRAMS, not what the silicon does)): the module writes roundEn = 0 explicitly on every picture (so vendor-encoded streams truncate like the old Linux driver did; the vendor quality scaling is the plain IJG formula, see JPGE_QPT). The Linux driver writes 1, which is what the board experiment recommends. Confidence PROVEN for the vendor value.";
            sw = rw;
            hw = r;
            reset = 1;
        } roundEn[19:19];

        field {
            name = "timeoutEn";
            desc = "Enable the hardware encode time-out (JPGE_TIMEOUT / JPGE_TIMER). Source: HiSTB driver (register semantics only), confidence LOW. Reset 0 (Source: Hi3520D board read-back 2026-11-10). The Linux driver uses a software watchdog instead. Not verified on hardware. Hi3536D vendor module (Hi3536D V100 vendor module hi3536dv100_jpege.ko (SDK V1.0.1.0): static analysis plus execution of its register writer under qemu-arm on a RAM window, 2026-11-22 (shows what the vendor PROGRAMS, not what the silicon does)): the HAL init sets timeoutEn = 1 (JPEGU_HAL_SetTimerMode(1)) but the module never writes JPGE_TIMEOUT (JPEGU_SetTimeOut is an empty function) and only reads JPGE_TIMER for a debug print, so the vendor relies on the TIMEOUT reset value; the vendor interrupt mask excludes bit 2 (no time-out interrupt). Confidence PROVEN for the programming, meaning INFERRED.";
            sw = rw;
            hw = r;
            reset = 0;
        } timeoutEn[18:18];

        field {
            name = "configlockEn";
            desc = "Lock the configuration registers while encoding. Source: HiSTB driver (register semantics only), confidence LOW. Reset 0 (Source: Hi3520D board read-back 2026-11-10). Not verified on hardware.";
            sw = rw;
            hw = r;
            reset = 0;
        } configlockEn[17:17];

        field {
            name = "memClkGateEn";
            desc = "Memory clock gating enable; the HiSTB driver and the Linux driver write 1 (Source: Hi3520D board read-back 2026-11-10: works). Reset 0 (Source: Hi3520D board read-back 2026-11-10). Effect of 0 during encoding: Not verified on hardware. Hi3536D vendor module (Hi3536D V100 vendor module hi3536dv100_jpege.ko (SDK V1.0.1.0): static analysis plus execution of its register writer under qemu-arm on a RAM window, 2026-11-22 (shows what the vendor PROGRAMS, not what the silicon does)): set to 1 by JPEGU_HAL_SetPowerMode when the module parameter g_bJpgePowerSaveEn (default 1) is 1, cleared when it is 0; clkGateEn is then 2 (1) or 0 (0). Confidence PROVEN.";
            sw = rw;
            hw = r;
            reset = 0;
        } memClkGateEn[16:16];

        field {
            name = "clkGateEn";
            desc = "Clock gating level; the HiSTB driver writes 2 (frame and block level gating). The Linux driver writes 2 and encodes correctly (Source: Hi3520D board read-back 2026-11-10). Other values: Not verified on hardware.";
            sw = rw;
            hw = r;
            reset = 0;
        } clkGateEn[15:14];

        field {
            name = "rotationAngle";
            desc = "Rotation of the source picture: 0 = none, 1 = 90, 2 = 270, 3 = 180 degrees (direction unknown). For 90/270 the HiSTB driver swaps width and height in the JFIF header and turns 4:2:2 into 4:2:0 with a doubled chroma stride. Source: HiSTB driver (register semantics only), confidence MEDIUM. Not used by the Linux driver. Not verified on hardware. Other chips (static analysis 2026-11-11): no vendor module analyzed writes a non-zero rotation (the Hi3516A, Hi3516CV300, Hi3518E and Hi3519V101 modules clear bits 13:12 explicitly, the Hi3518 module leaves them alone).";
            sw = rw;
            hw = r;
            reset = 0;
        } rotationAngle[13:12];

        field {
            name = "chnId";
            desc = "Channel ID copied into the packet descriptor (descriptor bytes 12..15). Source: HiSTB driver (register semantics only), confidence LOW. The Linux driver writes 0. Not verified on hardware. Other chips (static analysis 2026-11-11): the hi3518, hi3518e, hi3516a, hi3516cv300 and hi3519v101 modules write the channel number into bits [11:4] too (Source: vendor module, HIGH). Hi3536D vendor module (Hi3536D V100 vendor module hi3536dv100_jpege.ko (SDK V1.0.1.0): static analysis plus execution of its register writer under qemu-arm on a RAM window, 2026-11-22 (shows what the vendor PROGRAMS, not what the silicon does)): chnId is the channel number, and the vendor stream reader CHECKS that byte 12 of every packet descriptor equals the channel it expects (mismatch gives an error), which confirms that the field is copied into descriptor bytes 12..15. Confidence PROVEN for the check, INFERRED for the copy.";
            sw = rw;
            hw = r;
            reset = 0;
        } chnId[11:4];

        field {
            name = "yuvFmt";
            desc = "Chroma sampling of the picture and of the JPEG: 0 = 4:2:0, 1 = 4:2:2 (Source: Hi3520D board read-back 2026-11-10: NV21 and NV61 encodes decode correctly with SOF sampling 0x22 and 0x21), 2 = 4:4:4 (Source: HiSTB driver (register semantics only), confidence MEDIUM, Not verified on hardware). Value 3: unknown, the HiSTB JPGE driver rejects it (not verified, LOW). With 4:2:2 data and yuvFmt = 0 plus a doubled chroma stride the encoder skips every second chroma line (4:2:0 JPEG from 4:2:2 input): Source: HiSTB driver (register semantics only), confidence MEDIUM (used by the HiSTB driver for rotation and 4:2:2 semi-planar), Not verified on hardware. Other chips (static analysis 2026-11-11): the vendor modules of Hi3518, Hi3518E, Hi3516A, Hi3516CV300 and Hi3519V101 write a 2 bit value from the channel structure to [3:2] (same position, Source: vendor module, HIGH). Hi3536D vendor module (Hi3536D V100 vendor module hi3536dv100_jpege.ko (SDK V1.0.1.0): static analysis plus execution of its register writer under qemu-arm on a RAM window, 2026-11-22 (shows what the vendor PROGRAMS, not what the silicon does)): the module writes 0 for 4:2:0 and 1 for 4:2:2 (pixel formats 23 and 22); for the 400 format (29) it writes 0 and sets col2grayEn; it never writes 2 or 3. Confidence PROVEN.";
            sw = rw;
            hw = r;
            reset = 0;
        } yuvFmt[3:2];

        field {
            name = "strFmt";
            desc = "Input storage: 0 = semi-planar (Y plane + interleaved Cr/Cb plane, Cr first; Source: Hi3520D board read-back 2026-11-10: NV21/NV61 encodes give correct colors), 1 = planar (separate Y, Cb, Cr planes), 2 = packed (YUYV family). Values 1 and 2: Source: HiSTB driver (register semantics only), confidence MEDIUM (JPGE_STORE_* enum of the HiSTB VENC code; the HiSTB H.264 encoder uses a different numbering, 0 semi-planar, 1 packed, 2 planar). Board 2026-11-23 (Hi3520D V100, NVR0408, source: board, confidence HIGH): 1 = planar and 2 = packed are confirmed by the encodes of the Linux driver: planar input in 4:2:0, 4:2:2 and 4:4:4 (single buffer and one buffer per plane) and packed YUYV, UYVY, YVYU and VYUY input (with packageSel) all decode to the expected picture, 17 input formats and the packed widths that are not a multiple of 16 included; strFmt 0 is confirmed on the Hi3536D V100 as well (the Hi3536D table of the driver only uses semi-planar input). Other chips (static analysis 2026-11-11): of the vendor modules analyzed (Hi3518, Hi3518E, Hi3516A, Hi3516CV300, Hi3519V101) none writes a non-zero value (Hi3516A, Hi3516CV300, Hi3519V101 and Hi3518E write 0 explicitly, Hi3518 leaves the field alone), so planar/packed input is exercised by no vendor code seen.";
            sw = rw;
            hw = r;
            reset = 0;
        } strFmt[1:0];
    } JPGE_PICFG @ 0x10;

    reg {
        name = "JPGE ECSCFG";
        desc = "Restart interval (entropy-coded segment) configuration. Field positions: Layout: vendor header jpge_reg(r004).h (Hi3520D U-Boot 2010.06 upload), not in the data sheet. Semantics: Source: HiSTB driver (register semantics only), confidence LOW. The HiSTB driver writes ecsSplit = enable and ecsSize = interval in MCUs minus 1 and puts a DRI marker with the same interval in the JFIF header, but its JPGE configuration check refuses restart intervals, so the behavior is undocumented. Open questions (all Not verified on hardware): whether the hardware writes the RSTn markers, and whether it emits one 64-byte-descriptor packet per segment (the descriptor has a last-slice flag at byte 11). The Linux driver supports both outcomes and writes 0 here by default. Board 2026-11-23 (Hi3536D V100, NBD80XXS, source: board, confidence HIGH): the open questions above are answered. With ecsSplit = 1 and ecsSize = r - 1 the block ends a restart interval after r MCUs and writes EVERY segment as a packet of its own: a 64-byte descriptor (PacketLen a multiple of 64 including the descriptor, InvalidBytes = zero padding at the end of the packet, byte 11 = 1 in the last packet of the picture and 0 in the others), the scan data of the segment, the padding; the packets follow each other in the stream buffer and the write pointer cell (SWPTR) ends at the sum of the packet lengths. The block INSERTS the RSTn markers itself (modulo 8, as the first two bytes of the data of every packet but the first) and the last packet ends with EOI. The earlier note that the block stops after the first segment came from reading only the first packet: there is no second START and no consumer acknowledge. The units are JPEG MCUs (16 x 16 pixels in 4:2:0, 16 x 8 in 4:2:2). A file rebuilt from the packets (descriptors and padding removed, DRI marker = r added to the header) decodes to the same pixels as the file without restart intervals for r = 1 (300 packets for a 320 x 240 picture and 8160 for 1080p), 50, 100, 150, 299 and 599; r at or above the number of MCUs gives one packet like ecsSplit = 0 (the vendor stack does not split then either). Board 2026-11-23 (Hi3520D V100, NVR0408, source: board, confidence HIGH): the same protocol on the Hi3520D, 30 encodes of the Linux driver (semi-planar 4:2:0/4:2:2, planar 4:2:0/4:2:2/4:4:4 and packed YUYV input; 4:4:4 counts MCUs of 8 x 8 pixels; r = 1 to 8159 and at/above the MCU count): DRI value, RSTn count and order, one EOI, and the decoded pixels identical to the encode without restart.";

        field {
            name = "ecsSize";
            desc = "Segment size in MCUs minus 1 (the DRI interval minus 1). Source: HiSTB driver (register semantics only), confidence LOW. Not verified on hardware. Hi3536D vendor module (Hi3536D V100 vendor module hi3536dv100_jpege.ko (SDK V1.0.1.0): static analysis plus execution of its register writer under qemu-arm on a RAM window, 2026-11-22 (shows what the vendor PROGRAMS, not what the silicon does)): ecsSize = u32MCUPerECS - 1 (example: 100 MCUs gives ECSCFG 0x000000C7, 1199 gives 0x0000095D, interval >= total gives 0). The 20-bit field is wider than the vendor 16-bit DRI limit. Confidence PROVEN.";
            sw = rw;
            hw = r;
            reset = 0;
        } ecsSize[20:1];

        field {
            name = "ecsSplit";
            desc = "Enable the split into entropy-coded segments (restart intervals). Source: HiSTB driver (register semantics only), confidence LOW. Not verified on hardware. Hi3536D vendor module (Hi3536D V100 vendor module hi3536dv100_jpege.ko (SDK V1.0.1.0): static analysis plus execution of its register writer under qemu-arm on a RAM window, 2026-11-22 (shows what the vendor PROGRAMS, not what the silicon does)): set to 1 only when 0 < u32MCUPerECS < total MCU count of the picture (total = ((w+15)>>4) * ((h+15)>>4), doubled for 4:2:2), cleared otherwise; the vendor checks u32MCUPerECS < 65536 and <= twice the 4:2:0 MCU count and puts a DRI marker with the same interval into the software-written header (the vendor header always carries a DRI segment, interval 0 when unused). The vendor module contains no RSTn insertion code, so a DRI-compliant stream means the hardware inserts the markers. Confidence PROVEN for the programming, hardware behavior still unverified (the Hi3520D stopped after the first segment, docs/research/jpge-open-questions-2026-11-22.md).";
            sw = rw;
            hw = r;
            reset = 0;
        } ecsSplit[0:0];
    } JPGE_ECSCFG @ 0x14;

    reg {
        name = "JPGE START";
        desc = "Start one picture: the driver writes 0 and then 1 (HiSTB sequence; Source: Hi3520D board read-back 2026-11-10: every encode starts this way, 3000 back-to-back frames). Whether the bit self-clears: Not verified on hardware. Layout: vendor header jpge_reg(r004).h (Hi3520D U-Boot 2010.06 upload), not in the data sheet. Hi3536D vendor module (Hi3536D V100 vendor module hi3536dv100_jpege.ko (SDK V1.0.1.0): static analysis plus execution of its register writer under qemu-arm on a RAM window, 2026-11-22 (shows what the vendor PROGRAMS, not what the silicon does)): JPEGU_StartVpu writes 0 and then 1, as the Linux driver does.";

        field {
            name = "VStart";
            desc = "[inferred] Start encoding one picture (self-clearing start bit). (vendor header `jpeg_reg.h` (JPGE r004) field `VStart`; access and reset unknown, modelled RW)";
            sw = rw;
            hw = r;
        } VStart[0:0];
    } JPGE_START @ 0x1C;

    reg {
        name = "JPGE VEDIMGSIZE";
        desc = "Picture size minus 1, 13 bits each (maximum 8192). Layout: vendor header jpge_reg(r004).h (Hi3520D U-Boot 2010.06 upload), not in the data sheet. Sizes 64x64, 640x480, 644x484, 1280x720 and 1920x1080 encode with these values (Source: Hi3520D board read-back 2026-11-10). Size limits 64x64 to 8192x8192 in steps of 4: Source: data sheet 6.3.2. Whether sizes that are not a multiple of the MCU are padded correctly by the hardware: Not verified on hardware (the encode completes; the picture content at the edge was not compared). Hi3536D vendor module (Hi3536D V100 vendor module hi3536dv100_jpege.ko (SDK V1.0.1.0): static analysis plus execution of its register writer under qemu-arm on a RAM window, 2026-11-22 (shows what the vendor PROGRAMS, not what the silicon does)): width - 1 in [12:0] and height - 1 in [28:16]; the module accepts widths and heights that are multiples of 4 in 32..8192 (picture size at most the maximum size of the channel), strides and source addresses multiples of 16.";

        field {
            name = "ImgHeightInPixelsMinus1";
            desc = "[inferred] Picture height in pixels minus 1. (vendor header `jpeg_reg.h` (JPGE r004) field `ImgHeightInPixelsMinus1`; access and reset unknown, modelled RW)";
            sw = rw;
            hw = r;
        } ImgHeightInPixelsMinus1[28:16];

        field {
            name = "ImgWidthInPixelsMinus1";
            desc = "[inferred] Picture width in pixels minus 1. (vendor header `jpeg_reg.h` (JPGE r004) field `ImgWidthInPixelsMinus1`; access and reset unknown, modelled RW)";
            sw = rw;
            hw = r;
        } ImgWidthInPixelsMinus1[12:0];
    } JPGE_VEDIMGSIZE @ 0x20;

    reg {
        name = "JPGE clip THR";
        desc = "[inferred] JPGE clip THR. Not in the data sheet. Source: vendor U-Boot 2010.06 upload `product/hiosd/dec/jpeg_reg.h` = `jpge_reg(r004).h` (GPL-2.0 U-Boot tree, Huawei copyright 2012; github.com/Axl-zhang/hisilicon-hi3520d-uboot), union `U_JPGE_CLIP_THR`, struct offset 0x24 (GPL-2.0; same SDK generation as the Hi3520D, chip not named in the file). Reset value and access type unknown (modelled RW, no reset). Confidence: medium (vendor header for this chip family, not hardware verified). Hi3536D vendor module (Hi3536D V100 vendor module hi3536dv100_jpege.ko (SDK V1.0.1.0): static analysis plus execution of its register writer under qemu-arm on a RAM window, 2026-11-22 (shows what the vendor PROGRAMS, not what the silicon does)): never written (nor read); clip_en stays at its reset value.";

        field {
            name = "jcpi_chr_max";
            desc = "[inferred] Chroma clip maximum. (vendor header `jpeg_reg.h` (JPGE r004) field `jcpi_chr_max`; access and reset unknown, modelled RW)";
            sw = rw;
            hw = r;
        } jcpi_chr_max[31:24];

        field {
            name = "jcpi_chr_min";
            desc = "[inferred] Chroma clip minimum. (vendor header `jpeg_reg.h` (JPGE r004) field `jcpi_chr_min`; access and reset unknown, modelled RW)";
            sw = rw;
            hw = r;
        } jcpi_chr_min[23:16];

        field {
            name = "jcpi_luma_max";
            desc = "[inferred] Luma clip maximum. (vendor header `jpeg_reg.h` (JPGE r004) field `jcpi_luma_max`; access and reset unknown, modelled RW)";
            sw = rw;
            hw = r;
        } jcpi_luma_max[15:8];

        field {
            name = "jcpi_luma_min";
            desc = "[inferred] Luma clip minimum. (vendor header `jpeg_reg.h` (JPGE r004) field `jcpi_luma_min`; access and reset unknown, modelled RW)";
            sw = rw;
            hw = r;
        } jcpi_luma_min[7:0];
    } JPGE_CLIP_THR @ 0x24;

    reg {
        name = "JPGE SRCYADDR";
        desc = "Source luma plane address (semi-planar, planar) or the whole picture (packed). Must be 16-byte aligned (Source: HiSTB driver (register semantics only), confidence MEDIUM, alignment check in the HiSTB VENC code). Works as such for semi-planar input (Source: Hi3520D board read-back 2026-11-10). Packed input: Not verified on hardware. Board 2026-11-23 (Hi3536D V100, NBD80XXS, source: board, confidence HIGH): reset values of the address words: SRCYADDR, SRCCADDR, SRCVADDR (0x30, 0x34, 0x38), STRMADDR, SRPTRADDR and SWPTRADDR (0x40, 0x44, 0x48) read 0xFFFFFFFF after the reset (read with the clock on before any job); SSTRIDE (0x3C) and STRMBUFLEN (0x4C) read 0.";

        field {
            name = "value";
            desc = "[inferred] Register value (the header union has no named bits).";
            sw = rw;
            hw = r;
        } value[31:0];
    } JPGE_SRCYADDR @ 0x30;

    reg {
        name = "JPGE SRCCADDR";
        desc = "Source chroma address. Semi-planar: the interleaved Cr/Cb plane, Cr first (Source: Hi3520D board read-back 2026-11-10: NV21/NV61 give correct colors). Planar: assumed to be the Cb plane (Source: HiSTB driver (register semantics only), confidence MEDIUM, naming in the HiSTB VENC code), Not verified on hardware. 16-byte alignment: Source: HiSTB driver (register semantics only), confidence MEDIUM.";

        field {
            name = "value";
            desc = "[inferred] Register value (the header union has no named bits).";
            sw = rw;
            hw = r;
        } value[31:0];
    } JPGE_SRCCADDR @ 0x34;

    reg {
        name = "JPGE SRCVADDR";
        desc = "Source Cr plane address for planar input (Source: HiSTB driver (register semantics only), confidence MEDIUM, Not verified on hardware). Unused for semi-planar input: the Linux driver writes 0 and encodes correctly (Source: Hi3520D board read-back 2026-11-10). Hi3536D vendor module (Hi3536D V100 vendor module hi3536dv100_jpege.ko (SDK V1.0.1.0): static analysis plus execution of its register writer under qemu-arm on a RAM window, 2026-11-22 (shows what the vendor PROGRAMS, not what the silicon does)): never written (the module supports semi-planar input only).";

        field {
            name = "value";
            desc = "[inferred] Register value (the header union has no named bits).";
            sw = rw;
            hw = r;
        } value[31:0];
    } JPGE_SRCVADDR @ 0x38;

    reg {
        name = "JPGE SSTRIDE";
        desc = "Source line strides in bytes: luma/packed in [15:0], chroma in [31:16] (one chroma stride for Cb and Cr in planar mode). 16-byte multiples: Source: HiSTB driver (register semantics only), confidence MEDIUM. Semi-planar strides equal to bytesperline for both fields work (Source: Hi3520D board read-back 2026-11-10, 640 to 1920 wide). Doubling the chroma stride to read every second chroma line: Source: HiSTB driver (register semantics only), confidence MEDIUM, Not verified on hardware. Layout: vendor header jpge_reg(r004).h (Hi3520D U-Boot 2010.06 upload), not in the data sheet. Hi3536D vendor module (Hi3536D V100 vendor module hi3536dv100_jpege.ko (SDK V1.0.1.0): static analysis plus execution of its register writer under qemu-arm on a RAM window, 2026-11-22 (shows what the vendor PROGRAMS, not what the silicon does)): the module checks that both strides and the source addresses are multiples of 16; it writes the luma stride to [15:0] and the chroma stride to [31:16].";

        field {
            name = "SrcCStride";
            desc = "[inferred] Source chroma stride in bytes. (vendor header `jpeg_reg.h` (JPGE r004) field `SrcCStride`; access and reset unknown, modelled RW)";
            sw = rw;
            hw = r;
        } SrcCStride[31:16];

        field {
            name = "SrcYStride";
            desc = "[inferred] Source luma stride in bytes. (vendor header `jpeg_reg.h` (JPGE r004) field `SrcYStride`; access and reset unknown, modelled RW)";
            sw = rw;
            hw = r;
        } SrcYStride[15:0];
    } JPGE_SSTRIDE @ 0x3C;

    reg {
        name = "JPGE STRMADDR";
        desc = "Stream buffer start address (64-byte aligned in the Linux driver). The hardware writes a 64-byte packet descriptor here (dword 0 PacketLen including the descriptor, a multiple of 64; dword 1 InvalidBytes = padding at the end of the packet; byte 11 last-slice flag, dwords 3 channel id: Source: HiSTB driver (register semantics only), confidence MEDIUM for the layout) followed by the entropy-coded scan data and the EOI marker FF D9 (Source: Hi3520D board read-back 2026-11-10: every encode ends with ff d9, the PacketLen/InvalidBytes semantics gave correct file sizes). Layout: vendor header jpge_reg(r004).h (Hi3520D U-Boot 2010.06 upload), not in the data sheet. Hi3536D vendor module (Hi3536D V100 vendor module hi3536dv100_jpege.ko (SDK V1.0.1.0): static analysis plus execution of its register writer under qemu-arm on a RAM window, 2026-11-22 (shows what the vendor PROGRAMS, not what the silicon does)): descriptor layout as the vendor reader uses it: dword 0 PacketLen, dword 1 InvalidBytes (checked <= 63), byte 8 pack type (JPEGE_PACK_TYPE: ECS 5, APP 6, VDO 7, PIC 8; the software header pack uses 8), bytes 9 and 11 flags (checked to be 0 or 1; byte 11 is copied to the frame-end flag of the stream pack), dword 3 channel id (checked), bytes 16..23 PTS. The vendor reader gathers up to four consecutive packets per call. Confidence PROVEN for the reader, INFERRED for what the hardware writes.";

        field {
            name = "value";
            desc = "[inferred] Register value (the header union has no named bits).";
            sw = rw;
            hw = r;
        } value[31:0];
    } JPGE_STRMADDR @ 0x40;

    reg {
        name = "JPGE SRPTRADDR";
        desc = "Stream read/write pointer address (not used by the encoder as a pointer in single-picture mode). The Linux driver points it 16 bytes (SRPTR) or 32 bytes (SWPTR) below the stream address, as the HiSTB driver does. Board finding (Source: Hi3520D board read-back 2026-11-10, functional test): the 32 bytes below the stream address must not hold stale data; with a reused buffer that still held the previous JFIF header the second and later pictures lost their packet descriptor and the scan data started early; clearing those bytes (and the descriptor area) before every job fixed it, a per-job hardware reset did not. What the block reads there is Not verified on hardware. Layout: vendor header jpge_reg(r004).h (Hi3520D U-Boot 2010.06 upload), not in the data sheet. Hi3536D vendor module (Hi3536D V100 vendor module hi3536dv100_jpege.ko (SDK V1.0.1.0): static analysis plus execution of its register writer under qemu-arm on a RAM window, 2026-11-22 (shows what the vendor PROGRAMS, not what the silicon does)): the vendor ring buffer keeps the two pointer cells in a separate 128-byte structure (read-pointer cell at +0x40, write-pointer cell at +0x80, both 64-byte aligned: the module panics otherwise, as it does for a stream address or length that is not a multiple of 64); SRPTR points at the first, SWPTR at the second. The write-pointer cell holds a byte offset into the ring and wraps at STRMBUFLEN; the vendor derives the size of a frame as (write cell after the frame - write cell before the frame) mod length, and updates the read cell only when the application releases a stream. Confidence PROVEN for the allocation and use, INFERRED for the hardware semantics (initial write offset = the cell value; flow control against the read cell).";

        field {
            name = "value";
            desc = "[inferred] Register value (the header union has no named bits).";
            sw = rw;
            hw = r;
        } value[31:0];
    } JPGE_SRPTRADDR @ 0x44;

    reg {
        name = "JPGE SWPTRADDR";
        desc = "Stream read/write pointer address (not used by the encoder as a pointer in single-picture mode). The Linux driver points it 16 bytes (SRPTR) or 32 bytes (SWPTR) below the stream address, as the HiSTB driver does. Board finding (Source: Hi3520D board read-back 2026-11-10, functional test): the 32 bytes below the stream address must not hold stale data; with a reused buffer that still held the previous JFIF header the second and later pictures lost their packet descriptor and the scan data started early; clearing those bytes (and the descriptor area) before every job fixed it, a per-job hardware reset did not. What the block reads there is Not verified on hardware. Layout: vendor header jpge_reg(r004).h (Hi3520D U-Boot 2010.06 upload), not in the data sheet. Hi3536D vendor module (Hi3536D V100 vendor module hi3536dv100_jpege.ko (SDK V1.0.1.0): static analysis plus execution of its register writer under qemu-arm on a RAM window, 2026-11-22 (shows what the vendor PROGRAMS, not what the silicon does)): the vendor ring buffer keeps the two pointer cells in a separate 128-byte structure (read-pointer cell at +0x40, write-pointer cell at +0x80, both 64-byte aligned: the module panics otherwise, as it does for a stream address or length that is not a multiple of 64); SRPTR points at the first, SWPTR at the second. The write-pointer cell holds a byte offset into the ring and wraps at STRMBUFLEN; the vendor derives the size of a frame as (write cell after the frame - write cell before the frame) mod length, and updates the read cell only when the application releases a stream. Confidence PROVEN for the allocation and use, INFERRED for the hardware semantics (initial write offset = the cell value; flow control against the read cell). Board 2026-11-23 (Hi3536D V100, NBD80XXS, source: board, confidence HIGH): the cell at the address written here is a byte offset into the stream ring: the block writes the first packet at STRMADDR plus the value in the cell, and the cell is advanced by the length of every packet it writes (0xA80 after one packet of 2688 bytes, 0xB40 after the three packets of a restart-interval picture). The driver's cells (stream - 16 for SRPTR and stream - 32 for SWPTR) work; moving them to the vendor alignment (stream - 64 and stream - 128, both 64-byte aligned) gives byte-identical output; an initial value other than 0 in the cells (0x40, 0x1000) moves the first packet by that offset (the descriptor is then not where the driver expects it).";

        field {
            name = "value";
            desc = "[inferred] Register value (the header union has no named bits).";
            sw = rw;
            hw = r;
        } value[31:0];
    } JPGE_SWPTRADDR @ 0x48;

    reg {
        name = "JPGE STRMBUFLEN";
        desc = "Stream buffer length in bytes, low 6 bits not stored (the Linux driver writes the length with bits [5:0] clear). Source: HiSTB driver (register semantics only), confidence MEDIUM; Source: Hi3520D board read-back 2026-11-10: values up to a few MiB accept full pictures. The buffer-full interrupt behavior is Not verified on hardware (never reached in the test). Previously: described as 64-byte units; the register value is the byte count with the low bits cleared. Layout: vendor header jpge_reg(r004).h (Hi3520D U-Boot 2010.06 upload), not in the data sheet. Hi3536D vendor module (Hi3536D V100 vendor module hi3536dv100_jpege.ko (SDK V1.0.1.0): static analysis plus execution of its register writer under qemu-arm on a RAM window, 2026-11-22 (shows what the vendor PROGRAMS, not what the silicon does)): the length is the size of the whole ring (multiple of 64, checked); the vendor starts a picture only when the free ring space is at least max(4096, aligned(w,16) * aligned(h,16) / 2) bytes (about 0.5 byte per pixel, plus the pending header), in the memory-reduction mode (module parameter JpegeMiniBufMode) half the ring, and the interrupt-mask bit 1 (buffer full) is enabled. The documented VENC stream buffer size for a channel is at least 1/2 and recommended 1x of w*h*1.5 bytes.";

        field {
            name = "BufferLength";
            desc = "Stream buffer length in bytes (bits [5:0] not stored). Source: HiSTB driver (register semantics only), confidence MEDIUM; Not verified on hardware at the limit.";
            sw = rw;
            hw = r;
        } BufferLength[31:6];
    } JPGE_STRMBUFLEN @ 0x4C;

    reg {
        name = "JPGE PTS0";
        desc = "Frame time stamp word. Observed in the HiSTB driver: written (never read) with the caller's frame PTS in jpge_set_register(), just before OUTSTD and START; its purpose in the hardware (copied into the packet descriptor?) is unknown. The Linux driver does not write it. Source: HiSTB driver (register semantics only), confidence LOW. Not verified on hardware. Layout: vendor header jpge_reg(r004).h (Hi3520D U-Boot 2010.06 upload), not in the data sheet. Hi3536D vendor module (Hi3536D V100 vendor module hi3536dv100_jpege.ko (SDK V1.0.1.0): static analysis plus execution of its register writer under qemu-arm on a RAM window, 2026-11-22 (shows what the vendor PROGRAMS, not what the silicon does)): written on every picture with the low 32 bits of the frame PTS; the vendor stream reader copies descriptor bytes 16..23 into the 64-bit PTS of the stream pack, so the hardware most likely copies PTS0/PTS1 there (INFERRED; board experiment E-PTS). PTS2 and PTS3 are written 0. Confidence PROVEN for the writes. Board 2026-11-23 (Hi3536D V100, NBD80XXS, source: board, confidence HIGH): PTS0 and PTS1 appear unchanged in bytes 16 to 23 of the packet descriptor (PTS0 0x11111111, PTS1 0x22222222 gave 11 11 11 11 22 22 22 22); PTS2 and PTS3 were written 0 and the descriptor bytes 24 to 31 stayed 0. Reset value 0.";

        field {
            name = "value";
            desc = "[inferred] Register value (the header union has no named bits).";
            sw = rw;
            hw = r;
        } value[31:0];
    } JPGE_PTS0 @ 0x70;

    reg {
        name = "JPGE PTS1";
        desc = "Time stamp word 1 (name only). Not accessed by the HiSTB JPGE driver; purpose unknown. Source: HiSTB driver (register semantics only), confidence LOW. Not verified on hardware. Layout: vendor header jpge_reg(r004).h (Hi3520D U-Boot 2010.06 upload), not in the data sheet. Hi3536D vendor module (Hi3536D V100 vendor module hi3536dv100_jpege.ko (SDK V1.0.1.0): static analysis plus execution of its register writer under qemu-arm on a RAM window, 2026-11-22 (shows what the vendor PROGRAMS, not what the silicon does)): written on every picture with the high 32 bits of the frame PTS (see PTS0).";

        field {
            name = "value";
            desc = "[inferred] Register value (the header union has no named bits).";
            sw = rw;
            hw = r;
        } value[31:0];
    } JPGE_PTS1 @ 0x74;

    reg {
        name = "JPGE PTS2";
        desc = "Time stamp word 2 (name only). Not accessed by the HiSTB JPGE driver; purpose unknown. Source: HiSTB driver (register semantics only), confidence LOW. Not verified on hardware. Layout: vendor header jpge_reg(r004).h (Hi3520D U-Boot 2010.06 upload), not in the data sheet. Hi3536D vendor module (Hi3536D V100 vendor module hi3536dv100_jpege.ko (SDK V1.0.1.0): static analysis plus execution of its register writer under qemu-arm on a RAM window, 2026-11-22 (shows what the vendor PROGRAMS, not what the silicon does)): written 0 on every picture.";

        field {
            name = "value";
            desc = "[inferred] Register value (the header union has no named bits).";
            sw = rw;
            hw = r;
        } value[31:0];
    } JPGE_PTS2 @ 0x78;

    reg {
        name = "JPGE PTS3";
        desc = "Time stamp word 3 (name only). Not accessed by the HiSTB JPGE driver; purpose unknown. Source: HiSTB driver (register semantics only), confidence LOW. Not verified on hardware. Layout: vendor header jpge_reg(r004).h (Hi3520D U-Boot 2010.06 upload), not in the data sheet. Hi3536D vendor module (Hi3536D V100 vendor module hi3536dv100_jpege.ko (SDK V1.0.1.0): static analysis plus execution of its register writer under qemu-arm on a RAM window, 2026-11-22 (shows what the vendor PROGRAMS, not what the silicon does)): written 0 on every picture.";

        field {
            name = "value";
            desc = "[inferred] Register value (the header union has no named bits).";
            sw = rw;
            hw = r;
        } value[31:0];
    } JPGE_PTS3 @ 0x7C;

    reg {
        name = "JPGE TIMEOUT";
        desc = "Hardware encode time-out threshold (name only). Not accessed by the HiSTB driver (PICFG timeoutEn is never set there) and not by the Linux driver, which uses a software watchdog; unit and purpose unknown. Source: HiSTB driver (register semantics only), confidence LOW. Not verified on hardware. Layout: vendor header jpge_reg(r004).h (Hi3520D U-Boot 2010.06 upload), not in the data sheet. Hi3536D vendor module (Hi3536D V100 vendor module hi3536dv100_jpege.ko (SDK V1.0.1.0): static analysis plus execution of its register writer under qemu-arm on a RAM window, 2026-11-22 (shows what the vendor PROGRAMS, not what the silicon does)): never written (JPEGU_SetTimeOut and JPEGU_GetTimeOut are empty functions); PICFG timeoutEn is still set to 1. Board 2026-11-23 (Hi3536D V100, NBD80XXS, source: board, confidence HIGH): reads 0 after the reset and is never written by the vendor stack (the vendor sets the PICFG time-out enable and leaves the limit at 0); the hardware time-out was not exercised beyond that.";

        field {
            name = "value";
            desc = "[inferred] Register value (the header union has no named bits).";
            sw = rw;
            hw = r;
        } value[31:0];
    } JPGE_TIMEOUT @ 0x80;

    reg {
        name = "JPGE TIMER";
        desc = "Hardware encode timer (name only). Not accessed by the HiSTB driver or the Linux driver; unit and purpose unknown. Source: HiSTB driver (register semantics only), confidence LOW. Not verified on hardware. Layout: vendor header jpge_reg(r004).h (Hi3520D U-Boot 2010.06 upload), not in the data sheet. Hi3536D vendor module (Hi3536D V100 vendor module hi3536dv100_jpege.ko (SDK V1.0.1.0): static analysis plus execution of its register writer under qemu-arm on a RAM window, 2026-11-22 (shows what the vendor PROGRAMS, not what the silicon does)): read once, for a debug print (JPEGU_OutputDebugInfo); never written. Board 2026-11-23 (Hi3536D V100, NBD80XXS, source: board, confidence HIGH): reads 0 after the reset; after a 320 x 240 4:2:0 encode it reads 0x00039E5B, 0x00039E44, 0x00039ECE (about 0.24 million ticks, stable from run to run), so it is the tick count of the last picture; with PICFG timeoutEn (bit 18) set the end of the picture additionally raises RAWINT bit 2 (0x4, masked in INTSTAT because INTMASK bit 2 is 0).";

        field {
            name = "value";
            desc = "[inferred] Register value (the header union has no named bits).";
            sw = rw;
            hw = r;
        } value[31:0];
    } JPGE_TIMER @ 0x84;

    reg {
        name = "JPGE OUTSTD";
        desc = "AXI outstanding request count. Reset 0 (Source: Hi3520D board read-back 2026-11-10); the HiSTB driver and the Linux driver write 2 and the encodes work. Other values: Not verified on hardware. Layout: vendor header jpge_reg(r004).h (Hi3520D U-Boot 2010.06 upload), not in the data sheet. Hi3536D vendor module (Hi3536D V100 vendor module hi3536dv100_jpege.ko (SDK V1.0.1.0): static analysis plus execution of its register writer under qemu-arm on a RAM window, 2026-11-22 (shows what the vendor PROGRAMS, not what the silicon does)): the HAL init writes outstdNum = 1 (read-modify-write of bits [3:0]); the value is never changed afterwards.";

        field {
            name = "outstdNum";
            desc = "AXI outstanding request count (reset 0: Source: Hi3520D board read-back 2026-11-10; written 2 by the drivers).";
            sw = rw;
            hw = r;
            reset = 0;
        } outstdNum[3:0];
    } JPGE_OUTSTD @ 0xA4;

    reg {
        name = "JPGE VERSION";
        desc = "Version word. Reads 0x56325234 (ASCII 'V2R4') on the Hi3520D (Source: Hi3520D board read-back 2026-11-10); also 0x56325234 on the Hi3518E V200 (Night Owl camera, 2026-11-11, PERI_CRG24 clock on, CRG restored; +0x010 reads 0x0D880000, +0x030..+0x048 0xFFFFFFFF, all else 0); matches the r004 layout name of the vendor header. Read-only is assumed from the name (Not verified on hardware). Layout: vendor header jpge_reg(r004).h (Hi3520D U-Boot 2010.06 upload), not in the data sheet. Hi3536D vendor module (Hi3536D V100 vendor module hi3536dv100_jpege.ko (SDK V1.0.1.0): static analysis plus execution of its register writer under qemu-arm on a RAM window, 2026-11-22 (shows what the vendor PROGRAMS, not what the silicon does)): the module never reads this register and has no code path that depends on it (its chip-version variable is not used); the Linux driver is the only reader.";

        field {
            name = "value";
            desc = "Version, 0x56325234 = 'V2R4' (Source: Hi3520D board read-back 2026-11-10).";
            sw = r;
            hw = r;
            reset = 0x56325234;
        } value[31:0];
    } JPGE_VERSION @ 0xFC;

    reg {
        name = "VPP configuration";
        desc = "[inferred] VPP configuration. Not in the data sheet. Source: vendor U-Boot 2010.06 upload `product/hiosd/dec/jpeg_reg.h` = `jpge_reg(r004).h` (GPL-2.0 U-Boot tree, Huawei copyright 2012; github.com/Axl-zhang/hisilicon-hi3520d-uboot), union `U_JPGE_CFG`, struct offset 0x500 (GPL-2.0; same SDK generation as the Hi3520D, chip not named in the file). Reset value and access type unknown (modelled RW, no reset). Confidence: medium (vendor header for this chip family, not hardware verified). Hi3536D vendor module (Hi3536D V100 vendor module hi3536dv100_jpege.ko (SDK V1.0.1.0): static analysis plus execution of its register writer under qemu-arm on a RAM window, 2026-11-22 (shows what the vendor PROGRAMS, not what the silicon does)): for a plain encode (no overlay) the module does a read-modify-write of this register that CLEARS osdEn (bit 5) on every picture and writes nothing else of the VPP window; with an overlay it sets osdEn and programs 0x510-0x5C0 as described there. Board read 2026-11-22 (Hi3536D NBD80XXS, before and after the first encode): reads 0. Confidence PROVEN. Board 2026-11-23 (Hi3536D V100, NBD80XXS, source: board, confidence HIGH): the whole window 0x500 to 0x56C reads 0 after the reset and 0x590 to 0x5D0 reads 0, 0x570 to 0x58C (the region DMA address words) read 0xFFFFFFFF, before and after encodes: no overlay state is left in the block.";

        field {
            name = "osdEn";
            desc = "[inferred] OSD overlay enable. (vendor header `jpeg_reg.h` (JPGE r004) field `osdEn`; access and reset unknown, modelled RW)";
            sw = rw;
            hw = r;
        } osdEn[5:5];
    } VPP_CFG @ 0x500;

    reg {
        name = "VPP OSD configuration";
        desc = "[inferred] VPP OSD configuration. Not in the data sheet. Source: vendor U-Boot 2010.06 upload `product/hiosd/dec/jpeg_reg.h` = `jpge_reg(r004).h` (GPL-2.0 U-Boot tree, Huawei copyright 2012; github.com/Axl-zhang/hisilicon-hi3520d-uboot), union `U_JPGE_OSD_CFG`, struct offset 0x510 (GPL-2.0; same SDK generation as the Hi3520D, chip not named in the file). Reset value and access type unknown (modelled RW, no reset). Confidence: medium (vendor header for this chip family, not hardware verified). Hi3536D vendor module (Hi3536D V100 vendor module hi3536dv100_jpege.ko (SDK V1.0.1.0): static analysis plus execution of its register writer under qemu-arm on a RAM window, 2026-11-22 (shows what the vendor PROGRAMS, not what the silicon does)): with overlays the module writes osdRgbfmt = 1 when the region format code is 5 (otherwise 0), osdNEn (bits [31:24]) = 1 for every region index below the region count, and osdNGlobalEn (bits [23:16]) = 0 always; for a plain encode it does not touch this register. Board read 2026-11-22 (Hi3536D, 0x510 reads 0 before and after the first encode). Bit positions PROVEN against the vendor code.";

        field {
            name = "osd7En";
            desc = "[inferred] Osd7En. (vendor header `jpeg_reg.h` (JPGE r004) field `osd7En`; access and reset unknown, modelled RW)";
            sw = rw;
            hw = r;
        } osd7En[31:31];

        field {
            name = "osd6En";
            desc = "[inferred] Osd6En. (vendor header `jpeg_reg.h` (JPGE r004) field `osd6En`; access and reset unknown, modelled RW)";
            sw = rw;
            hw = r;
        } osd6En[30:30];

        field {
            name = "osd5En";
            desc = "[inferred] Osd5En. (vendor header `jpeg_reg.h` (JPGE r004) field `osd5En`; access and reset unknown, modelled RW)";
            sw = rw;
            hw = r;
        } osd5En[29:29];

        field {
            name = "osd4En";
            desc = "[inferred] Osd4En. (vendor header `jpeg_reg.h` (JPGE r004) field `osd4En`; access and reset unknown, modelled RW)";
            sw = rw;
            hw = r;
        } osd4En[28:28];

        field {
            name = "osd3En";
            desc = "[inferred] Osd3En. (vendor header `jpeg_reg.h` (JPGE r004) field `osd3En`; access and reset unknown, modelled RW)";
            sw = rw;
            hw = r;
        } osd3En[27:27];

        field {
            name = "osd2En";
            desc = "[inferred] Osd2En. (vendor header `jpeg_reg.h` (JPGE r004) field `osd2En`; access and reset unknown, modelled RW)";
            sw = rw;
            hw = r;
        } osd2En[26:26];

        field {
            name = "osd1En";
            desc = "[inferred] Osd1En. (vendor header `jpeg_reg.h` (JPGE r004) field `osd1En`; access and reset unknown, modelled RW)";
            sw = rw;
            hw = r;
        } osd1En[25:25];

        field {
            name = "osd0En";
            desc = "[inferred] Osd0En. (vendor header `jpeg_reg.h` (JPGE r004) field `osd0En`; access and reset unknown, modelled RW)";
            sw = rw;
            hw = r;
        } osd0En[24:24];

        field {
            name = "osd7GlobalEn";
            desc = "[inferred] Osd7GlobalEn. (vendor header `jpeg_reg.h` (JPGE r004) field `osd7GlobalEn`; access and reset unknown, modelled RW)";
            sw = rw;
            hw = r;
        } osd7GlobalEn[23:23];

        field {
            name = "osd6GlobalEn";
            desc = "[inferred] Osd6GlobalEn. (vendor header `jpeg_reg.h` (JPGE r004) field `osd6GlobalEn`; access and reset unknown, modelled RW)";
            sw = rw;
            hw = r;
        } osd6GlobalEn[22:22];

        field {
            name = "osd5GlobalEn";
            desc = "[inferred] Osd5GlobalEn. (vendor header `jpeg_reg.h` (JPGE r004) field `osd5GlobalEn`; access and reset unknown, modelled RW)";
            sw = rw;
            hw = r;
        } osd5GlobalEn[21:21];

        field {
            name = "osd4GlobalEn";
            desc = "[inferred] Osd4GlobalEn. (vendor header `jpeg_reg.h` (JPGE r004) field `osd4GlobalEn`; access and reset unknown, modelled RW)";
            sw = rw;
            hw = r;
        } osd4GlobalEn[20:20];

        field {
            name = "osd3GlobalEn";
            desc = "[inferred] Osd3GlobalEn. (vendor header `jpeg_reg.h` (JPGE r004) field `osd3GlobalEn`; access and reset unknown, modelled RW)";
            sw = rw;
            hw = r;
        } osd3GlobalEn[19:19];

        field {
            name = "osd2GlobalEn";
            desc = "[inferred] Osd2GlobalEn. (vendor header `jpeg_reg.h` (JPGE r004) field `osd2GlobalEn`; access and reset unknown, modelled RW)";
            sw = rw;
            hw = r;
        } osd2GlobalEn[18:18];

        field {
            name = "osd1GlobalEn";
            desc = "[inferred] Osd1GlobalEn. (vendor header `jpeg_reg.h` (JPGE r004) field `osd1GlobalEn`; access and reset unknown, modelled RW)";
            sw = rw;
            hw = r;
        } osd1GlobalEn[17:17];

        field {
            name = "osd0GlobalEn";
            desc = "[inferred] Osd0GlobalEn. (vendor header `jpeg_reg.h` (JPGE r004) field `osd0GlobalEn`; access and reset unknown, modelled RW)";
            sw = rw;
            hw = r;
        } osd0GlobalEn[16:16];

        field {
            name = "osdRgbfmt";
            desc = "[inferred] OSD pixel format. (vendor header `jpeg_reg.h` (JPGE r004) field `osdRgbfmt`; access and reset unknown, modelled RW)";
            sw = rw;
            hw = r;
        } osdRgbfmt[0:0];
    } VPP_OSD_CFG @ 0x510;

    reg {
        name = "VPP OSD01 alpha";
        desc = "[inferred] VPP OSD01 alpha. Not in the data sheet. Source: vendor U-Boot 2010.06 upload `product/hiosd/dec/jpeg_reg.h` = `jpge_reg(r004).h` (GPL-2.0 U-Boot tree, Huawei copyright 2012; github.com/Axl-zhang/hisilicon-hi3520d-uboot), union `U_JPGE_OSD01_ALPHA`, struct offset 0x514 (GPL-2.0; same SDK generation as the Hi3520D, chip not named in the file). Reset value and access type unknown (modelled RW, no reset). Confidence: medium (vendor header for this chip family, not hardware verified). Hi3536D vendor module (Hi3536D V100 vendor module hi3536dv100_jpege.ko (SDK V1.0.1.0): static analysis plus execution of its register writer under qemu-arm on a RAM window, 2026-11-22 (shows what the vendor PROGRAMS, not what the silicon does)): per region the module writes byte 0 = alpha0 and byte 1 = alpha1 of the first region and byte 2/3 of the second (positions match this layout). Region descriptor stride in the vendor structure 0x54 bytes: x +0x0C, y +0x10, w +0x14, h +0x18, layer +0x1C, global alpha +0x20, alpha1 +0x24, alpha0 +0x28, DMA address +0x2C, stride +0x30.";

        field {
            name = "osd1Alpha1";
            desc = "[inferred] Osd1Alpha1. (vendor header `jpeg_reg.h` (JPGE r004) field `osd1Alpha1`; access and reset unknown, modelled RW)";
            sw = rw;
            hw = r;
        } osd1Alpha1[31:24];

        field {
            name = "osd1Alpha0";
            desc = "[inferred] Osd1Alpha0. (vendor header `jpeg_reg.h` (JPGE r004) field `osd1Alpha0`; access and reset unknown, modelled RW)";
            sw = rw;
            hw = r;
        } osd1Alpha0[23:16];

        field {
            name = "osd0Alpha1";
            desc = "[inferred] Osd0Alpha1. (vendor header `jpeg_reg.h` (JPGE r004) field `osd0Alpha1`; access and reset unknown, modelled RW)";
            sw = rw;
            hw = r;
        } osd0Alpha1[15:8];

        field {
            name = "osd0Alpha0";
            desc = "[inferred] Osd0Alpha0. (vendor header `jpeg_reg.h` (JPGE r004) field `osd0Alpha0`; access and reset unknown, modelled RW)";
            sw = rw;
            hw = r;
        } osd0Alpha0[7:0];
    } VPP_OSD01_ALPHA @ 0x514;

    reg {
        name = "VPP OSD23 alpha";
        desc = "[inferred] VPP OSD23 alpha. Not in the data sheet. Source: vendor U-Boot 2010.06 upload `product/hiosd/dec/jpeg_reg.h` = `jpge_reg(r004).h` (GPL-2.0 U-Boot tree, Huawei copyright 2012; github.com/Axl-zhang/hisilicon-hi3520d-uboot), union `U_JPGE_OSD23_ALPHA`, struct offset 0x518 (GPL-2.0; same SDK generation as the Hi3520D, chip not named in the file). Reset value and access type unknown (modelled RW, no reset). Confidence: medium (vendor header for this chip family, not hardware verified).";

        field {
            name = "osd3Alpha1";
            desc = "[inferred] Osd3Alpha1. (vendor header `jpeg_reg.h` (JPGE r004) field `osd3Alpha1`; access and reset unknown, modelled RW)";
            sw = rw;
            hw = r;
        } osd3Alpha1[31:24];

        field {
            name = "osd3Alpha0";
            desc = "[inferred] Osd3Alpha0. (vendor header `jpeg_reg.h` (JPGE r004) field `osd3Alpha0`; access and reset unknown, modelled RW)";
            sw = rw;
            hw = r;
        } osd3Alpha0[23:16];

        field {
            name = "osd2Alpha1";
            desc = "[inferred] Osd2Alpha1. (vendor header `jpeg_reg.h` (JPGE r004) field `osd2Alpha1`; access and reset unknown, modelled RW)";
            sw = rw;
            hw = r;
        } osd2Alpha1[15:8];

        field {
            name = "osd2Alpha0";
            desc = "[inferred] Osd2Alpha0. (vendor header `jpeg_reg.h` (JPGE r004) field `osd2Alpha0`; access and reset unknown, modelled RW)";
            sw = rw;
            hw = r;
        } osd2Alpha0[7:0];
    } VPP_OSD23_ALPHA @ 0x518;

    reg {
        name = "VPP OSD45 alpha";
        desc = "[inferred] VPP OSD45 alpha. Not in the data sheet. Source: vendor U-Boot 2010.06 upload `product/hiosd/dec/jpeg_reg.h` = `jpge_reg(r004).h` (GPL-2.0 U-Boot tree, Huawei copyright 2012; github.com/Axl-zhang/hisilicon-hi3520d-uboot), union `U_JPGE_OSD45_ALPHA`, struct offset 0x51C (GPL-2.0; same SDK generation as the Hi3520D, chip not named in the file). Reset value and access type unknown (modelled RW, no reset). Confidence: medium (vendor header for this chip family, not hardware verified).";

        field {
            name = "osd5Alpha1";
            desc = "[inferred] Osd5Alpha1. (vendor header `jpeg_reg.h` (JPGE r004) field `osd5Alpha1`; access and reset unknown, modelled RW)";
            sw = rw;
            hw = r;
        } osd5Alpha1[31:24];

        field {
            name = "osd5Alpha0";
            desc = "[inferred] Osd5Alpha0. (vendor header `jpeg_reg.h` (JPGE r004) field `osd5Alpha0`; access and reset unknown, modelled RW)";
            sw = rw;
            hw = r;
        } osd5Alpha0[23:16];

        field {
            name = "osd4Alpha1";
            desc = "[inferred] Osd4Alpha1. (vendor header `jpeg_reg.h` (JPGE r004) field `osd4Alpha1`; access and reset unknown, modelled RW)";
            sw = rw;
            hw = r;
        } osd4Alpha1[15:8];

        field {
            name = "osd4Alpha0";
            desc = "[inferred] Osd4Alpha0. (vendor header `jpeg_reg.h` (JPGE r004) field `osd4Alpha0`; access and reset unknown, modelled RW)";
            sw = rw;
            hw = r;
        } osd4Alpha0[7:0];
    } VPP_OSD45_ALPHA @ 0x51C;

    reg {
        name = "VPP OSD67 alpha";
        desc = "[inferred] VPP OSD67 alpha. Not in the data sheet. Source: vendor U-Boot 2010.06 upload `product/hiosd/dec/jpeg_reg.h` = `jpge_reg(r004).h` (GPL-2.0 U-Boot tree, Huawei copyright 2012; github.com/Axl-zhang/hisilicon-hi3520d-uboot), union `U_JPGE_OSD67_ALPHA`, struct offset 0x520 (GPL-2.0; same SDK generation as the Hi3520D, chip not named in the file). Reset value and access type unknown (modelled RW, no reset). Confidence: medium (vendor header for this chip family, not hardware verified).";

        field {
            name = "osd7Alpha1";
            desc = "[inferred] Osd7Alpha1. (vendor header `jpeg_reg.h` (JPGE r004) field `osd7Alpha1`; access and reset unknown, modelled RW)";
            sw = rw;
            hw = r;
        } osd7Alpha1[31:24];

        field {
            name = "osd7Alpha0";
            desc = "[inferred] Osd7Alpha0. (vendor header `jpeg_reg.h` (JPGE r004) field `osd7Alpha0`; access and reset unknown, modelled RW)";
            sw = rw;
            hw = r;
        } osd7Alpha0[23:16];

        field {
            name = "osd6Alpha1";
            desc = "[inferred] Osd6Alpha1. (vendor header `jpeg_reg.h` (JPGE r004) field `osd6Alpha1`; access and reset unknown, modelled RW)";
            sw = rw;
            hw = r;
        } osd6Alpha1[15:8];

        field {
            name = "osd6Alpha0";
            desc = "[inferred] Osd6Alpha0. (vendor header `jpeg_reg.h` (JPGE r004) field `osd6Alpha0`; access and reset unknown, modelled RW)";
            sw = rw;
            hw = r;
        } osd6Alpha0[7:0];
    } VPP_OSD67_ALPHA @ 0x520;

    reg {
        name = "VPP OSD ALPHA0123";
        desc = "[inferred] VPP OSD ALPHA0123. Not in the data sheet. Source: vendor U-Boot 2010.06 upload `product/hiosd/dec/jpeg_reg.h` = `jpge_reg(r004).h` (GPL-2.0 U-Boot tree, Huawei copyright 2012; github.com/Axl-zhang/hisilicon-hi3520d-uboot), union `U_JPGE_OSD_ALPHA0123`, struct offset 0x524 (GPL-2.0; same SDK generation as the Hi3520D, chip not named in the file). Reset value and access type unknown (modelled RW, no reset). Confidence: medium (vendor header for this chip family, not hardware verified).";

        field {
            name = "osd3GlobalAlpha";
            desc = "[inferred] Osd3GlobalAlpha. (vendor header `jpeg_reg.h` (JPGE r004) field `osd3GlobalAlpha`; access and reset unknown, modelled RW)";
            sw = rw;
            hw = r;
        } osd3GlobalAlpha[31:24];

        field {
            name = "osd2GlobalAlpha";
            desc = "[inferred] Osd2GlobalAlpha. (vendor header `jpeg_reg.h` (JPGE r004) field `osd2GlobalAlpha`; access and reset unknown, modelled RW)";
            sw = rw;
            hw = r;
        } osd2GlobalAlpha[23:16];

        field {
            name = "osd1GlobalAlpha";
            desc = "[inferred] Osd1GlobalAlpha. (vendor header `jpeg_reg.h` (JPGE r004) field `osd1GlobalAlpha`; access and reset unknown, modelled RW)";
            sw = rw;
            hw = r;
        } osd1GlobalAlpha[15:8];

        field {
            name = "osd0GlobalAlpha";
            desc = "[inferred] Osd0GlobalAlpha. (vendor header `jpeg_reg.h` (JPGE r004) field `osd0GlobalAlpha`; access and reset unknown, modelled RW)";
            sw = rw;
            hw = r;
        } osd0GlobalAlpha[7:0];
    } VPP_OSD_ALPHA0123 @ 0x524;

    reg {
        name = "VPP OSD ALPHA4567";
        desc = "[inferred] VPP OSD ALPHA4567. Not in the data sheet. Source: vendor U-Boot 2010.06 upload `product/hiosd/dec/jpeg_reg.h` = `jpge_reg(r004).h` (GPL-2.0 U-Boot tree, Huawei copyright 2012; github.com/Axl-zhang/hisilicon-hi3520d-uboot), union `U_JPGE_OSD_ALPHA4567`, struct offset 0x528 (GPL-2.0; same SDK generation as the Hi3520D, chip not named in the file). Reset value and access type unknown (modelled RW, no reset). Confidence: medium (vendor header for this chip family, not hardware verified).";

        field {
            name = "osd7GlobalAlpha";
            desc = "[inferred] Osd7GlobalAlpha. (vendor header `jpeg_reg.h` (JPGE r004) field `osd7GlobalAlpha`; access and reset unknown, modelled RW)";
            sw = rw;
            hw = r;
        } osd7GlobalAlpha[31:24];

        field {
            name = "osd6GlobalAlpha";
            desc = "[inferred] Osd6GlobalAlpha. (vendor header `jpeg_reg.h` (JPGE r004) field `osd6GlobalAlpha`; access and reset unknown, modelled RW)";
            sw = rw;
            hw = r;
        } osd6GlobalAlpha[23:16];

        field {
            name = "osd5GlobalAlpha";
            desc = "[inferred] Osd5GlobalAlpha. (vendor header `jpeg_reg.h` (JPGE r004) field `osd5GlobalAlpha`; access and reset unknown, modelled RW)";
            sw = rw;
            hw = r;
        } osd5GlobalAlpha[15:8];

        field {
            name = "osd4GlobalAlpha";
            desc = "[inferred] Osd4GlobalAlpha. (vendor header `jpeg_reg.h` (JPGE r004) field `osd4GlobalAlpha`; access and reset unknown, modelled RW)";
            sw = rw;
            hw = r;
        } osd4GlobalAlpha[7:0];
    } VPP_OSD_ALPHA4567 @ 0x528;

    reg {
        name = "VPP OSD position";
        desc = "[inferred] VPP OSD position. Array of 8 consecutive 32-bit words (header `VPP_OSD_POS[8]`). Not in the data sheet. Source: vendor U-Boot 2010.06 upload `product/hiosd/dec/jpeg_reg.h` = `jpge_reg(r004).h` (GPL-2.0 U-Boot tree, Huawei copyright 2012; github.com/Axl-zhang/hisilicon-hi3520d-uboot), union `U_JPGE_OSD_POS`, struct offset 0x530 (GPL-2.0; same SDK generation as the Hi3520D, chip not named in the file). Reset value and access type unknown (modelled RW, no reset). Confidence: medium (vendor header for this chip family, not hardware verified). Hi3536D vendor module (Hi3536D V100 vendor module hi3536dv100_jpege.ko (SDK V1.0.1.0): static analysis plus execution of its register writer under qemu-arm on a RAM window, 2026-11-22 (shows what the vendor PROGRAMS, not what the silicon does)): word i = x in [12:0], y in [28:16] of region i, written only when an overlay is active.";

        field {
            name = "osdStartY";
            desc = "[inferred] OsdStartY. (vendor header `jpeg_reg.h` (JPGE r004) field `osdStartY`; access and reset unknown, modelled RW)";
            sw = rw;
            hw = r;
        } osdStartY[28:16];

        field {
            name = "osdStartX";
            desc = "[inferred] OsdStartX. (vendor header `jpeg_reg.h` (JPGE r004) field `osdStartX`; access and reset unknown, modelled RW)";
            sw = rw;
            hw = r;
        } osdStartX[12:0];
    } VPP_OSD_POS[8] @ 0x530 += 0x4;

    reg {
        name = "VPP OSD SIZE";
        desc = "[inferred] VPP OSD SIZE. Array of 8 consecutive 32-bit words (header `VPP_OSD_SIZE[8]`). Not in the data sheet. Source: vendor U-Boot 2010.06 upload `product/hiosd/dec/jpeg_reg.h` = `jpge_reg(r004).h` (GPL-2.0 U-Boot tree, Huawei copyright 2012; github.com/Axl-zhang/hisilicon-hi3520d-uboot), union `U_JPGE_OSD_SIZE`, struct offset 0x550 (GPL-2.0; same SDK generation as the Hi3520D, chip not named in the file). Reset value and access type unknown (modelled RW, no reset). Confidence: medium (vendor header for this chip family, not hardware verified). Hi3536D vendor module (Hi3536D V100 vendor module hi3536dv100_jpege.ko (SDK V1.0.1.0): static analysis plus execution of its register writer under qemu-arm on a RAM window, 2026-11-22 (shows what the vendor PROGRAMS, not what the silicon does)): word i = (w - 1) in [12:0], (h - 1) in [28:16] of region i, written only when an overlay is active.";

        field {
            name = "osdH";
            desc = "[inferred] OsdH. (vendor header `jpeg_reg.h` (JPGE r004) field `osdH`; access and reset unknown, modelled RW)";
            sw = rw;
            hw = r;
        } osdH[28:16];

        field {
            name = "osdW";
            desc = "[inferred] OsdW. (vendor header `jpeg_reg.h` (JPGE r004) field `osdW`; access and reset unknown, modelled RW)";
            sw = rw;
            hw = r;
        } osdW[12:0];
    } VPP_OSD_SIZE[8] @ 0x550 += 0x4;

    reg {
        name = "VPP OSD address";
        desc = "[inferred] VPP OSD address. Array of 8 consecutive 32-bit words (header `VPP_OSD_ADDR[8]`). Not in the data sheet. Source: vendor U-Boot 2010.06 upload `product/hiosd/dec/jpeg_reg.h` = `jpge_reg(r004).h` (GPL-2.0 U-Boot tree, Huawei copyright 2012; github.com/Axl-zhang/hisilicon-hi3520d-uboot), union `None`, struct offset 0x570 (GPL-2.0; same SDK generation as the Hi3520D, chip not named in the file). Reset value and access type unknown (modelled RW, no reset). Confidence: medium (vendor header for this chip family, not hardware verified). Hi3536D vendor module (Hi3536D V100 vendor module hi3536dv100_jpege.ko (SDK V1.0.1.0): static analysis plus execution of its register writer under qemu-arm on a RAM window, 2026-11-22 (shows what the vendor PROGRAMS, not what the silicon does)): word i = DMA address of the overlay bitmap of region i, written only when an overlay is active.";

        field {
            name = "value";
            desc = "[inferred] Register value (the header union has no named bits).";
            sw = rw;
            hw = r;
        } value[31:0];
    } VPP_OSD_ADDR[8] @ 0x570 += 0x4;

    reg {
        name = "VPP OSD stride";
        desc = "[inferred] VPP OSD stride. Array of 8 consecutive 32-bit words (header `VPP_OSD_STRIDE[8]`). Not in the data sheet. Source: vendor U-Boot 2010.06 upload `product/hiosd/dec/jpeg_reg.h` = `jpge_reg(r004).h` (GPL-2.0 U-Boot tree, Huawei copyright 2012; github.com/Axl-zhang/hisilicon-hi3520d-uboot), union `U_JPGE_OSD_STRIDE`, struct offset 0x590 (GPL-2.0; same SDK generation as the Hi3520D, chip not named in the file). Reset value and access type unknown (modelled RW, no reset). Confidence: medium (vendor header for this chip family, not hardware verified). Hi3536D vendor module (Hi3536D V100 vendor module hi3536dv100_jpege.ko (SDK V1.0.1.0): static analysis plus execution of its register writer under qemu-arm on a RAM window, 2026-11-22 (shows what the vendor PROGRAMS, not what the silicon does)): word i = stride in bytes of region i in [15:0], written only when an overlay is active.";

        field {
            name = "osdStride";
            desc = "[inferred] OsdStride. (vendor header `jpeg_reg.h` (JPGE r004) field `osdStride`; access and reset unknown, modelled RW)";
            sw = rw;
            hw = r;
        } osdStride[15:0];
    } VPP_OSD_STRIDE[8] @ 0x590 += 0x4;

    reg {
        name = "VPP OSD LAYERID";
        desc = "[inferred] VPP OSD LAYERID. Not in the data sheet. Source: vendor U-Boot 2010.06 upload `product/hiosd/dec/jpeg_reg.h` = `jpge_reg(r004).h` (GPL-2.0 U-Boot tree, Huawei copyright 2012; github.com/Axl-zhang/hisilicon-hi3520d-uboot), union `U_JPGE_OSD_LAYERID`, struct offset 0x5C0 (GPL-2.0; same SDK generation as the Hi3520D, chip not named in the file). Reset value and access type unknown (modelled RW, no reset). Confidence: medium (vendor header for this chip family, not hardware verified). Hi3536D vendor module (Hi3536D V100 vendor module hi3536dv100_jpege.ko (SDK V1.0.1.0): static analysis plus execution of its register writer under qemu-arm on a RAM window, 2026-11-22 (shows what the vendor PROGRAMS, not what the silicon does)): layer ids written 3 bits per region at bit 4*i; written only when an overlay is active. The vendor module never writes VPP OSD CINVCFG (0x5D0).";

        field {
            name = "osd7LayerId";
            desc = "[inferred] Osd7LayerId. (vendor header `jpeg_reg.h` (JPGE r004) field `osd7LayerId`; access and reset unknown, modelled RW)";
            sw = rw;
            hw = r;
        } osd7LayerId[30:28];

        field {
            name = "osd6LayerId";
            desc = "[inferred] Osd6LayerId. (vendor header `jpeg_reg.h` (JPGE r004) field `osd6LayerId`; access and reset unknown, modelled RW)";
            sw = rw;
            hw = r;
        } osd6LayerId[26:24];

        field {
            name = "osd5LayerId";
            desc = "[inferred] Osd5LayerId. (vendor header `jpeg_reg.h` (JPGE r004) field `osd5LayerId`; access and reset unknown, modelled RW)";
            sw = rw;
            hw = r;
        } osd5LayerId[22:20];

        field {
            name = "osd4LayerId";
            desc = "[inferred] Osd4LayerId. (vendor header `jpeg_reg.h` (JPGE r004) field `osd4LayerId`; access and reset unknown, modelled RW)";
            sw = rw;
            hw = r;
        } osd4LayerId[18:16];

        field {
            name = "osd3LayerId";
            desc = "[inferred] Osd3LayerId. (vendor header `jpeg_reg.h` (JPGE r004) field `osd3LayerId`; access and reset unknown, modelled RW)";
            sw = rw;
            hw = r;
        } osd3LayerId[14:12];

        field {
            name = "osd2LayerId";
            desc = "[inferred] Osd2LayerId. (vendor header `jpeg_reg.h` (JPGE r004) field `osd2LayerId`; access and reset unknown, modelled RW)";
            sw = rw;
            hw = r;
        } osd2LayerId[10:8];

        field {
            name = "osd1LayerId";
            desc = "[inferred] Osd1LayerId. (vendor header `jpeg_reg.h` (JPGE r004) field `osd1LayerId`; access and reset unknown, modelled RW)";
            sw = rw;
            hw = r;
        } osd1LayerId[6:4];

        field {
            name = "osd0LayerId";
            desc = "[inferred] Osd0LayerId. (vendor header `jpeg_reg.h` (JPGE r004) field `osd0LayerId`; access and reset unknown, modelled RW)";
            sw = rw;
            hw = r;
        } osd0LayerId[2:0];
    } VPP_OSD_LAYERID @ 0x5C0;

    reg {
        name = "VPP OSD CINVCFG";
        desc = "[inferred] VPP OSD CINVCFG. Not in the data sheet. Source: vendor U-Boot 2010.06 upload `product/hiosd/dec/jpeg_reg.h` = `jpge_reg(r004).h` (GPL-2.0 U-Boot tree, Huawei copyright 2012; github.com/Axl-zhang/hisilicon-hi3520d-uboot), union `U_JPGE_OSD_CINVCFG`, struct offset 0x5D0 (GPL-2.0; same SDK generation as the Hi3520D, chip not named in the file). Reset value and access type unknown (modelled RW, no reset). Confidence: medium (vendor header for this chip family, not hardware verified).";

        field {
            name = "osdCinvMode";
            desc = "[inferred] OsdCinvMode. (vendor header `jpeg_reg.h` (JPGE r004) field `osdCinvMode`; access and reset unknown, modelled RW)";
            sw = rw;
            hw = r;
        } osdCinvMode[24:24];

        field {
            name = "osdCinvThr";
            desc = "[inferred] OsdCinvThr. (vendor header `jpeg_reg.h` (JPGE r004) field `osdCinvThr`; access and reset unknown, modelled RW)";
            sw = rw;
            hw = r;
        } osdCinvThr[23:16];

        field {
            name = "osdCinvHeight";
            desc = "[inferred] OsdCinvHeight. (vendor header `jpeg_reg.h` (JPGE r004) field `osdCinvHeight`; access and reset unknown, modelled RW)";
            sw = rw;
            hw = r;
        } osdCinvHeight[11:10];

        field {
            name = "osdCinvWidth";
            desc = "[inferred] OsdCinvWidth. (vendor header `jpeg_reg.h` (JPGE r004) field `osdCinvWidth`; access and reset unknown, modelled RW)";
            sw = rw;
            hw = r;
        } osdCinvWidth[9:8];

        field {
            name = "osd7CinvEn";
            desc = "[inferred] Osd7CinvEn. (vendor header `jpeg_reg.h` (JPGE r004) field `osd7CinvEn`; access and reset unknown, modelled RW)";
            sw = rw;
            hw = r;
        } osd7CinvEn[7:7];

        field {
            name = "osd6CinvEn";
            desc = "[inferred] Osd6CinvEn. (vendor header `jpeg_reg.h` (JPGE r004) field `osd6CinvEn`; access and reset unknown, modelled RW)";
            sw = rw;
            hw = r;
        } osd6CinvEn[6:6];

        field {
            name = "osd5CinvEn";
            desc = "[inferred] Osd5CinvEn. (vendor header `jpeg_reg.h` (JPGE r004) field `osd5CinvEn`; access and reset unknown, modelled RW)";
            sw = rw;
            hw = r;
        } osd5CinvEn[5:5];

        field {
            name = "osd4CinvEn";
            desc = "[inferred] Osd4CinvEn. (vendor header `jpeg_reg.h` (JPGE r004) field `osd4CinvEn`; access and reset unknown, modelled RW)";
            sw = rw;
            hw = r;
        } osd4CinvEn[4:4];

        field {
            name = "osd3CinvEn";
            desc = "[inferred] Osd3CinvEn. (vendor header `jpeg_reg.h` (JPGE r004) field `osd3CinvEn`; access and reset unknown, modelled RW)";
            sw = rw;
            hw = r;
        } osd3CinvEn[3:3];

        field {
            name = "osd2CinvEn";
            desc = "[inferred] Osd2CinvEn. (vendor header `jpeg_reg.h` (JPGE r004) field `osd2CinvEn`; access and reset unknown, modelled RW)";
            sw = rw;
            hw = r;
        } osd2CinvEn[2:2];

        field {
            name = "osd1CinvEn";
            desc = "[inferred] Osd1CinvEn. (vendor header `jpeg_reg.h` (JPGE r004) field `osd1CinvEn`; access and reset unknown, modelled RW)";
            sw = rw;
            hw = r;
        } osd1CinvEn[1:1];

        field {
            name = "osd0CinvEn";
            desc = "[inferred] Osd0CinvEn. (vendor header `jpeg_reg.h` (JPGE r004) field `osd0CinvEn`; access and reset unknown, modelled RW)";
            sw = rw;
            hw = r;
        } osd0CinvEn[0:0];
    } VPP_OSD_CINVCFG @ 0x5D0;

    reg {
        name = "JPGE QPT";
        desc = "Quantization tables, 48 words: Y at words 0..15, Cb at 16..31, Cr at 32..47 (Source: HiSTB driver (register semantics only), confidence MEDIUM; the Linux driver writes Y, then the chroma table twice). Packing (HiSTB driver, MEDIUM): word n holds the 8-bit divisors of the natural-order (raster) entries s, s+8, s+16, s+24 in QP0..QP3 with s = (n & 1) * 32 + n / 2. Previously: 'entry 4n+k' (a guess from the field names); the vendor driver does not store the table that way. Board facts (Source: Hi3520D board read-back 2026-11-10): the window reads back 0 after a write (devmem write 0x12345678, read 0), so it is write-only or its read port is not wired (inferred, Not verified on hardware); the encoded size follows the quality setting (5812/6429/9075/11917 bytes at quality 10/50/95/100), so the writes take effect. Only entry 0 and the overall scale are confirmed by those pictures (flat color bars): the position of the other 63 entries is Not verified on hardware until a textured picture is compared with libjpeg at the same quality. Layout: vendor header jpge_reg(r004).h (Hi3520D U-Boot 2010.06 upload), not in the data sheet. Hi3536D vendor module (Hi3536D V100 vendor module hi3536dv100_jpege.ko (SDK V1.0.1.0): static analysis plus execution of its register writer under qemu-arm on a RAM window, 2026-11-22 (shows what the vendor PROGRAMS, not what the silicon does)): the module scales three 64-byte tables (Y, Cb, Cr) from its base tables (the T.81 example tables by default; user tables are used unchanged at quality 50) with the plain IJG formula, factor = 5000 / q for q < 50 else 200 - 2q, entry = clamp((base * factor + 50) / 100, 1, 255), for every quality 1..99 (the vendor interface limits Qfactor to 1..99; at 100 and above the module would use factor 2, which is unreachable). The three tables are written as 16 words each at words 0..15 (Y), 16..31 (Cb), 32..47 (Cr), each word = four consecutive bytes of the table kept in COLUMN-major (transposed natural) order, low byte first. This packing is algebraically and numerically identical to the packing of this description (word n = natural entries s, s+8, s+16, s+24 with s = (n & 1) * 32 + n / 2): verified for q = 0..101 against the module output, zero differences. No dead-zone tables or other quantization registers are programmed. Confidence PROVEN for the programmed words.";

        field {
            name = "QP3";
            desc = "Quantization divisor of natural-order entry s + 24 (word n = 0..15 of a table, s = (n & 1) * 32 + n / 2). Source: HiSTB driver (register semantics only), confidence MEDIUM; entry 0 and the scale confirmed (Source: Hi3520D board read-back 2026-11-10), the rest Not verified on hardware. Previously: entry 4n+3. Reads back 0 (Source: Hi3520D board read-back 2026-11-10).";
            sw = w;
            hw = r;
        } QP3[31:24];

        field {
            name = "QP2";
            desc = "Quantization divisor of natural-order entry s + 16 (word n = 0..15 of a table, s = (n & 1) * 32 + n / 2). Source: HiSTB driver (register semantics only), confidence MEDIUM; entry 0 and the scale confirmed (Source: Hi3520D board read-back 2026-11-10), the rest Not verified on hardware. Previously: entry 4n+2. Reads back 0 (Source: Hi3520D board read-back 2026-11-10).";
            sw = w;
            hw = r;
        } QP2[23:16];

        field {
            name = "QP1";
            desc = "Quantization divisor of natural-order entry s + 8 (word n = 0..15 of a table, s = (n & 1) * 32 + n / 2). Source: HiSTB driver (register semantics only), confidence MEDIUM; entry 0 and the scale confirmed (Source: Hi3520D board read-back 2026-11-10), the rest Not verified on hardware. Previously: entry 4n+1. Reads back 0 (Source: Hi3520D board read-back 2026-11-10).";
            sw = w;
            hw = r;
        } QP1[15:8];

        field {
            name = "QP0";
            desc = "Quantization divisor of natural-order entry s (word n = 0..15 of a table, s = (n & 1) * 32 + n / 2). Source: HiSTB driver (register semantics only), confidence MEDIUM; entry 0 and the scale confirmed (Source: Hi3520D board read-back 2026-11-10), the rest Not verified on hardware. Previously: entry 4n+0. Reads back 0 (Source: Hi3520D board read-back 2026-11-10).";
            sw = w;
            hw = r;
        } QP0[7:0];
    } JPGE_QPT[48] @ 0x1000 += 0x4;
};

addrmap aHISI_JPGE {
    name = "HiSilicon JPGE (window only, registers not described)";
    desc = "Window only (GAP RECORD, no invented registers): the 64 KB JPEG encoder window exists in the data sheet memory map but no register of this chip's JPEG encoder is described anywhere in the local corpus (no data sheet register table, no vendor module, no vendor source). Instantiated by the Hi3516 V100 only (JPEG window 0x20610000, 64 KB, interrupt 54, clock/reset PERI_CRG19 [3:2] clock frequency, [1] clock gate, [0] soft reset, data sheet 6.3). The Hi3516 V100 data sheet 6.3 JPGE feature list (baseline ISO 10918-1, YCbCr 4:2:0/4:2:2/4:4:4, planar/semi-planar/packed YUYV input, 32x32 to 8192x8192 in steps of 4, one quantization table per component, up to 8 OSD regions with 129 alpha levels, interrupt, software configures the quantization table and handles the interrupt) is the same as the Hi3520D one, which suggests the Hi3520D register layout (eHISI_JPGE above) but that is an INFERENCE from a feature list, confidence LOW, and is not recorded as registers; a hardware read of JPGE_VERSION (offset 0xFC) would confirm it. See docs/rdl-campaign/jpge-crosschip.md.";

    external mem {
        name = "Undocumented register window";
        desc = "The whole 64 KB window of the block. Register layout unknown; placeholder so the block base address and size exist in the map. No registers are described.";
        mementries = 16384;
        memwidth = 32;
        sw = rw;
    } REGS;
};

`endif
