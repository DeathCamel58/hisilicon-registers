`ifndef HISI_JPGE_RDL
`define HISI_JPGE_RDL


regfile eHISI_JPGE {
    name = "HiSilicon JPEG encoder (JPGE, r004 register layout)";
    desc = "
    LAYOUT PARTLY CONFIRMED ON THE Hi3520D BOARD (2026-11-10): the registers used by the Linux hisi-jpge driver (interrupts, PICFG, IMGSIZE, source addresses and strides for semi-planar input, stream address/length, QPT writes, START, OUTSTD, VERSION) produced correct JPEG files on the board, so offsets and the main field positions are confirmed; each register description below states its own source and confidence in the fixed forms 'Source: data sheet', 'Source: HiSTB driver (register semantics only), confidence HIGH|MEDIUM|LOW', 'Source: Hi3520D board read-back 2026-11-10' and 'Not verified on hardware'. Previously: CANDIDATE LAYOUT, LOW-MEDIUM CONFIDENCE, NOT HARDWARE VERIFIED. JPEG encoder (JPGE) of the Hi3520D SDK generation: 40 registers transcribed from the header `jpge_reg(r004).h` (file `product/hiosd/dec/jpeg_reg.h`, Huawei copyright 2012-05-16, version 2.0) that ships unused inside the Hi3520D vendor U-Boot 2010.06 uploads (https://github.com/Axl-zhang/hisilicon-hi3520d-uboot, https://github.com/hi35xx/hi35xx-buildroot `boot/uboot/u-boot-2010.06`; GPL-2.0 U-Boot tree). The header names no chip and gives no base address; the Hi3520D data sheet (Table 1-1) places the JPGE window at 0x20660000 (GIC interrupt 73) and its 6.3 feature list (baseline JPEG, 4:2:0/4:2:2/4:4:4, planar/semi-planar/packed input, 8192x8192, 8-region OSD, separate Y/Cb/Cr quantization tables) matches this register set (8 VPP_OSD regions, 48-word quantization table). Layout: interrupt set 0x0-0xC (end of picture, buffer full, time-out, config error), picture config 0x10-0x24, source addresses/strides 0x30-0x3C, stream buffer 0x40-0x4C (start, read/write pointers, length), PTS 0x70-0x7C, time-out/timer 0x80/0x84, OUTSTD 0xA4, VERSION 0xFC, VPP overlay 0x500-0x5D0 (8 OSD regions: alpha, position, size, address, stride, layer order, colour inversion), quantization table JPGE_QPT[48] at 0x1000. Reset values and access types are unknown (no data sheet register description; modelled RW, no reset). Hardware probe to confirm the layout before relying on it: read 0x20660000 + 0xFC (JPGE_VERSION, expect a non-zero version word), + 0x0 / + 0x8 (JPGE_INTSTAT / JPGE_RAWINT, expect 0) and + 0x1000.. (JPGE_QPT, read/write test) with the JPGE clock enabled (PERI_CRG). The HiSTB SDK `source/msp/drv/jpge/src/jpge_reg.h` is a later revision of the same register family (same names, extra registers) and was not used. Every register and field desc below is marked `[inferred]` (names from the header, meanings inferred from the names).

    Generated 2026-11-10 by build/rdl-audit/video-rdl-scratch/gen_blocks.py: mechanical transcription of the data sheet register tables (ds_extract2 + description extraction from the PDF) merged with the vendor header; not hardware verified.

    Register sources: 0 registers from the data sheet (-, section -); 40 registers (5 of them arrays) and 0 fields from vendor U-Boot 2010.06 upload `product/hiosd/dec/jpeg_reg.h` = `jpge_reg(r004).h` (GPL-2.0 U-Boot tree, Huawei copyright 2012; github.com/Axl-zhang/hisilicon-hi3520d-uboot) (GPL-2.0; same SDK generation as the Hi3520D, chip not named in the file), each marked `[inferred]` in its desc (names from the header, meanings inferred from the names, reset/access unknown). ";

    reg {
        name = "JPGE INTSTAT";
        desc = "Interrupt status (masked by INTMASK). Bit 0 end of picture, 1 stream buffer full, 2 time-out, 3 configuration error. Layout: vendor header jpge_reg(r004).h (Hi3520D U-Boot 2010.06 upload), not in the data sheet. Reads 0 when idle; the end-of-picture bit is delivered as the interrupt of every encode (Source: Hi3520D board read-back 2026-11-10). Meaning of bits 1..3: Source: HiSTB driver (register semantics only), confidence MEDIUM. Not verified on hardware: the buffer-full, time-out and configuration-error interrupts were never raised in the board test. Access type (read-only) not verified.";

        field {
            name = "cfgErr";
            desc = "[inferred] Configuration error interrupt. (vendor header `jpeg_reg.h` (JPGE r004) field `cfgErr`; access and reset unknown, modelled RW)";
            sw = rw;
            hw = r;
        } cfgErr[3:3];

        field {
            name = "JpgeTimeout";
            desc = "[inferred] Encoder time-out interrupt (see JPGE_TIMEOUT/JPGE_TIMER). (vendor header `jpeg_reg.h` (JPGE r004) field `JpgeTimeout`; access and reset unknown, modelled RW)";
            sw = rw;
            hw = r;
        } JpgeTimeout[2:2];

        field {
            name = "VencBufFull";
            desc = "[inferred] Stream buffer full interrupt. (vendor header `jpeg_reg.h` (JPGE r004) field `VencBufFull`; access and reset unknown, modelled RW)";
            sw = rw;
            hw = r;
        } VencBufFull[1:1];

        field {
            name = "VencEndOfPic";
            desc = "[inferred] End-of-picture (frame encoded) interrupt. (vendor header `jpeg_reg.h` (JPGE r004) field `VencEndOfPic`; access and reset unknown, modelled RW)";
            sw = rw;
            hw = r;
        } VencEndOfPic[0:0];
    } JPGE_INTSTAT @ 0x0;

    reg {
        name = "JPGE INTMASK";
        desc = "Interrupt mask/enable: 1 = interrupt enabled (the Linux driver writes bits 0, 1 and 3 and gets the end-of-picture interrupt: Source: Hi3520D board read-back 2026-11-10). Layout: vendor header jpge_reg(r004).h (Hi3520D U-Boot 2010.06 upload), not in the data sheet. Reset value not read. Bit 2 (time-out) enable: Source: HiSTB driver (register semantics only), confidence MEDIUM, Not verified on hardware.";

        field {
            name = "cfgErrMask";
            desc = "[inferred] Mask of the configuration-error interrupt. (vendor header `jpeg_reg.h` (JPGE r004) field `cfgErrMask`; access and reset unknown, modelled RW)";
            sw = rw;
            hw = r;
        } cfgErrMask[3:3];

        field {
            name = "JpgeTimeoutMask";
            desc = "[inferred] Mask of the time-out interrupt. (vendor header `jpeg_reg.h` (JPGE r004) field `JpgeTimeoutMask`; access and reset unknown, modelled RW)";
            sw = rw;
            hw = r;
        } JpgeTimeoutMask[2:2];

        field {
            name = "VencBufFullMask";
            desc = "[inferred] Mask of the buffer-full interrupt. (vendor header `jpeg_reg.h` (JPGE r004) field `VencBufFullMask`; access and reset unknown, modelled RW)";
            sw = rw;
            hw = r;
        } VencBufFullMask[1:1];

        field {
            name = "VencEndOfPicMask";
            desc = "[inferred] Mask of the end-of-picture interrupt. (vendor header `jpeg_reg.h` (JPGE r004) field `VencEndOfPicMask`; access and reset unknown, modelled RW)";
            sw = rw;
            hw = r;
        } VencEndOfPicMask[0:0];
    } JPGE_INTMASK @ 0x4;

    reg {
        name = "JPGE RAWINT";
        desc = "Raw (unmasked) interrupt status, same bits as INTSTAT. Reads 0 when idle (Source: Hi3520D board read-back 2026-11-10). Layout: vendor header jpge_reg(r004).h (Hi3520D U-Boot 2010.06 upload), not in the data sheet. Not verified on hardware: behavior while an interrupt is masked.";

        field {
            name = "cfgErr";
            desc = "[inferred] Configuration error interrupt. (vendor header `jpeg_reg.h` (JPGE r004) field `cfgErr`; access and reset unknown, modelled RW)";
            sw = rw;
            hw = r;
        } cfgErr[3:3];

        field {
            name = "JpgeTimeout";
            desc = "[inferred] Encoder time-out interrupt (see JPGE_TIMEOUT/JPGE_TIMER). (vendor header `jpeg_reg.h` (JPGE r004) field `JpgeTimeout`; access and reset unknown, modelled RW)";
            sw = rw;
            hw = r;
        } JpgeTimeout[2:2];

        field {
            name = "VencBufFull";
            desc = "[inferred] Stream buffer full interrupt. (vendor header `jpeg_reg.h` (JPGE r004) field `VencBufFull`; access and reset unknown, modelled RW)";
            sw = rw;
            hw = r;
        } VencBufFull[1:1];

        field {
            name = "VencEndOfPic";
            desc = "[inferred] End-of-picture (frame encoded) interrupt. (vendor header `jpeg_reg.h` (JPGE r004) field `VencEndOfPic`; access and reset unknown, modelled RW)";
            sw = rw;
            hw = r;
        } VencEndOfPic[0:0];
    } JPGE_RAWINT @ 0x8;

    reg {
        name = "JPGE INTCLR";
        desc = "Interrupt clear: write 1 to clear the matching bit. The Linux driver writes the status it read and the interrupt deasserts (Source: Hi3520D board read-back 2026-11-10, encode loops of 3000 frames). The HiSTB ISR path (jpge_hal.c Jpge_ReadReg, after reading INTSTAT) writes 0xFFFFFFFF to clear every bit (Source: HiSTB driver (register semantics only), confidence MEDIUM). Layout: vendor header jpge_reg(r004).h (Hi3520D U-Boot 2010.06 upload), not in the data sheet.";

        field {
            name = "cfgErrClr";
            desc = "[inferred] Clear the configuration-error interrupt. (vendor header `jpeg_reg.h` (JPGE r004) field `cfgErrClr`; access and reset unknown, modelled RW)";
            sw = rw;
            hw = r;
        } cfgErrClr[3:3];

        field {
            name = "JpgeTimeoutClr";
            desc = "[inferred] Clear the time-out interrupt. (vendor header `jpeg_reg.h` (JPGE r004) field `JpgeTimeoutClr`; access and reset unknown, modelled RW)";
            sw = rw;
            hw = r;
        } JpgeTimeoutClr[2:2];

        field {
            name = "VencBufFullClr";
            desc = "[inferred] Clear the buffer-full interrupt. (vendor header `jpeg_reg.h` (JPGE r004) field `VencBufFullClr`; access and reset unknown, modelled RW)";
            sw = rw;
            hw = r;
        } VencBufFullClr[1:1];

        field {
            name = "VencEndOfPicClr";
            desc = "[inferred] Clear the end-of-picture interrupt. (vendor header `jpeg_reg.h` (JPGE r004) field `VencEndOfPicClr`; access and reset unknown, modelled RW)";
            sw = rw;
            hw = r;
        } VencEndOfPicClr[0:0];
    } JPGE_INTCLR @ 0xC;

    reg {
        name = "JPGE PICFG";
        desc = "Picture configuration. Reset value 0x0D880000 (Source: Hi3520D board read-back 2026-11-10): roundEn = 1, packageSel = 0xD8 (YUYV), everything else 0. Layout: vendor header jpge_reg(r004).h (Hi3520D U-Boot 2010.06 upload), not in the data sheet. The Linux driver writes the whole register per job with roundEn = 0 (as the HiSTB driver does) and the encodes work on the board. Fields not covered by the encode test are marked per field.";

        field {
            name = "col2grayEn";
            desc = "Color to gray conversion (name only). Source: HiSTB driver (register semantics only), confidence LOW. Reset 0 (Source: Hi3520D board read-back 2026-11-10). The data sheet lists no 4:0:0 encoding. Not verified on hardware.";
            sw = rw;
            hw = r;
            reset = 0;
        } col2grayEn[29:29];

        field {
            name = "jcpi_clip_en";
            desc = "Enable clipping with JPGE_CLIP_THR. Source: HiSTB driver (register semantics only), confidence LOW. Reset 0 (Source: Hi3520D board read-back 2026-11-10). Not verified on hardware.";
            sw = rw;
            hw = r;
            reset = 0;
        } jcpi_clip_en[28:28];

        field {
            name = "packageSel";
            desc = "Component byte order of packed input, four 2 bit fields = byte position (0..3) in a 4 byte Y0 Cb/Cr Y1 Cr/Cb group: [1:0] Y0, [3:2] Y1, [5:4] Cb, [7:6] Cr. Reset 0xD8 = YUYV (Source: Hi3520D board read-back 2026-11-10; YUYV is the packed format the data sheet lists, Source: data sheet 6.3.2). The rule is derived from three vendor constants: UYVY 0x8D, YUYV 0xD8, YVYU 0x78 (Source: HiSTB driver (register semantics only), confidence MEDIUM; constants from the HiSTB VENC code, same field name); VYUY 0x2D follows from the rule (LOW). Not verified on hardware for non-default values and for any effect on planar or semi-planar input.";
            sw = rw;
            hw = r;
            reset = 0xD8;
        } packageSel[27:20];

        field {
            name = "roundEn";
            desc = "Rounding control. Reset 1 (Source: Hi3520D board read-back 2026-11-10); the HiSTB driver and the Linux driver write 0 and the output decodes correctly, so the effect of the bit is unknown. Not verified on hardware.";
            sw = rw;
            hw = r;
            reset = 1;
        } roundEn[19:19];

        field {
            name = "timeoutEn";
            desc = "Enable the hardware encode time-out (JPGE_TIMEOUT / JPGE_TIMER). Source: HiSTB driver (register semantics only), confidence LOW. Reset 0 (Source: Hi3520D board read-back 2026-11-10). The Linux driver uses a software watchdog instead. Not verified on hardware.";
            sw = rw;
            hw = r;
            reset = 0;
        } timeoutEn[18:18];

        field {
            name = "configlockEn";
            desc = "Lock the configuration registers while encoding. Source: HiSTB driver (register semantics only), confidence LOW. Reset 0 (Source: Hi3520D board read-back 2026-11-10). Not verified on hardware.";
            sw = rw;
            hw = r;
            reset = 0;
        } configlockEn[17:17];

        field {
            name = "memClkGateEn";
            desc = "Memory clock gating enable; the HiSTB driver and the Linux driver write 1 (Source: Hi3520D board read-back 2026-11-10: works). Reset 0 (Source: Hi3520D board read-back 2026-11-10). Effect of 0 during encoding: Not verified on hardware.";
            sw = rw;
            hw = r;
            reset = 0;
        } memClkGateEn[16:16];

        field {
            name = "clkGateEn";
            desc = "Clock gating level; the HiSTB driver writes 2 (frame and block level gating). The Linux driver writes 2 and encodes correctly (Source: Hi3520D board read-back 2026-11-10). Other values: Not verified on hardware.";
            sw = rw;
            hw = r;
            reset = 0;
        } clkGateEn[15:14];

        field {
            name = "rotationAngle";
            desc = "Rotation of the source picture: 0 = none, 1 = 90, 2 = 270, 3 = 180 degrees (direction unknown). For 90/270 the HiSTB driver swaps width and height in the JFIF header and turns 4:2:2 into 4:2:0 with a doubled chroma stride. Source: HiSTB driver (register semantics only), confidence MEDIUM. Not used by the Linux driver. Not verified on hardware.";
            sw = rw;
            hw = r;
            reset = 0;
        } rotationAngle[13:12];

        field {
            name = "chnId";
            desc = "Channel ID copied into the packet descriptor (descriptor bytes 12..15). Source: HiSTB driver (register semantics only), confidence LOW. The Linux driver writes 0. Not verified on hardware.";
            sw = rw;
            hw = r;
            reset = 0;
        } chnId[11:4];

        field {
            name = "yuvFmt";
            desc = "Chroma sampling of the picture and of the JPEG: 0 = 4:2:0, 1 = 4:2:2 (Source: Hi3520D board read-back 2026-11-10: NV21 and NV61 encodes decode correctly with SOF sampling 0x22 and 0x21), 2 = 4:4:4 (Source: HiSTB driver (register semantics only), confidence MEDIUM, Not verified on hardware). Value 3: unknown, the HiSTB JPGE driver rejects it (not verified, LOW). With 4:2:2 data and yuvFmt = 0 plus a doubled chroma stride the encoder skips every second chroma line (4:2:0 JPEG from 4:2:2 input): Source: HiSTB driver (register semantics only), confidence MEDIUM (used by the HiSTB driver for rotation and 4:2:2 semi-planar), Not verified on hardware.";
            sw = rw;
            hw = r;
            reset = 0;
        } yuvFmt[3:2];

        field {
            name = "strFmt";
            desc = "Input storage: 0 = semi-planar (Y plane + interleaved Cr/Cb plane, Cr first; Source: Hi3520D board read-back 2026-11-10: NV21/NV61 encodes give correct colors), 1 = planar (separate Y, Cb, Cr planes), 2 = packed (YUYV family). Values 1 and 2: Source: HiSTB driver (register semantics only), confidence MEDIUM (JPGE_STORE_* enum of the HiSTB VENC code; the HiSTB H.264 encoder uses a different numbering, 0 semi-planar, 1 packed, 2 planar). Not verified on hardware for 1 and 2.";
            sw = rw;
            hw = r;
            reset = 0;
        } strFmt[1:0];
    } JPGE_PICFG @ 0x10;

    reg {
        name = "JPGE ECSCFG";
        desc = "Restart interval (entropy-coded segment) configuration. Field positions: Layout: vendor header jpge_reg(r004).h (Hi3520D U-Boot 2010.06 upload), not in the data sheet. Semantics: Source: HiSTB driver (register semantics only), confidence LOW. The HiSTB driver writes ecsSplit = enable and ecsSize = interval in MCUs minus 1 and puts a DRI marker with the same interval in the JFIF header, but its JPGE configuration check refuses restart intervals, so the behavior is undocumented. Open questions (all Not verified on hardware): whether the hardware writes the RSTn markers, and whether it emits one 64-byte-descriptor packet per segment (the descriptor has a last-slice flag at byte 11). The Linux driver supports both outcomes and writes 0 here by default.";

        field {
            name = "ecsSize";
            desc = "Segment size in MCUs minus 1 (the DRI interval minus 1). Source: HiSTB driver (register semantics only), confidence LOW. Not verified on hardware.";
            sw = rw;
            hw = r;
            reset = 0;
        } ecsSize[20:1];

        field {
            name = "ecsSplit";
            desc = "Enable the split into entropy-coded segments (restart intervals). Source: HiSTB driver (register semantics only), confidence LOW. Not verified on hardware.";
            sw = rw;
            hw = r;
            reset = 0;
        } ecsSplit[0:0];
    } JPGE_ECSCFG @ 0x14;

    reg {
        name = "JPGE START";
        desc = "Start one picture: the driver writes 0 and then 1 (HiSTB sequence; Source: Hi3520D board read-back 2026-11-10: every encode starts this way, 3000 back-to-back frames). Whether the bit self-clears: Not verified on hardware. Layout: vendor header jpge_reg(r004).h (Hi3520D U-Boot 2010.06 upload), not in the data sheet.";

        field {
            name = "VStart";
            desc = "[inferred] Start encoding one picture (self-clearing start bit). (vendor header `jpeg_reg.h` (JPGE r004) field `VStart`; access and reset unknown, modelled RW)";
            sw = rw;
            hw = r;
        } VStart[0:0];
    } JPGE_START @ 0x1C;

    reg {
        name = "JPGE VEDIMGSIZE";
        desc = "Picture size minus 1, 13 bits each (maximum 8192). Layout: vendor header jpge_reg(r004).h (Hi3520D U-Boot 2010.06 upload), not in the data sheet. Sizes 64x64, 640x480, 644x484, 1280x720 and 1920x1080 encode with these values (Source: Hi3520D board read-back 2026-11-10). Size limits 64x64 to 8192x8192 in steps of 4: Source: data sheet 6.3.2. Whether sizes that are not a multiple of the MCU are padded correctly by the hardware: Not verified on hardware (the encode completes; the picture content at the edge was not compared).";

        field {
            name = "ImgHeightInPixelsMinus1";
            desc = "[inferred] Picture height in pixels minus 1. (vendor header `jpeg_reg.h` (JPGE r004) field `ImgHeightInPixelsMinus1`; access and reset unknown, modelled RW)";
            sw = rw;
            hw = r;
        } ImgHeightInPixelsMinus1[28:16];

        field {
            name = "ImgWidthInPixelsMinus1";
            desc = "[inferred] Picture width in pixels minus 1. (vendor header `jpeg_reg.h` (JPGE r004) field `ImgWidthInPixelsMinus1`; access and reset unknown, modelled RW)";
            sw = rw;
            hw = r;
        } ImgWidthInPixelsMinus1[12:0];
    } JPGE_VEDIMGSIZE @ 0x20;

    reg {
        name = "JPGE clip THR";
        desc = "[inferred] JPGE clip THR. Not in the data sheet. Source: vendor U-Boot 2010.06 upload `product/hiosd/dec/jpeg_reg.h` = `jpge_reg(r004).h` (GPL-2.0 U-Boot tree, Huawei copyright 2012; github.com/Axl-zhang/hisilicon-hi3520d-uboot), union `U_JPGE_CLIP_THR`, struct offset 0x24 (GPL-2.0; same SDK generation as the Hi3520D, chip not named in the file). Reset value and access type unknown (modelled RW, no reset). Confidence: medium (vendor header for this chip family, not hardware verified).";

        field {
            name = "jcpi_chr_max";
            desc = "[inferred] Chroma clip maximum. (vendor header `jpeg_reg.h` (JPGE r004) field `jcpi_chr_max`; access and reset unknown, modelled RW)";
            sw = rw;
            hw = r;
        } jcpi_chr_max[31:24];

        field {
            name = "jcpi_chr_min";
            desc = "[inferred] Chroma clip minimum. (vendor header `jpeg_reg.h` (JPGE r004) field `jcpi_chr_min`; access and reset unknown, modelled RW)";
            sw = rw;
            hw = r;
        } jcpi_chr_min[23:16];

        field {
            name = "jcpi_luma_max";
            desc = "[inferred] Luma clip maximum. (vendor header `jpeg_reg.h` (JPGE r004) field `jcpi_luma_max`; access and reset unknown, modelled RW)";
            sw = rw;
            hw = r;
        } jcpi_luma_max[15:8];

        field {
            name = "jcpi_luma_min";
            desc = "[inferred] Luma clip minimum. (vendor header `jpeg_reg.h` (JPGE r004) field `jcpi_luma_min`; access and reset unknown, modelled RW)";
            sw = rw;
            hw = r;
        } jcpi_luma_min[7:0];
    } JPGE_CLIP_THR @ 0x24;

    reg {
        name = "JPGE SRCYADDR";
        desc = "Source luma plane address (semi-planar, planar) or the whole picture (packed). Must be 16-byte aligned (Source: HiSTB driver (register semantics only), confidence MEDIUM, alignment check in the HiSTB VENC code). Works as such for semi-planar input (Source: Hi3520D board read-back 2026-11-10). Packed input: Not verified on hardware.";

        field {
            name = "value";
            desc = "[inferred] Register value (the header union has no named bits).";
            sw = rw;
            hw = r;
        } value[31:0];
    } JPGE_SRCYADDR @ 0x30;

    reg {
        name = "JPGE SRCCADDR";
        desc = "Source chroma address. Semi-planar: the interleaved Cr/Cb plane, Cr first (Source: Hi3520D board read-back 2026-11-10: NV21/NV61 give correct colors). Planar: assumed to be the Cb plane (Source: HiSTB driver (register semantics only), confidence MEDIUM, naming in the HiSTB VENC code), Not verified on hardware. 16-byte alignment: Source: HiSTB driver (register semantics only), confidence MEDIUM.";

        field {
            name = "value";
            desc = "[inferred] Register value (the header union has no named bits).";
            sw = rw;
            hw = r;
        } value[31:0];
    } JPGE_SRCCADDR @ 0x34;

    reg {
        name = "JPGE SRCVADDR";
        desc = "Source Cr plane address for planar input (Source: HiSTB driver (register semantics only), confidence MEDIUM, Not verified on hardware). Unused for semi-planar input: the Linux driver writes 0 and encodes correctly (Source: Hi3520D board read-back 2026-11-10).";

        field {
            name = "value";
            desc = "[inferred] Register value (the header union has no named bits).";
            sw = rw;
            hw = r;
        } value[31:0];
    } JPGE_SRCVADDR @ 0x38;

    reg {
        name = "JPGE SSTRIDE";
        desc = "Source line strides in bytes: luma/packed in [15:0], chroma in [31:16] (one chroma stride for Cb and Cr in planar mode). 16-byte multiples: Source: HiSTB driver (register semantics only), confidence MEDIUM. Semi-planar strides equal to bytesperline for both fields work (Source: Hi3520D board read-back 2026-11-10, 640 to 1920 wide). Doubling the chroma stride to read every second chroma line: Source: HiSTB driver (register semantics only), confidence MEDIUM, Not verified on hardware. Layout: vendor header jpge_reg(r004).h (Hi3520D U-Boot 2010.06 upload), not in the data sheet.";

        field {
            name = "SrcCStride";
            desc = "[inferred] Source chroma stride in bytes. (vendor header `jpeg_reg.h` (JPGE r004) field `SrcCStride`; access and reset unknown, modelled RW)";
            sw = rw;
            hw = r;
        } SrcCStride[31:16];

        field {
            name = "SrcYStride";
            desc = "[inferred] Source luma stride in bytes. (vendor header `jpeg_reg.h` (JPGE r004) field `SrcYStride`; access and reset unknown, modelled RW)";
            sw = rw;
            hw = r;
        } SrcYStride[15:0];
    } JPGE_SSTRIDE @ 0x3C;

    reg {
        name = "JPGE STRMADDR";
        desc = "Stream buffer start address (64-byte aligned in the Linux driver). The hardware writes a 64-byte packet descriptor here (dword 0 PacketLen including the descriptor, a multiple of 64; dword 1 InvalidBytes = padding at the end of the packet; byte 11 last-slice flag, dwords 3 channel id: Source: HiSTB driver (register semantics only), confidence MEDIUM for the layout) followed by the entropy-coded scan data and the EOI marker FF D9 (Source: Hi3520D board read-back 2026-11-10: every encode ends with ff d9, the PacketLen/InvalidBytes semantics gave correct file sizes). Layout: vendor header jpge_reg(r004).h (Hi3520D U-Boot 2010.06 upload), not in the data sheet.";

        field {
            name = "value";
            desc = "[inferred] Register value (the header union has no named bits).";
            sw = rw;
            hw = r;
        } value[31:0];
    } JPGE_STRMADDR @ 0x40;

    reg {
        name = "JPGE SRPTRADDR";
        desc = "Stream read/write pointer address (not used by the encoder as a pointer in single-picture mode). The Linux driver points it 16 bytes (SRPTR) or 32 bytes (SWPTR) below the stream address, as the HiSTB driver does. Board finding (Source: Hi3520D board read-back 2026-11-10, functional test): the 32 bytes below the stream address must not hold stale data; with a reused buffer that still held the previous JFIF header the second and later pictures lost their packet descriptor and the scan data started early; clearing those bytes (and the descriptor area) before every job fixed it, a per-job hardware reset did not. What the block reads there is Not verified on hardware. Layout: vendor header jpge_reg(r004).h (Hi3520D U-Boot 2010.06 upload), not in the data sheet.";

        field {
            name = "value";
            desc = "[inferred] Register value (the header union has no named bits).";
            sw = rw;
            hw = r;
        } value[31:0];
    } JPGE_SRPTRADDR @ 0x44;

    reg {
        name = "JPGE SWPTRADDR";
        desc = "Stream read/write pointer address (not used by the encoder as a pointer in single-picture mode). The Linux driver points it 16 bytes (SRPTR) or 32 bytes (SWPTR) below the stream address, as the HiSTB driver does. Board finding (Source: Hi3520D board read-back 2026-11-10, functional test): the 32 bytes below the stream address must not hold stale data; with a reused buffer that still held the previous JFIF header the second and later pictures lost their packet descriptor and the scan data started early; clearing those bytes (and the descriptor area) before every job fixed it, a per-job hardware reset did not. What the block reads there is Not verified on hardware. Layout: vendor header jpge_reg(r004).h (Hi3520D U-Boot 2010.06 upload), not in the data sheet.";

        field {
            name = "value";
            desc = "[inferred] Register value (the header union has no named bits).";
            sw = rw;
            hw = r;
        } value[31:0];
    } JPGE_SWPTRADDR @ 0x48;

    reg {
        name = "JPGE STRMBUFLEN";
        desc = "Stream buffer length in bytes, low 6 bits not stored (the Linux driver writes the length with bits [5:0] clear). Source: HiSTB driver (register semantics only), confidence MEDIUM; Source: Hi3520D board read-back 2026-11-10: values up to a few MiB accept full pictures. The buffer-full interrupt behavior is Not verified on hardware (never reached in the test). Previously: described as 64-byte units; the register value is the byte count with the low bits cleared. Layout: vendor header jpge_reg(r004).h (Hi3520D U-Boot 2010.06 upload), not in the data sheet.";

        field {
            name = "BufferLength";
            desc = "Stream buffer length in bytes (bits [5:0] not stored). Source: HiSTB driver (register semantics only), confidence MEDIUM; Not verified on hardware at the limit.";
            sw = rw;
            hw = r;
        } BufferLength[31:6];
    } JPGE_STRMBUFLEN @ 0x4C;

    reg {
        name = "JPGE PTS0";
        desc = "Frame time stamp word. Observed in the HiSTB driver: written (never read) with the caller's frame PTS in jpge_set_register(), just before OUTSTD and START; its purpose in the hardware (copied into the packet descriptor?) is unknown. The Linux driver does not write it. Source: HiSTB driver (register semantics only), confidence LOW. Not verified on hardware. Layout: vendor header jpge_reg(r004).h (Hi3520D U-Boot 2010.06 upload), not in the data sheet.";

        field {
            name = "value";
            desc = "[inferred] Register value (the header union has no named bits).";
            sw = rw;
            hw = r;
        } value[31:0];
    } JPGE_PTS0 @ 0x70;

    reg {
        name = "JPGE PTS1";
        desc = "Time stamp word 1 (name only). Not accessed by the HiSTB JPGE driver; purpose unknown. Source: HiSTB driver (register semantics only), confidence LOW. Not verified on hardware. Layout: vendor header jpge_reg(r004).h (Hi3520D U-Boot 2010.06 upload), not in the data sheet.";

        field {
            name = "value";
            desc = "[inferred] Register value (the header union has no named bits).";
            sw = rw;
            hw = r;
        } value[31:0];
    } JPGE_PTS1 @ 0x74;

    reg {
        name = "JPGE PTS2";
        desc = "Time stamp word 2 (name only). Not accessed by the HiSTB JPGE driver; purpose unknown. Source: HiSTB driver (register semantics only), confidence LOW. Not verified on hardware. Layout: vendor header jpge_reg(r004).h (Hi3520D U-Boot 2010.06 upload), not in the data sheet.";

        field {
            name = "value";
            desc = "[inferred] Register value (the header union has no named bits).";
            sw = rw;
            hw = r;
        } value[31:0];
    } JPGE_PTS2 @ 0x78;

    reg {
        name = "JPGE PTS3";
        desc = "Time stamp word 3 (name only). Not accessed by the HiSTB JPGE driver; purpose unknown. Source: HiSTB driver (register semantics only), confidence LOW. Not verified on hardware. Layout: vendor header jpge_reg(r004).h (Hi3520D U-Boot 2010.06 upload), not in the data sheet.";

        field {
            name = "value";
            desc = "[inferred] Register value (the header union has no named bits).";
            sw = rw;
            hw = r;
        } value[31:0];
    } JPGE_PTS3 @ 0x7C;

    reg {
        name = "JPGE TIMEOUT";
        desc = "Hardware encode time-out threshold (name only). Not accessed by the HiSTB driver (PICFG timeoutEn is never set there) and not by the Linux driver, which uses a software watchdog; unit and purpose unknown. Source: HiSTB driver (register semantics only), confidence LOW. Not verified on hardware. Layout: vendor header jpge_reg(r004).h (Hi3520D U-Boot 2010.06 upload), not in the data sheet.";

        field {
            name = "value";
            desc = "[inferred] Register value (the header union has no named bits).";
            sw = rw;
            hw = r;
        } value[31:0];
    } JPGE_TIMEOUT @ 0x80;

    reg {
        name = "JPGE TIMER";
        desc = "Hardware encode timer (name only). Not accessed by the HiSTB driver or the Linux driver; unit and purpose unknown. Source: HiSTB driver (register semantics only), confidence LOW. Not verified on hardware. Layout: vendor header jpge_reg(r004).h (Hi3520D U-Boot 2010.06 upload), not in the data sheet.";

        field {
            name = "value";
            desc = "[inferred] Register value (the header union has no named bits).";
            sw = rw;
            hw = r;
        } value[31:0];
    } JPGE_TIMER @ 0x84;

    reg {
        name = "JPGE OUTSTD";
        desc = "AXI outstanding request count. Reset 0 (Source: Hi3520D board read-back 2026-11-10); the HiSTB driver and the Linux driver write 2 and the encodes work. Other values: Not verified on hardware. Layout: vendor header jpge_reg(r004).h (Hi3520D U-Boot 2010.06 upload), not in the data sheet.";

        field {
            name = "outstdNum";
            desc = "AXI outstanding request count (reset 0: Source: Hi3520D board read-back 2026-11-10; written 2 by the drivers).";
            sw = rw;
            hw = r;
            reset = 0;
        } outstdNum[3:0];
    } JPGE_OUTSTD @ 0xA4;

    reg {
        name = "JPGE VERSION";
        desc = "Version word. Reads 0x56325234 (ASCII 'V2R4') on the Hi3520D (Source: Hi3520D board read-back 2026-11-10); matches the r004 layout name of the vendor header. Read-only is assumed from the name (Not verified on hardware). Layout: vendor header jpge_reg(r004).h (Hi3520D U-Boot 2010.06 upload), not in the data sheet.";

        field {
            name = "value";
            desc = "Version, 0x56325234 = 'V2R4' (Source: Hi3520D board read-back 2026-11-10).";
            sw = r;
            hw = r;
            reset = 0x56325234;
        } value[31:0];
    } JPGE_VERSION @ 0xFC;

    reg {
        name = "VPP configuration";
        desc = "[inferred] VPP configuration. Not in the data sheet. Source: vendor U-Boot 2010.06 upload `product/hiosd/dec/jpeg_reg.h` = `jpge_reg(r004).h` (GPL-2.0 U-Boot tree, Huawei copyright 2012; github.com/Axl-zhang/hisilicon-hi3520d-uboot), union `U_JPGE_CFG`, struct offset 0x500 (GPL-2.0; same SDK generation as the Hi3520D, chip not named in the file). Reset value and access type unknown (modelled RW, no reset). Confidence: medium (vendor header for this chip family, not hardware verified).";

        field {
            name = "osdEn";
            desc = "[inferred] OSD overlay enable. (vendor header `jpeg_reg.h` (JPGE r004) field `osdEn`; access and reset unknown, modelled RW)";
            sw = rw;
            hw = r;
        } osdEn[5:5];
    } VPP_CFG @ 0x500;

    reg {
        name = "VPP OSD configuration";
        desc = "[inferred] VPP OSD configuration. Not in the data sheet. Source: vendor U-Boot 2010.06 upload `product/hiosd/dec/jpeg_reg.h` = `jpge_reg(r004).h` (GPL-2.0 U-Boot tree, Huawei copyright 2012; github.com/Axl-zhang/hisilicon-hi3520d-uboot), union `U_JPGE_OSD_CFG`, struct offset 0x510 (GPL-2.0; same SDK generation as the Hi3520D, chip not named in the file). Reset value and access type unknown (modelled RW, no reset). Confidence: medium (vendor header for this chip family, not hardware verified).";

        field {
            name = "osd7En";
            desc = "[inferred] Osd7En. (vendor header `jpeg_reg.h` (JPGE r004) field `osd7En`; access and reset unknown, modelled RW)";
            sw = rw;
            hw = r;
        } osd7En[31:31];

        field {
            name = "osd6En";
            desc = "[inferred] Osd6En. (vendor header `jpeg_reg.h` (JPGE r004) field `osd6En`; access and reset unknown, modelled RW)";
            sw = rw;
            hw = r;
        } osd6En[30:30];

        field {
            name = "osd5En";
            desc = "[inferred] Osd5En. (vendor header `jpeg_reg.h` (JPGE r004) field `osd5En`; access and reset unknown, modelled RW)";
            sw = rw;
            hw = r;
        } osd5En[29:29];

        field {
            name = "osd4En";
            desc = "[inferred] Osd4En. (vendor header `jpeg_reg.h` (JPGE r004) field `osd4En`; access and reset unknown, modelled RW)";
            sw = rw;
            hw = r;
        } osd4En[28:28];

        field {
            name = "osd3En";
            desc = "[inferred] Osd3En. (vendor header `jpeg_reg.h` (JPGE r004) field `osd3En`; access and reset unknown, modelled RW)";
            sw = rw;
            hw = r;
        } osd3En[27:27];

        field {
            name = "osd2En";
            desc = "[inferred] Osd2En. (vendor header `jpeg_reg.h` (JPGE r004) field `osd2En`; access and reset unknown, modelled RW)";
            sw = rw;
            hw = r;
        } osd2En[26:26];

        field {
            name = "osd1En";
            desc = "[inferred] Osd1En. (vendor header `jpeg_reg.h` (JPGE r004) field `osd1En`; access and reset unknown, modelled RW)";
            sw = rw;
            hw = r;
        } osd1En[25:25];

        field {
            name = "osd0En";
            desc = "[inferred] Osd0En. (vendor header `jpeg_reg.h` (JPGE r004) field `osd0En`; access and reset unknown, modelled RW)";
            sw = rw;
            hw = r;
        } osd0En[24:24];

        field {
            name = "osd7GlobalEn";
            desc = "[inferred] Osd7GlobalEn. (vendor header `jpeg_reg.h` (JPGE r004) field `osd7GlobalEn`; access and reset unknown, modelled RW)";
            sw = rw;
            hw = r;
        } osd7GlobalEn[23:23];

        field {
            name = "osd6GlobalEn";
            desc = "[inferred] Osd6GlobalEn. (vendor header `jpeg_reg.h` (JPGE r004) field `osd6GlobalEn`; access and reset unknown, modelled RW)";
            sw = rw;
            hw = r;
        } osd6GlobalEn[22:22];

        field {
            name = "osd5GlobalEn";
            desc = "[inferred] Osd5GlobalEn. (vendor header `jpeg_reg.h` (JPGE r004) field `osd5GlobalEn`; access and reset unknown, modelled RW)";
            sw = rw;
            hw = r;
        } osd5GlobalEn[21:21];

        field {
            name = "osd4GlobalEn";
            desc = "[inferred] Osd4GlobalEn. (vendor header `jpeg_reg.h` (JPGE r004) field `osd4GlobalEn`; access and reset unknown, modelled RW)";
            sw = rw;
            hw = r;
        } osd4GlobalEn[20:20];

        field {
            name = "osd3GlobalEn";
            desc = "[inferred] Osd3GlobalEn. (vendor header `jpeg_reg.h` (JPGE r004) field `osd3GlobalEn`; access and reset unknown, modelled RW)";
            sw = rw;
            hw = r;
        } osd3GlobalEn[19:19];

        field {
            name = "osd2GlobalEn";
            desc = "[inferred] Osd2GlobalEn. (vendor header `jpeg_reg.h` (JPGE r004) field `osd2GlobalEn`; access and reset unknown, modelled RW)";
            sw = rw;
            hw = r;
        } osd2GlobalEn[18:18];

        field {
            name = "osd1GlobalEn";
            desc = "[inferred] Osd1GlobalEn. (vendor header `jpeg_reg.h` (JPGE r004) field `osd1GlobalEn`; access and reset unknown, modelled RW)";
            sw = rw;
            hw = r;
        } osd1GlobalEn[17:17];

        field {
            name = "osd0GlobalEn";
            desc = "[inferred] Osd0GlobalEn. (vendor header `jpeg_reg.h` (JPGE r004) field `osd0GlobalEn`; access and reset unknown, modelled RW)";
            sw = rw;
            hw = r;
        } osd0GlobalEn[16:16];

        field {
            name = "osdRgbfmt";
            desc = "[inferred] OSD pixel format. (vendor header `jpeg_reg.h` (JPGE r004) field `osdRgbfmt`; access and reset unknown, modelled RW)";
            sw = rw;
            hw = r;
        } osdRgbfmt[0:0];
    } VPP_OSD_CFG @ 0x510;

    reg {
        name = "VPP OSD01 alpha";
        desc = "[inferred] VPP OSD01 alpha. Not in the data sheet. Source: vendor U-Boot 2010.06 upload `product/hiosd/dec/jpeg_reg.h` = `jpge_reg(r004).h` (GPL-2.0 U-Boot tree, Huawei copyright 2012; github.com/Axl-zhang/hisilicon-hi3520d-uboot), union `U_JPGE_OSD01_ALPHA`, struct offset 0x514 (GPL-2.0; same SDK generation as the Hi3520D, chip not named in the file). Reset value and access type unknown (modelled RW, no reset). Confidence: medium (vendor header for this chip family, not hardware verified).";

        field {
            name = "osd1Alpha1";
            desc = "[inferred] Osd1Alpha1. (vendor header `jpeg_reg.h` (JPGE r004) field `osd1Alpha1`; access and reset unknown, modelled RW)";
            sw = rw;
            hw = r;
        } osd1Alpha1[31:24];

        field {
            name = "osd1Alpha0";
            desc = "[inferred] Osd1Alpha0. (vendor header `jpeg_reg.h` (JPGE r004) field `osd1Alpha0`; access and reset unknown, modelled RW)";
            sw = rw;
            hw = r;
        } osd1Alpha0[23:16];

        field {
            name = "osd0Alpha1";
            desc = "[inferred] Osd0Alpha1. (vendor header `jpeg_reg.h` (JPGE r004) field `osd0Alpha1`; access and reset unknown, modelled RW)";
            sw = rw;
            hw = r;
        } osd0Alpha1[15:8];

        field {
            name = "osd0Alpha0";
            desc = "[inferred] Osd0Alpha0. (vendor header `jpeg_reg.h` (JPGE r004) field `osd0Alpha0`; access and reset unknown, modelled RW)";
            sw = rw;
            hw = r;
        } osd0Alpha0[7:0];
    } VPP_OSD01_ALPHA @ 0x514;

    reg {
        name = "VPP OSD23 alpha";
        desc = "[inferred] VPP OSD23 alpha. Not in the data sheet. Source: vendor U-Boot 2010.06 upload `product/hiosd/dec/jpeg_reg.h` = `jpge_reg(r004).h` (GPL-2.0 U-Boot tree, Huawei copyright 2012; github.com/Axl-zhang/hisilicon-hi3520d-uboot), union `U_JPGE_OSD23_ALPHA`, struct offset 0x518 (GPL-2.0; same SDK generation as the Hi3520D, chip not named in the file). Reset value and access type unknown (modelled RW, no reset). Confidence: medium (vendor header for this chip family, not hardware verified).";

        field {
            name = "osd3Alpha1";
            desc = "[inferred] Osd3Alpha1. (vendor header `jpeg_reg.h` (JPGE r004) field `osd3Alpha1`; access and reset unknown, modelled RW)";
            sw = rw;
            hw = r;
        } osd3Alpha1[31:24];

        field {
            name = "osd3Alpha0";
            desc = "[inferred] Osd3Alpha0. (vendor header `jpeg_reg.h` (JPGE r004) field `osd3Alpha0`; access and reset unknown, modelled RW)";
            sw = rw;
            hw = r;
        } osd3Alpha0[23:16];

        field {
            name = "osd2Alpha1";
            desc = "[inferred] Osd2Alpha1. (vendor header `jpeg_reg.h` (JPGE r004) field `osd2Alpha1`; access and reset unknown, modelled RW)";
            sw = rw;
            hw = r;
        } osd2Alpha1[15:8];

        field {
            name = "osd2Alpha0";
            desc = "[inferred] Osd2Alpha0. (vendor header `jpeg_reg.h` (JPGE r004) field `osd2Alpha0`; access and reset unknown, modelled RW)";
            sw = rw;
            hw = r;
        } osd2Alpha0[7:0];
    } VPP_OSD23_ALPHA @ 0x518;

    reg {
        name = "VPP OSD45 alpha";
        desc = "[inferred] VPP OSD45 alpha. Not in the data sheet. Source: vendor U-Boot 2010.06 upload `product/hiosd/dec/jpeg_reg.h` = `jpge_reg(r004).h` (GPL-2.0 U-Boot tree, Huawei copyright 2012; github.com/Axl-zhang/hisilicon-hi3520d-uboot), union `U_JPGE_OSD45_ALPHA`, struct offset 0x51C (GPL-2.0; same SDK generation as the Hi3520D, chip not named in the file). Reset value and access type unknown (modelled RW, no reset). Confidence: medium (vendor header for this chip family, not hardware verified).";

        field {
            name = "osd5Alpha1";
            desc = "[inferred] Osd5Alpha1. (vendor header `jpeg_reg.h` (JPGE r004) field `osd5Alpha1`; access and reset unknown, modelled RW)";
            sw = rw;
            hw = r;
        } osd5Alpha1[31:24];

        field {
            name = "osd5Alpha0";
            desc = "[inferred] Osd5Alpha0. (vendor header `jpeg_reg.h` (JPGE r004) field `osd5Alpha0`; access and reset unknown, modelled RW)";
            sw = rw;
            hw = r;
        } osd5Alpha0[23:16];

        field {
            name = "osd4Alpha1";
            desc = "[inferred] Osd4Alpha1. (vendor header `jpeg_reg.h` (JPGE r004) field `osd4Alpha1`; access and reset unknown, modelled RW)";
            sw = rw;
            hw = r;
        } osd4Alpha1[15:8];

        field {
            name = "osd4Alpha0";
            desc = "[inferred] Osd4Alpha0. (vendor header `jpeg_reg.h` (JPGE r004) field `osd4Alpha0`; access and reset unknown, modelled RW)";
            sw = rw;
            hw = r;
        } osd4Alpha0[7:0];
    } VPP_OSD45_ALPHA @ 0x51C;

    reg {
        name = "VPP OSD67 alpha";
        desc = "[inferred] VPP OSD67 alpha. Not in the data sheet. Source: vendor U-Boot 2010.06 upload `product/hiosd/dec/jpeg_reg.h` = `jpge_reg(r004).h` (GPL-2.0 U-Boot tree, Huawei copyright 2012; github.com/Axl-zhang/hisilicon-hi3520d-uboot), union `U_JPGE_OSD67_ALPHA`, struct offset 0x520 (GPL-2.0; same SDK generation as the Hi3520D, chip not named in the file). Reset value and access type unknown (modelled RW, no reset). Confidence: medium (vendor header for this chip family, not hardware verified).";

        field {
            name = "osd7Alpha1";
            desc = "[inferred] Osd7Alpha1. (vendor header `jpeg_reg.h` (JPGE r004) field `osd7Alpha1`; access and reset unknown, modelled RW)";
            sw = rw;
            hw = r;
        } osd7Alpha1[31:24];

        field {
            name = "osd7Alpha0";
            desc = "[inferred] Osd7Alpha0. (vendor header `jpeg_reg.h` (JPGE r004) field `osd7Alpha0`; access and reset unknown, modelled RW)";
            sw = rw;
            hw = r;
        } osd7Alpha0[23:16];

        field {
            name = "osd6Alpha1";
            desc = "[inferred] Osd6Alpha1. (vendor header `jpeg_reg.h` (JPGE r004) field `osd6Alpha1`; access and reset unknown, modelled RW)";
            sw = rw;
            hw = r;
        } osd6Alpha1[15:8];

        field {
            name = "osd6Alpha0";
            desc = "[inferred] Osd6Alpha0. (vendor header `jpeg_reg.h` (JPGE r004) field `osd6Alpha0`; access and reset unknown, modelled RW)";
            sw = rw;
            hw = r;
        } osd6Alpha0[7:0];
    } VPP_OSD67_ALPHA @ 0x520;

    reg {
        name = "VPP OSD ALPHA0123";
        desc = "[inferred] VPP OSD ALPHA0123. Not in the data sheet. Source: vendor U-Boot 2010.06 upload `product/hiosd/dec/jpeg_reg.h` = `jpge_reg(r004).h` (GPL-2.0 U-Boot tree, Huawei copyright 2012; github.com/Axl-zhang/hisilicon-hi3520d-uboot), union `U_JPGE_OSD_ALPHA0123`, struct offset 0x524 (GPL-2.0; same SDK generation as the Hi3520D, chip not named in the file). Reset value and access type unknown (modelled RW, no reset). Confidence: medium (vendor header for this chip family, not hardware verified).";

        field {
            name = "osd3GlobalAlpha";
            desc = "[inferred] Osd3GlobalAlpha. (vendor header `jpeg_reg.h` (JPGE r004) field `osd3GlobalAlpha`; access and reset unknown, modelled RW)";
            sw = rw;
            hw = r;
        } osd3GlobalAlpha[31:24];

        field {
            name = "osd2GlobalAlpha";
            desc = "[inferred] Osd2GlobalAlpha. (vendor header `jpeg_reg.h` (JPGE r004) field `osd2GlobalAlpha`; access and reset unknown, modelled RW)";
            sw = rw;
            hw = r;
        } osd2GlobalAlpha[23:16];

        field {
            name = "osd1GlobalAlpha";
            desc = "[inferred] Osd1GlobalAlpha. (vendor header `jpeg_reg.h` (JPGE r004) field `osd1GlobalAlpha`; access and reset unknown, modelled RW)";
            sw = rw;
            hw = r;
        } osd1GlobalAlpha[15:8];

        field {
            name = "osd0GlobalAlpha";
            desc = "[inferred] Osd0GlobalAlpha. (vendor header `jpeg_reg.h` (JPGE r004) field `osd0GlobalAlpha`; access and reset unknown, modelled RW)";
            sw = rw;
            hw = r;
        } osd0GlobalAlpha[7:0];
    } VPP_OSD_ALPHA0123 @ 0x524;

    reg {
        name = "VPP OSD ALPHA4567";
        desc = "[inferred] VPP OSD ALPHA4567. Not in the data sheet. Source: vendor U-Boot 2010.06 upload `product/hiosd/dec/jpeg_reg.h` = `jpge_reg(r004).h` (GPL-2.0 U-Boot tree, Huawei copyright 2012; github.com/Axl-zhang/hisilicon-hi3520d-uboot), union `U_JPGE_OSD_ALPHA4567`, struct offset 0x528 (GPL-2.0; same SDK generation as the Hi3520D, chip not named in the file). Reset value and access type unknown (modelled RW, no reset). Confidence: medium (vendor header for this chip family, not hardware verified).";

        field {
            name = "osd7GlobalAlpha";
            desc = "[inferred] Osd7GlobalAlpha. (vendor header `jpeg_reg.h` (JPGE r004) field `osd7GlobalAlpha`; access and reset unknown, modelled RW)";
            sw = rw;
            hw = r;
        } osd7GlobalAlpha[31:24];

        field {
            name = "osd6GlobalAlpha";
            desc = "[inferred] Osd6GlobalAlpha. (vendor header `jpeg_reg.h` (JPGE r004) field `osd6GlobalAlpha`; access and reset unknown, modelled RW)";
            sw = rw;
            hw = r;
        } osd6GlobalAlpha[23:16];

        field {
            name = "osd5GlobalAlpha";
            desc = "[inferred] Osd5GlobalAlpha. (vendor header `jpeg_reg.h` (JPGE r004) field `osd5GlobalAlpha`; access and reset unknown, modelled RW)";
            sw = rw;
            hw = r;
        } osd5GlobalAlpha[15:8];

        field {
            name = "osd4GlobalAlpha";
            desc = "[inferred] Osd4GlobalAlpha. (vendor header `jpeg_reg.h` (JPGE r004) field `osd4GlobalAlpha`; access and reset unknown, modelled RW)";
            sw = rw;
            hw = r;
        } osd4GlobalAlpha[7:0];
    } VPP_OSD_ALPHA4567 @ 0x528;

    reg {
        name = "VPP OSD position";
        desc = "[inferred] VPP OSD position. Array of 8 consecutive 32-bit words (header `VPP_OSD_POS[8]`). Not in the data sheet. Source: vendor U-Boot 2010.06 upload `product/hiosd/dec/jpeg_reg.h` = `jpge_reg(r004).h` (GPL-2.0 U-Boot tree, Huawei copyright 2012; github.com/Axl-zhang/hisilicon-hi3520d-uboot), union `U_JPGE_OSD_POS`, struct offset 0x530 (GPL-2.0; same SDK generation as the Hi3520D, chip not named in the file). Reset value and access type unknown (modelled RW, no reset). Confidence: medium (vendor header for this chip family, not hardware verified).";

        field {
            name = "osdStartY";
            desc = "[inferred] OsdStartY. (vendor header `jpeg_reg.h` (JPGE r004) field `osdStartY`; access and reset unknown, modelled RW)";
            sw = rw;
            hw = r;
        } osdStartY[28:16];

        field {
            name = "osdStartX";
            desc = "[inferred] OsdStartX. (vendor header `jpeg_reg.h` (JPGE r004) field `osdStartX`; access and reset unknown, modelled RW)";
            sw = rw;
            hw = r;
        } osdStartX[12:0];
    } VPP_OSD_POS[8] @ 0x530 += 0x4;

    reg {
        name = "VPP OSD SIZE";
        desc = "[inferred] VPP OSD SIZE. Array of 8 consecutive 32-bit words (header `VPP_OSD_SIZE[8]`). Not in the data sheet. Source: vendor U-Boot 2010.06 upload `product/hiosd/dec/jpeg_reg.h` = `jpge_reg(r004).h` (GPL-2.0 U-Boot tree, Huawei copyright 2012; github.com/Axl-zhang/hisilicon-hi3520d-uboot), union `U_JPGE_OSD_SIZE`, struct offset 0x550 (GPL-2.0; same SDK generation as the Hi3520D, chip not named in the file). Reset value and access type unknown (modelled RW, no reset). Confidence: medium (vendor header for this chip family, not hardware verified).";

        field {
            name = "osdH";
            desc = "[inferred] OsdH. (vendor header `jpeg_reg.h` (JPGE r004) field `osdH`; access and reset unknown, modelled RW)";
            sw = rw;
            hw = r;
        } osdH[28:16];

        field {
            name = "osdW";
            desc = "[inferred] OsdW. (vendor header `jpeg_reg.h` (JPGE r004) field `osdW`; access and reset unknown, modelled RW)";
            sw = rw;
            hw = r;
        } osdW[12:0];
    } VPP_OSD_SIZE[8] @ 0x550 += 0x4;

    reg {
        name = "VPP OSD address";
        desc = "[inferred] VPP OSD address. Array of 8 consecutive 32-bit words (header `VPP_OSD_ADDR[8]`). Not in the data sheet. Source: vendor U-Boot 2010.06 upload `product/hiosd/dec/jpeg_reg.h` = `jpge_reg(r004).h` (GPL-2.0 U-Boot tree, Huawei copyright 2012; github.com/Axl-zhang/hisilicon-hi3520d-uboot), union `None`, struct offset 0x570 (GPL-2.0; same SDK generation as the Hi3520D, chip not named in the file). Reset value and access type unknown (modelled RW, no reset). Confidence: medium (vendor header for this chip family, not hardware verified).";

        field {
            name = "value";
            desc = "[inferred] Register value (the header union has no named bits).";
            sw = rw;
            hw = r;
        } value[31:0];
    } VPP_OSD_ADDR[8] @ 0x570 += 0x4;

    reg {
        name = "VPP OSD stride";
        desc = "[inferred] VPP OSD stride. Array of 8 consecutive 32-bit words (header `VPP_OSD_STRIDE[8]`). Not in the data sheet. Source: vendor U-Boot 2010.06 upload `product/hiosd/dec/jpeg_reg.h` = `jpge_reg(r004).h` (GPL-2.0 U-Boot tree, Huawei copyright 2012; github.com/Axl-zhang/hisilicon-hi3520d-uboot), union `U_JPGE_OSD_STRIDE`, struct offset 0x590 (GPL-2.0; same SDK generation as the Hi3520D, chip not named in the file). Reset value and access type unknown (modelled RW, no reset). Confidence: medium (vendor header for this chip family, not hardware verified).";

        field {
            name = "osdStride";
            desc = "[inferred] OsdStride. (vendor header `jpeg_reg.h` (JPGE r004) field `osdStride`; access and reset unknown, modelled RW)";
            sw = rw;
            hw = r;
        } osdStride[15:0];
    } VPP_OSD_STRIDE[8] @ 0x590 += 0x4;

    reg {
        name = "VPP OSD LAYERID";
        desc = "[inferred] VPP OSD LAYERID. Not in the data sheet. Source: vendor U-Boot 2010.06 upload `product/hiosd/dec/jpeg_reg.h` = `jpge_reg(r004).h` (GPL-2.0 U-Boot tree, Huawei copyright 2012; github.com/Axl-zhang/hisilicon-hi3520d-uboot), union `U_JPGE_OSD_LAYERID`, struct offset 0x5C0 (GPL-2.0; same SDK generation as the Hi3520D, chip not named in the file). Reset value and access type unknown (modelled RW, no reset). Confidence: medium (vendor header for this chip family, not hardware verified).";

        field {
            name = "osd7LayerId";
            desc = "[inferred] Osd7LayerId. (vendor header `jpeg_reg.h` (JPGE r004) field `osd7LayerId`; access and reset unknown, modelled RW)";
            sw = rw;
            hw = r;
        } osd7LayerId[30:28];

        field {
            name = "osd6LayerId";
            desc = "[inferred] Osd6LayerId. (vendor header `jpeg_reg.h` (JPGE r004) field `osd6LayerId`; access and reset unknown, modelled RW)";
            sw = rw;
            hw = r;
        } osd6LayerId[26:24];

        field {
            name = "osd5LayerId";
            desc = "[inferred] Osd5LayerId. (vendor header `jpeg_reg.h` (JPGE r004) field `osd5LayerId`; access and reset unknown, modelled RW)";
            sw = rw;
            hw = r;
        } osd5LayerId[22:20];

        field {
            name = "osd4LayerId";
            desc = "[inferred] Osd4LayerId. (vendor header `jpeg_reg.h` (JPGE r004) field `osd4LayerId`; access and reset unknown, modelled RW)";
            sw = rw;
            hw = r;
        } osd4LayerId[18:16];

        field {
            name = "osd3LayerId";
            desc = "[inferred] Osd3LayerId. (vendor header `jpeg_reg.h` (JPGE r004) field `osd3LayerId`; access and reset unknown, modelled RW)";
            sw = rw;
            hw = r;
        } osd3LayerId[14:12];

        field {
            name = "osd2LayerId";
            desc = "[inferred] Osd2LayerId. (vendor header `jpeg_reg.h` (JPGE r004) field `osd2LayerId`; access and reset unknown, modelled RW)";
            sw = rw;
            hw = r;
        } osd2LayerId[10:8];

        field {
            name = "osd1LayerId";
            desc = "[inferred] Osd1LayerId. (vendor header `jpeg_reg.h` (JPGE r004) field `osd1LayerId`; access and reset unknown, modelled RW)";
            sw = rw;
            hw = r;
        } osd1LayerId[6:4];

        field {
            name = "osd0LayerId";
            desc = "[inferred] Osd0LayerId. (vendor header `jpeg_reg.h` (JPGE r004) field `osd0LayerId`; access and reset unknown, modelled RW)";
            sw = rw;
            hw = r;
        } osd0LayerId[2:0];
    } VPP_OSD_LAYERID @ 0x5C0;

    reg {
        name = "VPP OSD CINVCFG";
        desc = "[inferred] VPP OSD CINVCFG. Not in the data sheet. Source: vendor U-Boot 2010.06 upload `product/hiosd/dec/jpeg_reg.h` = `jpge_reg(r004).h` (GPL-2.0 U-Boot tree, Huawei copyright 2012; github.com/Axl-zhang/hisilicon-hi3520d-uboot), union `U_JPGE_OSD_CINVCFG`, struct offset 0x5D0 (GPL-2.0; same SDK generation as the Hi3520D, chip not named in the file). Reset value and access type unknown (modelled RW, no reset). Confidence: medium (vendor header for this chip family, not hardware verified).";

        field {
            name = "osdCinvMode";
            desc = "[inferred] OsdCinvMode. (vendor header `jpeg_reg.h` (JPGE r004) field `osdCinvMode`; access and reset unknown, modelled RW)";
            sw = rw;
            hw = r;
        } osdCinvMode[24:24];

        field {
            name = "osdCinvThr";
            desc = "[inferred] OsdCinvThr. (vendor header `jpeg_reg.h` (JPGE r004) field `osdCinvThr`; access and reset unknown, modelled RW)";
            sw = rw;
            hw = r;
        } osdCinvThr[23:16];

        field {
            name = "osdCinvHeight";
            desc = "[inferred] OsdCinvHeight. (vendor header `jpeg_reg.h` (JPGE r004) field `osdCinvHeight`; access and reset unknown, modelled RW)";
            sw = rw;
            hw = r;
        } osdCinvHeight[11:10];

        field {
            name = "osdCinvWidth";
            desc = "[inferred] OsdCinvWidth. (vendor header `jpeg_reg.h` (JPGE r004) field `osdCinvWidth`; access and reset unknown, modelled RW)";
            sw = rw;
            hw = r;
        } osdCinvWidth[9:8];

        field {
            name = "osd7CinvEn";
            desc = "[inferred] Osd7CinvEn. (vendor header `jpeg_reg.h` (JPGE r004) field `osd7CinvEn`; access and reset unknown, modelled RW)";
            sw = rw;
            hw = r;
        } osd7CinvEn[7:7];

        field {
            name = "osd6CinvEn";
            desc = "[inferred] Osd6CinvEn. (vendor header `jpeg_reg.h` (JPGE r004) field `osd6CinvEn`; access and reset unknown, modelled RW)";
            sw = rw;
            hw = r;
        } osd6CinvEn[6:6];

        field {
            name = "osd5CinvEn";
            desc = "[inferred] Osd5CinvEn. (vendor header `jpeg_reg.h` (JPGE r004) field `osd5CinvEn`; access and reset unknown, modelled RW)";
            sw = rw;
            hw = r;
        } osd5CinvEn[5:5];

        field {
            name = "osd4CinvEn";
            desc = "[inferred] Osd4CinvEn. (vendor header `jpeg_reg.h` (JPGE r004) field `osd4CinvEn`; access and reset unknown, modelled RW)";
            sw = rw;
            hw = r;
        } osd4CinvEn[4:4];

        field {
            name = "osd3CinvEn";
            desc = "[inferred] Osd3CinvEn. (vendor header `jpeg_reg.h` (JPGE r004) field `osd3CinvEn`; access and reset unknown, modelled RW)";
            sw = rw;
            hw = r;
        } osd3CinvEn[3:3];

        field {
            name = "osd2CinvEn";
            desc = "[inferred] Osd2CinvEn. (vendor header `jpeg_reg.h` (JPGE r004) field `osd2CinvEn`; access and reset unknown, modelled RW)";
            sw = rw;
            hw = r;
        } osd2CinvEn[2:2];

        field {
            name = "osd1CinvEn";
            desc = "[inferred] Osd1CinvEn. (vendor header `jpeg_reg.h` (JPGE r004) field `osd1CinvEn`; access and reset unknown, modelled RW)";
            sw = rw;
            hw = r;
        } osd1CinvEn[1:1];

        field {
            name = "osd0CinvEn";
            desc = "[inferred] Osd0CinvEn. (vendor header `jpeg_reg.h` (JPGE r004) field `osd0CinvEn`; access and reset unknown, modelled RW)";
            sw = rw;
            hw = r;
        } osd0CinvEn[0:0];
    } VPP_OSD_CINVCFG @ 0x5D0;

    reg {
        name = "JPGE QPT";
        desc = "Quantization tables, 48 words: Y at words 0..15, Cb at 16..31, Cr at 32..47 (Source: HiSTB driver (register semantics only), confidence MEDIUM; the Linux driver writes Y, then the chroma table twice). Packing (HiSTB driver, MEDIUM): word n holds the 8-bit divisors of the natural-order (raster) entries s, s+8, s+16, s+24 in QP0..QP3 with s = (n & 1) * 32 + n / 2. Previously: 'entry 4n+k' (a guess from the field names); the vendor driver does not store the table that way. Board facts (Source: Hi3520D board read-back 2026-11-10): the window reads back 0 after a write (devmem write 0x12345678, read 0), so it is write-only or its read port is not wired (inferred, Not verified on hardware); the encoded size follows the quality setting (5812/6429/9075/11917 bytes at quality 10/50/95/100), so the writes take effect. Only entry 0 and the overall scale are confirmed by those pictures (flat color bars): the position of the other 63 entries is Not verified on hardware until a textured picture is compared with libjpeg at the same quality. Layout: vendor header jpge_reg(r004).h (Hi3520D U-Boot 2010.06 upload), not in the data sheet.";

        field {
            name = "QP3";
            desc = "Quantization divisor of natural-order entry s + 24 (word n = 0..15 of a table, s = (n & 1) * 32 + n / 2). Source: HiSTB driver (register semantics only), confidence MEDIUM; entry 0 and the scale confirmed (Source: Hi3520D board read-back 2026-11-10), the rest Not verified on hardware. Previously: entry 4n+3. Reads back 0 (Source: Hi3520D board read-back 2026-11-10).";
            sw = w;
            hw = r;
        } QP3[31:24];

        field {
            name = "QP2";
            desc = "Quantization divisor of natural-order entry s + 16 (word n = 0..15 of a table, s = (n & 1) * 32 + n / 2). Source: HiSTB driver (register semantics only), confidence MEDIUM; entry 0 and the scale confirmed (Source: Hi3520D board read-back 2026-11-10), the rest Not verified on hardware. Previously: entry 4n+2. Reads back 0 (Source: Hi3520D board read-back 2026-11-10).";
            sw = w;
            hw = r;
        } QP2[23:16];

        field {
            name = "QP1";
            desc = "Quantization divisor of natural-order entry s + 8 (word n = 0..15 of a table, s = (n & 1) * 32 + n / 2). Source: HiSTB driver (register semantics only), confidence MEDIUM; entry 0 and the scale confirmed (Source: Hi3520D board read-back 2026-11-10), the rest Not verified on hardware. Previously: entry 4n+1. Reads back 0 (Source: Hi3520D board read-back 2026-11-10).";
            sw = w;
            hw = r;
        } QP1[15:8];

        field {
            name = "QP0";
            desc = "Quantization divisor of natural-order entry s (word n = 0..15 of a table, s = (n & 1) * 32 + n / 2). Source: HiSTB driver (register semantics only), confidence MEDIUM; entry 0 and the scale confirmed (Source: Hi3520D board read-back 2026-11-10), the rest Not verified on hardware. Previously: entry 4n+0. Reads back 0 (Source: Hi3520D board read-back 2026-11-10).";
            sw = w;
            hw = r;
        } QP0[7:0];
    } JPGE_QPT[48] @ 0x1000 += 0x4;
};

addrmap aHISI_JPGE {
    name = "HiSilicon JPGE (registers not described)";
    desc = "Not described: no register of this block is described; the registers exist only in closed vendor libraries (the MPP binary modules), not in the data sheet or any vendor source in the tree. The 64 KB window is kept only so that the block base address and size exist in the address map (STUB). JPEG encoder (data sheet 6.3, overview/features only): ISO 10918-1 baseline, YCbCr 4:2:0/4:2:2/4:4:4, planar/semi-planar/YUYV input, up to 8192x8192, separate Y/Cb/Cr quantization tables, 8-region OSD overlay. The vendor MPP JPEGE is a closed-source module (openhisilicon `kernel/jpege` is for other SoCs). No register description anywhere. Base address 0x20660000, GIC interrupt ID 73. Listed as an open item in docs/rdl-sweep/PORT-BLOCKS.md.";

    external mem {
        name = "Undocumented register window";
        desc = "The whole 64 KB window of the block. Register layout unknown; placeholder so the block base address and size exist in the map. No registers are described.";
        mementries = 16384;
        memwidth = 32;
        sw = rw;
    } REGS;
};

`endif
