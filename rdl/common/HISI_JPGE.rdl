`ifndef HISI_JPGE_RDL
`define HISI_JPGE_RDL


regfile eHISI_JPGE {
    name = "HiSilicon JPEG encoder (JPGE, r004 register layout)";
    desc = "
    CANDIDATE LAYOUT, LOW-MEDIUM CONFIDENCE, NOT HARDWARE VERIFIED. JPEG encoder (JPGE) of the Hi3520D SDK generation: 40 registers transcribed from the header `jpge_reg(r004).h` (file `product/hiosd/dec/jpeg_reg.h`, Huawei copyright 2012-05-16, version 2.0) that ships unused inside the Hi3520D vendor U-Boot 2010.06 uploads (https://github.com/Axl-zhang/hisilicon-hi3520d-uboot, https://github.com/hi35xx/hi35xx-buildroot `boot/uboot/u-boot-2010.06`; GPL-2.0 U-Boot tree). The header names no chip and gives no base address; the Hi3520D data sheet (Table 1-1) places the JPGE window at 0x20660000 (GIC interrupt 73) and its 6.3 feature list (baseline JPEG, 4:2:0/4:2:2/4:4:4, planar/semi-planar/packed input, 8192x8192, 8-region OSD, separate Y/Cb/Cr quantization tables) matches this register set (8 VPP_OSD regions, 48-word quantization table). Layout: interrupt set 0x0-0xC (end of picture, buffer full, time-out, config error), picture config 0x10-0x24, source addresses/strides 0x30-0x3C, stream buffer 0x40-0x4C (start, read/write pointers, length), PTS 0x70-0x7C, time-out/timer 0x80/0x84, OUTSTD 0xA4, VERSION 0xFC, VPP overlay 0x500-0x5D0 (8 OSD regions: alpha, position, size, address, stride, layer order, colour inversion), quantization table JPGE_QPT[48] at 0x1000. Reset values and access types are unknown (no data sheet register description; modelled RW, no reset). Hardware probe to confirm the layout before relying on it: read 0x20660000 + 0xFC (JPGE_VERSION, expect a non-zero version word), + 0x0 / + 0x8 (JPGE_INTSTAT / JPGE_RAWINT, expect 0) and + 0x1000.. (JPGE_QPT, read/write test) with the JPGE clock enabled (PERI_CRG). The HiSTB SDK `source/msp/drv/jpge/src/jpge_reg.h` is a later revision of the same register family (same names, extra registers) and was not used. Every register and field desc below is marked `[inferred]` (names from the header, meanings inferred from the names).

    Generated 2026-11-10 by build/rdl-audit/video-rdl-scratch/gen_blocks.py: mechanical transcription of the data sheet register tables (ds_extract2 + description extraction from the PDF) merged with the vendor header; not hardware verified.

    Register sources: 0 registers from the data sheet (-, section -); 40 registers (5 of them arrays) and 0 fields from vendor U-Boot 2010.06 upload `product/hiosd/dec/jpeg_reg.h` = `jpge_reg(r004).h` (GPL-2.0 U-Boot tree, Huawei copyright 2012; github.com/Axl-zhang/hisilicon-hi3520d-uboot) (GPL-2.0; same SDK generation as the Hi3520D, chip not named in the file), each marked `[inferred]` in its desc (names from the header, meanings inferred from the names, reset/access unknown). ";

    reg {
        name = "JPGE INTSTAT";
        desc = "[inferred] JPGE INTSTAT. Not in the data sheet. Source: vendor U-Boot 2010.06 upload `product/hiosd/dec/jpeg_reg.h` = `jpge_reg(r004).h` (GPL-2.0 U-Boot tree, Huawei copyright 2012; github.com/Axl-zhang/hisilicon-hi3520d-uboot), union `U_JPGE_INTSTAT`, struct offset 0x0 (GPL-2.0; same SDK generation as the Hi3520D, chip not named in the file). Reset value and access type unknown (modelled RW, no reset). Confidence: medium (vendor header for this chip family, not hardware verified).";

        field {
            name = "cfgErr";
            desc = "[inferred] Configuration error interrupt. (vendor header `jpeg_reg.h` (JPGE r004) field `cfgErr`; access and reset unknown, modelled RW)";
            sw = rw;
            hw = r;
        } cfgErr[3:3];

        field {
            name = "JpgeTimeout";
            desc = "[inferred] Encoder time-out interrupt (see JPGE_TIMEOUT/JPGE_TIMER). (vendor header `jpeg_reg.h` (JPGE r004) field `JpgeTimeout`; access and reset unknown, modelled RW)";
            sw = rw;
            hw = r;
        } JpgeTimeout[2:2];

        field {
            name = "VencBufFull";
            desc = "[inferred] Stream buffer full interrupt. (vendor header `jpeg_reg.h` (JPGE r004) field `VencBufFull`; access and reset unknown, modelled RW)";
            sw = rw;
            hw = r;
        } VencBufFull[1:1];

        field {
            name = "VencEndOfPic";
            desc = "[inferred] End-of-picture (frame encoded) interrupt. (vendor header `jpeg_reg.h` (JPGE r004) field `VencEndOfPic`; access and reset unknown, modelled RW)";
            sw = rw;
            hw = r;
        } VencEndOfPic[0:0];
    } JPGE_INTSTAT @ 0x0;

    reg {
        name = "JPGE INTMASK";
        desc = "[inferred] JPGE INTMASK. Not in the data sheet. Source: vendor U-Boot 2010.06 upload `product/hiosd/dec/jpeg_reg.h` = `jpge_reg(r004).h` (GPL-2.0 U-Boot tree, Huawei copyright 2012; github.com/Axl-zhang/hisilicon-hi3520d-uboot), union `U_JPGE_INTMASK`, struct offset 0x4 (GPL-2.0; same SDK generation as the Hi3520D, chip not named in the file). Reset value and access type unknown (modelled RW, no reset). Confidence: medium (vendor header for this chip family, not hardware verified).";

        field {
            name = "cfgErrMask";
            desc = "[inferred] Mask of the configuration-error interrupt. (vendor header `jpeg_reg.h` (JPGE r004) field `cfgErrMask`; access and reset unknown, modelled RW)";
            sw = rw;
            hw = r;
        } cfgErrMask[3:3];

        field {
            name = "JpgeTimeoutMask";
            desc = "[inferred] Mask of the time-out interrupt. (vendor header `jpeg_reg.h` (JPGE r004) field `JpgeTimeoutMask`; access and reset unknown, modelled RW)";
            sw = rw;
            hw = r;
        } JpgeTimeoutMask[2:2];

        field {
            name = "VencBufFullMask";
            desc = "[inferred] Mask of the buffer-full interrupt. (vendor header `jpeg_reg.h` (JPGE r004) field `VencBufFullMask`; access and reset unknown, modelled RW)";
            sw = rw;
            hw = r;
        } VencBufFullMask[1:1];

        field {
            name = "VencEndOfPicMask";
            desc = "[inferred] Mask of the end-of-picture interrupt. (vendor header `jpeg_reg.h` (JPGE r004) field `VencEndOfPicMask`; access and reset unknown, modelled RW)";
            sw = rw;
            hw = r;
        } VencEndOfPicMask[0:0];
    } JPGE_INTMASK @ 0x4;

    reg {
        name = "JPGE RAWINT";
        desc = "[inferred] JPGE RAWINT. Not in the data sheet. Source: vendor U-Boot 2010.06 upload `product/hiosd/dec/jpeg_reg.h` = `jpge_reg(r004).h` (GPL-2.0 U-Boot tree, Huawei copyright 2012; github.com/Axl-zhang/hisilicon-hi3520d-uboot), union `U_JPGE_RAWINT`, struct offset 0x8 (GPL-2.0; same SDK generation as the Hi3520D, chip not named in the file). Reset value and access type unknown (modelled RW, no reset). Confidence: medium (vendor header for this chip family, not hardware verified).";

        field {
            name = "cfgErr";
            desc = "[inferred] Configuration error interrupt. (vendor header `jpeg_reg.h` (JPGE r004) field `cfgErr`; access and reset unknown, modelled RW)";
            sw = rw;
            hw = r;
        } cfgErr[3:3];

        field {
            name = "JpgeTimeout";
            desc = "[inferred] Encoder time-out interrupt (see JPGE_TIMEOUT/JPGE_TIMER). (vendor header `jpeg_reg.h` (JPGE r004) field `JpgeTimeout`; access and reset unknown, modelled RW)";
            sw = rw;
            hw = r;
        } JpgeTimeout[2:2];

        field {
            name = "VencBufFull";
            desc = "[inferred] Stream buffer full interrupt. (vendor header `jpeg_reg.h` (JPGE r004) field `VencBufFull`; access and reset unknown, modelled RW)";
            sw = rw;
            hw = r;
        } VencBufFull[1:1];

        field {
            name = "VencEndOfPic";
            desc = "[inferred] End-of-picture (frame encoded) interrupt. (vendor header `jpeg_reg.h` (JPGE r004) field `VencEndOfPic`; access and reset unknown, modelled RW)";
            sw = rw;
            hw = r;
        } VencEndOfPic[0:0];
    } JPGE_RAWINT @ 0x8;

    reg {
        name = "JPGE INTCLR";
        desc = "[inferred] JPGE INTCLR. Not in the data sheet. Source: vendor U-Boot 2010.06 upload `product/hiosd/dec/jpeg_reg.h` = `jpge_reg(r004).h` (GPL-2.0 U-Boot tree, Huawei copyright 2012; github.com/Axl-zhang/hisilicon-hi3520d-uboot), union `U_JPGE_INTCLR`, struct offset 0xC (GPL-2.0; same SDK generation as the Hi3520D, chip not named in the file). Reset value and access type unknown (modelled RW, no reset). Confidence: medium (vendor header for this chip family, not hardware verified).";

        field {
            name = "cfgErrClr";
            desc = "[inferred] Clear the configuration-error interrupt. (vendor header `jpeg_reg.h` (JPGE r004) field `cfgErrClr`; access and reset unknown, modelled RW)";
            sw = rw;
            hw = r;
        } cfgErrClr[3:3];

        field {
            name = "JpgeTimeoutClr";
            desc = "[inferred] Clear the time-out interrupt. (vendor header `jpeg_reg.h` (JPGE r004) field `JpgeTimeoutClr`; access and reset unknown, modelled RW)";
            sw = rw;
            hw = r;
        } JpgeTimeoutClr[2:2];

        field {
            name = "VencBufFullClr";
            desc = "[inferred] Clear the buffer-full interrupt. (vendor header `jpeg_reg.h` (JPGE r004) field `VencBufFullClr`; access and reset unknown, modelled RW)";
            sw = rw;
            hw = r;
        } VencBufFullClr[1:1];

        field {
            name = "VencEndOfPicClr";
            desc = "[inferred] Clear the end-of-picture interrupt. (vendor header `jpeg_reg.h` (JPGE r004) field `VencEndOfPicClr`; access and reset unknown, modelled RW)";
            sw = rw;
            hw = r;
        } VencEndOfPicClr[0:0];
    } JPGE_INTCLR @ 0xC;

    reg {
        name = "JPGE PICFG";
        desc = "[inferred] JPGE PICFG. Not in the data sheet. Source: vendor U-Boot 2010.06 upload `product/hiosd/dec/jpeg_reg.h` = `jpge_reg(r004).h` (GPL-2.0 U-Boot tree, Huawei copyright 2012; github.com/Axl-zhang/hisilicon-hi3520d-uboot), union `U_JPGE_PICFG`, struct offset 0x10 (GPL-2.0; same SDK generation as the Hi3520D, chip not named in the file). Reset value and access type unknown (modelled RW, no reset). Confidence: medium (vendor header for this chip family, not hardware verified).";

        field {
            name = "col2grayEn";
            desc = "[inferred] Col2grayEn. (vendor header `jpeg_reg.h` (JPGE r004) field `col2grayEn`; access and reset unknown, modelled RW)";
            sw = rw;
            hw = r;
        } col2grayEn[29:29];

        field {
            name = "jcpi_clip_en";
            desc = "[inferred] Jcpi clip enable. (vendor header `jpeg_reg.h` (JPGE r004) field `jcpi_clip_en`; access and reset unknown, modelled RW)";
            sw = rw;
            hw = r;
        } jcpi_clip_en[28:28];

        field {
            name = "packageSel";
            desc = "[inferred] PackageSel. (vendor header `jpeg_reg.h` (JPGE r004) field `packageSel`; access and reset unknown, modelled RW)";
            sw = rw;
            hw = r;
        } packageSel[27:20];

        field {
            name = "roundEn";
            desc = "[inferred] RoundEn. (vendor header `jpeg_reg.h` (JPGE r004) field `roundEn`; access and reset unknown, modelled RW)";
            sw = rw;
            hw = r;
        } roundEn[19:19];

        field {
            name = "timeoutEn";
            desc = "[inferred] Enable the encoder time-out. (vendor header `jpeg_reg.h` (JPGE r004) field `timeoutEn`; access and reset unknown, modelled RW)";
            sw = rw;
            hw = r;
        } timeoutEn[18:18];

        field {
            name = "configlockEn";
            desc = "[inferred] Lock the configuration registers while encoding. (vendor header `jpeg_reg.h` (JPGE r004) field `configlockEn`; access and reset unknown, modelled RW)";
            sw = rw;
            hw = r;
        } configlockEn[17:17];

        field {
            name = "memClkGateEn";
            desc = "[inferred] Memory clock-gating enable. (vendor header `jpeg_reg.h` (JPGE r004) field `memClkGateEn`; access and reset unknown, modelled RW)";
            sw = rw;
            hw = r;
        } memClkGateEn[16:16];

        field {
            name = "clkGateEn";
            desc = "[inferred] Clock-gating enable. (vendor header `jpeg_reg.h` (JPGE r004) field `clkGateEn`; access and reset unknown, modelled RW)";
            sw = rw;
            hw = r;
        } clkGateEn[15:14];

        field {
            name = "rotationAngle";
            desc = "[inferred] Rotation of the source picture (0/90/180/270 degrees; encoding not documented). (vendor header `jpeg_reg.h` (JPGE r004) field `rotationAngle`; access and reset unknown, modelled RW)";
            sw = rw;
            hw = r;
        } rotationAngle[13:12];

        field {
            name = "chnId";
            desc = "[inferred] Channel ID written into the stream descriptor. (vendor header `jpeg_reg.h` (JPGE r004) field `chnId`; access and reset unknown, modelled RW)";
            sw = rw;
            hw = r;
        } chnId[11:4];

        field {
            name = "yuvFmt";
            desc = "[inferred] YUV sampling format (4:2:0 / 4:2:2 / 4:4:4; encoding not documented). (vendor header `jpeg_reg.h` (JPGE r004) field `yuvFmt`; access and reset unknown, modelled RW)";
            sw = rw;
            hw = r;
        } yuvFmt[3:2];

        field {
            name = "strFmt";
            desc = "[inferred] Stream/input storage format (planar, semi-planar or packed; encoding not documented). (vendor header `jpeg_reg.h` (JPGE r004) field `strFmt`; access and reset unknown, modelled RW)";
            sw = rw;
            hw = r;
        } strFmt[1:0];
    } JPGE_PICFG @ 0x10;

    reg {
        name = "JPGE ECSCFG";
        desc = "[inferred] JPGE ECSCFG. Not in the data sheet. Source: vendor U-Boot 2010.06 upload `product/hiosd/dec/jpeg_reg.h` = `jpge_reg(r004).h` (GPL-2.0 U-Boot tree, Huawei copyright 2012; github.com/Axl-zhang/hisilicon-hi3520d-uboot), union `U_JPGE_ECSCFG`, struct offset 0x14 (GPL-2.0; same SDK generation as the Hi3520D, chip not named in the file). Reset value and access type unknown (modelled RW, no reset). Confidence: medium (vendor header for this chip family, not hardware verified).";

        field {
            name = "ecsSize";
            desc = "[inferred] Entropy-coded segment size. (vendor header `jpeg_reg.h` (JPGE r004) field `ecsSize`; access and reset unknown, modelled RW)";
            sw = rw;
            hw = r;
        } ecsSize[20:1];

        field {
            name = "ecsSplit";
            desc = "[inferred] Split the stream into entropy-coded segments (restart intervals). (vendor header `jpeg_reg.h` (JPGE r004) field `ecsSplit`; access and reset unknown, modelled RW)";
            sw = rw;
            hw = r;
        } ecsSplit[0:0];
    } JPGE_ECSCFG @ 0x14;

    reg {
        name = "JPGE START";
        desc = "[inferred] JPGE START. Not in the data sheet. Source: vendor U-Boot 2010.06 upload `product/hiosd/dec/jpeg_reg.h` = `jpge_reg(r004).h` (GPL-2.0 U-Boot tree, Huawei copyright 2012; github.com/Axl-zhang/hisilicon-hi3520d-uboot), union `U_JPGE_START`, struct offset 0x1C (GPL-2.0; same SDK generation as the Hi3520D, chip not named in the file). Reset value and access type unknown (modelled RW, no reset). Confidence: medium (vendor header for this chip family, not hardware verified).";

        field {
            name = "VStart";
            desc = "[inferred] Start encoding one picture (self-clearing start bit). (vendor header `jpeg_reg.h` (JPGE r004) field `VStart`; access and reset unknown, modelled RW)";
            sw = rw;
            hw = r;
        } VStart[0:0];
    } JPGE_START @ 0x1C;

    reg {
        name = "JPGE VEDIMGSIZE";
        desc = "[inferred] JPGE VEDIMGSIZE. Not in the data sheet. Source: vendor U-Boot 2010.06 upload `product/hiosd/dec/jpeg_reg.h` = `jpge_reg(r004).h` (GPL-2.0 U-Boot tree, Huawei copyright 2012; github.com/Axl-zhang/hisilicon-hi3520d-uboot), union `U_JPGE_VEDIMGSIZE`, struct offset 0x20 (GPL-2.0; same SDK generation as the Hi3520D, chip not named in the file). Reset value and access type unknown (modelled RW, no reset). Confidence: medium (vendor header for this chip family, not hardware verified).";

        field {
            name = "ImgHeightInPixelsMinus1";
            desc = "[inferred] Picture height in pixels minus 1. (vendor header `jpeg_reg.h` (JPGE r004) field `ImgHeightInPixelsMinus1`; access and reset unknown, modelled RW)";
            sw = rw;
            hw = r;
        } ImgHeightInPixelsMinus1[28:16];

        field {
            name = "ImgWidthInPixelsMinus1";
            desc = "[inferred] Picture width in pixels minus 1. (vendor header `jpeg_reg.h` (JPGE r004) field `ImgWidthInPixelsMinus1`; access and reset unknown, modelled RW)";
            sw = rw;
            hw = r;
        } ImgWidthInPixelsMinus1[12:0];
    } JPGE_VEDIMGSIZE @ 0x20;

    reg {
        name = "JPGE clip THR";
        desc = "[inferred] JPGE clip THR. Not in the data sheet. Source: vendor U-Boot 2010.06 upload `product/hiosd/dec/jpeg_reg.h` = `jpge_reg(r004).h` (GPL-2.0 U-Boot tree, Huawei copyright 2012; github.com/Axl-zhang/hisilicon-hi3520d-uboot), union `U_JPGE_CLIP_THR`, struct offset 0x24 (GPL-2.0; same SDK generation as the Hi3520D, chip not named in the file). Reset value and access type unknown (modelled RW, no reset). Confidence: medium (vendor header for this chip family, not hardware verified).";

        field {
            name = "jcpi_chr_max";
            desc = "[inferred] Chroma clip maximum. (vendor header `jpeg_reg.h` (JPGE r004) field `jcpi_chr_max`; access and reset unknown, modelled RW)";
            sw = rw;
            hw = r;
        } jcpi_chr_max[31:24];

        field {
            name = "jcpi_chr_min";
            desc = "[inferred] Chroma clip minimum. (vendor header `jpeg_reg.h` (JPGE r004) field `jcpi_chr_min`; access and reset unknown, modelled RW)";
            sw = rw;
            hw = r;
        } jcpi_chr_min[23:16];

        field {
            name = "jcpi_luma_max";
            desc = "[inferred] Luma clip maximum. (vendor header `jpeg_reg.h` (JPGE r004) field `jcpi_luma_max`; access and reset unknown, modelled RW)";
            sw = rw;
            hw = r;
        } jcpi_luma_max[15:8];

        field {
            name = "jcpi_luma_min";
            desc = "[inferred] Luma clip minimum. (vendor header `jpeg_reg.h` (JPGE r004) field `jcpi_luma_min`; access and reset unknown, modelled RW)";
            sw = rw;
            hw = r;
        } jcpi_luma_min[7:0];
    } JPGE_CLIP_THR @ 0x24;

    reg {
        name = "JPGE SRCYADDR";
        desc = "[inferred] JPGE SRCYADDR. Not in the data sheet. Source: vendor U-Boot 2010.06 upload `product/hiosd/dec/jpeg_reg.h` = `jpge_reg(r004).h` (GPL-2.0 U-Boot tree, Huawei copyright 2012; github.com/Axl-zhang/hisilicon-hi3520d-uboot), union `None`, struct offset 0x30 (GPL-2.0; same SDK generation as the Hi3520D, chip not named in the file). Reset value and access type unknown (modelled RW, no reset). Confidence: medium (vendor header for this chip family, not hardware verified).";

        field {
            name = "value";
            desc = "[inferred] Register value (the header union has no named bits).";
            sw = rw;
            hw = r;
        } value[31:0];
    } JPGE_SRCYADDR @ 0x30;

    reg {
        name = "JPGE SRCCADDR";
        desc = "[inferred] JPGE SRCCADDR. Not in the data sheet. Source: vendor U-Boot 2010.06 upload `product/hiosd/dec/jpeg_reg.h` = `jpge_reg(r004).h` (GPL-2.0 U-Boot tree, Huawei copyright 2012; github.com/Axl-zhang/hisilicon-hi3520d-uboot), union `None`, struct offset 0x34 (GPL-2.0; same SDK generation as the Hi3520D, chip not named in the file). Reset value and access type unknown (modelled RW, no reset). Confidence: medium (vendor header for this chip family, not hardware verified).";

        field {
            name = "value";
            desc = "[inferred] Register value (the header union has no named bits).";
            sw = rw;
            hw = r;
        } value[31:0];
    } JPGE_SRCCADDR @ 0x34;

    reg {
        name = "JPGE SRCVADDR";
        desc = "[inferred] JPGE SRCVADDR. Not in the data sheet. Source: vendor U-Boot 2010.06 upload `product/hiosd/dec/jpeg_reg.h` = `jpge_reg(r004).h` (GPL-2.0 U-Boot tree, Huawei copyright 2012; github.com/Axl-zhang/hisilicon-hi3520d-uboot), union `None`, struct offset 0x38 (GPL-2.0; same SDK generation as the Hi3520D, chip not named in the file). Reset value and access type unknown (modelled RW, no reset). Confidence: medium (vendor header for this chip family, not hardware verified).";

        field {
            name = "value";
            desc = "[inferred] Register value (the header union has no named bits).";
            sw = rw;
            hw = r;
        } value[31:0];
    } JPGE_SRCVADDR @ 0x38;

    reg {
        name = "JPGE SSTRIDE";
        desc = "[inferred] JPGE SSTRIDE. Not in the data sheet. Source: vendor U-Boot 2010.06 upload `product/hiosd/dec/jpeg_reg.h` = `jpge_reg(r004).h` (GPL-2.0 U-Boot tree, Huawei copyright 2012; github.com/Axl-zhang/hisilicon-hi3520d-uboot), union `U_JPGE_SSTRIDE`, struct offset 0x3C (GPL-2.0; same SDK generation as the Hi3520D, chip not named in the file). Reset value and access type unknown (modelled RW, no reset). Confidence: medium (vendor header for this chip family, not hardware verified).";

        field {
            name = "SrcCStride";
            desc = "[inferred] Source chroma stride in bytes. (vendor header `jpeg_reg.h` (JPGE r004) field `SrcCStride`; access and reset unknown, modelled RW)";
            sw = rw;
            hw = r;
        } SrcCStride[31:16];

        field {
            name = "SrcYStride";
            desc = "[inferred] Source luma stride in bytes. (vendor header `jpeg_reg.h` (JPGE r004) field `SrcYStride`; access and reset unknown, modelled RW)";
            sw = rw;
            hw = r;
        } SrcYStride[15:0];
    } JPGE_SSTRIDE @ 0x3C;

    reg {
        name = "JPGE STRMADDR";
        desc = "[inferred] JPGE STRMADDR. Not in the data sheet. Source: vendor U-Boot 2010.06 upload `product/hiosd/dec/jpeg_reg.h` = `jpge_reg(r004).h` (GPL-2.0 U-Boot tree, Huawei copyright 2012; github.com/Axl-zhang/hisilicon-hi3520d-uboot), union `None`, struct offset 0x40 (GPL-2.0; same SDK generation as the Hi3520D, chip not named in the file). Reset value and access type unknown (modelled RW, no reset). Confidence: medium (vendor header for this chip family, not hardware verified).";

        field {
            name = "value";
            desc = "[inferred] Register value (the header union has no named bits).";
            sw = rw;
            hw = r;
        } value[31:0];
    } JPGE_STRMADDR @ 0x40;

    reg {
        name = "JPGE SRPTRADDR";
        desc = "[inferred] JPGE SRPTRADDR. Not in the data sheet. Source: vendor U-Boot 2010.06 upload `product/hiosd/dec/jpeg_reg.h` = `jpge_reg(r004).h` (GPL-2.0 U-Boot tree, Huawei copyright 2012; github.com/Axl-zhang/hisilicon-hi3520d-uboot), union `None`, struct offset 0x44 (GPL-2.0; same SDK generation as the Hi3520D, chip not named in the file). Reset value and access type unknown (modelled RW, no reset). Confidence: medium (vendor header for this chip family, not hardware verified).";

        field {
            name = "value";
            desc = "[inferred] Register value (the header union has no named bits).";
            sw = rw;
            hw = r;
        } value[31:0];
    } JPGE_SRPTRADDR @ 0x44;

    reg {
        name = "JPGE SWPTRADDR";
        desc = "[inferred] JPGE SWPTRADDR. Not in the data sheet. Source: vendor U-Boot 2010.06 upload `product/hiosd/dec/jpeg_reg.h` = `jpge_reg(r004).h` (GPL-2.0 U-Boot tree, Huawei copyright 2012; github.com/Axl-zhang/hisilicon-hi3520d-uboot), union `None`, struct offset 0x48 (GPL-2.0; same SDK generation as the Hi3520D, chip not named in the file). Reset value and access type unknown (modelled RW, no reset). Confidence: medium (vendor header for this chip family, not hardware verified).";

        field {
            name = "value";
            desc = "[inferred] Register value (the header union has no named bits).";
            sw = rw;
            hw = r;
        } value[31:0];
    } JPGE_SWPTRADDR @ 0x48;

    reg {
        name = "JPGE STRMBUFLEN";
        desc = "[inferred] JPGE STRMBUFLEN. Not in the data sheet. Source: vendor U-Boot 2010.06 upload `product/hiosd/dec/jpeg_reg.h` = `jpge_reg(r004).h` (GPL-2.0 U-Boot tree, Huawei copyright 2012; github.com/Axl-zhang/hisilicon-hi3520d-uboot), union `U_JPGE_STRMBUFLEN`, struct offset 0x4C (GPL-2.0; same SDK generation as the Hi3520D, chip not named in the file). Reset value and access type unknown (modelled RW, no reset). Confidence: medium (vendor header for this chip family, not hardware verified).";

        field {
            name = "BufferLength";
            desc = "[inferred] Stream buffer length (64-byte units: bits [5:0] are not stored). (vendor header `jpeg_reg.h` (JPGE r004) field `BufferLength`; access and reset unknown, modelled RW)";
            sw = rw;
            hw = r;
        } BufferLength[31:6];
    } JPGE_STRMBUFLEN @ 0x4C;

    reg {
        name = "JPGE PTS0";
        desc = "[inferred] JPGE PTS0. Not in the data sheet. Source: vendor U-Boot 2010.06 upload `product/hiosd/dec/jpeg_reg.h` = `jpge_reg(r004).h` (GPL-2.0 U-Boot tree, Huawei copyright 2012; github.com/Axl-zhang/hisilicon-hi3520d-uboot), union `None`, struct offset 0x70 (GPL-2.0; same SDK generation as the Hi3520D, chip not named in the file). Reset value and access type unknown (modelled RW, no reset). Confidence: medium (vendor header for this chip family, not hardware verified).";

        field {
            name = "value";
            desc = "[inferred] Register value (the header union has no named bits).";
            sw = rw;
            hw = r;
        } value[31:0];
    } JPGE_PTS0 @ 0x70;

    reg {
        name = "JPGE PTS1";
        desc = "[inferred] JPGE PTS1. Not in the data sheet. Source: vendor U-Boot 2010.06 upload `product/hiosd/dec/jpeg_reg.h` = `jpge_reg(r004).h` (GPL-2.0 U-Boot tree, Huawei copyright 2012; github.com/Axl-zhang/hisilicon-hi3520d-uboot), union `None`, struct offset 0x74 (GPL-2.0; same SDK generation as the Hi3520D, chip not named in the file). Reset value and access type unknown (modelled RW, no reset). Confidence: medium (vendor header for this chip family, not hardware verified).";

        field {
            name = "value";
            desc = "[inferred] Register value (the header union has no named bits).";
            sw = rw;
            hw = r;
        } value[31:0];
    } JPGE_PTS1 @ 0x74;

    reg {
        name = "JPGE PTS2";
        desc = "[inferred] JPGE PTS2. Not in the data sheet. Source: vendor U-Boot 2010.06 upload `product/hiosd/dec/jpeg_reg.h` = `jpge_reg(r004).h` (GPL-2.0 U-Boot tree, Huawei copyright 2012; github.com/Axl-zhang/hisilicon-hi3520d-uboot), union `None`, struct offset 0x78 (GPL-2.0; same SDK generation as the Hi3520D, chip not named in the file). Reset value and access type unknown (modelled RW, no reset). Confidence: medium (vendor header for this chip family, not hardware verified).";

        field {
            name = "value";
            desc = "[inferred] Register value (the header union has no named bits).";
            sw = rw;
            hw = r;
        } value[31:0];
    } JPGE_PTS2 @ 0x78;

    reg {
        name = "JPGE PTS3";
        desc = "[inferred] JPGE PTS3. Not in the data sheet. Source: vendor U-Boot 2010.06 upload `product/hiosd/dec/jpeg_reg.h` = `jpge_reg(r004).h` (GPL-2.0 U-Boot tree, Huawei copyright 2012; github.com/Axl-zhang/hisilicon-hi3520d-uboot), union `None`, struct offset 0x7C (GPL-2.0; same SDK generation as the Hi3520D, chip not named in the file). Reset value and access type unknown (modelled RW, no reset). Confidence: medium (vendor header for this chip family, not hardware verified).";

        field {
            name = "value";
            desc = "[inferred] Register value (the header union has no named bits).";
            sw = rw;
            hw = r;
        } value[31:0];
    } JPGE_PTS3 @ 0x7C;

    reg {
        name = "JPGE TIMEOUT";
        desc = "[inferred] JPGE TIMEOUT. Not in the data sheet. Source: vendor U-Boot 2010.06 upload `product/hiosd/dec/jpeg_reg.h` = `jpge_reg(r004).h` (GPL-2.0 U-Boot tree, Huawei copyright 2012; github.com/Axl-zhang/hisilicon-hi3520d-uboot), union `None`, struct offset 0x80 (GPL-2.0; same SDK generation as the Hi3520D, chip not named in the file). Reset value and access type unknown (modelled RW, no reset). Confidence: medium (vendor header for this chip family, not hardware verified).";

        field {
            name = "value";
            desc = "[inferred] Register value (the header union has no named bits).";
            sw = rw;
            hw = r;
        } value[31:0];
    } JPGE_TIMEOUT @ 0x80;

    reg {
        name = "JPGE TIMER";
        desc = "[inferred] JPGE TIMER. Not in the data sheet. Source: vendor U-Boot 2010.06 upload `product/hiosd/dec/jpeg_reg.h` = `jpge_reg(r004).h` (GPL-2.0 U-Boot tree, Huawei copyright 2012; github.com/Axl-zhang/hisilicon-hi3520d-uboot), union `None`, struct offset 0x84 (GPL-2.0; same SDK generation as the Hi3520D, chip not named in the file). Reset value and access type unknown (modelled RW, no reset). Confidence: medium (vendor header for this chip family, not hardware verified).";

        field {
            name = "value";
            desc = "[inferred] Register value (the header union has no named bits).";
            sw = rw;
            hw = r;
        } value[31:0];
    } JPGE_TIMER @ 0x84;

    reg {
        name = "JPGE OUTSTD";
        desc = "[inferred] JPGE OUTSTD. Not in the data sheet. Source: vendor U-Boot 2010.06 upload `product/hiosd/dec/jpeg_reg.h` = `jpge_reg(r004).h` (GPL-2.0 U-Boot tree, Huawei copyright 2012; github.com/Axl-zhang/hisilicon-hi3520d-uboot), union `U_JPGE_OUTSTD`, struct offset 0xA4 (GPL-2.0; same SDK generation as the Hi3520D, chip not named in the file). Reset value and access type unknown (modelled RW, no reset). Confidence: medium (vendor header for this chip family, not hardware verified).";

        field {
            name = "outstdNum";
            desc = "[inferred] AXI outstanding request count. (vendor header `jpeg_reg.h` (JPGE r004) field `outstdNum`; access and reset unknown, modelled RW)";
            sw = rw;
            hw = r;
        } outstdNum[3:0];
    } JPGE_OUTSTD @ 0xA4;

    reg {
        name = "JPGE VERSION";
        desc = "[inferred] JPGE VERSION. Not in the data sheet. Source: vendor U-Boot 2010.06 upload `product/hiosd/dec/jpeg_reg.h` = `jpge_reg(r004).h` (GPL-2.0 U-Boot tree, Huawei copyright 2012; github.com/Axl-zhang/hisilicon-hi3520d-uboot), union `None`, struct offset 0xFC (GPL-2.0; same SDK generation as the Hi3520D, chip not named in the file). Reset value and access type unknown (modelled RW, no reset). Confidence: medium (vendor header for this chip family, not hardware verified).";

        field {
            name = "value";
            desc = "[inferred] Register value (the header union has no named bits).";
            sw = rw;
            hw = r;
        } value[31:0];
    } JPGE_VERSION @ 0xFC;

    reg {
        name = "VPP configuration";
        desc = "[inferred] VPP configuration. Not in the data sheet. Source: vendor U-Boot 2010.06 upload `product/hiosd/dec/jpeg_reg.h` = `jpge_reg(r004).h` (GPL-2.0 U-Boot tree, Huawei copyright 2012; github.com/Axl-zhang/hisilicon-hi3520d-uboot), union `U_JPGE_CFG`, struct offset 0x500 (GPL-2.0; same SDK generation as the Hi3520D, chip not named in the file). Reset value and access type unknown (modelled RW, no reset). Confidence: medium (vendor header for this chip family, not hardware verified).";

        field {
            name = "osdEn";
            desc = "[inferred] OSD overlay enable. (vendor header `jpeg_reg.h` (JPGE r004) field `osdEn`; access and reset unknown, modelled RW)";
            sw = rw;
            hw = r;
        } osdEn[5:5];
    } VPP_CFG @ 0x500;

    reg {
        name = "VPP OSD configuration";
        desc = "[inferred] VPP OSD configuration. Not in the data sheet. Source: vendor U-Boot 2010.06 upload `product/hiosd/dec/jpeg_reg.h` = `jpge_reg(r004).h` (GPL-2.0 U-Boot tree, Huawei copyright 2012; github.com/Axl-zhang/hisilicon-hi3520d-uboot), union `U_JPGE_OSD_CFG`, struct offset 0x510 (GPL-2.0; same SDK generation as the Hi3520D, chip not named in the file). Reset value and access type unknown (modelled RW, no reset). Confidence: medium (vendor header for this chip family, not hardware verified).";

        field {
            name = "osd7En";
            desc = "[inferred] Osd7En. (vendor header `jpeg_reg.h` (JPGE r004) field `osd7En`; access and reset unknown, modelled RW)";
            sw = rw;
            hw = r;
        } osd7En[31:31];

        field {
            name = "osd6En";
            desc = "[inferred] Osd6En. (vendor header `jpeg_reg.h` (JPGE r004) field `osd6En`; access and reset unknown, modelled RW)";
            sw = rw;
            hw = r;
        } osd6En[30:30];

        field {
            name = "osd5En";
            desc = "[inferred] Osd5En. (vendor header `jpeg_reg.h` (JPGE r004) field `osd5En`; access and reset unknown, modelled RW)";
            sw = rw;
            hw = r;
        } osd5En[29:29];

        field {
            name = "osd4En";
            desc = "[inferred] Osd4En. (vendor header `jpeg_reg.h` (JPGE r004) field `osd4En`; access and reset unknown, modelled RW)";
            sw = rw;
            hw = r;
        } osd4En[28:28];

        field {
            name = "osd3En";
            desc = "[inferred] Osd3En. (vendor header `jpeg_reg.h` (JPGE r004) field `osd3En`; access and reset unknown, modelled RW)";
            sw = rw;
            hw = r;
        } osd3En[27:27];

        field {
            name = "osd2En";
            desc = "[inferred] Osd2En. (vendor header `jpeg_reg.h` (JPGE r004) field `osd2En`; access and reset unknown, modelled RW)";
            sw = rw;
            hw = r;
        } osd2En[26:26];

        field {
            name = "osd1En";
            desc = "[inferred] Osd1En. (vendor header `jpeg_reg.h` (JPGE r004) field `osd1En`; access and reset unknown, modelled RW)";
            sw = rw;
            hw = r;
        } osd1En[25:25];

        field {
            name = "osd0En";
            desc = "[inferred] Osd0En. (vendor header `jpeg_reg.h` (JPGE r004) field `osd0En`; access and reset unknown, modelled RW)";
            sw = rw;
            hw = r;
        } osd0En[24:24];

        field {
            name = "osd7GlobalEn";
            desc = "[inferred] Osd7GlobalEn. (vendor header `jpeg_reg.h` (JPGE r004) field `osd7GlobalEn`; access and reset unknown, modelled RW)";
            sw = rw;
            hw = r;
        } osd7GlobalEn[23:23];

        field {
            name = "osd6GlobalEn";
            desc = "[inferred] Osd6GlobalEn. (vendor header `jpeg_reg.h` (JPGE r004) field `osd6GlobalEn`; access and reset unknown, modelled RW)";
            sw = rw;
            hw = r;
        } osd6GlobalEn[22:22];

        field {
            name = "osd5GlobalEn";
            desc = "[inferred] Osd5GlobalEn. (vendor header `jpeg_reg.h` (JPGE r004) field `osd5GlobalEn`; access and reset unknown, modelled RW)";
            sw = rw;
            hw = r;
        } osd5GlobalEn[21:21];

        field {
            name = "osd4GlobalEn";
            desc = "[inferred] Osd4GlobalEn. (vendor header `jpeg_reg.h` (JPGE r004) field `osd4GlobalEn`; access and reset unknown, modelled RW)";
            sw = rw;
            hw = r;
        } osd4GlobalEn[20:20];

        field {
            name = "osd3GlobalEn";
            desc = "[inferred] Osd3GlobalEn. (vendor header `jpeg_reg.h` (JPGE r004) field `osd3GlobalEn`; access and reset unknown, modelled RW)";
            sw = rw;
            hw = r;
        } osd3GlobalEn[19:19];

        field {
            name = "osd2GlobalEn";
            desc = "[inferred] Osd2GlobalEn. (vendor header `jpeg_reg.h` (JPGE r004) field `osd2GlobalEn`; access and reset unknown, modelled RW)";
            sw = rw;
            hw = r;
        } osd2GlobalEn[18:18];

        field {
            name = "osd1GlobalEn";
            desc = "[inferred] Osd1GlobalEn. (vendor header `jpeg_reg.h` (JPGE r004) field `osd1GlobalEn`; access and reset unknown, modelled RW)";
            sw = rw;
            hw = r;
        } osd1GlobalEn[17:17];

        field {
            name = "osd0GlobalEn";
            desc = "[inferred] Osd0GlobalEn. (vendor header `jpeg_reg.h` (JPGE r004) field `osd0GlobalEn`; access and reset unknown, modelled RW)";
            sw = rw;
            hw = r;
        } osd0GlobalEn[16:16];

        field {
            name = "osdRgbfmt";
            desc = "[inferred] OSD pixel format. (vendor header `jpeg_reg.h` (JPGE r004) field `osdRgbfmt`; access and reset unknown, modelled RW)";
            sw = rw;
            hw = r;
        } osdRgbfmt[0:0];
    } VPP_OSD_CFG @ 0x510;

    reg {
        name = "VPP OSD01 alpha";
        desc = "[inferred] VPP OSD01 alpha. Not in the data sheet. Source: vendor U-Boot 2010.06 upload `product/hiosd/dec/jpeg_reg.h` = `jpge_reg(r004).h` (GPL-2.0 U-Boot tree, Huawei copyright 2012; github.com/Axl-zhang/hisilicon-hi3520d-uboot), union `U_JPGE_OSD01_ALPHA`, struct offset 0x514 (GPL-2.0; same SDK generation as the Hi3520D, chip not named in the file). Reset value and access type unknown (modelled RW, no reset). Confidence: medium (vendor header for this chip family, not hardware verified).";

        field {
            name = "osd1Alpha1";
            desc = "[inferred] Osd1Alpha1. (vendor header `jpeg_reg.h` (JPGE r004) field `osd1Alpha1`; access and reset unknown, modelled RW)";
            sw = rw;
            hw = r;
        } osd1Alpha1[31:24];

        field {
            name = "osd1Alpha0";
            desc = "[inferred] Osd1Alpha0. (vendor header `jpeg_reg.h` (JPGE r004) field `osd1Alpha0`; access and reset unknown, modelled RW)";
            sw = rw;
            hw = r;
        } osd1Alpha0[23:16];

        field {
            name = "osd0Alpha1";
            desc = "[inferred] Osd0Alpha1. (vendor header `jpeg_reg.h` (JPGE r004) field `osd0Alpha1`; access and reset unknown, modelled RW)";
            sw = rw;
            hw = r;
        } osd0Alpha1[15:8];

        field {
            name = "osd0Alpha0";
            desc = "[inferred] Osd0Alpha0. (vendor header `jpeg_reg.h` (JPGE r004) field `osd0Alpha0`; access and reset unknown, modelled RW)";
            sw = rw;
            hw = r;
        } osd0Alpha0[7:0];
    } VPP_OSD01_ALPHA @ 0x514;

    reg {
        name = "VPP OSD23 alpha";
        desc = "[inferred] VPP OSD23 alpha. Not in the data sheet. Source: vendor U-Boot 2010.06 upload `product/hiosd/dec/jpeg_reg.h` = `jpge_reg(r004).h` (GPL-2.0 U-Boot tree, Huawei copyright 2012; github.com/Axl-zhang/hisilicon-hi3520d-uboot), union `U_JPGE_OSD23_ALPHA`, struct offset 0x518 (GPL-2.0; same SDK generation as the Hi3520D, chip not named in the file). Reset value and access type unknown (modelled RW, no reset). Confidence: medium (vendor header for this chip family, not hardware verified).";

        field {
            name = "osd3Alpha1";
            desc = "[inferred] Osd3Alpha1. (vendor header `jpeg_reg.h` (JPGE r004) field `osd3Alpha1`; access and reset unknown, modelled RW)";
            sw = rw;
            hw = r;
        } osd3Alpha1[31:24];

        field {
            name = "osd3Alpha0";
            desc = "[inferred] Osd3Alpha0. (vendor header `jpeg_reg.h` (JPGE r004) field `osd3Alpha0`; access and reset unknown, modelled RW)";
            sw = rw;
            hw = r;
        } osd3Alpha0[23:16];

        field {
            name = "osd2Alpha1";
            desc = "[inferred] Osd2Alpha1. (vendor header `jpeg_reg.h` (JPGE r004) field `osd2Alpha1`; access and reset unknown, modelled RW)";
            sw = rw;
            hw = r;
        } osd2Alpha1[15:8];

        field {
            name = "osd2Alpha0";
            desc = "[inferred] Osd2Alpha0. (vendor header `jpeg_reg.h` (JPGE r004) field `osd2Alpha0`; access and reset unknown, modelled RW)";
            sw = rw;
            hw = r;
        } osd2Alpha0[7:0];
    } VPP_OSD23_ALPHA @ 0x518;

    reg {
        name = "VPP OSD45 alpha";
        desc = "[inferred] VPP OSD45 alpha. Not in the data sheet. Source: vendor U-Boot 2010.06 upload `product/hiosd/dec/jpeg_reg.h` = `jpge_reg(r004).h` (GPL-2.0 U-Boot tree, Huawei copyright 2012; github.com/Axl-zhang/hisilicon-hi3520d-uboot), union `U_JPGE_OSD45_ALPHA`, struct offset 0x51C (GPL-2.0; same SDK generation as the Hi3520D, chip not named in the file). Reset value and access type unknown (modelled RW, no reset). Confidence: medium (vendor header for this chip family, not hardware verified).";

        field {
            name = "osd5Alpha1";
            desc = "[inferred] Osd5Alpha1. (vendor header `jpeg_reg.h` (JPGE r004) field `osd5Alpha1`; access and reset unknown, modelled RW)";
            sw = rw;
            hw = r;
        } osd5Alpha1[31:24];

        field {
            name = "osd5Alpha0";
            desc = "[inferred] Osd5Alpha0. (vendor header `jpeg_reg.h` (JPGE r004) field `osd5Alpha0`; access and reset unknown, modelled RW)";
            sw = rw;
            hw = r;
        } osd5Alpha0[23:16];

        field {
            name = "osd4Alpha1";
            desc = "[inferred] Osd4Alpha1. (vendor header `jpeg_reg.h` (JPGE r004) field `osd4Alpha1`; access and reset unknown, modelled RW)";
            sw = rw;
            hw = r;
        } osd4Alpha1[15:8];

        field {
            name = "osd4Alpha0";
            desc = "[inferred] Osd4Alpha0. (vendor header `jpeg_reg.h` (JPGE r004) field `osd4Alpha0`; access and reset unknown, modelled RW)";
            sw = rw;
            hw = r;
        } osd4Alpha0[7:0];
    } VPP_OSD45_ALPHA @ 0x51C;

    reg {
        name = "VPP OSD67 alpha";
        desc = "[inferred] VPP OSD67 alpha. Not in the data sheet. Source: vendor U-Boot 2010.06 upload `product/hiosd/dec/jpeg_reg.h` = `jpge_reg(r004).h` (GPL-2.0 U-Boot tree, Huawei copyright 2012; github.com/Axl-zhang/hisilicon-hi3520d-uboot), union `U_JPGE_OSD67_ALPHA`, struct offset 0x520 (GPL-2.0; same SDK generation as the Hi3520D, chip not named in the file). Reset value and access type unknown (modelled RW, no reset). Confidence: medium (vendor header for this chip family, not hardware verified).";

        field {
            name = "osd7Alpha1";
            desc = "[inferred] Osd7Alpha1. (vendor header `jpeg_reg.h` (JPGE r004) field `osd7Alpha1`; access and reset unknown, modelled RW)";
            sw = rw;
            hw = r;
        } osd7Alpha1[31:24];

        field {
            name = "osd7Alpha0";
            desc = "[inferred] Osd7Alpha0. (vendor header `jpeg_reg.h` (JPGE r004) field `osd7Alpha0`; access and reset unknown, modelled RW)";
            sw = rw;
            hw = r;
        } osd7Alpha0[23:16];

        field {
            name = "osd6Alpha1";
            desc = "[inferred] Osd6Alpha1. (vendor header `jpeg_reg.h` (JPGE r004) field `osd6Alpha1`; access and reset unknown, modelled RW)";
            sw = rw;
            hw = r;
        } osd6Alpha1[15:8];

        field {
            name = "osd6Alpha0";
            desc = "[inferred] Osd6Alpha0. (vendor header `jpeg_reg.h` (JPGE r004) field `osd6Alpha0`; access and reset unknown, modelled RW)";
            sw = rw;
            hw = r;
        } osd6Alpha0[7:0];
    } VPP_OSD67_ALPHA @ 0x520;

    reg {
        name = "VPP OSD ALPHA0123";
        desc = "[inferred] VPP OSD ALPHA0123. Not in the data sheet. Source: vendor U-Boot 2010.06 upload `product/hiosd/dec/jpeg_reg.h` = `jpge_reg(r004).h` (GPL-2.0 U-Boot tree, Huawei copyright 2012; github.com/Axl-zhang/hisilicon-hi3520d-uboot), union `U_JPGE_OSD_ALPHA0123`, struct offset 0x524 (GPL-2.0; same SDK generation as the Hi3520D, chip not named in the file). Reset value and access type unknown (modelled RW, no reset). Confidence: medium (vendor header for this chip family, not hardware verified).";

        field {
            name = "osd3GlobalAlpha";
            desc = "[inferred] Osd3GlobalAlpha. (vendor header `jpeg_reg.h` (JPGE r004) field `osd3GlobalAlpha`; access and reset unknown, modelled RW)";
            sw = rw;
            hw = r;
        } osd3GlobalAlpha[31:24];

        field {
            name = "osd2GlobalAlpha";
            desc = "[inferred] Osd2GlobalAlpha. (vendor header `jpeg_reg.h` (JPGE r004) field `osd2GlobalAlpha`; access and reset unknown, modelled RW)";
            sw = rw;
            hw = r;
        } osd2GlobalAlpha[23:16];

        field {
            name = "osd1GlobalAlpha";
            desc = "[inferred] Osd1GlobalAlpha. (vendor header `jpeg_reg.h` (JPGE r004) field `osd1GlobalAlpha`; access and reset unknown, modelled RW)";
            sw = rw;
            hw = r;
        } osd1GlobalAlpha[15:8];

        field {
            name = "osd0GlobalAlpha";
            desc = "[inferred] Osd0GlobalAlpha. (vendor header `jpeg_reg.h` (JPGE r004) field `osd0GlobalAlpha`; access and reset unknown, modelled RW)";
            sw = rw;
            hw = r;
        } osd0GlobalAlpha[7:0];
    } VPP_OSD_ALPHA0123 @ 0x524;

    reg {
        name = "VPP OSD ALPHA4567";
        desc = "[inferred] VPP OSD ALPHA4567. Not in the data sheet. Source: vendor U-Boot 2010.06 upload `product/hiosd/dec/jpeg_reg.h` = `jpge_reg(r004).h` (GPL-2.0 U-Boot tree, Huawei copyright 2012; github.com/Axl-zhang/hisilicon-hi3520d-uboot), union `U_JPGE_OSD_ALPHA4567`, struct offset 0x528 (GPL-2.0; same SDK generation as the Hi3520D, chip not named in the file). Reset value and access type unknown (modelled RW, no reset). Confidence: medium (vendor header for this chip family, not hardware verified).";

        field {
            name = "osd7GlobalAlpha";
            desc = "[inferred] Osd7GlobalAlpha. (vendor header `jpeg_reg.h` (JPGE r004) field `osd7GlobalAlpha`; access and reset unknown, modelled RW)";
            sw = rw;
            hw = r;
        } osd7GlobalAlpha[31:24];

        field {
            name = "osd6GlobalAlpha";
            desc = "[inferred] Osd6GlobalAlpha. (vendor header `jpeg_reg.h` (JPGE r004) field `osd6GlobalAlpha`; access and reset unknown, modelled RW)";
            sw = rw;
            hw = r;
        } osd6GlobalAlpha[23:16];

        field {
            name = "osd5GlobalAlpha";
            desc = "[inferred] Osd5GlobalAlpha. (vendor header `jpeg_reg.h` (JPGE r004) field `osd5GlobalAlpha`; access and reset unknown, modelled RW)";
            sw = rw;
            hw = r;
        } osd5GlobalAlpha[15:8];

        field {
            name = "osd4GlobalAlpha";
            desc = "[inferred] Osd4GlobalAlpha. (vendor header `jpeg_reg.h` (JPGE r004) field `osd4GlobalAlpha`; access and reset unknown, modelled RW)";
            sw = rw;
            hw = r;
        } osd4GlobalAlpha[7:0];
    } VPP_OSD_ALPHA4567 @ 0x528;

    reg {
        name = "VPP OSD position";
        desc = "[inferred] VPP OSD position. Array of 8 consecutive 32-bit words (header `VPP_OSD_POS[8]`). Not in the data sheet. Source: vendor U-Boot 2010.06 upload `product/hiosd/dec/jpeg_reg.h` = `jpge_reg(r004).h` (GPL-2.0 U-Boot tree, Huawei copyright 2012; github.com/Axl-zhang/hisilicon-hi3520d-uboot), union `U_JPGE_OSD_POS`, struct offset 0x530 (GPL-2.0; same SDK generation as the Hi3520D, chip not named in the file). Reset value and access type unknown (modelled RW, no reset). Confidence: medium (vendor header for this chip family, not hardware verified).";

        field {
            name = "osdStartY";
            desc = "[inferred] OsdStartY. (vendor header `jpeg_reg.h` (JPGE r004) field `osdStartY`; access and reset unknown, modelled RW)";
            sw = rw;
            hw = r;
        } osdStartY[28:16];

        field {
            name = "osdStartX";
            desc = "[inferred] OsdStartX. (vendor header `jpeg_reg.h` (JPGE r004) field `osdStartX`; access and reset unknown, modelled RW)";
            sw = rw;
            hw = r;
        } osdStartX[12:0];
    } VPP_OSD_POS[8] @ 0x530 += 0x4;

    reg {
        name = "VPP OSD SIZE";
        desc = "[inferred] VPP OSD SIZE. Array of 8 consecutive 32-bit words (header `VPP_OSD_SIZE[8]`). Not in the data sheet. Source: vendor U-Boot 2010.06 upload `product/hiosd/dec/jpeg_reg.h` = `jpge_reg(r004).h` (GPL-2.0 U-Boot tree, Huawei copyright 2012; github.com/Axl-zhang/hisilicon-hi3520d-uboot), union `U_JPGE_OSD_SIZE`, struct offset 0x550 (GPL-2.0; same SDK generation as the Hi3520D, chip not named in the file). Reset value and access type unknown (modelled RW, no reset). Confidence: medium (vendor header for this chip family, not hardware verified).";

        field {
            name = "osdH";
            desc = "[inferred] OsdH. (vendor header `jpeg_reg.h` (JPGE r004) field `osdH`; access and reset unknown, modelled RW)";
            sw = rw;
            hw = r;
        } osdH[28:16];

        field {
            name = "osdW";
            desc = "[inferred] OsdW. (vendor header `jpeg_reg.h` (JPGE r004) field `osdW`; access and reset unknown, modelled RW)";
            sw = rw;
            hw = r;
        } osdW[12:0];
    } VPP_OSD_SIZE[8] @ 0x550 += 0x4;

    reg {
        name = "VPP OSD address";
        desc = "[inferred] VPP OSD address. Array of 8 consecutive 32-bit words (header `VPP_OSD_ADDR[8]`). Not in the data sheet. Source: vendor U-Boot 2010.06 upload `product/hiosd/dec/jpeg_reg.h` = `jpge_reg(r004).h` (GPL-2.0 U-Boot tree, Huawei copyright 2012; github.com/Axl-zhang/hisilicon-hi3520d-uboot), union `None`, struct offset 0x570 (GPL-2.0; same SDK generation as the Hi3520D, chip not named in the file). Reset value and access type unknown (modelled RW, no reset). Confidence: medium (vendor header for this chip family, not hardware verified).";

        field {
            name = "value";
            desc = "[inferred] Register value (the header union has no named bits).";
            sw = rw;
            hw = r;
        } value[31:0];
    } VPP_OSD_ADDR[8] @ 0x570 += 0x4;

    reg {
        name = "VPP OSD stride";
        desc = "[inferred] VPP OSD stride. Array of 8 consecutive 32-bit words (header `VPP_OSD_STRIDE[8]`). Not in the data sheet. Source: vendor U-Boot 2010.06 upload `product/hiosd/dec/jpeg_reg.h` = `jpge_reg(r004).h` (GPL-2.0 U-Boot tree, Huawei copyright 2012; github.com/Axl-zhang/hisilicon-hi3520d-uboot), union `U_JPGE_OSD_STRIDE`, struct offset 0x590 (GPL-2.0; same SDK generation as the Hi3520D, chip not named in the file). Reset value and access type unknown (modelled RW, no reset). Confidence: medium (vendor header for this chip family, not hardware verified).";

        field {
            name = "osdStride";
            desc = "[inferred] OsdStride. (vendor header `jpeg_reg.h` (JPGE r004) field `osdStride`; access and reset unknown, modelled RW)";
            sw = rw;
            hw = r;
        } osdStride[15:0];
    } VPP_OSD_STRIDE[8] @ 0x590 += 0x4;

    reg {
        name = "VPP OSD LAYERID";
        desc = "[inferred] VPP OSD LAYERID. Not in the data sheet. Source: vendor U-Boot 2010.06 upload `product/hiosd/dec/jpeg_reg.h` = `jpge_reg(r004).h` (GPL-2.0 U-Boot tree, Huawei copyright 2012; github.com/Axl-zhang/hisilicon-hi3520d-uboot), union `U_JPGE_OSD_LAYERID`, struct offset 0x5C0 (GPL-2.0; same SDK generation as the Hi3520D, chip not named in the file). Reset value and access type unknown (modelled RW, no reset). Confidence: medium (vendor header for this chip family, not hardware verified).";

        field {
            name = "osd7LayerId";
            desc = "[inferred] Osd7LayerId. (vendor header `jpeg_reg.h` (JPGE r004) field `osd7LayerId`; access and reset unknown, modelled RW)";
            sw = rw;
            hw = r;
        } osd7LayerId[30:28];

        field {
            name = "osd6LayerId";
            desc = "[inferred] Osd6LayerId. (vendor header `jpeg_reg.h` (JPGE r004) field `osd6LayerId`; access and reset unknown, modelled RW)";
            sw = rw;
            hw = r;
        } osd6LayerId[26:24];

        field {
            name = "osd5LayerId";
            desc = "[inferred] Osd5LayerId. (vendor header `jpeg_reg.h` (JPGE r004) field `osd5LayerId`; access and reset unknown, modelled RW)";
            sw = rw;
            hw = r;
        } osd5LayerId[22:20];

        field {
            name = "osd4LayerId";
            desc = "[inferred] Osd4LayerId. (vendor header `jpeg_reg.h` (JPGE r004) field `osd4LayerId`; access and reset unknown, modelled RW)";
            sw = rw;
            hw = r;
        } osd4LayerId[18:16];

        field {
            name = "osd3LayerId";
            desc = "[inferred] Osd3LayerId. (vendor header `jpeg_reg.h` (JPGE r004) field `osd3LayerId`; access and reset unknown, modelled RW)";
            sw = rw;
            hw = r;
        } osd3LayerId[14:12];

        field {
            name = "osd2LayerId";
            desc = "[inferred] Osd2LayerId. (vendor header `jpeg_reg.h` (JPGE r004) field `osd2LayerId`; access and reset unknown, modelled RW)";
            sw = rw;
            hw = r;
        } osd2LayerId[10:8];

        field {
            name = "osd1LayerId";
            desc = "[inferred] Osd1LayerId. (vendor header `jpeg_reg.h` (JPGE r004) field `osd1LayerId`; access and reset unknown, modelled RW)";
            sw = rw;
            hw = r;
        } osd1LayerId[6:4];

        field {
            name = "osd0LayerId";
            desc = "[inferred] Osd0LayerId. (vendor header `jpeg_reg.h` (JPGE r004) field `osd0LayerId`; access and reset unknown, modelled RW)";
            sw = rw;
            hw = r;
        } osd0LayerId[2:0];
    } VPP_OSD_LAYERID @ 0x5C0;

    reg {
        name = "VPP OSD CINVCFG";
        desc = "[inferred] VPP OSD CINVCFG. Not in the data sheet. Source: vendor U-Boot 2010.06 upload `product/hiosd/dec/jpeg_reg.h` = `jpge_reg(r004).h` (GPL-2.0 U-Boot tree, Huawei copyright 2012; github.com/Axl-zhang/hisilicon-hi3520d-uboot), union `U_JPGE_OSD_CINVCFG`, struct offset 0x5D0 (GPL-2.0; same SDK generation as the Hi3520D, chip not named in the file). Reset value and access type unknown (modelled RW, no reset). Confidence: medium (vendor header for this chip family, not hardware verified).";

        field {
            name = "osdCinvMode";
            desc = "[inferred] OsdCinvMode. (vendor header `jpeg_reg.h` (JPGE r004) field `osdCinvMode`; access and reset unknown, modelled RW)";
            sw = rw;
            hw = r;
        } osdCinvMode[24:24];

        field {
            name = "osdCinvThr";
            desc = "[inferred] OsdCinvThr. (vendor header `jpeg_reg.h` (JPGE r004) field `osdCinvThr`; access and reset unknown, modelled RW)";
            sw = rw;
            hw = r;
        } osdCinvThr[23:16];

        field {
            name = "osdCinvHeight";
            desc = "[inferred] OsdCinvHeight. (vendor header `jpeg_reg.h` (JPGE r004) field `osdCinvHeight`; access and reset unknown, modelled RW)";
            sw = rw;
            hw = r;
        } osdCinvHeight[11:10];

        field {
            name = "osdCinvWidth";
            desc = "[inferred] OsdCinvWidth. (vendor header `jpeg_reg.h` (JPGE r004) field `osdCinvWidth`; access and reset unknown, modelled RW)";
            sw = rw;
            hw = r;
        } osdCinvWidth[9:8];

        field {
            name = "osd7CinvEn";
            desc = "[inferred] Osd7CinvEn. (vendor header `jpeg_reg.h` (JPGE r004) field `osd7CinvEn`; access and reset unknown, modelled RW)";
            sw = rw;
            hw = r;
        } osd7CinvEn[7:7];

        field {
            name = "osd6CinvEn";
            desc = "[inferred] Osd6CinvEn. (vendor header `jpeg_reg.h` (JPGE r004) field `osd6CinvEn`; access and reset unknown, modelled RW)";
            sw = rw;
            hw = r;
        } osd6CinvEn[6:6];

        field {
            name = "osd5CinvEn";
            desc = "[inferred] Osd5CinvEn. (vendor header `jpeg_reg.h` (JPGE r004) field `osd5CinvEn`; access and reset unknown, modelled RW)";
            sw = rw;
            hw = r;
        } osd5CinvEn[5:5];

        field {
            name = "osd4CinvEn";
            desc = "[inferred] Osd4CinvEn. (vendor header `jpeg_reg.h` (JPGE r004) field `osd4CinvEn`; access and reset unknown, modelled RW)";
            sw = rw;
            hw = r;
        } osd4CinvEn[4:4];

        field {
            name = "osd3CinvEn";
            desc = "[inferred] Osd3CinvEn. (vendor header `jpeg_reg.h` (JPGE r004) field `osd3CinvEn`; access and reset unknown, modelled RW)";
            sw = rw;
            hw = r;
        } osd3CinvEn[3:3];

        field {
            name = "osd2CinvEn";
            desc = "[inferred] Osd2CinvEn. (vendor header `jpeg_reg.h` (JPGE r004) field `osd2CinvEn`; access and reset unknown, modelled RW)";
            sw = rw;
            hw = r;
        } osd2CinvEn[2:2];

        field {
            name = "osd1CinvEn";
            desc = "[inferred] Osd1CinvEn. (vendor header `jpeg_reg.h` (JPGE r004) field `osd1CinvEn`; access and reset unknown, modelled RW)";
            sw = rw;
            hw = r;
        } osd1CinvEn[1:1];

        field {
            name = "osd0CinvEn";
            desc = "[inferred] Osd0CinvEn. (vendor header `jpeg_reg.h` (JPGE r004) field `osd0CinvEn`; access and reset unknown, modelled RW)";
            sw = rw;
            hw = r;
        } osd0CinvEn[0:0];
    } VPP_OSD_CINVCFG @ 0x5D0;

    reg {
        name = "JPGE QPT";
        desc = "[inferred] JPGE QPT. Array of 48 consecutive 32-bit words (header `JPGE_QPT[48]`). Not in the data sheet. Source: vendor U-Boot 2010.06 upload `product/hiosd/dec/jpeg_reg.h` = `jpge_reg(r004).h` (GPL-2.0 U-Boot tree, Huawei copyright 2012; github.com/Axl-zhang/hisilicon-hi3520d-uboot), union `U_JPGE_QPT`, struct offset 0x1000 (GPL-2.0; same SDK generation as the Hi3520D, chip not named in the file). Reset value and access type unknown (modelled RW, no reset). Confidence: medium (vendor header for this chip family, not hardware verified).";

        field {
            name = "QP3";
            desc = "[inferred] Quantization table entry 4n+3. (vendor header `jpeg_reg.h` (JPGE r004) field `QP3`; access and reset unknown, modelled RW)";
            sw = rw;
            hw = r;
        } QP3[31:24];

        field {
            name = "QP2";
            desc = "[inferred] Quantization table entry 4n+2. (vendor header `jpeg_reg.h` (JPGE r004) field `QP2`; access and reset unknown, modelled RW)";
            sw = rw;
            hw = r;
        } QP2[23:16];

        field {
            name = "QP1";
            desc = "[inferred] Quantization table entry 4n+1. (vendor header `jpeg_reg.h` (JPGE r004) field `QP1`; access and reset unknown, modelled RW)";
            sw = rw;
            hw = r;
        } QP1[15:8];

        field {
            name = "QP0";
            desc = "[inferred] Quantization table entry 4n. (vendor header `jpeg_reg.h` (JPGE r004) field `QP0`; access and reset unknown, modelled RW)";
            sw = rw;
            hw = r;
        } QP0[7:0];
    } JPGE_QPT[48] @ 0x1000 += 0x4;
};

addrmap aHISI_JPGE {
    name = "HiSilicon JPGE (registers not described)";
    desc = "Not described: no register of this block is described; the registers exist only in closed vendor libraries (the MPP binary modules), not in the data sheet or any vendor source in the tree. The 64 KB window is kept only so that the block base address and size exist in the address map (STUB). JPEG encoder (data sheet 6.3, overview/features only): ISO 10918-1 baseline, YCbCr 4:2:0/4:2:2/4:4:4, planar/semi-planar/YUYV input, up to 8192x8192, separate Y/Cb/Cr quantization tables, 8-region OSD overlay. The vendor MPP JPEGE is a closed-source module (openhisilicon `kernel/jpege` is for other SoCs). No register description anywhere. Base address 0x20660000, GIC interrupt ID 73. Listed as an open item in docs/rdl-sweep/PORT-BLOCKS.md.";

    external mem {
        name = "Undocumented register window";
        desc = "The whole 64 KB window of the block. Register layout unknown; placeholder so the block base address and size exist in the map. No registers are described.";
        mementries = 16384;
        memwidth = 32;
        sw = rw;
    } REGS;
};

`endif
