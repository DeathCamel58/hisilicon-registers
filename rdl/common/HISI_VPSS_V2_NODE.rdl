`ifndef HISI_VPSS_V2_NODE_RDL
`define HISI_VPSS_V2_NODE_RDL

regfile eHISI_VPSS_V2_NODE {
    name = "VPSS job node image (NOT A REGISTER FILE), Hi3516C V300 / E V100";
    desc = "NOT A REGISTER FILE and NOT INSTANTIATED: layout of one VPSS job node (register image in DDR) as written by the VPSS_HAL_Set* functions of hi3516cv300_vpss.ko (Xiongmai V4.02.R12, MPP V1.0.0.0), described as a regfile only to document offsets. Link words: NODE_ID 0x1F4, MASK 0x1FC, NEXT 0x2FC, timeout 0x31C (see eHISI_VPSS_V2). 44 setter functions were scanned; fields written through register arithmetic the scanner does not follow (computed shifts and widths) show only the constant masks, so bit extents are LOWER BOUNDS, and functions that call other helpers (SetChnCtrl, SetOutstanding, SetLcmpCfg, SetRfrLcmpSize) show no word. Provenance per word below. Not hardware verified.";

    reg {
        name = "Node word at offset 0x4";
        desc = "Word 0x4 of the node image. PROVENANCE: PROVEN offset and the listed bit extents (read from the load/store/bic/orr sequence of the named vendor function, hi3516cv300 Xiongmai module); INFERRED that a function name describes the content; UNKNOWN field meaning. Written by: VPSS_HAL_SetGrpCropAttr; VPSS_HAL_SetCover; VPSS_HAL_SetChnSclCfg.";
        field {
            name = "word";
            desc = "32-bit word (layout see the register description).";
            sw = rw;
            hw = r;
        } word[31:0];
    } NODE_W_004 @ 0x4;

    reg {
        name = "Node word at offset 0x8";
        desc = "Word 0x8 of the node image. PROVENANCE: PROVEN offset and the listed bit extents (read from the load/store/bic/orr sequence of the named vendor function, hi3516cv300 Xiongmai module); INFERRED that a function name describes the content; UNKNOWN field meaning. Written by: VPSS_HAL_SetChnEn modifies bits [2:2] (inserts a value at shift 2); VPSS_HAL_SetSrcImgType modifies bits [20:20] (inserts a value at shift 20); VPSS_HAL_SetCover; VPSS_HAL_SetChnSclCfg.";
        field {
            name = "word";
            desc = "32-bit word (layout see the register description).";
            sw = rw;
            hw = r;
        } word[31:0];
    } NODE_W_008 @ 0x8;

    reg {
        name = "Node word at offset 0xC";
        desc = "Word 0xC of the node image. PROVENANCE: PROVEN offset and the listed bit extents (read from the load/store/bic/orr sequence of the named vendor function, hi3516cv300 Xiongmai module); INFERRED that a function name describes the content; UNKNOWN field meaning. Written by: VPSS_HAL_SetVadSel modifies bits [3:3] (inserts a value at shift 3); VPSS_HAL_SetImgWorkType modifies bits [2:1] (inserts a value at shift 1); VPSS_HAL_SetCover; VPSS_HAL_SetChnSclCfg modifies bits [20:19] (inserts a value at shift 19).";
        field {
            name = "word";
            desc = "32-bit word (layout see the register description).";
            sw = rw;
            hw = r;
        } word[31:0];
    } NODE_W_00C @ 0xC;

    reg {
        name = "Node word at offset 0x10";
        desc = "Word 0x10 of the node image. PROVENANCE: PROVEN offset and the listed bit extents (read from the load/store/bic/orr sequence of the named vendor function, hi3516cv300 Xiongmai module); INFERRED that a function name describes the content; UNKNOWN field meaning. Written by: VPSS_HAL_SetRegup; VPSS_HAL_SetCover; VPSS_HAL_SetChnSclCfg.";
        field {
            name = "word";
            desc = "32-bit word (layout see the register description).";
            sw = rw;
            hw = r;
        } word[31:0];
    } NODE_W_010 @ 0x10;

    reg {
        name = "Node word at offset 0x14";
        desc = "Word 0x14 of the node image. PROVENANCE: PROVEN offset and the listed bit extents (read from the load/store/bic/orr sequence of the named vendor function, hi3516cv300 Xiongmai module); INFERRED that a function name describes the content; UNKNOWN field meaning. Written by: VPSS_HAL_SetCover; VPSS_HAL_SetChnSclCfg.";
        field {
            name = "word";
            desc = "32-bit word (layout see the register description).";
            sw = rw;
            hw = r;
        } word[31:0];
    } NODE_W_014 @ 0x14;

    reg {
        name = "Node word at offset 0x18";
        desc = "Word 0x18 of the node image. PROVENANCE: PROVEN offset and the listed bit extents (read from the load/store/bic/orr sequence of the named vendor function, hi3516cv300 Xiongmai module); INFERRED that a function name describes the content; UNKNOWN field meaning. Written by: VPSS_HAL_SetChnSclCfg.";
        field {
            name = "word";
            desc = "32-bit word (layout see the register description).";
            sw = rw;
            hw = r;
        } word[31:0];
    } NODE_W_018 @ 0x18;

    reg {
        name = "Node word at offset 0x20";
        desc = "Word 0x20 of the node image. PROVENANCE: PROVEN offset and the listed bit extents (read from the load/store/bic/orr sequence of the named vendor function, hi3516cv300 Xiongmai module); INFERRED that a function name describes the content; UNKNOWN field meaning. Written by: VPSS_HAL_SetSrcImgSize.";
        field {
            name = "word";
            desc = "32-bit word (layout see the register description).";
            sw = rw;
            hw = r;
        } word[31:0];
    } NODE_W_020 @ 0x20;

    reg {
        name = "Node word at offset 0x24";
        desc = "Word 0x24 of the node image. PROVENANCE: PROVEN offset and the listed bit extents (read from the load/store/bic/orr sequence of the named vendor function, hi3516cv300 Xiongmai module); INFERRED that a function name describes the content; UNKNOWN field meaning. Written by: VPSS_HAL_SetRefPicSize.";
        field {
            name = "word";
            desc = "32-bit word (layout see the register description).";
            sw = rw;
            hw = r;
        } word[31:0];
    } NODE_W_024 @ 0x24;

    reg {
        name = "Node word at offset 0x28";
        desc = "Word 0x28 of the node image. PROVENANCE: PROVEN offset and the listed bit extents (read from the load/store/bic/orr sequence of the named vendor function, hi3516cv300 Xiongmai module); INFERRED that a function name describes the content; UNKNOWN field meaning. Written by: VPSS_HAL_SetGrpCropAttr.";
        field {
            name = "word";
            desc = "32-bit word (layout see the register description).";
            sw = rw;
            hw = r;
        } word[31:0];
    } NODE_W_028 @ 0x28;

    reg {
        name = "Node word at offset 0x2C";
        desc = "Word 0x2C of the node image. PROVENANCE: PROVEN offset and the listed bit extents (read from the load/store/bic/orr sequence of the named vendor function, hi3516cv300 Xiongmai module); INFERRED that a function name describes the content; UNKNOWN field meaning. Written by: VPSS_HAL_SetGrpCropAttr.";
        field {
            name = "word";
            desc = "32-bit word (layout see the register description).";
            sw = rw;
            hw = r;
        } word[31:0];
    } NODE_W_02C @ 0x2C;

    reg {
        name = "Node word at offset 0x30";
        desc = "Word 0x30 of the node image. PROVENANCE: PROVEN offset and the listed bit extents (read from the load/store/bic/orr sequence of the named vendor function, hi3516cv300 Xiongmai module); INFERRED that a function name describes the content; UNKNOWN field meaning. Written by: VPSS_HAL_SetGrpCropAttr.";
        field {
            name = "word";
            desc = "32-bit word (layout see the register description).";
            sw = rw;
            hw = r;
        } word[31:0];
    } NODE_W_030 @ 0x30;

    reg {
        name = "Node word at offset 0x34";
        desc = "Word 0x34 of the node image. PROVENANCE: PROVEN offset and the listed bit extents (read from the load/store/bic/orr sequence of the named vendor function, hi3516cv300 Xiongmai module); INFERRED that a function name describes the content; UNKNOWN field meaning. Written by: VPSS_HAL_SetGrpCropAttr.";
        field {
            name = "word";
            desc = "32-bit word (layout see the register description).";
            sw = rw;
            hw = r;
        } word[31:0];
    } NODE_W_034 @ 0x34;

    reg {
        name = "Node word at offset 0x3C";
        desc = "Word 0x3C of the node image. PROVENANCE: PROVEN offset and the listed bit extents (read from the load/store/bic/orr sequence of the named vendor function, hi3516cv300 Xiongmai module); INFERRED that a function name describes the content; UNKNOWN field meaning. Written by: VPSS_HAL_SetChnCrop.";
        field {
            name = "word";
            desc = "32-bit word (layout see the register description).";
            sw = rw;
            hw = r;
        } word[31:0];
    } NODE_W_03C @ 0x3C;

    reg {
        name = "Node word at offset 0x40";
        desc = "Word 0x40 of the node image. PROVENANCE: PROVEN offset and the listed bit extents (read from the load/store/bic/orr sequence of the named vendor function, hi3516cv300 Xiongmai module); INFERRED that a function name describes the content; UNKNOWN field meaning. Written by: VPSS_HAL_SetChnSclCfg.";
        field {
            name = "word";
            desc = "32-bit word (layout see the register description).";
            sw = rw;
            hw = r;
        } word[31:0];
    } NODE_W_040 @ 0x40;

    reg {
        name = "Node word at offset 0x44";
        desc = "Word 0x44 of the node image. PROVENANCE: PROVEN offset and the listed bit extents (read from the load/store/bic/orr sequence of the named vendor function, hi3516cv300 Xiongmai module); INFERRED that a function name describes the content; UNKNOWN field meaning. Written by: VPSS_HAL_SetChnCrop; VPSS_HAL_SetChnSclCfg.";
        field {
            name = "word";
            desc = "32-bit word (layout see the register description).";
            sw = rw;
            hw = r;
        } word[31:0];
    } NODE_W_044 @ 0x44;

    reg {
        name = "Node word at offset 0x48";
        desc = "Word 0x48 of the node image. PROVENANCE: PROVEN offset and the listed bit extents (read from the load/store/bic/orr sequence of the named vendor function, hi3516cv300 Xiongmai module); INFERRED that a function name describes the content; UNKNOWN field meaning. Written by: VPSS_HAL_SetChnSclCfg.";
        field {
            name = "word";
            desc = "32-bit word (layout see the register description).";
            sw = rw;
            hw = r;
        } word[31:0];
    } NODE_W_048 @ 0x48;

    reg {
        name = "Node word at offset 0x4C";
        desc = "Word 0x4C of the node image. PROVENANCE: PROVEN offset and the listed bit extents (read from the load/store/bic/orr sequence of the named vendor function, hi3516cv300 Xiongmai module); INFERRED that a function name describes the content; UNKNOWN field meaning. Written by: VPSS_HAL_SetChnSclCfg modifies bits [20:19] (inserts a value at shift 19).";
        field {
            name = "word";
            desc = "32-bit word (layout see the register description).";
            sw = rw;
            hw = r;
        } word[31:0];
    } NODE_W_04C @ 0x4C;

    reg {
        name = "Node word at offset 0x50";
        desc = "Word 0x50 of the node image. PROVENANCE: PROVEN offset and the listed bit extents (read from the load/store/bic/orr sequence of the named vendor function, hi3516cv300 Xiongmai module); INFERRED that a function name describes the content; UNKNOWN field meaning. Written by: VPSS_HAL_SetChnSclCfg.";
        field {
            name = "word";
            desc = "32-bit word (layout see the register description).";
            sw = rw;
            hw = r;
        } word[31:0];
    } NODE_W_050 @ 0x50;

    reg {
        name = "Node word at offset 0x54";
        desc = "Word 0x54 of the node image. PROVENANCE: PROVEN offset and the listed bit extents (read from the load/store/bic/orr sequence of the named vendor function, hi3516cv300 Xiongmai module); INFERRED that a function name describes the content; UNKNOWN field meaning. Written by: VPSS_HAL_SetChnSclCfg.";
        field {
            name = "word";
            desc = "32-bit word (layout see the register description).";
            sw = rw;
            hw = r;
        } word[31:0];
    } NODE_W_054 @ 0x54;

    reg {
        name = "Node word at offset 0x58";
        desc = "Word 0x58 of the node image. PROVENANCE: PROVEN offset and the listed bit extents (read from the load/store/bic/orr sequence of the named vendor function, hi3516cv300 Xiongmai module); INFERRED that a function name describes the content; UNKNOWN field meaning. Written by: VPSS_HAL_SetChnSclCfg.";
        field {
            name = "word";
            desc = "32-bit word (layout see the register description).";
            sw = rw;
            hw = r;
        } word[31:0];
    } NODE_W_058 @ 0x58;

    reg {
        name = "Node word at offset 0x64";
        desc = "Word 0x64 of the node image. PROVENANCE: PROVEN offset and the listed bit extents (read from the load/store/bic/orr sequence of the named vendor function, hi3516cv300 Xiongmai module); INFERRED that a function name describes the content; UNKNOWN field meaning. Written by: VPSS_HAL_SetChnImgSize.";
        field {
            name = "word";
            desc = "32-bit word (layout see the register description).";
            sw = rw;
            hw = r;
        } word[31:0];
    } NODE_W_064 @ 0x64;

    reg {
        name = "Node word at offset 0x68";
        desc = "Word 0x68 of the node image. PROVENANCE: PROVEN offset and the listed bit extents (read from the load/store/bic/orr sequence of the named vendor function, hi3516cv300 Xiongmai module); INFERRED that a function name describes the content; UNKNOWN field meaning. Written by: VPSS_HAL_SetChnImgSize.";
        field {
            name = "word";
            desc = "32-bit word (layout see the register description).";
            sw = rw;
            hw = r;
        } word[31:0];
    } NODE_W_068 @ 0x68;

    reg {
        name = "Node word at offset 0x70";
        desc = "Word 0x70 of the node image. PROVENANCE: PROVEN offset and the listed bit extents (read from the load/store/bic/orr sequence of the named vendor function, hi3516cv300 Xiongmai module); INFERRED that a function name describes the content; UNKNOWN field meaning. Written by: VPSS_HAL_SetChnImgSize.";
        field {
            name = "word";
            desc = "32-bit word (layout see the register description).";
            sw = rw;
            hw = r;
        } word[31:0];
    } NODE_W_070 @ 0x70;

    reg {
        name = "Node word at offset 0x74";
        desc = "Word 0x74 of the node image. PROVENANCE: PROVEN offset and the listed bit extents (read from the load/store/bic/orr sequence of the named vendor function, hi3516cv300 Xiongmai module); INFERRED that a function name describes the content; UNKNOWN field meaning. Written by: VPSS_HAL_SetRfrPicSize.";
        field {
            name = "word";
            desc = "32-bit word (layout see the register description).";
            sw = rw;
            hw = r;
        } word[31:0];
    } NODE_W_074 @ 0x74;

    reg {
        name = "Node word at offset 0xC0";
        desc = "Word 0xC0 of the node image. PROVENANCE: PROVEN offset and the listed bit extents (read from the load/store/bic/orr sequence of the named vendor function, hi3516cv300 Xiongmai module); INFERRED that a function name describes the content; UNKNOWN field meaning. Written by: VPSS_HAL_SetChnSclCfg.";
        field {
            name = "word";
            desc = "32-bit word (layout see the register description).";
            sw = rw;
            hw = r;
        } word[31:0];
    } NODE_W_0C0 @ 0xC0;

    reg {
        name = "Node word at offset 0xC4";
        desc = "Word 0xC4 of the node image. PROVENANCE: PROVEN offset and the listed bit extents (read from the load/store/bic/orr sequence of the named vendor function, hi3516cv300 Xiongmai module); INFERRED that a function name describes the content; UNKNOWN field meaning. Written by: VPSS_HAL_SetChnSclCfg.";
        field {
            name = "word";
            desc = "32-bit word (layout see the register description).";
            sw = rw;
            hw = r;
        } word[31:0];
    } NODE_W_0C4 @ 0xC4;

    reg {
        name = "Node word at offset 0xC8";
        desc = "Word 0xC8 of the node image. PROVENANCE: PROVEN offset and the listed bit extents (read from the load/store/bic/orr sequence of the named vendor function, hi3516cv300 Xiongmai module); INFERRED that a function name describes the content; UNKNOWN field meaning. Written by: VPSS_HAL_SetChnSclCfg.";
        field {
            name = "word";
            desc = "32-bit word (layout see the register description).";
            sw = rw;
            hw = r;
        } word[31:0];
    } NODE_W_0C8 @ 0xC8;

    reg {
        name = "Node word at offset 0xCC";
        desc = "Word 0xCC of the node image. PROVENANCE: PROVEN offset and the listed bit extents (read from the load/store/bic/orr sequence of the named vendor function, hi3516cv300 Xiongmai module); INFERRED that a function name describes the content; UNKNOWN field meaning. Written by: VPSS_HAL_SetChnSclCfg modifies bits [20:19] (inserts a value at shift 19).";
        field {
            name = "word";
            desc = "32-bit word (layout see the register description).";
            sw = rw;
            hw = r;
        } word[31:0];
    } NODE_W_0CC @ 0xCC;

    reg {
        name = "Node word at offset 0xD0";
        desc = "Word 0xD0 of the node image. PROVENANCE: PROVEN offset and the listed bit extents (read from the load/store/bic/orr sequence of the named vendor function, hi3516cv300 Xiongmai module); INFERRED that a function name describes the content; UNKNOWN field meaning. Written by: VPSS_HAL_SetChnSclCfg; VPSS_HAL_SetMadAddr.";
        field {
            name = "word";
            desc = "32-bit word (layout see the register description).";
            sw = rw;
            hw = r;
        } word[31:0];
    } NODE_W_0D0 @ 0xD0;

    reg {
        name = "Node word at offset 0xD4";
        desc = "Word 0xD4 of the node image. PROVENANCE: PROVEN offset and the listed bit extents (read from the load/store/bic/orr sequence of the named vendor function, hi3516cv300 Xiongmai module); INFERRED that a function name describes the content; UNKNOWN field meaning. Written by: VPSS_HAL_SetChnSclCfg; VPSS_HAL_SetMadAddr.";
        field {
            name = "word";
            desc = "32-bit word (layout see the register description).";
            sw = rw;
            hw = r;
        } word[31:0];
    } NODE_W_0D4 @ 0xD4;

    reg {
        name = "Node word at offset 0xD8";
        desc = "Word 0xD8 of the node image. PROVENANCE: PROVEN offset and the listed bit extents (read from the load/store/bic/orr sequence of the named vendor function, hi3516cv300 Xiongmai module); INFERRED that a function name describes the content; UNKNOWN field meaning. Written by: VPSS_HAL_SetChnSclCfg; VPSS_HAL_SetMadAddr.";
        field {
            name = "word";
            desc = "32-bit word (layout see the register description).";
            sw = rw;
            hw = r;
        } word[31:0];
    } NODE_W_0D8 @ 0xD8;

    reg {
        name = "Node word at offset 0xDC";
        desc = "Word 0xDC of the node image. PROVENANCE: PROVEN offset and the listed bit extents (read from the load/store/bic/orr sequence of the named vendor function, hi3516cv300 Xiongmai module); INFERRED that a function name describes the content; UNKNOWN field meaning. Written by: VPSS_HAL_SetChnSclCfg; VPSS_HAL_SetMadAddr.";
        field {
            name = "word";
            desc = "32-bit word (layout see the register description).";
            sw = rw;
            hw = r;
        } word[31:0];
    } NODE_W_0DC @ 0xDC;

    reg {
        name = "Node word at offset 0xE0";
        desc = "Word 0xE0 of the node image. PROVENANCE: PROVEN offset and the listed bit extents (read from the load/store/bic/orr sequence of the named vendor function, hi3516cv300 Xiongmai module); INFERRED that a function name describes the content; UNKNOWN field meaning. Written by: VPSS_HAL_SetMadAddr.";
        field {
            name = "word";
            desc = "32-bit word (layout see the register description).";
            sw = rw;
            hw = r;
        } word[31:0];
    } NODE_W_0E0 @ 0xE0;

    reg {
        name = "Node word at offset 0xE4";
        desc = "Word 0xE4 of the node image. PROVENANCE: PROVEN offset and the listed bit extents (read from the load/store/bic/orr sequence of the named vendor function, hi3516cv300 Xiongmai module); INFERRED that a function name describes the content; UNKNOWN field meaning. Written by: VPSS_HAL_SetMadAddr.";
        field {
            name = "word";
            desc = "32-bit word (layout see the register description).";
            sw = rw;
            hw = r;
        } word[31:0];
    } NODE_W_0E4 @ 0xE4;

    reg {
        name = "Node word at offset 0xE8";
        desc = "Word 0xE8 of the node image. PROVENANCE: PROVEN offset and the listed bit extents (read from the load/store/bic/orr sequence of the named vendor function, hi3516cv300 Xiongmai module); INFERRED that a function name describes the content; UNKNOWN field meaning. Written by: VPSS_HAL_SetMadAddr.";
        field {
            name = "word";
            desc = "32-bit word (layout see the register description).";
            sw = rw;
            hw = r;
        } word[31:0];
    } NODE_W_0E8 @ 0xE8;

    reg {
        name = "Node word at offset 0x100";
        desc = "Word 0x100 of the node image. PROVENANCE: PROVEN offset and the listed bit extents (read from the load/store/bic/orr sequence of the named vendor function, hi3516cv300 Xiongmai module); INFERRED that a function name describes the content; UNKNOWN field meaning. Written by: VPSS_HAL_SetCurPicAddr.";
        field {
            name = "word";
            desc = "32-bit word (layout see the register description).";
            sw = rw;
            hw = r;
        } word[31:0];
    } NODE_W_100 @ 0x100;

    reg {
        name = "Node word at offset 0x104";
        desc = "Word 0x104 of the node image. PROVENANCE: PROVEN offset and the listed bit extents (read from the load/store/bic/orr sequence of the named vendor function, hi3516cv300 Xiongmai module); INFERRED that a function name describes the content; UNKNOWN field meaning. Written by: VPSS_HAL_SetCurPicAddr.";
        field {
            name = "word";
            desc = "32-bit word (layout see the register description).";
            sw = rw;
            hw = r;
        } word[31:0];
    } NODE_W_104 @ 0x104;

    reg {
        name = "Node word at offset 0x108";
        desc = "Word 0x108 of the node image. PROVENANCE: PROVEN offset and the listed bit extents (read from the load/store/bic/orr sequence of the named vendor function, hi3516cv300 Xiongmai module); INFERRED that a function name describes the content; UNKNOWN field meaning. Written by: VPSS_HAL_SetCurPicAddr.";
        field {
            name = "word";
            desc = "32-bit word (layout see the register description).";
            sw = rw;
            hw = r;
        } word[31:0];
    } NODE_W_108 @ 0x108;

    reg {
        name = "Node word at offset 0x10C";
        desc = "Word 0x10C of the node image. PROVENANCE: PROVEN offset and the listed bit extents (read from the load/store/bic/orr sequence of the named vendor function, hi3516cv300 Xiongmai module); INFERRED that a function name describes the content; UNKNOWN field meaning. Written by: VPSS_HAL_SetCurPicAddr.";
        field {
            name = "word";
            desc = "32-bit word (layout see the register description).";
            sw = rw;
            hw = r;
        } word[31:0];
    } NODE_W_10C @ 0x10C;

    reg {
        name = "Node word at offset 0x110";
        desc = "Word 0x110 of the node image. PROVENANCE: PROVEN offset and the listed bit extents (read from the load/store/bic/orr sequence of the named vendor function, hi3516cv300 Xiongmai module); INFERRED that a function name describes the content; UNKNOWN field meaning. Written by: VPSS_HAL_SetCurPicAddr.";
        field {
            name = "word";
            desc = "32-bit word (layout see the register description).";
            sw = rw;
            hw = r;
        } word[31:0];
    } NODE_W_110 @ 0x110;

    reg {
        name = "Node word at offset 0x114";
        desc = "Word 0x114 of the node image. PROVENANCE: PROVEN offset and the listed bit extents (read from the load/store/bic/orr sequence of the named vendor function, hi3516cv300 Xiongmai module); INFERRED that a function name describes the content; UNKNOWN field meaning. Written by: VPSS_HAL_SetCurPicAddr.";
        field {
            name = "word";
            desc = "32-bit word (layout see the register description).";
            sw = rw;
            hw = r;
        } word[31:0];
    } NODE_W_114 @ 0x114;

    reg {
        name = "Node word at offset 0x118";
        desc = "Word 0x118 of the node image. PROVENANCE: PROVEN offset and the listed bit extents (read from the load/store/bic/orr sequence of the named vendor function, hi3516cv300 Xiongmai module); INFERRED that a function name describes the content; UNKNOWN field meaning. Written by: VPSS_HAL_SetRefDcmp; VPSS_HAL_SetRef modifies bits [30:0] (inserts a value at shift 2, 3, 4, 5, 18).";
        field {
            name = "word";
            desc = "32-bit word (layout see the register description).";
            sw = rw;
            hw = r;
        } word[31:0];
    } NODE_W_118 @ 0x118;

    reg {
        name = "Node word at offset 0x11C";
        desc = "Word 0x11C of the node image. PROVENANCE: PROVEN offset and the listed bit extents (read from the load/store/bic/orr sequence of the named vendor function, hi3516cv300 Xiongmai module); INFERRED that a function name describes the content; UNKNOWN field meaning. Written by: VPSS_HAL_SetRef.";
        field {
            name = "word";
            desc = "32-bit word (layout see the register description).";
            sw = rw;
            hw = r;
        } word[31:0];
    } NODE_W_11C @ 0x11C;

    reg {
        name = "Node word at offset 0x120";
        desc = "Word 0x120 of the node image. PROVENANCE: PROVEN offset and the listed bit extents (read from the load/store/bic/orr sequence of the named vendor function, hi3516cv300 Xiongmai module); INFERRED that a function name describes the content; UNKNOWN field meaning. Written by: VPSS_HAL_SetRef.";
        field {
            name = "word";
            desc = "32-bit word (layout see the register description).";
            sw = rw;
            hw = r;
        } word[31:0];
    } NODE_W_120 @ 0x120;

    reg {
        name = "Node word at offset 0x124";
        desc = "Word 0x124 of the node image. PROVENANCE: PROVEN offset and the listed bit extents (read from the load/store/bic/orr sequence of the named vendor function, hi3516cv300 Xiongmai module); INFERRED that a function name describes the content; UNKNOWN field meaning. Written by: VPSS_HAL_SetRef.";
        field {
            name = "word";
            desc = "32-bit word (layout see the register description).";
            sw = rw;
            hw = r;
        } word[31:0];
    } NODE_W_124 @ 0x124;

    reg {
        name = "Node word at offset 0x128";
        desc = "Word 0x128 of the node image. PROVENANCE: PROVEN offset and the listed bit extents (read from the load/store/bic/orr sequence of the named vendor function, hi3516cv300 Xiongmai module); INFERRED that a function name describes the content; UNKNOWN field meaning. Written by: VPSS_HAL_SetRef.";
        field {
            name = "word";
            desc = "32-bit word (layout see the register description).";
            sw = rw;
            hw = r;
        } word[31:0];
    } NODE_W_128 @ 0x128;

    reg {
        name = "Node word at offset 0x12C";
        desc = "Word 0x12C of the node image. PROVENANCE: PROVEN offset and the listed bit extents (read from the load/store/bic/orr sequence of the named vendor function, hi3516cv300 Xiongmai module); INFERRED that a function name describes the content; UNKNOWN field meaning. Written by: VPSS_HAL_SetRef.";
        field {
            name = "word";
            desc = "32-bit word (layout see the register description).";
            sw = rw;
            hw = r;
        } word[31:0];
    } NODE_W_12C @ 0x12C;

    reg {
        name = "Node word at offset 0x148";
        desc = "Word 0x148 of the node image. PROVENANCE: PROVEN offset and the listed bit extents (read from the load/store/bic/orr sequence of the named vendor function, hi3516cv300 Xiongmai module); INFERRED that a function name describes the content; UNKNOWN field meaning. Written by: VPSS_HAL_SetChnPicAddr.";
        field {
            name = "word";
            desc = "32-bit word (layout see the register description).";
            sw = rw;
            hw = r;
        } word[31:0];
    } NODE_W_148 @ 0x148;

    reg {
        name = "Node word at offset 0x14C";
        desc = "Word 0x14C of the node image. PROVENANCE: PROVEN offset and the listed bit extents (read from the load/store/bic/orr sequence of the named vendor function, hi3516cv300 Xiongmai module); INFERRED that a function name describes the content; UNKNOWN field meaning. Written by: VPSS_HAL_SetChnPicAddr.";
        field {
            name = "word";
            desc = "32-bit word (layout see the register description).";
            sw = rw;
            hw = r;
        } word[31:0];
    } NODE_W_14C @ 0x14C;

    reg {
        name = "Node word at offset 0x150";
        desc = "Word 0x150 of the node image. PROVENANCE: PROVEN offset and the listed bit extents (read from the load/store/bic/orr sequence of the named vendor function, hi3516cv300 Xiongmai module); INFERRED that a function name describes the content; UNKNOWN field meaning. Written by: VPSS_HAL_SetChnPicAddr.";
        field {
            name = "word";
            desc = "32-bit word (layout see the register description).";
            sw = rw;
            hw = r;
        } word[31:0];
    } NODE_W_150 @ 0x150;

    reg {
        name = "Node word at offset 0x154";
        desc = "Word 0x154 of the node image. PROVENANCE: PROVEN offset and the listed bit extents (read from the load/store/bic/orr sequence of the named vendor function, hi3516cv300 Xiongmai module); INFERRED that a function name describes the content; UNKNOWN field meaning. Written by: VPSS_HAL_SetChnPicAddr.";
        field {
            name = "word";
            desc = "32-bit word (layout see the register description).";
            sw = rw;
            hw = r;
        } word[31:0];
    } NODE_W_154 @ 0x154;

    reg {
        name = "Node word at offset 0x158";
        desc = "Word 0x158 of the node image. PROVENANCE: PROVEN offset and the listed bit extents (read from the load/store/bic/orr sequence of the named vendor function, hi3516cv300 Xiongmai module); INFERRED that a function name describes the content; UNKNOWN field meaning. Written by: VPSS_HAL_SetChnPicAddr.";
        field {
            name = "word";
            desc = "32-bit word (layout see the register description).";
            sw = rw;
            hw = r;
        } word[31:0];
    } NODE_W_158 @ 0x158;

    reg {
        name = "Node word at offset 0x160";
        desc = "Word 0x160 of the node image. PROVENANCE: PROVEN offset and the listed bit extents (read from the load/store/bic/orr sequence of the named vendor function, hi3516cv300 Xiongmai module); INFERRED that a function name describes the content; UNKNOWN field meaning. Written by: VPSS_HAL_SetChnPicAddr.";
        field {
            name = "word";
            desc = "32-bit word (layout see the register description).";
            sw = rw;
            hw = r;
        } word[31:0];
    } NODE_W_160 @ 0x160;

    reg {
        name = "Node word at offset 0x164";
        desc = "Word 0x164 of the node image. PROVENANCE: PROVEN offset and the listed bit extents (read from the load/store/bic/orr sequence of the named vendor function, hi3516cv300 Xiongmai module); INFERRED that a function name describes the content; UNKNOWN field meaning. Written by: VPSS_HAL_SetChnPicAddr.";
        field {
            name = "word";
            desc = "32-bit word (layout see the register description).";
            sw = rw;
            hw = r;
        } word[31:0];
    } NODE_W_164 @ 0x164;

    reg {
        name = "Node word at offset 0x168";
        desc = "Word 0x168 of the node image. PROVENANCE: PROVEN offset and the listed bit extents (read from the load/store/bic/orr sequence of the named vendor function, hi3516cv300 Xiongmai module); INFERRED that a function name describes the content; UNKNOWN field meaning. Written by: VPSS_HAL_SetChnPicAddr.";
        field {
            name = "word";
            desc = "32-bit word (layout see the register description).";
            sw = rw;
            hw = r;
        } word[31:0];
    } NODE_W_168 @ 0x168;

    reg {
        name = "Node word at offset 0x16C";
        desc = "Word 0x16C of the node image. PROVENANCE: PROVEN offset and the listed bit extents (read from the load/store/bic/orr sequence of the named vendor function, hi3516cv300 Xiongmai module); INFERRED that a function name describes the content; UNKNOWN field meaning. Written by: VPSS_HAL_SetChnPicAddr.";
        field {
            name = "word";
            desc = "32-bit word (layout see the register description).";
            sw = rw;
            hw = r;
        } word[31:0];
    } NODE_W_16C @ 0x16C;

    reg {
        name = "Node word at offset 0x170";
        desc = "Word 0x170 of the node image. PROVENANCE: PROVEN offset and the listed bit extents (read from the load/store/bic/orr sequence of the named vendor function, hi3516cv300 Xiongmai module); INFERRED that a function name describes the content; UNKNOWN field meaning. Written by: VPSS_HAL_SetChnPicAddr.";
        field {
            name = "word";
            desc = "32-bit word (layout see the register description).";
            sw = rw;
            hw = r;
        } word[31:0];
    } NODE_W_170 @ 0x170;

    reg {
        name = "Node word at offset 0x190";
        desc = "Word 0x190 of the node image. PROVENANCE: PROVEN offset and the listed bit extents (read from the load/store/bic/orr sequence of the named vendor function, hi3516cv300 Xiongmai module); INFERRED that a function name describes the content; UNKNOWN field meaning. Written by: VPSS_HAL_SetChnPicAddr.";
        field {
            name = "word";
            desc = "32-bit word (layout see the register description).";
            sw = rw;
            hw = r;
        } word[31:0];
    } NODE_W_190 @ 0x190;

    reg {
        name = "Node word at offset 0x194";
        desc = "Word 0x194 of the node image. PROVENANCE: PROVEN offset and the listed bit extents (read from the load/store/bic/orr sequence of the named vendor function, hi3516cv300 Xiongmai module); INFERRED that a function name describes the content; UNKNOWN field meaning. Written by: VPSS_HAL_SetChnPicAddr.";
        field {
            name = "word";
            desc = "32-bit word (layout see the register description).";
            sw = rw;
            hw = r;
        } word[31:0];
    } NODE_W_194 @ 0x194;

    reg {
        name = "Node word at offset 0x198";
        desc = "Word 0x198 of the node image. PROVENANCE: PROVEN offset and the listed bit extents (read from the load/store/bic/orr sequence of the named vendor function, hi3516cv300 Xiongmai module); INFERRED that a function name describes the content; UNKNOWN field meaning. Written by: VPSS_HAL_SetChnPicAddr.";
        field {
            name = "word";
            desc = "32-bit word (layout see the register description).";
            sw = rw;
            hw = r;
        } word[31:0];
    } NODE_W_198 @ 0x198;

    reg {
        name = "Node word at offset 0x19C";
        desc = "Word 0x19C of the node image. PROVENANCE: PROVEN offset and the listed bit extents (read from the load/store/bic/orr sequence of the named vendor function, hi3516cv300 Xiongmai module); INFERRED that a function name describes the content; UNKNOWN field meaning. Written by: VPSS_HAL_SetChnPicAddr.";
        field {
            name = "word";
            desc = "32-bit word (layout see the register description).";
            sw = rw;
            hw = r;
        } word[31:0];
    } NODE_W_19C @ 0x19C;

    reg {
        name = "Node word at offset 0x1A0";
        desc = "Word 0x1A0 of the node image. PROVENANCE: PROVEN offset and the listed bit extents (read from the load/store/bic/orr sequence of the named vendor function, hi3516cv300 Xiongmai module); INFERRED that a function name describes the content; UNKNOWN field meaning. Written by: VPSS_HAL_SetChnPicAddr.";
        field {
            name = "word";
            desc = "32-bit word (layout see the register description).";
            sw = rw;
            hw = r;
        } word[31:0];
    } NODE_W_1A0 @ 0x1A0;

    reg {
        name = "Node word at offset 0x1A8";
        desc = "Word 0x1A8 of the node image. PROVENANCE: PROVEN offset and the listed bit extents (read from the load/store/bic/orr sequence of the named vendor function, hi3516cv300 Xiongmai module); INFERRED that a function name describes the content; UNKNOWN field meaning. Written by: VPSS_HAL_SetRfrPicAddr.";
        field {
            name = "word";
            desc = "32-bit word (layout see the register description).";
            sw = rw;
            hw = r;
        } word[31:0];
    } NODE_W_1A8 @ 0x1A8;

    reg {
        name = "Node word at offset 0x1AC";
        desc = "Word 0x1AC of the node image. PROVENANCE: PROVEN offset and the listed bit extents (read from the load/store/bic/orr sequence of the named vendor function, hi3516cv300 Xiongmai module); INFERRED that a function name describes the content; UNKNOWN field meaning. Written by: VPSS_HAL_SetRfrPicAddr.";
        field {
            name = "word";
            desc = "32-bit word (layout see the register description).";
            sw = rw;
            hw = r;
        } word[31:0];
    } NODE_W_1AC @ 0x1AC;

    reg {
        name = "Node word at offset 0x1B0";
        desc = "Word 0x1B0 of the node image. PROVENANCE: PROVEN offset and the listed bit extents (read from the load/store/bic/orr sequence of the named vendor function, hi3516cv300 Xiongmai module); INFERRED that a function name describes the content; UNKNOWN field meaning. Written by: VPSS_HAL_SetRfrPicAddr.";
        field {
            name = "word";
            desc = "32-bit word (layout see the register description).";
            sw = rw;
            hw = r;
        } word[31:0];
    } NODE_W_1B0 @ 0x1B0;

    reg {
        name = "Node word at offset 0x1B4";
        desc = "Word 0x1B4 of the node image. PROVENANCE: PROVEN offset and the listed bit extents (read from the load/store/bic/orr sequence of the named vendor function, hi3516cv300 Xiongmai module); INFERRED that a function name describes the content; UNKNOWN field meaning. Written by: VPSS_HAL_SetRfrPicAddr.";
        field {
            name = "word";
            desc = "32-bit word (layout see the register description).";
            sw = rw;
            hw = r;
        } word[31:0];
    } NODE_W_1B4 @ 0x1B4;

    reg {
        name = "Node word at offset 0x1B8";
        desc = "Word 0x1B8 of the node image. PROVENANCE: PROVEN offset and the listed bit extents (read from the load/store/bic/orr sequence of the named vendor function, hi3516cv300 Xiongmai module); INFERRED that a function name describes the content; UNKNOWN field meaning. Written by: VPSS_HAL_SetRfrPicAddr.";
        field {
            name = "word";
            desc = "32-bit word (layout see the register description).";
            sw = rw;
            hw = r;
        } word[31:0];
    } NODE_W_1B8 @ 0x1B8;

    reg {
        name = "Node word at offset 0x1C8";
        desc = "Word 0x1C8 of the node image. PROVENANCE: PROVEN offset and the listed bit extents (read from the load/store/bic/orr sequence of the named vendor function, hi3516cv300 Xiongmai module); INFERRED that a function name describes the content; UNKNOWN field meaning. Written by: VPSS_HAL_SetLowDelayAddr.";
        field {
            name = "word";
            desc = "32-bit word (layout see the register description).";
            sw = rw;
            hw = r;
        } word[31:0];
    } NODE_W_1C8 @ 0x1C8;

    reg {
        name = "Node word at offset 0x1CC";
        desc = "Word 0x1CC of the node image. PROVENANCE: PROVEN offset and the listed bit extents (read from the load/store/bic/orr sequence of the named vendor function, hi3516cv300 Xiongmai module); INFERRED that a function name describes the content; UNKNOWN field meaning. Written by: VPSS_HAL_SetLowDelayAddr.";
        field {
            name = "word";
            desc = "32-bit word (layout see the register description).";
            sw = rw;
            hw = r;
        } word[31:0];
    } NODE_W_1CC @ 0x1CC;

    reg {
        name = "Node word at offset 0x1D0";
        desc = "Word 0x1D0 of the node image. PROVENANCE: PROVEN offset and the listed bit extents (read from the load/store/bic/orr sequence of the named vendor function, hi3516cv300 Xiongmai module); INFERRED that a function name describes the content; UNKNOWN field meaning. Written by: VPSS_HAL_SetLowDelayAddr.";
        field {
            name = "word";
            desc = "32-bit word (layout see the register description).";
            sw = rw;
            hw = r;
        } word[31:0];
    } NODE_W_1D0 @ 0x1D0;

    reg {
        name = "Node word at offset 0x1D4";
        desc = "Word 0x1D4 of the node image. PROVENANCE: PROVEN offset and the listed bit extents (read from the load/store/bic/orr sequence of the named vendor function, hi3516cv300 Xiongmai module); INFERRED that a function name describes the content; UNKNOWN field meaning. Written by: VPSS_HAL_SetRefDcmp modifies bits [6:5] (inserts a value at shift 5, 6); VPSS_HAL_SetRef modifies bits [6:5].";
        field {
            name = "word";
            desc = "32-bit word (layout see the register description).";
            sw = rw;
            hw = r;
        } word[31:0];
    } NODE_W_1D4 @ 0x1D4;

    reg {
        name = "Node word at offset 0x1D8";
        desc = "Word 0x1D8 of the node image. PROVENANCE: PROVEN offset and the listed bit extents (read from the load/store/bic/orr sequence of the named vendor function, hi3516cv300 Xiongmai module); INFERRED that a function name describes the content; UNKNOWN field meaning. Written by: VPSS_HAL_SetLcmpLoadAddr.";
        field {
            name = "word";
            desc = "32-bit word (layout see the register description).";
            sw = rw;
            hw = r;
        } word[31:0];
    } NODE_W_1D8 @ 0x1D8;

    reg {
        name = "Node word at offset 0x1F4";
        desc = "Word 0x1F4 of the node image. PROVENANCE: PROVEN offset and the listed bit extents (read from the load/store/bic/orr sequence of the named vendor function, hi3516cv300 Xiongmai module); INFERRED that a function name describes the content; UNKNOWN field meaning. Written by: VPSS_HAL_SetNodeID.";
        field {
            name = "word";
            desc = "32-bit word (layout see the register description).";
            sw = rw;
            hw = r;
        } word[31:0];
    } NODE_W_1F4 @ 0x1F4;

    reg {
        name = "Node word at offset 0x1FC";
        desc = "Word 0x1FC of the node image. PROVENANCE: PROVEN offset and the listed bit extents (read from the load/store/bic/orr sequence of the named vendor function, hi3516cv300 Xiongmai module); INFERRED that a function name describes the content; UNKNOWN field meaning. Written by: VPSS_HAL_SetMask.";
        field {
            name = "word";
            desc = "32-bit word (layout see the register description).";
            sw = rw;
            hw = r;
        } word[31:0];
    } NODE_W_1FC @ 0x1FC;

    reg {
        name = "Node word at offset 0x200";
        desc = "Word 0x200 of the node image. PROVENANCE: PROVEN offset and the listed bit extents (read from the load/store/bic/orr sequence of the named vendor function, hi3516cv300 Xiongmai module); INFERRED that a function name describes the content; UNKNOWN field meaning. Written by: VPSS_HAL_SetSharpenCtrl.";
        field {
            name = "word";
            desc = "32-bit word (layout see the register description).";
            sw = rw;
            hw = r;
        } word[31:0];
    } NODE_W_200 @ 0x200;

    reg {
        name = "Node word at offset 0x210";
        desc = "Word 0x210 of the node image. PROVENANCE: PROVEN offset and the listed bit extents (read from the load/store/bic/orr sequence of the named vendor function, hi3516cv300 Xiongmai module); INFERRED that a function name describes the content; UNKNOWN field meaning. Written by: VPSS_HAL_SetSharpenCoef.";
        field {
            name = "word";
            desc = "32-bit word (layout see the register description).";
            sw = rw;
            hw = r;
        } word[31:0];
    } NODE_W_210 @ 0x210;

    reg {
        name = "Node word at offset 0x214";
        desc = "Word 0x214 of the node image. PROVENANCE: PROVEN offset and the listed bit extents (read from the load/store/bic/orr sequence of the named vendor function, hi3516cv300 Xiongmai module); INFERRED that a function name describes the content; UNKNOWN field meaning. Written by: VPSS_HAL_SetSharpenCoef.";
        field {
            name = "word";
            desc = "32-bit word (layout see the register description).";
            sw = rw;
            hw = r;
        } word[31:0];
    } NODE_W_214 @ 0x214;

    reg {
        name = "Node word at offset 0x218";
        desc = "Word 0x218 of the node image. PROVENANCE: PROVEN offset and the listed bit extents (read from the load/store/bic/orr sequence of the named vendor function, hi3516cv300 Xiongmai module); INFERRED that a function name describes the content; UNKNOWN field meaning. Written by: VPSS_HAL_SetSharpenCoef.";
        field {
            name = "word";
            desc = "32-bit word (layout see the register description).";
            sw = rw;
            hw = r;
        } word[31:0];
    } NODE_W_218 @ 0x218;

    reg {
        name = "Node word at offset 0x21C";
        desc = "Word 0x21C of the node image. PROVENANCE: PROVEN offset and the listed bit extents (read from the load/store/bic/orr sequence of the named vendor function, hi3516cv300 Xiongmai module); INFERRED that a function name describes the content; UNKNOWN field meaning. Written by: VPSS_HAL_SetSharpenCoef.";
        field {
            name = "word";
            desc = "32-bit word (layout see the register description).";
            sw = rw;
            hw = r;
        } word[31:0];
    } NODE_W_21C @ 0x21C;

    reg {
        name = "Node word at offset 0x220";
        desc = "Word 0x220 of the node image. PROVENANCE: PROVEN offset and the listed bit extents (read from the load/store/bic/orr sequence of the named vendor function, hi3516cv300 Xiongmai module); INFERRED that a function name describes the content; UNKNOWN field meaning. Written by: VPSS_HAL_SetSharpenCoef.";
        field {
            name = "word";
            desc = "32-bit word (layout see the register description).";
            sw = rw;
            hw = r;
        } word[31:0];
    } NODE_W_220 @ 0x220;

    reg {
        name = "Node word at offset 0x224";
        desc = "Word 0x224 of the node image. PROVENANCE: PROVEN offset and the listed bit extents (read from the load/store/bic/orr sequence of the named vendor function, hi3516cv300 Xiongmai module); INFERRED that a function name describes the content; UNKNOWN field meaning. Written by: VPSS_HAL_SetSharpenCoef.";
        field {
            name = "word";
            desc = "32-bit word (layout see the register description).";
            sw = rw;
            hw = r;
        } word[31:0];
    } NODE_W_224 @ 0x224;

    reg {
        name = "Node word at offset 0x228";
        desc = "Word 0x228 of the node image. PROVENANCE: PROVEN offset and the listed bit extents (read from the load/store/bic/orr sequence of the named vendor function, hi3516cv300 Xiongmai module); INFERRED that a function name describes the content; UNKNOWN field meaning. Written by: VPSS_HAL_SetSharpenCoef.";
        field {
            name = "word";
            desc = "32-bit word (layout see the register description).";
            sw = rw;
            hw = r;
        } word[31:0];
    } NODE_W_228 @ 0x228;

    reg {
        name = "Node word at offset 0x22C";
        desc = "Word 0x22C of the node image. PROVENANCE: PROVEN offset and the listed bit extents (read from the load/store/bic/orr sequence of the named vendor function, hi3516cv300 Xiongmai module); INFERRED that a function name describes the content; UNKNOWN field meaning. Written by: VPSS_HAL_SetSharpenCoef.";
        field {
            name = "word";
            desc = "32-bit word (layout see the register description).";
            sw = rw;
            hw = r;
        } word[31:0];
    } NODE_W_22C @ 0x22C;

    reg {
        name = "Node word at offset 0x230";
        desc = "Word 0x230 of the node image. PROVENANCE: PROVEN offset and the listed bit extents (read from the load/store/bic/orr sequence of the named vendor function, hi3516cv300 Xiongmai module); INFERRED that a function name describes the content; UNKNOWN field meaning. Written by: VPSS_HAL_SetSharpenCoef.";
        field {
            name = "word";
            desc = "32-bit word (layout see the register description).";
            sw = rw;
            hw = r;
        } word[31:0];
    } NODE_W_230 @ 0x230;

    reg {
        name = "Node word at offset 0x234";
        desc = "Word 0x234 of the node image. PROVENANCE: PROVEN offset and the listed bit extents (read from the load/store/bic/orr sequence of the named vendor function, hi3516cv300 Xiongmai module); INFERRED that a function name describes the content; UNKNOWN field meaning. Written by: VPSS_HAL_SetSharpenCoef.";
        field {
            name = "word";
            desc = "32-bit word (layout see the register description).";
            sw = rw;
            hw = r;
        } word[31:0];
    } NODE_W_234 @ 0x234;

    reg {
        name = "Node word at offset 0x238";
        desc = "Word 0x238 of the node image. PROVENANCE: PROVEN offset and the listed bit extents (read from the load/store/bic/orr sequence of the named vendor function, hi3516cv300 Xiongmai module); INFERRED that a function name describes the content; UNKNOWN field meaning. Written by: VPSS_HAL_SetSharpenCoef.";
        field {
            name = "word";
            desc = "32-bit word (layout see the register description).";
            sw = rw;
            hw = r;
        } word[31:0];
    } NODE_W_238 @ 0x238;

    reg {
        name = "Node word at offset 0x23C";
        desc = "Word 0x23C of the node image. PROVENANCE: PROVEN offset and the listed bit extents (read from the load/store/bic/orr sequence of the named vendor function, hi3516cv300 Xiongmai module); INFERRED that a function name describes the content; UNKNOWN field meaning. Written by: VPSS_HAL_SetSharpenCoef.";
        field {
            name = "word";
            desc = "32-bit word (layout see the register description).";
            sw = rw;
            hw = r;
        } word[31:0];
    } NODE_W_23C @ 0x23C;

    reg {
        name = "Node word at offset 0x240";
        desc = "Word 0x240 of the node image. PROVENANCE: PROVEN offset and the listed bit extents (read from the load/store/bic/orr sequence of the named vendor function, hi3516cv300 Xiongmai module); INFERRED that a function name describes the content; UNKNOWN field meaning. Written by: VPSS_HAL_SetZmeLoadAddr; VPSS_HAL_SetSharpenCoef.";
        field {
            name = "word";
            desc = "32-bit word (layout see the register description).";
            sw = rw;
            hw = r;
        } word[31:0];
    } NODE_W_240 @ 0x240;

    reg {
        name = "Node word at offset 0x244";
        desc = "Word 0x244 of the node image. PROVENANCE: PROVEN offset and the listed bit extents (read from the load/store/bic/orr sequence of the named vendor function, hi3516cv300 Xiongmai module); INFERRED that a function name describes the content; UNKNOWN field meaning. Written by: VPSS_HAL_SetShbdLoadAddr; VPSS_HAL_SetSharpenCoef modifies bits [4:1] [12:8] (inserts a value at shift 1, 2, 3, 4, 8).";
        field {
            name = "word";
            desc = "32-bit word (layout see the register description).";
            sw = rw;
            hw = r;
        } word[31:0];
    } NODE_W_244 @ 0x244;

    reg {
        name = "Node word at offset 0x248";
        desc = "Word 0x248 of the node image. PROVENANCE: PROVEN offset and the listed bit extents (read from the load/store/bic/orr sequence of the named vendor function, hi3516cv300 Xiongmai module); INFERRED that a function name describes the content; UNKNOWN field meaning. Written by: VPSS_HAL_SetNrLoadAddr; VPSS_HAL_SetSharpenCoef.";
        field {
            name = "word";
            desc = "32-bit word (layout see the register description).";
            sw = rw;
            hw = r;
        } word[31:0];
    } NODE_W_248 @ 0x248;

    reg {
        name = "Node word at offset 0x24C";
        desc = "Word 0x24C of the node image. PROVENANCE: PROVEN offset and the listed bit extents (read from the load/store/bic/orr sequence of the named vendor function, hi3516cv300 Xiongmai module); INFERRED that a function name describes the content; UNKNOWN field meaning. Written by: VPSS_HAL_SetSharpenCoef.";
        field {
            name = "word";
            desc = "32-bit word (layout see the register description).";
            sw = rw;
            hw = r;
        } word[31:0];
    } NODE_W_24C @ 0x24C;

    reg {
        name = "Node word at offset 0x250";
        desc = "Word 0x250 of the node image. PROVENANCE: PROVEN offset and the listed bit extents (read from the load/store/bic/orr sequence of the named vendor function, hi3516cv300 Xiongmai module); INFERRED that a function name describes the content; UNKNOWN field meaning. Written by: VPSS_HAL_SetSharpenCoef.";
        field {
            name = "word";
            desc = "32-bit word (layout see the register description).";
            sw = rw;
            hw = r;
        } word[31:0];
    } NODE_W_250 @ 0x250;

    reg {
        name = "Node word at offset 0x254";
        desc = "Word 0x254 of the node image. PROVENANCE: PROVEN offset and the listed bit extents (read from the load/store/bic/orr sequence of the named vendor function, hi3516cv300 Xiongmai module); INFERRED that a function name describes the content; UNKNOWN field meaning. Written by: VPSS_HAL_SetSharpenLoadAddr; VPSS_HAL_SetSharpenCoef.";
        field {
            name = "word";
            desc = "32-bit word (layout see the register description).";
            sw = rw;
            hw = r;
        } word[31:0];
    } NODE_W_254 @ 0x254;

    reg {
        name = "Node word at offset 0x258";
        desc = "Word 0x258 of the node image. PROVENANCE: PROVEN offset and the listed bit extents (read from the load/store/bic/orr sequence of the named vendor function, hi3516cv300 Xiongmai module); INFERRED that a function name describes the content; UNKNOWN field meaning. Written by: VPSS_HAL_SetMosaicLoadAddr; VPSS_HAL_SetSharpenCoef.";
        field {
            name = "word";
            desc = "32-bit word (layout see the register description).";
            sw = rw;
            hw = r;
        } word[31:0];
    } NODE_W_258 @ 0x258;

    reg {
        name = "Node word at offset 0x25C";
        desc = "Word 0x25C of the node image. PROVENANCE: PROVEN offset and the listed bit extents (read from the load/store/bic/orr sequence of the named vendor function, hi3516cv300 Xiongmai module); INFERRED that a function name describes the content; UNKNOWN field meaning. Written by: VPSS_HAL_SetSharpenCoef.";
        field {
            name = "word";
            desc = "32-bit word (layout see the register description).";
            sw = rw;
            hw = r;
        } word[31:0];
    } NODE_W_25C @ 0x25C;

    reg {
        name = "Node word at offset 0x260";
        desc = "Word 0x260 of the node image. PROVENANCE: PROVEN offset and the listed bit extents (read from the load/store/bic/orr sequence of the named vendor function, hi3516cv300 Xiongmai module); INFERRED that a function name describes the content; UNKNOWN field meaning. Written by: VPSS_HAL_SetSharpenCoef.";
        field {
            name = "word";
            desc = "32-bit word (layout see the register description).";
            sw = rw;
            hw = r;
        } word[31:0];
    } NODE_W_260 @ 0x260;

    reg {
        name = "Node word at offset 0x264";
        desc = "Word 0x264 of the node image. PROVENANCE: PROVEN offset and the listed bit extents (read from the load/store/bic/orr sequence of the named vendor function, hi3516cv300 Xiongmai module); INFERRED that a function name describes the content; UNKNOWN field meaning. Written by: VPSS_HAL_SetSharpenCoef.";
        field {
            name = "word";
            desc = "32-bit word (layout see the register description).";
            sw = rw;
            hw = r;
        } word[31:0];
    } NODE_W_264 @ 0x264;

    reg {
        name = "Node word at offset 0x268";
        desc = "Word 0x268 of the node image. PROVENANCE: PROVEN offset and the listed bit extents (read from the load/store/bic/orr sequence of the named vendor function, hi3516cv300 Xiongmai module); INFERRED that a function name describes the content; UNKNOWN field meaning. Written by: VPSS_HAL_SetSharpenCoef.";
        field {
            name = "word";
            desc = "32-bit word (layout see the register description).";
            sw = rw;
            hw = r;
        } word[31:0];
    } NODE_W_268 @ 0x268;

    reg {
        name = "Node word at offset 0x26C";
        desc = "Word 0x26C of the node image. PROVENANCE: PROVEN offset and the listed bit extents (read from the load/store/bic/orr sequence of the named vendor function, hi3516cv300 Xiongmai module); INFERRED that a function name describes the content; UNKNOWN field meaning. Written by: VPSS_HAL_SetSharpenCoef.";
        field {
            name = "word";
            desc = "32-bit word (layout see the register description).";
            sw = rw;
            hw = r;
        } word[31:0];
    } NODE_W_26C @ 0x26C;

    reg {
        name = "Node word at offset 0x270";
        desc = "Word 0x270 of the node image. PROVENANCE: PROVEN offset and the listed bit extents (read from the load/store/bic/orr sequence of the named vendor function, hi3516cv300 Xiongmai module); INFERRED that a function name describes the content; UNKNOWN field meaning. Written by: VPSS_HAL_SetChnLowDelayAttr modifies bits [28:16] (inserts a value at shift 16); VPSS_HAL_SetSharpenCoef.";
        field {
            name = "word";
            desc = "32-bit word (layout see the register description).";
            sw = rw;
            hw = r;
        } word[31:0];
    } NODE_W_270 @ 0x270;

    reg {
        name = "Node word at offset 0x274";
        desc = "Word 0x274 of the node image. PROVENANCE: PROVEN offset and the listed bit extents (read from the load/store/bic/orr sequence of the named vendor function, hi3516cv300 Xiongmai module); INFERRED that a function name describes the content; UNKNOWN field meaning. Written by: VPSS_HAL_SetChnLowDelayAttr modifies bits [26:26] (sets constants 0x8000000); VPSS_HAL_SetSharpenCoef.";
        field {
            name = "word";
            desc = "32-bit word (layout see the register description).";
            sw = rw;
            hw = r;
        } word[31:0];
    } NODE_W_274 @ 0x274;

    reg {
        name = "Node word at offset 0x278";
        desc = "Word 0x278 of the node image. PROVENANCE: PROVEN offset and the listed bit extents (read from the load/store/bic/orr sequence of the named vendor function, hi3516cv300 Xiongmai module); INFERRED that a function name describes the content; UNKNOWN field meaning. Written by: VPSS_HAL_SetSharpenCoef.";
        field {
            name = "word";
            desc = "32-bit word (layout see the register description).";
            sw = rw;
            hw = r;
        } word[31:0];
    } NODE_W_278 @ 0x278;

    reg {
        name = "Node word at offset 0x27C";
        desc = "Word 0x27C of the node image. PROVENANCE: PROVEN offset and the listed bit extents (read from the load/store/bic/orr sequence of the named vendor function, hi3516cv300 Xiongmai module); INFERRED that a function name describes the content; UNKNOWN field meaning. Written by: VPSS_HAL_SetSharpenCoef.";
        field {
            name = "word";
            desc = "32-bit word (layout see the register description).";
            sw = rw;
            hw = r;
        } word[31:0];
    } NODE_W_27C @ 0x27C;

    reg {
        name = "Node word at offset 0x2E4";
        desc = "Word 0x2E4 of the node image. PROVENANCE: PROVEN offset and the listed bit extents (read from the load/store/bic/orr sequence of the named vendor function, hi3516cv300 Xiongmai module); INFERRED that a function name describes the content; UNKNOWN field meaning. Written by: VPSS_HAL_SetSharpenCoef.";
        field {
            name = "word";
            desc = "32-bit word (layout see the register description).";
            sw = rw;
            hw = r;
        } word[31:0];
    } NODE_W_2E4 @ 0x2E4;

    reg {
        name = "Node word at offset 0x2E8";
        desc = "Word 0x2E8 of the node image. PROVENANCE: PROVEN offset and the listed bit extents (read from the load/store/bic/orr sequence of the named vendor function, hi3516cv300 Xiongmai module); INFERRED that a function name describes the content; UNKNOWN field meaning. Written by: VPSS_HAL_SetSharpenCoef modifies bits [13:1] (inserts a value at shift 1).";
        field {
            name = "word";
            desc = "32-bit word (layout see the register description).";
            sw = rw;
            hw = r;
        } word[31:0];
    } NODE_W_2E8 @ 0x2E8;

    reg {
        name = "Node word at offset 0x2EC";
        desc = "Word 0x2EC of the node image. PROVENANCE: PROVEN offset and the listed bit extents (read from the load/store/bic/orr sequence of the named vendor function, hi3516cv300 Xiongmai module); INFERRED that a function name describes the content; UNKNOWN field meaning. Written by: VPSS_HAL_SetSharpenCoef.";
        field {
            name = "word";
            desc = "32-bit word (layout see the register description).";
            sw = rw;
            hw = r;
        } word[31:0];
    } NODE_W_2EC @ 0x2EC;

    reg {
        name = "Node word at offset 0x2F0";
        desc = "Word 0x2F0 of the node image. PROVENANCE: PROVEN offset and the listed bit extents (read from the load/store/bic/orr sequence of the named vendor function, hi3516cv300 Xiongmai module); INFERRED that a function name describes the content; UNKNOWN field meaning. Written by: VPSS_HAL_SetSharpenCoef.";
        field {
            name = "word";
            desc = "32-bit word (layout see the register description).";
            sw = rw;
            hw = r;
        } word[31:0];
    } NODE_W_2F0 @ 0x2F0;

    reg {
        name = "Node word at offset 0x2F4";
        desc = "Word 0x2F4 of the node image. PROVENANCE: PROVEN offset and the listed bit extents (read from the load/store/bic/orr sequence of the named vendor function, hi3516cv300 Xiongmai module); INFERRED that a function name describes the content; UNKNOWN field meaning. Written by: VPSS_HAL_SetSharpenCoef.";
        field {
            name = "word";
            desc = "32-bit word (layout see the register description).";
            sw = rw;
            hw = r;
        } word[31:0];
    } NODE_W_2F4 @ 0x2F4;

    reg {
        name = "Node word at offset 0x2F8";
        desc = "Word 0x2F8 of the node image. PROVENANCE: PROVEN offset and the listed bit extents (read from the load/store/bic/orr sequence of the named vendor function, hi3516cv300 Xiongmai module); INFERRED that a function name describes the content; UNKNOWN field meaning. Written by: VPSS_HAL_SetSharpenCoef.";
        field {
            name = "word";
            desc = "32-bit word (layout see the register description).";
            sw = rw;
            hw = r;
        } word[31:0];
    } NODE_W_2F8 @ 0x2F8;

    reg {
        name = "Node word at offset 0x2FC";
        desc = "Word 0x2FC of the node image. PROVENANCE: PROVEN offset and the listed bit extents (read from the load/store/bic/orr sequence of the named vendor function, hi3516cv300 Xiongmai module); INFERRED that a function name describes the content; UNKNOWN field meaning. Written by: VPSS_HAL_SetNext.";
        field {
            name = "word";
            desc = "32-bit word (layout see the register description).";
            sw = rw;
            hw = r;
        } word[31:0];
    } NODE_W_2FC @ 0x2FC;

    reg {
        name = "Node word at offset 0x31C";
        desc = "Word 0x31C of the node image. PROVENANCE: PROVEN offset and the listed bit extents (read from the load/store/bic/orr sequence of the named vendor function, hi3516cv300 Xiongmai module); INFERRED that a function name describes the content; UNKNOWN field meaning. Written by: VPSS_HAL_SetTimeOut.";
        field {
            name = "word";
            desc = "32-bit word (layout see the register description).";
            sw = rw;
            hw = r;
        } word[31:0];
    } NODE_W_31C @ 0x31C;

    reg {
        name = "Node word at offset 0x328";
        desc = "Word 0x328 of the node image. PROVENANCE: PROVEN offset and the listed bit extents (read from the load/store/bic/orr sequence of the named vendor function, hi3516cv300 Xiongmai module); INFERRED that a function name describes the content; UNKNOWN field meaning. Written by: VPSS_HAL_SetSharpenCoef.";
        field {
            name = "word";
            desc = "32-bit word (layout see the register description).";
            sw = rw;
            hw = r;
        } word[31:0];
    } NODE_W_328 @ 0x328;

    reg {
        name = "Node word at offset 0x330";
        desc = "Word 0x330 of the node image. PROVENANCE: PROVEN offset and the listed bit extents (read from the load/store/bic/orr sequence of the named vendor function, hi3516cv300 Xiongmai module); INFERRED that a function name describes the content; UNKNOWN field meaning. Written by: VPSS_HAL_SetSharpenCoef.";
        field {
            name = "word";
            desc = "32-bit word (layout see the register description).";
            sw = rw;
            hw = r;
        } word[31:0];
    } NODE_W_330 @ 0x330;

    reg {
        name = "Node word at offset 0x334";
        desc = "Word 0x334 of the node image. PROVENANCE: PROVEN offset and the listed bit extents (read from the load/store/bic/orr sequence of the named vendor function, hi3516cv300 Xiongmai module); INFERRED that a function name describes the content; UNKNOWN field meaning. Written by: VPSS_HAL_SetSharpenCoef.";
        field {
            name = "word";
            desc = "32-bit word (layout see the register description).";
            sw = rw;
            hw = r;
        } word[31:0];
    } NODE_W_334 @ 0x334;

    reg {
        name = "Node word at offset 0x338";
        desc = "Word 0x338 of the node image. PROVENANCE: PROVEN offset and the listed bit extents (read from the load/store/bic/orr sequence of the named vendor function, hi3516cv300 Xiongmai module); INFERRED that a function name describes the content; UNKNOWN field meaning. Written by: VPSS_HAL_SetSharpenCoef.";
        field {
            name = "word";
            desc = "32-bit word (layout see the register description).";
            sw = rw;
            hw = r;
        } word[31:0];
    } NODE_W_338 @ 0x338;

    reg {
        name = "Node word at offset 0x33C";
        desc = "Word 0x33C of the node image. PROVENANCE: PROVEN offset and the listed bit extents (read from the load/store/bic/orr sequence of the named vendor function, hi3516cv300 Xiongmai module); INFERRED that a function name describes the content; UNKNOWN field meaning. Written by: VPSS_HAL_SetSharpenCoef.";
        field {
            name = "word";
            desc = "32-bit word (layout see the register description).";
            sw = rw;
            hw = r;
        } word[31:0];
    } NODE_W_33C @ 0x33C;

    reg {
        name = "Node word at offset 0x340";
        desc = "Word 0x340 of the node image. PROVENANCE: PROVEN offset and the listed bit extents (read from the load/store/bic/orr sequence of the named vendor function, hi3516cv300 Xiongmai module); INFERRED that a function name describes the content; UNKNOWN field meaning. Written by: VPSS_HAL_SetSharpenCoef.";
        field {
            name = "word";
            desc = "32-bit word (layout see the register description).";
            sw = rw;
            hw = r;
        } word[31:0];
    } NODE_W_340 @ 0x340;

    reg {
        name = "Node word at offset 0x344";
        desc = "Word 0x344 of the node image. PROVENANCE: PROVEN offset and the listed bit extents (read from the load/store/bic/orr sequence of the named vendor function, hi3516cv300 Xiongmai module); INFERRED that a function name describes the content; UNKNOWN field meaning. Written by: VPSS_HAL_SetSharpenCoef.";
        field {
            name = "word";
            desc = "32-bit word (layout see the register description).";
            sw = rw;
            hw = r;
        } word[31:0];
    } NODE_W_344 @ 0x344;

    reg {
        name = "Node word at offset 0x348";
        desc = "Word 0x348 of the node image. PROVENANCE: PROVEN offset and the listed bit extents (read from the load/store/bic/orr sequence of the named vendor function, hi3516cv300 Xiongmai module); INFERRED that a function name describes the content; UNKNOWN field meaning. Written by: VPSS_HAL_SetSharpenCoef.";
        field {
            name = "word";
            desc = "32-bit word (layout see the register description).";
            sw = rw;
            hw = r;
        } word[31:0];
    } NODE_W_348 @ 0x348;

    reg {
        name = "Node word at offset 0x34C";
        desc = "Word 0x34C of the node image. PROVENANCE: PROVEN offset and the listed bit extents (read from the load/store/bic/orr sequence of the named vendor function, hi3516cv300 Xiongmai module); INFERRED that a function name describes the content; UNKNOWN field meaning. Written by: VPSS_HAL_SetSharpenCoef.";
        field {
            name = "word";
            desc = "32-bit word (layout see the register description).";
            sw = rw;
            hw = r;
        } word[31:0];
    } NODE_W_34C @ 0x34C;

    reg {
        name = "Node word at offset 0x350";
        desc = "Word 0x350 of the node image. PROVENANCE: PROVEN offset and the listed bit extents (read from the load/store/bic/orr sequence of the named vendor function, hi3516cv300 Xiongmai module); INFERRED that a function name describes the content; UNKNOWN field meaning. Written by: VPSS_HAL_SetSharpenCoef.";
        field {
            name = "word";
            desc = "32-bit word (layout see the register description).";
            sw = rw;
            hw = r;
        } word[31:0];
    } NODE_W_350 @ 0x350;

    reg {
        name = "Node word at offset 0x354";
        desc = "Word 0x354 of the node image. PROVENANCE: PROVEN offset and the listed bit extents (read from the load/store/bic/orr sequence of the named vendor function, hi3516cv300 Xiongmai module); INFERRED that a function name describes the content; UNKNOWN field meaning. Written by: VPSS_HAL_SetSharpenCoef.";
        field {
            name = "word";
            desc = "32-bit word (layout see the register description).";
            sw = rw;
            hw = r;
        } word[31:0];
    } NODE_W_354 @ 0x354;

    reg {
        name = "Node word at offset 0x358";
        desc = "Word 0x358 of the node image. PROVENANCE: PROVEN offset and the listed bit extents (read from the load/store/bic/orr sequence of the named vendor function, hi3516cv300 Xiongmai module); INFERRED that a function name describes the content; UNKNOWN field meaning. Written by: VPSS_HAL_SetSharpenCoef.";
        field {
            name = "word";
            desc = "32-bit word (layout see the register description).";
            sw = rw;
            hw = r;
        } word[31:0];
    } NODE_W_358 @ 0x358;

    reg {
        name = "Node word at offset 0x3E4";
        desc = "Word 0x3E4 of the node image. PROVENANCE: PROVEN offset and the listed bit extents (read from the load/store/bic/orr sequence of the named vendor function, hi3516cv300 Xiongmai module); INFERRED that a function name describes the content; UNKNOWN field meaning. Written by: VPSS_HAL_SetSharpenCoef.";
        field {
            name = "word";
            desc = "32-bit word (layout see the register description).";
            sw = rw;
            hw = r;
        } word[31:0];
    } NODE_W_3E4 @ 0x3E4;

    reg {
        name = "Node word at offset 0x3EC";
        desc = "Word 0x3EC of the node image. PROVENANCE: PROVEN offset and the listed bit extents (read from the load/store/bic/orr sequence of the named vendor function, hi3516cv300 Xiongmai module); INFERRED that a function name describes the content; UNKNOWN field meaning. Written by: VPSS_HAL_SetSharpenCoef.";
        field {
            name = "word";
            desc = "32-bit word (layout see the register description).";
            sw = rw;
            hw = r;
        } word[31:0];
    } NODE_W_3EC @ 0x3EC;

    reg {
        name = "Node word at offset 0x400";
        desc = "Word 0x400 of the node image. PROVENANCE: PROVEN offset and the listed bit extents (read from the load/store/bic/orr sequence of the named vendor function, hi3516cv300 Xiongmai module); INFERRED that a function name describes the content; UNKNOWN field meaning. Written by: VPSS_HAL_SetMosaic modifies bits [3:1] (inserts a value at shift 1, 2, 3).";
        field {
            name = "word";
            desc = "32-bit word (layout see the register description).";
            sw = rw;
            hw = r;
        } word[31:0];
    } NODE_W_400 @ 0x400;

    reg {
        name = "Node word at offset 0x404";
        desc = "Word 0x404 of the node image. PROVENANCE: PROVEN offset and the listed bit extents (read from the load/store/bic/orr sequence of the named vendor function, hi3516cv300 Xiongmai module); INFERRED that a function name describes the content; UNKNOWN field meaning. Written by: VPSS_HAL_SetMosaic.";
        field {
            name = "word";
            desc = "32-bit word (layout see the register description).";
            sw = rw;
            hw = r;
        } word[31:0];
    } NODE_W_404 @ 0x404;

    reg {
        name = "Node word at offset 0x408";
        desc = "Word 0x408 of the node image. PROVENANCE: PROVEN offset and the listed bit extents (read from the load/store/bic/orr sequence of the named vendor function, hi3516cv300 Xiongmai module); INFERRED that a function name describes the content; UNKNOWN field meaning. Written by: VPSS_HAL_SetMosaic.";
        field {
            name = "word";
            desc = "32-bit word (layout see the register description).";
            sw = rw;
            hw = r;
        } word[31:0];
    } NODE_W_408 @ 0x408;

    reg {
        name = "Node word at offset 0x40C";
        desc = "Word 0x40C of the node image. PROVENANCE: PROVEN offset and the listed bit extents (read from the load/store/bic/orr sequence of the named vendor function, hi3516cv300 Xiongmai module); INFERRED that a function name describes the content; UNKNOWN field meaning. Written by: VPSS_HAL_SetMosaic.";
        field {
            name = "word";
            desc = "32-bit word (layout see the register description).";
            sw = rw;
            hw = r;
        } word[31:0];
    } NODE_W_40C @ 0x40C;

    reg {
        name = "Node word at offset 0x410";
        desc = "Word 0x410 of the node image. PROVENANCE: PROVEN offset and the listed bit extents (read from the load/store/bic/orr sequence of the named vendor function, hi3516cv300 Xiongmai module); INFERRED that a function name describes the content; UNKNOWN field meaning. Written by: VPSS_HAL_SetMosaic.";
        field {
            name = "word";
            desc = "32-bit word (layout see the register description).";
            sw = rw;
            hw = r;
        } word[31:0];
    } NODE_W_410 @ 0x410;

    reg {
        name = "Node word at offset 0x414";
        desc = "Word 0x414 of the node image. PROVENANCE: PROVEN offset and the listed bit extents (read from the load/store/bic/orr sequence of the named vendor function, hi3516cv300 Xiongmai module); INFERRED that a function name describes the content; UNKNOWN field meaning. Written by: VPSS_HAL_SetMosaic.";
        field {
            name = "word";
            desc = "32-bit word (layout see the register description).";
            sw = rw;
            hw = r;
        } word[31:0];
    } NODE_W_414 @ 0x414;

    reg {
        name = "Node word at offset 0x418";
        desc = "Word 0x418 of the node image. PROVENANCE: PROVEN offset and the listed bit extents (read from the load/store/bic/orr sequence of the named vendor function, hi3516cv300 Xiongmai module); INFERRED that a function name describes the content; UNKNOWN field meaning. Written by: VPSS_HAL_SetMosaic.";
        field {
            name = "word";
            desc = "32-bit word (layout see the register description).";
            sw = rw;
            hw = r;
        } word[31:0];
    } NODE_W_418 @ 0x418;

    reg {
        name = "Node word at offset 0x41C";
        desc = "Word 0x41C of the node image. PROVENANCE: PROVEN offset and the listed bit extents (read from the load/store/bic/orr sequence of the named vendor function, hi3516cv300 Xiongmai module); INFERRED that a function name describes the content; UNKNOWN field meaning. Written by: VPSS_HAL_SetMosaic.";
        field {
            name = "word";
            desc = "32-bit word (layout see the register description).";
            sw = rw;
            hw = r;
        } word[31:0];
    } NODE_W_41C @ 0x41C;

    reg {
        name = "Node word at offset 0x420";
        desc = "Word 0x420 of the node image. PROVENANCE: PROVEN offset and the listed bit extents (read from the load/store/bic/orr sequence of the named vendor function, hi3516cv300 Xiongmai module); INFERRED that a function name describes the content; UNKNOWN field meaning. Written by: VPSS_HAL_SetMosaic.";
        field {
            name = "word";
            desc = "32-bit word (layout see the register description).";
            sw = rw;
            hw = r;
        } word[31:0];
    } NODE_W_420 @ 0x420;

    reg {
        name = "Node word at offset 0x424";
        desc = "Word 0x424 of the node image. PROVENANCE: PROVEN offset and the listed bit extents (read from the load/store/bic/orr sequence of the named vendor function, hi3516cv300 Xiongmai module); INFERRED that a function name describes the content; UNKNOWN field meaning. Written by: VPSS_HAL_SetMosaic.";
        field {
            name = "word";
            desc = "32-bit word (layout see the register description).";
            sw = rw;
            hw = r;
        } word[31:0];
    } NODE_W_424 @ 0x424;

};

`endif
