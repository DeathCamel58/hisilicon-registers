`ifndef HISI_VPSS_V2_NODE_RDL
`define HISI_VPSS_V2_NODE_RDL

regfile eHISI_VPSS_V2_NODE {
    name = "VPSS job node image (NOT A REGISTER FILE), Hi3516C V300 / E V100";
    desc = "NOT A REGISTER FILE and NOT INSTANTIATED: layout of one VPSS job node (register image in DDR) as written by the VPSS_HAL_Set* functions of hi3516cv300_vpss.ko (Xiongmai V4.02.R12, MPP V1.0.0.0), described as a regfile only to document offsets. Link words: NODE_ID 0x1F4, MASK 0x1FC, NEXT 0x2FC, timeout 0x31C (see eHISI_VPSS_V2). 44 setter functions were scanned; fields written through register arithmetic the scanner does not follow (computed shifts and widths) show only the constant masks, so bit extents are LOWER BOUNDS, and VPSS_HAL_SetLcmpCfg and VPSS_HAL_SetRfrLcmpSize are EMPTY functions (a single bx lr, PROVEN), VPSS_HAL_SetOutstanding writes the MMIO register 0x314 (see eHISI_VPSS_V2), and VPSS_HAL_SetChnCtrl writes words 0x008 (bits 16, 18, 19), 0x144, 0x15C and 0x18C (bits [5:0] each, one bit per channel/stage flag). Provenance per word below. Reconciled 2026-11-12 with the path-sensitive arm-re engine (docs/research/arm-re-rediff.md): words confirmed, new words added, words the engine does not produce are marked. Not hardware verified.";

    reg {
        name = "Word at offset 0x0";
        desc = "Word 0x0 (NEW in the arm-re rediff 2026-11-12). PROVENANCE: PROVEN offset and stored byte lanes 0123, cleared bit extents [11:11] [12:12], written by VPSS_HAL_SetCoverCtrl, VPSS_HAL_SetMosaicCtrl, VPSS_HAL_SetSharpenCtrl (3 stores) in the path-sensitive static run (conditional paths and indexed loop records folded into the word; some are loop-built or conditional and not individually proven). Meaning UNKNOWN. NOTE (2026-11-12): dynamic harness run (qemu, ko-harness, 9 argument patterns): written by VPSS_HAL_CreatNodeQueue, VPSS_HAL_GetIntStatus, VPSS_HAL_GetNodeID, VPSS_HAL_GetOnlineChnZmeAddr.";
        field {
            name = "word";
            desc = "32-bit word.";
            sw = rw;
            hw = r;
        } word[31:0];
    } NODE_W_000 @ 0x0;
    reg {
        name = "Node word at offset 0x4";
        desc = "Word 0x4 of the node image. PROVENANCE: PROVEN offset and the listed bit extents (read from the load/store/bic/orr sequence of the named vendor function, hi3516cv300 Xiongmai module); INFERRED that a function name describes the content; UNKNOWN field meaning. Written by: VPSS_HAL_SetGrpCropAttr; VPSS_HAL_SetCover; VPSS_HAL_SetChnSclCfg. NOTE (2026-11-12): dynamic harness run (qemu, ko-harness, 9 argument patterns): written by VPSS_HAL_CleanChnLowDelay, VPSS_HAL_ClearLowDelayEn, VPSS_HAL_CreatNodeQueue, VPSS_HAL_DestroyNodeQueue.";
        field {
            name = "word";
            desc = "32-bit word (layout see the register description).";
            sw = rw;
            hw = r;
        } word[31:0];
    } NODE_W_004 @ 0x4;

    reg {
        name = "Node word at offset 0x8";
        desc = "Word 0x8 of the node image. PROVENANCE: PROVEN offset and the listed bit extents (read from the load/store/bic/orr sequence of the named vendor function, hi3516cv300 Xiongmai module); INFERRED that a function name describes the content; UNKNOWN field meaning. Written by: VPSS_HAL_SetChnEn modifies bits [2:2] (inserts a value at shift 2); VPSS_HAL_SetChnCtrl modifies bits [16:16] [19:18]; VPSS_HAL_SetSrcImgType modifies bits [20:20] (inserts a value at shift 20); VPSS_HAL_SetCover; VPSS_HAL_SetChnSclCfg. NOTE (2026-11-12): dynamic harness run (qemu, ko-harness, 9 argument patterns): written by VPSS_HAL_CreatNodeQueue, VPSS_HAL_DestroyNodeQueue, VPSS_HAL_NodeQueuePutFree, VPSS_HAL_NrRfrEn.";
        field {
            name = "word";
            desc = "32-bit word (layout see the register description).";
            sw = rw;
            hw = r;
        } word[31:0];
    } NODE_W_008 @ 0x8;

    reg {
        name = "Node word at offset 0xC";
        desc = "Word 0xC of the node image. PROVENANCE: PROVEN offset and the listed bit extents (read from the load/store/bic/orr sequence of the named vendor function, hi3516cv300 Xiongmai module); INFERRED that a function name describes the content; UNKNOWN field meaning. Written by: VPSS_HAL_SetVadSel modifies bits [3:3] (inserts a value at shift 3); VPSS_HAL_SetImgWorkType modifies bits [2:1] (inserts a value at shift 1); VPSS_HAL_SetCover; VPSS_HAL_SetChnSclCfg modifies bits [20:19] (inserts a value at shift 19). NOTE (2026-11-12): dynamic harness run (qemu, ko-harness, 9 argument patterns): written by VPSS_HAL_CreatNodeQueue, VPSS_HAL_DestroyNodeQueue, VPSS_HAL_NrRfrEn, VPSS_HAL_SetImgWorkType.";
        field {
            name = "word";
            desc = "32-bit word (layout see the register description).";
            sw = rw;
            hw = r;
        } word[31:0];
    } NODE_W_00C @ 0xC;

    reg {
        name = "Node word at offset 0x10";
        desc = "Word 0x10 of the node image. PROVENANCE: PROVEN offset and the listed bit extents (read from the load/store/bic/orr sequence of the named vendor function, hi3516cv300 Xiongmai module); INFERRED that a function name describes the content; UNKNOWN field meaning. Written by: VPSS_HAL_SetRegup; VPSS_HAL_SetCover; VPSS_HAL_SetChnSclCfg. NOTE (2026-11-12): dynamic harness run (qemu, ko-harness, 9 argument patterns): written by VPSS_HAL_CreatNodeQueue, VPSS_HAL_DestroyNodeQueue, VPSS_HAL_NodeQueuePutWait, VPSS_HAL_ScaleRegup.";
        field {
            name = "word";
            desc = "32-bit word (layout see the register description).";
            sw = rw;
            hw = r;
        } word[31:0];
    } NODE_W_010 @ 0x10;

    reg {
        name = "Node word at offset 0x14";
        desc = "Word 0x14 of the node image. PROVENANCE: PROVEN offset and the listed bit extents (read from the load/store/bic/orr sequence of the named vendor function, hi3516cv300 Xiongmai module); INFERRED that a function name describes the content; UNKNOWN field meaning. Written by: VPSS_HAL_SetCover; VPSS_HAL_SetChnSclCfg. NOTE (2026-11-12): not produced by VPSS_HAL_Set* (source unknown): the path-sensitive static run of the setters does not write this word (carried over from the earlier linear scan); dynamic harness run (qemu, ko-harness, 9 argument patterns): written by VPSS_HAL_CreatNodeQueue, VPSS_HAL_DestroyNodeQueue; INFERRED software bookkeeping: VPSS_HAL_CreatNodeQueue/DestroyNodeQueue write this word, so it is probably a list link of the driver node object, not a hardware image word.";
        field {
            name = "word";
            desc = "32-bit word (layout see the register description).";
            sw = rw;
            hw = r;
        } word[31:0];
    } NODE_W_014 @ 0x14;

    reg {
        name = "Node word at offset 0x18";
        desc = "Word 0x18 of the node image. PROVENANCE: PROVEN offset and the listed bit extents (read from the load/store/bic/orr sequence of the named vendor function, hi3516cv300 Xiongmai module); INFERRED that a function name describes the content; UNKNOWN field meaning. Written by: VPSS_HAL_SetChnSclCfg. NOTE (2026-11-12): not produced by VPSS_HAL_Set* (source unknown): the path-sensitive static run of the setters does not write this word (carried over from the earlier linear scan); dynamic harness run (qemu, ko-harness, 9 argument patterns): written by VPSS_HAL_CreatNodeQueue, VPSS_HAL_DestroyNodeQueue; INFERRED software bookkeeping: VPSS_HAL_CreatNodeQueue/DestroyNodeQueue write this word, so it is probably a list link of the driver node object, not a hardware image word.";
        field {
            name = "word";
            desc = "32-bit word (layout see the register description).";
            sw = rw;
            hw = r;
        } word[31:0];
    } NODE_W_018 @ 0x18;

    reg {
        name = "Word at offset 0x1C";
        desc = "Word 0x1C (NEW 2026-11-12). PROVENANCE: PROVEN offset, written in the dynamic harness run (qemu, ko-harness) by VPSS_HAL_CreatNodeQueue, VPSS_HAL_DestroyNodeQueue; not found by the static run. Meaning UNKNOWN.";
        field {
            name = "word";
            desc = "32-bit word.";
            sw = rw;
            hw = r;
        } word[31:0];
    } NODE_W_01C @ 0x1C;
    reg {
        name = "Node word at offset 0x20";
        desc = "Word 0x20 of the node image. PROVENANCE: PROVEN offset and the listed bit extents (read from the load/store/bic/orr sequence of the named vendor function, hi3516cv300 Xiongmai module); INFERRED that a function name describes the content; UNKNOWN field meaning. Written by: VPSS_HAL_SetSrcImgSize. NOTE (2026-11-12): dynamic harness run (qemu, ko-harness, 9 argument patterns): written by VPSS_HAL_CreatNodeQueue, VPSS_HAL_DestroyNodeQueue, VPSS_HAL_NodeQueuePutFree, VPSS_HAL_NodeQueuePutWait.";
        field {
            name = "word";
            desc = "32-bit word (layout see the register description).";
            sw = rw;
            hw = r;
        } word[31:0];
    } NODE_W_020 @ 0x20;

    reg {
        name = "Node word at offset 0x24";
        desc = "Word 0x24 of the node image. PROVENANCE: PROVEN offset and the listed bit extents (read from the load/store/bic/orr sequence of the named vendor function, hi3516cv300 Xiongmai module); INFERRED that a function name describes the content; UNKNOWN field meaning. Written by: VPSS_HAL_SetRefPicSize. NOTE (2026-11-12): dynamic harness run (qemu, ko-harness, 9 argument patterns): written by VPSS_HAL_CreatNodeQueue, VPSS_HAL_DestroyNodeQueue, VPSS_HAL_NodeQueuePutFree, VPSS_HAL_NodeQueuePutWait.";
        field {
            name = "word";
            desc = "32-bit word (layout see the register description).";
            sw = rw;
            hw = r;
        } word[31:0];
    } NODE_W_024 @ 0x24;

    reg {
        name = "Node word at offset 0x28";
        desc = "Word 0x28 of the node image. PROVENANCE: PROVEN offset and the listed bit extents (read from the load/store/bic/orr sequence of the named vendor function, hi3516cv300 Xiongmai module); INFERRED that a function name describes the content; UNKNOWN field meaning. Written by: VPSS_HAL_SetGrpCropAttr. NOTE (2026-11-12): dynamic harness run (qemu, ko-harness, 9 argument patterns): written by VPSS_HAL_CreatNodeQueue, VPSS_HAL_DestroyNodeQueue, VPSS_HAL_SetGrpCropAttr.";
        field {
            name = "word";
            desc = "32-bit word (layout see the register description).";
            sw = rw;
            hw = r;
        } word[31:0];
    } NODE_W_028 @ 0x28;

    reg {
        name = "Node word at offset 0x2C";
        desc = "Word 0x2C of the node image. PROVENANCE: PROVEN offset and the listed bit extents (read from the load/store/bic/orr sequence of the named vendor function, hi3516cv300 Xiongmai module); INFERRED that a function name describes the content; UNKNOWN field meaning. Written by: VPSS_HAL_SetGrpCropAttr. NOTE (2026-11-12): dynamic harness run (qemu, ko-harness, 9 argument patterns): written by VPSS_HAL_CreatNodeQueue, VPSS_HAL_DestroyNodeQueue, VPSS_HAL_SetGrpCropAttr.";
        field {
            name = "word";
            desc = "32-bit word (layout see the register description).";
            sw = rw;
            hw = r;
        } word[31:0];
    } NODE_W_02C @ 0x2C;

    reg {
        name = "Node word at offset 0x30";
        desc = "Word 0x30 of the node image. PROVENANCE: PROVEN offset and the listed bit extents (read from the load/store/bic/orr sequence of the named vendor function, hi3516cv300 Xiongmai module); INFERRED that a function name describes the content; UNKNOWN field meaning. Written by: VPSS_HAL_SetGrpCropAttr. NOTE (2026-11-12): dynamic harness run (qemu, ko-harness, 9 argument patterns): written by VPSS_HAL_CreatNodeQueue, VPSS_HAL_DestroyNodeQueue, VPSS_HAL_NodeQueuePutBusy, VPSS_HAL_SetGrpCropAttr.";
        field {
            name = "word";
            desc = "32-bit word (layout see the register description).";
            sw = rw;
            hw = r;
        } word[31:0];
    } NODE_W_030 @ 0x30;

    reg {
        name = "Node word at offset 0x34";
        desc = "Word 0x34 of the node image. PROVENANCE: PROVEN offset and the listed bit extents (read from the load/store/bic/orr sequence of the named vendor function, hi3516cv300 Xiongmai module); INFERRED that a function name describes the content; UNKNOWN field meaning. Written by: VPSS_HAL_SetGrpCropAttr. NOTE (2026-11-12): dynamic harness run (qemu, ko-harness, 9 argument patterns): written by VPSS_HAL_CreatNodeQueue, VPSS_HAL_DestroyNodeQueue, VPSS_HAL_SetGrpCropAttr.";
        field {
            name = "word";
            desc = "32-bit word (layout see the register description).";
            sw = rw;
            hw = r;
        } word[31:0];
    } NODE_W_034 @ 0x34;

    reg {
        name = "Word at offset 0x38";
        desc = "Word 0x38 (NEW in the arm-re rediff 2026-11-12). PROVENANCE: PROVEN offset and stored byte lanes 0123, cleared bit extents [28:16], written by VPSS_HAL_SetChnCrop (1 stores) in the path-sensitive static run (conditional paths and indexed loop records folded into the word; some are loop-built or conditional and not individually proven). Meaning UNKNOWN. NOTE (2026-11-12): dynamic harness run (qemu, ko-harness, 9 argument patterns): written by VPSS_HAL_CreatNodeQueue, VPSS_HAL_DestroyNodeQueue, VPSS_HAL_NodeQueuePutBusy.";
        field {
            name = "word";
            desc = "32-bit word.";
            sw = rw;
            hw = r;
        } word[31:0];
    } NODE_W_038 @ 0x38;
    reg {
        name = "Node word at offset 0x3C";
        desc = "Word 0x3C of the node image. PROVENANCE: PROVEN offset and the listed bit extents (read from the load/store/bic/orr sequence of the named vendor function, hi3516cv300 Xiongmai module); INFERRED that a function name describes the content; UNKNOWN field meaning. Written by: VPSS_HAL_SetChnCrop. NOTE (2026-11-12): dynamic harness run (qemu, ko-harness, 9 argument patterns): written by VPSS_HAL_CreatNodeQueue, VPSS_HAL_DestroyNodeQueue.";
        field {
            name = "word";
            desc = "32-bit word (layout see the register description).";
            sw = rw;
            hw = r;
        } word[31:0];
    } NODE_W_03C @ 0x3C;

    reg {
        name = "Node word at offset 0x40";
        desc = "Word 0x40 of the node image. PROVENANCE: PROVEN offset and the listed bit extents (read from the load/store/bic/orr sequence of the named vendor function, hi3516cv300 Xiongmai module); INFERRED that a function name describes the content; UNKNOWN field meaning. Written by: VPSS_HAL_SetChnSclCfg. NOTE (2026-11-12): dynamic harness run (qemu, ko-harness, 9 argument patterns): written by VPSS_HAL_CreatNodeQueue, VPSS_HAL_DestroyNodeQueue.";
        field {
            name = "word";
            desc = "32-bit word (layout see the register description).";
            sw = rw;
            hw = r;
        } word[31:0];
    } NODE_W_040 @ 0x40;

    reg {
        name = "Node word at offset 0x44";
        desc = "Word 0x44 of the node image. PROVENANCE: PROVEN offset and the listed bit extents (read from the load/store/bic/orr sequence of the named vendor function, hi3516cv300 Xiongmai module); INFERRED that a function name describes the content; UNKNOWN field meaning. Written by: VPSS_HAL_SetChnCrop; VPSS_HAL_SetChnSclCfg. NOTE (2026-11-12): dynamic harness run (qemu, ko-harness, 9 argument patterns): written by VPSS_HAL_CreatNodeQueue, VPSS_HAL_DestroyNodeQueue.";
        field {
            name = "word";
            desc = "32-bit word (layout see the register description).";
            sw = rw;
            hw = r;
        } word[31:0];
    } NODE_W_044 @ 0x44;

    reg {
        name = "Node word at offset 0x48";
        desc = "Word 0x48 of the node image. PROVENANCE: PROVEN offset and the listed bit extents (read from the load/store/bic/orr sequence of the named vendor function, hi3516cv300 Xiongmai module); INFERRED that a function name describes the content; UNKNOWN field meaning. Written by: VPSS_HAL_SetChnSclCfg. NOTE (2026-11-12): not produced by VPSS_HAL_Set* (source unknown): the path-sensitive static run of the setters does not write this word (carried over from the earlier linear scan); dynamic harness run (qemu, ko-harness, 9 argument patterns): written by VPSS_HAL_CreatNodeQueue, VPSS_HAL_DestroyNodeQueue; INFERRED software bookkeeping: VPSS_HAL_CreatNodeQueue/DestroyNodeQueue write this word, so it is probably a list link of the driver node object, not a hardware image word.";
        field {
            name = "word";
            desc = "32-bit word (layout see the register description).";
            sw = rw;
            hw = r;
        } word[31:0];
    } NODE_W_048 @ 0x48;

    reg {
        name = "Node word at offset 0x4C";
        desc = "Word 0x4C of the node image. PROVENANCE: PROVEN offset and the listed bit extents (read from the load/store/bic/orr sequence of the named vendor function, hi3516cv300 Xiongmai module); INFERRED that a function name describes the content; UNKNOWN field meaning. Written by: VPSS_HAL_SetChnSclCfg modifies bits [20:19] (inserts a value at shift 19). NOTE (2026-11-12): not produced by VPSS_HAL_Set* (source unknown): the path-sensitive static run of the setters does not write this word (carried over from the earlier linear scan); dynamic harness run (qemu, ko-harness, 9 argument patterns): written by VPSS_HAL_CreatNodeQueue; INFERRED software bookkeeping: VPSS_HAL_CreatNodeQueue/DestroyNodeQueue write this word, so it is probably a list link of the driver node object, not a hardware image word.";
        field {
            name = "word";
            desc = "32-bit word (layout see the register description).";
            sw = rw;
            hw = r;
        } word[31:0];
    } NODE_W_04C @ 0x4C;

    reg {
        name = "Node word at offset 0x50";
        desc = "Word 0x50 of the node image. PROVENANCE: PROVEN offset and the listed bit extents (read from the load/store/bic/orr sequence of the named vendor function, hi3516cv300 Xiongmai module); INFERRED that a function name describes the content; UNKNOWN field meaning. Written by: VPSS_HAL_SetChnSclCfg. NOTE (2026-11-12): not produced by VPSS_HAL_Set* (source unknown): the path-sensitive static run of the setters does not write this word (carried over from the earlier linear scan); dynamic harness run (qemu, ko-harness, 9 argument patterns): written by VPSS_HAL_CreatNodeQueue; INFERRED software bookkeeping: VPSS_HAL_CreatNodeQueue/DestroyNodeQueue write this word, so it is probably a list link of the driver node object, not a hardware image word.";
        field {
            name = "word";
            desc = "32-bit word (layout see the register description).";
            sw = rw;
            hw = r;
        } word[31:0];
    } NODE_W_050 @ 0x50;

    reg {
        name = "Node word at offset 0x54";
        desc = "Word 0x54 of the node image. PROVENANCE: PROVEN offset and the listed bit extents (read from the load/store/bic/orr sequence of the named vendor function, hi3516cv300 Xiongmai module); INFERRED that a function name describes the content; UNKNOWN field meaning. Written by: VPSS_HAL_SetChnSclCfg. NOTE (2026-11-12): not produced by VPSS_HAL_Set* (source unknown): the path-sensitive static run of the setters does not write this word (carried over from the earlier linear scan).";
        field {
            name = "word";
            desc = "32-bit word (layout see the register description).";
            sw = rw;
            hw = r;
        } word[31:0];
    } NODE_W_054 @ 0x54;

    reg {
        name = "Node word at offset 0x58";
        desc = "Word 0x58 of the node image. PROVENANCE: PROVEN offset and the listed bit extents (read from the load/store/bic/orr sequence of the named vendor function, hi3516cv300 Xiongmai module); INFERRED that a function name describes the content; UNKNOWN field meaning. Written by: VPSS_HAL_SetChnSclCfg. NOTE (2026-11-12): not produced by VPSS_HAL_Set* (source unknown): the path-sensitive static run of the setters does not write this word (carried over from the earlier linear scan).";
        field {
            name = "word";
            desc = "32-bit word (layout see the register description).";
            sw = rw;
            hw = r;
        } word[31:0];
    } NODE_W_058 @ 0x58;

    reg {
        name = "Node word at offset 0x64";
        desc = "Word 0x64 of the node image. PROVENANCE: PROVEN offset and the listed bit extents (read from the load/store/bic/orr sequence of the named vendor function, hi3516cv300 Xiongmai module); INFERRED that a function name describes the content; UNKNOWN field meaning. Written by: VPSS_HAL_SetChnImgSize. NOTE (2026-11-12): dynamic harness run (qemu, ko-harness, 9 argument patterns): written by VPSS_HAL_SetChnImgSize.";
        field {
            name = "word";
            desc = "32-bit word (layout see the register description).";
            sw = rw;
            hw = r;
        } word[31:0];
    } NODE_W_064 @ 0x64;

    reg {
        name = "Node word at offset 0x68";
        desc = "Word 0x68 of the node image. PROVENANCE: PROVEN offset and the listed bit extents (read from the load/store/bic/orr sequence of the named vendor function, hi3516cv300 Xiongmai module); INFERRED that a function name describes the content; UNKNOWN field meaning. Written by: VPSS_HAL_SetChnImgSize. NOTE (2026-11-12): dynamic harness run (qemu, ko-harness, 9 argument patterns): written by VPSS_HAL_SetChnImgSize.";
        field {
            name = "word";
            desc = "32-bit word (layout see the register description).";
            sw = rw;
            hw = r;
        } word[31:0];
    } NODE_W_068 @ 0x68;

    reg {
        name = "Node word at offset 0x70";
        desc = "Word 0x70 of the node image. PROVENANCE: PROVEN offset and the listed bit extents (read from the load/store/bic/orr sequence of the named vendor function, hi3516cv300 Xiongmai module); INFERRED that a function name describes the content; UNKNOWN field meaning. Written by: VPSS_HAL_SetChnImgSize.";
        field {
            name = "word";
            desc = "32-bit word (layout see the register description).";
            sw = rw;
            hw = r;
        } word[31:0];
    } NODE_W_070 @ 0x70;

    reg {
        name = "Node word at offset 0x74";
        desc = "Word 0x74 of the node image. PROVENANCE: PROVEN offset and the listed bit extents (read from the load/store/bic/orr sequence of the named vendor function, hi3516cv300 Xiongmai module); INFERRED that a function name describes the content; UNKNOWN field meaning. Written by: VPSS_HAL_SetRfrPicSize. NOTE (2026-11-12): dynamic harness run (qemu, ko-harness, 9 argument patterns): written by VPSS_HAL_SetRfrPicSize.";
        field {
            name = "word";
            desc = "32-bit word (layout see the register description).";
            sw = rw;
            hw = r;
        } word[31:0];
    } NODE_W_074 @ 0x74;

    reg {
        name = "Node word at offset 0xC0";
        desc = "Word 0xC0 of the node image. PROVENANCE: PROVEN offset and the listed bit extents (read from the load/store/bic/orr sequence of the named vendor function, hi3516cv300 Xiongmai module); INFERRED that a function name describes the content; UNKNOWN field meaning. Written by: VPSS_HAL_SetChnSclCfg. NOTE (2026-11-12): not produced by VPSS_HAL_Set* (source unknown): the path-sensitive static run of the setters does not write this word (carried over from the earlier linear scan).";
        field {
            name = "word";
            desc = "32-bit word (layout see the register description).";
            sw = rw;
            hw = r;
        } word[31:0];
    } NODE_W_0C0 @ 0xC0;

    reg {
        name = "Node word at offset 0xC4";
        desc = "Word 0xC4 of the node image. PROVENANCE: PROVEN offset and the listed bit extents (read from the load/store/bic/orr sequence of the named vendor function, hi3516cv300 Xiongmai module); INFERRED that a function name describes the content; UNKNOWN field meaning. Written by: VPSS_HAL_SetChnSclCfg. NOTE (2026-11-12): not produced by VPSS_HAL_Set* (source unknown): the path-sensitive static run of the setters does not write this word (carried over from the earlier linear scan).";
        field {
            name = "word";
            desc = "32-bit word (layout see the register description).";
            sw = rw;
            hw = r;
        } word[31:0];
    } NODE_W_0C4 @ 0xC4;

    reg {
        name = "Node word at offset 0xC8";
        desc = "Word 0xC8 of the node image. PROVENANCE: PROVEN offset and the listed bit extents (read from the load/store/bic/orr sequence of the named vendor function, hi3516cv300 Xiongmai module); INFERRED that a function name describes the content; UNKNOWN field meaning. Written by: VPSS_HAL_SetChnSclCfg. NOTE (2026-11-12): not produced by VPSS_HAL_Set* (source unknown): the path-sensitive static run of the setters does not write this word (carried over from the earlier linear scan).";
        field {
            name = "word";
            desc = "32-bit word (layout see the register description).";
            sw = rw;
            hw = r;
        } word[31:0];
    } NODE_W_0C8 @ 0xC8;

    reg {
        name = "Node word at offset 0xCC";
        desc = "Word 0xCC of the node image. PROVENANCE: PROVEN offset and the listed bit extents (read from the load/store/bic/orr sequence of the named vendor function, hi3516cv300 Xiongmai module); INFERRED that a function name describes the content; UNKNOWN field meaning. Written by: VPSS_HAL_SetChnSclCfg modifies bits [20:19] (inserts a value at shift 19). NOTE (2026-11-12): not produced by VPSS_HAL_Set* (source unknown): the path-sensitive static run of the setters does not write this word (carried over from the earlier linear scan).";
        field {
            name = "word";
            desc = "32-bit word (layout see the register description).";
            sw = rw;
            hw = r;
        } word[31:0];
    } NODE_W_0CC @ 0xCC;

    reg {
        name = "Node word at offset 0xD0";
        desc = "Word 0xD0 of the node image. PROVENANCE: PROVEN offset and the listed bit extents (read from the load/store/bic/orr sequence of the named vendor function, hi3516cv300 Xiongmai module); INFERRED that a function name describes the content; UNKNOWN field meaning. Written by: VPSS_HAL_SetChnSclCfg; VPSS_HAL_SetMadAddr. NOTE (2026-11-12): dynamic harness run (qemu, ko-harness, 9 argument patterns): written by VPSS_HAL_SetMadAddr.";
        field {
            name = "word";
            desc = "32-bit word (layout see the register description).";
            sw = rw;
            hw = r;
        } word[31:0];
    } NODE_W_0D0 @ 0xD0;

    reg {
        name = "Node word at offset 0xD4";
        desc = "Word 0xD4 of the node image. PROVENANCE: PROVEN offset and the listed bit extents (read from the load/store/bic/orr sequence of the named vendor function, hi3516cv300 Xiongmai module); INFERRED that a function name describes the content; UNKNOWN field meaning. Written by: VPSS_HAL_SetChnSclCfg; VPSS_HAL_SetMadAddr. NOTE (2026-11-12): dynamic harness run (qemu, ko-harness, 9 argument patterns): written by VPSS_HAL_SetMadAddr.";
        field {
            name = "word";
            desc = "32-bit word (layout see the register description).";
            sw = rw;
            hw = r;
        } word[31:0];
    } NODE_W_0D4 @ 0xD4;

    reg {
        name = "Node word at offset 0xD8";
        desc = "Word 0xD8 of the node image. PROVENANCE: PROVEN offset and the listed bit extents (read from the load/store/bic/orr sequence of the named vendor function, hi3516cv300 Xiongmai module); INFERRED that a function name describes the content; UNKNOWN field meaning. Written by: VPSS_HAL_SetChnSclCfg; VPSS_HAL_SetMadAddr. NOTE (2026-11-12): dynamic harness run (qemu, ko-harness, 9 argument patterns): written by VPSS_HAL_SetMadAddr.";
        field {
            name = "word";
            desc = "32-bit word (layout see the register description).";
            sw = rw;
            hw = r;
        } word[31:0];
    } NODE_W_0D8 @ 0xD8;

    reg {
        name = "Node word at offset 0xDC";
        desc = "Word 0xDC of the node image. PROVENANCE: PROVEN offset and the listed bit extents (read from the load/store/bic/orr sequence of the named vendor function, hi3516cv300 Xiongmai module); INFERRED that a function name describes the content; UNKNOWN field meaning. Written by: VPSS_HAL_SetChnSclCfg; VPSS_HAL_SetMadAddr. NOTE (2026-11-12): dynamic harness run (qemu, ko-harness, 9 argument patterns): written by VPSS_HAL_SetMadAddr.";
        field {
            name = "word";
            desc = "32-bit word (layout see the register description).";
            sw = rw;
            hw = r;
        } word[31:0];
    } NODE_W_0DC @ 0xDC;

    reg {
        name = "Node word at offset 0xE0";
        desc = "Word 0xE0 of the node image. PROVENANCE: PROVEN offset and the listed bit extents (read from the load/store/bic/orr sequence of the named vendor function, hi3516cv300 Xiongmai module); INFERRED that a function name describes the content; UNKNOWN field meaning. Written by: VPSS_HAL_SetMadAddr. NOTE (2026-11-12): dynamic harness run (qemu, ko-harness, 9 argument patterns): written by VPSS_HAL_SetMadAddr.";
        field {
            name = "word";
            desc = "32-bit word (layout see the register description).";
            sw = rw;
            hw = r;
        } word[31:0];
    } NODE_W_0E0 @ 0xE0;

    reg {
        name = "Node word at offset 0xE4";
        desc = "Word 0xE4 of the node image. PROVENANCE: PROVEN offset and the listed bit extents (read from the load/store/bic/orr sequence of the named vendor function, hi3516cv300 Xiongmai module); INFERRED that a function name describes the content; UNKNOWN field meaning. Written by: VPSS_HAL_SetMadAddr. NOTE (2026-11-12): dynamic harness run (qemu, ko-harness, 9 argument patterns): written by VPSS_HAL_SetMadAddr.";
        field {
            name = "word";
            desc = "32-bit word (layout see the register description).";
            sw = rw;
            hw = r;
        } word[31:0];
    } NODE_W_0E4 @ 0xE4;

    reg {
        name = "Node word at offset 0xE8";
        desc = "Word 0xE8 of the node image. PROVENANCE: PROVEN offset and the listed bit extents (read from the load/store/bic/orr sequence of the named vendor function, hi3516cv300 Xiongmai module); INFERRED that a function name describes the content; UNKNOWN field meaning. Written by: VPSS_HAL_SetMadAddr. NOTE (2026-11-12): dynamic harness run (qemu, ko-harness, 9 argument patterns): written by VPSS_HAL_SetMadAddr.";
        field {
            name = "word";
            desc = "32-bit word (layout see the register description).";
            sw = rw;
            hw = r;
        } word[31:0];
    } NODE_W_0E8 @ 0xE8;

    reg {
        name = "Node word at offset 0x100";
        desc = "Word 0x100 of the node image. PROVENANCE: PROVEN offset and the listed bit extents (read from the load/store/bic/orr sequence of the named vendor function, hi3516cv300 Xiongmai module); INFERRED that a function name describes the content; UNKNOWN field meaning. Written by: VPSS_HAL_SetCurPicAddr. NOTE (2026-11-12): dynamic harness run (qemu, ko-harness, 9 argument patterns): written by VPSS_HAL_SetCurPicAddr.";
        field {
            name = "word";
            desc = "32-bit word (layout see the register description).";
            sw = rw;
            hw = r;
        } word[31:0];
    } NODE_W_100 @ 0x100;

    reg {
        name = "Node word at offset 0x104";
        desc = "Word 0x104 of the node image. PROVENANCE: PROVEN offset and the listed bit extents (read from the load/store/bic/orr sequence of the named vendor function, hi3516cv300 Xiongmai module); INFERRED that a function name describes the content; UNKNOWN field meaning. Written by: VPSS_HAL_SetCurPicAddr. NOTE (2026-11-12): dynamic harness run (qemu, ko-harness, 9 argument patterns): written by VPSS_HAL_SetCurPicAddr.";
        field {
            name = "word";
            desc = "32-bit word (layout see the register description).";
            sw = rw;
            hw = r;
        } word[31:0];
    } NODE_W_104 @ 0x104;

    reg {
        name = "Node word at offset 0x108";
        desc = "Word 0x108 of the node image. PROVENANCE: PROVEN offset and the listed bit extents (read from the load/store/bic/orr sequence of the named vendor function, hi3516cv300 Xiongmai module); INFERRED that a function name describes the content; UNKNOWN field meaning. Written by: VPSS_HAL_SetCurPicAddr. NOTE (2026-11-12): dynamic harness run (qemu, ko-harness, 9 argument patterns): written by VPSS_HAL_SetCurPicAddr.";
        field {
            name = "word";
            desc = "32-bit word (layout see the register description).";
            sw = rw;
            hw = r;
        } word[31:0];
    } NODE_W_108 @ 0x108;

    reg {
        name = "Node word at offset 0x10C";
        desc = "Word 0x10C of the node image. PROVENANCE: PROVEN offset and the listed bit extents (read from the load/store/bic/orr sequence of the named vendor function, hi3516cv300 Xiongmai module); INFERRED that a function name describes the content; UNKNOWN field meaning. Written by: VPSS_HAL_SetCurPicAddr. NOTE (2026-11-12): dynamic harness run (qemu, ko-harness, 9 argument patterns): written by VPSS_HAL_SetCurPicAddr.";
        field {
            name = "word";
            desc = "32-bit word (layout see the register description).";
            sw = rw;
            hw = r;
        } word[31:0];
    } NODE_W_10C @ 0x10C;

    reg {
        name = "Node word at offset 0x110";
        desc = "Word 0x110 of the node image. PROVENANCE: PROVEN offset and the listed bit extents (read from the load/store/bic/orr sequence of the named vendor function, hi3516cv300 Xiongmai module); INFERRED that a function name describes the content; UNKNOWN field meaning. Written by: VPSS_HAL_SetCurPicAddr. NOTE (2026-11-12): dynamic harness run (qemu, ko-harness, 9 argument patterns): written by VPSS_HAL_SetCurPicAddr.";
        field {
            name = "word";
            desc = "32-bit word (layout see the register description).";
            sw = rw;
            hw = r;
        } word[31:0];
    } NODE_W_110 @ 0x110;

    reg {
        name = "Node word at offset 0x114";
        desc = "Word 0x114 of the node image. PROVENANCE: PROVEN offset and the listed bit extents (read from the load/store/bic/orr sequence of the named vendor function, hi3516cv300 Xiongmai module); INFERRED that a function name describes the content; UNKNOWN field meaning. Written by: VPSS_HAL_SetCurPicAddr. NOTE (2026-11-12): dynamic harness run (qemu, ko-harness, 9 argument patterns): written by VPSS_HAL_SetCurPicAddr.";
        field {
            name = "word";
            desc = "32-bit word (layout see the register description).";
            sw = rw;
            hw = r;
        } word[31:0];
    } NODE_W_114 @ 0x114;

    reg {
        name = "Node word at offset 0x118";
        desc = "Word 0x118 of the node image. PROVENANCE: PROVEN offset and the listed bit extents (read from the load/store/bic/orr sequence of the named vendor function, hi3516cv300 Xiongmai module); INFERRED that a function name describes the content; UNKNOWN field meaning. Written by: VPSS_HAL_SetRefDcmp; VPSS_HAL_SetRef modifies bits [30:0] (inserts a value at shift 2, 3, 4, 5, 18). NOTE (2026-11-12): dynamic harness run (qemu, ko-harness, 9 argument patterns): written by VPSS_HAL_SetRef, VPSS_HAL_SetRefDcmp.";
        field {
            name = "word";
            desc = "32-bit word (layout see the register description).";
            sw = rw;
            hw = r;
        } word[31:0];
    } NODE_W_118 @ 0x118;

    reg {
        name = "Node word at offset 0x11C";
        desc = "Word 0x11C of the node image. PROVENANCE: PROVEN offset and the listed bit extents (read from the load/store/bic/orr sequence of the named vendor function, hi3516cv300 Xiongmai module); INFERRED that a function name describes the content; UNKNOWN field meaning. Written by: VPSS_HAL_SetRef. NOTE (2026-11-12): dynamic harness run (qemu, ko-harness, 9 argument patterns): written by VPSS_HAL_SetRef.";
        field {
            name = "word";
            desc = "32-bit word (layout see the register description).";
            sw = rw;
            hw = r;
        } word[31:0];
    } NODE_W_11C @ 0x11C;

    reg {
        name = "Node word at offset 0x120";
        desc = "Word 0x120 of the node image. PROVENANCE: PROVEN offset and the listed bit extents (read from the load/store/bic/orr sequence of the named vendor function, hi3516cv300 Xiongmai module); INFERRED that a function name describes the content; UNKNOWN field meaning. Written by: VPSS_HAL_SetRef. NOTE (2026-11-12): dynamic harness run (qemu, ko-harness, 9 argument patterns): written by VPSS_HAL_SetRef.";
        field {
            name = "word";
            desc = "32-bit word (layout see the register description).";
            sw = rw;
            hw = r;
        } word[31:0];
    } NODE_W_120 @ 0x120;

    reg {
        name = "Node word at offset 0x124";
        desc = "Word 0x124 of the node image. PROVENANCE: PROVEN offset and the listed bit extents (read from the load/store/bic/orr sequence of the named vendor function, hi3516cv300 Xiongmai module); INFERRED that a function name describes the content; UNKNOWN field meaning. Written by: VPSS_HAL_SetRef. NOTE (2026-11-12): dynamic harness run (qemu, ko-harness, 9 argument patterns): written by VPSS_HAL_SetRef.";
        field {
            name = "word";
            desc = "32-bit word (layout see the register description).";
            sw = rw;
            hw = r;
        } word[31:0];
    } NODE_W_124 @ 0x124;

    reg {
        name = "Node word at offset 0x128";
        desc = "Word 0x128 of the node image. PROVENANCE: PROVEN offset and the listed bit extents (read from the load/store/bic/orr sequence of the named vendor function, hi3516cv300 Xiongmai module); INFERRED that a function name describes the content; UNKNOWN field meaning. Written by: VPSS_HAL_SetRef. NOTE (2026-11-12): dynamic harness run (qemu, ko-harness, 9 argument patterns): written by VPSS_HAL_SetRef.";
        field {
            name = "word";
            desc = "32-bit word (layout see the register description).";
            sw = rw;
            hw = r;
        } word[31:0];
    } NODE_W_128 @ 0x128;

    reg {
        name = "Node word at offset 0x12C";
        desc = "Word 0x12C of the node image. PROVENANCE: PROVEN offset and the listed bit extents (read from the load/store/bic/orr sequence of the named vendor function, hi3516cv300 Xiongmai module); INFERRED that a function name describes the content; UNKNOWN field meaning. Written by: VPSS_HAL_SetRef. NOTE (2026-11-12): dynamic harness run (qemu, ko-harness, 9 argument patterns): written by VPSS_HAL_SetRef.";
        field {
            name = "word";
            desc = "32-bit word (layout see the register description).";
            sw = rw;
            hw = r;
        } word[31:0];
    } NODE_W_12C @ 0x12C;

    reg {
        name = "Node word at offset 0x144";
        desc = "Word 0x144 of the node image. PROVENANCE: PROVEN offset and the listed bit extents (read from the load/store/bic/orr sequence of the named vendor function, hi3516cv300 Xiongmai module); INFERRED that a function name describes the content; UNKNOWN field meaning. Written by: VPSS_HAL_SetChnCtrl modifies bits [5:0].";
        field {
            name = "word";
            desc = "32-bit word (layout see the register description).";
            sw = rw;
            hw = r;
        } word[31:0];
    } NODE_W_144 @ 0x144;

    reg {
        name = "Node word at offset 0x148";
        desc = "Word 0x148 of the node image. PROVENANCE: PROVEN offset and the listed bit extents (read from the load/store/bic/orr sequence of the named vendor function, hi3516cv300 Xiongmai module); INFERRED that a function name describes the content; UNKNOWN field meaning. Written by: VPSS_HAL_SetChnPicAddr.";
        field {
            name = "word";
            desc = "32-bit word (layout see the register description).";
            sw = rw;
            hw = r;
        } word[31:0];
    } NODE_W_148 @ 0x148;

    reg {
        name = "Node word at offset 0x14C";
        desc = "Word 0x14C of the node image. PROVENANCE: PROVEN offset and the listed bit extents (read from the load/store/bic/orr sequence of the named vendor function, hi3516cv300 Xiongmai module); INFERRED that a function name describes the content; UNKNOWN field meaning. Written by: VPSS_HAL_SetChnPicAddr.";
        field {
            name = "word";
            desc = "32-bit word (layout see the register description).";
            sw = rw;
            hw = r;
        } word[31:0];
    } NODE_W_14C @ 0x14C;

    reg {
        name = "Node word at offset 0x150";
        desc = "Word 0x150 of the node image. PROVENANCE: PROVEN offset and the listed bit extents (read from the load/store/bic/orr sequence of the named vendor function, hi3516cv300 Xiongmai module); INFERRED that a function name describes the content; UNKNOWN field meaning. Written by: VPSS_HAL_SetChnPicAddr.";
        field {
            name = "word";
            desc = "32-bit word (layout see the register description).";
            sw = rw;
            hw = r;
        } word[31:0];
    } NODE_W_150 @ 0x150;

    reg {
        name = "Node word at offset 0x154";
        desc = "Word 0x154 of the node image. PROVENANCE: PROVEN offset and the listed bit extents (read from the load/store/bic/orr sequence of the named vendor function, hi3516cv300 Xiongmai module); INFERRED that a function name describes the content; UNKNOWN field meaning. Written by: VPSS_HAL_SetChnPicAddr.";
        field {
            name = "word";
            desc = "32-bit word (layout see the register description).";
            sw = rw;
            hw = r;
        } word[31:0];
    } NODE_W_154 @ 0x154;

    reg {
        name = "Node word at offset 0x158";
        desc = "Word 0x158 of the node image. PROVENANCE: PROVEN offset and the listed bit extents (read from the load/store/bic/orr sequence of the named vendor function, hi3516cv300 Xiongmai module); INFERRED that a function name describes the content; UNKNOWN field meaning. Written by: VPSS_HAL_SetChnPicAddr.";
        field {
            name = "word";
            desc = "32-bit word (layout see the register description).";
            sw = rw;
            hw = r;
        } word[31:0];
    } NODE_W_158 @ 0x158;

    reg {
        name = "Node word at offset 0x15C";
        desc = "Word 0x15C of the node image. PROVENANCE: PROVEN offset and the listed bit extents (read from the load/store/bic/orr sequence of the named vendor function, hi3516cv300 Xiongmai module); INFERRED that a function name describes the content; UNKNOWN field meaning. Written by: VPSS_HAL_SetChnCtrl modifies bits [5:0].";
        field {
            name = "word";
            desc = "32-bit word (layout see the register description).";
            sw = rw;
            hw = r;
        } word[31:0];
    } NODE_W_15C @ 0x15C;

    reg {
        name = "Node word at offset 0x160";
        desc = "Word 0x160 of the node image. PROVENANCE: PROVEN offset and the listed bit extents (read from the load/store/bic/orr sequence of the named vendor function, hi3516cv300 Xiongmai module); INFERRED that a function name describes the content; UNKNOWN field meaning. Written by: VPSS_HAL_SetChnPicAddr.";
        field {
            name = "word";
            desc = "32-bit word (layout see the register description).";
            sw = rw;
            hw = r;
        } word[31:0];
    } NODE_W_160 @ 0x160;

    reg {
        name = "Node word at offset 0x164";
        desc = "Word 0x164 of the node image. PROVENANCE: PROVEN offset and the listed bit extents (read from the load/store/bic/orr sequence of the named vendor function, hi3516cv300 Xiongmai module); INFERRED that a function name describes the content; UNKNOWN field meaning. Written by: VPSS_HAL_SetChnPicAddr.";
        field {
            name = "word";
            desc = "32-bit word (layout see the register description).";
            sw = rw;
            hw = r;
        } word[31:0];
    } NODE_W_164 @ 0x164;

    reg {
        name = "Node word at offset 0x168";
        desc = "Word 0x168 of the node image. PROVENANCE: PROVEN offset and the listed bit extents (read from the load/store/bic/orr sequence of the named vendor function, hi3516cv300 Xiongmai module); INFERRED that a function name describes the content; UNKNOWN field meaning. Written by: VPSS_HAL_SetChnPicAddr.";
        field {
            name = "word";
            desc = "32-bit word (layout see the register description).";
            sw = rw;
            hw = r;
        } word[31:0];
    } NODE_W_168 @ 0x168;

    reg {
        name = "Node word at offset 0x16C";
        desc = "Word 0x16C of the node image. PROVENANCE: PROVEN offset and the listed bit extents (read from the load/store/bic/orr sequence of the named vendor function, hi3516cv300 Xiongmai module); INFERRED that a function name describes the content; UNKNOWN field meaning. Written by: VPSS_HAL_SetChnPicAddr.";
        field {
            name = "word";
            desc = "32-bit word (layout see the register description).";
            sw = rw;
            hw = r;
        } word[31:0];
    } NODE_W_16C @ 0x16C;

    reg {
        name = "Node word at offset 0x170";
        desc = "Word 0x170 of the node image. PROVENANCE: PROVEN offset and the listed bit extents (read from the load/store/bic/orr sequence of the named vendor function, hi3516cv300 Xiongmai module); INFERRED that a function name describes the content; UNKNOWN field meaning. Written by: VPSS_HAL_SetChnPicAddr.";
        field {
            name = "word";
            desc = "32-bit word (layout see the register description).";
            sw = rw;
            hw = r;
        } word[31:0];
    } NODE_W_170 @ 0x170;

    reg {
        name = "Node word at offset 0x18C";
        desc = "Word 0x18C of the node image. PROVENANCE: PROVEN offset and the listed bit extents (read from the load/store/bic/orr sequence of the named vendor function, hi3516cv300 Xiongmai module); INFERRED that a function name describes the content; UNKNOWN field meaning. Written by: VPSS_HAL_SetChnCtrl modifies bits [5:0].";
        field {
            name = "word";
            desc = "32-bit word (layout see the register description).";
            sw = rw;
            hw = r;
        } word[31:0];
    } NODE_W_18C @ 0x18C;

    reg {
        name = "Node word at offset 0x190";
        desc = "Word 0x190 of the node image. PROVENANCE: PROVEN offset and the listed bit extents (read from the load/store/bic/orr sequence of the named vendor function, hi3516cv300 Xiongmai module); INFERRED that a function name describes the content; UNKNOWN field meaning. Written by: VPSS_HAL_SetChnPicAddr.";
        field {
            name = "word";
            desc = "32-bit word (layout see the register description).";
            sw = rw;
            hw = r;
        } word[31:0];
    } NODE_W_190 @ 0x190;

    reg {
        name = "Node word at offset 0x194";
        desc = "Word 0x194 of the node image. PROVENANCE: PROVEN offset and the listed bit extents (read from the load/store/bic/orr sequence of the named vendor function, hi3516cv300 Xiongmai module); INFERRED that a function name describes the content; UNKNOWN field meaning. Written by: VPSS_HAL_SetChnPicAddr.";
        field {
            name = "word";
            desc = "32-bit word (layout see the register description).";
            sw = rw;
            hw = r;
        } word[31:0];
    } NODE_W_194 @ 0x194;

    reg {
        name = "Node word at offset 0x198";
        desc = "Word 0x198 of the node image. PROVENANCE: PROVEN offset and the listed bit extents (read from the load/store/bic/orr sequence of the named vendor function, hi3516cv300 Xiongmai module); INFERRED that a function name describes the content; UNKNOWN field meaning. Written by: VPSS_HAL_SetChnPicAddr.";
        field {
            name = "word";
            desc = "32-bit word (layout see the register description).";
            sw = rw;
            hw = r;
        } word[31:0];
    } NODE_W_198 @ 0x198;

    reg {
        name = "Node word at offset 0x19C";
        desc = "Word 0x19C of the node image. PROVENANCE: PROVEN offset and the listed bit extents (read from the load/store/bic/orr sequence of the named vendor function, hi3516cv300 Xiongmai module); INFERRED that a function name describes the content; UNKNOWN field meaning. Written by: VPSS_HAL_SetChnPicAddr.";
        field {
            name = "word";
            desc = "32-bit word (layout see the register description).";
            sw = rw;
            hw = r;
        } word[31:0];
    } NODE_W_19C @ 0x19C;

    reg {
        name = "Node word at offset 0x1A0";
        desc = "Word 0x1A0 of the node image. PROVENANCE: PROVEN offset and the listed bit extents (read from the load/store/bic/orr sequence of the named vendor function, hi3516cv300 Xiongmai module); INFERRED that a function name describes the content; UNKNOWN field meaning. Written by: VPSS_HAL_SetChnPicAddr.";
        field {
            name = "word";
            desc = "32-bit word (layout see the register description).";
            sw = rw;
            hw = r;
        } word[31:0];
    } NODE_W_1A0 @ 0x1A0;

    reg {
        name = "Node word at offset 0x1A8";
        desc = "Word 0x1A8 of the node image. PROVENANCE: PROVEN offset and the listed bit extents (read from the load/store/bic/orr sequence of the named vendor function, hi3516cv300 Xiongmai module); INFERRED that a function name describes the content; UNKNOWN field meaning. Written by: VPSS_HAL_SetRfrPicAddr. NOTE (2026-11-12): dynamic harness run (qemu, ko-harness, 9 argument patterns): written by VPSS_HAL_SetRfrPicAddr.";
        field {
            name = "word";
            desc = "32-bit word (layout see the register description).";
            sw = rw;
            hw = r;
        } word[31:0];
    } NODE_W_1A8 @ 0x1A8;

    reg {
        name = "Node word at offset 0x1AC";
        desc = "Word 0x1AC of the node image. PROVENANCE: PROVEN offset and the listed bit extents (read from the load/store/bic/orr sequence of the named vendor function, hi3516cv300 Xiongmai module); INFERRED that a function name describes the content; UNKNOWN field meaning. Written by: VPSS_HAL_SetRfrPicAddr. NOTE (2026-11-12): dynamic harness run (qemu, ko-harness, 9 argument patterns): written by VPSS_HAL_SetRfrPicAddr.";
        field {
            name = "word";
            desc = "32-bit word (layout see the register description).";
            sw = rw;
            hw = r;
        } word[31:0];
    } NODE_W_1AC @ 0x1AC;

    reg {
        name = "Node word at offset 0x1B0";
        desc = "Word 0x1B0 of the node image. PROVENANCE: PROVEN offset and the listed bit extents (read from the load/store/bic/orr sequence of the named vendor function, hi3516cv300 Xiongmai module); INFERRED that a function name describes the content; UNKNOWN field meaning. Written by: VPSS_HAL_SetRfrPicAddr. NOTE (2026-11-12): dynamic harness run (qemu, ko-harness, 9 argument patterns): written by VPSS_HAL_SetRfrPicAddr.";
        field {
            name = "word";
            desc = "32-bit word (layout see the register description).";
            sw = rw;
            hw = r;
        } word[31:0];
    } NODE_W_1B0 @ 0x1B0;

    reg {
        name = "Node word at offset 0x1B4";
        desc = "Word 0x1B4 of the node image. PROVENANCE: PROVEN offset and the listed bit extents (read from the load/store/bic/orr sequence of the named vendor function, hi3516cv300 Xiongmai module); INFERRED that a function name describes the content; UNKNOWN field meaning. Written by: VPSS_HAL_SetRfrPicAddr. NOTE (2026-11-12): dynamic harness run (qemu, ko-harness, 9 argument patterns): written by VPSS_HAL_SetRfrPicAddr.";
        field {
            name = "word";
            desc = "32-bit word (layout see the register description).";
            sw = rw;
            hw = r;
        } word[31:0];
    } NODE_W_1B4 @ 0x1B4;

    reg {
        name = "Node word at offset 0x1B8";
        desc = "Word 0x1B8 of the node image. PROVENANCE: PROVEN offset and the listed bit extents (read from the load/store/bic/orr sequence of the named vendor function, hi3516cv300 Xiongmai module); INFERRED that a function name describes the content; UNKNOWN field meaning. Written by: VPSS_HAL_SetRfrPicAddr. NOTE (2026-11-12): dynamic harness run (qemu, ko-harness, 9 argument patterns): written by VPSS_HAL_SetRfrPicAddr.";
        field {
            name = "word";
            desc = "32-bit word (layout see the register description).";
            sw = rw;
            hw = r;
        } word[31:0];
    } NODE_W_1B8 @ 0x1B8;

    reg {
        name = "Node word at offset 0x1C8";
        desc = "Word 0x1C8 of the node image. PROVENANCE: PROVEN offset and the listed bit extents (read from the load/store/bic/orr sequence of the named vendor function, hi3516cv300 Xiongmai module); INFERRED that a function name describes the content; UNKNOWN field meaning. Written by: VPSS_HAL_SetLowDelayAddr. NOTE (2026-11-12): dynamic harness run (qemu, ko-harness, 9 argument patterns): written by VPSS_HAL_SetLowDelayAddr.";
        field {
            name = "word";
            desc = "32-bit word (layout see the register description).";
            sw = rw;
            hw = r;
        } word[31:0];
    } NODE_W_1C8 @ 0x1C8;

    reg {
        name = "Node word at offset 0x1CC";
        desc = "Word 0x1CC of the node image. PROVENANCE: PROVEN offset and the listed bit extents (read from the load/store/bic/orr sequence of the named vendor function, hi3516cv300 Xiongmai module); INFERRED that a function name describes the content; UNKNOWN field meaning. Written by: VPSS_HAL_SetLowDelayAddr. NOTE (2026-11-12): dynamic harness run (qemu, ko-harness, 9 argument patterns): written by VPSS_HAL_SetLowDelayAddr.";
        field {
            name = "word";
            desc = "32-bit word (layout see the register description).";
            sw = rw;
            hw = r;
        } word[31:0];
    } NODE_W_1CC @ 0x1CC;

    reg {
        name = "Node word at offset 0x1D0";
        desc = "Word 0x1D0 of the node image. PROVENANCE: PROVEN offset and the listed bit extents (read from the load/store/bic/orr sequence of the named vendor function, hi3516cv300 Xiongmai module); INFERRED that a function name describes the content; UNKNOWN field meaning. Written by: VPSS_HAL_SetLowDelayAddr.";
        field {
            name = "word";
            desc = "32-bit word (layout see the register description).";
            sw = rw;
            hw = r;
        } word[31:0];
    } NODE_W_1D0 @ 0x1D0;

    reg {
        name = "Node word at offset 0x1D4";
        desc = "Word 0x1D4 of the node image. PROVENANCE: PROVEN offset and the listed bit extents (read from the load/store/bic/orr sequence of the named vendor function, hi3516cv300 Xiongmai module); INFERRED that a function name describes the content; UNKNOWN field meaning. Written by: VPSS_HAL_SetRefDcmp modifies bits [6:5] (inserts a value at shift 5, 6); VPSS_HAL_SetRef modifies bits [6:5]. NOTE (2026-11-12): dynamic harness run (qemu, ko-harness, 9 argument patterns): written by VPSS_HAL_SetRefDcmp.";
        field {
            name = "word";
            desc = "32-bit word (layout see the register description).";
            sw = rw;
            hw = r;
        } word[31:0];
    } NODE_W_1D4 @ 0x1D4;

    reg {
        name = "Node word at offset 0x1D8";
        desc = "Word 0x1D8 of the node image. PROVENANCE: PROVEN offset and the listed bit extents (read from the load/store/bic/orr sequence of the named vendor function, hi3516cv300 Xiongmai module); INFERRED that a function name describes the content; UNKNOWN field meaning. Written by: VPSS_HAL_SetLcmpLoadAddr. NOTE (2026-11-12): dynamic harness run (qemu, ko-harness, 9 argument patterns): written by VPSS_HAL_SetLcmpLoadAddr.";
        field {
            name = "word";
            desc = "32-bit word (layout see the register description).";
            sw = rw;
            hw = r;
        } word[31:0];
    } NODE_W_1D8 @ 0x1D8;

    reg {
        name = "Node word at offset 0x1F4";
        desc = "Word 0x1F4 of the node image. PROVENANCE: PROVEN offset and the listed bit extents (read from the load/store/bic/orr sequence of the named vendor function, hi3516cv300 Xiongmai module); INFERRED that a function name describes the content; UNKNOWN field meaning. Written by: VPSS_HAL_SetNodeID. NOTE (2026-11-12): dynamic harness run (qemu, ko-harness, 9 argument patterns): written by VPSS_HAL_SetNodeID.";
        field {
            name = "word";
            desc = "32-bit word (layout see the register description).";
            sw = rw;
            hw = r;
        } word[31:0];
    } NODE_W_1F4 @ 0x1F4;

    reg {
        name = "Node word at offset 0x1FC";
        desc = "Word 0x1FC of the node image. PROVENANCE: PROVEN offset and the listed bit extents (read from the load/store/bic/orr sequence of the named vendor function, hi3516cv300 Xiongmai module); INFERRED that a function name describes the content; UNKNOWN field meaning. Written by: VPSS_HAL_SetMask. NOTE (2026-11-12): dynamic harness run (qemu, ko-harness, 9 argument patterns): written by VPSS_HAL_SetMask.";
        field {
            name = "word";
            desc = "32-bit word (layout see the register description).";
            sw = rw;
            hw = r;
        } word[31:0];
    } NODE_W_1FC @ 0x1FC;

    reg {
        name = "Node word at offset 0x200";
        desc = "Word 0x200 of the node image. PROVENANCE: PROVEN offset and the listed bit extents (read from the load/store/bic/orr sequence of the named vendor function, hi3516cv300 Xiongmai module); INFERRED that a function name describes the content; UNKNOWN field meaning. Written by: VPSS_HAL_SetSharpenCtrl.";
        field {
            name = "word";
            desc = "32-bit word (layout see the register description).";
            sw = rw;
            hw = r;
        } word[31:0];
    } NODE_W_200 @ 0x200;

    reg {
        name = "Word at offset 0x204";
        desc = "Word 0x204 (NEW in the arm-re rediff 2026-11-12). PROVENANCE: PROVEN offset and stored byte lanes 0123, cleared bit extents none seen, written by VPSS_HAL_SetChnSclCoeff (1 stores) in the path-sensitive static run (conditional paths and indexed loop records folded into the word; some are loop-built or conditional and not individually proven). Meaning UNKNOWN.";
        field {
            name = "word";
            desc = "32-bit word.";
            sw = rw;
            hw = r;
        } word[31:0];
    } NODE_W_204 @ 0x204;
    reg {
        name = "Word at offset 0x208";
        desc = "Word 0x208 (NEW in the arm-re rediff 2026-11-12). PROVENANCE: PROVEN offset and stored byte lanes 0123, cleared bit extents none seen, written by VPSS_HAL_SetChnSclCoeff (1 stores) in the path-sensitive static run (conditional paths and indexed loop records folded into the word; some are loop-built or conditional and not individually proven). Meaning UNKNOWN.";
        field {
            name = "word";
            desc = "32-bit word.";
            sw = rw;
            hw = r;
        } word[31:0];
    } NODE_W_208 @ 0x208;
    reg {
        name = "Word at offset 0x20C";
        desc = "Word 0x20C (NEW in the arm-re rediff 2026-11-12). PROVENANCE: PROVEN offset and stored byte lanes 0123, cleared bit extents none seen, written by VPSS_HAL_SetChnSclCoeff (1 stores) in the path-sensitive static run (conditional paths and indexed loop records folded into the word; some are loop-built or conditional and not individually proven). Meaning UNKNOWN.";
        field {
            name = "word";
            desc = "32-bit word.";
            sw = rw;
            hw = r;
        } word[31:0];
    } NODE_W_20C @ 0x20C;
    reg {
        name = "Node word at offset 0x210";
        desc = "Word 0x210 of the node image. PROVENANCE: PROVEN offset and the listed bit extents (read from the load/store/bic/orr sequence of the named vendor function, hi3516cv300 Xiongmai module); INFERRED that a function name describes the content; UNKNOWN field meaning. Written by: VPSS_HAL_SetSharpenCoef.";
        field {
            name = "word";
            desc = "32-bit word (layout see the register description).";
            sw = rw;
            hw = r;
        } word[31:0];
    } NODE_W_210 @ 0x210;

    reg {
        name = "Node word at offset 0x214";
        desc = "Word 0x214 of the node image. PROVENANCE: PROVEN offset and the listed bit extents (read from the load/store/bic/orr sequence of the named vendor function, hi3516cv300 Xiongmai module); INFERRED that a function name describes the content; UNKNOWN field meaning. Written by: VPSS_HAL_SetSharpenCoef.";
        field {
            name = "word";
            desc = "32-bit word (layout see the register description).";
            sw = rw;
            hw = r;
        } word[31:0];
    } NODE_W_214 @ 0x214;

    reg {
        name = "Node word at offset 0x218";
        desc = "Word 0x218 of the node image. PROVENANCE: PROVEN offset and the listed bit extents (read from the load/store/bic/orr sequence of the named vendor function, hi3516cv300 Xiongmai module); INFERRED that a function name describes the content; UNKNOWN field meaning. Written by: VPSS_HAL_SetSharpenCoef.";
        field {
            name = "word";
            desc = "32-bit word (layout see the register description).";
            sw = rw;
            hw = r;
        } word[31:0];
    } NODE_W_218 @ 0x218;

    reg {
        name = "Node word at offset 0x21C";
        desc = "Word 0x21C of the node image. PROVENANCE: PROVEN offset and the listed bit extents (read from the load/store/bic/orr sequence of the named vendor function, hi3516cv300 Xiongmai module); INFERRED that a function name describes the content; UNKNOWN field meaning. Written by: VPSS_HAL_SetSharpenCoef.";
        field {
            name = "word";
            desc = "32-bit word (layout see the register description).";
            sw = rw;
            hw = r;
        } word[31:0];
    } NODE_W_21C @ 0x21C;

    reg {
        name = "Node word at offset 0x220";
        desc = "Word 0x220 of the node image. PROVENANCE: PROVEN offset and the listed bit extents (read from the load/store/bic/orr sequence of the named vendor function, hi3516cv300 Xiongmai module); INFERRED that a function name describes the content; UNKNOWN field meaning. Written by: VPSS_HAL_SetSharpenCoef. NOTE (2026-11-12): not produced by VPSS_HAL_Set* (source unknown): the path-sensitive static run of the setters does not write this word (carried over from the earlier linear scan).";
        field {
            name = "word";
            desc = "32-bit word (layout see the register description).";
            sw = rw;
            hw = r;
        } word[31:0];
    } NODE_W_220 @ 0x220;

    reg {
        name = "Node word at offset 0x224";
        desc = "Word 0x224 of the node image. PROVENANCE: PROVEN offset and the listed bit extents (read from the load/store/bic/orr sequence of the named vendor function, hi3516cv300 Xiongmai module); INFERRED that a function name describes the content; UNKNOWN field meaning. Written by: VPSS_HAL_SetSharpenCoef. NOTE (2026-11-12): not produced by VPSS_HAL_Set* (source unknown): the path-sensitive static run of the setters does not write this word (carried over from the earlier linear scan).";
        field {
            name = "word";
            desc = "32-bit word (layout see the register description).";
            sw = rw;
            hw = r;
        } word[31:0];
    } NODE_W_224 @ 0x224;

    reg {
        name = "Node word at offset 0x228";
        desc = "Word 0x228 of the node image. PROVENANCE: PROVEN offset and the listed bit extents (read from the load/store/bic/orr sequence of the named vendor function, hi3516cv300 Xiongmai module); INFERRED that a function name describes the content; UNKNOWN field meaning. Written by: VPSS_HAL_SetSharpenCoef. NOTE (2026-11-12): not produced by VPSS_HAL_Set* (source unknown): the path-sensitive static run of the setters does not write this word (carried over from the earlier linear scan).";
        field {
            name = "word";
            desc = "32-bit word (layout see the register description).";
            sw = rw;
            hw = r;
        } word[31:0];
    } NODE_W_228 @ 0x228;

    reg {
        name = "Node word at offset 0x22C";
        desc = "Word 0x22C of the node image. PROVENANCE: PROVEN offset and the listed bit extents (read from the load/store/bic/orr sequence of the named vendor function, hi3516cv300 Xiongmai module); INFERRED that a function name describes the content; UNKNOWN field meaning. Written by: VPSS_HAL_SetSharpenCoef. NOTE (2026-11-12): not produced by VPSS_HAL_Set* (source unknown): the path-sensitive static run of the setters does not write this word (carried over from the earlier linear scan).";
        field {
            name = "word";
            desc = "32-bit word (layout see the register description).";
            sw = rw;
            hw = r;
        } word[31:0];
    } NODE_W_22C @ 0x22C;

    reg {
        name = "Node word at offset 0x230";
        desc = "Word 0x230 of the node image. PROVENANCE: PROVEN offset and the listed bit extents (read from the load/store/bic/orr sequence of the named vendor function, hi3516cv300 Xiongmai module); INFERRED that a function name describes the content; UNKNOWN field meaning. Written by: VPSS_HAL_SetSharpenCoef.";
        field {
            name = "word";
            desc = "32-bit word (layout see the register description).";
            sw = rw;
            hw = r;
        } word[31:0];
    } NODE_W_230 @ 0x230;

    reg {
        name = "Node word at offset 0x234";
        desc = "Word 0x234 of the node image. PROVENANCE: PROVEN offset and the listed bit extents (read from the load/store/bic/orr sequence of the named vendor function, hi3516cv300 Xiongmai module); INFERRED that a function name describes the content; UNKNOWN field meaning. Written by: VPSS_HAL_SetSharpenCoef.";
        field {
            name = "word";
            desc = "32-bit word (layout see the register description).";
            sw = rw;
            hw = r;
        } word[31:0];
    } NODE_W_234 @ 0x234;

    reg {
        name = "Node word at offset 0x238";
        desc = "Word 0x238 of the node image. PROVENANCE: PROVEN offset and the listed bit extents (read from the load/store/bic/orr sequence of the named vendor function, hi3516cv300 Xiongmai module); INFERRED that a function name describes the content; UNKNOWN field meaning. Written by: VPSS_HAL_SetSharpenCoef.";
        field {
            name = "word";
            desc = "32-bit word (layout see the register description).";
            sw = rw;
            hw = r;
        } word[31:0];
    } NODE_W_238 @ 0x238;

    reg {
        name = "Node word at offset 0x23C";
        desc = "Word 0x23C of the node image. PROVENANCE: PROVEN offset and the listed bit extents (read from the load/store/bic/orr sequence of the named vendor function, hi3516cv300 Xiongmai module); INFERRED that a function name describes the content; UNKNOWN field meaning. Written by: VPSS_HAL_SetSharpenCoef.";
        field {
            name = "word";
            desc = "32-bit word (layout see the register description).";
            sw = rw;
            hw = r;
        } word[31:0];
    } NODE_W_23C @ 0x23C;

    reg {
        name = "Node word at offset 0x240";
        desc = "Word 0x240 of the node image. PROVENANCE: PROVEN offset and the listed bit extents (read from the load/store/bic/orr sequence of the named vendor function, hi3516cv300 Xiongmai module); INFERRED that a function name describes the content; UNKNOWN field meaning. Written by: VPSS_HAL_SetZmeLoadAddr; VPSS_HAL_SetSharpenCoef. NOTE (2026-11-12): dynamic harness run (qemu, ko-harness, 9 argument patterns): written by VPSS_HAL_SetZmeLoadAddr.";
        field {
            name = "word";
            desc = "32-bit word (layout see the register description).";
            sw = rw;
            hw = r;
        } word[31:0];
    } NODE_W_240 @ 0x240;

    reg {
        name = "Node word at offset 0x244";
        desc = "Word 0x244 of the node image. PROVENANCE: PROVEN offset and the listed bit extents (read from the load/store/bic/orr sequence of the named vendor function, hi3516cv300 Xiongmai module); INFERRED that a function name describes the content; UNKNOWN field meaning. Written by: VPSS_HAL_SetShbdLoadAddr; VPSS_HAL_SetSharpenCoef modifies bits [4:1] [12:8] (inserts a value at shift 1, 2, 3, 4, 8). NOTE (2026-11-12): dynamic harness run (qemu, ko-harness, 9 argument patterns): written by VPSS_HAL_SetShbdLoadAddr.";
        field {
            name = "word";
            desc = "32-bit word (layout see the register description).";
            sw = rw;
            hw = r;
        } word[31:0];
    } NODE_W_244 @ 0x244;

    reg {
        name = "Node word at offset 0x248";
        desc = "Word 0x248 of the node image. PROVENANCE: PROVEN offset and the listed bit extents (read from the load/store/bic/orr sequence of the named vendor function, hi3516cv300 Xiongmai module); INFERRED that a function name describes the content; UNKNOWN field meaning. Written by: VPSS_HAL_SetNrLoadAddr; VPSS_HAL_SetSharpenCoef. NOTE (2026-11-12): dynamic harness run (qemu, ko-harness, 9 argument patterns): written by VPSS_HAL_SetNrLoadAddr.";
        field {
            name = "word";
            desc = "32-bit word (layout see the register description).";
            sw = rw;
            hw = r;
        } word[31:0];
    } NODE_W_248 @ 0x248;

    reg {
        name = "Node word at offset 0x24C";
        desc = "Word 0x24C of the node image. PROVENANCE: PROVEN offset and the listed bit extents (read from the load/store/bic/orr sequence of the named vendor function, hi3516cv300 Xiongmai module); INFERRED that a function name describes the content; UNKNOWN field meaning. Written by: VPSS_HAL_SetSharpenCoef. NOTE (2026-11-12): not produced by VPSS_HAL_Set* (source unknown): the path-sensitive static run of the setters does not write this word (carried over from the earlier linear scan).";
        field {
            name = "word";
            desc = "32-bit word (layout see the register description).";
            sw = rw;
            hw = r;
        } word[31:0];
    } NODE_W_24C @ 0x24C;

    reg {
        name = "Node word at offset 0x250";
        desc = "Word 0x250 of the node image. PROVENANCE: PROVEN offset and the listed bit extents (read from the load/store/bic/orr sequence of the named vendor function, hi3516cv300 Xiongmai module); INFERRED that a function name describes the content; UNKNOWN field meaning. Written by: VPSS_HAL_SetSharpenCoef. NOTE (2026-11-12): not produced by VPSS_HAL_Set* (source unknown): the path-sensitive static run of the setters does not write this word (carried over from the earlier linear scan).";
        field {
            name = "word";
            desc = "32-bit word (layout see the register description).";
            sw = rw;
            hw = r;
        } word[31:0];
    } NODE_W_250 @ 0x250;

    reg {
        name = "Node word at offset 0x254";
        desc = "Word 0x254 of the node image. PROVENANCE: PROVEN offset and the listed bit extents (read from the load/store/bic/orr sequence of the named vendor function, hi3516cv300 Xiongmai module); INFERRED that a function name describes the content; UNKNOWN field meaning. Written by: VPSS_HAL_SetSharpenLoadAddr; VPSS_HAL_SetSharpenCoef. NOTE (2026-11-12): dynamic harness run (qemu, ko-harness, 9 argument patterns): written by VPSS_HAL_SetSharpenLoadAddr.";
        field {
            name = "word";
            desc = "32-bit word (layout see the register description).";
            sw = rw;
            hw = r;
        } word[31:0];
    } NODE_W_254 @ 0x254;

    reg {
        name = "Node word at offset 0x258";
        desc = "Word 0x258 of the node image. PROVENANCE: PROVEN offset and the listed bit extents (read from the load/store/bic/orr sequence of the named vendor function, hi3516cv300 Xiongmai module); INFERRED that a function name describes the content; UNKNOWN field meaning. Written by: VPSS_HAL_SetMosaicLoadAddr; VPSS_HAL_SetSharpenCoef. NOTE (2026-11-12): dynamic harness run (qemu, ko-harness, 9 argument patterns): written by VPSS_HAL_SetMosaicLoadAddr.";
        field {
            name = "word";
            desc = "32-bit word (layout see the register description).";
            sw = rw;
            hw = r;
        } word[31:0];
    } NODE_W_258 @ 0x258;

    reg {
        name = "Node word at offset 0x25C";
        desc = "Word 0x25C of the node image. PROVENANCE: PROVEN offset and the listed bit extents (read from the load/store/bic/orr sequence of the named vendor function, hi3516cv300 Xiongmai module); INFERRED that a function name describes the content; UNKNOWN field meaning. Written by: VPSS_HAL_SetSharpenCoef. NOTE (2026-11-12): not produced by VPSS_HAL_Set* (source unknown): the path-sensitive static run of the setters does not write this word (carried over from the earlier linear scan).";
        field {
            name = "word";
            desc = "32-bit word (layout see the register description).";
            sw = rw;
            hw = r;
        } word[31:0];
    } NODE_W_25C @ 0x25C;

    reg {
        name = "Node word at offset 0x260";
        desc = "Word 0x260 of the node image. PROVENANCE: PROVEN offset and the listed bit extents (read from the load/store/bic/orr sequence of the named vendor function, hi3516cv300 Xiongmai module); INFERRED that a function name describes the content; UNKNOWN field meaning. Written by: VPSS_HAL_SetSharpenCoef. NOTE (2026-11-12): not produced by VPSS_HAL_Set* (source unknown): the path-sensitive static run of the setters does not write this word (carried over from the earlier linear scan).";
        field {
            name = "word";
            desc = "32-bit word (layout see the register description).";
            sw = rw;
            hw = r;
        } word[31:0];
    } NODE_W_260 @ 0x260;

    reg {
        name = "Node word at offset 0x264";
        desc = "Word 0x264 of the node image. PROVENANCE: PROVEN offset and the listed bit extents (read from the load/store/bic/orr sequence of the named vendor function, hi3516cv300 Xiongmai module); INFERRED that a function name describes the content; UNKNOWN field meaning. Written by: VPSS_HAL_SetSharpenCoef. NOTE (2026-11-12): not produced by VPSS_HAL_Set* (source unknown): the path-sensitive static run of the setters does not write this word (carried over from the earlier linear scan).";
        field {
            name = "word";
            desc = "32-bit word (layout see the register description).";
            sw = rw;
            hw = r;
        } word[31:0];
    } NODE_W_264 @ 0x264;

    reg {
        name = "Node word at offset 0x268";
        desc = "Word 0x268 of the node image. PROVENANCE: PROVEN offset and the listed bit extents (read from the load/store/bic/orr sequence of the named vendor function, hi3516cv300 Xiongmai module); INFERRED that a function name describes the content; UNKNOWN field meaning. Written by: VPSS_HAL_SetSharpenCoef. NOTE (2026-11-12): not produced by VPSS_HAL_Set* (source unknown): the path-sensitive static run of the setters does not write this word (carried over from the earlier linear scan).";
        field {
            name = "word";
            desc = "32-bit word (layout see the register description).";
            sw = rw;
            hw = r;
        } word[31:0];
    } NODE_W_268 @ 0x268;

    reg {
        name = "Node word at offset 0x26C";
        desc = "Word 0x26C of the node image. PROVENANCE: PROVEN offset and the listed bit extents (read from the load/store/bic/orr sequence of the named vendor function, hi3516cv300 Xiongmai module); INFERRED that a function name describes the content; UNKNOWN field meaning. Written by: VPSS_HAL_SetSharpenCoef. NOTE (2026-11-12): not produced by VPSS_HAL_Set* (source unknown): the path-sensitive static run of the setters does not write this word (carried over from the earlier linear scan).";
        field {
            name = "word";
            desc = "32-bit word (layout see the register description).";
            sw = rw;
            hw = r;
        } word[31:0];
    } NODE_W_26C @ 0x26C;

    reg {
        name = "Node word at offset 0x270";
        desc = "Word 0x270 of the node image. PROVENANCE: PROVEN offset and the listed bit extents (read from the load/store/bic/orr sequence of the named vendor function, hi3516cv300 Xiongmai module); INFERRED that a function name describes the content; UNKNOWN field meaning. Written by: VPSS_HAL_SetChnLowDelayAttr modifies bits [28:16] (inserts a value at shift 16); VPSS_HAL_SetSharpenCoef.";
        field {
            name = "word";
            desc = "32-bit word (layout see the register description).";
            sw = rw;
            hw = r;
        } word[31:0];
    } NODE_W_270 @ 0x270;

    reg {
        name = "Node word at offset 0x274";
        desc = "Word 0x274 of the node image. PROVENANCE: PROVEN offset and the listed bit extents (read from the load/store/bic/orr sequence of the named vendor function, hi3516cv300 Xiongmai module); INFERRED that a function name describes the content; UNKNOWN field meaning. Written by: VPSS_HAL_SetChnLowDelayAttr modifies bits [26:26] (sets constants 0x8000000); VPSS_HAL_SetSharpenCoef.";
        field {
            name = "word";
            desc = "32-bit word (layout see the register description).";
            sw = rw;
            hw = r;
        } word[31:0];
    } NODE_W_274 @ 0x274;

    reg {
        name = "Node word at offset 0x278";
        desc = "Word 0x278 of the node image. PROVENANCE: PROVEN offset and the listed bit extents (read from the load/store/bic/orr sequence of the named vendor function, hi3516cv300 Xiongmai module); INFERRED that a function name describes the content; UNKNOWN field meaning. Written by: VPSS_HAL_SetSharpenCoef. NOTE (2026-11-12): not produced by VPSS_HAL_Set* (source unknown): the path-sensitive static run of the setters does not write this word (carried over from the earlier linear scan).";
        field {
            name = "word";
            desc = "32-bit word (layout see the register description).";
            sw = rw;
            hw = r;
        } word[31:0];
    } NODE_W_278 @ 0x278;

    reg {
        name = "Node word at offset 0x27C";
        desc = "Word 0x27C of the node image. PROVENANCE: PROVEN offset and the listed bit extents (read from the load/store/bic/orr sequence of the named vendor function, hi3516cv300 Xiongmai module); INFERRED that a function name describes the content; UNKNOWN field meaning. Written by: VPSS_HAL_SetSharpenCoef. NOTE (2026-11-12): not produced by VPSS_HAL_Set* (source unknown): the path-sensitive static run of the setters does not write this word (carried over from the earlier linear scan).";
        field {
            name = "word";
            desc = "32-bit word (layout see the register description).";
            sw = rw;
            hw = r;
        } word[31:0];
    } NODE_W_27C @ 0x27C;

    reg {
        name = "Node word at offset 0x2E4";
        desc = "Word 0x2E4 of the node image. PROVENANCE: PROVEN offset and the listed bit extents (read from the load/store/bic/orr sequence of the named vendor function, hi3516cv300 Xiongmai module); INFERRED that a function name describes the content; UNKNOWN field meaning. Written by: VPSS_HAL_SetSharpenCoef. NOTE (2026-11-12): not produced by VPSS_HAL_Set* (source unknown): the path-sensitive static run of the setters does not write this word (carried over from the earlier linear scan).";
        field {
            name = "word";
            desc = "32-bit word (layout see the register description).";
            sw = rw;
            hw = r;
        } word[31:0];
    } NODE_W_2E4 @ 0x2E4;

    reg {
        name = "Node word at offset 0x2E8";
        desc = "Word 0x2E8 of the node image. PROVENANCE: PROVEN offset and the listed bit extents (read from the load/store/bic/orr sequence of the named vendor function, hi3516cv300 Xiongmai module); INFERRED that a function name describes the content; UNKNOWN field meaning. Written by: VPSS_HAL_SetSharpenCoef modifies bits [13:1] (inserts a value at shift 1). NOTE (2026-11-12): not produced by VPSS_HAL_Set* (source unknown): the path-sensitive static run of the setters does not write this word (carried over from the earlier linear scan).";
        field {
            name = "word";
            desc = "32-bit word (layout see the register description).";
            sw = rw;
            hw = r;
        } word[31:0];
    } NODE_W_2E8 @ 0x2E8;

    reg {
        name = "Node word at offset 0x2EC";
        desc = "Word 0x2EC of the node image. PROVENANCE: PROVEN offset and the listed bit extents (read from the load/store/bic/orr sequence of the named vendor function, hi3516cv300 Xiongmai module); INFERRED that a function name describes the content; UNKNOWN field meaning. Written by: VPSS_HAL_SetSharpenCoef. NOTE (2026-11-12): not produced by VPSS_HAL_Set* (source unknown): the path-sensitive static run of the setters does not write this word (carried over from the earlier linear scan).";
        field {
            name = "word";
            desc = "32-bit word (layout see the register description).";
            sw = rw;
            hw = r;
        } word[31:0];
    } NODE_W_2EC @ 0x2EC;

    reg {
        name = "Node word at offset 0x2F0";
        desc = "Word 0x2F0 of the node image. PROVENANCE: PROVEN offset and the listed bit extents (read from the load/store/bic/orr sequence of the named vendor function, hi3516cv300 Xiongmai module); INFERRED that a function name describes the content; UNKNOWN field meaning. Written by: VPSS_HAL_SetSharpenCoef. NOTE (2026-11-12): not produced by VPSS_HAL_Set* (source unknown): the path-sensitive static run of the setters does not write this word (carried over from the earlier linear scan).";
        field {
            name = "word";
            desc = "32-bit word (layout see the register description).";
            sw = rw;
            hw = r;
        } word[31:0];
    } NODE_W_2F0 @ 0x2F0;

    reg {
        name = "Node word at offset 0x2F4";
        desc = "Word 0x2F4 of the node image. PROVENANCE: PROVEN offset and the listed bit extents (read from the load/store/bic/orr sequence of the named vendor function, hi3516cv300 Xiongmai module); INFERRED that a function name describes the content; UNKNOWN field meaning. Written by: VPSS_HAL_SetSharpenCoef. NOTE (2026-11-12): not produced by VPSS_HAL_Set* (source unknown): the path-sensitive static run of the setters does not write this word (carried over from the earlier linear scan).";
        field {
            name = "word";
            desc = "32-bit word (layout see the register description).";
            sw = rw;
            hw = r;
        } word[31:0];
    } NODE_W_2F4 @ 0x2F4;

    reg {
        name = "Node word at offset 0x2F8";
        desc = "Word 0x2F8 of the node image. PROVENANCE: PROVEN offset and the listed bit extents (read from the load/store/bic/orr sequence of the named vendor function, hi3516cv300 Xiongmai module); INFERRED that a function name describes the content; UNKNOWN field meaning. Written by: VPSS_HAL_SetSharpenCoef. NOTE (2026-11-12): not produced by VPSS_HAL_Set* (source unknown): the path-sensitive static run of the setters does not write this word (carried over from the earlier linear scan).";
        field {
            name = "word";
            desc = "32-bit word (layout see the register description).";
            sw = rw;
            hw = r;
        } word[31:0];
    } NODE_W_2F8 @ 0x2F8;

    reg {
        name = "Node word at offset 0x2FC";
        desc = "Word 0x2FC of the node image. PROVENANCE: PROVEN offset and the listed bit extents (read from the load/store/bic/orr sequence of the named vendor function, hi3516cv300 Xiongmai module); INFERRED that a function name describes the content; UNKNOWN field meaning. Written by: VPSS_HAL_SetNext. NOTE (2026-11-12): dynamic harness run (qemu, ko-harness, 9 argument patterns): written by VPSS_HAL_SetNext.";
        field {
            name = "word";
            desc = "32-bit word (layout see the register description).";
            sw = rw;
            hw = r;
        } word[31:0];
    } NODE_W_2FC @ 0x2FC;

    reg {
        name = "Node word at offset 0x31C";
        desc = "Word 0x31C of the node image. PROVENANCE: PROVEN offset and the listed bit extents (read from the load/store/bic/orr sequence of the named vendor function, hi3516cv300 Xiongmai module); INFERRED that a function name describes the content; UNKNOWN field meaning. Written by: VPSS_HAL_SetTimeOut. NOTE (2026-11-12): dynamic harness run (qemu, ko-harness, 9 argument patterns): written by VPSS_HAL_SetTimeOut.";
        field {
            name = "word";
            desc = "32-bit word (layout see the register description).";
            sw = rw;
            hw = r;
        } word[31:0];
    } NODE_W_31C @ 0x31C;

    reg {
        name = "Node word at offset 0x328";
        desc = "Word 0x328 of the node image. PROVENANCE: PROVEN offset and the listed bit extents (read from the load/store/bic/orr sequence of the named vendor function, hi3516cv300 Xiongmai module); INFERRED that a function name describes the content; UNKNOWN field meaning. Written by: VPSS_HAL_SetSharpenCoef. NOTE (2026-11-12): not produced by VPSS_HAL_Set* (source unknown): the path-sensitive static run of the setters does not write this word (carried over from the earlier linear scan).";
        field {
            name = "word";
            desc = "32-bit word (layout see the register description).";
            sw = rw;
            hw = r;
        } word[31:0];
    } NODE_W_328 @ 0x328;

    reg {
        name = "Node word at offset 0x330";
        desc = "Word 0x330 of the node image. PROVENANCE: PROVEN offset and the listed bit extents (read from the load/store/bic/orr sequence of the named vendor function, hi3516cv300 Xiongmai module); INFERRED that a function name describes the content; UNKNOWN field meaning. Written by: VPSS_HAL_SetSharpenCoef. NOTE (2026-11-12): not produced by VPSS_HAL_Set* (source unknown): the path-sensitive static run of the setters does not write this word (carried over from the earlier linear scan).";
        field {
            name = "word";
            desc = "32-bit word (layout see the register description).";
            sw = rw;
            hw = r;
        } word[31:0];
    } NODE_W_330 @ 0x330;

    reg {
        name = "Node word at offset 0x334";
        desc = "Word 0x334 of the node image. PROVENANCE: PROVEN offset and the listed bit extents (read from the load/store/bic/orr sequence of the named vendor function, hi3516cv300 Xiongmai module); INFERRED that a function name describes the content; UNKNOWN field meaning. Written by: VPSS_HAL_SetSharpenCoef. NOTE (2026-11-12): not produced by VPSS_HAL_Set* (source unknown): the path-sensitive static run of the setters does not write this word (carried over from the earlier linear scan).";
        field {
            name = "word";
            desc = "32-bit word (layout see the register description).";
            sw = rw;
            hw = r;
        } word[31:0];
    } NODE_W_334 @ 0x334;

    reg {
        name = "Node word at offset 0x338";
        desc = "Word 0x338 of the node image. PROVENANCE: PROVEN offset and the listed bit extents (read from the load/store/bic/orr sequence of the named vendor function, hi3516cv300 Xiongmai module); INFERRED that a function name describes the content; UNKNOWN field meaning. Written by: VPSS_HAL_SetSharpenCoef. NOTE (2026-11-12): not produced by VPSS_HAL_Set* (source unknown): the path-sensitive static run of the setters does not write this word (carried over from the earlier linear scan).";
        field {
            name = "word";
            desc = "32-bit word (layout see the register description).";
            sw = rw;
            hw = r;
        } word[31:0];
    } NODE_W_338 @ 0x338;

    reg {
        name = "Node word at offset 0x33C";
        desc = "Word 0x33C of the node image. PROVENANCE: PROVEN offset and the listed bit extents (read from the load/store/bic/orr sequence of the named vendor function, hi3516cv300 Xiongmai module); INFERRED that a function name describes the content; UNKNOWN field meaning. Written by: VPSS_HAL_SetSharpenCoef. NOTE (2026-11-12): not produced by VPSS_HAL_Set* (source unknown): the path-sensitive static run of the setters does not write this word (carried over from the earlier linear scan).";
        field {
            name = "word";
            desc = "32-bit word (layout see the register description).";
            sw = rw;
            hw = r;
        } word[31:0];
    } NODE_W_33C @ 0x33C;

    reg {
        name = "Node word at offset 0x340";
        desc = "Word 0x340 of the node image. PROVENANCE: PROVEN offset and the listed bit extents (read from the load/store/bic/orr sequence of the named vendor function, hi3516cv300 Xiongmai module); INFERRED that a function name describes the content; UNKNOWN field meaning. Written by: VPSS_HAL_SetSharpenCoef. NOTE (2026-11-12): not produced by VPSS_HAL_Set* (source unknown): the path-sensitive static run of the setters does not write this word (carried over from the earlier linear scan).";
        field {
            name = "word";
            desc = "32-bit word (layout see the register description).";
            sw = rw;
            hw = r;
        } word[31:0];
    } NODE_W_340 @ 0x340;

    reg {
        name = "Node word at offset 0x344";
        desc = "Word 0x344 of the node image. PROVENANCE: PROVEN offset and the listed bit extents (read from the load/store/bic/orr sequence of the named vendor function, hi3516cv300 Xiongmai module); INFERRED that a function name describes the content; UNKNOWN field meaning. Written by: VPSS_HAL_SetSharpenCoef. NOTE (2026-11-12): not produced by VPSS_HAL_Set* (source unknown): the path-sensitive static run of the setters does not write this word (carried over from the earlier linear scan).";
        field {
            name = "word";
            desc = "32-bit word (layout see the register description).";
            sw = rw;
            hw = r;
        } word[31:0];
    } NODE_W_344 @ 0x344;

    reg {
        name = "Node word at offset 0x348";
        desc = "Word 0x348 of the node image. PROVENANCE: PROVEN offset and the listed bit extents (read from the load/store/bic/orr sequence of the named vendor function, hi3516cv300 Xiongmai module); INFERRED that a function name describes the content; UNKNOWN field meaning. Written by: VPSS_HAL_SetSharpenCoef. NOTE (2026-11-12): not produced by VPSS_HAL_Set* (source unknown): the path-sensitive static run of the setters does not write this word (carried over from the earlier linear scan).";
        field {
            name = "word";
            desc = "32-bit word (layout see the register description).";
            sw = rw;
            hw = r;
        } word[31:0];
    } NODE_W_348 @ 0x348;

    reg {
        name = "Node word at offset 0x34C";
        desc = "Word 0x34C of the node image. PROVENANCE: PROVEN offset and the listed bit extents (read from the load/store/bic/orr sequence of the named vendor function, hi3516cv300 Xiongmai module); INFERRED that a function name describes the content; UNKNOWN field meaning. Written by: VPSS_HAL_SetSharpenCoef. NOTE (2026-11-12): not produced by VPSS_HAL_Set* (source unknown): the path-sensitive static run of the setters does not write this word (carried over from the earlier linear scan).";
        field {
            name = "word";
            desc = "32-bit word (layout see the register description).";
            sw = rw;
            hw = r;
        } word[31:0];
    } NODE_W_34C @ 0x34C;

    reg {
        name = "Node word at offset 0x350";
        desc = "Word 0x350 of the node image. PROVENANCE: PROVEN offset and the listed bit extents (read from the load/store/bic/orr sequence of the named vendor function, hi3516cv300 Xiongmai module); INFERRED that a function name describes the content; UNKNOWN field meaning. Written by: VPSS_HAL_SetSharpenCoef. NOTE (2026-11-12): not produced by VPSS_HAL_Set* (source unknown): the path-sensitive static run of the setters does not write this word (carried over from the earlier linear scan).";
        field {
            name = "word";
            desc = "32-bit word (layout see the register description).";
            sw = rw;
            hw = r;
        } word[31:0];
    } NODE_W_350 @ 0x350;

    reg {
        name = "Node word at offset 0x354";
        desc = "Word 0x354 of the node image. PROVENANCE: PROVEN offset and the listed bit extents (read from the load/store/bic/orr sequence of the named vendor function, hi3516cv300 Xiongmai module); INFERRED that a function name describes the content; UNKNOWN field meaning. Written by: VPSS_HAL_SetSharpenCoef. NOTE (2026-11-12): not produced by VPSS_HAL_Set* (source unknown): the path-sensitive static run of the setters does not write this word (carried over from the earlier linear scan).";
        field {
            name = "word";
            desc = "32-bit word (layout see the register description).";
            sw = rw;
            hw = r;
        } word[31:0];
    } NODE_W_354 @ 0x354;

    reg {
        name = "Node word at offset 0x358";
        desc = "Word 0x358 of the node image. PROVENANCE: PROVEN offset and the listed bit extents (read from the load/store/bic/orr sequence of the named vendor function, hi3516cv300 Xiongmai module); INFERRED that a function name describes the content; UNKNOWN field meaning. Written by: VPSS_HAL_SetSharpenCoef. NOTE (2026-11-12): not produced by VPSS_HAL_Set* (source unknown): the path-sensitive static run of the setters does not write this word (carried over from the earlier linear scan).";
        field {
            name = "word";
            desc = "32-bit word (layout see the register description).";
            sw = rw;
            hw = r;
        } word[31:0];
    } NODE_W_358 @ 0x358;

    reg {
        name = "Node word at offset 0x3E4";
        desc = "Word 0x3E4 of the node image. PROVENANCE: PROVEN offset and the listed bit extents (read from the load/store/bic/orr sequence of the named vendor function, hi3516cv300 Xiongmai module); INFERRED that a function name describes the content; UNKNOWN field meaning. Written by: VPSS_HAL_SetSharpenCoef. NOTE (2026-11-12): not produced by VPSS_HAL_Set* (source unknown): the path-sensitive static run of the setters does not write this word (carried over from the earlier linear scan).";
        field {
            name = "word";
            desc = "32-bit word (layout see the register description).";
            sw = rw;
            hw = r;
        } word[31:0];
    } NODE_W_3E4 @ 0x3E4;

    reg {
        name = "Node word at offset 0x3EC";
        desc = "Word 0x3EC of the node image. PROVENANCE: PROVEN offset and the listed bit extents (read from the load/store/bic/orr sequence of the named vendor function, hi3516cv300 Xiongmai module); INFERRED that a function name describes the content; UNKNOWN field meaning. Written by: VPSS_HAL_SetSharpenCoef. NOTE (2026-11-12): not produced by VPSS_HAL_Set* (source unknown): the path-sensitive static run of the setters does not write this word (carried over from the earlier linear scan).";
        field {
            name = "word";
            desc = "32-bit word (layout see the register description).";
            sw = rw;
            hw = r;
        } word[31:0];
    } NODE_W_3EC @ 0x3EC;

    reg {
        name = "Node word at offset 0x400";
        desc = "Word 0x400 of the node image. PROVENANCE: PROVEN offset and the listed bit extents (read from the load/store/bic/orr sequence of the named vendor function, hi3516cv300 Xiongmai module); INFERRED that a function name describes the content; UNKNOWN field meaning. Written by: VPSS_HAL_SetMosaic modifies bits [3:1] (inserts a value at shift 1, 2, 3). NOTE (2026-11-12): not produced by VPSS_HAL_Set* (source unknown): the path-sensitive static run of the setters does not write this word (carried over from the earlier linear scan).";
        field {
            name = "word";
            desc = "32-bit word (layout see the register description).";
            sw = rw;
            hw = r;
        } word[31:0];
    } NODE_W_400 @ 0x400;

    reg {
        name = "Node word at offset 0x404";
        desc = "Word 0x404 of the node image. PROVENANCE: PROVEN offset and the listed bit extents (read from the load/store/bic/orr sequence of the named vendor function, hi3516cv300 Xiongmai module); INFERRED that a function name describes the content; UNKNOWN field meaning. Written by: VPSS_HAL_SetMosaic. NOTE (2026-11-12): not produced by VPSS_HAL_Set* (source unknown): the path-sensitive static run of the setters does not write this word (carried over from the earlier linear scan).";
        field {
            name = "word";
            desc = "32-bit word (layout see the register description).";
            sw = rw;
            hw = r;
        } word[31:0];
    } NODE_W_404 @ 0x404;

    reg {
        name = "Node word at offset 0x408";
        desc = "Word 0x408 of the node image. PROVENANCE: PROVEN offset and the listed bit extents (read from the load/store/bic/orr sequence of the named vendor function, hi3516cv300 Xiongmai module); INFERRED that a function name describes the content; UNKNOWN field meaning. Written by: VPSS_HAL_SetMosaic. NOTE (2026-11-12): not produced by VPSS_HAL_Set* (source unknown): the path-sensitive static run of the setters does not write this word (carried over from the earlier linear scan).";
        field {
            name = "word";
            desc = "32-bit word (layout see the register description).";
            sw = rw;
            hw = r;
        } word[31:0];
    } NODE_W_408 @ 0x408;

    reg {
        name = "Node word at offset 0x40C";
        desc = "Word 0x40C of the node image. PROVENANCE: PROVEN offset and the listed bit extents (read from the load/store/bic/orr sequence of the named vendor function, hi3516cv300 Xiongmai module); INFERRED that a function name describes the content; UNKNOWN field meaning. Written by: VPSS_HAL_SetMosaic. NOTE (2026-11-12): not produced by VPSS_HAL_Set* (source unknown): the path-sensitive static run of the setters does not write this word (carried over from the earlier linear scan).";
        field {
            name = "word";
            desc = "32-bit word (layout see the register description).";
            sw = rw;
            hw = r;
        } word[31:0];
    } NODE_W_40C @ 0x40C;

    reg {
        name = "Node word at offset 0x410";
        desc = "Word 0x410 of the node image. PROVENANCE: PROVEN offset and the listed bit extents (read from the load/store/bic/orr sequence of the named vendor function, hi3516cv300 Xiongmai module); INFERRED that a function name describes the content; UNKNOWN field meaning. Written by: VPSS_HAL_SetMosaic. NOTE (2026-11-12): not produced by VPSS_HAL_Set* (source unknown): the path-sensitive static run of the setters does not write this word (carried over from the earlier linear scan).";
        field {
            name = "word";
            desc = "32-bit word (layout see the register description).";
            sw = rw;
            hw = r;
        } word[31:0];
    } NODE_W_410 @ 0x410;

    reg {
        name = "Node word at offset 0x414";
        desc = "Word 0x414 of the node image. PROVENANCE: PROVEN offset and the listed bit extents (read from the load/store/bic/orr sequence of the named vendor function, hi3516cv300 Xiongmai module); INFERRED that a function name describes the content; UNKNOWN field meaning. Written by: VPSS_HAL_SetMosaic. NOTE (2026-11-12): not produced by VPSS_HAL_Set* (source unknown): the path-sensitive static run of the setters does not write this word (carried over from the earlier linear scan).";
        field {
            name = "word";
            desc = "32-bit word (layout see the register description).";
            sw = rw;
            hw = r;
        } word[31:0];
    } NODE_W_414 @ 0x414;

    reg {
        name = "Node word at offset 0x418";
        desc = "Word 0x418 of the node image. PROVENANCE: PROVEN offset and the listed bit extents (read from the load/store/bic/orr sequence of the named vendor function, hi3516cv300 Xiongmai module); INFERRED that a function name describes the content; UNKNOWN field meaning. Written by: VPSS_HAL_SetMosaic. NOTE (2026-11-12): not produced by VPSS_HAL_Set* (source unknown): the path-sensitive static run of the setters does not write this word (carried over from the earlier linear scan).";
        field {
            name = "word";
            desc = "32-bit word (layout see the register description).";
            sw = rw;
            hw = r;
        } word[31:0];
    } NODE_W_418 @ 0x418;

    reg {
        name = "Node word at offset 0x41C";
        desc = "Word 0x41C of the node image. PROVENANCE: PROVEN offset and the listed bit extents (read from the load/store/bic/orr sequence of the named vendor function, hi3516cv300 Xiongmai module); INFERRED that a function name describes the content; UNKNOWN field meaning. Written by: VPSS_HAL_SetMosaic. NOTE (2026-11-12): not produced by VPSS_HAL_Set* (source unknown): the path-sensitive static run of the setters does not write this word (carried over from the earlier linear scan).";
        field {
            name = "word";
            desc = "32-bit word (layout see the register description).";
            sw = rw;
            hw = r;
        } word[31:0];
    } NODE_W_41C @ 0x41C;

    reg {
        name = "Node word at offset 0x420";
        desc = "Word 0x420 of the node image. PROVENANCE: PROVEN offset and the listed bit extents (read from the load/store/bic/orr sequence of the named vendor function, hi3516cv300 Xiongmai module); INFERRED that a function name describes the content; UNKNOWN field meaning. Written by: VPSS_HAL_SetMosaic. NOTE (2026-11-12): not produced by VPSS_HAL_Set* (source unknown): the path-sensitive static run of the setters does not write this word (carried over from the earlier linear scan).";
        field {
            name = "word";
            desc = "32-bit word (layout see the register description).";
            sw = rw;
            hw = r;
        } word[31:0];
    } NODE_W_420 @ 0x420;

    reg {
        name = "Node word at offset 0x424";
        desc = "Word 0x424 of the node image. PROVENANCE: PROVEN offset and the listed bit extents (read from the load/store/bic/orr sequence of the named vendor function, hi3516cv300 Xiongmai module); INFERRED that a function name describes the content; UNKNOWN field meaning. Written by: VPSS_HAL_SetMosaic. NOTE (2026-11-12): not produced by VPSS_HAL_Set* (source unknown): the path-sensitive static run of the setters does not write this word (carried over from the earlier linear scan).";
        field {
            name = "word";
            desc = "32-bit word (layout see the register description).";
            sw = rw;
            hw = r;
        } word[31:0];
    } NODE_W_424 @ 0x424;

    reg {
        name = "Word at offset 0x2000";
        desc = "Word 0x2000 (NEW in the arm-re rediff 2026-11-12). PROVENANCE: PROVEN offset and stored byte lanes 0123, cleared bit extents [31:24], written by VPSS_HAL_SetChnSclCfg (1 stores) in the path-sensitive static run (conditional paths and indexed loop records folded into the word; some are loop-built or conditional and not individually proven). Meaning UNKNOWN.";
        field {
            name = "word";
            desc = "32-bit word.";
            sw = rw;
            hw = r;
        } word[31:0];
    } NODE_W_2000 @ 0x2000;
    reg {
        name = "Word at offset 0x2004";
        desc = "Word 0x2004 (NEW in the arm-re rediff 2026-11-12). PROVENANCE: PROVEN offset and stored byte lanes 0123, cleared bit extents [31:30], written by VPSS_HAL_SetChnSclCfg (1 stores) in the path-sensitive static run (conditional paths and indexed loop records folded into the word; some are loop-built or conditional and not individually proven). Meaning UNKNOWN.";
        field {
            name = "word";
            desc = "32-bit word.";
            sw = rw;
            hw = r;
        } word[31:0];
    } NODE_W_2004 @ 0x2004;
    reg {
        name = "Word at offset 0x2008";
        desc = "Word 0x2008 (NEW in the arm-re rediff 2026-11-12). PROVENANCE: PROVEN offset and stored byte lanes 0123, cleared bit extents [31:30], written by VPSS_HAL_SetChnSclCfg (1 stores) in the path-sensitive static run (conditional paths and indexed loop records folded into the word; some are loop-built or conditional and not individually proven). Meaning UNKNOWN.";
        field {
            name = "word";
            desc = "32-bit word.";
            sw = rw;
            hw = r;
        } word[31:0];
    } NODE_W_2008 @ 0x2008;
    reg {
        name = "Word at offset 0x200C";
        desc = "Word 0x200C (NEW in the arm-re rediff 2026-11-12). PROVENANCE: PROVEN offset and stored byte lanes 0123, cleared bit extents none seen, written by VPSS_HAL_SetChnSclCfg (1 stores) in the path-sensitive static run (conditional paths and indexed loop records folded into the word; some are loop-built or conditional and not individually proven). Meaning UNKNOWN.";
        field {
            name = "word";
            desc = "32-bit word.";
            sw = rw;
            hw = r;
        } word[31:0];
    } NODE_W_200C @ 0x200C;
    reg {
        name = "Word at offset 0x2010";
        desc = "Word 0x2010 (NEW in the arm-re rediff 2026-11-12). PROVENANCE: PROVEN offset and stored byte lanes 0123, cleared bit extents none seen, written by VPSS_HAL_SetChnSclCfg (1 stores) in the path-sensitive static run (conditional paths and indexed loop records folded into the word; some are loop-built or conditional and not individually proven). Meaning UNKNOWN.";
        field {
            name = "word";
            desc = "32-bit word.";
            sw = rw;
            hw = r;
        } word[31:0];
    } NODE_W_2010 @ 0x2010;
    reg {
        name = "Word at offset 0x2014";
        desc = "Word 0x2014 (NEW in the arm-re rediff 2026-11-12). PROVENANCE: PROVEN offset and stored byte lanes 0123, cleared bit extents none seen, written by VPSS_HAL_SetChnSclCfg (1 stores) in the path-sensitive static run (conditional paths and indexed loop records folded into the word; some are loop-built or conditional and not individually proven). Meaning UNKNOWN.";
        field {
            name = "word";
            desc = "32-bit word.";
            sw = rw;
            hw = r;
        } word[31:0];
    } NODE_W_2014 @ 0x2014;
    reg {
        name = "Word at offset 0x2018";
        desc = "Word 0x2018 (NEW in the arm-re rediff 2026-11-12). PROVENANCE: PROVEN offset and stored byte lanes 0123, cleared bit extents none seen, written by VPSS_HAL_SetChnSclCfg (1 stores) in the path-sensitive static run (conditional paths and indexed loop records folded into the word; some are loop-built or conditional and not individually proven). Meaning UNKNOWN.";
        field {
            name = "word";
            desc = "32-bit word.";
            sw = rw;
            hw = r;
        } word[31:0];
    } NODE_W_2018 @ 0x2018;
    reg {
        name = "Word at offset 0x2040";
        desc = "Word 0x2040 (NEW in the arm-re rediff 2026-11-12). PROVENANCE: PROVEN offset and stored byte lanes 0123, cleared bit extents [31:24], written by VPSS_HAL_SetChnSclCfg (1 stores) in the path-sensitive static run (conditional paths and indexed loop records folded into the word; some are loop-built or conditional and not individually proven). Meaning UNKNOWN.";
        field {
            name = "word";
            desc = "32-bit word.";
            sw = rw;
            hw = r;
        } word[31:0];
    } NODE_W_2040 @ 0x2040;
    reg {
        name = "Word at offset 0x2044";
        desc = "Word 0x2044 (NEW in the arm-re rediff 2026-11-12). PROVENANCE: PROVEN offset and stored byte lanes 0123, cleared bit extents [31:30], written by VPSS_HAL_SetChnSclCfg (1 stores) in the path-sensitive static run (conditional paths and indexed loop records folded into the word; some are loop-built or conditional and not individually proven). Meaning UNKNOWN.";
        field {
            name = "word";
            desc = "32-bit word.";
            sw = rw;
            hw = r;
        } word[31:0];
    } NODE_W_2044 @ 0x2044;
    reg {
        name = "Word at offset 0x2048";
        desc = "Word 0x2048 (NEW in the arm-re rediff 2026-11-12). PROVENANCE: PROVEN offset and stored byte lanes 0123, cleared bit extents [31:30], written by VPSS_HAL_SetChnSclCfg (1 stores) in the path-sensitive static run (conditional paths and indexed loop records folded into the word; some are loop-built or conditional and not individually proven). Meaning UNKNOWN.";
        field {
            name = "word";
            desc = "32-bit word.";
            sw = rw;
            hw = r;
        } word[31:0];
    } NODE_W_2048 @ 0x2048;
    reg {
        name = "Word at offset 0x204C";
        desc = "Word 0x204C (NEW in the arm-re rediff 2026-11-12). PROVENANCE: PROVEN offset and stored byte lanes 0123, cleared bit extents none seen, written by VPSS_HAL_SetChnSclCfg (1 stores) in the path-sensitive static run (conditional paths and indexed loop records folded into the word; some are loop-built or conditional and not individually proven). Meaning UNKNOWN.";
        field {
            name = "word";
            desc = "32-bit word.";
            sw = rw;
            hw = r;
        } word[31:0];
    } NODE_W_204C @ 0x204C;
    reg {
        name = "Word at offset 0x2050";
        desc = "Word 0x2050 (NEW in the arm-re rediff 2026-11-12). PROVENANCE: PROVEN offset and stored byte lanes 0123, cleared bit extents none seen, written by VPSS_HAL_SetChnSclCfg (1 stores) in the path-sensitive static run (conditional paths and indexed loop records folded into the word; some are loop-built or conditional and not individually proven). Meaning UNKNOWN.";
        field {
            name = "word";
            desc = "32-bit word.";
            sw = rw;
            hw = r;
        } word[31:0];
    } NODE_W_2050 @ 0x2050;
    reg {
        name = "Word at offset 0x2054";
        desc = "Word 0x2054 (NEW in the arm-re rediff 2026-11-12). PROVENANCE: PROVEN offset and stored byte lanes 0123, cleared bit extents none seen, written by VPSS_HAL_SetChnSclCfg (1 stores) in the path-sensitive static run (conditional paths and indexed loop records folded into the word; some are loop-built or conditional and not individually proven). Meaning UNKNOWN.";
        field {
            name = "word";
            desc = "32-bit word.";
            sw = rw;
            hw = r;
        } word[31:0];
    } NODE_W_2054 @ 0x2054;
    reg {
        name = "Word at offset 0x2058";
        desc = "Word 0x2058 (NEW in the arm-re rediff 2026-11-12). PROVENANCE: PROVEN offset and stored byte lanes 0123, cleared bit extents none seen, written by VPSS_HAL_SetChnSclCfg (1 stores) in the path-sensitive static run (conditional paths and indexed loop records folded into the word; some are loop-built or conditional and not individually proven). Meaning UNKNOWN.";
        field {
            name = "word";
            desc = "32-bit word.";
            sw = rw;
            hw = r;
        } word[31:0];
    } NODE_W_2058 @ 0x2058;
    reg {
        name = "Word at offset 0x20C0";
        desc = "Word 0x20C0 (NEW in the arm-re rediff 2026-11-12). PROVENANCE: PROVEN offset and stored byte lanes 0123, cleared bit extents [31:24], written by VPSS_HAL_SetChnSclCfg (1 stores) in the path-sensitive static run (conditional paths and indexed loop records folded into the word; some are loop-built or conditional and not individually proven). Meaning UNKNOWN.";
        field {
            name = "word";
            desc = "32-bit word.";
            sw = rw;
            hw = r;
        } word[31:0];
    } NODE_W_20C0 @ 0x20C0;
    reg {
        name = "Word at offset 0x20C4";
        desc = "Word 0x20C4 (NEW in the arm-re rediff 2026-11-12). PROVENANCE: PROVEN offset and stored byte lanes 0123, cleared bit extents [31:30], written by VPSS_HAL_SetChnSclCfg (1 stores) in the path-sensitive static run (conditional paths and indexed loop records folded into the word; some are loop-built or conditional and not individually proven). Meaning UNKNOWN.";
        field {
            name = "word";
            desc = "32-bit word.";
            sw = rw;
            hw = r;
        } word[31:0];
    } NODE_W_20C4 @ 0x20C4;
    reg {
        name = "Word at offset 0x20C8";
        desc = "Word 0x20C8 (NEW in the arm-re rediff 2026-11-12). PROVENANCE: PROVEN offset and stored byte lanes 0123, cleared bit extents [31:30], written by VPSS_HAL_SetChnSclCfg (1 stores) in the path-sensitive static run (conditional paths and indexed loop records folded into the word; some are loop-built or conditional and not individually proven). Meaning UNKNOWN.";
        field {
            name = "word";
            desc = "32-bit word.";
            sw = rw;
            hw = r;
        } word[31:0];
    } NODE_W_20C8 @ 0x20C8;
    reg {
        name = "Word at offset 0x20CC";
        desc = "Word 0x20CC (NEW in the arm-re rediff 2026-11-12). PROVENANCE: PROVEN offset and stored byte lanes 0123, cleared bit extents [20:19], written by VPSS_HAL_SetChnSclCfg (2 stores) in the path-sensitive static run (conditional paths and indexed loop records folded into the word; some are loop-built or conditional and not individually proven). Meaning UNKNOWN. NOTE (2026-11-12): dynamic harness run (qemu, ko-harness, 9 argument patterns): written by VPSS_HAL_SetChnSclCfg.";
        field {
            name = "word";
            desc = "32-bit word.";
            sw = rw;
            hw = r;
        } word[31:0];
    } NODE_W_20CC @ 0x20CC;
    reg {
        name = "Word at offset 0x20D0";
        desc = "Word 0x20D0 (NEW in the arm-re rediff 2026-11-12). PROVENANCE: PROVEN offset and stored byte lanes 0123, cleared bit extents none seen, written by VPSS_HAL_SetChnSclCfg (1 stores) in the path-sensitive static run (conditional paths and indexed loop records folded into the word; some are loop-built or conditional and not individually proven). Meaning UNKNOWN.";
        field {
            name = "word";
            desc = "32-bit word.";
            sw = rw;
            hw = r;
        } word[31:0];
    } NODE_W_20D0 @ 0x20D0;
    reg {
        name = "Word at offset 0x20D4";
        desc = "Word 0x20D4 (NEW in the arm-re rediff 2026-11-12). PROVENANCE: PROVEN offset and stored byte lanes 0123, cleared bit extents none seen, written by VPSS_HAL_SetChnSclCfg (1 stores) in the path-sensitive static run (conditional paths and indexed loop records folded into the word; some are loop-built or conditional and not individually proven). Meaning UNKNOWN.";
        field {
            name = "word";
            desc = "32-bit word.";
            sw = rw;
            hw = r;
        } word[31:0];
    } NODE_W_20D4 @ 0x20D4;
    reg {
        name = "Word at offset 0x20D8";
        desc = "Word 0x20D8 (NEW in the arm-re rediff 2026-11-12). PROVENANCE: PROVEN offset and stored byte lanes 0123, cleared bit extents none seen, written by VPSS_HAL_SetChnSclCfg (1 stores) in the path-sensitive static run (conditional paths and indexed loop records folded into the word; some are loop-built or conditional and not individually proven). Meaning UNKNOWN.";
        field {
            name = "word";
            desc = "32-bit word.";
            sw = rw;
            hw = r;
        } word[31:0];
    } NODE_W_20D8 @ 0x20D8;
    reg {
        name = "Word at offset 0x20DC";
        desc = "Word 0x20DC (NEW in the arm-re rediff 2026-11-12). PROVENANCE: PROVEN offset and stored byte lanes 0123, cleared bit extents none seen, written by VPSS_HAL_SetChnSclCfg (1 stores) in the path-sensitive static run (conditional paths and indexed loop records folded into the word; some are loop-built or conditional and not individually proven). Meaning UNKNOWN. NOTE (2026-11-12): dynamic harness run (qemu, ko-harness, 9 argument patterns): written by VPSS_HAL_SetChnSclCfg.";
        field {
            name = "word";
            desc = "32-bit word.";
            sw = rw;
            hw = r;
        } word[31:0];
    } NODE_W_20DC @ 0x20DC;
    reg {
        name = "Word at offset 0x2200";
        desc = "Word 0x2200 (NEW in the arm-re rediff 2026-11-12). PROVENANCE: PROVEN offset and stored byte lanes 0123, cleared bit extents [0:0], written by VPSS_HAL_SetSharpenCtrl (1 stores) in the path-sensitive static run (conditional paths and indexed loop records folded into the word; some are loop-built or conditional and not individually proven). Meaning UNKNOWN. NOTE (2026-11-12): dynamic harness run (qemu, ko-harness, 9 argument patterns): written by VPSS_HAL_SetSharpenCtrl.";
        field {
            name = "word";
            desc = "32-bit word.";
            sw = rw;
            hw = r;
        } word[31:0];
    } NODE_W_2200 @ 0x2200;
    reg {
        name = "Word at offset 0x2210";
        desc = "Word 0x2210 (NEW in the arm-re rediff 2026-11-12). PROVENANCE: PROVEN offset and stored byte lanes 0123, cleared bit extents [27:16], written by VPSS_HAL_SetSharpenCoef (1 stores) in the path-sensitive static run (conditional paths and indexed loop records folded into the word; some are loop-built or conditional and not individually proven). Meaning UNKNOWN. NOTE (2026-11-12): dynamic harness run (qemu, ko-harness, 9 argument patterns): written by VPSS_HAL_SetSharpenCoef.";
        field {
            name = "word";
            desc = "32-bit word.";
            sw = rw;
            hw = r;
        } word[31:0];
    } NODE_W_2210 @ 0x2210;
    reg {
        name = "Word at offset 0x2214";
        desc = "Word 0x2214 (NEW in the arm-re rediff 2026-11-12). PROVENANCE: PROVEN offset and stored byte lanes 0123, cleared bit extents [25:16], written by VPSS_HAL_SetSharpenCoef (1 stores) in the path-sensitive static run (conditional paths and indexed loop records folded into the word; some are loop-built or conditional and not individually proven). Meaning UNKNOWN. NOTE (2026-11-12): dynamic harness run (qemu, ko-harness, 9 argument patterns): written by VPSS_HAL_SetSharpenCoef.";
        field {
            name = "word";
            desc = "32-bit word.";
            sw = rw;
            hw = r;
        } word[31:0];
    } NODE_W_2214 @ 0x2214;
    reg {
        name = "Word at offset 0x2218";
        desc = "Word 0x2218 (NEW in the arm-re rediff 2026-11-12). PROVENANCE: PROVEN offset and stored byte lanes 0123, cleared bit extents [25:16], written by VPSS_HAL_SetSharpenCoef (1 stores) in the path-sensitive static run (conditional paths and indexed loop records folded into the word; some are loop-built or conditional and not individually proven). Meaning UNKNOWN. NOTE (2026-11-12): dynamic harness run (qemu, ko-harness, 9 argument patterns): written by VPSS_HAL_SetSharpenCoef.";
        field {
            name = "word";
            desc = "32-bit word.";
            sw = rw;
            hw = r;
        } word[31:0];
    } NODE_W_2218 @ 0x2218;
    reg {
        name = "Word at offset 0x221C";
        desc = "Word 0x221C (NEW in the arm-re rediff 2026-11-12). PROVENANCE: PROVEN offset and stored byte lanes 0123, cleared bit extents [27:16], written by VPSS_HAL_SetSharpenCoef (1 stores) in the path-sensitive static run (conditional paths and indexed loop records folded into the word; some are loop-built or conditional and not individually proven). Meaning UNKNOWN. NOTE (2026-11-12): dynamic harness run (qemu, ko-harness, 9 argument patterns): written by VPSS_HAL_SetSharpenCoef.";
        field {
            name = "word";
            desc = "32-bit word.";
            sw = rw;
            hw = r;
        } word[31:0];
    } NODE_W_221C @ 0x221C;
    reg {
        name = "Word at offset 0x2220";
        desc = "Word 0x2220 (NEW in the arm-re rediff 2026-11-12). PROVENANCE: PROVEN offset and stored byte lanes 0123, cleared bit extents [7:0] [23:16], written by VPSS_HAL_SetSharpenCoef (1 stores) in the path-sensitive static run (conditional paths and indexed loop records folded into the word; some are loop-built or conditional and not individually proven). Meaning UNKNOWN. NOTE (2026-11-12): dynamic harness run (qemu, ko-harness, 9 argument patterns): written by VPSS_HAL_SetSharpenCoef.";
        field {
            name = "word";
            desc = "32-bit word.";
            sw = rw;
            hw = r;
        } word[31:0];
    } NODE_W_2220 @ 0x2220;
    reg {
        name = "Word at offset 0x2224";
        desc = "Word 0x2224 (NEW in the arm-re rediff 2026-11-12). PROVENANCE: PROVEN offset and stored byte lanes 0123, cleared bit extents [25:16], written by VPSS_HAL_SetSharpenCoef (1 stores) in the path-sensitive static run (conditional paths and indexed loop records folded into the word; some are loop-built or conditional and not individually proven). Meaning UNKNOWN. NOTE (2026-11-12): dynamic harness run (qemu, ko-harness, 9 argument patterns): written by VPSS_HAL_SetSharpenCoef.";
        field {
            name = "word";
            desc = "32-bit word.";
            sw = rw;
            hw = r;
        } word[31:0];
    } NODE_W_2224 @ 0x2224;
    reg {
        name = "Word at offset 0x2228";
        desc = "Word 0x2228 (NEW in the arm-re rediff 2026-11-12). PROVENANCE: PROVEN offset and stored byte lanes 0123, cleared bit extents [28:16], written by VPSS_HAL_SetSharpenCoef (1 stores) in the path-sensitive static run (conditional paths and indexed loop records folded into the word; some are loop-built or conditional and not individually proven). Meaning UNKNOWN. NOTE (2026-11-12): dynamic harness run (qemu, ko-harness, 9 argument patterns): written by VPSS_HAL_SetSharpenCoef.";
        field {
            name = "word";
            desc = "32-bit word.";
            sw = rw;
            hw = r;
        } word[31:0];
    } NODE_W_2228 @ 0x2228;
    reg {
        name = "Word at offset 0x222C";
        desc = "Word 0x222C (NEW in the arm-re rediff 2026-11-12). PROVENANCE: PROVEN offset and stored byte lanes 0123, cleared bit extents [7:0] [28:16], written by VPSS_HAL_SetSharpenCoef (1 stores) in the path-sensitive static run (conditional paths and indexed loop records folded into the word; some are loop-built or conditional and not individually proven). Meaning UNKNOWN. NOTE (2026-11-12): dynamic harness run (qemu, ko-harness, 9 argument patterns): written by VPSS_HAL_SetSharpenCoef.";
        field {
            name = "word";
            desc = "32-bit word.";
            sw = rw;
            hw = r;
        } word[31:0];
    } NODE_W_222C @ 0x222C;
    reg {
        name = "Word at offset 0x2230";
        desc = "Word 0x2230 (NEW in the arm-re rediff 2026-11-12). PROVENANCE: PROVEN offset and stored byte lanes 0123, cleared bit extents [7:0] [28:16], written by VPSS_HAL_SetSharpenCoef (1 stores) in the path-sensitive static run (conditional paths and indexed loop records folded into the word; some are loop-built or conditional and not individually proven). Meaning UNKNOWN. NOTE (2026-11-12): dynamic harness run (qemu, ko-harness, 9 argument patterns): written by VPSS_HAL_SetSharpenCoef.";
        field {
            name = "word";
            desc = "32-bit word.";
            sw = rw;
            hw = r;
        } word[31:0];
    } NODE_W_2230 @ 0x2230;
    reg {
        name = "Word at offset 0x2234";
        desc = "Word 0x2234 (NEW in the arm-re rediff 2026-11-12). PROVENANCE: PROVEN offset and stored byte lanes 0123, cleared bit extents [23:0], written by VPSS_HAL_SetSharpenCoef (1 stores) in the path-sensitive static run (conditional paths and indexed loop records folded into the word; some are loop-built or conditional and not individually proven). Meaning UNKNOWN. NOTE (2026-11-12): dynamic harness run (qemu, ko-harness, 9 argument patterns): written by VPSS_HAL_SetSharpenCoef.";
        field {
            name = "word";
            desc = "32-bit word.";
            sw = rw;
            hw = r;
        } word[31:0];
    } NODE_W_2234 @ 0x2234;
    reg {
        name = "Word at offset 0x2238";
        desc = "Word 0x2238 (NEW in the arm-re rediff 2026-11-12). PROVENANCE: PROVEN offset and stored byte lanes 0123, cleared bit extents [23:0], written by VPSS_HAL_SetSharpenCoef (1 stores) in the path-sensitive static run (conditional paths and indexed loop records folded into the word; some are loop-built or conditional and not individually proven). Meaning UNKNOWN. NOTE (2026-11-12): dynamic harness run (qemu, ko-harness, 9 argument patterns): written by VPSS_HAL_SetSharpenCoef.";
        field {
            name = "word";
            desc = "32-bit word.";
            sw = rw;
            hw = r;
        } word[31:0];
    } NODE_W_2238 @ 0x2238;
    reg {
        name = "Word at offset 0x223C";
        desc = "Word 0x223C (NEW in the arm-re rediff 2026-11-12). PROVENANCE: PROVEN offset and stored byte lanes 0123, cleared bit extents [23:0], written by VPSS_HAL_SetSharpenCoef (1 stores) in the path-sensitive static run (conditional paths and indexed loop records folded into the word; some are loop-built or conditional and not individually proven). Meaning UNKNOWN. NOTE (2026-11-12): dynamic harness run (qemu, ko-harness, 9 argument patterns): written by VPSS_HAL_SetSharpenCoef.";
        field {
            name = "word";
            desc = "32-bit word.";
            sw = rw;
            hw = r;
        } word[31:0];
    } NODE_W_223C @ 0x223C;
    reg {
        name = "Word at offset 0x2240";
        desc = "Word 0x2240 (NEW in the arm-re rediff 2026-11-12). PROVENANCE: PROVEN offset and stored byte lanes 0123, cleared bit extents [7:0] [23:16], written by VPSS_HAL_SetSharpenCoef (1 stores) in the path-sensitive static run (conditional paths and indexed loop records folded into the word; some are loop-built or conditional and not individually proven). Meaning UNKNOWN. NOTE (2026-11-12): dynamic harness run (qemu, ko-harness, 9 argument patterns): written by VPSS_HAL_SetSharpenCoef.";
        field {
            name = "word";
            desc = "32-bit word.";
            sw = rw;
            hw = r;
        } word[31:0];
    } NODE_W_2240 @ 0x2240;
    reg {
        name = "Word at offset 0x2244";
        desc = "Word 0x2244 (NEW in the arm-re rediff 2026-11-12). PROVENANCE: PROVEN offset and stored byte lanes 0123, cleared bit extents [4:1] [12:8], written by VPSS_HAL_SetSharpenCoef (1 stores) in the path-sensitive static run (conditional paths and indexed loop records folded into the word; some are loop-built or conditional and not individually proven). Meaning UNKNOWN. NOTE (2026-11-12): dynamic harness run (qemu, ko-harness, 9 argument patterns): written by VPSS_HAL_SetSharpenCoef.";
        field {
            name = "word";
            desc = "32-bit word.";
            sw = rw;
            hw = r;
        } word[31:0];
    } NODE_W_2244 @ 0x2244;
    reg {
        name = "Word at offset 0x2248";
        desc = "Word 0x2248 (NEW in the arm-re rediff 2026-11-12). PROVENANCE: PROVEN offset and stored byte lanes 0123, cleared bit extents [15:0], written by VPSS_HAL_SetSharpenCoef (1 stores) in the path-sensitive static run (conditional paths and indexed loop records folded into the word; some are loop-built or conditional and not individually proven). Meaning UNKNOWN. NOTE (2026-11-12): dynamic harness run (qemu, ko-harness, 9 argument patterns): written by VPSS_HAL_SetSharpenCoef.";
        field {
            name = "word";
            desc = "32-bit word.";
            sw = rw;
            hw = r;
        } word[31:0];
    } NODE_W_2248 @ 0x2248;
    reg {
        name = "Word at offset 0x224C";
        desc = "Word 0x224C (NEW in the arm-re rediff 2026-11-12). PROVENANCE: PROVEN offset and stored byte lanes 0123, cleared bit extents [4:0] [10:8] [18:16], written by VPSS_HAL_SetSharpenCoef (1 stores) in the path-sensitive static run (conditional paths and indexed loop records folded into the word; some are loop-built or conditional and not individually proven). Meaning UNKNOWN. NOTE (2026-11-12): dynamic harness run (qemu, ko-harness, 9 argument patterns): written by VPSS_HAL_SetSharpenCoef.";
        field {
            name = "word";
            desc = "32-bit word.";
            sw = rw;
            hw = r;
        } word[31:0];
    } NODE_W_224C @ 0x224C;
    reg {
        name = "Word at offset 0x2250";
        desc = "Word 0x2250 (NEW in the arm-re rediff 2026-11-12). PROVENANCE: PROVEN offset and stored byte lanes 0123, cleared bit extents [25:16], written by VPSS_HAL_SetSharpenCoef (1 stores) in the path-sensitive static run (conditional paths and indexed loop records folded into the word; some are loop-built or conditional and not individually proven). Meaning UNKNOWN. NOTE (2026-11-12): dynamic harness run (qemu, ko-harness, 9 argument patterns): written by VPSS_HAL_SetSharpenCoef.";
        field {
            name = "word";
            desc = "32-bit word.";
            sw = rw;
            hw = r;
        } word[31:0];
    } NODE_W_2250 @ 0x2250;
    reg {
        name = "Word at offset 0x2254";
        desc = "Word 0x2254 (NEW in the arm-re rediff 2026-11-12). PROVENANCE: PROVEN offset and stored byte lanes 0123, cleared bit extents [7:0] [28:16], written by VPSS_HAL_SetSharpenCoef (1 stores) in the path-sensitive static run (conditional paths and indexed loop records folded into the word; some are loop-built or conditional and not individually proven). Meaning UNKNOWN. NOTE (2026-11-12): dynamic harness run (qemu, ko-harness, 9 argument patterns): written by VPSS_HAL_SetSharpenCoef.";
        field {
            name = "word";
            desc = "32-bit word.";
            sw = rw;
            hw = r;
        } word[31:0];
    } NODE_W_2254 @ 0x2254;
    reg {
        name = "Word at offset 0x2258";
        desc = "Word 0x2258 (NEW in the arm-re rediff 2026-11-12). PROVENANCE: PROVEN offset and stored byte lanes 0123, cleared bit extents [25:16], written by VPSS_HAL_SetSharpenCoef (1 stores) in the path-sensitive static run (conditional paths and indexed loop records folded into the word; some are loop-built or conditional and not individually proven). Meaning UNKNOWN. NOTE (2026-11-12): dynamic harness run (qemu, ko-harness, 9 argument patterns): written by VPSS_HAL_SetSharpenCoef.";
        field {
            name = "word";
            desc = "32-bit word.";
            sw = rw;
            hw = r;
        } word[31:0];
    } NODE_W_2258 @ 0x2258;
    reg {
        name = "Word at offset 0x225C";
        desc = "Word 0x225C (NEW in the arm-re rediff 2026-11-12). PROVENANCE: PROVEN offset and stored byte lanes 0123, cleared bit extents [7:0] [28:16], written by VPSS_HAL_SetSharpenCoef (1 stores) in the path-sensitive static run (conditional paths and indexed loop records folded into the word; some are loop-built or conditional and not individually proven). Meaning UNKNOWN. NOTE (2026-11-12): dynamic harness run (qemu, ko-harness, 9 argument patterns): written by VPSS_HAL_SetSharpenCoef.";
        field {
            name = "word";
            desc = "32-bit word.";
            sw = rw;
            hw = r;
        } word[31:0];
    } NODE_W_225C @ 0x225C;
    reg {
        name = "Word at offset 0x2260";
        desc = "Word 0x2260 (NEW in the arm-re rediff 2026-11-12). PROVENANCE: PROVEN offset and stored byte lanes 0123, cleared bit extents [31:0], written by VPSS_HAL_SetSharpenCoef (1 stores) in the path-sensitive static run (conditional paths and indexed loop records folded into the word; some are loop-built or conditional and not individually proven). Meaning UNKNOWN. NOTE (2026-11-12): dynamic harness run (qemu, ko-harness, 9 argument patterns): written by VPSS_HAL_SetSharpenCoef.";
        field {
            name = "word";
            desc = "32-bit word.";
            sw = rw;
            hw = r;
        } word[31:0];
    } NODE_W_2260 @ 0x2260;
    reg {
        name = "Word at offset 0x2264";
        desc = "Word 0x2264 (NEW in the arm-re rediff 2026-11-12). PROVENANCE: PROVEN offset and stored byte lanes 0123, cleared bit extents [31:0], written by VPSS_HAL_SetSharpenCoef (1 stores) in the path-sensitive static run (conditional paths and indexed loop records folded into the word; some are loop-built or conditional and not individually proven). Meaning UNKNOWN. NOTE (2026-11-12): dynamic harness run (qemu, ko-harness, 9 argument patterns): written by VPSS_HAL_SetSharpenCoef.";
        field {
            name = "word";
            desc = "32-bit word.";
            sw = rw;
            hw = r;
        } word[31:0];
    } NODE_W_2264 @ 0x2264;
    reg {
        name = "Word at offset 0x2268";
        desc = "Word 0x2268 (NEW in the arm-re rediff 2026-11-12). PROVENANCE: PROVEN offset and stored byte lanes 0123, cleared bit extents [31:0], written by VPSS_HAL_SetSharpenCoef (1 stores) in the path-sensitive static run (conditional paths and indexed loop records folded into the word; some are loop-built or conditional and not individually proven). Meaning UNKNOWN. NOTE (2026-11-12): dynamic harness run (qemu, ko-harness, 9 argument patterns): written by VPSS_HAL_SetSharpenCoef.";
        field {
            name = "word";
            desc = "32-bit word.";
            sw = rw;
            hw = r;
        } word[31:0];
    } NODE_W_2268 @ 0x2268;
    reg {
        name = "Word at offset 0x226C";
        desc = "Word 0x226C (NEW in the arm-re rediff 2026-11-12). PROVENANCE: PROVEN offset and stored byte lanes 0123, cleared bit extents [31:0], written by VPSS_HAL_SetSharpenCoef (1 stores) in the path-sensitive static run (conditional paths and indexed loop records folded into the word; some are loop-built or conditional and not individually proven). Meaning UNKNOWN. NOTE (2026-11-12): dynamic harness run (qemu, ko-harness, 9 argument patterns): written by VPSS_HAL_SetSharpenCoef.";
        field {
            name = "word";
            desc = "32-bit word.";
            sw = rw;
            hw = r;
        } word[31:0];
    } NODE_W_226C @ 0x226C;
    reg {
        name = "Word at offset 0x2270";
        desc = "Word 0x2270 (NEW in the arm-re rediff 2026-11-12). PROVENANCE: PROVEN offset and stored byte lanes 0123, cleared bit extents [31:0], written by VPSS_HAL_SetSharpenCoef (1 stores) in the path-sensitive static run (conditional paths and indexed loop records folded into the word; some are loop-built or conditional and not individually proven). Meaning UNKNOWN. NOTE (2026-11-12): dynamic harness run (qemu, ko-harness, 9 argument patterns): written by VPSS_HAL_SetSharpenCoef.";
        field {
            name = "word";
            desc = "32-bit word.";
            sw = rw;
            hw = r;
        } word[31:0];
    } NODE_W_2270 @ 0x2270;
    reg {
        name = "Word at offset 0x2274";
        desc = "Word 0x2274 (NEW in the arm-re rediff 2026-11-12). PROVENANCE: PROVEN offset and stored byte lanes 0123, cleared bit extents [31:0], written by VPSS_HAL_SetSharpenCoef (1 stores) in the path-sensitive static run (conditional paths and indexed loop records folded into the word; some are loop-built or conditional and not individually proven). Meaning UNKNOWN. NOTE (2026-11-12): dynamic harness run (qemu, ko-harness, 9 argument patterns): written by VPSS_HAL_SetSharpenCoef.";
        field {
            name = "word";
            desc = "32-bit word.";
            sw = rw;
            hw = r;
        } word[31:0];
    } NODE_W_2274 @ 0x2274;
    reg {
        name = "Word at offset 0x2278";
        desc = "Word 0x2278 (NEW in the arm-re rediff 2026-11-12). PROVENANCE: PROVEN offset and stored byte lanes 0123, cleared bit extents [31:0], written by VPSS_HAL_SetSharpenCoef (1 stores) in the path-sensitive static run (conditional paths and indexed loop records folded into the word; some are loop-built or conditional and not individually proven). Meaning UNKNOWN. NOTE (2026-11-12): dynamic harness run (qemu, ko-harness, 9 argument patterns): written by VPSS_HAL_SetSharpenCoef.";
        field {
            name = "word";
            desc = "32-bit word.";
            sw = rw;
            hw = r;
        } word[31:0];
    } NODE_W_2278 @ 0x2278;
    reg {
        name = "Word at offset 0x227C";
        desc = "Word 0x227C (NEW in the arm-re rediff 2026-11-12). PROVENANCE: PROVEN offset and stored byte lanes 0123, cleared bit extents [31:0], written by VPSS_HAL_SetSharpenCoef (1 stores) in the path-sensitive static run (conditional paths and indexed loop records folded into the word; some are loop-built or conditional and not individually proven). Meaning UNKNOWN. NOTE (2026-11-12): dynamic harness run (qemu, ko-harness, 9 argument patterns): written by VPSS_HAL_SetSharpenCoef.";
        field {
            name = "word";
            desc = "32-bit word.";
            sw = rw;
            hw = r;
        } word[31:0];
    } NODE_W_227C @ 0x227C;
    reg {
        name = "Word at offset 0x22E4";
        desc = "Word 0x22E4 (NEW in the arm-re rediff 2026-11-12). PROVENANCE: PROVEN offset and stored byte lanes 0123, cleared bit extents [0:0], written by VPSS_HAL_SetSharpenCoef (1 stores) in the path-sensitive static run (conditional paths and indexed loop records folded into the word; some are loop-built or conditional and not individually proven). Meaning UNKNOWN. NOTE (2026-11-12): dynamic harness run (qemu, ko-harness, 9 argument patterns): written by VPSS_HAL_SetSharpenCoef.";
        field {
            name = "word";
            desc = "32-bit word.";
            sw = rw;
            hw = r;
        } word[31:0];
    } NODE_W_22E4 @ 0x22E4;
    reg {
        name = "Word at offset 0x22E8";
        desc = "Word 0x22E8 (NEW in the arm-re rediff 2026-11-12). PROVENANCE: PROVEN offset and stored byte lanes 0123, cleared bit extents [13:1], written by VPSS_HAL_SetSharpenCoef (1 stores) in the path-sensitive static run (conditional paths and indexed loop records folded into the word; some are loop-built or conditional and not individually proven). Meaning UNKNOWN. NOTE (2026-11-12): dynamic harness run (qemu, ko-harness, 9 argument patterns): written by VPSS_HAL_SetSharpenCoef.";
        field {
            name = "word";
            desc = "32-bit word.";
            sw = rw;
            hw = r;
        } word[31:0];
    } NODE_W_22E8 @ 0x22E8;
    reg {
        name = "Word at offset 0x22EC";
        desc = "Word 0x22EC (NEW in the arm-re rediff 2026-11-12). PROVENANCE: PROVEN offset and stored byte lanes 0123, cleared bit extents [0:0], written by VPSS_HAL_SetSharpenCoef (1 stores) in the path-sensitive static run (conditional paths and indexed loop records folded into the word; some are loop-built or conditional and not individually proven). Meaning UNKNOWN. NOTE (2026-11-12): dynamic harness run (qemu, ko-harness, 9 argument patterns): written by VPSS_HAL_SetSharpenCoef.";
        field {
            name = "word";
            desc = "32-bit word.";
            sw = rw;
            hw = r;
        } word[31:0];
    } NODE_W_22EC @ 0x22EC;
    reg {
        name = "Word at offset 0x22F0";
        desc = "Word 0x22F0 (NEW in the arm-re rediff 2026-11-12). PROVENANCE: PROVEN offset and stored byte lanes 0123, cleared bit extents [28:16], written by VPSS_HAL_SetSharpenCoef (1 stores) in the path-sensitive static run (conditional paths and indexed loop records folded into the word; some are loop-built or conditional and not individually proven). Meaning UNKNOWN. NOTE (2026-11-12): dynamic harness run (qemu, ko-harness, 9 argument patterns): written by VPSS_HAL_SetSharpenCoef.";
        field {
            name = "word";
            desc = "32-bit word.";
            sw = rw;
            hw = r;
        } word[31:0];
    } NODE_W_22F0 @ 0x22F0;
    reg {
        name = "Word at offset 0x22F4";
        desc = "Word 0x22F4 (NEW in the arm-re rediff 2026-11-12). PROVENANCE: PROVEN offset and stored byte lanes 0123, cleared bit extents none seen, written by VPSS_HAL_SetSharpenCoef (1 stores) in the path-sensitive static run (conditional paths and indexed loop records folded into the word; some are loop-built or conditional and not individually proven). Meaning UNKNOWN. NOTE (2026-11-12): dynamic harness run (qemu, ko-harness, 9 argument patterns): written by VPSS_HAL_SetSharpenCoef.";
        field {
            name = "word";
            desc = "32-bit word.";
            sw = rw;
            hw = r;
        } word[31:0];
    } NODE_W_22F4 @ 0x22F4;
    reg {
        name = "Word at offset 0x22F8";
        desc = "Word 0x22F8 (NEW in the arm-re rediff 2026-11-12). PROVENANCE: PROVEN offset and stored byte lanes 0123, cleared bit extents none seen, written by VPSS_HAL_SetSharpenCoef (1 stores) in the path-sensitive static run (conditional paths and indexed loop records folded into the word; some are loop-built or conditional and not individually proven). Meaning UNKNOWN. NOTE (2026-11-12): dynamic harness run (qemu, ko-harness, 9 argument patterns): written by VPSS_HAL_SetSharpenCoef.";
        field {
            name = "word";
            desc = "32-bit word.";
            sw = rw;
            hw = r;
        } word[31:0];
    } NODE_W_22F8 @ 0x22F8;
    reg {
        name = "Word at offset 0x2328";
        desc = "Word 0x2328 (NEW in the arm-re rediff 2026-11-12). PROVENANCE: PROVEN offset and stored byte lanes 0123, cleared bit extents [16:0] [24:24], written by VPSS_HAL_SetSharpenCoef (1 stores) in the path-sensitive static run (conditional paths and indexed loop records folded into the word; some are loop-built or conditional and not individually proven). Meaning UNKNOWN. NOTE (2026-11-12): dynamic harness run (qemu, ko-harness, 9 argument patterns): written by VPSS_HAL_SetSharpenCoef.";
        field {
            name = "word";
            desc = "32-bit word.";
            sw = rw;
            hw = r;
        } word[31:0];
    } NODE_W_2328 @ 0x2328;
    reg {
        name = "Word at offset 0x2330";
        desc = "Word 0x2330 (NEW in the arm-re rediff 2026-11-12). PROVENANCE: PROVEN offset and stored byte lanes 0123, cleared bit extents [7:0] [23:16], written by VPSS_HAL_SetSharpenCoef (1 stores) in the path-sensitive static run (conditional paths and indexed loop records folded into the word; some are loop-built or conditional and not individually proven). Meaning UNKNOWN. NOTE (2026-11-12): dynamic harness run (qemu, ko-harness, 9 argument patterns): written by VPSS_HAL_SetSharpenCoef.";
        field {
            name = "word";
            desc = "32-bit word.";
            sw = rw;
            hw = r;
        } word[31:0];
    } NODE_W_2330 @ 0x2330;
    reg {
        name = "Word at offset 0x2334";
        desc = "Word 0x2334 (NEW in the arm-re rediff 2026-11-12). PROVENANCE: PROVEN offset and stored byte lanes 0123, cleared bit extents [23:16], written by VPSS_HAL_SetSharpenCoef (1 stores) in the path-sensitive static run (conditional paths and indexed loop records folded into the word; some are loop-built or conditional and not individually proven). Meaning UNKNOWN. NOTE (2026-11-12): dynamic harness run (qemu, ko-harness, 9 argument patterns): written by VPSS_HAL_SetSharpenCoef.";
        field {
            name = "word";
            desc = "32-bit word.";
            sw = rw;
            hw = r;
        } word[31:0];
    } NODE_W_2334 @ 0x2334;
    reg {
        name = "Word at offset 0x2338";
        desc = "Word 0x2338 (NEW in the arm-re rediff 2026-11-12). PROVENANCE: PROVEN offset and stored byte lanes 0123, cleared bit extents [7:0] [23:16], written by VPSS_HAL_SetSharpenCoef (1 stores) in the path-sensitive static run (conditional paths and indexed loop records folded into the word; some are loop-built or conditional and not individually proven). Meaning UNKNOWN. NOTE (2026-11-12): dynamic harness run (qemu, ko-harness, 9 argument patterns): written by VPSS_HAL_SetSharpenCoef.";
        field {
            name = "word";
            desc = "32-bit word.";
            sw = rw;
            hw = r;
        } word[31:0];
    } NODE_W_2338 @ 0x2338;
    reg {
        name = "Word at offset 0x233C";
        desc = "Word 0x233C (NEW in the arm-re rediff 2026-11-12). PROVENANCE: PROVEN offset and stored byte lanes 0123, cleared bit extents [23:16], written by VPSS_HAL_SetSharpenCoef (1 stores) in the path-sensitive static run (conditional paths and indexed loop records folded into the word; some are loop-built or conditional and not individually proven). Meaning UNKNOWN. NOTE (2026-11-12): dynamic harness run (qemu, ko-harness, 9 argument patterns): written by VPSS_HAL_SetSharpenCoef.";
        field {
            name = "word";
            desc = "32-bit word.";
            sw = rw;
            hw = r;
        } word[31:0];
    } NODE_W_233C @ 0x233C;
    reg {
        name = "Word at offset 0x2340";
        desc = "Word 0x2340 (NEW in the arm-re rediff 2026-11-12). PROVENANCE: PROVEN offset and stored byte lanes 0123, cleared bit extents [7:0] [23:16], written by VPSS_HAL_SetSharpenCoef (1 stores) in the path-sensitive static run (conditional paths and indexed loop records folded into the word; some are loop-built or conditional and not individually proven). Meaning UNKNOWN. NOTE (2026-11-12): dynamic harness run (qemu, ko-harness, 9 argument patterns): written by VPSS_HAL_SetSharpenCoef.";
        field {
            name = "word";
            desc = "32-bit word.";
            sw = rw;
            hw = r;
        } word[31:0];
    } NODE_W_2340 @ 0x2340;
    reg {
        name = "Word at offset 0x2344";
        desc = "Word 0x2344 (NEW in the arm-re rediff 2026-11-12). PROVENANCE: PROVEN offset and stored byte lanes 0123, cleared bit extents [23:16], written by VPSS_HAL_SetSharpenCoef (1 stores) in the path-sensitive static run (conditional paths and indexed loop records folded into the word; some are loop-built or conditional and not individually proven). Meaning UNKNOWN. NOTE (2026-11-12): dynamic harness run (qemu, ko-harness, 9 argument patterns): written by VPSS_HAL_SetSharpenCoef.";
        field {
            name = "word";
            desc = "32-bit word.";
            sw = rw;
            hw = r;
        } word[31:0];
    } NODE_W_2344 @ 0x2344;
    reg {
        name = "Word at offset 0x2348";
        desc = "Word 0x2348 (NEW in the arm-re rediff 2026-11-12). PROVENANCE: PROVEN offset and stored byte lanes 0123, cleared bit extents [7:0] [23:16], written by VPSS_HAL_SetSharpenCoef (1 stores) in the path-sensitive static run (conditional paths and indexed loop records folded into the word; some are loop-built or conditional and not individually proven). Meaning UNKNOWN. NOTE (2026-11-12): dynamic harness run (qemu, ko-harness, 9 argument patterns): written by VPSS_HAL_SetSharpenCoef.";
        field {
            name = "word";
            desc = "32-bit word.";
            sw = rw;
            hw = r;
        } word[31:0];
    } NODE_W_2348 @ 0x2348;
    reg {
        name = "Word at offset 0x234C";
        desc = "Word 0x234C (NEW in the arm-re rediff 2026-11-12). PROVENANCE: PROVEN offset and stored byte lanes 0123, cleared bit extents [23:16], written by VPSS_HAL_SetSharpenCoef (1 stores) in the path-sensitive static run (conditional paths and indexed loop records folded into the word; some are loop-built or conditional and not individually proven). Meaning UNKNOWN. NOTE (2026-11-12): dynamic harness run (qemu, ko-harness, 9 argument patterns): written by VPSS_HAL_SetSharpenCoef.";
        field {
            name = "word";
            desc = "32-bit word.";
            sw = rw;
            hw = r;
        } word[31:0];
    } NODE_W_234C @ 0x234C;
    reg {
        name = "Word at offset 0x2350";
        desc = "Word 0x2350 (NEW in the arm-re rediff 2026-11-12). PROVENANCE: PROVEN offset and stored byte lanes 0123, cleared bit extents [7:0] [23:16], written by VPSS_HAL_SetSharpenCoef (1 stores) in the path-sensitive static run (conditional paths and indexed loop records folded into the word; some are loop-built or conditional and not individually proven). Meaning UNKNOWN. NOTE (2026-11-12): dynamic harness run (qemu, ko-harness, 9 argument patterns): written by VPSS_HAL_SetSharpenCoef.";
        field {
            name = "word";
            desc = "32-bit word.";
            sw = rw;
            hw = r;
        } word[31:0];
    } NODE_W_2350 @ 0x2350;
    reg {
        name = "Word at offset 0x2354";
        desc = "Word 0x2354 (NEW in the arm-re rediff 2026-11-12). PROVENANCE: PROVEN offset and stored byte lanes 0123, cleared bit extents [3:0] [16:16], written by VPSS_HAL_SetSharpenCoef (1 stores) in the path-sensitive static run (conditional paths and indexed loop records folded into the word; some are loop-built or conditional and not individually proven). Meaning UNKNOWN. NOTE (2026-11-12): dynamic harness run (qemu, ko-harness, 9 argument patterns): written by VPSS_HAL_SetSharpenCoef.";
        field {
            name = "word";
            desc = "32-bit word.";
            sw = rw;
            hw = r;
        } word[31:0];
    } NODE_W_2354 @ 0x2354;
    reg {
        name = "Word at offset 0x2358";
        desc = "Word 0x2358 (NEW in the arm-re rediff 2026-11-12). PROVENANCE: PROVEN offset and stored byte lanes 0123, cleared bit extents [7:0], written by VPSS_HAL_SetSharpenCoef (1 stores) in the path-sensitive static run (conditional paths and indexed loop records folded into the word; some are loop-built or conditional and not individually proven). Meaning UNKNOWN. NOTE (2026-11-12): dynamic harness run (qemu, ko-harness, 9 argument patterns): written by VPSS_HAL_SetSharpenCoef.";
        field {
            name = "word";
            desc = "32-bit word.";
            sw = rw;
            hw = r;
        } word[31:0];
    } NODE_W_2358 @ 0x2358;
    reg {
        name = "Word at offset 0x23E4";
        desc = "Word 0x23E4 (NEW in the arm-re rediff 2026-11-12). PROVENANCE: PROVEN offset and stored byte lanes 0123, cleared bit extents [0:0], written by VPSS_HAL_SetSharpenCoef (1 stores) in the path-sensitive static run (conditional paths and indexed loop records folded into the word; some are loop-built or conditional and not individually proven). Meaning UNKNOWN. NOTE (2026-11-12): dynamic harness run (qemu, ko-harness, 9 argument patterns): written by VPSS_HAL_SetSharpenCoef.";
        field {
            name = "word";
            desc = "32-bit word.";
            sw = rw;
            hw = r;
        } word[31:0];
    } NODE_W_23E4 @ 0x23E4;
    reg {
        name = "Word at offset 0x23EC";
        desc = "Word 0x23EC (NEW in the arm-re rediff 2026-11-12). PROVENANCE: PROVEN offset and stored byte lanes 0123, cleared bit extents [0:0], written by VPSS_HAL_SetSharpenCoef (1 stores) in the path-sensitive static run (conditional paths and indexed loop records folded into the word; some are loop-built or conditional and not individually proven). Meaning UNKNOWN. NOTE (2026-11-12): dynamic harness run (qemu, ko-harness, 9 argument patterns): written by VPSS_HAL_SetSharpenCoef.";
        field {
            name = "word";
            desc = "32-bit word.";
            sw = rw;
            hw = r;
        } word[31:0];
    } NODE_W_23EC @ 0x23EC;
    reg {
        name = "Word at offset 0x2400";
        desc = "Word 0x2400 (NEW in the arm-re rediff 2026-11-12). PROVENANCE: PROVEN offset and stored byte lanes 0123, cleared bit extents [0:0] [1:1] [2:2] [3:3], written by VPSS_HAL_SetMosaic (4 stores) in the path-sensitive static run (conditional paths and indexed loop records folded into the word; some are loop-built or conditional and not individually proven). Meaning UNKNOWN.";
        field {
            name = "word";
            desc = "32-bit word.";
            sw = rw;
            hw = r;
        } word[31:0];
    } NODE_W_2400 @ 0x2400;
    reg {
        name = "Word at offset 0x2404";
        desc = "Word 0x2404 (NEW in the arm-re rediff 2026-11-12). PROVENANCE: PROVEN offset and stored byte lanes 0123, cleared bit extents [1:0], written by VPSS_HAL_SetMosaic (4 stores) in the path-sensitive static run (conditional paths and indexed loop records folded into the word; some are loop-built or conditional and not individually proven). Meaning UNKNOWN.";
        field {
            name = "word";
            desc = "32-bit word.";
            sw = rw;
            hw = r;
        } word[31:0];
    } NODE_W_2404 @ 0x2404;
    reg {
        name = "Word at offset 0x2408";
        desc = "Word 0x2408 (NEW in the arm-re rediff 2026-11-12). PROVENANCE: PROVEN offset and stored byte lanes 0123, cleared bit extents none seen, written by VPSS_HAL_SetMosaic (1 stores) in the path-sensitive static run (conditional paths and indexed loop records folded into the word; some are loop-built or conditional and not individually proven). Meaning UNKNOWN.";
        field {
            name = "word";
            desc = "32-bit word.";
            sw = rw;
            hw = r;
        } word[31:0];
    } NODE_W_2408 @ 0x2408;
    reg {
        name = "Word at offset 0x240C";
        desc = "Word 0x240C (NEW in the arm-re rediff 2026-11-12). PROVENANCE: PROVEN offset and stored byte lanes 0123, cleared bit extents none seen, written by VPSS_HAL_SetMosaic (4 stores) in the path-sensitive static run (conditional paths and indexed loop records folded into the word; some are loop-built or conditional and not individually proven). Meaning UNKNOWN.";
        field {
            name = "word";
            desc = "32-bit word.";
            sw = rw;
            hw = r;
        } word[31:0];
    } NODE_W_240C @ 0x240C;
    reg {
        name = "Word at offset 0x2410";
        desc = "Word 0x2410 (NEW in the arm-re rediff 2026-11-12). PROVENANCE: PROVEN offset and stored byte lanes 0123, cleared bit extents none seen, written by VPSS_HAL_SetMosaic (1 stores) in the path-sensitive static run (conditional paths and indexed loop records folded into the word; some are loop-built or conditional and not individually proven). Meaning UNKNOWN.";
        field {
            name = "word";
            desc = "32-bit word.";
            sw = rw;
            hw = r;
        } word[31:0];
    } NODE_W_2410 @ 0x2410;
    reg {
        name = "Word at offset 0x2414";
        desc = "Word 0x2414 (NEW in the arm-re rediff 2026-11-12). PROVENANCE: PROVEN offset and stored byte lanes 0123, cleared bit extents none seen, written by VPSS_HAL_SetMosaic (4 stores) in the path-sensitive static run (conditional paths and indexed loop records folded into the word; some are loop-built or conditional and not individually proven). Meaning UNKNOWN.";
        field {
            name = "word";
            desc = "32-bit word.";
            sw = rw;
            hw = r;
        } word[31:0];
    } NODE_W_2414 @ 0x2414;
    reg {
        name = "Word at offset 0x2418";
        desc = "Word 0x2418 (NEW in the arm-re rediff 2026-11-12). PROVENANCE: PROVEN offset and stored byte lanes 0123, cleared bit extents none seen, written by VPSS_HAL_SetMosaic (1 stores) in the path-sensitive static run (conditional paths and indexed loop records folded into the word; some are loop-built or conditional and not individually proven). Meaning UNKNOWN.";
        field {
            name = "word";
            desc = "32-bit word.";
            sw = rw;
            hw = r;
        } word[31:0];
    } NODE_W_2418 @ 0x2418;
    reg {
        name = "Word at offset 0x241C";
        desc = "Word 0x241C (NEW in the arm-re rediff 2026-11-12). PROVENANCE: PROVEN offset and stored byte lanes 0123, cleared bit extents none seen, written by VPSS_HAL_SetMosaic (4 stores) in the path-sensitive static run (conditional paths and indexed loop records folded into the word; some are loop-built or conditional and not individually proven). Meaning UNKNOWN.";
        field {
            name = "word";
            desc = "32-bit word.";
            sw = rw;
            hw = r;
        } word[31:0];
    } NODE_W_241C @ 0x241C;
    reg {
        name = "Word at offset 0x2420";
        desc = "Word 0x2420 (NEW in the arm-re rediff 2026-11-12). PROVENANCE: PROVEN offset and stored byte lanes 0123, cleared bit extents none seen, written by VPSS_HAL_SetMosaic (1 stores) in the path-sensitive static run (conditional paths and indexed loop records folded into the word; some are loop-built or conditional and not individually proven). Meaning UNKNOWN.";
        field {
            name = "word";
            desc = "32-bit word.";
            sw = rw;
            hw = r;
        } word[31:0];
    } NODE_W_2420 @ 0x2420;
    reg {
        name = "Word at offset 0x2424";
        desc = "Word 0x2424 (NEW in the arm-re rediff 2026-11-12). PROVENANCE: PROVEN offset and stored byte lanes 0123, cleared bit extents none seen, written by VPSS_HAL_SetMosaic (4 stores) in the path-sensitive static run (conditional paths and indexed loop records folded into the word; some are loop-built or conditional and not individually proven). Meaning UNKNOWN.";
        field {
            name = "word";
            desc = "32-bit word.";
            sw = rw;
            hw = r;
        } word[31:0];
    } NODE_W_2424 @ 0x2424;
    reg {
        name = "Word at offset 0x2600";
        desc = "Word 0x2600 (NEW in the arm-re rediff 2026-11-12). PROVENANCE: PROVEN offset and stored byte lanes 0123, cleared bit extents [7:0], written by VPSS_HAL_SetCoverCtrl (1 stores) in the path-sensitive static run (conditional paths and indexed loop records folded into the word; some are loop-built or conditional and not individually proven). Meaning UNKNOWN. NOTE (2026-11-12): dynamic harness run (qemu, ko-harness, 9 argument patterns): written by VPSS_HAL_SetCoverCtrl.";
        field {
            name = "word";
            desc = "32-bit word.";
            sw = rw;
            hw = r;
        } word[31:0];
    } NODE_W_2600 @ 0x2600;
    reg {
        name = "Word at offset 0x2604";
        desc = "Word 0x2604 (NEW in the arm-re rediff 2026-11-12). PROVENANCE: PROVEN offset and stored byte lanes 0123, cleared bit extents [23:0], written by VPSS_HAL_SetCover (1 stores) in the path-sensitive static run (conditional paths and indexed loop records folded into the word; some are loop-built or conditional and not individually proven). Meaning UNKNOWN.";
        field {
            name = "word";
            desc = "32-bit word.";
            sw = rw;
            hw = r;
        } word[31:0];
    } NODE_W_2604 @ 0x2604;
    reg {
        name = "Word at offset 0x2608";
        desc = "Word 0x2608 (NEW in the arm-re rediff 2026-11-12). PROVENANCE: PROVEN offset and stored byte lanes 0123, cleared bit extents none seen, written by VPSS_HAL_SetCover (1 stores) in the path-sensitive static run (conditional paths and indexed loop records folded into the word; some are loop-built or conditional and not individually proven). Meaning UNKNOWN.";
        field {
            name = "word";
            desc = "32-bit word.";
            sw = rw;
            hw = r;
        } word[31:0];
    } NODE_W_2608 @ 0x2608;
    reg {
        name = "Word at offset 0x260C";
        desc = "Word 0x260C (NEW in the arm-re rediff 2026-11-12). PROVENANCE: PROVEN offset and stored byte lanes 0123, cleared bit extents none seen, written by VPSS_HAL_SetCover (1 stores) in the path-sensitive static run (conditional paths and indexed loop records folded into the word; some are loop-built or conditional and not individually proven). Meaning UNKNOWN.";
        field {
            name = "word";
            desc = "32-bit word.";
            sw = rw;
            hw = r;
        } word[31:0];
    } NODE_W_260C @ 0x260C;
    reg {
        name = "Word at offset 0x2610";
        desc = "Word 0x2610 (NEW in the arm-re rediff 2026-11-12). PROVENANCE: PROVEN offset and stored byte lanes 0123, cleared bit extents none seen, written by VPSS_HAL_SetCover (1 stores) in the path-sensitive static run (conditional paths and indexed loop records folded into the word; some are loop-built or conditional and not individually proven). Meaning UNKNOWN.";
        field {
            name = "word";
            desc = "32-bit word.";
            sw = rw;
            hw = r;
        } word[31:0];
    } NODE_W_2610 @ 0x2610;
    reg {
        name = "Word at offset 0x2614";
        desc = "Word 0x2614 (NEW in the arm-re rediff 2026-11-12). PROVENANCE: PROVEN offset and stored byte lanes 0123, cleared bit extents none seen, written by VPSS_HAL_SetCover (1 stores) in the path-sensitive static run (conditional paths and indexed loop records folded into the word; some are loop-built or conditional and not individually proven). Meaning UNKNOWN.";
        field {
            name = "word";
            desc = "32-bit word.";
            sw = rw;
            hw = r;
        } word[31:0];
    } NODE_W_2614 @ 0x2614;
    reg {
        name = "Word at offset 0x2618";
        desc = "Word 0x2618 (NEW in the arm-re rediff 2026-11-12). PROVENANCE: PROVEN offset and stored byte lanes 0123, cleared bit extents [31:0] [28:1], written by VPSS_HAL_SetCover1 (2 stores) in the path-sensitive static run (conditional paths and indexed loop records folded into the word; some are loop-built or conditional and not individually proven). Meaning UNKNOWN.";
        field {
            name = "word";
            desc = "32-bit word.";
            sw = rw;
            hw = r;
        } word[31:0];
    } NODE_W_2618 @ 0x2618;
    reg {
        name = "Word at offset 0x261C";
        desc = "Word 0x261C (NEW in the arm-re rediff 2026-11-12). PROVENANCE: PROVEN offset and stored byte lanes 0123, cleared bit extents [31:0] [28:1], written by VPSS_HAL_SetCover1 (2 stores) in the path-sensitive static run (conditional paths and indexed loop records folded into the word; some are loop-built or conditional and not individually proven). Meaning UNKNOWN.";
        field {
            name = "word";
            desc = "32-bit word.";
            sw = rw;
            hw = r;
        } word[31:0];
    } NODE_W_261C @ 0x261C;
    reg {
        name = "Word at offset 0x2620";
        desc = "Word 0x2620 (NEW in the arm-re rediff 2026-11-12). PROVENANCE: PROVEN offset and stored byte lanes 0123, cleared bit extents [31:0] [28:1], written by VPSS_HAL_SetCover1 (2 stores) in the path-sensitive static run (conditional paths and indexed loop records folded into the word; some are loop-built or conditional and not individually proven). Meaning UNKNOWN.";
        field {
            name = "word";
            desc = "32-bit word.";
            sw = rw;
            hw = r;
        } word[31:0];
    } NODE_W_2620 @ 0x2620;
    reg {
        name = "Word at offset 0x2624";
        desc = "Word 0x2624 (NEW in the arm-re rediff 2026-11-12). PROVENANCE: PROVEN offset and stored byte lanes 0123, cleared bit extents [31:0] [28:1], written by VPSS_HAL_SetCover1 (2 stores) in the path-sensitive static run (conditional paths and indexed loop records folded into the word; some are loop-built or conditional and not individually proven). Meaning UNKNOWN.";
        field {
            name = "word";
            desc = "32-bit word.";
            sw = rw;
            hw = r;
        } word[31:0];
    } NODE_W_2624 @ 0x2624;
    reg {
        name = "Word at offset 0x2628";
        desc = "Word 0x2628 (NEW in the arm-re rediff 2026-11-12). PROVENANCE: PROVEN offset and stored byte lanes 0123, cleared bit extents [31:0] [28:1], written by VPSS_HAL_SetCover1 (2 stores) in the path-sensitive static run (conditional paths and indexed loop records folded into the word; some are loop-built or conditional and not individually proven). Meaning UNKNOWN.";
        field {
            name = "word";
            desc = "32-bit word.";
            sw = rw;
            hw = r;
        } word[31:0];
    } NODE_W_2628 @ 0x2628;
    reg {
        name = "Word at offset 0x262C";
        desc = "Word 0x262C (NEW in the arm-re rediff 2026-11-12). PROVENANCE: PROVEN offset and stored byte lanes 0123, cleared bit extents [31:0] [28:1], written by VPSS_HAL_SetCover1 (2 stores) in the path-sensitive static run (conditional paths and indexed loop records folded into the word; some are loop-built or conditional and not individually proven). Meaning UNKNOWN.";
        field {
            name = "word";
            desc = "32-bit word.";
            sw = rw;
            hw = r;
        } word[31:0];
    } NODE_W_262C @ 0x262C;
    reg {
        name = "Word at offset 0x28C4";
        desc = "Word 0x28C4 (NEW 2026-11-12). PROVENANCE: PROVEN offset, written in the dynamic harness run (qemu, ko-harness) by VPSS_HAL_SetCover; not found by the static run. Meaning UNKNOWN.";
        field {
            name = "word";
            desc = "32-bit word.";
            sw = rw;
            hw = r;
        } word[31:0];
    } NODE_W_28C4 @ 0x28C4;
    reg {
        name = "Word at offset 0x28C8";
        desc = "Word 0x28C8 (NEW 2026-11-12). PROVENANCE: PROVEN offset, written in the dynamic harness run (qemu, ko-harness) by VPSS_HAL_SetCover; not found by the static run. Meaning UNKNOWN.";
        field {
            name = "word";
            desc = "32-bit word.";
            sw = rw;
            hw = r;
        } word[31:0];
    } NODE_W_28C8 @ 0x28C8;
    reg {
        name = "Word at offset 0x28CC";
        desc = "Word 0x28CC (NEW 2026-11-12). PROVENANCE: PROVEN offset, written in the dynamic harness run (qemu, ko-harness) by VPSS_HAL_SetCover; not found by the static run. Meaning UNKNOWN.";
        field {
            name = "word";
            desc = "32-bit word.";
            sw = rw;
            hw = r;
        } word[31:0];
    } NODE_W_28CC @ 0x28CC;
    reg {
        name = "Word at offset 0x28D0";
        desc = "Word 0x28D0 (NEW 2026-11-12). PROVENANCE: PROVEN offset, written in the dynamic harness run (qemu, ko-harness) by VPSS_HAL_SetCover; not found by the static run. Meaning UNKNOWN.";
        field {
            name = "word";
            desc = "32-bit word.";
            sw = rw;
            hw = r;
        } word[31:0];
    } NODE_W_28D0 @ 0x28D0;
    reg {
        name = "Word at offset 0x28D4";
        desc = "Word 0x28D4 (NEW 2026-11-12). PROVENANCE: PROVEN offset, written in the dynamic harness run (qemu, ko-harness) by VPSS_HAL_SetCover; not found by the static run. Meaning UNKNOWN.";
        field {
            name = "word";
            desc = "32-bit word.";
            sw = rw;
            hw = r;
        } word[31:0];
    } NODE_W_28D4 @ 0x28D4;
    reg {
        name = "Word at offset 0x28D8";
        desc = "Word 0x28D8 (NEW 2026-11-12). PROVENANCE: PROVEN offset, written in the dynamic harness run (qemu, ko-harness) by VPSS_HAL_SetCover1; not found by the static run. Meaning UNKNOWN.";
        field {
            name = "word";
            desc = "32-bit word.";
            sw = rw;
            hw = r;
        } word[31:0];
    } NODE_W_28D8 @ 0x28D8;
    reg {
        name = "Word at offset 0x28DC";
        desc = "Word 0x28DC (NEW 2026-11-12). PROVENANCE: PROVEN offset, written in the dynamic harness run (qemu, ko-harness) by VPSS_HAL_SetCover1; not found by the static run. Meaning UNKNOWN.";
        field {
            name = "word";
            desc = "32-bit word.";
            sw = rw;
            hw = r;
        } word[31:0];
    } NODE_W_28DC @ 0x28DC;
    reg {
        name = "Word at offset 0x28E0";
        desc = "Word 0x28E0 (NEW 2026-11-12). PROVENANCE: PROVEN offset, written in the dynamic harness run (qemu, ko-harness) by VPSS_HAL_SetCover1; not found by the static run. Meaning UNKNOWN.";
        field {
            name = "word";
            desc = "32-bit word.";
            sw = rw;
            hw = r;
        } word[31:0];
    } NODE_W_28E0 @ 0x28E0;
    reg {
        name = "Word at offset 0x28E4";
        desc = "Word 0x28E4 (NEW 2026-11-12). PROVENANCE: PROVEN offset, written in the dynamic harness run (qemu, ko-harness) by VPSS_HAL_SetCover1; not found by the static run. Meaning UNKNOWN.";
        field {
            name = "word";
            desc = "32-bit word.";
            sw = rw;
            hw = r;
        } word[31:0];
    } NODE_W_28E4 @ 0x28E4;
    reg {
        name = "Word at offset 0x28E8";
        desc = "Word 0x28E8 (NEW 2026-11-12). PROVENANCE: PROVEN offset, written in the dynamic harness run (qemu, ko-harness) by VPSS_HAL_SetCover1; not found by the static run. Meaning UNKNOWN.";
        field {
            name = "word";
            desc = "32-bit word.";
            sw = rw;
            hw = r;
        } word[31:0];
    } NODE_W_28E8 @ 0x28E8;
    reg {
        name = "Word at offset 0x28EC";
        desc = "Word 0x28EC (NEW 2026-11-12). PROVENANCE: PROVEN offset, written in the dynamic harness run (qemu, ko-harness) by VPSS_HAL_SetCover1; not found by the static run. Meaning UNKNOWN.";
        field {
            name = "word";
            desc = "32-bit word.";
            sw = rw;
            hw = r;
        } word[31:0];
    } NODE_W_28EC @ 0x28EC;
};

`endif
