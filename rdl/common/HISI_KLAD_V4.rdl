`ifndef HISI_KLAD_V4_RDL
`define HISI_KLAD_V4_RDL

regfile eHISI_KLAD_V4 {
    name = "Key ladder (KLAD), Hi3516E V200 / V300 generation";
    desc = "Window 0x10060000 (KLAD_REG_BASE_ADDR_PHY), clock/reset CRG 0x1A0 bit 1 / bit 0 (KLAD_CRG_CLOCK_BIT, KLAD_CRG_RESET_BIT). The key itself is first loaded from OTP into the ladder through the OTP user interface (hal_efuse_otp_load_cipher_key). Hardware not read; access types and resets are GUESS (all rw, no reset).";

    reg {
        name = "Key ladder control";
        desc = "KLAD_CTRL [PROVEN] openhisilicon kernel/cipher/hi3516ev200/src/drv/cipher_v1.0/compat/drv_klad.c hal_cipher_klad_config / hal_cipher_start_klad / hal_cipher_wait_klad_done (bit 0 polled for idle). Hardware not read.";
        field { name = "start"; desc = "Write 1 to start; reads 0 when done (hal_cipher_wait_klad_done). [PROVEN]"; } start[0:0];
        field { name = "decrypt"; desc = "1 = decrypt (is_decrypt << 1). [PROVEN]"; } decrypt[1:1];
        field { name = "target"; desc = "Key target (cipher key ladder, target << 2). [PROVEN]"; } target[3:2];
        field { name = "block_high"; desc = "Second 64-bit block flag (block_num == 1, hal_cipher_start_klad). [PROVEN]"; } block_high[4:4];
        field { name = "chn_id"; desc = "Cipher channel number (chn_id << 16; field width INFERRED). [INFERRED]"; } chn_id[23:16];
    } KLAD_CTRL @ 0x0;

    reg {
        name = "Data in word 0";
        desc = "KLAD_DAT_IN0 [PROVEN] openhisilicon kernel/cipher/hi3516ev200/src/drv/cipher_v1.0/compat/drv_klad.c hal_cipher_set_klad_data: 4 words at 0x10, 0x14, 0x18, 0x1C. Hardware not read.";
        field { name = "value"; desc = "Whole register."; } value[31:0];
    } KLAD_DAT_IN0 @ 0x10;

    reg {
        name = "Data in word 1";
        desc = "KLAD_DAT_IN1 [PROVEN] openhisilicon kernel/cipher/hi3516ev200/src/drv/cipher_v1.0/compat/drv_klad.c hal_cipher_set_klad_data. Hardware not read.";
        field { name = "value"; desc = "Whole register."; } value[31:0];
    } KLAD_DAT_IN1 @ 0x14;

    reg {
        name = "Data in word 2";
        desc = "KLAD_DAT_IN2 [PROVEN] openhisilicon kernel/cipher/hi3516ev200/src/drv/cipher_v1.0/compat/drv_klad.c hal_cipher_set_klad_data. Hardware not read.";
        field { name = "value"; desc = "Whole register."; } value[31:0];
    } KLAD_DAT_IN2 @ 0x18;

    reg {
        name = "Data in word 3";
        desc = "KLAD_DAT_IN3 [PROVEN] openhisilicon kernel/cipher/hi3516ev200/src/drv/cipher_v1.0/compat/drv_klad.c hal_cipher_set_klad_data. Hardware not read.";
        field { name = "value"; desc = "Whole register."; } value[31:0];
    } KLAD_DAT_IN3 @ 0x1C;

    reg {
        name = "Encrypted/decrypted output word 0";
        desc = "KLAD_ENC_OUT0 [PROVEN] openhisilicon kernel/cipher/hi3516ev200/src/drv/cipher_v1.0/compat/drv_klad.c hal_cipher_get_klad_data: 4 words at 0x20..0x2C. Hardware not read.";
        field { name = "value"; desc = "Whole register."; } value[31:0];
    } KLAD_ENC_OUT0 @ 0x20;

    reg {
        name = "Output word 1";
        desc = "KLAD_ENC_OUT1 [PROVEN] openhisilicon kernel/cipher/hi3516ev200/src/drv/cipher_v1.0/compat/drv_klad.c hal_cipher_get_klad_data. Hardware not read.";
        field { name = "value"; desc = "Whole register."; } value[31:0];
    } KLAD_ENC_OUT1 @ 0x24;

    reg {
        name = "Output word 2";
        desc = "KLAD_ENC_OUT2 [PROVEN] openhisilicon kernel/cipher/hi3516ev200/src/drv/cipher_v1.0/compat/drv_klad.c hal_cipher_get_klad_data. Hardware not read.";
        field { name = "value"; desc = "Whole register."; } value[31:0];
    } KLAD_ENC_OUT2 @ 0x28;

    reg {
        name = "Output word 3";
        desc = "KLAD_ENC_OUT3 [PROVEN] openhisilicon kernel/cipher/hi3516ev200/src/drv/cipher_v1.0/compat/drv_klad.c hal_cipher_get_klad_data. Hardware not read.";
        field { name = "value"; desc = "Whole register."; } value[31:0];
    } KLAD_ENC_OUT3 @ 0x2C;

};
`endif
