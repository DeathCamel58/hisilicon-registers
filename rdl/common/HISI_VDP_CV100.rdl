`ifndef HISI_VDP_CV100_RDL
`define HISI_VDP_CV100_RDL


regfile eHISI_VDP_CV100 {
    name = "VDP (video display processor, Hi3516C V100 / Hi3518 V100)";
    desc = "Video display processor (VDP, called VOU in the interrupt table: interrupt 23) of the Hi3516C V100 and Hi3518A/C V100 at 0x205C0000 (64 KB, data sheet chapter 10.2). The Hi3518 V100 data sheet lists the same 113 registers (offset, name, bit fields identical). Standard-definition display subset: VSD1 video layer, G3 graphics layer, DSD (standard-definition channel), DATE TV encoder and DAC registers. [check] VSD1VFPOS and VSD1VLPOS are printed at 0x3068/0x306C in their description blocks but at 0x4068/0x406C in the register summary table; this regfile uses 0x4068/0x406C (the VSD1 layer base is 0x4000, the summary lists them directly after VSD1DFPOS 0x4060; the description offsets look copied from the VSD0 layer). Generated 2026-11-15 by scripts/rdl-extract/gen_m_cells.py from the data sheet register tables (ds_extract2 + description extraction from the PDF); PROVENANCE: PROVEN = offsets, names, bit fields, access and reset values from the data sheet tables; nothing here is hardware verified.

    Register sources: 113 registers from the data sheet (hi3516cv100--Hi3516C-Datasheet.txt, section 10.2.5). ";

    reg {
        name = "VSD control register";
        desc = "VSD1CTRL is a VSD control register (non-instant register). It is used to configure the layer information

Data sheet 10.2.5 VSD1CTRL (offset 0x4000, printed page 10-99, `hi3516cv100--Hi3516C-Datasheet.txt` line 41867).";

        enum VSD1CTRL_surface_en_enum {
            DISABLED = 0 { name = "Disabled"; desc = "disabled"; };
            ENABLED = 1 { name = "Enabled"; desc = "enabled"; };
        };

        field {
            name = "surface_en";
            desc = "Surface enable (non-instant register).";
            sw = rw;
            hw = r;
            encode = VSD1CTRL_surface_en_enum;
            reset = 0x0;
        } surface_en[31:31];

        enum VSD1CTRL_ifir_mode_enum {
            RESERVED = 0 { name = "Reserved"; desc = "reserved"; };
            CHROMINANCE_IFIR_COPY = 1 { name = "Chrominance Ifir Copy"; desc = "chrominance IFIR copy mode"; };
            BILINEAR_INTERPOLATION = 2 { name = "Bilinear Interpolation"; desc = "bilinear interpolation"; };
            V_6_TAP_FIR = 3 { name = "V 6 Tap Fir"; desc = "6-tap FIR"; };
        };

        field {
            name = "ifir_mode";
            desc = "Horizontal chrominance IFIR mode.";
            sw = rw;
            hw = r;
            encode = VSD1CTRL_ifir_mode_enum;
            reset = 0x0;
        } ifir_mode[19:18];

        enum VSD1CTRL_vup_mode_enum {
            UPDATE_FIELD = 0 { name = "Update Field"; desc = "update by field"; };
            UPDATE_FRAME_CHECK = 1 { name = "Update Frame Check"; desc = "update by frame [check] The data sheet prints '-' in the access column of this named field; modelled RW."; };
        };

        field {
            name = "vup_mode";
            desc = "Register update mode.";
            sw = rw;
            hw = r;
            encode = VSD1CTRL_vup_mode_enum;
            reset = 0x0;
        } vup_mode[17:17];

        enum VSD1CTRL_ifmt_enum {
            SPYCBCR420 = 3 { name = "Spycbcr420"; desc = "SPYCbCr420"; };
            SPYCBCR422_OTHER_VALUES = 4 { name = "Spycbcr422 Other Values"; desc = "SPYCbCr422 Other values: reserved"; };
        };

        field {
            name = "ifmt";
            desc = "Input data format.";
            sw = rw;
            hw = r;
            encode = VSD1CTRL_ifmt_enum;
            reset = 0x0;
        } ifmt[3:0];
    } VSD1CTRL @ 0x4000;

    reg {
        name = "VSD channel update enable register";
        desc = "VSD1UPD is a VSD channel update enable register.

Data sheet 10.2.5 VSD1UPD (offset 0x4004, printed page 10-100, `hi3516cv100--Hi3516C-Datasheet.txt` line 41920).";

        field {
            name = "regup";
            desc = "Surface register update. After the registers at this layer are configured, the registers are updated when the value 1 is written to this bit. After updates, this bit is cleared automatically by the hardware.";
            sw = rw;
            hw = r;
            reset = 0x0;
        } regup[0:0];
    } VSD1UPD @ 0x4004;

    reg {
        name = "VSD current frame address register";
        desc = "VSD1CADDR is a VSD current frame address register. In package pixel format, the address is the address of the frame buffer; in semi-planar pixel format, the address is the address of the luminance frame buffer.

Data sheet 10.2.5 VSD1CADDR (offset 0x4010, printed page 10-100, `hi3516cv100--Hi3516C-Datasheet.txt` line 41948).";

        field {
            name = "surface_caddr";
            desc = "Address of the current frame.";
            sw = rw;
            hw = r;
            reset = 0x0;
        } surface_caddr[31:0];
    } VSD1CADDR @ 0x4010;

    reg {
        name = "VSD current frame chrominance address register";
        desc = "VSD1CCADDR is a VSD current frame chrominance address register. In package pixel format, the address is invalid; in semi-planar pixel format, the address is the address of the luminance frame buffer.

Data sheet 10.2.5 VSD1CCADDR (offset 0x4014, printed page 10-101, `hi3516cv100--Hi3516C-Datasheet.txt` line 41975).";

        field {
            name = "surface_ccaddr";
            desc = "Chrominance address of the current frame.";
            sw = rw;
            hw = r;
            reset = 0x0;
        } surface_ccaddr[31:0];
    } VSD1CCADDR @ 0x4014;

    reg {
        name = "VSD surface stride register";
        desc = "VSD1STRIDE is a VSD surface stride register.

Data sheet 10.2.5 VSD1STRIDE (offset 0x4024, printed page 10-101, `hi3516cv100--Hi3516C-Datasheet.txt` line 41994).";

        field {
            name = "surface_cstride";
            desc = "Stride of the chrominance frame buffer (valid in semi-planar format), 128-bit alignment.";
            sw = rw;
            hw = r;
            reset = 0x0;
        } surface_cstride[31:16];

        field {
            name = "surface_stride";
            desc = "Stride of the frame buffer (valid in semi-planar format, luminance stride), 128-bit alignment.";
            sw = rw;
            hw = r;
            reset = 0x0;
        } surface_stride[15:0];
    } VSD1STRIDE @ 0x4024;

    reg {
        name = "VSD input resolution register";
        desc = "VSD1IRESO is a VSD input resolution register (non-instant register).

Data sheet 10.2.5 VSD1IRESO (offset 0x4028, printed page 10-102, `hi3516cv100--Hi3516C-Datasheet.txt` line 42027).";

        field {
            name = "ih";
            desc = "Height (in line). The value is the actual height minus 1. The frame height is referenced.";
            sw = rw;
            hw = r;
            reset = 0x0;
        } ih[23:12];

        field {
            name = "iw";
            desc = "Width (in pixel). The value is the actual width minus 1.";
            sw = rw;
            hw = r;
            reset = 0x0;
        } iw[11:0];
    } VSD1IRESO @ 0x4028;

    reg {
        name = "VSD overlay parameter register";
        desc = "VSD1CBMPARA is a VSD overlay parameter register (non-instant register).

Data sheet 10.2.5 VSD1CBMPARA (offset 0x4034, printed page 10-102, `hi3516cv100--Hi3516C-Datasheet.txt` line 42050).";

        field {
            name = "galpha";
            desc = "Overlay global alpha value. The value ranges from 0 to 128. The value 128 indicates opaque, and the value 0 indicates full transparent.";
            sw = rw;
            hw = r;
            reset = 0x0;
        } galpha[7:0];
    } VSD1CBMPARA @ 0x4034;

    reg {
        name = "VSD surface start position";
        desc = "VSD1DFPOS is a VSD surface start position (in the display window) register (non-instant register).

Data sheet 10.2.5 VSD1DFPOS (offset 0x4060, printed page 10-103, `hi3516cv100--Hi3516C-Datasheet.txt` line 42082).";

        field {
            name = "disp_yfpos";
            desc = "Start coordinate of the display column. The frame height is referenced and the unit is line.";
            sw = rw;
            hw = r;
            reset = 0x0;
        } disp_yfpos[23:12];

        field {
            name = "disp_xfpos";
            desc = "Start coordinate of the display row.";
            sw = rw;
            hw = r;
            reset = 0x0;
        } disp_xfpos[11:0];
    } VSD1DFPOS @ 0x4060;

    reg {
        name = "VSD surface end position";
        desc = "VSD1DLPOS is a VSD surface end position (in the display window) register (non-instant register). The end position is in the unit of pixel.

Data sheet 10.2.5 VSD1DLPOS (offset 0x4064, printed page 10-103, `hi3516cv100--Hi3516C-Datasheet.txt` line 42106).";

        field {
            name = "disp_ylpos";
            desc = "End coordinate of the display column. The frame height is referenced and the unit is line.";
            sw = rw;
            hw = r;
            reset = 0x0;
        } disp_ylpos[23:12];

        field {
            name = "disp_xlpos";
            desc = "End coordinate of the display row.";
            sw = rw;
            hw = r;
            reset = 0x0;
        } disp_xlpos[11:0];
    } VSD1DLPOS @ 0x4064;

    reg {
        name = "VSD surface content start position";
        desc = "VSD1VFPOS is a VSD surface content start position (in the display window) register (non- instant register). The start position is in the unit of pixel.

Data sheet 10.2.5 VSD1VFPOS (offset 0x4068, printed page 10-104, `hi3516cv100--Hi3516C-Datasheet.txt` line 42139).";

        field {
            name = "video_yfpos";
            desc = "Start coordinate of the video column. The frame height is referenced and the unit is line.";
            sw = rw;
            hw = r;
            reset = 0x0;
        } video_yfpos[23:12];

        field {
            name = "video_xfpos";
            desc = "Start coordinate of the video row.";
            sw = rw;
            hw = r;
            reset = 0x0;
        } video_xfpos[11:0];
    } VSD1VFPOS @ 0x4068;

    reg {
        name = "VSD surface content end position";
        desc = "VSD1VLPOS is a VSD surface content end position (in the display window) register (non- instant register). The end position is in the unit of pixel.

Data sheet 10.2.5 VSD1VLPOS (offset 0x406C, printed page 10-104, `hi3516cv100--Hi3516C-Datasheet.txt` line 42163).";

        field {
            name = "video_ylpos";
            desc = "End coordinate of the video column. The frame height is referenced and the unit is line.";
            sw = rw;
            hw = r;
            reset = 0x0;
        } video_ylpos[23:12];

        field {
            name = "video_xlpos";
            desc = "End coordinate of the video row.";
            sw = rw;
            hw = r;
            reset = 0x0;
        } video_xlpos[11:0];
    } VSD1VLPOS @ 0x406C;

    reg {
        name = "Video layer background color register";
        desc = "VSD1BK is a video layer background color register.

Data sheet 10.2.5 VSD1BK (offset 0x4070, printed page 10-105, `hi3516cv100--Hi3516C-Datasheet.txt` line 42194).";

        field {
            name = "vbk_alpha";
            desc = "Levels 0-128 of the background filling color of the video layer.";
            sw = rw;
            hw = r;
            reset = 0x0;
        } vbk_alpha[31:24];

        field {
            name = "vbk_y";
            desc = "Y component.";
            sw = rw;
            hw = r;
            reset = 0x0;
        } vbk_y[23:16];

        field {
            name = "vbk_cb";
            desc = "Cb component.";
            sw = rw;
            hw = r;
            reset = 0x0;
        } vbk_cb[15:8];

        field {
            name = "vbk_cr";
            desc = "Cr component.";
            sw = rw;
            hw = r;
            reset = 0x0;
        } vbk_cr[7:0];
    } VSD1BK @ 0x4070;

    reg {
        name = "VSD input DC component register for CSC";
        desc = "VSD1CSCIDC is a VSD input DC component register for CSC (instant register).

Data sheet 10.2.5 VSD1CSCIDC (offset 0x4080, printed page 10-105, `hi3516cv100--Hi3516C-Datasheet.txt` line 42216).";

        enum VSD1CSCIDC_csc_en_enum {
            DISABLED = 0 { name = "Disabled"; desc = "disabled"; };
            ENABLED = 1 { name = "Enabled"; desc = "enabled"; };
        };

        field {
            name = "csc_en";
            desc = "CSC enable.";
            sw = rw;
            hw = r;
            encode = VSD1CSCIDC_csc_en_enum;
            reset = 0x0;
        } csc_en[27:27];

        field {
            name = "cscidc2";
            desc = "DC parameter of input component 2. The MSB is the signed bit. The value is expressed as the complementary code.";
            sw = rw;
            hw = r;
            reset = 0x0;
        } cscidc2[26:18];

        field {
            name = "cscidc1";
            desc = "DC parameter of input component 1. The MSB is the signed bit. The value is expressed as the complementary code.";
            sw = rw;
            hw = r;
            reset = 0x0;
        } cscidc1[17:9];

        field {
            name = "cscidc0";
            desc = "DC parameter of input component 0. The MSB is the signed bit. The value is expressed as the complementary code.";
            sw = rw;
            hw = r;
            reset = 0x0;
        } cscidc0[8:0];
    } VSD1CSCIDC @ 0x4080;

    reg {
        name = "VSD output DC component register for CSC";
        desc = "VSD1CSCODC is a VSD output DC component register for CSC (instant register).

Data sheet 10.2.5 VSD1CSCODC (offset 0x4084, printed page 10-106, `hi3516cv100--Hi3516C-Datasheet.txt` line 42256).";

        field {
            name = "cscodc2";
            desc = "DC parameter of output component 2. The MSB is the signed bit. The value is expressed as the complementary code.";
            sw = rw;
            hw = r;
            reset = 0x0;
        } cscodc2[26:18];

        field {
            name = "cscodc1";
            desc = "DC parameter of output component 1. The MSB is the signed bit. The value is expressed as the complementary code.";
            sw = rw;
            hw = r;
            reset = 0x0;
        } cscodc1[17:9];

        field {
            name = "cscodc0";
            desc = "DC parameter of output component 0. The MSB is the signed bit. The value is expressed as the complementary code.";
            sw = rw;
            hw = r;
            reset = 0x0;
        } cscodc0[8:0];
    } VSD1CSCODC @ 0x4084;

    reg {
        name = "VSD CSC parameter 0 register";
        desc = "VSD1CSCP0 is VSD CSC parameter 0 register (instant register).

Data sheet 10.2.5 VSD1CSCP0 (offset 0x4088, printed page 10-106, `hi3516cv100--Hi3516C-Datasheet.txt` line 42284).";

        field {
            name = "cscp01";
            desc = "5.8 data format. The value consists of a 1-bit signed bit, a 4-bit integral part, and an 8-bit fractional part. The value is expressed as the complementary code.";
            sw = rw;
            hw = r;
            reset = 0x0;
        } cscp01[28:16];

        field {
            name = "cscp00";
            desc = "5.8 data format. The value consists of a 1-bit signed bit, a 4-bit integral part, and an 8-bit fractional part. The value is expressed as the complementary code.";
            sw = rw;
            hw = r;
            reset = 0x0;
        } cscp00[12:0];
    } VSD1CSCP0 @ 0x4088;

    reg {
        name = "VSD CSC parameter 1 register";
        desc = "VSD1CSCP1 is VSD CSC parameter 1 register (instant register).

Data sheet 10.2.5 VSD1CSCP1 (offset 0x408C, printed page 10-107, `hi3516cv100--Hi3516C-Datasheet.txt` line 42322).";

        field {
            name = "cscp10";
            desc = "5.8 data format. The value consists of a 1-bit signed bit, a 4-bit integral part, and an 8-bit fractional part. The value is expressed as the complementary code.";
            sw = rw;
            hw = r;
            reset = 0x0;
        } cscp10[28:16];

        field {
            name = "cscp02";
            desc = "5.8 data format. The value consists of a 1-bit signed bit, a 4-bit integral part, and an 8-bit fractional part. The value is expressed as the complementary code.";
            sw = rw;
            hw = r;
            reset = 0x0;
        } cscp02[12:0];
    } VSD1CSCP1 @ 0x408C;

    reg {
        name = "VSD CSC parameter 2 register";
        desc = "VSD1CSCP2 is VSD CSC parameter 2 register (instant register).

Data sheet 10.2.5 VSD1CSCP2 (offset 0x4090, printed page 10-107, `hi3516cv100--Hi3516C-Datasheet.txt` line 42354).";

        field {
            name = "cscp12";
            desc = "5.8 data format. The value consists of a 1-bit signed bit, a 4-bit integral part, and an 8-bit fractional part. The value is expressed as the complementary code.";
            sw = rw;
            hw = r;
            reset = 0x0;
        } cscp12[28:16];

        field {
            name = "cscp11";
            desc = "5.8 data format. The value consists of a 1-bit signed bit, a 4-bit integral part, and an 8-bit fractional part. The value is expressed as the complementary code.";
            sw = rw;
            hw = r;
            reset = 0x0;
        } cscp11[12:0];
    } VSD1CSCP2 @ 0x4090;

    reg {
        name = "VSD CSC parameter 3 register";
        desc = "VSD1CSCP3 is VSD CSC parameter 3 register (instant register).

Data sheet 10.2.5 VSD1CSCP3 (offset 0x4094, printed page 10-108, `hi3516cv100--Hi3516C-Datasheet.txt` line 42395).";

        field {
            name = "cscp21";
            desc = "5.8 data format. The value consists of a 1-bit signed bit, a 4-bit integral part, and an 8-bit fractional part. The value is expressed as the complementary code.";
            sw = rw;
            hw = r;
            reset = 0x0;
        } cscp21[28:16];

        field {
            name = "cscp20";
            desc = "5.8 data format. The value consists of a 1-bit signed bit, a 4-bit integral part, and an 8-bit fractional part. The value is expressed as the complementary code.";
            sw = rw;
            hw = r;
            reset = 0x0;
        } cscp20[12:0];
    } VSD1CSCP3 @ 0x4094;

    reg {
        name = "VSD CSC parameter 4 register";
        desc = "VSD1CSCP4 is VSD CSC parameter 4 register (instant register).

Data sheet 10.2.5 VSD1CSCP4 (offset 0x4098, printed page 10-108, `hi3516cv100--Hi3516C-Datasheet.txt` line 42427).";

        field {
            name = "cscp22";
            desc = "5.8 data format. The value consists of a 1-bit signed bit, a 4-bit integral part, and an 8-bit fractional part. The value is expressed as the complementary code.";
            sw = rw;
            hw = r;
            reset = 0x0;
        } cscp22[12:0];
    } VSD1CSCP4 @ 0x4098;

    reg {
        name = "VSD IFIR filtering coefficients 0-1 register";
        desc = "VSD1IFIRCOEF01 is a VSD IFIR filtering coefficients 0-1 register.

Data sheet 10.2.5 VSD1IFIRCOEF01 (offset 0x4180, printed page 10-109, `hi3516cv100--Hi3516C-Datasheet.txt` line 42459).";

        field {
            name = "coef1";
            desc = "IFIR filtering coefficient 1.";
            sw = rw;
            hw = r;
            reset = 0xD;
        } coef1[25:16];

        field {
            name = "coef0";
            desc = "IFIR filtering coefficient 0.";
            sw = rw;
            hw = r;
            reset = 0x0;
        } coef0[9:0];
    } VSD1IFIRCOEF01 @ 0x4180;

    reg {
        name = "VSD IFIR filtering coefficients 2-3 register";
        desc = "VSD1IFIRCOEF23 is a VSD IFIR filtering coefficients 2-3 register.

Data sheet 10.2.5 VSD1IFIRCOEF23 (offset 0x4184, printed page 10-109, `hi3516cv100--Hi3516C-Datasheet.txt` line 42481).";

        field {
            name = "coef3";
            desc = "IFIR filtering coefficient 3.";
            sw = rw;
            hw = r;
            reset = 0x132;
        } coef3[25:16];

        field {
            name = "coef2";
            desc = "IFIR filtering coefficients 2.";
            sw = rw;
            hw = r;
            reset = 0x3C1;
        } coef2[9:0];
    } VSD1IFIRCOEF23 @ 0x4184;

    reg {
        name = "VSD IFIR filtering coefficients 4-5 register";
        desc = "VSD1IFIRCOEF45 is a VSD IFIR filtering coefficients 4-5 register.

Data sheet 10.2.5 VSD1IFIRCOEF45 (offset 0x4188, printed page 10-110, `hi3516cv100--Hi3516C-Datasheet.txt` line 42509).";

        field {
            name = "coef5";
            desc = "IFIR filtering coefficient 5.";
            sw = rw;
            hw = r;
            reset = 0x3C;
        } coef5[25:16];

        field {
            name = "coef4";
            desc = "IFIR filtering coefficient 4.";
            sw = rw;
            hw = r;
            reset = 0x132;
        } coef4[9:0];
    } VSD1IFIRCOEF45 @ 0x4188;

    reg {
        name = "VSD IFIR filtering coefficients 6-7 register";
        desc = "VSD1IFIRCOEF67 is a VSD IFIR filtering coefficients 6-7 register.

Data sheet 10.2.5 VSD1IFIRCOEF67 (offset 0x418C, printed page 10-110, `hi3516cv100--Hi3516C-Datasheet.txt` line 42531).";

        field {
            name = "coef7";
            desc = "IFIR filtering coefficient 7.";
            sw = rw;
            hw = r;
            reset = 0x0;
        } coef7[25:16];

        field {
            name = "coef6";
            desc = "IFIR filtering coefficient 6.";
            sw = rw;
            hw = r;
            reset = 0xD;
        } coef6[9:0];
    } VSD1IFIRCOEF67 @ 0x418C;

    reg {
        name = "VSD1 region 0 resolution register";
        desc = "VSD1P0RESO is a VSD1 region 0 resolution register (non-instant register).

Data sheet 10.2.5 VSD1P0RESO (offset 0x4400, printed page 10-111, `hi3516cv100--Hi3516C-Datasheet.txt` line 42564).";

        field {
            name = "h";
            desc = "Height (in line). The frame height is referenced. The value is the actual height minus 1. Note: The actual height must be an even number.";
            sw = rw;
            hw = r;
            reset = 0x0;
        } h[23:12];

        field {
            name = "w";
            desc = "Width (in pixel). The value is the actual width minus 1. Note: The actual width must be an even number.";
            sw = rw;
            hw = r;
            reset = 0x0;
        } w_f[11:0];
    } VSD1P0RESO @ 0x4400;

    reg {
        name = "VSD1 region 0 address register";
        desc = "VSD1P0LADDR is a VSD1 region 0 address register.

Data sheet 10.2.5 VSD1P0LADDR (offset 0x4404, printed page 10-111, `hi3516cv100--Hi3516C-Datasheet.txt` line 42590).";

        field {
            name = "surface_addr";
            desc = "Start address of VSD1 region 0.";
            sw = rw;
            hw = r;
            reset = 0x0;
        } surface_addr[31:0];
    } VSD1P0LADDR @ 0x4404;

    reg {
        name = "VSD1 region 0 chrominance address register";
        desc = "VSD1P0CADDR is a VSD1 region 0 chrominance address register.

Data sheet 10.2.5 VSD1P0CADDR (offset 0x4408, printed page 10-112, `hi3516cv100--Hi3516C-Datasheet.txt` line 42618).";

        field {
            name = "surface_addr";
            desc = "Chrominance start address of VSD1 region 0.";
            sw = rw;
            hw = r;
            reset = 0x0;
        } surface_addr[31:0];
    } VSD1P0CADDR @ 0x4408;

    reg {
        name = "VSD1 region 0 stride register";
        desc = "VSD1P0STRIDE is a VSD1 region 0 stride register.

Data sheet 10.2.5 VSD1P0STRIDE (offset 0x440C, printed page 10-112, `hi3516cv100--Hi3516C-Datasheet.txt` line 42637).";

        field {
            name = "surface_cstride";
            desc = "Stride of the chrominance buffer of VSD1 region 0 (valid in semi- planar format), 128-bit alignment.";
            sw = rw;
            hw = r;
            reset = 0x0;
        } surface_cstride[31:16];

        field {
            name = "surface_stride";
            desc = "Stride of the buffer of VSD1 region 0 (valid in semi-planar format, luminance stride), 128-bit alignment.";
            sw = rw;
            hw = r;
            reset = 0x0;
        } surface_stride[15:0];
    } VSD1P0STRIDE @ 0x440C;

    reg {
        name = "VSD1 region 0 video start position register";
        desc = "VSD1P0VFPOS is a VSD1 region 0 video start position register. The start position is in the unit of pixel.

Data sheet 10.2.5 VSD1P0VFPOS (offset 0x4410, printed page 10-112, `hi3516cv100--Hi3516C-Datasheet.txt` line 42662).";

        field {
            name = "video_yfpos";
            desc = "Start coordinate of the video column. The frame height is referenced and the unit is line.";
            sw = rw;
            hw = r;
            reset = 0x0;
        } video_yfpos[23:12];

        field {
            name = "video_xfpos";
            desc = "Start coordinate of the video row.";
            sw = rw;
            hw = r;
            reset = 0x0;
        } video_xfpos[11:0];
    } VSD1P0VFPOS @ 0x4410;

    reg {
        name = "VSD1 region 0 video end position register";
        desc = "VSD1P0VLPOS is a VSD1 region 0 video end position register (non-instant register). The end position is in the unit of pixel.

Data sheet 10.2.5 VSD1P0VLPOS (offset 0x4414, printed page 10-113, `hi3516cv100--Hi3516C-Datasheet.txt` line 42696).";

        field {
            name = "video_ylpos";
            desc = "Start coordinate of the video column. The frame height is referenced and the unit is line.";
            sw = rw;
            hw = r;
            reset = 0x0;
        } video_ylpos[23:12];

        field {
            name = "video_xlpos";
            desc = "Start coordinate of the video row.";
            sw = rw;
            hw = r;
            reset = 0x0;
        } video_xlpos[11:0];
    } VSD1P0VLPOS @ 0x4414;

    reg {
        name = "VSD1 region 0 enable register";
        desc = "VSD116REGIONEN is a VSD1 region 0 enable register (non-instant register).

Data sheet 10.2.5 VSD116REGIONEN (offset 0x4C04, printed page 10-113, `hi3516cv100--Hi3516C-Datasheet.txt` line 42719).";

        enum VSD116REGIONEN_p0_en_enum {
            DISABLED = 0 { name = "Disabled"; desc = "disabled"; };
            ENABLED = 1 { name = "Enabled"; desc = "enabled"; };
        };

        field {
            name = "p0_en";
            desc = "VSD1 region 0 enable.";
            sw = rw;
            hw = r;
            encode = VSD116REGIONEN_p0_en_enum;
            reset = 0x0;
        } p0_en[0:0];
    } VSD116REGIONEN @ 0x4C04;

    reg {
        name = "G3 control register";
        desc = "G3CTRL is the G3 control register (non-instant register). It is used to configure the layer information

Data sheet 10.2.5 G3CTRL (offset 0x9600, printed page 10-114, `hi3516cv100--Hi3516C-Datasheet.txt` line 42749).";

        enum G3CTRL_surface_en_enum {
            DISABLED = 0 { name = "Disabled"; desc = "disabled"; };
            ENABLED = 1 { name = "Enabled"; desc = "enabled"; };
        };

        field {
            name = "surface_en";
            desc = "Surface enable (non-instant register).";
            sw = rw;
            hw = r;
            encode = G3CTRL_surface_en_enum;
            reset = 0x0;
        } surface_en[31:31];

        enum G3CTRL_upd_mode_enum {
            UPDATE_FRAME = 0 { name = "Update Frame"; desc = "update by frame"; };
            UPDATE_FIELD = 1 { name = "Update Field"; desc = "update by field"; };
        };

        field {
            name = "upd_mode";
            desc = "Update mode.";
            sw = rw;
            hw = r;
            encode = G3CTRL_upd_mode_enum;
            reset = 0x0;
        } upd_mode[27:27];

        enum G3CTRL_read_mode_enum {
            READ_MODE_AUTOMATICALLY = 0 { name = "Read Mode Automatically"; desc = "The read mode is automatically selected based on the interface read mode. That is, the progressive read mode is selected in progressive display mode, and the interlaced read mode is selected in interlaced display mode."; };
            PROGRESSIVE_READ_MODE = 1 { name = "Progressive Read Mode"; desc = "The progressive read mode is selected forcibly."; };
        };

        field {
            name = "read_mode";
            desc = "Data read mode.";
            sw = rw;
            hw = r;
            encode = G3CTRL_read_mode_enum;
            reset = 0x0;
        } read_mode[26:26];

        enum G3CTRL_bitext_enum {
            LOWER_BITS_STUFFED = 2 { name = "Lower Bits Stuffed"; desc = "lower bits stuffed with the MSB"; };
            LOWER_BITS_STUFFED_2 = 3 { name = "Lower Bits Stuffed 2"; desc = "lower bits stuffed with upper bits"; };
        };

        field {
            name = "bitext";
            desc = "Bit extend mode of the input bitmap. 0X: lower bits stuffed with 0s";
            sw = rw;
            hw = r;
            encode = G3CTRL_bitext_enum;
            reset = 0x0;
        } bitext[9:8];

        enum G3CTRL_ifmt_enum {
            ARGB1555 = 0x49 { name = "Argb1555"; desc = "ARGB1555"; };
            ARGB8888_OTHER_VALUES = 0x68 { name = "Argb8888 Other Values"; desc = "ARGB8888 Other values: reserved"; };
        };

        field {
            name = "ifmt";
            desc = "Input data format.";
            sw = rw;
            hw = r;
            encode = G3CTRL_ifmt_enum;
            reset = 0x0;
        } ifmt[7:0];
    } G3CTRL @ 0x9600;

    reg {
        name = "G3 channel update enable register";
        desc = "G3UPD is the G3 channel update enable register.

Data sheet 10.2.5 G3UPD (offset 0x9604, printed page 10-115, `hi3516cv100--Hi3516C-Datasheet.txt` line 42807).";

        field {
            name = "regup";
            desc = "Surface register update. After the registers at this layer are configured, the registers are updated when the value 1 is written to this bit. After updates, this bit is cleared automatically by the hardware";
            sw = rw;
            hw = r;
            reset = 0x0;
        } regup[0:0];
    } G3UPD @ 0x9604;

    reg {
        name = "G3 address register";
        desc = "G3ADDR is the G3 address register. When the horizontal pixel offsets, the address is calculated according to the description of G3SFPOS.

Data sheet 10.2.5 G3ADDR (offset 0x9608, printed page 10-115, `hi3516cv100--Hi3516C-Datasheet.txt` line 42834).";

        field {
            name = "surface_addr";
            desc = "Address of the surface frame buffer.";
            sw = rw;
            hw = r;
            reset = 0x0;
        } surface_addr[31:0];
    } G3ADDR @ 0x9608;

    reg {
        name = "G3 stride register";
        desc = "G3STRIDE is the G3 stride register.

Data sheet 10.2.5 G3STRIDE (offset 0x960C, printed page 10-116, `hi3516cv100--Hi3516C-Datasheet.txt` line 42862).";

        field {
            name = "surface_stride";
            desc = "Stride of the frame buffer.";
            sw = rw;
            hw = r;
            reset = 0x0;
        } surface_stride[15:0];
    } G3STRIDE @ 0x960C;

    reg {
        name = "G3 overlay parameter register";
        desc = "G3CBMPARA is the G3 overlay parameter register (non-instant register).

Data sheet 10.2.5 G3CBMPARA (offset 0x9610, printed page 10-116, `hi3516cv100--Hi3516C-Datasheet.txt` line 42883).";

        enum G3CBMPARA_key_mode_enum {
            COLOR_REGARDED_AS = 0 { name = "Color Regarded As"; desc = "The color is regarded as the colorkey when the following condition is met: Keymin <= Pixel <= Keymax"; };
            COLOR_REGARDED_AS_2 = 1 { name = "Color Regarded As 2"; desc = "The color is regarded as the colorkey when either of the following conditions is met: Pixel <= Keymin or Pixel >= Keymax"; };
        };

        field {
            name = "key_mode";
            desc = "Colorkey mode.";
            sw = rw;
            hw = r;
            encode = G3CBMPARA_key_mode_enum;
            reset = 0x0;
        } key_mode[15:15];

        enum G3CBMPARA_key_en_enum {
            DISABLED = 0 { name = "Disabled"; desc = "disabled"; };
            ENABLED = 1 { name = "Enabled"; desc = "enabled"; };
        };

        field {
            name = "key_en";
            desc = "Colorkey enable.";
            sw = rw;
            hw = r;
            encode = G3CBMPARA_key_en_enum;
            reset = 0x0;
        } key_en[14:14];

        enum G3CBMPARA_palpha_en_enum {
            DISABLED = 0 { name = "Disabled"; desc = "disabled"; };
            ENABLED = 1 { name = "Enabled"; desc = "enabled"; };
        };

        field {
            name = "palpha_en";
            desc = "Pixel alpha enable.";
            sw = rw;
            hw = r;
            encode = G3CBMPARA_palpha_en_enum;
            reset = 0x0;
        } palpha_en[12:12];

        enum G3CBMPARA_palpha_range_enum {
            V_0_128 = 0 { name = "V 0 128"; desc = "0-128"; };
            V_0_255 = 1 { name = "V 0 255"; desc = "0-255"; };
        };

        field {
            name = "palpha_range";
            desc = "Pixel alpha range.";
            sw = rw;
            hw = r;
            encode = G3CBMPARA_palpha_range_enum;
            reset = 0x0;
        } palpha_range[8:8];

        field {
            name = "galpha";
            desc = "Overlay global alpha value. This value ranges from 0 to 255. The value 255 indicates opaque, and the value 0 indicates full transparent.";
            sw = rw;
            hw = r;
            reset = 0x0;
        } galpha[7:0];
    } G3CBMPARA @ 0x9610;

    reg {
        name = "G3 maximum colorkey register";
        desc = "G3CKEYMAX is the G3 maximum colorkey register (non-instant register).

Data sheet 10.2.5 G3CKEYMAX (offset 0x9614, printed page 10-117, `hi3516cv100--Hi3516C-Datasheet.txt` line 42938).";

        field {
            name = "va0";
            desc = "Alpha0 value. When the data format is alphaRGB1555 and the alpha value is 0, the alpha0 value is used.";
            sw = rw;
            hw = r;
            reset = 0x0;
        } va0[31:24];

        field {
            name = "keyr_max";
            desc = "Maximum value of colorkey R component.";
            sw = rw;
            hw = r;
            reset = 0x0;
        } keyr_max[23:16];

        field {
            name = "keyg_max";
            desc = "Maximum value of colorkey G component.";
            sw = rw;
            hw = r;
            reset = 0x0;
        } keyg_max[15:8];

        field {
            name = "keyb_max";
            desc = "Maximum value of colorkey B component.";
            sw = rw;
            hw = r;
            reset = 0x0;
        } keyb_max[7:0];
    } G3CKEYMAX @ 0x9614;

    reg {
        name = "G3 minimum colorkey register";
        desc = "G3CKEYMIN is the G3 minimum colorkey register (non-instant register).

Data sheet 10.2.5 G3CKEYMIN (offset 0x9618, printed page 10-117, `hi3516cv100--Hi3516C-Datasheet.txt` line 42962).";

        field {
            name = "va1";
            desc = "Alpha1 value. When the data format is alphaRGB1555 and the alpha value is 1, the alpha1 value is used.";
            sw = rw;
            hw = r;
            reset = 0x0;
        } va1[31:24];

        field {
            name = "keyr_min";
            desc = "Minimum value of colorkey R component.";
            sw = rw;
            hw = r;
            reset = 0x0;
        } keyr_min[23:16];

        field {
            name = "keyg_min";
            desc = "Minimum value of colorkey G component.";
            sw = rw;
            hw = r;
            reset = 0x0;
        } keyg_min[15:8];

        field {
            name = "keyb_min";
            desc = "keyb_min";
            sw = rw;
            hw = r;
            reset = 0x0;
        } keyb_min[7:0];
    } G3CKEYMIN @ 0x9618;

    reg {
        name = "G3 colorkey mask register";
        desc = "G3CMASK is the G3 colorkey mask register (non-instant register). When the corresponding bit is 0, the colorkey is compared. In this case, this bit can be ignored.

Data sheet 10.2.5 G3CMASK (offset 0x961C, printed page 10-118, `hi3516cv100--Hi3516C-Datasheet.txt` line 43006).";

        field {
            name = "kmsk_r";
            desc = "R component of colorkey mask.";
            sw = rw;
            hw = r;
            reset = 0x0;
        } kmsk_r[23:16];

        field {
            name = "kmsk_g";
            desc = "G component of colorkey mask.";
            sw = rw;
            hw = r;
            reset = 0x0;
        } kmsk_g[15:8];

        field {
            name = "kmsk_b";
            desc = "B component of colorkey mask.";
            sw = rw;
            hw = r;
            reset = 0x0;
        } kmsk_b[7:0];
    } G3CMASK @ 0x961C;

    reg {
        name = "G3 input resolution register";
        desc = "G3IRESO is the G3 input resolution register (non-instant register).

Data sheet 10.2.5 G3IRESO (offset 0x9620, printed page 10-118, `hi3516cv100--Hi3516C-Datasheet.txt` line 43028).";

        field {
            name = "ih";
            desc = "Height (in line). The value is the actual height minus 1. Note: In interlaced output mode, the actual layer height must be an even number. There is no such limitation in progressive output mode.";
            sw = rw;
            hw = r;
            reset = 0x0;
        } ih[23:12];

        field {
            name = "iw";
            desc = "Width (in pixel). The value is the actual width minus 1. Note: The actual layer width must be an even number.";
            sw = rw;
            hw = r;
            reset = 0x0;
        } iw[11:0];
    } G3IRESO @ 0x9620;

    reg {
        name = "G3 output resolution register";
        desc = "G3ORESO is the G3 output resolution register (non-instant register).

Data sheet 10.2.5 G3ORESO (offset 0x9624, printed page 10-119, `hi3516cv100--Hi3516C-Datasheet.txt` line 43064).";

        field {
            name = "oh";
            desc = "Height (in line). The value is the actual height minus 1. Note: In interlaced output mode, the actual layer height must be an even number. There is no such limitation in progressive output mode.";
            sw = rw;
            hw = r;
            reset = 0x0;
        } oh[23:12];

        field {
            name = "ow";
            desc = "Width (in pixel). The value is the actual width minus 1. Note: The actual layer width must be an even number.";
            sw = rw;
            hw = r;
            reset = 0x0;
        } ow[11:0];
    } G3ORESO @ 0x9624;

    reg {
        name = "G3 surface start position";
        desc = "G3DFPOS is the G3 surface start position (in the display window) register (non-instant register). The start position is in the unit of pixel.

Data sheet 10.2.5 G3DFPOS (offset 0x962C, printed page 10-119, `hi3516cv100--Hi3516C-Datasheet.txt` line 43091).";

        field {
            name = "disp_yfpos";
            desc = "Column start coordinate.";
            sw = rw;
            hw = r;
            reset = 0x0;
        } disp_yfpos[23:12];

        field {
            name = "disp_xfpos";
            desc = "Row start coordinate.";
            sw = rw;
            hw = r;
            reset = 0x0;
        } disp_xfpos[11:0];
    } G3DFPOS @ 0x962C;

    reg {
        name = "G3 surface end position";
        desc = "G3DLPOS is the G3 surface end position (in the display window) register (non-instant register). The end position is in the unit of pixel.

Data sheet 10.2.5 G3DLPOS (offset 0x9630, printed page 10-120, `hi3516cv100--Hi3516C-Datasheet.txt` line 43121).";

        field {
            name = "disp_ylpos";
            desc = "Column end coordinate.";
            sw = rw;
            hw = r;
            reset = 0x0;
        } disp_ylpos[23:12];

        field {
            name = "disp_xlpos";
            desc = "Row end coordinate.";
            sw = rw;
            hw = r;
            reset = 0x0;
        } disp_xlpos[11:0];
    } G3DLPOS @ 0x9630;

    reg {
        name = "G3 input DC component register for CSC";
        desc = "G3CSCIDC is the G3 input DC component register for CSC (instant register).

Data sheet 10.2.5 G3CSCIDC (offset 0x96A0, printed page 10-120, `hi3516cv100--Hi3516C-Datasheet.txt` line 43142).";

        enum G3CSCIDC_csc_mode_enum {
            RGB_YUV_601 = 0 { name = "Rgb Yuv 601"; desc = "RGB to YUV 601"; };
            RGB_YUV_709 = 1 { name = "Rgb Yuv 709"; desc = "RGB to YUV 709"; };
        };

        field {
            name = "csc_mode";
            desc = "CSC mode.";
            sw = rw;
            hw = r;
            encode = G3CSCIDC_csc_mode_enum;
            reset = 0x0;
        } csc_mode[28:28];

        enum G3CSCIDC_csc_en_enum {
            DISABLED = 0 { name = "Disabled"; desc = "disabled"; };
            ENABLED = 1 { name = "Enabled"; desc = "enabled"; };
        };

        field {
            name = "csc_en";
            desc = "CSC enable.";
            sw = rw;
            hw = r;
            encode = G3CSCIDC_csc_en_enum;
            reset = 0x0;
        } csc_en[27:27];

        field {
            name = "cscidc2";
            desc = "DC parameter of input component 2. The MSB is the signed bit. The value is expressed as the complementary code.";
            sw = r;
            hw = w;
            reset = 0x0;
        } cscidc2[26:18];

        field {
            name = "cscidc1";
            desc = "DC parameter of input component 1. The MSB is the signed bit. The value is expressed as the complementary code.";
            sw = r;
            hw = w;
            reset = 0x0;
        } cscidc1[17:9];

        field {
            name = "cscidc0";
            desc = "DC parameter of input component 0. The MSB is the signed bit. The value is expressed as the complementary code.";
            sw = r;
            hw = w;
            reset = 0x0;
        } cscidc0[8:0];
    } G3CSCIDC @ 0x96A0;

    reg {
        name = "G3 output DC component register for CSC";
        desc = "G3CSCODC is the G3 output DC component register for CSC (instant register).

Data sheet 10.2.5 G3CSCODC (offset 0x96A4, printed page 10-121, `hi3516cv100--Hi3516C-Datasheet.txt` line 43191).";

        field {
            name = "cscodc2";
            desc = "DC parameter of output component 2. The MSB is the signed bit. The value is expressed as the complementary code.";
            sw = r;
            hw = w;
            reset = 0x0;
        } cscodc2[26:18];

        field {
            name = "cscodc1";
            desc = "DC parameter of output component 1. The MSB is the signed bit. The value is expressed as the complementary code.";
            sw = r;
            hw = w;
            reset = 0x0;
        } cscodc1[17:9];

        field {
            name = "cscodc0";
            desc = "DC parameter of output component 0. The MSB is the signed bit. The value is expressed as the complementary code.";
            sw = r;
            hw = w;
            reset = 0x0;
        } cscodc0[8:0];
    } G3CSCODC @ 0x96A4;

    reg {
        name = "G3 CSC parameter 0 register";
        desc = "G3CSCP0 is the G3 CSC parameter 0 register (instant register).

Data sheet 10.2.5 G3CSCP0 (offset 0x96A8, printed page 10-122, `hi3516cv100--Hi3516C-Datasheet.txt` line 43228).";

        field {
            name = "cscp01";
            desc = "5.8 data format. The value consists of a 1-bit signed bit, a 4-bit integral part, and an 8-bit fractional part. The value is expressed as the complementary code.";
            sw = r;
            hw = w;
            reset = 0x0;
        } cscp01[28:16];

        field {
            name = "cscp00";
            desc = "5.8 data format. The value consists of a 1-bit signed bit, a 4-bit integral part, and an 8-bit fractional part. The value is expressed as the complementary code.";
            sw = r;
            hw = w;
            reset = 0x0;
        } cscp00[12:0];
    } G3CSCP0 @ 0x96A8;

    reg {
        name = "G3 CSC parameter 1 register";
        desc = "G3CSCP1 is the G3 CSC parameter 1 register (instant register).

Data sheet 10.2.5 G3CSCP1 (offset 0x96AC, printed page 10-122, `hi3516cv100--Hi3516C-Datasheet.txt` line 43260).";

        field {
            name = "cscp10";
            desc = "5.8 data format. The value consists of a 1-bit signed bit, a 4-bit integral part, and an 8-bit fractional part. The value is expressed as the complementary code.";
            sw = r;
            hw = w;
            reset = 0x0;
        } cscp10[28:16];

        field {
            name = "cscp02";
            desc = "5.8 data format. The value consists of a 1-bit signed bit, a 4-bit integral part, and an 8-bit fractional part. The value is expressed as the complementary code.";
            sw = r;
            hw = w;
            reset = 0x0;
        } cscp02[12:0];
    } G3CSCP1 @ 0x96AC;

    reg {
        name = "G3 CSC parameter 2 register";
        desc = "G3CSCP2 is the G3 CSC parameter 2 register (instant register).

Data sheet 10.2.5 G3CSCP2 (offset 0x96B0, printed page 10-123, `hi3516cv100--Hi3516C-Datasheet.txt` line 43300).";

        field {
            name = "cscp12";
            desc = "5.8 data format. The value consists of a 1-bit signed bit, a 4-bit integral part, and an 8-bit fractional part. The value is expressed as the complementary code.";
            sw = r;
            hw = w;
            reset = 0x0;
        } cscp12[28:16];

        field {
            name = "cscp11";
            desc = "5.8 data format. The value consists of a 1-bit signed bit, a 4-bit integral part, and an 8-bit fractional part. The value is expressed as the complementary code.";
            sw = r;
            hw = w;
            reset = 0x0;
        } cscp11[12:0];
    } G3CSCP2 @ 0x96B0;

    reg {
        name = "G3 CSC parameter 3 register";
        desc = "G3CSCP3 is the G3 CSC parameter 3 register (instant register).

Data sheet 10.2.5 G3CSCP3 (offset 0x96B4, printed page 10-123, `hi3516cv100--Hi3516C-Datasheet.txt` line 43332).";

        field {
            name = "cscp21";
            desc = "5.8 data format. The value consists of a 1-bit signed bit, a 4-bit integral part, and an 8-bit fractional part. The value is expressed as the complementary code.";
            sw = r;
            hw = w;
            reset = 0x0;
        } cscp21[28:16];

        field {
            name = "cscp20";
            desc = "5.8 data format. The value consists of a 1-bit signed bit, a 4-bit integral part, and an 8-bit fractional part. The value is expressed as the complementary code.";
            sw = r;
            hw = w;
            reset = 0x0;
        } cscp20[12:0];
    } G3CSCP3 @ 0x96B4;

    reg {
        name = "G3 CSC parameter 4 register";
        desc = "G3CSCP4 is the G3 CSC parameter 4 register (instant register).

Data sheet 10.2.5 G3CSCP4 (offset 0x96B8, printed page 10-124, `hi3516cv100--Hi3516C-Datasheet.txt` line 43372).";

        field {
            name = "cscp22";
            desc = "5.8 data format. The value consists of a 1-bit signed bit, a 4-bit integral part, and an 8-bit fractional part. The value is expressed as the complementary code.";
            sw = r;
            hw = w;
            reset = 0x0;
        } cscp22[12:0];
    } G3CSCP4 @ 0x96B8;

    reg {
        name = "SD1 overlay background color register";
        desc = "CBMBKG4 is the SD1 overlay background color register.

Data sheet 10.2.5 CBMBKG4 (offset 0x9E0C, printed page 10-124, `hi3516cv100--Hi3516C-Datasheet.txt` line 43394).";

        field {
            name = "cbm_bkgy";
            desc = "Overlay background color of mixer 4, Y component.";
            sw = rw;
            hw = r;
            reset = 0x0;
        } cbm_bkgy[23:16];

        field {
            name = "cbm_bkgcb";
            desc = "Overlay background color of mixer 4, Cb component.";
            sw = rw;
            hw = r;
            reset = 0x0;
        } cbm_bkgcb[15:8];

        field {
            name = "cbm_bkgcr";
            desc = "Overlay background color of mixer 4, Cr component.";
            sw = rw;
            hw = r;
            reset = 0x0;
        } cbm_bkgcr[7:0];
    } CBMBKG4 @ 0x9E0C;

    reg {
        name = "Mixer 4 priority configuration register";
        desc = "CBMMIX4 is the mixer 4 priority configuration register (non-instant register). The register configuration takes effect only when the VSYNC signal is valid.

Data sheet 10.2.5 CBMMIX4 (offset 0x9E20, printed page 10-125, `hi3516cv100--Hi3516C-Datasheet.txt` line 43423).";

        enum CBMMIX4_mixer_prio1_enum {
            NO_OVERLAY_LAYER = 0 { name = "No Overlay Layer"; desc = "no overlay layer"; };
            VSD1 = 5 { name = "Vsd1"; desc = "VSD1"; };
            G3_OTHER_VALUES = 12 { name = "G3 Other Values"; desc = "G3 Other values: reserved"; };
        };

        field {
            name = "mixer_prio1";
            desc = "Priority 1 of the overlay layer of mixer 4.";
            sw = rw;
            hw = r;
            encode = CBMMIX4_mixer_prio1_enum;
            reset = 0x0;
        } mixer_prio1[7:4];

        enum CBMMIX4_mixer_prio0_enum {
            NO_OVERLAY_LAYER = 0 { name = "No Overlay Layer"; desc = "no overlay layer"; };
            VSD1 = 5 { name = "Vsd1"; desc = "VSD1"; };
            G3_OTHER_VALUES = 12 { name = "G3 Other Values"; desc = "G3 Other values: reserved"; };
        };

        field {
            name = "mixer_prio0";
            desc = "Priority 0 of the overlay layer of mixer 4.";
            sw = rw;
            hw = r;
            encode = CBMMIX4_mixer_prio0_enum;
            reset = 0x0;
        } mixer_prio0[3:0];
    } CBMMIX4 @ 0x9E20;

    reg {
        name = "DSD1CTRL";
        desc = "DSD1CTRL.

Data sheet 10.2.5 DSD1CTRL (offset 0xAC00, printed page 10-126, `hi3516cv100--Hi3516C-Datasheet.txt` line 43467).";

        enum DSD1CTRL_intf_en_enum {
            DISABLED = 0 { name = "Disabled"; desc = "disabled"; };
            ENABLED = 1 { name = "Enabled"; desc = "enabled"; };
        };

        field {
            name = "intf_en";
            desc = "Display interface enable (instant register). Data is output over the interface only when this bit is enabled.";
            sw = rw;
            hw = r;
            encode = DSD1CTRL_intf_en_enum;
            reset = 0x0;
        } intf_en[31:31];

        enum DSD1CTRL_idv_enum {
            DISABLED = 0 { name = "Disabled"; desc = "disabled"; };
            ENABLED = 1 { name = "Enabled"; desc = "enabled"; };
        };

        field {
            name = "idv";
            desc = "Output phase reverse enable for the data valid signal (instant field).";
            sw = rw;
            hw = r;
            encode = DSD1CTRL_idv_enum;
            reset = 0x0;
        } idv[10:10];

        enum DSD1CTRL_ihs_enum {
            DISABLED = 0 { name = "Disabled"; desc = "disabled"; };
            ENABLED = 1 { name = "Enabled"; desc = "enabled"; };
        };

        field {
            name = "ihs";
            desc = "Output phase reverse enable for the horizontal sync pulse (instant field).";
            sw = rw;
            hw = r;
            encode = DSD1CTRL_ihs_enum;
            reset = 0x0;
        } ihs[9:9];

        enum DSD1CTRL_ivs_enum {
            DISABLED = 0 { name = "Disabled"; desc = "disabled"; };
            ENABLED = 1 { name = "Enabled"; desc = "enabled"; };
        };

        field {
            name = "ivs";
            desc = "Output phase reverse enable for the vertical sync pulse (instant field).";
            sw = rw;
            hw = r;
            encode = DSD1CTRL_ivs_enum;
            reset = 0x0;
        } ivs[8:8];

        enum DSD1CTRL_iop_enum {
            INTERLACED_DISPLAY = 0 { name = "Interlaced Display"; desc = "interlaced display"; };
            PROGRESSIVE_DISPLAY = 1 { name = "Progressive Display"; desc = "progressive display"; };
        };

        field {
            name = "iop";
            desc = "Progressive or interlaced display (instant field).";
            sw = rw;
            hw = r;
            encode = DSD1CTRL_iop_enum;
            reset = 0x0;
        } iop[7:7];

        enum DSD1CTRL_synm_enum {
            TIMING_LABEL_MODE = 0 { name = "Timing Label Mode"; desc = "timing label mode (such as BT.656)"; };
            SYNC_SIGNAL_MODE = 1 { name = "Sync Signal Mode"; desc = "sync signal mode (such as LCD display)"; };
        };

        field {
            name = "synm";
            desc = "Sync mode (instant field).";
            sw = rw;
            hw = r;
            encode = DSD1CTRL_synm_enum;
            reset = 0x0;
        } synm[6:6];

        field {
            name = "intfb";
            desc = "Bit width mode of the output interface (instant field). 00: single-component mode (each clock outputs one component) Other values: reserved";
            sw = rw;
            hw = r;
            reset = 0x0;
        } intfb[5:4];

        field {
            name = "intfdm";
            desc = "Interface data format (instant field). 0x0: YCbCr422 Other values: reserved";
            sw = rw;
            hw = r;
            reset = 0x0;
        } intfdm[3:0];
    } DSD1CTRL @ 0xAC00;

    reg {
        name = "DSD1 vertical timing register";
        desc = "DSD1VSYNC is the DSD1 vertical timing register. In interlaced output mode, this register indicates the top vertical sync timing; in progressive output mode, this register indicates the frame vertical sync timing. The setting of this register takes effect immediately after configuration. That is, the timing of the VSYNC pin is affected immediately. You must configure this register before configuring DSDCTRL[intf_en]. Otherwise, the configuration does not take effect.

Data sheet 10.2.5 DSD1VSYNC (offset 0xAC04, printed page 10-127, `hi3516cv100--Hi3516C-Datasheet.txt` line 43539).";

        field {
            name = "vfb";
            desc = "In interlaced output mode: TVFB In progressive output mode: VFB Unit: line";
            sw = rw;
            hw = r;
            reset = 0x1;
        } vfb[27:20];

        field {
            name = "vbb";
            desc = "In interlaced output mode: TVBB In progressive output mode: VBB + VPW Unit: line";
            sw = rw;
            hw = r;
            reset = 0x15;
        } vbb[19:12];

        field {
            name = "vact";
            desc = "In interlaced output mode: height of an active picture in the top field In progressive output format: height of an active picture in a frame. The register value is the actual value minus 1. Unit: line";
            sw = rw;
            hw = r;
            reset = 0x11F;
        } vact[11:0];
    } DSD1VSYNC @ 0xAC04;

    reg {
        name = "DSD1HSYNC1";
        desc = "DSD1HSYNC1.

Data sheet 10.2.5 DSD1HSYNC1 (offset 0xAC08, printed page 10-128, `hi3516cv100--Hi3516C-Datasheet.txt` line 43589).";

        field {
            name = "hbb";
            desc = "HBB. Unit: pixel";
            sw = rw;
            hw = r;
            reset = 0x107;
        } hbb[31:16];

        field {
            name = "hact";
            desc = "Number of horizontal pixels in an active region.";
            sw = rw;
            hw = r;
            reset = 0x2CF;
        } hact[15:0];
    } DSD1HSYNC1 @ 0xAC08;

    reg {
        name = "DSD1 horizontal timing register 2";
        desc = "DSD1HSYNC2 is DSD1 horizontal timing register 2. In interlaced or progressive output mode, this register is the horizontal sync timing configuration register. The setting of this register takes effect immediately after configuration. That is, the timing of the HSYNC pin is affected immediately. You must configure this register before configuring DSDCTRL[intf_en]. Otherwise, the configuration does not take effect.

Data sheet 10.2.5 DSD1HSYNC2 (offset 0xAC0C, printed page 10-128, `hi3516cv100--Hi3516C-Datasheet.txt` line 43622).";

        field {
            name = "hfb";
            desc = "HFB. Unit: pixel";
            sw = rw;
            hw = r;
            reset = 0x17;
        } hfb[15:0];
    } DSD1HSYNC2 @ 0xAC0C;

    reg {
        name = "DSD1 bottom vertical sync timing register in interlaced output mode";
        desc = "DSD1VPLUS is the DSD1 bottom vertical sync timing register in interlaced output mode. You must configure this register before configuring DSDCTRL[intf_en]. Otherwise, the configuration does not take effect.

Data sheet 10.2.5 DSD1VPLUS (offset 0xAC10, printed page 10-129, `hi3516cv100--Hi3516C-Datasheet.txt` line 43661).";

        field {
            name = "bvfb";
            desc = "In interlaced output mode: BVFB Unit: line";
            sw = rw;
            hw = r;
            reset = 0x1;
        } bvfb[27:20];

        field {
            name = "bvbb";
            desc = "In interlaced output mode: BVBB + VPW Unit: line";
            sw = rw;
            hw = r;
            reset = 0x16;
        } bvbb[19:12];

        field {
            name = "bvact";
            desc = "In interlaced output mode: height of an active picture in the bottom field. The register value is the actual value minus 1. Unit: line";
            sw = rw;
            hw = r;
            reset = 0x11F;
        } bvact[11:0];
    } DSD1VPLUS @ 0xAC10;

    reg {
        name = "DSD1PWR";
        desc = "DSD1PWR.

Data sheet 10.2.5 DSD1PWR (offset 0xAC14, printed page 10-130, `hi3516cv100--Hi3516C-Datasheet.txt` line 43708).";

        field {
            name = "vpw";
            desc = "VPW minus 1. Unit: pixel";
            sw = rw;
            hw = r;
            reset = 0x0;
        } vpw[23:16];

        field {
            name = "hpw";
            desc = "HPW minus 1. Unit: pixel";
            sw = rw;
            hw = r;
            reset = 0x0;
        } hpw[15:0];
    } DSD1PWR @ 0xAC14;

    reg {
        name = "DSD1 vertical timing threshold register";
        desc = "DSD1VTTHD is the DSD1 vertical timing threshold register (instant register). It can be used to set two thresholds for generating two interrupts separately.

Data sheet 10.2.5 DSD1VTTHD (offset 0xAC1C, printed page 10-130, `hi3516cv100--Hi3516C-Datasheet.txt` line 43734).";

        enum DSD1VTTHD_thd1_mode_enum {
            FRAME_MODE_THRESHOLD = 0 { name = "Frame Mode Threshold"; desc = "frame mode. The threshold count is in the unit of frame."; };
            FIELD_MODE_THRESHOLD = 1 { name = "Field Mode Threshold"; desc = "field mode. The threshold count is in the unit of field in interlaced display mode."; };
        };

        field {
            name = "thd1_mode";
            desc = "Threshold 1 interrupt generation mode.";
            sw = rw;
            hw = r;
            encode = DSD1VTTHD_thd1_mode_enum;
            reset = 0x0;
        } thd1_mode[15:15];

        field {
            name = "vtmgthd1";
            desc = "Vertical timing threshold 1. When the vertical timing counter reaches this threshold, the VOINTSTA[dsdvtthd_int1] interrupt is triggered.";
            sw = rw;
            hw = r;
            reset = 0x1;
        } vtmgthd1[12:0];
    } DSD1VTTHD @ 0xAC1C;

    reg {
        name = "DSD1 clip lower threshold register";
        desc = "DSD1CLIPL is the DSD1 clip lower threshold register (instant register).

Data sheet 10.2.5 DSD1CLIPL (offset 0xAC40, printed page 10-131, `hi3516cv100--Hi3516C-Datasheet.txt` line 43777).";

        enum DSD1CLIPL_clipen_enum {
            DISABLED = 0 { name = "Disabled"; desc = "disabled"; };
            ENABLED = 1 { name = "Enabled"; desc = "enabled"; };
        };

        field {
            name = "clipen";
            desc = "Output clip enable (instant field).";
            sw = rw;
            hw = r;
            encode = DSD1CLIPL_clipen_enum;
            reset = 0x0;
        } clipen[31:31];

        enum DSD1CLIPL_dfir_en_enum {
            DISABLED = 0 { name = "Disabled"; desc = "disabled"; };
            ENABLED = 1 { name = "Enabled"; desc = "enabled"; };
        };

        field {
            name = "dfir_en";
            desc = "Horizontal chrominance down scaling enable.";
            sw = rw;
            hw = r;
            encode = DSD1CLIPL_dfir_en_enum;
            reset = 0x1;
        } dfir_en[30:30];

        field {
            name = "clipcl2";
            desc = "Lower threshold Y/R of component 2, unsigned integer.";
            sw = rw;
            hw = r;
            reset = 0x1;
        } clipcl2[29:20];

        field {
            name = "clipcl1";
            desc = "Lower threshold Cb/G of component 1, unsigned integer.";
            sw = rw;
            hw = r;
            reset = 0x4;
        } clipcl1[19:10];

        field {
            name = "clipcl0";
            desc = "Lower threshold Cr/B of component 0, unsigned integer.";
            sw = rw;
            hw = r;
            reset = 0x10;
        } clipcl0[9:0];
    } DSD1CLIPL @ 0xAC40;

    reg {
        name = "DSD1 clip upper threshold register";
        desc = "DSD1CLIPH is the DSD1 clip upper threshold register (instant register). For example, the output data needs to be clipped in BT.656 output mode.

Data sheet 10.2.5 DSD1CLIPH (offset 0xAC44, printed page 10-132, `hi3516cv100--Hi3516C-Datasheet.txt` line 43818).";

        field {
            name = "clipch2";
            desc = "Upper threshold Y/R of component 2, unsigned integer.";
            sw = rw;
            hw = r;
            reset = 0xE;
        } clipch2[29:20];

        field {
            name = "clipch1";
            desc = "Upper threshold Cb/G of component 1, unsigned integer.";
            sw = rw;
            hw = r;
            reset = 0x2FC;
        } clipch1[19:10];

        field {
            name = "clipch0";
            desc = "Upper threshold Cr/B of component 0, unsigned integer.";
            sw = rw;
            hw = r;
            reset = 0xF0;
        } clipch0[9:0];
    } DSD1CLIPH @ 0xAC44;

    reg {
        name = "DSD1 status register";
        desc = "DSD1STATE is the DSD1 status register.

Data sheet 10.2.5 DSD1STATE (offset 0xACF0, printed page 10-132, `hi3516cv100--Hi3516C-Datasheet.txt` line 43846).";

        enum DSD1STATE_bottom_field_enum {
            TOP_FIELD = 0 { name = "Top Field"; desc = "top field"; };
            BOTTOM_FIELD = 1 { name = "Bottom Field"; desc = "bottom field"; };
        };

        field {
            name = "bottom_field";
            desc = "DSD1 top/bottom field flag.";
            sw = rw;
            hw = r;
            encode = DSD1STATE_bottom_field_enum;
            reset = 0x0;
        } bottom_field[2:2];

        enum DSD1STATE_vblank_enum {
            ACTIVE_REGION = 0 { name = "Active Region"; desc = "active region"; };
            BLANKING_REGION = 1 { name = "Blanking Region"; desc = "blanking region"; };
        };

        field {
            name = "vblank";
            desc = "DSD1 blanking region flag.";
            sw = rw;
            hw = r;
            encode = DSD1STATE_vblank_enum;
            reset = 0x0;
        } vblank[1:1];

        enum DSD1STATE_vback_blank_enum {
            NON_BACK_BLANKING = 0 { name = "Non Back Blanking"; desc = "non-back blanking region"; };
            BACK_BLANKING_REGION = 1 { name = "Back Blanking Region"; desc = "back blanking region"; };
        };

        field {
            name = "vback_blank";
            desc = "DSD1 back blanking region flag.";
            sw = rw;
            hw = r;
            encode = DSD1STATE_vback_blank_enum;
            reset = 0x0;
        } vback_blank[0:0];
    } DSD1STATE @ 0xACF0;

    reg {
        name = "DATE amplitude configuration register";
        desc = "DATE_COEFF1 is the DATE amplitude configuration register.

Data sheet 10.2.5 DATE_COEFF1 (offset 0xC204, printed page 10-133, `hi3516cv100--Hi3516C-Datasheet.txt` line 43891).";

        field {
            name = "c_gain";
            desc = "Adjustment of the chrominance sync gain amplitude.";
            sw = rw;
            hw = r;
            reset = 0x0;
        } c_gain[31:29];

        enum DATE_COEFF1_cvbs_limit_en_enum {
            DISABLED = 0 { name = "Disabled"; desc = "disabled"; };
            ENABLED = 1 { name = "Enabled"; desc = "enabled"; };
        };

        field {
            name = "cvbs_limit_en";
            desc = "CVBS amplitude limit enable.";
            sw = rw;
            hw = r;
            encode = DATE_COEFF1_cvbs_limit_en_enum;
            reset = 0x0;
        } cvbs_limit_en[28:28];

        enum DATE_COEFF1_wss_seq_enum {
            FROM_UPPER_BITS = 0 { name = "From Upper Bits"; desc = "from upper bits to lower bits"; };
            FROM_LOWER_BITS = 1 { name = "From Lower Bits"; desc = "from lower bits to upper bits"; };
        };

        field {
            name = "wss_seq";
            desc = "Sequence of transmitting the bits of the WSS data.";
            sw = rw;
            hw = r;
            encode = DATE_COEFF1_wss_seq_enum;
            reset = 0x0;
        } wss_seq[27:27];

        enum DATE_COEFF1_vps_seq_enum {
            FROM_UPPER_BITS = 0 { name = "From Upper Bits"; desc = "from upper bits to lower bits"; };
            FROM_LOWER_BITS = 1 { name = "From Lower Bits"; desc = "from lower bits to upper bits"; };
        };

        field {
            name = "vps_seq";
            desc = "Sequence of transmitting the bits of the VPS data.";
            sw = rw;
            hw = r;
            encode = DATE_COEFF1_vps_seq_enum;
            reset = 0x0;
        } vps_seq[26:26];

        enum DATE_COEFF1_cgms_seq_enum {
            FROM_UPPER_BITS = 0 { name = "From Upper Bits"; desc = "from upper bits to lower bits"; };
            FROM_LOWER_BITS = 1 { name = "From Lower Bits"; desc = "from lower bits to upper bits"; };
        };

        field {
            name = "cgms_seq";
            desc = "Sequence of transmitting the bits of the CGMS data.";
            sw = rw;
            hw = r;
            encode = DATE_COEFF1_cgms_seq_enum;
            reset = 0x0;
        } cgms_seq[25:25];

        enum DATE_COEFF1_cc_seq_enum {
            FROM_UPPER_BITS = 0 { name = "From Upper Bits"; desc = "from upper bits to lower bits"; };
            FROM_LOWER_BITS = 1 { name = "From Lower Bits"; desc = "from lower bits to upper bits"; };
        };

        field {
            name = "cc_seq";
            desc = "Sequence of transmitting the bits of the closed caption data.";
            sw = rw;
            hw = r;
            encode = DATE_COEFF1_cc_seq_enum;
            reset = 0x0;
        } cc_seq[24:24];

        enum DATE_COEFF1_c_limit_en_enum {
            DISABLED = 0 { name = "Disabled"; desc = "disabled"; };
            ENABLED = 1 { name = "Enabled"; desc = "enabled"; };
        };

        field {
            name = "c_limit_en";
            desc = "Chrominance amplitude limit enable.";
            sw = rw;
            hw = r;
            encode = DATE_COEFF1_c_limit_en_enum;
            reset = 0x0;
        } c_limit_en[23:23];

        field {
            name = "amp_outside";
            desc = "Pulse amplitude input of the external AGC.";
            sw = rw;
            hw = r;
            reset = 0x0;
        } amp_outside[22:13];

        enum DATE_COEFF1_date_test_en_enum {
            INVALID = 0 { name = "Invalid"; desc = "invalid"; };
            VALID = 1 { name = "Valid"; desc = "valid"; };
        };

        field {
            name = "date_test_en";
            desc = "Test valid signal.";
            sw = rw;
            hw = r;
            encode = DATE_COEFF1_date_test_en_enum;
            reset = 0x0;
        } date_test_en[12:12];

        field {
            name = "date_test_mode";
            desc = "Test mode signal.";
            sw = rw;
            hw = r;
            reset = 0x0;
        } date_test_mode[11:10];

        field {
            name = "dac_test";
            desc = "DAC test value input.";
            sw = rw;
            hw = r;
            reset = 0x0;
        } dac_test[9:0];
    } DATE_COEFF1 @ 0xC204;

    reg {
        name = "DATE teletext configuration register";
        desc = "DATE_COEFF7 is a DATE teletext configuration register.

Data sheet 10.2.5 DATE_COEFF7 (offset 0xC21C, printed page 10-134, `hi3516cv100--Hi3516C-Datasheet.txt` line 43952).";

        enum DATE_COEFF7_tt22_enf1_enum {
            DISABLED = 0 { name = "Disabled"; desc = "disabled"; };
            ENABLED = 1 { name = "Enabled"; desc = "enabled"; };
        };

        field {
            name = "tt22_enf1";
            desc = "Control of the teletext in line 22 in the odd field.";
            sw = rw;
            hw = r;
            encode = DATE_COEFF7_tt22_enf1_enum;
            reset = 0x0;
        } tt22_enf1[31:31];

        enum DATE_COEFF7_tt21_enf1_enum {
            DISABLED = 0 { name = "Disabled"; desc = "disabled"; };
            ENABLED = 1 { name = "Enabled"; desc = "enabled"; };
        };

        field {
            name = "tt21_enf1";
            desc = "Control of the teletext in line 21 in the odd field.";
            sw = rw;
            hw = r;
            encode = DATE_COEFF7_tt21_enf1_enum;
            reset = 0x0;
        } tt21_enf1[30:30];

        enum DATE_COEFF7_tt20_enf1_enum {
            DISABLED = 0 { name = "Disabled"; desc = "disabled"; };
            ENABLED = 1 { name = "Enabled"; desc = "enabled"; };
        };

        field {
            name = "tt20_enf1";
            desc = "Control of the teletext in line 20 in the odd field.";
            sw = rw;
            hw = r;
            encode = DATE_COEFF7_tt20_enf1_enum;
            reset = 0x0;
        } tt20_enf1[29:29];

        enum DATE_COEFF7_tt19_enf1_enum {
            DISABLED = 0 { name = "Disabled"; desc = "disabled"; };
            ENABLED = 1 { name = "Enabled"; desc = "enabled"; };
        };

        field {
            name = "tt19_enf1";
            desc = "Control of the teletext in line 19 in the odd field.";
            sw = rw;
            hw = r;
            encode = DATE_COEFF7_tt19_enf1_enum;
            reset = 0x0;
        } tt19_enf1[28:28];

        enum DATE_COEFF7_tt18_enf1_enum {
            DISABLED = 0 { name = "Disabled"; desc = "disabled"; };
            ENABLED = 1 { name = "Enabled"; desc = "enabled"; };
        };

        field {
            name = "tt18_enf1";
            desc = "Control of the teletext in line 18 in the odd field.";
            sw = rw;
            hw = r;
            encode = DATE_COEFF7_tt18_enf1_enum;
            reset = 0x0;
        } tt18_enf1[27:27];

        enum DATE_COEFF7_tt17_enf1_enum {
            DISABLED = 0 { name = "Disabled"; desc = "disabled"; };
            ENABLED = 1 { name = "Enabled"; desc = "enabled"; };
        };

        field {
            name = "tt17_enf1";
            desc = "Control of the teletext in line 17 in the odd field.";
            sw = rw;
            hw = r;
            encode = DATE_COEFF7_tt17_enf1_enum;
            reset = 0x0;
        } tt17_enf1[26:26];

        enum DATE_COEFF7_tt16_enf1_enum {
            DISABLED = 0 { name = "Disabled"; desc = "disabled"; };
            ENABLED = 1 { name = "Enabled"; desc = "enabled"; };
        };

        field {
            name = "tt16_enf1";
            desc = "Control of the teletext in line 16 in the odd field.";
            sw = rw;
            hw = r;
            encode = DATE_COEFF7_tt16_enf1_enum;
            reset = 0x0;
        } tt16_enf1[25:25];

        enum DATE_COEFF7_tt15_enf1_enum {
            DISABLED = 0 { name = "Disabled"; desc = "disabled"; };
            ENABLED = 1 { name = "Enabled"; desc = "enabled"; };
        };

        field {
            name = "tt15_enf1";
            desc = "Control of the teletext in line 15 in the odd field.";
            sw = rw;
            hw = r;
            encode = DATE_COEFF7_tt15_enf1_enum;
            reset = 0x0;
        } tt15_enf1[24:24];

        enum DATE_COEFF7_tt14_enf1_enum {
            DISABLED = 0 { name = "Disabled"; desc = "disabled"; };
            ENABLED = 1 { name = "Enabled"; desc = "enabled"; };
        };

        field {
            name = "tt14_enf1";
            desc = "Control of the teletext in line 14 in the odd field.";
            sw = rw;
            hw = r;
            encode = DATE_COEFF7_tt14_enf1_enum;
            reset = 0x0;
        } tt14_enf1[23:23];

        enum DATE_COEFF7_tt13_enf1_enum {
            DISABLED = 0 { name = "Disabled"; desc = "disabled"; };
            ENABLED = 1 { name = "Enabled"; desc = "enabled"; };
        };

        field {
            name = "tt13_enf1";
            desc = "Control of the teletext in line 13 in the odd field.";
            sw = rw;
            hw = r;
            encode = DATE_COEFF7_tt13_enf1_enum;
            reset = 0x0;
        } tt13_enf1[22:22];

        field {
            name = "tt12_enf1";
            desc = "Control of the teletext in line 12 in the odd field.0: disabled 1: enabled";
            sw = rw;
            hw = r;
            reset = 0x0;
        } tt12_enf1[21:21];

        field {
            name = "tt11_enf1";
            desc = "Control of the teletext in line 11 in the odd field.0: disabled 1: enabled";
            sw = rw;
            hw = r;
            reset = 0x0;
        } tt11_enf1[20:20];

        enum DATE_COEFF7_tt10_enf1_enum {
            DISABLED = 0 { name = "Disabled"; desc = "disabled"; };
            ENABLED = 1 { name = "Enabled"; desc = "enabled"; };
        };

        field {
            name = "tt10_enf1";
            desc = "Control of the teletext in line 10 in the odd field.";
            sw = rw;
            hw = r;
            encode = DATE_COEFF7_tt10_enf1_enum;
            reset = 0x0;
        } tt10_enf1[19:19];

        enum DATE_COEFF7_tt09_enf1_enum {
            DISABLED = 0 { name = "Disabled"; desc = "disabled"; };
            ENABLED = 1 { name = "Enabled"; desc = "enabled"; };
        };

        field {
            name = "tt09_enf1";
            desc = "Control of the teletext in line 9 in the odd field.";
            sw = rw;
            hw = r;
            encode = DATE_COEFF7_tt09_enf1_enum;
            reset = 0x0;
        } tt09_enf1[18:18];

        enum DATE_COEFF7_tt08_enf1_enum {
            DISABLED = 0 { name = "Disabled"; desc = "disabled"; };
            ENABLED = 1 { name = "Enabled"; desc = "enabled"; };
        };

        field {
            name = "tt08_enf1";
            desc = "Control of the teletext in line 8 in the odd field.";
            sw = rw;
            hw = r;
            encode = DATE_COEFF7_tt08_enf1_enum;
            reset = 0x0;
        } tt08_enf1[17:17];

        enum DATE_COEFF7_tt07_enf1_enum {
            DISABLED = 0 { name = "Disabled"; desc = "disabled"; };
            ENABLED = 1 { name = "Enabled"; desc = "enabled"; };
        };

        field {
            name = "tt07_enf1";
            desc = "Control of the teletext in line 7 in the odd field.";
            sw = rw;
            hw = r;
            encode = DATE_COEFF7_tt07_enf1_enum;
            reset = 0x0;
        } tt07_enf1[16:16];

        enum DATE_COEFF7_tt22_enf2_enum {
            DISABLED = 0 { name = "Disabled"; desc = "disabled"; };
            ENABLED = 1 { name = "Enabled"; desc = "enabled"; };
        };

        field {
            name = "tt22_enf2";
            desc = "Control of teletext in line 22 in the even field.";
            sw = rw;
            hw = r;
            encode = DATE_COEFF7_tt22_enf2_enum;
            reset = 0x0;
        } tt22_enf2[15:15];

        enum DATE_COEFF7_tt21_enf2_enum {
            DISABLED = 0 { name = "Disabled"; desc = "disabled"; };
            ENABLED = 1 { name = "Enabled"; desc = "enabled"; };
        };

        field {
            name = "tt21_enf2";
            desc = "Control of teletext in line 21 in the even field.";
            sw = rw;
            hw = r;
            encode = DATE_COEFF7_tt21_enf2_enum;
            reset = 0x0;
        } tt21_enf2[14:14];

        enum DATE_COEFF7_tt20_enf2_enum {
            DISABLED = 0 { name = "Disabled"; desc = "disabled"; };
            ENABLED = 1 { name = "Enabled"; desc = "enabled"; };
        };

        field {
            name = "tt20_enf2";
            desc = "Control of teletext in line 20 in the even field.";
            sw = rw;
            hw = r;
            encode = DATE_COEFF7_tt20_enf2_enum;
            reset = 0x0;
        } tt20_enf2[13:13];

        enum DATE_COEFF7_tt19_enf2_enum {
            DISABLED = 0 { name = "Disabled"; desc = "disabled"; };
            ENABLED = 1 { name = "Enabled"; desc = "enabled"; };
        };

        field {
            name = "tt19_enf2";
            desc = "Control of teletext in line 19 in the even field.";
            sw = rw;
            hw = r;
            encode = DATE_COEFF7_tt19_enf2_enum;
            reset = 0x0;
        } tt19_enf2[12:12];

        enum DATE_COEFF7_tt18_enf2_enum {
            DISABLED = 0 { name = "Disabled"; desc = "disabled"; };
            ENABLED = 1 { name = "Enabled"; desc = "enabled"; };
        };

        field {
            name = "tt18_enf2";
            desc = "Control of teletext in line 18 in the even field.";
            sw = rw;
            hw = r;
            encode = DATE_COEFF7_tt18_enf2_enum;
            reset = 0x0;
        } tt18_enf2[11:11];

        enum DATE_COEFF7_tt17_enf2_enum {
            DISABLED = 0 { name = "Disabled"; desc = "disabled"; };
            ENABLED = 1 { name = "Enabled"; desc = "enabled"; };
        };

        field {
            name = "tt17_enf2";
            desc = "Control of teletext in line 17 in the even field.";
            sw = rw;
            hw = r;
            encode = DATE_COEFF7_tt17_enf2_enum;
            reset = 0x0;
        } tt17_enf2[10:10];

        enum DATE_COEFF7_tt16_enf2_enum {
            DISABLED = 0 { name = "Disabled"; desc = "disabled"; };
            ENABLED = 1 { name = "Enabled"; desc = "enabled"; };
        };

        field {
            name = "tt16_enf2";
            desc = "Control of teletext in line 16 in the even field.";
            sw = rw;
            hw = r;
            encode = DATE_COEFF7_tt16_enf2_enum;
            reset = 0x0;
        } tt16_enf2[9:9];

        enum DATE_COEFF7_tt15_enf2_enum {
            DISABLED = 0 { name = "Disabled"; desc = "disabled"; };
            ENABLED = 1 { name = "Enabled"; desc = "enabled"; };
        };

        field {
            name = "tt15_enf2";
            desc = "Control of teletext in line 15 in the even field.";
            sw = rw;
            hw = r;
            encode = DATE_COEFF7_tt15_enf2_enum;
            reset = 0x0;
        } tt15_enf2[8:8];

        enum DATE_COEFF7_tt14_enf2_enum {
            DISABLED = 0 { name = "Disabled"; desc = "disabled"; };
            ENABLED = 1 { name = "Enabled"; desc = "enabled"; };
        };

        field {
            name = "tt14_enf2";
            desc = "Control of teletext in line 14 in the even field.";
            sw = rw;
            hw = r;
            encode = DATE_COEFF7_tt14_enf2_enum;
            reset = 0x0;
        } tt14_enf2[7:7];

        enum DATE_COEFF7_tt13_enf2_enum {
            DISABLED = 0 { name = "Disabled"; desc = "disabled"; };
            ENABLED = 1 { name = "Enabled"; desc = "enabled"; };
        };

        field {
            name = "tt13_enf2";
            desc = "Control of teletext in line 13 in the even field.";
            sw = rw;
            hw = r;
            encode = DATE_COEFF7_tt13_enf2_enum;
            reset = 0x0;
        } tt13_enf2[6:6];

        enum DATE_COEFF7_tt12_enf2_enum {
            DISABLED = 0 { name = "Disabled"; desc = "disabled"; };
            ENABLED = 1 { name = "Enabled"; desc = "enabled"; };
        };

        field {
            name = "tt12_enf2";
            desc = "Control of teletext in line 12 in the even field.";
            sw = rw;
            hw = r;
            encode = DATE_COEFF7_tt12_enf2_enum;
            reset = 0x0;
        } tt12_enf2[5:5];

        enum DATE_COEFF7_tt11_enf2_enum {
            DISABLED = 0 { name = "Disabled"; desc = "disabled"; };
            ENABLED = 1 { name = "Enabled"; desc = "enabled"; };
        };

        field {
            name = "tt11_enf2";
            desc = "Control of teletext in line 11 in the even field.";
            sw = rw;
            hw = r;
            encode = DATE_COEFF7_tt11_enf2_enum;
            reset = 0x0;
        } tt11_enf2[4:4];

        enum DATE_COEFF7_tt10_enf2_enum {
            DISABLED = 0 { name = "Disabled"; desc = "disabled"; };
            ENABLED = 1 { name = "Enabled"; desc = "enabled"; };
        };

        field {
            name = "tt10_enf2";
            desc = "Control of teletext in line 10 in the even field.";
            sw = rw;
            hw = r;
            encode = DATE_COEFF7_tt10_enf2_enum;
            reset = 0x0;
        } tt10_enf2[3:3];

        enum DATE_COEFF7_tt09_enf2_enum {
            DISABLED = 0 { name = "Disabled"; desc = "disabled"; };
            ENABLED = 1 { name = "Enabled"; desc = "enabled"; };
        };

        field {
            name = "tt09_enf2";
            desc = "Control of teletext in line 9 in the even field.";
            sw = rw;
            hw = r;
            encode = DATE_COEFF7_tt09_enf2_enum;
            reset = 0x0;
        } tt09_enf2[2:2];

        enum DATE_COEFF7_tt08_enf2_enum {
            DISABLED = 0 { name = "Disabled"; desc = "disabled"; };
            ENABLED = 1 { name = "Enabled"; desc = "enabled"; };
        };

        field {
            name = "tt08_enf2";
            desc = "Control of teletext in line 8 in the even field.";
            sw = rw;
            hw = r;
            encode = DATE_COEFF7_tt08_enf2_enum;
            reset = 0x0;
        } tt08_enf2[1:1];

        enum DATE_COEFF7_tt07_enf2_enum {
            DISABLED = 0 { name = "Disabled"; desc = "disabled"; };
            ENABLED = 1 { name = "Enabled"; desc = "enabled"; };
        };

        field {
            name = "tt07_enf2";
            desc = "Control of teletext in line 7 in the even field.";
            sw = rw;
            hw = r;
            encode = DATE_COEFF7_tt07_enf2_enum;
            reset = 0x0;
        } tt07_enf2[0:0];
    } DATE_COEFF7 @ 0xC21C;

    reg {
        name = "DATE teletext configuration register";
        desc = "DATE_COEFF8 is a DATE teletext configuration register.

Data sheet 10.2.5 DATE_COEFF8 (offset 0xC220, printed page 10-137, `hi3516cv100--Hi3516C-Datasheet.txt` line 44101).";

        field {
            name = "tt_staddr";
            desc = "Start address of the teletext data.";
            sw = rw;
            hw = r;
            reset = 0x0;
        } tt_staddr[31:0];
    } DATE_COEFF8 @ 0xC220;

    reg {
        name = "DATE teletext configuration register";
        desc = "DATE_COEFF9 is a DATE teletext configuration register.

Data sheet 10.2.5 DATE_COEFF9 (offset 0xC224, printed page 10-137, `hi3516cv100--Hi3516C-Datasheet.txt` line 44120).";

        field {
            name = "tt_edaddr";
            desc = "End address of the teletext data.";
            sw = rw;
            hw = r;
            reset = 0x0;
        } tt_edaddr[31:0];
    } DATE_COEFF9 @ 0xC224;

    reg {
        name = "DATE_COEFF10";
        desc = "DATE_COEFF10.

Data sheet 10.2.5 DATE_COEFF10 (offset 0xC228, printed page 10-138, `hi3516cv100--Hi3516C-Datasheet.txt` line 44151).";

        field {
            name = "tt_ready";
            desc = "When software sets related parameters through the bus, this bit is set to 1 and the teletext module starts to work. When the teletext module completes data transfer, this bit is set to 0. The bit status can be queried through software for the next configuration.";
            sw = rw;
            hw = r;
            reset = 0x0;
        } tt_ready[31:31];

        enum DATE_COEFF10_nabts_100ire_enum {
            V_70_IRE = 0 { name = "V 70 Ire"; desc = "70 IRE"; };
            V_100_IRE = 1 { name = "V 100 Ire"; desc = "100 IRE"; };
        };

        field {
            name = "nabts_100ire";
            desc = "NABTS-NTSC data height.";
            sw = rw;
            hw = r;
            encode = DATE_COEFF10_nabts_100ire_enum;
            reset = 0x0;
        } nabts_100ire[12:12];

        enum DATE_COEFF10_full_page_enum {
            NORMAL_MODE_TELETEXT = 0 { name = "Normal Mode Teletext"; desc = "normal mode. The teletext data is transmitted from the blanking line."; };
            FULL_PAGE_MODE = 1 { name = "Full Page Mode"; desc = "full page mode. The teletext data can also be transmitted from the active video region."; };
        };

        field {
            name = "full_page";
            desc = "Teletext data transmission mode.";
            sw = rw;
            hw = r;
            encode = DATE_COEFF10_full_page_enum;
            reset = 0x0;
        } full_page[11:11];

        enum DATE_COEFF10_tt_highest_enum {
            TELETEXT_DATA_HAS = 0 { name = "Teletext Data Has"; desc = "The teletext data has the highest priority."; };
            TELETEXT_DATA_HAS_2 = 1 { name = "Teletext Data Has 2"; desc = "The teletext data has the lowest priority. Teletext mode. This field is set to 01 in 625-line mode, indicating WST-PAL. This field is set to 10 in 525-line mode, indicating NABTS-NTSC."; };
        };

        field {
            name = "tt_highest";
            desc = "Teletext priority control.";
            sw = rw;
            hw = r;
            encode = DATE_COEFF10_tt_highest_enum;
            reset = 0x0;
        } tt_highest[10:10];

        field {
            name = "tt_mode";
            desc = "tt_mode";
            sw = rw;
            hw = r;
            reset = 0x0;
        } tt_mode[9:8];

        field {
            name = "tt_pktoff";
            desc = "tt_pktoff";
            sw = rw;
            hw = r;
            reset = 0x0;
        } tt_pktoff[7:0];
    } DATE_COEFF10 @ 0xC228;

    reg {
        name = "DATE closed caption configuration register";
        desc = "DATE_COEFF11 is a DATE closed caption configuration register.

Data sheet 10.2.5 DATE_COEFF11 (offset 0xC22C, printed page 10-139, `hi3516cv100--Hi3516C-Datasheet.txt` line 44205).";

        enum DATE_COEFF11_cc_enf1_enum {
            DISABLED = 0 { name = "Disabled"; desc = "disabled"; };
            ENABLED = 1 { name = "Enabled"; desc = "enabled"; };
        };

        field {
            name = "cc_enf1";
            desc = "Closed caption odd field enable.";
            sw = rw;
            hw = r;
            encode = DATE_COEFF11_cc_enf1_enum;
            reset = 0x0;
        } cc_enf1[21:21];

        enum DATE_COEFF11_cc_enf2_enum {
            DISABLED = 0 { name = "Disabled"; desc = "disabled"; };
            ENABLED = 1 { name = "Enabled"; desc = "enabled"; };
        };

        field {
            name = "cc_enf2";
            desc = "Closed caption even field enable.";
            sw = rw;
            hw = r;
            encode = DATE_COEFF11_cc_enf2_enum;
            reset = 0x0;
        } cc_enf2[20:20];

        field {
            name = "date_clf1";
            desc = "Configuration line of the closed caption odd field.";
            sw = rw;
            hw = r;
            reset = 0x0;
        } date_clf1[19:10];

        field {
            name = "date_clf2";
            desc = "Configuration line of the closed caption even field.";
            sw = rw;
            hw = r;
            reset = 0x0;
        } date_clf2[9:0];
    } DATE_COEFF11 @ 0xC22C;

    reg {
        name = "DATE closed caption configuration register";
        desc = "DATE_COEFF12 is a DATE closed caption configuration register.

Data sheet 10.2.5 DATE_COEFF12 (offset 0xC230, printed page 10-139, `hi3516cv100--Hi3516C-Datasheet.txt` line 44236).";

        field {
            name = "cc_f1data";
            desc = "Data of the closed caption odd field.";
            sw = rw;
            hw = r;
            reset = 0x0;
        } cc_f1data[31:16];

        field {
            name = "cc_f2data";
            desc = "Data of the closed caption even field.";
            sw = rw;
            hw = r;
            reset = 0x0;
        } cc_f2data[15:0];
    } DATE_COEFF12 @ 0xC230;

    reg {
        name = "DATE CGMS configuration register";
        desc = "DATE_COEFF13 is a DATE CGMS configuration register.

Data sheet 10.2.5 DATE_COEFF13 (offset 0xC234, printed page 10-140, `hi3516cv100--Hi3516C-Datasheet.txt` line 44262).";

        enum DATE_COEFF13_cg_enf1_enum {
            DISABLED = 0 { name = "Disabled"; desc = "disabled"; };
            ENABLED = 1 { name = "Enabled"; desc = "enabled"; };
        };

        field {
            name = "cg_enf1";
            desc = "CGMS odd field enable.";
            sw = rw;
            hw = r;
            encode = DATE_COEFF13_cg_enf1_enum;
            reset = 0x0;
        } cg_enf1[21:21];

        enum DATE_COEFF13_cg_enf2_enum {
            DISABLED = 0 { name = "Disabled"; desc = "disabled"; };
            ENABLED = 1 { name = "Enabled"; desc = "enabled"; };
        };

        field {
            name = "cg_enf2";
            desc = "CGMS even field enable.";
            sw = rw;
            hw = r;
            encode = DATE_COEFF13_cg_enf2_enum;
            reset = 0x0;
        } cg_enf2[20:20];

        field {
            name = "cg_f1data";
            desc = "Data of the CGMS odd field.";
            sw = rw;
            hw = r;
            reset = 0x0;
        } cg_f1data[19:0];
    } DATE_COEFF13 @ 0xC234;

    reg {
        name = "DATE CGMS configuration register";
        desc = "DATE_COEFF14 is a DATE CGMS configuration register.

Data sheet 10.2.5 DATE_COEFF14 (offset 0xC238, printed page 10-140, `hi3516cv100--Hi3516C-Datasheet.txt` line 44294).";

        field {
            name = "cg_f2data";
            desc = "Data of the CGMS even field.";
            sw = rw;
            hw = r;
            reset = 0x0;
        } cg_f2data[19:0];
    } DATE_COEFF14 @ 0xC238;

    reg {
        name = "DATE WSS configuration register";
        desc = "DATE_COEFF15 is a DATE WSS configuration register. The WSS is available only in 625-line mode and is fixed at line 23.

Data sheet 10.2.5 DATE_COEFF15 (offset 0xC23C, printed page 10-141, `hi3516cv100--Hi3516C-Datasheet.txt` line 44327).";

        enum DATE_COEFF15_wss_en_enum {
            DISABLED = 0 { name = "Disabled"; desc = "disabled"; };
            ENABLED = 1 { name = "Enabled"; desc = "enabled"; };
        };

        field {
            name = "wss_en";
            desc = "WSS enable.";
            sw = rw;
            hw = r;
            encode = DATE_COEFF15_wss_en_enum;
            reset = 0x0;
        } wss_en[14:14];

        field {
            name = "wss_data";
            desc = "WSS data.";
            sw = rw;
            hw = r;
            reset = 0x0;
        } wss_data[13:0];
    } DATE_COEFF15 @ 0xC23C;

    reg {
        name = "DATE VPS configuration register";
        desc = "DATE_COEFF16 is a DATE VPS configuration register.

Data sheet 10.2.5 DATE_COEFF16 (offset 0xC240, printed page 10-141, `hi3516cv100--Hi3516C-Datasheet.txt` line 44353).";

        enum DATE_COEFF16_vps_en_enum {
            DISABLED = 0 { name = "Disabled"; desc = "disabled"; };
            ENABLED = 1 { name = "Enabled"; desc = "enabled"; };
        };

        field {
            name = "vps_en";
            desc = "VPS enable.";
            sw = rw;
            hw = r;
            encode = DATE_COEFF16_vps_en_enum;
            reset = 0x0;
        } vps_en[24:24];

        field {
            name = "vps_data";
            desc = "VPS data from bit 23 to bit 0. Bit 0 is the LSB.";
            sw = rw;
            hw = r;
            reset = 0x0;
        } vps_data[23:0];
    } DATE_COEFF16 @ 0xC240;

    reg {
        name = "DATE VPS configuration register";
        desc = "DATE_COEFF17 is a DATE VPS configuration register.

Data sheet 10.2.5 DATE_COEFF17 (offset 0xC244, printed page 10-142, `hi3516cv100--Hi3516C-Datasheet.txt` line 44390).";

        field {
            name = "vps_data";
            desc = "VPS data from bit 55 to bit 24. Bit 0 is the LSB.";
            sw = rw;
            hw = r;
            reset = 0x0;
        } vps_data[31:0];
    } DATE_COEFF17 @ 0xC244;

    reg {
        name = "DATE VPS configuration register";
        desc = "DATE_COEFF18 is a DATE VPS configuration register.

Data sheet 10.2.5 DATE_COEFF18 (offset 0xC248, printed page 10-142, `hi3516cv100--Hi3516C-Datasheet.txt` line 44408).";

        field {
            name = "vps_data";
            desc = "VPS data from bit 87 to bit 56. Bit 0 is the LSB.";
            sw = rw;
            hw = r;
            reset = 0x0;
        } vps_data[31:0];
    } DATE_COEFF18 @ 0xC248;

    reg {
        name = "DATE_COEFF19";
        desc = "DATE_COEFF19.

Data sheet 10.2.5 DATE_COEFF19 (offset 0xC24C, printed page 10-143, `hi3516cv100--Hi3516C-Datasheet.txt` line 44439).";

        field {
            name = "vps_data";
            desc = "VPS data from bit 103 to bit 88. Bit 0 is the LSB.";
            sw = rw;
            hw = r;
            reset = 0x0;
        } vps_data[15:0];
    } DATE_COEFF19 @ 0xC24C;

    reg {
        name = "DATE teletext configuration register";
        desc = "DATE_COEFF20 is a DATE teletext configuration register.

Data sheet 10.2.5 DATE_COEFF20 (offset 0xC250, printed page 10-143, `hi3516cv100--Hi3516C-Datasheet.txt` line 44461).";

        enum DATE_COEFF20_tt06_enf1_enum {
            DISABLED = 0 { name = "Disabled"; desc = "disabled"; };
            ENABLED = 1 { name = "Enabled"; desc = "enabled"; };
        };

        field {
            name = "tt06_enf1";
            desc = "Control of teletext in line 6 in the odd field.";
            sw = rw;
            hw = r;
            encode = DATE_COEFF20_tt06_enf1_enum;
            reset = 0x0;
        } tt06_enf1[2:2];

        enum DATE_COEFF20_tt06_enf2_enum {
            DISABLED = 0 { name = "Disabled"; desc = "disabled"; };
            ENABLED = 1 { name = "Enabled"; desc = "enabled"; };
        };

        field {
            name = "tt06_enf2";
            desc = "Control of teletext in line 6 in the even field.";
            sw = rw;
            hw = r;
            encode = DATE_COEFF20_tt06_enf2_enum;
            reset = 0x0;
        } tt06_enf2[1:1];

        enum DATE_COEFF20_tt05_enf2_enum {
            DISABLED = 0 { name = "Disabled"; desc = "disabled"; };
            ENABLED = 1 { name = "Enabled"; desc = "enabled"; };
        };

        field {
            name = "tt05_enf2";
            desc = "Control of teletext in line 5 in the even field.";
            sw = rw;
            hw = r;
            encode = DATE_COEFF20_tt05_enf2_enum;
            reset = 0x0;
        } tt05_enf2[0:0];
    } DATE_COEFF20 @ 0xC250;

    reg {
        name = "DATE DTO initial phase configuration register";
        desc = "DATE_COEFF22 is the DATE DTO initial phase configuration register.

Data sheet 10.2.5 DATE_COEFF22 (offset 0xC258, printed page 10-144, `hi3516cv100--Hi3516C-Datasheet.txt` line 44502).";

        field {
            name = "video_phase_delta";
            desc = "DTO initial phase.";
            sw = rw;
            hw = r;
            reset = 0x0;
        } video_phase_delta[10:0];
    } DATE_COEFF22 @ 0xC258;

    reg {
        name = "DATE interrupt mask register";
        desc = "DATE_ISRMASK is the DATE interrupt mask register.

Data sheet 10.2.5 DATE_ISRMASK (offset 0xC280, printed page 10-144, `hi3516cv100--Hi3516C-Datasheet.txt` line 44524).";

        enum DATE_ISRMASK_tt_mask_enum {
            ENABLED = 0 { name = "Enabled"; desc = "enabled"; };
            MASKED = 1 { name = "Masked"; desc = "masked"; };
        };

        field {
            name = "tt_mask";
            desc = "Teletext interrupt mask.";
            sw = rw;
            hw = r;
            encode = DATE_ISRMASK_tt_mask_enum;
            reset = 0x0;
        } tt_mask[0:0];
    } DATE_ISRMASK @ 0xC280;

    reg {
        name = "DATE interrupt status register";
        desc = "DATE_ISRSTATE is the DATE interrupt status register.

Data sheet 10.2.5 DATE_ISRSTATE (offset 0xC284, printed page 10-145, `hi3516cv100--Hi3516C-Datasheet.txt` line 44562).";

        field {
            name = "tt_status";
            desc = "Teletext interrupt flag. After the DATE module reads all the teletext data, the bit is set to 1. Writing 1 to this bit clears this bit.";
            sw = rw;
            hw = w;
            onwrite = woclr;
            reset = 0x0;
        } tt_status[0:0];
    } DATE_ISRSTATE @ 0xC284;

    reg {
        name = "DATE interrupt register";
        desc = "DATE_ISR is the DATE interrupt register.

Data sheet 10.2.5 DATE_ISR (offset 0xC288, printed page 10-145, `hi3516cv100--Hi3516C-Datasheet.txt` line 44591).";

        enum DATE_ISR_tt_int_enum {
            NO_INTERRUPT_GENERATED = 0 { name = "No Interrupt Generated"; desc = "No interrupt is generated."; };
            INTERRUPT_GENERATED = 1 { name = "Interrupt Generated"; desc = "An interrupt is generated."; };
        };

        field {
            name = "tt_int";
            desc = "Teletext interrupt. It is the interrupt status after tt_status is masked by tt_mask.";
            sw = rw;
            hw = r;
            encode = DATE_ISR_tt_int_enum;
            reset = 0x0;
        } tt_int[0:0];
    } DATE_ISR @ 0xC288;

    reg {
        name = "DATE version register";
        desc = "DATE_VERSION is the DATE version register. The data sheet lists no bit fields for it.

Data sheet 10.2.5 DATE_VERSION (offset 0xC290, printed page 10-146, `hi3516cv100--Hi3516C-Datasheet.txt` line 44628).";

        field {
            name = "value";
            desc = "Register value (the data sheet gives no bit table for this register).";
            sw = rw;
            hw = r;
            reset = 0x24;
        } value[31:0];
    } DATE_VERSION @ 0xC290;

    reg {
        name = "DATE1 norm parameter configuration register";
        desc = "DATE1_COEFF0 is the DATE1 norm parameter configuration register.

Data sheet 10.2.5 DATE1_COEFF0 (offset 0xC400, printed page 10-146, `hi3516cv100--Hi3516C-Datasheet.txt` line 44649).";

        enum DATE1_COEFF0_clpf_sel_enum {
            V_1_1_MHZ = 0 { name = "V 1 1 Mhz"; desc = "1.1 MHz (NTSC)"; };
            V_1_3_MHZ = 1 { name = "V 1 3 Mhz"; desc = "1.3 MHz (PAL)"; };
            V_1_6_MHZ = 2 { name = "V 1 6 Mhz"; desc = "1.6 MHz (for test)"; };
            RESERVED = 3 { name = "Reserved"; desc = "reserved"; };
        };

        field {
            name = "clpf_sel";
            desc = "Bandwidth select of the chrominance low-pass filter.";
            sw = rw;
            hw = r;
            encode = DATE1_COEFF0_clpf_sel_enum;
            reset = 0x1;
        } clpf_sel[31:30];

        enum DATE1_COEFF0_dis_ire_enum {
            BLACK_LEVEL_7 = 0 { name = "Black Level 7"; desc = "The black level is 7.5 IRE higher than the blanking level."; };
            BLACK_LEVEL_EQUAL = 1 { name = "Black Level Equal"; desc = "The black level is equal to the blanking level."; };
        };

        field {
            name = "dis_ire";
            desc = "For the (M) NTSC and (M, N) PAL norms, the black level is 7.5 IRE higher than the blanking level; for other norms, the black level is equal to the blanking level. This bit controls whether the black level is 7.5 IRE higher than the blanking level.";
            sw = rw;
            hw = r;
            encode = DATE1_COEFF0_dis_ire_enum;
            reset = 0x0;
        } dis_ire[29:29];

        enum DATE1_COEFF0_scanline_enum {
            V_525_LINES_FRAME = 0 { name = "V 525 Lines Frame"; desc = "525 lines in a frame"; };
            V_625_LINES_FRAME = 1 { name = "V 625 Lines Frame"; desc = "625 lines in a frame"; };
        };

        field {
            name = "scanline";
            desc = "Number of scanned lines in each frame based on norms. For the (M) NTSC, NTSC-J, and (M) PAL norm, each line contains 525 lines; for the (B, D, J, H, I) PAL, (N) PAL, and (Nc) PAL norms, each frame contains 625 lines.";
            sw = rw;
            hw = r;
            encode = DATE1_COEFF0_scanline_enum;
            reset = 0x1;
        } scanline[25:25];

        enum DATE1_COEFF0_rgb_en_enum {
            YPBPR = 0 { name = "Ypbpr"; desc = "YPbPr"; };
            RGB = 1 { name = "Rgb"; desc = "RGB"; };
        };

        field {
            name = "rgb_en";
            desc = "When intf_sel is set to 100, this bit determines whether the component signal is RGB or YPbPr.";
            sw = rw;
            hw = r;
            encode = DATE1_COEFF0_rgb_en_enum;
            reset = 0x0;
        } rgb_en[24:24];

        enum DATE1_COEFF0_vbi_lpf_en_enum {
            DISABLED = 0 { name = "Disabled"; desc = "disabled"; };
            ENABLED = 1 { name = "Enabled"; desc = "enabled"; };
        };

        field {
            name = "vbi_lpf_en";
            desc = "VBI data low-pass filtering enable.";
            sw = rw;
            hw = r;
            encode = DATE1_COEFF0_vbi_lpf_en_enum;
            reset = 0x1;
        } vbi_lpf_en[23:23];

        enum DATE1_COEFF0_fm_sel_enum {
            SIN_USED_SECAM = 0 { name = "Sin Used Secam"; desc = "sin used for SECAM frequency modulation"; };
            COS_USED_SECAM = 1 { name = "Cos Used Secam"; desc = "cos used for SECAM frequency modulation"; };
        };

        field {
            name = "fm_sel";
            desc = "FMSECAM frequency modulation select.";
            sw = rw;
            hw = r;
            encode = DATE1_COEFF0_fm_sel_enum;
            reset = 0x0;
        } fm_sel[22:22];

        field {
            name = "style_sel";
            desc = "CVBS/S-Video output signal norm when this bit works with the scanline bit. When the scanline bit is 0 (525 scanned lines in a frame), the definition of the style_sel bit is as follows: 0x1: (M) NTSC 0x2: NTSC-J 0x4: (M) PAL Other values: reserved When the scanline bit is 1 (625 scanned lines in a frame), the definition of the style_sel bit is as follows: 0x1: (B, D, G, H, I) PAL 0x2: (N) PAL 0x4: (Nc) PAL 0x8: SECAM Other values: reserved";
            sw = rw;
            hw = r;
            reset = 0x1;
        } style_sel[21:18];

        field {
            name = "sync_mode_sel";
            desc = "bit[17]: specifies whether there are sync signals in three channels during component output. This bit takes effect only when the sync_mode_scart bit is set to 0. bit[17] is valid only when the intf_sel is set to 100 (component output enabled). The definition of bit[17] is as follows: 0: Only one channel contains sync signals using component output. 1: Three channels contain sync signals during component output. When bit[17] is set to 0, the sync channel must be the Y channel for YPbPr output and G channel for RGB output. bit[16]: specifies whether there are blanking radixes during RGB output. bit[16] is valid only when the intf_sel is set to 100 and the rgb_en bit is set to 1. The definition of bit[16] is as follows: 0: There are no blanking radixes during RGB output. 1: There are blanking radixes during RGB output.";
            sw = rw;
            hw = r;
            reset = 0x0;
        } sync_mode_sel[17:16];

        enum DATE1_COEFF0_sync_mode_scart_enum {
            COMPONENT_SYNC_OUTPUT = 0 { name = "Component Sync Output"; desc = "Component sync output is configured based on sync_mode_sel[1]."; };
            COMPONENTS_THREE_CHANNELS = 1 { name = "Components Three Channels"; desc = "The components of the three channels are not overlaid and synchronized. In this case, sync_mode_sel bit[1] must be set to 0."; };
        };

        field {
            name = "sync_mode_scart";
            desc = "Overlay sync control of the components of three channels.";
            sw = rw;
            hw = r;
            encode = DATE1_COEFF0_sync_mode_scart_enum;
            reset = 0x0;
        } sync_mode_scart[15:15];

        enum DATE1_COEFF0_length_sel_enum {
            OUTPUT_ACCORDING_ACTIVE = 0 { name = "Output According Active"; desc = "output according to the active line width in BT.601 mode"; };
            OUTPUT_ACCORDING_ACTIVE_2 = 1 { name = "Output According Active 2"; desc = "output according to the active line width in BT.470 mode. When this bit is set to 0, the active width of the line is 720 pixels. When this bit is set to 1, the active width of the line is 704 pixels for the 625-line norm or 712 pixels for the 525-line norm. Currently, the BT.601 mode and BT.470 mode cannot be changed dynamically. You can change the mode only after reset. The BT.601 mode is recommended and this mode is the default value after power-on reset."; };
        };

        field {
            name = "length_sel";
            desc = "Active width of each video line (in pixel).";
            sw = rw;
            hw = r;
            encode = DATE1_COEFF0_length_sel_enum;
            reset = 0x0;
        } length_sel[14:14];

        enum DATE1_COEFF0_agc_amp_sel_enum {
            AGC_PULSE_GENERATED = 0 { name = "Agc Pulse Generated"; desc = "The AGC pulse is generated based on the on-chip default value (recommended)."; };
            AGC_PULSE_GENERATED_2 = 1 { name = "Agc Pulse Generated 2"; desc = "The AGC pulse is generated based on DATE_COEFF1[amp_outside]."; };
        };

        field {
            name = "agc_amp_sel";
            desc = "AGC pulse select.";
            sw = rw;
            hw = r;
            encode = DATE1_COEFF0_agc_amp_sel_enum;
            reset = 0x0;
        } agc_amp_sel[13:13];

        field {
            name = "luma_dl";
            desc = "Forward or backward offset of the chrominance signal relative to the luminance signal, in the unit of half a pixel width. bit[12]: offset direction of the chrominance signal relative to the luminance signal. 0: backward offset 1: forward offset bit[11:9]: absolute offset of the chrominance signal relative to the luminance signal. The value is in binary format and ranges from 0 to 7. 000: The chrominance signal is aligned with the luminance signal. No adjustment is required. 001-111: The chrominance signal offsets from the luminance signal forward or backward by one to seven units.";
            sw = rw;
            hw = r;
            reset = 0xA;
        } luma_dl[12:9];

        field {
            name = "oversam_en";
            desc = "Level-1 oversampling enable. Both the luminance oversampling and chrominance oversampling are controlled. bit[7]: luminance oversampling enable. 0: disabled 1: enabled bit[6]: chrominance oversampling enable. 0: disabled 1: enabled";
            sw = rw;
            hw = r;
            reset = 0x3;
        } oversam_en[7:6];

        enum DATE1_COEFF0_lunt_en_enum {
            DISABLED = 0 { name = "Disabled"; desc = "disabled"; };
            ENABLED = 1 { name = "Enabled"; desc = "enabled"; };
        };

        field {
            name = "lunt_en";
            desc = "Luminance notch enable.";
            sw = rw;
            hw = r;
            encode = DATE1_COEFF0_lunt_en_enum;
            reset = 0x1;
        } lunt_en[5:5];

        enum DATE1_COEFF0_oversam2_en_enum {
            DISABLED = 0 { name = "Disabled"; desc = "disabled"; };
            ENABLED = 1 { name = "Enabled"; desc = "enabled"; };
        };

        field {
            name = "oversam2_en";
            desc = "Level-2 oversampling enable. Both the luminance channel and chrominance channel are controlled.";
            sw = rw;
            hw = r;
            encode = DATE1_COEFF0_oversam2_en_enum;
            reset = 0x1;
        } oversam2_en[4:4];

        enum DATE1_COEFF0_chlp_en_enum {
            DISABLED = 0 { name = "Disabled"; desc = "disabled"; };
            ENABLED = 1 { name = "Enabled"; desc = "enabled"; };
        };

        field {
            name = "chlp_en";
            desc = "Chrominance low-pass filtering enable.";
            sw = rw;
            hw = r;
            encode = DATE1_COEFF0_chlp_en_enum;
            reset = 0x1;
        } chlp_en[3:3];

        enum DATE1_COEFF0_sylp_en_enum {
            DISABLED = 0 { name = "Disabled"; desc = "disabled"; };
            ENABLED = 1 { name = "Enabled"; desc = "enabled"; };
        };

        field {
            name = "sylp_en";
            desc = "Sync low-pass filtering enable.";
            sw = rw;
            hw = r;
            encode = DATE1_COEFF0_sylp_en_enum;
            reset = 0x1;
        } sylp_en[2:2];

        enum DATE1_COEFF0_chgain_en_enum {
            DISABLED = 0 { name = "Disabled"; desc = "disabled"; };
            ENABLED = 1 { name = "Enabled"; desc = "enabled"; };
        };

        field {
            name = "chgain_en";
            desc = "Chrominance gain enable.";
            sw = rw;
            hw = r;
            encode = DATE1_COEFF0_chgain_en_enum;
            reset = 0x0;
        } chgain_en[1:1];

        field {
            name = "tt_seq";
            desc = "tt_seq";
            sw = rw;
            hw = r;
            reset = 0x0;
        } tt_seq[0:0];
    } DATE1_COEFF0 @ 0xC400;

    reg {
        name = "DATE1 amplitude configuration register";
        desc = "DATE1_COEFF1 is the DATE1 amplitude configuration register.

Data sheet 10.2.5 DATE1_COEFF1 (offset 0xC404, printed page 10-150, `hi3516cv100--Hi3516C-Datasheet.txt` line 44843).";

        field {
            name = "c_gain";
            desc = "Adjustment of the chrominance sync gain amplitude.";
            sw = rw;
            hw = r;
            reset = 0x0;
        } c_gain[31:29];

        enum DATE1_COEFF1_cvbs_limit_en_enum {
            DISABLED = 0 { name = "Disabled"; desc = "disabled"; };
            ENABLED = 1 { name = "Enabled"; desc = "enabled"; };
        };

        field {
            name = "cvbs_limit_en";
            desc = "CVBS amplitude limit enable.";
            sw = rw;
            hw = r;
            encode = DATE1_COEFF1_cvbs_limit_en_enum;
            reset = 0x0;
        } cvbs_limit_en[28:28];

        enum DATE1_COEFF1_wss_seq_enum {
            FROM_UPPER_BITS = 0 { name = "From Upper Bits"; desc = "from upper bits to lower bits"; };
            FROM_LOWER_BITS = 1 { name = "From Lower Bits"; desc = "from lower bits to upper bits"; };
        };

        field {
            name = "wss_seq";
            desc = "Sequence of transmitting the bits of the WSS data.";
            sw = rw;
            hw = r;
            encode = DATE1_COEFF1_wss_seq_enum;
            reset = 0x0;
        } wss_seq[27:27];

        enum DATE1_COEFF1_vps_seq_enum {
            FROM_UPPER_BITS = 0 { name = "From Upper Bits"; desc = "from upper bits to lower bits"; };
            FROM_LOWER_BITS = 1 { name = "From Lower Bits"; desc = "from lower bits to upper bits"; };
        };

        field {
            name = "vps_seq";
            desc = "Sequence of transmitting the bits of the VPS data.";
            sw = rw;
            hw = r;
            encode = DATE1_COEFF1_vps_seq_enum;
            reset = 0x0;
        } vps_seq[26:26];

        enum DATE1_COEFF1_cgms_seq_enum {
            FROM_UPPER_BITS = 0 { name = "From Upper Bits"; desc = "from upper bits to lower bits"; };
            FROM_LOWER_BITS = 1 { name = "From Lower Bits"; desc = "from lower bits to upper bits"; };
        };

        field {
            name = "cgms_seq";
            desc = "Sequence of transmitting the bits of the CGMS data.";
            sw = rw;
            hw = r;
            encode = DATE1_COEFF1_cgms_seq_enum;
            reset = 0x0;
        } cgms_seq[25:25];

        enum DATE1_COEFF1_cc_seq_enum {
            FROM_UPPER_BITS = 0 { name = "From Upper Bits"; desc = "from upper bits to lower bits"; };
            FROM_LOWER_BITS = 1 { name = "From Lower Bits"; desc = "from lower bits to upper bits"; };
        };

        field {
            name = "cc_seq";
            desc = "Sequence of transmitting the bits of the closed caption data.";
            sw = rw;
            hw = r;
            encode = DATE1_COEFF1_cc_seq_enum;
            reset = 0x0;
        } cc_seq[24:24];

        enum DATE1_COEFF1_c_limit_en_enum {
            DISABLED = 0 { name = "Disabled"; desc = "disabled"; };
            ENABLED = 1 { name = "Enabled"; desc = "enabled"; };
        };

        field {
            name = "c_limit_en";
            desc = "Chrominance amplitude limit enable.";
            sw = rw;
            hw = r;
            encode = DATE1_COEFF1_c_limit_en_enum;
            reset = 0x0;
        } c_limit_en[23:23];

        field {
            name = "amp_outside";
            desc = "Pulse amplitude input of the external AGC.";
            sw = rw;
            hw = r;
            reset = 0x0;
        } amp_outside[22:13];

        enum DATE1_COEFF1_date_test_en_enum {
            INVALID = 0 { name = "Invalid"; desc = "invalid"; };
            VALID = 1 { name = "Valid"; desc = "valid"; };
        };

        field {
            name = "date_test_en";
            desc = "Test valid signal.";
            sw = rw;
            hw = r;
            encode = DATE1_COEFF1_date_test_en_enum;
            reset = 0x0;
        } date_test_en[12:12];

        field {
            name = "date_test_mode";
            desc = "Test mode signal.";
            sw = rw;
            hw = r;
            reset = 0x0;
        } date_test_mode[11:10];

        field {
            name = "dac_test";
            desc = "DAC test value input.";
            sw = rw;
            hw = r;
            reset = 0x0;
        } dac_test[9:0];
    } DATE1_COEFF1 @ 0xC404;

    reg {
        name = "DATE1 teletext configuration register";
        desc = "DATE1_COEFF7 is a DATE1 teletext configuration register.

Data sheet 10.2.5 DATE1_COEFF7 (offset 0xC41C, printed page 10-151, `hi3516cv100--Hi3516C-Datasheet.txt` line 44904).";

        enum DATE1_COEFF7_tt22_enf1_enum {
            DISABLED = 0 { name = "Disabled"; desc = "disabled"; };
            ENABLED = 1 { name = "Enabled"; desc = "enabled"; };
        };

        field {
            name = "tt22_enf1";
            desc = "Control of teletext in line 22 in the odd field.";
            sw = rw;
            hw = r;
            encode = DATE1_COEFF7_tt22_enf1_enum;
            reset = 0x0;
        } tt22_enf1[31:31];

        enum DATE1_COEFF7_tt21_enf1_enum {
            DISABLED = 0 { name = "Disabled"; desc = "disabled"; };
            ENABLED = 1 { name = "Enabled"; desc = "enabled"; };
        };

        field {
            name = "tt21_enf1";
            desc = "Control of teletext in line 21 in the odd field.";
            sw = rw;
            hw = r;
            encode = DATE1_COEFF7_tt21_enf1_enum;
            reset = 0x0;
        } tt21_enf1[30:30];

        enum DATE1_COEFF7_tt20_enf1_enum {
            DISABLED = 0 { name = "Disabled"; desc = "disabled"; };
            ENABLED = 1 { name = "Enabled"; desc = "enabled"; };
        };

        field {
            name = "tt20_enf1";
            desc = "Control of teletext in line 20 in the odd field.";
            sw = rw;
            hw = r;
            encode = DATE1_COEFF7_tt20_enf1_enum;
            reset = 0x0;
        } tt20_enf1[29:29];

        enum DATE1_COEFF7_tt19_enf1_enum {
            DISABLED = 0 { name = "Disabled"; desc = "disabled"; };
            ENABLED = 1 { name = "Enabled"; desc = "enabled"; };
        };

        field {
            name = "tt19_enf1";
            desc = "Control of teletext in line 19 in the odd field.";
            sw = rw;
            hw = r;
            encode = DATE1_COEFF7_tt19_enf1_enum;
            reset = 0x0;
        } tt19_enf1[28:28];

        enum DATE1_COEFF7_tt18_enf1_enum {
            DISABLED = 0 { name = "Disabled"; desc = "disabled"; };
            ENABLED = 1 { name = "Enabled"; desc = "enabled"; };
        };

        field {
            name = "tt18_enf1";
            desc = "Control of teletext in line 18 in the odd field.";
            sw = rw;
            hw = r;
            encode = DATE1_COEFF7_tt18_enf1_enum;
            reset = 0x0;
        } tt18_enf1[27:27];

        enum DATE1_COEFF7_tt17_enf1_enum {
            DISABLED = 0 { name = "Disabled"; desc = "disabled"; };
            ENABLED = 1 { name = "Enabled"; desc = "enabled"; };
        };

        field {
            name = "tt17_enf1";
            desc = "Control of teletext in line 17 in the odd field.";
            sw = rw;
            hw = r;
            encode = DATE1_COEFF7_tt17_enf1_enum;
            reset = 0x0;
        } tt17_enf1[26:26];

        enum DATE1_COEFF7_tt16_enf1_enum {
            DISABLED = 0 { name = "Disabled"; desc = "disabled"; };
            ENABLED = 1 { name = "Enabled"; desc = "enabled"; };
        };

        field {
            name = "tt16_enf1";
            desc = "Control of teletext in line 16 in the odd field.";
            sw = rw;
            hw = r;
            encode = DATE1_COEFF7_tt16_enf1_enum;
            reset = 0x0;
        } tt16_enf1[25:25];

        enum DATE1_COEFF7_tt15_enf1_enum {
            DISABLED = 0 { name = "Disabled"; desc = "disabled"; };
            ENABLED = 1 { name = "Enabled"; desc = "enabled"; };
        };

        field {
            name = "tt15_enf1";
            desc = "Control of teletext in line 15 in the odd field.";
            sw = rw;
            hw = r;
            encode = DATE1_COEFF7_tt15_enf1_enum;
            reset = 0x0;
        } tt15_enf1[24:24];

        enum DATE1_COEFF7_tt14_enf1_enum {
            DISABLED = 0 { name = "Disabled"; desc = "disabled"; };
            ENABLED = 1 { name = "Enabled"; desc = "enabled"; };
        };

        field {
            name = "tt14_enf1";
            desc = "Control of teletext in line 14 in the odd field.";
            sw = rw;
            hw = r;
            encode = DATE1_COEFF7_tt14_enf1_enum;
            reset = 0x0;
        } tt14_enf1[23:23];

        enum DATE1_COEFF7_tt13_enf1_enum {
            DISABLED = 0 { name = "Disabled"; desc = "disabled"; };
            ENABLED = 1 { name = "Enabled"; desc = "enabled"; };
        };

        field {
            name = "tt13_enf1";
            desc = "Control of teletext in line 13 in the odd field.";
            sw = rw;
            hw = r;
            encode = DATE1_COEFF7_tt13_enf1_enum;
            reset = 0x0;
        } tt13_enf1[22:22];

        enum DATE1_COEFF7_tt12_enf1_enum {
            DISABLED = 0 { name = "Disabled"; desc = "disabled"; };
            ENABLED = 1 { name = "Enabled"; desc = "enabled"; };
        };

        field {
            name = "tt12_enf1";
            desc = "Control of teletext in line 12 in the odd field.";
            sw = rw;
            hw = r;
            encode = DATE1_COEFF7_tt12_enf1_enum;
            reset = 0x0;
        } tt12_enf1[21:21];

        enum DATE1_COEFF7_tt11_enf1_enum {
            DISABLED = 0 { name = "Disabled"; desc = "disabled"; };
            ENABLED = 1 { name = "Enabled"; desc = "enabled"; };
        };

        field {
            name = "tt11_enf1";
            desc = "Control of teletext in line 11 in the odd field.";
            sw = rw;
            hw = r;
            encode = DATE1_COEFF7_tt11_enf1_enum;
            reset = 0x0;
        } tt11_enf1[20:20];

        enum DATE1_COEFF7_tt10_enf1_enum {
            DISABLED = 0 { name = "Disabled"; desc = "disabled"; };
            ENABLED = 1 { name = "Enabled"; desc = "enabled"; };
        };

        field {
            name = "tt10_enf1";
            desc = "Control of teletext in line 10 in the odd field.";
            sw = rw;
            hw = r;
            encode = DATE1_COEFF7_tt10_enf1_enum;
            reset = 0x0;
        } tt10_enf1[19:19];

        enum DATE1_COEFF7_tt09_enf1_enum {
            DISABLED = 0 { name = "Disabled"; desc = "disabled"; };
            ENABLED = 1 { name = "Enabled"; desc = "enabled"; };
        };

        field {
            name = "tt09_enf1";
            desc = "Control of teletext in line 9 in the odd field.";
            sw = rw;
            hw = r;
            encode = DATE1_COEFF7_tt09_enf1_enum;
            reset = 0x0;
        } tt09_enf1[18:18];

        enum DATE1_COEFF7_tt08_enf1_enum {
            DISABLED = 0 { name = "Disabled"; desc = "disabled"; };
            ENABLED = 1 { name = "Enabled"; desc = "enabled"; };
        };

        field {
            name = "tt08_enf1";
            desc = "Control of teletext in line 8 in the odd field.";
            sw = rw;
            hw = r;
            encode = DATE1_COEFF7_tt08_enf1_enum;
            reset = 0x0;
        } tt08_enf1[17:17];

        enum DATE1_COEFF7_tt07_enf1_enum {
            DISABLED = 0 { name = "Disabled"; desc = "disabled"; };
            ENABLED = 1 { name = "Enabled"; desc = "enabled"; };
        };

        field {
            name = "tt07_enf1";
            desc = "Control of teletext in line 7 in the odd field.";
            sw = rw;
            hw = r;
            encode = DATE1_COEFF7_tt07_enf1_enum;
            reset = 0x0;
        } tt07_enf1[16:16];

        enum DATE1_COEFF7_tt22_enf2_enum {
            DISABLED = 0 { name = "Disabled"; desc = "disabled"; };
            ENABLED = 1 { name = "Enabled"; desc = "enabled"; };
        };

        field {
            name = "tt22_enf2";
            desc = "Control of teletext in line 22 in the even field.";
            sw = rw;
            hw = r;
            encode = DATE1_COEFF7_tt22_enf2_enum;
            reset = 0x0;
        } tt22_enf2[15:15];

        enum DATE1_COEFF7_tt21_enf2_enum {
            DISABLED = 0 { name = "Disabled"; desc = "disabled"; };
            ENABLED = 1 { name = "Enabled"; desc = "enabled"; };
        };

        field {
            name = "tt21_enf2";
            desc = "Control of teletext in line 21 in the even field.";
            sw = rw;
            hw = r;
            encode = DATE1_COEFF7_tt21_enf2_enum;
            reset = 0x0;
        } tt21_enf2[14:14];

        enum DATE1_COEFF7_tt20_enf2_enum {
            DISABLED = 0 { name = "Disabled"; desc = "disabled"; };
            ENABLED = 1 { name = "Enabled"; desc = "enabled"; };
        };

        field {
            name = "tt20_enf2";
            desc = "Control of teletext in line 20 in the even field.";
            sw = rw;
            hw = r;
            encode = DATE1_COEFF7_tt20_enf2_enum;
            reset = 0x0;
        } tt20_enf2[13:13];

        enum DATE1_COEFF7_tt19_enf2_enum {
            DISABLED = 0 { name = "Disabled"; desc = "disabled"; };
            ENABLED = 1 { name = "Enabled"; desc = "enabled"; };
        };

        field {
            name = "tt19_enf2";
            desc = "Control of teletext in line 19 in the even field.";
            sw = rw;
            hw = r;
            encode = DATE1_COEFF7_tt19_enf2_enum;
            reset = 0x0;
        } tt19_enf2[12:12];

        enum DATE1_COEFF7_tt18_enf2_enum {
            DISABLED = 0 { name = "Disabled"; desc = "disabled"; };
            ENABLED = 1 { name = "Enabled"; desc = "enabled"; };
        };

        field {
            name = "tt18_enf2";
            desc = "Control of teletext in line 18 in the even field.";
            sw = rw;
            hw = r;
            encode = DATE1_COEFF7_tt18_enf2_enum;
            reset = 0x0;
        } tt18_enf2[11:11];

        enum DATE1_COEFF7_tt17_enf2_enum {
            DISABLED = 0 { name = "Disabled"; desc = "disabled"; };
            ENABLED = 1 { name = "Enabled"; desc = "enabled"; };
        };

        field {
            name = "tt17_enf2";
            desc = "Control of teletext in line 17 in the even field.";
            sw = rw;
            hw = r;
            encode = DATE1_COEFF7_tt17_enf2_enum;
            reset = 0x0;
        } tt17_enf2[10:10];

        enum DATE1_COEFF7_tt16_enf2_enum {
            DISABLED = 0 { name = "Disabled"; desc = "disabled"; };
            ENABLED = 1 { name = "Enabled"; desc = "enabled"; };
        };

        field {
            name = "tt16_enf2";
            desc = "Control of teletext in line 16 in the even field.";
            sw = rw;
            hw = r;
            encode = DATE1_COEFF7_tt16_enf2_enum;
            reset = 0x0;
        } tt16_enf2[9:9];

        enum DATE1_COEFF7_tt15_enf2_enum {
            DISABLED = 0 { name = "Disabled"; desc = "disabled"; };
            ENABLED = 1 { name = "Enabled"; desc = "enabled"; };
        };

        field {
            name = "tt15_enf2";
            desc = "Control of teletext in line 15 in the even field.";
            sw = rw;
            hw = r;
            encode = DATE1_COEFF7_tt15_enf2_enum;
            reset = 0x0;
        } tt15_enf2[8:8];

        enum DATE1_COEFF7_tt14_enf2_enum {
            DISABLED = 0 { name = "Disabled"; desc = "disabled"; };
            ENABLED = 1 { name = "Enabled"; desc = "enabled"; };
        };

        field {
            name = "tt14_enf2";
            desc = "Control of teletext in line 14 in the even field.";
            sw = rw;
            hw = r;
            encode = DATE1_COEFF7_tt14_enf2_enum;
            reset = 0x0;
        } tt14_enf2[7:7];

        enum DATE1_COEFF7_tt13_enf2_enum {
            DISABLED = 0 { name = "Disabled"; desc = "disabled"; };
            ENABLED = 1 { name = "Enabled"; desc = "enabled"; };
        };

        field {
            name = "tt13_enf2";
            desc = "Control of teletext in line 13 in the even field.";
            sw = rw;
            hw = r;
            encode = DATE1_COEFF7_tt13_enf2_enum;
            reset = 0x0;
        } tt13_enf2[6:6];

        enum DATE1_COEFF7_tt12_enf2_enum {
            DISABLED = 0 { name = "Disabled"; desc = "disabled"; };
            ENABLED = 1 { name = "Enabled"; desc = "enabled"; };
        };

        field {
            name = "tt12_enf2";
            desc = "Control of teletext in line 12 in the even field.";
            sw = rw;
            hw = r;
            encode = DATE1_COEFF7_tt12_enf2_enum;
            reset = 0x0;
        } tt12_enf2[5:5];

        enum DATE1_COEFF7_tt11_enf2_enum {
            DISABLED = 0 { name = "Disabled"; desc = "disabled"; };
            ENABLED = 1 { name = "Enabled"; desc = "enabled"; };
        };

        field {
            name = "tt11_enf2";
            desc = "Control of teletext in line 11 in the even field.";
            sw = rw;
            hw = r;
            encode = DATE1_COEFF7_tt11_enf2_enum;
            reset = 0x0;
        } tt11_enf2[4:4];

        enum DATE1_COEFF7_tt10_enf2_enum {
            DISABLED = 0 { name = "Disabled"; desc = "disabled"; };
            ENABLED = 1 { name = "Enabled"; desc = "enabled"; };
        };

        field {
            name = "tt10_enf2";
            desc = "Control of teletext in line 10 in the even field.";
            sw = rw;
            hw = r;
            encode = DATE1_COEFF7_tt10_enf2_enum;
            reset = 0x0;
        } tt10_enf2[3:3];

        enum DATE1_COEFF7_tt09_enf2_enum {
            DISABLED = 0 { name = "Disabled"; desc = "disabled"; };
            ENABLED = 1 { name = "Enabled"; desc = "enabled"; };
        };

        field {
            name = "tt09_enf2";
            desc = "Control of teletext in line 9 in the even field.";
            sw = rw;
            hw = r;
            encode = DATE1_COEFF7_tt09_enf2_enum;
            reset = 0x0;
        } tt09_enf2[2:2];

        enum DATE1_COEFF7_tt08_enf2_enum {
            DISABLED = 0 { name = "Disabled"; desc = "disabled"; };
            ENABLED = 1 { name = "Enabled"; desc = "enabled"; };
        };

        field {
            name = "tt08_enf2";
            desc = "Control of teletext in line 8 in the even field.";
            sw = rw;
            hw = r;
            encode = DATE1_COEFF7_tt08_enf2_enum;
            reset = 0x0;
        } tt08_enf2[1:1];

        enum DATE1_COEFF7_tt07_enf2_enum {
            DISABLED = 0 { name = "Disabled"; desc = "disabled"; };
            ENABLED = 1 { name = "Enabled"; desc = "enabled"; };
        };

        field {
            name = "tt07_enf2";
            desc = "Control of teletext in line 7 in the even field.";
            sw = rw;
            hw = r;
            encode = DATE1_COEFF7_tt07_enf2_enum;
            reset = 0x0;
        } tt07_enf2[0:0];
    } DATE1_COEFF7 @ 0xC41C;

    reg {
        name = "DATE1 teletext configuration register";
        desc = "DATE1_COEFF8 is a DATE1 teletext configuration register.

Data sheet 10.2.5 DATE1_COEFF8 (offset 0xC420, printed page 10-154, `hi3516cv100--Hi3516C-Datasheet.txt` line 45053).";

        field {
            name = "tt_staddr";
            desc = "Start address of the teletext data.";
            sw = rw;
            hw = r;
            reset = 0x0;
        } tt_staddr[31:0];
    } DATE1_COEFF8 @ 0xC420;

    reg {
        name = "DATE1 teletext configuration register";
        desc = "DATE1_COEFF9 is a DATE1 teletext configuration register.

Data sheet 10.2.5 DATE1_COEFF9 (offset 0xC424, printed page 10-154, `hi3516cv100--Hi3516C-Datasheet.txt` line 45072).";

        field {
            name = "tt_edaddr";
            desc = "End address of the teletext data.";
            sw = rw;
            hw = r;
            reset = 0x0;
        } tt_edaddr[31:0];
    } DATE1_COEFF9 @ 0xC424;

    reg {
        name = "DATE1 teletext configuration register";
        desc = "DATE1_COEFF10 is a DATE1 teletext configuration register. The teletext function is supported in both 625-line mode and 525-line mode. The tt_mode bit is set to 01 in 625-line mode or 10 in 525-line mode.

Data sheet 10.2.5 DATE1_COEFF10 (offset 0xC428, printed page 10-155, `hi3516cv100--Hi3516C-Datasheet.txt` line 45102).";

        field {
            name = "tt_ready";
            desc = "When software sets related parameters through the bus, this bit is set to 1 and the teletext module starts to work. When the teletext module completes data transfer, this bit is set to 0. The bit status can be queried through software for the next configuration.";
            sw = rw;
            hw = r;
            reset = 0x0;
        } tt_ready[31:31];

        enum DATE1_COEFF10_nabts_100ire_enum {
            V_70_IRE = 0 { name = "V 70 Ire"; desc = "70 IRE"; };
            V_100_IRE = 1 { name = "V 100 Ire"; desc = "100 IRE"; };
        };

        field {
            name = "nabts_100ire";
            desc = "NABTS-NTSC data height.";
            sw = rw;
            hw = r;
            encode = DATE1_COEFF10_nabts_100ire_enum;
            reset = 0x0;
        } nabts_100ire[12:12];

        enum DATE1_COEFF10_full_page_enum {
            NORMAL_MODE_TELETEXT = 0 { name = "Normal Mode Teletext"; desc = "normal mode. The teletext data is transmitted from the blanking line."; };
            FULL_PAGE_MODE = 1 { name = "Full Page Mode"; desc = "full page mode. The teletext data can also be transmitted from the active video region."; };
        };

        field {
            name = "full_page";
            desc = "Teletext data transmission mode.";
            sw = rw;
            hw = r;
            encode = DATE1_COEFF10_full_page_enum;
            reset = 0x0;
        } full_page[11:11];

        enum DATE1_COEFF10_tt_highest_enum {
            TELETEXT_DATA_HAS = 0 { name = "Teletext Data Has"; desc = "The teletext data has the highest priority."; };
            TELETEXT_DATA_HAS_2 = 1 { name = "Teletext Data Has 2"; desc = "The teletext data has the lowest priority."; };
        };

        field {
            name = "tt_highest";
            desc = "Teletext priority control.";
            sw = rw;
            hw = r;
            encode = DATE1_COEFF10_tt_highest_enum;
            reset = 0x0;
        } tt_highest[10:10];

        field {
            name = "tt_mode";
            desc = "tt_mode";
            sw = rw;
            hw = r;
            reset = 0x0;
        } tt_mode[9:8];

        field {
            name = "tt_pktoff";
            desc = "tt_pktoff";
            sw = rw;
            hw = r;
            reset = 0x0;
        } tt_pktoff[7:0];
    } DATE1_COEFF10 @ 0xC428;

    reg {
        name = "DATE1 closed caption configuration register";
        desc = "DATE1_COEFF11 is a DATE1 closed caption configuration register.

Data sheet 10.2.5 DATE1_COEFF11 (offset 0xC42C, printed page 10-156, `hi3516cv100--Hi3516C-Datasheet.txt` line 45160).";

        enum DATE1_COEFF11_cc_enf1_enum {
            DISABLED = 0 { name = "Disabled"; desc = "disabled"; };
            ENABLED = 1 { name = "Enabled"; desc = "enabled"; };
        };

        field {
            name = "cc_enf1";
            desc = "Closed caption odd field enable.";
            sw = rw;
            hw = r;
            encode = DATE1_COEFF11_cc_enf1_enum;
            reset = 0x0;
        } cc_enf1[21:21];

        enum DATE1_COEFF11_cc_enf2_enum {
            DISABLED = 0 { name = "Disabled"; desc = "disabled"; };
            ENABLED = 1 { name = "Enabled"; desc = "enabled"; };
        };

        field {
            name = "cc_enf2";
            desc = "Closed caption even field enable.";
            sw = rw;
            hw = r;
            encode = DATE1_COEFF11_cc_enf2_enum;
            reset = 0x0;
        } cc_enf2[20:20];

        field {
            name = "date_clf1";
            desc = "Configuration line of the closed caption odd field.";
            sw = rw;
            hw = r;
            reset = 0x0;
        } date_clf1[19:10];

        field {
            name = "date_clf2";
            desc = "Configuration line of the closed caption even field.";
            sw = rw;
            hw = r;
            reset = 0x0;
        } date_clf2[9:0];
    } DATE1_COEFF11 @ 0xC42C;

    reg {
        name = "DATE1 closed caption configuration register";
        desc = "DATE1_COEFF12 is a DATE1 closed caption configuration register.

Data sheet 10.2.5 DATE1_COEFF12 (offset 0xC430, printed page 10-157, `hi3516cv100--Hi3516C-Datasheet.txt` line 45201).";

        field {
            name = "cc_f1data";
            desc = "Data of the closed caption odd field.";
            sw = rw;
            hw = r;
            reset = 0x0;
        } cc_f1data[31:16];

        field {
            name = "cc_f2data";
            desc = "Data of the closed caption even field.";
            sw = rw;
            hw = r;
            reset = 0x0;
        } cc_f2data[15:0];
    } DATE1_COEFF12 @ 0xC430;

    reg {
        name = "DATE1 CGMS configuration register";
        desc = "DATE1_COEFF13 is a DATE1 CGMS configuration register.

Data sheet 10.2.5 DATE1_COEFF13 (offset 0xC434, printed page 10-157, `hi3516cv100--Hi3516C-Datasheet.txt` line 45221).";

        enum DATE1_COEFF13_cg_enf1_enum {
            DISABLED = 0 { name = "Disabled"; desc = "disabled"; };
            ENABLED = 1 { name = "Enabled"; desc = "enabled"; };
        };

        field {
            name = "cg_enf1";
            desc = "CGMS odd field enable.";
            sw = rw;
            hw = r;
            encode = DATE1_COEFF13_cg_enf1_enum;
            reset = 0x0;
        } cg_enf1[21:21];

        enum DATE1_COEFF13_cg_enf2_enum {
            DISABLED = 0 { name = "Disabled"; desc = "disabled"; };
            ENABLED = 1 { name = "Enabled"; desc = "enabled"; };
        };

        field {
            name = "cg_enf2";
            desc = "CGMS even field enable.";
            sw = rw;
            hw = r;
            encode = DATE1_COEFF13_cg_enf2_enum;
            reset = 0x0;
        } cg_enf2[20:20];

        field {
            name = "cg_f1data";
            desc = "Data of the CGMS odd field.";
            sw = rw;
            hw = r;
            reset = 0x0;
        } cg_f1data[19:0];
    } DATE1_COEFF13 @ 0xC434;

    reg {
        name = "DATE1 CGMS configuration register";
        desc = "DATE1_COEFF14 is a DATE1 CGMS configuration register.

Data sheet 10.2.5 DATE1_COEFF14 (offset 0xC438, printed page 10-158, `hi3516cv100--Hi3516C-Datasheet.txt` line 45263).";

        field {
            name = "cg_f2data";
            desc = "Data of the CGMS even field.";
            sw = rw;
            hw = r;
            reset = 0x0;
        } cg_f2data[19:0];
    } DATE1_COEFF14 @ 0xC438;

    reg {
        name = "DATE1 WSS configuration register";
        desc = "DATE1_COEFF15 is a DATE1 WSS configuration register. The WSS is available only in 625-line mode and is fixed at line 23.

Data sheet 10.2.5 DATE1_COEFF15 (offset 0xC43C, printed page 10-158, `hi3516cv100--Hi3516C-Datasheet.txt` line 45290).";

        enum DATE1_COEFF15_wss_en_enum {
            DISABLED = 0 { name = "Disabled"; desc = "disabled"; };
            ENABLED = 1 { name = "Enabled"; desc = "enabled"; };
        };

        field {
            name = "wss_en";
            desc = "WSS enable.";
            sw = rw;
            hw = r;
            encode = DATE1_COEFF15_wss_en_enum;
            reset = 0x0;
        } wss_en[14:14];

        field {
            name = "wss_data";
            desc = "WSS data.";
            sw = rw;
            hw = r;
            reset = 0x0;
        } wss_data[13:0];
    } DATE1_COEFF15 @ 0xC43C;

    reg {
        name = "DATE1 VPS configuration register";
        desc = "DATE1_COEFF16 is a DATE1 VPS configuration register.

Data sheet 10.2.5 DATE1_COEFF16 (offset 0xC440, printed page 10-159, `hi3516cv100--Hi3516C-Datasheet.txt` line 45323).";

        enum DATE1_COEFF16_vps_en_enum {
            DISABLED = 0 { name = "Disabled"; desc = "disabled"; };
            ENABLED = 1 { name = "Enabled"; desc = "enabled"; };
        };

        field {
            name = "vps_en";
            desc = "VPS enable.";
            sw = rw;
            hw = r;
            encode = DATE1_COEFF16_vps_en_enum;
            reset = 0x0;
        } vps_en[24:24];

        field {
            name = "vps_data";
            desc = "VPS data from bit 23 to bit 0. Bit 0 is the LSB.";
            sw = rw;
            hw = r;
            reset = 0x0;
        } vps_data[23:0];
    } DATE1_COEFF16 @ 0xC440;

    reg {
        name = "DATE1 VPS configuration register";
        desc = "DATE1_COEFF17 is a DATE1 VPS configuration register.

Data sheet 10.2.5 DATE1_COEFF17 (offset 0xC444, printed page 10-159, `hi3516cv100--Hi3516C-Datasheet.txt` line 45349).";

        field {
            name = "vps_data";
            desc = "VPS data from bit 55 to bit 24. Bit 0 is the LSB.";
            sw = rw;
            hw = r;
            reset = 0x0;
        } vps_data[31:0];
    } DATE1_COEFF17 @ 0xC444;

    reg {
        name = "DATE1 VPS configuration register";
        desc = "DATE1_COEFF18 is a DATE1 VPS configuration register.

Data sheet 10.2.5 DATE1_COEFF18 (offset 0xC448, printed page 10-160, `hi3516cv100--Hi3516C-Datasheet.txt` line 45376).";

        field {
            name = "vps_data";
            desc = "VPS data from bit 87 to bit 56. Bit 0 is the LSB.";
            sw = rw;
            hw = r;
            reset = 0x0;
        } vps_data[31:0];
    } DATE1_COEFF18 @ 0xC448;

    reg {
        name = "DATE1 VPS configuration register";
        desc = "DATE1_COEFF19 is a DATE1 VPS configuration register. The VPS is available only in 625-line mode and is fixed at line 16.

Data sheet 10.2.5 DATE1_COEFF19 (offset 0xC44C, printed page 10-160, `hi3516cv100--Hi3516C-Datasheet.txt` line 45400).";

        field {
            name = "vps_data";
            desc = "VPS data from bit 103 to bit 88. Bit 0 is the LSB.";
            sw = rw;
            hw = r;
            reset = 0x0;
        } vps_data[15:0];
    } DATE1_COEFF19 @ 0xC44C;

    reg {
        name = "DATE1 teletext configuration register";
        desc = "DATE1_COEFF20 is a DATE1 teletext configuration register.

Data sheet 10.2.5 DATE1_COEFF20 (offset 0xC450, printed page 10-161, `hi3516cv100--Hi3516C-Datasheet.txt` line 45430).";

        enum DATE1_COEFF20_tt06_enf1_enum {
            DISABLED = 0 { name = "Disabled"; desc = "disabled"; };
            ENABLED = 1 { name = "Enabled"; desc = "enabled"; };
        };

        field {
            name = "tt06_enf1";
            desc = "Control of teletext in line 6 in the odd field.";
            sw = rw;
            hw = r;
            encode = DATE1_COEFF20_tt06_enf1_enum;
            reset = 0x0;
        } tt06_enf1[2:2];

        enum DATE1_COEFF20_tt06_enf2_enum {
            DISABLED = 0 { name = "Disabled"; desc = "disabled"; };
            ENABLED = 1 { name = "Enabled"; desc = "enabled"; };
        };

        field {
            name = "tt06_enf2";
            desc = "Control of teletext in line 6 in the even field.";
            sw = rw;
            hw = r;
            encode = DATE1_COEFF20_tt06_enf2_enum;
            reset = 0x0;
        } tt06_enf2[1:1];

        enum DATE1_COEFF20_tt05_enf2_enum {
            DISABLED = 0 { name = "Disabled"; desc = "disabled"; };
            ENABLED = 1 { name = "Enabled"; desc = "enabled"; };
        };

        field {
            name = "tt05_enf2";
            desc = "Control of teletext in line 5 in the even field.";
            sw = rw;
            hw = r;
            encode = DATE1_COEFF20_tt05_enf2_enum;
            reset = 0x0;
        } tt05_enf2[0:0];
    } DATE1_COEFF20 @ 0xC450;

    reg {
        name = "DATE1 output matrix control register";
        desc = "DATE1_COEFF21 is the DATE1 output matrix control register.

Data sheet 10.2.5 DATE1_COEFF21 (offset 0xC454, printed page 10-161, `hi3516cv100--Hi3516C-Datasheet.txt` line 45465).";

        enum DATE1_COEFF21_dac5_in_sel_enum {
            V_0 = 0 { name = "V 0"; desc = "0"; };
            CVBS = 1 { name = "Cvbs"; desc = "CVBS"; };
            G_Y = 2 { name = "G Y"; desc = "G/Y"; };
            B_PB = 3 { name = "B Pb"; desc = "B/Pb"; };
            R_PR = 4 { name = "R Pr"; desc = "R/Pr"; };
            SVIDEO_Y = 5 { name = "Svideo Y"; desc = "svideo_y"; };
            SVIDEO_C = 6 { name = "Svideo C"; desc = "svideo_c"; };
            V_0_2 = 7 { name = "V 0 2"; desc = "0"; };
        };

        field {
            name = "dac5_in_sel";
            desc = "DAC5 output mode select.";
            sw = rw;
            hw = r;
            encode = DATE1_COEFF21_dac5_in_sel_enum;
            reset = 0x6;
        } dac5_in_sel[22:20];

        enum DATE1_COEFF21_dac4_in_sel_enum {
            V_0 = 0 { name = "V 0"; desc = "0"; };
            CVBS = 1 { name = "Cvbs"; desc = "CVBS"; };
            G_Y = 2 { name = "G Y"; desc = "G/Y"; };
            B_PB = 3 { name = "B Pb"; desc = "B/Pb"; };
            R_PR = 4 { name = "R Pr"; desc = "R/Pr"; };
            SVIDEO_Y = 5 { name = "Svideo Y"; desc = "svideo_y"; };
            SVIDEO_C = 6 { name = "Svideo C"; desc = "svideo_c"; };
            V_0_2 = 7 { name = "V 0 2"; desc = "0"; };
        };

        field {
            name = "dac4_in_sel";
            desc = "DAC4 output mode select.";
            sw = rw;
            hw = r;
            encode = DATE1_COEFF21_dac4_in_sel_enum;
            reset = 0x5;
        } dac4_in_sel[18:16];

        enum DATE1_COEFF21_dac3_in_sel_enum {
            V_0 = 0 { name = "V 0"; desc = "0"; };
            CVBS = 1 { name = "Cvbs"; desc = "CVBS"; };
            G_Y = 2 { name = "G Y"; desc = "G/Y"; };
            B_PB = 3 { name = "B Pb"; desc = "B/Pb"; };
            R_PR = 4 { name = "R Pr"; desc = "R/Pr"; };
            SVIDEO_Y = 5 { name = "Svideo Y"; desc = "svideo_y"; };
            SVIDEO_C = 6 { name = "Svideo C"; desc = "svideo_c"; };
            V_0_2 = 7 { name = "V 0 2"; desc = "0"; };
        };

        field {
            name = "dac3_in_sel";
            desc = "DAC3 output mode select.";
            sw = rw;
            hw = r;
            encode = DATE1_COEFF21_dac3_in_sel_enum;
            reset = 0x1;
        } dac3_in_sel[14:12];

        enum DATE1_COEFF21_dac2_in_sel_enum {
            V_0 = 0 { name = "V 0"; desc = "0"; };
            CVBS = 1 { name = "Cvbs"; desc = "CVBS"; };
            G_Y = 2 { name = "G Y"; desc = "G/Y"; };
            B_PB = 3 { name = "B Pb"; desc = "B/Pb"; };
            R_PR = 4 { name = "R Pr"; desc = "R/Pr"; };
            SVIDEO_Y = 5 { name = "Svideo Y"; desc = "svideo_y"; };
            SVIDEO_C = 6 { name = "Svideo C"; desc = "svideo_c"; };
            V_0_2 = 7 { name = "V 0 2"; desc = "0"; };
        };

        field {
            name = "dac2_in_sel";
            desc = "DAC2 output mode select.";
            sw = rw;
            hw = r;
            encode = DATE1_COEFF21_dac2_in_sel_enum;
            reset = 0x4;
        } dac2_in_sel[10:8];

        enum DATE1_COEFF21_dac1_in_sel_enum {
            V_0 = 0 { name = "V 0"; desc = "0"; };
            CVBS = 1 { name = "Cvbs"; desc = "CVBS"; };
            G_Y = 2 { name = "G Y"; desc = "G/Y"; };
            B_PB = 3 { name = "B Pb"; desc = "B/Pb"; };
            R_PR = 4 { name = "R Pr"; desc = "R/Pr"; };
            SVIDEO_Y = 5 { name = "Svideo Y"; desc = "svideo_y"; };
            SVIDEO_C = 6 { name = "Svideo C"; desc = "svideo_c"; };
            V_0_2 = 7 { name = "V 0 2"; desc = "0"; };
        };

        field {
            name = "dac1_in_sel";
            desc = "DAC1 output mode select.";
            sw = rw;
            hw = r;
            encode = DATE1_COEFF21_dac1_in_sel_enum;
            reset = 0x3;
        } dac1_in_sel[6:4];

        enum DATE1_COEFF21_dac0_in_sel_enum {
            V_0 = 0 { name = "V 0"; desc = "0"; };
            CVBS = 1 { name = "Cvbs"; desc = "CVBS"; };
            G_Y = 2 { name = "G Y"; desc = "G/Y"; };
            B_PB = 3 { name = "B Pb"; desc = "B/Pb"; };
            R_PR = 4 { name = "R Pr"; desc = "R/Pr"; };
            SVIDEO_Y = 5 { name = "Svideo Y"; desc = "svideo_y"; };
            SVIDEO_C = 6 { name = "Svideo C"; desc = "svideo_c"; };
            V_0_2 = 7 { name = "V 0 2"; desc = "0"; };
        };

        field {
            name = "dac0_in_sel";
            desc = "DAC0 output mode select.";
            sw = rw;
            hw = r;
            encode = DATE1_COEFF21_dac0_in_sel_enum;
            reset = 0x2;
        } dac0_in_sel[2:0];
    } DATE1_COEFF21 @ 0xC454;

    reg {
        name = "DATE1 DTO initial phase configuration register";
        desc = "DATE1_COEFF22 is the DATE1 DTO initial phase configuration register.

Data sheet 10.2.5 DATE1_COEFF22 (offset 0xC458, printed page 10-164, `hi3516cv100--Hi3516C-Datasheet.txt` line 45590).";

        field {
            name = "video_phase_delta";
            desc = "DTO initial phase.";
            sw = rw;
            hw = r;
            reset = 0x0;
        } video_phase_delta[10:0];
    } DATE1_COEFF22 @ 0xC458;

    reg {
        name = "DATE1 video output delay configuration register";
        desc = "DATE1_COEFF23 is the DATE1 video output delay configuration register.

Data sheet 10.2.5 DATE1_COEFF23 (offset 0xC45C, printed page 10-164, `hi3516cv100--Hi3516C-Datasheet.txt` line 45612).";

        field {
            name = "dac5_out_dly";
            desc = "DAC5 output delay cycle. The value is in the unit of a 54 MHz clock cycle and the value n indicates n delay cycles.";
            sw = rw;
            hw = r;
            reset = 0x6;
        } dac5_out_dly[22:20];

        field {
            name = "dac4_out_dly";
            desc = "DAC4 output delay cycle. The value is in the unit of a 54 MHz clock cycle and the value n indicates n delay cycles.";
            sw = rw;
            hw = r;
            reset = 0x5;
        } dac4_out_dly[18:16];

        field {
            name = "dac3_out_dly";
            desc = "DAC3 output delay cycle. The value is in the unit of a 54 MHz clock cycle and the value n indicates n delay cycles.";
            sw = rw;
            hw = r;
            reset = 0x4;
        } dac3_out_dly[14:12];

        field {
            name = "dac2_out_dly";
            desc = "DAC2 output delay cycle. The value is in the unit of a 54 MHz clock cycle and the value n indicates n delay cycles.";
            sw = rw;
            hw = r;
            reset = 0x3;
        } dac2_out_dly[10:8];

        field {
            name = "dac1_out_dly";
            desc = "DAC1 output delay cycle. The value is in the unit of a 54 MHz clock cycle and the value n indicates n delay cycles.";
            sw = rw;
            hw = r;
            reset = 0x2;
        } dac1_out_dly[6:4];

        field {
            name = "dac0_out_dly";
            desc = "DAC0 output delay cycle. The value is in the unit of a 54 MHz clock cycle and the value n indicates n delay cycles.";
            sw = rw;
            hw = r;
            reset = 0x1;
        } dac0_out_dly[2:0];
    } DATE1_COEFF23 @ 0xC45C;

    reg {
        name = "DATE1 interrupt mask register";
        desc = "DATE1_ISRMASK is the DATE1 interrupt mask register.

Data sheet 10.2.5 DATE1_ISRMASK (offset 0xC480, printed page 10-165, `hi3516cv100--Hi3516C-Datasheet.txt` line 45683).";

        enum DATE1_ISRMASK_tt_mask_enum {
            ENABLED = 0 { name = "Enabled"; desc = "enabled"; };
            MASKED = 1 { name = "Masked"; desc = "masked"; };
        };

        field {
            name = "tt_mask";
            desc = "Teletext interrupt mask.";
            sw = rw;
            hw = r;
            encode = DATE1_ISRMASK_tt_mask_enum;
            reset = 0x0;
        } tt_mask[0:0];
    } DATE1_ISRMASK @ 0xC480;

    reg {
        name = "DATE1 interrupt status register";
        desc = "DATE1_ISRSTATE is the DATE1 interrupt status register.

Data sheet 10.2.5 DATE1_ISRSTATE (offset 0xC484, printed page 10-166, `hi3516cv100--Hi3516C-Datasheet.txt` line 45718).";

        field {
            name = "tt_status";
            desc = "Teletext interrupt flag. After the DATE module reads all the teletext data, the bit is set to 1. Writing 1 to this bit clears this bit.";
            sw = rw;
            hw = w;
            onwrite = woclr;
            reset = 0x0;
        } tt_status[0:0];
    } DATE1_ISRSTATE @ 0xC484;

    reg {
        name = "DATE1 interrupt register";
        desc = "DATE1_ISR is the DATE1 interrupt register.

Data sheet 10.2.5 DATE1_ISR (offset 0xC488, printed page 10-166, `hi3516cv100--Hi3516C-Datasheet.txt` line 45747).";

        enum DATE1_ISR_tt_int_enum {
            NO_INTERRUPT_GENERATED = 0 { name = "No Interrupt Generated"; desc = "No interrupt is generated."; };
            INTERRUPT_GENERATED = 1 { name = "Interrupt Generated"; desc = "An interrupt is generated."; };
        };

        field {
            name = "tt_int";
            desc = "Teletext interrupt. It is the interrupt status after tt_status is masked by tt_mask.";
            sw = rw;
            hw = r;
            encode = DATE1_ISR_tt_int_enum;
            reset = 0x0;
        } tt_int[0:0];
    } DATE1_ISR @ 0xC488;

    reg {
        name = "DATE1 version register";
        desc = "DATE1_VERSION is the DATE1 version register. The data sheet lists no bit fields for it.

Data sheet 10.2.5 DATE1_VERSION (offset 0xC490, printed page 10-167, `hi3516cv100--Hi3516C-Datasheet.txt` line 45781).";

        field {
            name = "value";
            desc = "Register value (the data sheet gives no bit table for this register).";
            sw = rw;
            hw = r;
            reset = 0x24;
        } value[31:0];
    } DATE1_VERSION @ 0xC490;

    reg {
        name = "VDAC detection register 1";
        desc = "DATE_DACDET1 is VDAC detection register 1.

Data sheet 10.2.5 DATE_DACDET1 (offset 0xC4AC, printed page 10-167, `hi3516cv100--Hi3516C-Datasheet.txt` line 45802).";

        field {
            name = "det_line";
            desc = "Line where the detected level is located. The line must be in the vertical blanking region but not in the pre- and post-equalization region and field sync field. This field indicates the number of line after the field sync region where the detected level is located.";
            sw = rw;
            hw = r;
            reset = 0xD;
        } det_line[25:16];

        field {
            name = "vdac_det_high";
            desc = "Detected level.";
            sw = rw;
            hw = r;
            reset = 0x303;
        } vdac_det_high[9:0];
    } DATE_DACDET1 @ 0xC4AC;

    reg {
        name = "VDAC detection register 2";
        desc = "DATE_DACDET2 is VDAC detection register 2.

Data sheet 10.2.5 DATE_DACDET2 (offset 0xC4B0, printed page 10-168, `hi3516cv100--Hi3516C-Datasheet.txt` line 45837).";

        enum DATE_DACDET2_vdac_det_en_enum {
            DISABLED = 0 { name = "Disabled"; desc = "disabled"; };
            ENABLED = 1 { name = "Enabled"; desc = "enabled"; };
        };

        field {
            name = "vdac_det_en";
            desc = "VDAC automatic detection enable.";
            sw = rw;
            hw = r;
            encode = DATE_DACDET2_vdac_det_en_enum;
            reset = 0x0;
        } vdac_det_en[31:31];

        field {
            name = "det_pixel_wid";
            desc = "Number of clock cycles during which the detected level lasts. The clock is 27 MHz.";
            sw = rw;
            hw = r;
            reset = 0x30;
        } det_pixel_wid[26:16];

        field {
            name = "det_pixel_sta";
            desc = "Pixel start position in a line. It must be in the horizontal blanking region but not in the chrominance sub-carrier region. This field indicates the number of pixel after the line sync region.";
            sw = rw;
            hw = r;
            reset = 0x118;
        } det_pixel_sta[10:0];
    } DATE_DACDET2 @ 0xC4B0;

    reg {
        name = "VO control register";
        desc = "VOCTRL is a VO control register.

Data sheet 10.2.5 VOCTRL (offset 0xCE00, printed page 10-168, `hi3516cv100--Hi3516C-Datasheet.txt` line 45871).";

        enum VOCTRL_vo_ck_gt_en_enum {
            DISABLED = 0 { name = "Disabled"; desc = "disabled"; };
            ENABLED_CHECK_DATA = 1 { name = "Enabled Check Data"; desc = "enabled [check] The data sheet prints '-' in the access column of this named field; modelled RW."; };
        };

        field {
            name = "vo_ck_gt_en";
            desc = "Clock gating enable.";
            sw = rw;
            hw = r;
            encode = VOCTRL_vo_ck_gt_en_enum;
            reset = 0x0;
        } vo_ck_gt_en[31:31];

        enum VOCTRL_vo_id_sel_enum {
            V_0 = 0 { name = "V 0"; desc = "0"; };
            V_1 = 1 { name = "V 1"; desc = "1"; };
        };

        field {
            name = "vo_id_sel";
            desc = "VOU read ID select.";
            sw = rw;
            hw = r;
            encode = VOCTRL_vo_id_sel_enum;
            reset = 0x0;
        } vo_id_sel[30:30];

        field {
            name = "awid_cfg";
            desc = "ID written by the AXI bus.";
            sw = rw;
            hw = r;
            reset = 0x0;
        } awid_cfg[27:24];

        enum VOCTRL_bus_dbg_en_enum {
            NORMAL_MODE = 0 { name = "Normal Mode"; desc = "normal mode"; };
            READ_WRITE_LOOPBACK = 1 { name = "Read Write Loopback"; desc = "read-write loopback mode for bus test"; };
            WRITE_LOOPBACK_MODE = 2 { name = "Write Loopback Mode"; desc = "write loopback mode for bus test Other values: reserved"; };
        };

        field {
            name = "bus_dbg_en";
            desc = "Bus debugging enable.";
            sw = rw;
            hw = r;
            encode = VOCTRL_bus_dbg_en_enum;
            reset = 0x0;
        } bus_dbg_en[21:20];

        field {
            name = "outstd_wid0";
            desc = "Outstanding of the AXI bus write channel.";
            sw = rw;
            hw = r;
            reset = 0x0;
        } outstd_wid0[19:16];

        field {
            name = "arid_cfg1";
            desc = "ID1 of the AXI bus read channel.";
            sw = rw;
            hw = r;
            reset = 0x0;
        } arid_cfg1[15:12];

        field {
            name = "outstd_rid0";
            desc = "ID0 of the AXI bus read channel.";
            sw = rw;
            hw = r;
            reset = 0x0;
        } outstd_rid0[11:8];

        field {
            name = "outstd_rid1";
            desc = "Outstanding of the AXI bus read channel.";
            sw = rw;
            hw = r;
            reset = 0x0;
        } outstd_rid1[7:4];

        enum VOCTRL_arb_mode_enum {
            POLLING_MODE_USED = 0 { name = "Polling Mode Used"; desc = "The polling mode is used."; };
            GRAPHICS_LAYER_TAKES = 1 { name = "Graphics Layer Takes"; desc = "The graphics layer takes priority. Other values: reserved"; };
        };

        field {
            name = "arb_mode";
            desc = "Arbitration mode of requesting data for each internal surface bus of the VOU.";
            sw = rw;
            hw = r;
            encode = VOCTRL_arb_mode_enum;
            reset = 0x0;
        } arb_mode[3:0];
    } VOCTRL @ 0xCE00;

    reg {
        name = "VO interrupt status register";
        desc = "VOINTSTA is a VO interrupt status register. It is a read-only register.

Data sheet 10.2.5 VOINTSTA (offset 0xCE04, printed page 10-169, `hi3516cv100--Hi3516C-Datasheet.txt` line 45929).";

        enum VOINTSTA_be_int_enum {
            NO_INTERRUPT_GENERATED = 0 { name = "No Interrupt Generated"; desc = "No interrupt is generated."; };
            INTERRUPT_GENERATED = 1 { name = "Interrupt Generated"; desc = "An interrupt is generated."; };
        };

        field {
            name = "be_int";
            desc = "Bus error interrupt (AXI_Master).";
            sw = r;
            hw = w;
            encode = VOINTSTA_be_int_enum;
            reset = 0x0;
        } be_int[31:31];

        field {
            name = "vdac_int";
            desc = "vdac_int";
            sw = r;
            hw = w;
            reset = 0x0;
        } vdac_int[29:29];

        field {
            name = "g3rr_int";
            desc = "g3rr_int";
            sw = r;
            hw = w;
            reset = 0x0;
        } g3rr_int[23:23];

        field {
            name = "vsd1rr_int";
            desc = "vsd1rr_int";
            sw = r;
            hw = w;
            reset = 0x0;
        } vsd1rr_int[20:20];

        field {
            name = "dsduf_int";
            desc = "dsduf_int";
            sw = r;
            hw = w;
            reset = 0x0;
        } dsduf_int[3:3];

        field {
            name = "dsdvtthd1_int";
            desc = "dsdvtthd1_int";
            sw = r;
            hw = w;
            reset = 0x0;
        } dsdvtthd1_int[1:1];
    } VOINTSTA @ 0xCE04;

    reg {
        name = "VO masked interrupt status register";
        desc = "VOMSKINTSTA is a VO masked interrupt status register. Writing 1 clears this register.

Data sheet 10.2.5 VOMSKINTSTA (offset 0xCE08, printed page 10-171, `hi3516cv100--Hi3516C-Datasheet.txt` line 46004).";

        enum VOMSKINTSTA_be_int_enum {
            NO_INTERRUPT_GENERATED = 0 { name = "No Interrupt Generated"; desc = "No interrupt is generated."; };
            INTERRUPT_GENERATED = 1 { name = "Interrupt Generated"; desc = "An interrupt is generated."; };
        };

        field {
            name = "be_int";
            desc = "Bus error interrupt (AXI_Master).";
            sw = r;
            hw = w;
            encode = VOMSKINTSTA_be_int_enum;
            reset = 0x0;
        } be_int[31:31];

        field {
            name = "vdac_int";
            desc = "VDAC connection interrupt.";
            sw = r;
            hw = w;
            reset = 0x0;
        } vdac_int[29:29];

        field {
            name = "g3rr_int";
            desc = "G3 register update interrupt.";
            sw = r;
            hw = w;
            reset = 0x0;
        } g3rr_int[23:23];

        field {
            name = "vsd1rr_int";
            desc = "VSD1 register update interrupt.";
            sw = r;
            hw = w;
            reset = 0x0;
        } vsd1rr_int[20:20];

        field {
            name = "dsduf_int";
            desc = "DSD low-bandwidth alarm interrupt.";
            sw = r;
            hw = w;
            reset = 0x0;
        } dsduf_int[3:3];

        field {
            name = "dsdvtthd1_int";
            desc = "DSD1 vertical timing interrupt.";
            sw = r;
            hw = w;
            reset = 0x0;
        } dsdvtthd1_int[1:1];
    } VOMSKINTSTA @ 0xCE08;

    reg {
        name = "VDP interrupt mask register";
        desc = "VOINTMSK is a VDP interrupt mask register. It corresponds to VOINTSTA. When the corresponding bit is set to 1, the interrupt is enabled; when the corresponding bit is set to 0, the interrupt is masked.

Data sheet 10.2.5 VOINTMSK (offset 0xCE0C, printed page 10-172, `hi3516cv100--Hi3516C-Datasheet.txt` line 46054).";

        enum VOINTMSK_be_intmask_enum {
            NO_INTERRUPT_GENERATED = 0 { name = "No Interrupt Generated"; desc = "No interrupt is generated."; };
            INTERRUPT_GENERATED = 1 { name = "Interrupt Generated"; desc = "An interrupt is generated."; };
        };

        field {
            name = "be_intmask";
            desc = "Bus error interrupt (AXI_Master).";
            sw = r;
            hw = w;
            encode = VOINTMSK_be_intmask_enum;
            reset = 0x0;
        } be_intmask[31:31];

        field {
            name = "vdac_ic_int";
            desc = "VDAC connection interrupt.";
            sw = r;
            hw = w;
            reset = 0x0;
        } vdac_ic_int[29:29];

        field {
            name = "g3rr_intmsk";
            desc = "G3 register update interrupt.";
            sw = r;
            hw = w;
            reset = 0x0;
        } g3rr_intmsk[23:23];

        field {
            name = "vsd1rr_intmask";
            desc = "VSD1 register update interrupt.";
            sw = r;
            hw = w;
            reset = 0x0;
        } vsd1rr_intmask[20:20];

        field {
            name = "dsduf_intmask";
            desc = "DSD low-bandwidth alarm interrupt.";
            sw = r;
            hw = w;
            reset = 0x0;
        } dsduf_intmask[3:3];

        field {
            name = "dsdvtthd1_intmask";
            desc = "DSD1 vertical timing interrupt.";
            sw = r;
            hw = w;
            reset = 0x0;
        } dsdvtthd1_intmask[1:1];
    } VOINTMSK @ 0xCE0C;

    reg {
        name = "VDP version register 1";
        desc = "VOUVERSION1 is VDP version register 1.

Data sheet 10.2.5 VOUVERSION1 (offset 0xCE10, printed page 10-173, `hi3516cv100--Hi3516C-Datasheet.txt` line 46103).";

        field {
            name = "vouversion0";
            desc = "VDP version.";
            sw = r;
            hw = w;
            reset = 0x76756F76;
        } vouversion0[31:0];
    } VOUVERSION1 @ 0xCE10;

    reg {
        name = "VDP version register 2";
        desc = "VOUVERSION2 is VDP version register 2.

Data sheet 10.2.5 VOUVERSION2 (offset 0xCE14, printed page 10-173, `hi3516cv100--Hi3516C-Datasheet.txt` line 46122).";

        field {
            name = "vouversion1";
            desc = "VDP version.";
            sw = r;
            hw = w;
            reset = 0x30303134;
        } vouversion1[31:0];
    } VOUVERSION2 @ 0xCE14;

    reg {
        name = "VO interface multiplexing register";
        desc = "VOMUX is a VO interface multiplexing register.

Data sheet 10.2.5 VOMUX (offset 0xCE1C, printed page 10-173, `hi3516cv100--Hi3516C-Datasheet.txt` line 46140).";

        enum VOMUX_bt1120_sel_yc_enum {
            UPPER_EIGHT_BITS = 0 { name = "Upper Eight Bits"; desc = "The upper eight bits are used to transmit the Y component, and the lower eight bits are used to transmit the C component."; };
            UPPER_EIGHT_BITS_2 = 1 { name = "Upper Eight Bits 2"; desc = "The upper eight bits are used to transmit the C component, and the lower eight bits are used to transmit the Y component."; };
        };

        field {
            name = "bt1120_sel_yc";
            desc = "BT.1120 Y/C position select.";
            sw = rw;
            hw = r;
            encode = VOMUX_bt1120_sel_yc_enum;
            reset = 0x0;
        } bt1120_sel_yc[23:23];
    } VOMUX @ 0xCE1C;
};

`endif
