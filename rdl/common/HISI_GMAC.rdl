`ifndef HISI_GMAC_RDL
`define HISI_GMAC_RDL


regfile eHISI_GMAC {
    name = "HiSilicon GSF gigabit Ethernet MAC with descriptor queues and MDIO";
    desc = "
    HiSilicon \"GSF\" gigabit Ethernet MAC (vendor driver name \"higmac\", the Linux driver is hix5hd2_gmac.c: compatible hisilicon,hi3516a-gmac, hisilicon,hisi-gmac-v2 and hisilicon,hi3798cv200-gmac; vendor U-Boot drivers higmacv300 for the Hi3516A/AV200/Hi3519 class and the older higmac for the Hi3516 V100 class): one 10/100/1000 Mbit/s port (RMII, MII, RGMII; full or half duplex) with an MDIO master, packet counters, a CRF block (flow control of control, IP and broadcast/multicast packets with a 16-entry frame type filter list, TX/RX FIFOs, TSO/SG/checksum offload on the AV200/Hi3519 generation) and four DMA descriptor queues in DDR: RX_FQ (idle descriptors, software writes empty buffers), RX_BQ (RX descriptors written back by the MAC), TX_BQ (TX descriptors written by software) and TX_RQ (recycled TX descriptors), each with start address, depth, read and write pointers, thresholds and a register write-enable (QUEUE_REG_EN) register at 0x500..0x5BC; interrupts are enabled/read/cleared through ENA_PMU_INT, STATUS_PMU_INT and RAW_PMU_INT (0x5C0..0x5C8, write 1 to clear the raw bits); EEE (0x800..0x814) and PMT wake-on-LAN (0xA00..0xA20) exist from the Hi3516A generation on. Unlike the femac (eHISI_FEMAC) and hieth (eHISI_HIETH_SF) Ethernet blocks of the other chips there are no frame FIFOs behind registers: frames are moved by the MAC with its own DMA through the descriptor rings. The data sheets call the block \"GSF\" (gigabit switch fabric, Hi3516A/AV200/Hi3519: two ports on the data-sheet block diagram, but only one port register set and one MDIO) or \"GMAC\"/\"Ethernet\" (Hi3516 V100).
    Variants. The default (no macro defined) is the Hi3516A / Hi3516D / Hi3516A V200 / Hi3519 V101 layout: the four data sheets print the same register set (the register tables of the Hi3516A V200 and Hi3519 V101 are identical, the Hi3516A one differs in one typo only). Define HISI_GMAC_HI3516V100 before including this file for the Hi3516 V100: it lacks DUPLEX_SEL_RGMII (0x08), COL_DISTANCE (0x14), RX_JABBER_ERRORS (0xC4), TX_EXC_COL_ERR_CNT (0x144), TX_TAGGED (0x154), COL_SLOT_TIME (0x1C0), VLAN_CODE (0x1E8), SHORT_ERR_PKT_CNT (0x284), the EEE registers (0x800..0x814) and the PMT registers (0xA00..0xA20), has the extra registers FIFO_THRSLD (0x10), APP_LOOP_EN (0x27C), IP_CHK_ERR_CNT (0x2B4), UDP_CHK_ERR_CNT (0x2B8), TX_RUNT_ERR_PKG_CNT (0x2BC), RX_ERR_TOTAL_CNT (0x2C0), RX_TRANS_PKG_CNT (0x2C8), TX_TRANS_PKG_CNT (0x2CC), RX_BM_OVERFLOW (0x2D0) and MDIO_SCAN_EN (0x3C8), calls 0x344 CRF_RX_ADDR_NUM (CRF_RX_LEFT_NUM elsewhere) and differs in fields: TRANSMIT_CONTROL (an_enable, link_sel), REC_FILT_CONTROL (no vlan_drop_en), CONTROL_WORD (hrdy_sel and other reserved-bit resets), MAC_DA_ADDR_H and CRF_MIN_PACKET (no crf_tx_max_packet / tso_version), CRF_RX_FIFO_THRSLD (11-bit thresholds, other resets) and BQ1_ALFULL_TH (reset 16 instead of 0). The Hi3516 V100 has STATUS_PMU_INT (0x5C8) like the others. The Hi3516 V100 data sheet is the only one that has a Chinese original; no Chinese original of the Hi3516A, Hi3516A V200 and Hi3519 V101 data sheets is available in this workspace (the English editions are used and may carry translation or copy-paste errors; they are noted per register).
    Base address, interrupt and clock/reset. Hi3516A/Hi3516D (hi3516av100, hi3516dv100) and Hi3516 V100: 0x10090000; Hi3516A V200 and Hi3519 V101: 0x10050000 (64 KB window each, data sheet memory map). Interrupt: data sheet interrupt table (Table 3-8) bit 57 \"GSF\" on Hi3516A/Hi3516D, Hi3516A V200 and Hi3519 V101; bit 60 \"GMAC\" on the Hi3516 V100. Clock and reset: PERI_CRG51 (CRG base + 0xCC: 0x200300CC on the Hi3516A/D, 0x120100CC on the Hi3516A V200 and Hi3519 V101): gsf_srst_req bit 0 (GSF soft reset), gsf_cken/gsf_clken bit 1, gmac_if_srst_req bit 2 (MAC_IF reset), gmac_if_cken/gmac_if_clken bit 3 (reset value 0xA: both clocks on), rmii_cksel/rmii_clksel bit 4 (0 CRG clock, 1 pad input), external FE PHY clock select bit 6 (Hi3516A/D: 0 = 50 MHz, 1 = 25 MHz; Hi3516A V200/Hi3519: 0 = 25 MHz, 1 = 50 MHz, the vendor U-Boot agrees) and on the Hi3516A V200/Hi3519 V101 external FE PHY soft reset bit 7 (ext_fephy_srst_req; the vendor U-Boot uses bit 5 for the PHY reset on the Hi3516A, a bit the Hi3516A data sheet lists as reserved); PERI_CRG59 (CRG + 0xEC) is the MAC_IF mode control (port select, speed, RGMII/RMII/MII interface mode) and PERI_CRG60 (CRG + 0xF0) the MAC_IF status. Switching the operating mode (RMII 10/100 or RGMII 10/100/1000): set PERI_CRG51 to 0xE (reset), write PERI_CRG59 bits 8:0, set PERI_CRG51 to 0xA, then program MODE_CHANGE_EN = 1, PORT_MODE, MODE_CHANGE_EN = 0 (data sheet 5.4.6; the same sequence is in Linux and the vendor U-Boot). Hi3516 V100: PERI_CRG21 (0x20030054): gmac_rst_req bit 0, gmac_cken bit 1, gmac_txclk_mode bits 5:4 (MII / RGMII 10, 100, 1000 Mbit/s); the older vendor U-Boot driver higmac programs it as PERI_CRG21.
    Descriptors (data sheet 5.4.2): word 0 = packet buffer address, word 1 = hw_own / sg_flag / coe_flag / tso_flag / data_len / vlan and IP header fields (Table 5-2); the queue depth registers count words, not descriptors; the maximum RX frame length is 1.6 KB, the drivers use 1600 byte frames in 1728 byte buffers and 32 byte descriptors.
    Register names, offsets, resets and field descriptions are from the Hi3516A V200 data sheet issue 01 (2018-07-05), chapter 5 (printed pages 5-17..5-109, section 5.6 summary at text dump line 30283, section 5.7 descriptions at lines 30690-35983, file Hi3516AV200-Datasheet.txt); the Hi3516A/Hi3516D data sheet issue 01 (2016-10-28; summary 50835, descriptions 51241-56448), the Hi3519 V101 data sheet (summary 30218, descriptions 30625-35918) and the Hi3516 V100 data sheet issue 00B60 (2011-08-12, Chinese; summary 28426, descriptions 28895-34678) were compared register by register and field by field (the three English editions are identical apart from the register and the field descriptions in one sentence of TX_BQ_RD_ADDR; the V100 differences are the variant above). The V100-only registers are translated from the Chinese text. The summary table and the register headers of the data sheet contain several errors that were corrected as noted per register (the registers at 0xC8 and 0xCC are only in the summary table and in a block directly after RX_JABBER_ERRORS; the FILTER_LIST register has no summary row; RX_FQ_ALRMPTY_TH is spelled ALRMPTY; PMT_CTRL_STAUTS is spelled STAUTS). Cross-checked against Linux hix5hd2_gmac.c (every offset, bit mask and access pattern it defines agrees; it additionally names RX_CFF_NUM_REG 0x5F0, PMU_FSM_REG 0x5F8, RX_FIFO_PKT_IN_NUM 0x5FC and RX_FIFO_PKT_OUT_NUM 0x600, which no data sheet describes and the driver never uses, so they are not modelled) and the vendor U-Boot higmacv300 and higmac headers (offsets agree; the FLUSH_CMD bit layout and the PHY address mask differ, see FLUSH_CMD and MDIO_SINGLE_CMD). The vendor U-Boot also writes 0xE to GSF offset 0x3004 (\"CRF ack threshold\" of the dual-MAC variant), which is outside the documented registers. Not hardware verified.
";

    reg {
        name = "Local MAC address register";
        desc = "STATION_ADDR_LOW is a local MAC address register.

Vendor U-Boot (higmac_hw_set_macaddress) writes STATION_ADDR_HIGH (bits 15:0 = MAC bytes 0 and 1) and then STATION_ADDR_LOW (bytes 2..5).

Data sheet 5.7 STATION_ADDR_LOW (offset 0x0, printed page 5-17, `Hi3516AV200-Datasheet.txt` line 30695).
Hi3516 V100 data sheet (Chinese original) 5.6 STATION_ADDR_LOW (offset 0x0, printed page 5-18, `Hi3516-Datasheet.txt` line 28910).";

        field {
            name = "station_addr_low";
            desc = "Lower 32 bits for the source MAC address of MAC_CORE";
            sw = rw;
            hw = r;
            reset = 0x0;
        } station_addr_low[31:0];
    } STATION_ADDR_LOW @ 0x0;

    reg {
        name = "Local MAC address register";
        desc = "STATION_ADDR_HIGH is a local MAC address register.

Data sheet 5.7 STATION_ADDR_HIGH (offset 0x4, printed page 5-17, `Hi3516AV200-Datasheet.txt` line 30714).
Hi3516 V100 data sheet (Chinese original) 5.6 STATION_ADDR_HIGH (offset 0x4, printed page 5-18, `Hi3516-Datasheet.txt` line 28929).";

        field {
            name = "station_addr_high";
            desc = "Upper 16 bits of the source MAC address of MAC_CORE. The default configurations can be used.";
            sw = rw;
            hw = r;
            reset = 0x0;
        } station_addr_high[15:0];
    } STATION_ADDR_HIGH @ 0x4;

`ifndef HISI_GMAC_HI3516V100
    reg {
        name = "Half-duplex selection register";
        desc = "DUPLEX_SEL_RGMII is a half-duplex selection register.

Linux hix5hd2_gmac.c calls this register MAC_DUPLEX_HALF_CTRL and writes the duplex flag (1 = full) after programming PORT_MODE; the vendor U-Boot (higmac.c) writes 0 (half) or 1 (full). Not present on the Hi3516 V100.

Data sheet 5.7 DUPLEX_SEL_RGMII (offset 0x8, printed page 5-18, `Hi3516AV200-Datasheet.txt` line 30746).";

        enum DUPLEX_SEL_RGMII_duplex_sel_rgmii_enum {
            HALF_DUPLEX = 0 { name = "Half Duplex"; desc = "half duplex"; };
            FULL_DUPLEX = 1 { name = "Full Duplex"; desc = "full duplex"; };
        };

        field {
            name = "duplex_sel_rgmii";
            desc = "Half-duplex selection signal";
            sw = rw;
            hw = r;
            encode = DUPLEX_SEL_RGMII_duplex_sel_rgmii_enum;
            reset = 0x1;
        } duplex_sel_rgmii[0:0];
    } DUPLEX_SEL_RGMII @ 0x8;
`endif

    reg {
        name = "Flow control frame type domain register";
        desc = "FD_FC_TYPE is a flow control frame type domain register.

Data sheet 5.7 FD_FC_TYPE (offset 0xC, printed page 5-18, `Hi3516AV200-Datasheet.txt` line 30774).
Hi3516 V100 data sheet (Chinese original) 5.6 FD_FC_TYPE (offset 0xC, printed page 5-18, `Hi3516-Datasheet.txt` line 28950).";

        field {
            name = "fd_fc_type";
            desc = "Flow control frame type domain in full-duplex mode";
            sw = rw;
            hw = r;
            reset = 0x8808;
        } fd_fc_type[15:0];
    } FD_FC_TYPE @ 0xC;

`ifdef HISI_GMAC_HI3516V100
    reg {
        name = "MAC application-side FIFO parameter setting register";
        desc = "FIFO_THRSLD is the MAC application-side FIFO parameter setting register.

Hi3516 V100 data sheet (Chinese original) 5.6 FIFO_THRSLD (offset 0x10, printed page 5-19, `Hi3516-Datasheet.txt` line 28977). Hi3516 V100 only (not in the Hi3516A, Hi3516A V200 and Hi3519 V101 data sheets).";

        field {
            name = "thrsld_inter_clock";
            desc = "Application-side FIFO parameter that defines the ratio between the FIFO read and write clocks.";
            sw = rw;
            hw = r;
            reset = 0x0;
        } thrsld_inter_clock[31:24];

        field {
            name = "thrsld_for_p_empty";
            desc = "Application-side FIFO parameter that defines the low watermark of the FIFO.";
            sw = rw;
            hw = r;
            reset = 0xA;
        } thrsld_for_p_empty[23:16];

        field {
            name = "thrsld_for_p_full";
            desc = "Application-side FIFO parameter that defines the high watermark of the FIFO. The user must not modify it.";
            sw = rw;
            hw = r;
            reset = 0x19;
        } thrsld_for_p_full[15:8];

        field {
            name = "buff_sz_for_tsmt";
            desc = "Application-side FIFO parameter that defines the threshold for starting a read operation of the FIFO.";
            sw = rw;
            hw = r;
            reset = 0x10;
        } buff_sz_for_tsmt[7:0];
    } FIFO_THRSLD @ 0x10;
`endif

`ifndef HISI_GMAC_HI3516V100
    reg {
        name = "Single retransmission packet length threshold register";
        desc = "COL_DISTANCE is a single retransmission packet length threshold register.

Data sheet 5.7 COL_DISTANCE (offset 0x14, printed page 5-19, `Hi3516AV200-Datasheet.txt` line 30799).";

        field {
            name = "col_distance";
            desc = "Single retransmission packet length threshold";
            sw = rw;
            hw = r;
            reset = 0x43;
        } col_distance[9:0];
    } COL_DISTANCE @ 0x14;
`endif

    reg {
        name = "Flow control time parameter register";
        desc = "FC_TX_TIMER is a flow control time parameter register.

Data sheet 5.7 FC_TX_TIMER (offset 0x1C, printed page 5-19, `Hi3516AV200-Datasheet.txt` line 30819).
Hi3516 V100 data sheet (Chinese original) 5.6 FC_TX_TIMER (offset 0x1C, printed page 5-19, `Hi3516-Datasheet.txt` line 29004).";

        field {
            name = "fc_tx_timer";
            desc = "Parameter of the time period during which flow control frames are transmitted. The unit of the time period is measured by how long 512 bits are transmitted. In 100 Mbit/s mode, the unit is equivalent to 128 clock periods. In 1000 Mbit/s mode, the unit is equivalent to 64 clock periods.";
            sw = rw;
            hw = r;
            reset = 0xFF;
        } fc_tx_timer[15:0];
    } FC_TX_TIMER @ 0x1C;

    reg {
        name = "Flow control frame destination address lower 32 bits register";
        desc = "FD_FC_ADDR_LOW is a flow control frame destination address lower 32 bits register.

Data sheet 5.7 FD_FC_ADDR_LOW (offset 0x20, printed page 5-20, `Hi3516AV200-Datasheet.txt` line 30851).
Hi3516 V100 data sheet (Chinese original) 5.6 FD_FC_ADDR_LOW (offset 0x20, printed page 5-20, `Hi3516-Datasheet.txt` line 29037).";

        field {
            name = "fd_fc_addr_low";
            desc = "Lower 32 bits of the destination address of the flow control frame";
            sw = rw;
            hw = r;
            reset = 0xC2000001;
        } fd_fc_addr_low[31:0];
    } FD_FC_ADDR_LOW @ 0x20;

    reg {
        name = "Flow control frame destination address upper 16 bits register";
        desc = "FD_FC_ADDR_HIGH is a flow control frame destination address upper 16 bits register.

Data sheet 5.7 FD_FC_ADDR_HIGH (offset 0x24, printed page 5-20, `Hi3516AV200-Datasheet.txt` line 30869).
Hi3516 V100 data sheet (Chinese original) 5.6 FD_FC_ADDR_HIGH (offset 0x24, printed page 5-20, `Hi3516-Datasheet.txt` line 29056).";

        field {
            name = "fd_fc_addr_high";
            desc = "Upper 16 bits of the destination address of the flow control frame";
            sw = rw;
            hw = r;
            reset = 0x180;
        } fd_fc_addr_high[15:0];
    } FD_FC_ADDR_HIGH @ 0x24;

    reg {
        name = "TX frame inter-packet gap (IPG) register";
        desc = "IPG_TX_TIMER is a TX frame IPG register.

Data sheet 5.7 IPG_TX_TIMER (offset 0x30, printed page 5-20, `Hi3516AV200-Datasheet.txt` line 30889).
Hi3516 V100 data sheet (Chinese original) 5.6 IPG_TX_TIMER (offset 0x30, printed page 5-20, `Hi3516-Datasheet.txt` line 29077).";

        field {
            name = "ipg_tx_timer";
            desc = "TX frame IPG, in the unit of byte";
            sw = rw;
            hw = r;
            reset = 0x8;
        } ipg_tx_timer[7:0];
    } IPG_TX_TIMER @ 0x30;

    reg {
        name = "TX flow control frame IPG register";
        desc = "PAUSE_THR is a TX flow control frame IPG register.

Data sheet 5.7 PAUSE_THR (offset 0x38, printed page 5-21, `Hi3516AV200-Datasheet.txt` line 30913).
Hi3516 V100 data sheet (Chinese original) 5.6 PAUSE_THR (offset 0x38, printed page 5-21, `Hi3516-Datasheet.txt` line 29104).";

        field {
            name = "pause_thr";
            desc = "IPG of the flow control frame. If the flow control time is longer than the IPG, the MAC transmits the flow control frame automatically. The unit of the time period is measured by how long 512 bits are transmitted. In 100 Mbit/s mode, the unit is equivalent to 128 clock periods. In 1000 Mbit/s mode, the unit is equivalent to 64 clock periods.";
            sw = rw;
            hw = r;
            reset = 0x2F;
        } pause_thr[15:0];
    } PAUSE_THR @ 0x38;

    reg {
        name = "Maximum frame length register";
        desc = "MAX_FRM_SIZE is a maximum frame length register.

Linux/U-Boot: the field is 14 bits wide (BITS_MAX_FRM_SIZE = bits 13:0).

Data sheet 5.7 MAX_FRM_SIZE (offset 0x3C, printed page 5-21, `Hi3516AV200-Datasheet.txt` line 30938).
Hi3516 V100 data sheet (Chinese original) 5.6 MAX_FRM_SIZE (offset 0x3C, printed page 5-21, `Hi3516-Datasheet.txt` line 29129).";

        field {
            name = "max_frm_size";
            desc = "Maximum frame length on the MAC side If the length of an RX frame is greater than the maximum length, the RX frame is regarded as an oversized frame. When the length of a frame to be transmitted is greater than the maximum length, the frame is broken up and then transmitted as an error frame.";
            sw = rw;
            hw = r;
            reset = 0x5EE;
        } max_frm_size[13:0];
    } MAX_FRM_SIZE @ 0x3C;

    reg {
        name = "Port status register";
        desc = "PORT_MODE is a port status register.

Linux hix5hd2_gmac.c and the vendor U-Boot write 0 (10M), 1 (100M) or 5 (1000M) here between writes of 1 and 0 to MODE_CHANGE_EN (the MAC_IF mode and duplex are programmed separately in the CRG register PERI_CRG59). The vendor U-Boot names the values PORT_MOD_*.

Data sheet 5.7 PORT_MODE (offset 0x40, printed page 5-22, `Hi3516AV200-Datasheet.txt` line 30967).
Hi3516 V100 data sheet (Chinese original) 5.6 PORT_MODE (offset 0x40, printed page 5-22, `Hi3516-Datasheet.txt` line 29164).";

        enum PORT_MODE_port_mode_enum {
            SPEED_10M = 0 { name = "10 Mbit/s"; desc = "10 Mbit/s"; };
            SPEED_100M = 1 { name = "100 Mbit/s"; desc = "100 Mbit/s"; };
            SPEED_1000M = 5 { name = "1000 Mbit/s"; desc = "1000 Mbit/s (other values are reserved)"; };
        };

        field {
            name = "port_mode";
            desc = "Current MAC port mode";
            sw = rw;
            hw = r;
            encode = PORT_MODE_port_mode_enum;
            reset = 0x1;
        } port_mode[2:0];
    } PORT_MODE @ 0x40;

    reg {
        name = "Channel enable register";
        desc = "PORT_EN is a channel enable register.

Linux BITS_TX_EN = bit 2 and BITS_RX_EN = bit 1; the reset value 0x6 has both channels enabled.

Data sheet 5.7 PORT_EN (offset 0x44, printed page 5-22, `Hi3516AV200-Datasheet.txt` line 30995).
Hi3516 V100 data sheet (Chinese original) 5.6 PORT_EN (offset 0x44, printed page 5-22, `Hi3516-Datasheet.txt` line 29199).";

        enum PORT_EN_tx_en_enum {
            DISABLED = 0 { name = "Disabled"; desc = "disabled"; };
            ENABLED = 1 { name = "Enabled"; desc = "enabled"; };
        };

        field {
            name = "tx_en";
            desc = "TX channel enable";
            sw = rw;
            hw = r;
            encode = PORT_EN_tx_en_enum;
            reset = 0x1;
        } tx_en[2:2];

        enum PORT_EN_rx_en_enum {
            DISABLED = 0 { name = "Disabled"; desc = "disabled"; };
            ENABLED = 1 { name = "Enabled"; desc = "enabled"; };
        };

        field {
            name = "rx_en";
            desc = "RX channel enable";
            sw = rw;
            hw = r;
            encode = PORT_EN_rx_en_enum;
            reset = 0x1;
        } rx_en[1:1];
    } PORT_EN @ 0x44;

    reg {
        name = "Flow control enable register";
        desc = "PAUSE_EN is a flow control enable register.

Data sheet 5.7 PAUSE_EN (offset 0x48, printed page 5-23, `Hi3516AV200-Datasheet.txt` line 31032).
Hi3516 V100 data sheet (Chinese original) 5.6 PAUSE_EN (offset 0x48, printed page 5-23, `Hi3516-Datasheet.txt` line 29241).";

        field {
            name = "reserved_nz";
            desc = "Reserved (RO); reads 1: the data sheet total reset value is 0x0000_0007 although only bits 1:0 are described (identical in all data sheet editions; not read on hardware).";
            sw = r;
            hw = w;
            reset = 0x1;
        } reserved_nz[2:2];

        enum PAUSE_EN_tx_fdfc_enum {
            DISABLED = 0 { name = "Disabled"; desc = "disabled"; };
            ENABLED = 1 { name = "Enabled"; desc = "enabled"; };
        };

        field {
            name = "tx_fdfc";
            desc = "Flow control frame transmit enable in full-duplex mode";
            sw = rw;
            hw = r;
            encode = PAUSE_EN_tx_fdfc_enum;
            reset = 0x1;
        } tx_fdfc[1:1];

        enum PAUSE_EN_rx_fdfc_enum {
            DISABLED = 0 { name = "Disabled"; desc = "disabled"; };
            ENABLED = 1 { name = "Enabled"; desc = "enabled"; };
        };

        field {
            name = "rx_fdfc";
            desc = "Flow control frame response enable in full-duplex mode";
            sw = rw;
            hw = r;
            encode = PAUSE_EN_rx_fdfc_enum;
            reset = 0x1;
        } rx_fdfc[0:0];
    } PAUSE_EN @ 0x48;

    reg {
        name = "Short frame threshold register";
        desc = "SHORT_RUNTS_THR is a short frame threshold register.

Data sheet 5.7 SHORT_RUNTS_THR (offset 0x50, printed page 5-23, `Hi3516AV200-Datasheet.txt` line 31060).
Hi3516 V100 data sheet (Chinese original) 5.6 SHORT_RUNTS_THR (offset 0x50, printed page 5-23, `Hi3516-Datasheet.txt` line 29270).";

        field {
            name = "short_runts_thr";
            desc = "Short frame threshold (for statistics only)";
            sw = rw;
            hw = r;
            reset = 0xC;
        } short_runts_thr[4:0];
    } SHORT_RUNTS_THR @ 0x50;

    reg {
        name = "Drop enable register for unknown control frames";
        desc = "DROP_UNK_CTL_FRM is a drop enable register for unknown control frames.

Data sheet 5.7 DROP_UNK_CTL_FRM (offset 0x54, printed page 5-24, `Hi3516AV200-Datasheet.txt` line 31085).
Hi3516 V100 data sheet (Chinese original) 5.6 DROP_UNK_CTL_FRM (offset 0x54, printed page 5-24, `Hi3516-Datasheet.txt` line 29300).";

        enum DROP_UNK_CTL_FRM_drop_unk_ctl_frm_enum {
            FORWARD = 0 { name = "Forward"; desc = "The unknown control frames are forwarded normally."; };
            DROP = 1 { name = "Drop"; desc = "The unknown control frames are dropped."; };
        };

        field {
            name = "drop_unk_ctl_frm";
            desc = "Processing method of the unknown control frames";
            sw = rw;
            hw = r;
            encode = DROP_UNK_CTL_FRM_drop_unk_ctl_frm_enum;
            reset = 0x1;
        } drop_unk_ctl_frm[0:0];
    } DROP_UNK_CTL_FRM @ 0x54;

    reg {
        name = "Common configuration register";
        desc = "TRANSMIT_CONTROL is a common configuration register.

Data sheet 5.7 TRANSMIT_CONTROL (offset 0x60, printed page 5-24, `Hi3516AV200-Datasheet.txt` line 31114).
Hi3516 V100 data sheet (Chinese original) 5.6 TRANSMIT_CONTROL (offset 0x60, printed page 5-24, `Hi3516-Datasheet.txt` line 29330).";

        enum TRANSMIT_CONTROL_pad_enable_enum {
            DISABLED = 0 { name = "Disabled"; desc = "disabled"; };
            ENABLED = 1 { name = "Enabled"; desc = "enabled"; };
        };

        field {
            name = "pad_enable";
            desc = "PAD addition enable";
            sw = rw;
            hw = r;
            encode = TRANSMIT_CONTROL_pad_enable_enum;
            reset = 0x1;
        } pad_enable[7:7];

        enum TRANSMIT_CONTROL_crc_add_enum {
            ENABLED = 0 { name = "Enabled"; desc = "enabled"; };
            DISABLED = 1 { name = "Disabled"; desc = "disabled"; };
        };

        field {
            name = "crc_add";
            desc = "FCS addition enable";
            sw = rw;
            hw = r;
            encode = TRANSMIT_CONTROL_crc_add_enum;
            reset = 0x1;
        } crc_add[6:6];

`ifdef HISI_GMAC_HI3516V100
        field {
            name = "an_enable";
            desc = "Auto-negotiation enable. 0: disabled, fixed configuration; 1: enabled. (Hi3516 V100 data sheet, Chinese original; read-only there.)";
            sw = r;
            hw = w;
            reset = 0x0;
        } an_enable[5:5];
`endif

`ifndef HISI_GMAC_HI3516V100
        field {
            name = "reserved_nz";
            desc = "Reserved (RO); reads 1: the data sheet total reset value is 0x0000_00D0 (this bit is link_sel on the Hi3516 V100; not read on hardware).";
            sw = r;
            hw = w;
            reset = 0x1;
        } reserved_nz[4:4];
`endif

`ifdef HISI_GMAC_HI3516V100
        field {
            name = "link_sel";
            desc = "Link status selection. 1: the link status is always forced to link up (default); 0: invalid. (Hi3516 V100 data sheet, Chinese original; read-only there.)";
            sw = r;
            hw = w;
            reset = 0x1;
        } link_sel[4:4];
`endif
    } TRANSMIT_CONTROL @ 0x60;

    reg {
        name = "RX frame filter control register";
        desc = "REC_FILT_CONTROL is an RX frame filter control register.

Linux/U-Boot use the same bit masks (crc_err_pass bit 5 ... uc_match_en bit 0). Linux sets only crc_err_pass at init; the vendor U-Boot writes 0x3F and then clears bc_drop_en. vlan_drop_en does not exist on the Hi3516 V100 data sheet.

Data sheet 5.7 REC_FILT_CONTROL (offset 0x64, printed page 5-25, `Hi3516AV200-Datasheet.txt` line 31154).
Hi3516 V100 data sheet (Chinese original) 5.6 REC_FILT_CONTROL (offset 0x64, printed page 5-25, `Hi3516-Datasheet.txt` line 29384).";

        enum REC_FILT_CONTROL_crc_err_pass_enum {
            DISABLED = 0 { name = "Disabled"; desc = "disabled"; };
            ENABLED = 1 { name = "Enabled"; desc = "enabled"; };
        };

        field {
            name = "crc_err_pass";
            desc = "CRC error frame filter enable";
            sw = rw;
            hw = r;
            encode = REC_FILT_CONTROL_crc_err_pass_enum;
            reset = 0x0;
        } crc_err_pass[5:5];

        enum REC_FILT_CONTROL_pause_frm_pass_enum {
            DISABLED_THIS_BIT = 0 { name = "Disabled This Bit"; desc = "disabled. This bit takes effect only when flow control is enabled, which is transmitted to the software."; };
            ENABLED_THIS_BIT = 1 { name = "Enabled This Bit"; desc = "enabled. This bit takes effect only when flow control is enabled, which is not transmitted to the software."; };
        };

        field {
            name = "pause_frm_pass";
            desc = "Flow control frame filter enable";
            sw = rw;
            hw = r;
            encode = REC_FILT_CONTROL_pause_frm_pass_enum;
            reset = 0x0;
        } pause_frm_pass[4:4];

`ifndef HISI_GMAC_HI3516V100
        enum REC_FILT_CONTROL_vlan_drop_en_enum {
            DISABLED = 0 { name = "Disabled"; desc = "disabled"; };
            ENABLED = 1 { name = "Enabled"; desc = "enabled"; };
        };

        field {
            name = "vlan_drop_en";
            desc = "VLAN frame filter enable";
            sw = rw;
            hw = r;
            encode = REC_FILT_CONTROL_vlan_drop_en_enum;
            reset = 0x0;
        } vlan_drop_en[3:3];
`endif

        enum REC_FILT_CONTROL_bc_drop_en_enum {
            DISABLED = 0 { name = "Disabled"; desc = "disabled"; };
            ENABLED = 1 { name = "Enabled"; desc = "enabled"; };
        };

        field {
            name = "bc_drop_en";
            desc = "Broadcast frame filter enable";
            sw = rw;
            hw = r;
            encode = REC_FILT_CONTROL_bc_drop_en_enum;
            reset = 0x0;
        } bc_drop_en[2:2];

        enum REC_FILT_CONTROL_mc_match_en_enum {
            DISABLED = 0 { name = "Disabled"; desc = "disabled"; };
            ENABLED = 1 { name = "Enabled"; desc = "enabled"; };
        };

        field {
            name = "mc_match_en";
            desc = "Multicast frame enable with unmatched DA filter";
            sw = rw;
            hw = r;
            encode = REC_FILT_CONTROL_mc_match_en_enum;
            reset = 0x0;
        } mc_match_en[1:1];

        enum REC_FILT_CONTROL_uc_match_en_enum {
            DISABLED = 0 { name = "Disabled"; desc = "disabled"; };
            ENABLED = 1 { name = "Enabled"; desc = "enabled"; };
        };

        field {
            name = "uc_match_en";
            desc = "Unicast frame enable with unmatched DA filter";
            sw = rw;
            hw = r;
            encode = REC_FILT_CONTROL_uc_match_en_enum;
            reset = 0x0;
        } uc_match_en[0:0];
    } REC_FILT_CONTROL @ 0x64;

    reg {
        name = "Multicast address register";
        desc = "PORT_MC_ADDR_LOW is a multicast address register.

Data sheet 5.7 PORT_MC_ADDR_LOW (offset 0x68, printed page 5-26, `Hi3516AV200-Datasheet.txt` line 31204).
Hi3516 V100 data sheet (Chinese original) 5.6 PORT_MC_ADDR_LOW (offset 0x68, printed page 5-26, `Hi3516-Datasheet.txt` line 29440).";

        field {
            name = "port_mc_addr_low";
            desc = "Lower 32 bits of the multicast address, used to check whether the multicast frames match";
            sw = rw;
            hw = r;
            reset = 0x0;
        } port_mc_addr_low[31:0];
    } PORT_MC_ADDR_LOW @ 0x68;

    reg {
        name = "Multicast address register";
        desc = "PORT_MC_ADDR_HIGH is a multicast address register.

Data sheet 5.7 PORT_MC_ADDR_HIGH (offset 0x6C, printed page 5-26, `Hi3516AV200-Datasheet.txt` line 31225).
Hi3516 V100 data sheet (Chinese original) 5.6 PORT_MC_ADDR_HIGH (offset 0x6C, printed page 5-26, `Hi3516-Datasheet.txt` line 29459).";

        field {
            name = "port_mc_addr_high";
            desc = "Upper 16 bits of the multicast address, used to check whether the multicast frames match";
            sw = rw;
            hw = r;
            reset = 0x0;
        } port_mc_addr_high[15:0];
    } PORT_MC_ADDR_HIGH @ 0x6C;

    reg {
        name = "MAC clear register";
        desc = "MAC_CLR is a MAC clear register.

Reset bits of the MAC sub-blocks (the data sheet does not say whether they self-clear).

Data sheet 5.7 MAC_CLR (offset 0x70, printed page 5-27, `Hi3516AV200-Datasheet.txt` line 31251).
Hi3516 V100 data sheet (Chinese original) 5.6 MAC_CLR (offset 0x70, printed page 5-27, `Hi3516-Datasheet.txt` line 29488).";

        enum MAC_CLR_soft_rst_mdio_enum {
            INVALID = 0 { name = "Invalid"; desc = "invalid"; };
            VALID = 1 { name = "Valid"; desc = "valid"; };
        };

        field {
            name = "soft_rst_mdio";
            desc = "MDIO clear signal";
            sw = rw;
            hw = r;
            encode = MAC_CLR_soft_rst_mdio_enum;
            reset = 0x0;
        } soft_rst_mdio[3:3];

        enum MAC_CLR_soft_rst_mii_enum {
            INVALID = 0 { name = "Invalid"; desc = "invalid"; };
            VALID = 1 { name = "Valid"; desc = "valid"; };
        };

        field {
            name = "soft_rst_mii";
            desc = "MII clear signal";
            sw = rw;
            hw = r;
            encode = MAC_CLR_soft_rst_mii_enum;
            reset = 0x0;
        } soft_rst_mii[2:2];

        enum MAC_CLR_soft_rst_rx_enum {
            INVALID = 0 { name = "Invalid"; desc = "invalid"; };
            VALID = 1 { name = "Valid"; desc = "valid"; };
        };

        field {
            name = "soft_rst_rx";
            desc = "RX clear signal";
            sw = rw;
            hw = r;
            encode = MAC_CLR_soft_rst_rx_enum;
            reset = 0x0;
        } soft_rst_rx[1:1];

        enum MAC_CLR_soft_rst_tx_enum {
            INVALID = 0 { name = "Invalid"; desc = "invalid"; };
            VALID = 1 { name = "Valid"; desc = "valid"; };
        };

        field {
            name = "soft_rst_tx";
            desc = "TX clear signal";
            sw = rw;
            hw = r;
            encode = MAC_CLR_soft_rst_tx_enum;
            reset = 0x0;
        } soft_rst_tx[0:0];
    } MAC_CLR @ 0x70;

    reg {
        name = "Byte count register for valid RX frames";
        desc = "RX_OCTETS_OK_CNT is a byte count register for valid RX frames.

Data sheet 5.7 RX_OCTETS_OK_CNT (offset 0x80, printed page 5-27, `Hi3516AV200-Datasheet.txt` line 31289).
Hi3516 V100 data sheet (Chinese original) 5.6 RX_OCTETS_TOTAL_OK (offset 0x80, printed page 5-31, `Hi3516-Datasheet.txt` line 29776). The Hi3516 V100 data sheet names the field rx_octets_total_ok.";

        field {
            name = "rx_octets_ok_cnt";
            desc = "Count of bytes of the valid RX frames, ranging from DA to FCS";
            sw = r;
            hw = w;
            onread = rclr;
            reset = 0x0;
        } rx_octets_ok_cnt[31:0];
    } RX_OCTETS_OK_CNT @ 0x80;

    reg {
        name = "Byte count register for error RX frames";
        desc = "RX_OCTETS_BAD_CNT is a byte count register for error RX frames.

Data sheet 5.7 RX_OCTETS_BAD_CNT (offset 0x84, printed page 5-28, `Hi3516AV200-Datasheet.txt` line 31314).
Hi3516 V100 data sheet (Chinese original) 5.6 RX_OCTETS_BAD (offset 0x84, printed page 5-32, `Hi3516-Datasheet.txt` line 29803). The Hi3516 V100 data sheet names the field rx_octets_bad.";

        field {
            name = "rx_octets_bad_cnt";
            desc = "Count of bytes of the frames with CRC errors and alignment errors";
            sw = r;
            hw = w;
            onread = rclr;
            reset = 0x0;
        } rx_octets_bad_cnt[31:0];
    } RX_OCTETS_BAD_CNT @ 0x84;

    reg {
        name = "MAC frame count register for RX unicast frames";
        desc = "RX_UC_PKTS is a MAC frame count register for RX unicast frames.

Data sheet 5.7 RX_UC_PKTS (offset 0x88, printed page 5-28, `Hi3516AV200-Datasheet.txt` line 31333).
Hi3516 V100 data sheet (Chinese original) 5.6 RX_UC_PKTS (offset 0x88, printed page 5-32, `Hi3516-Datasheet.txt` line 29822). The Hi3516 V100 data sheet names the field rx_uc_pkts.";

        field {
            name = "rx_uc_pkts_cnt";
            desc = "Count of RX unicast frames, excluding bad frames";
            sw = r;
            hw = w;
            onread = rclr;
            reset = 0x0;
        } rx_uc_pkts_cnt[31:0];
    } RX_UC_PKTS @ 0x88;

    reg {
        name = "Frame count register for RX multicast frames";
        desc = "RX_MC_PKTS is a frame count register for RX multicast frames.

Data sheet 5.7 RX_MC_PKTS (offset 0x8C, printed page 5-28, `Hi3516AV200-Datasheet.txt` line 31351).
Hi3516 V100 data sheet (Chinese original) 5.6 RX_MC_PKTS (offset 0x8C, printed page 5-32, `Hi3516-Datasheet.txt` line 29841). The Hi3516 V100 data sheet names the field rx_mc_pkts.";

        field {
            name = "rx_mc_pkts_cnt";
            desc = "Count of RX multicast frames, excluding bad frames";
            sw = r;
            hw = w;
            onread = rclr;
            reset = 0x0;
        } rx_mc_pkts_cnt[31:0];
    } RX_MC_PKTS @ 0x8C;

    reg {
        name = "Frame count register for RX broadcast frames";
        desc = "RX_BC_PKTS is a frame count register for RX broadcast frames.

Data sheet 5.7 RX_BC_PKTS (offset 0x90, printed page 5-29, `Hi3516AV200-Datasheet.txt` line 31375).
Hi3516 V100 data sheet (Chinese original) 5.6 RX_BC_PKTS (offset 0x90, printed page 5-33, `Hi3516-Datasheet.txt` line 29868). The Hi3516 V100 data sheet names the field rx_bc_pkts.";

        field {
            name = "rx_bc_pkts_cnt";
            desc = "Count of RX broadcast frames, excluding bad frames";
            sw = r;
            hw = w;
            onread = rclr;
            reset = 0x0;
        } rx_bc_pkts_cnt[31:0];
    } RX_BC_PKTS @ 0x90;

    reg {
        name = "Frame count register for RX 64- byte frames";
        desc = "RX_PKTS_64OCTETS is a frame count register for RX 64-byte frames.

Data sheet 5.7 RX_PKTS_64OCTETS (offset 0x94, printed page 5-29, `Hi3516AV200-Datasheet.txt` line 31394).
Hi3516 V100 data sheet (Chinese original) 5.6 RX_PKTS_64OCTETS (offset 0x94, printed page 5-33, `Hi3516-Datasheet.txt` line 29887). The Hi3516 V100 data sheet names the field rx_pkts_64octets.";

        field {
            name = "rx_pks_64oct_cnt";
            desc = "Count of RX 64-byte frames, including bad frames";
            sw = r;
            hw = w;
            onread = rclr;
            reset = 0x0;
        } rx_pks_64oct_cnt[31:0];
    } RX_PKTS_64OCTETS @ 0x94;

    reg {
        name = "Frame count register for RX frames ETS ranging from 65 bytes to 127 bytes in length";
        desc = "RX_PKTS_65TO127OCTETS is a frame count register for RX frames ranging from 65 bytes to 127 bytes in length.

Data sheet 5.7 RX_PKTS_65TO127OCTETS (offset 0x98, printed page 5-29, `Hi3516AV200-Datasheet.txt` line 31414).
Hi3516 V100 data sheet (Chinese original) 5.6 RX_PKTS_65TO127OCTETS (offset 0x98, printed page 5-33, `Hi3516-Datasheet.txt` line 29906). The Hi3516 V100 data sheet names the field rx_pkts_65to127octets.";

        field {
            name = "rx_pks_65to127_oct_cnt";
            desc = "Count of RX frames ranging from 65 bytes to 127 bytes in length, including bad frames";
            sw = r;
            hw = w;
            onread = rclr;
            reset = 0x0;
        } rx_pks_65to127_oct_cnt[31:0];
    } RX_PKTS_65TO127OCTETS @ 0x98;

    reg {
        name = "Frame count register for RX frames TETS ranging from 128 bytes to 255 bytes in length";
        desc = "RX_PKTS_128TO255OCTETS is a frame count register for RX frames ranging from 128 bytes to 255 bytes in length.

Data sheet 5.7 RX_PKTS_128TO255OCTETS (offset 0x9C, printed page 5-30, `Hi3516AV200-Datasheet.txt` line 31441).
Hi3516 V100 data sheet (Chinese original) 5.6 RX_PKTS_128TO255OCTETS (offset 0x9C, printed page 5-34, `Hi3516-Datasheet.txt` line 29934). The Hi3516 V100 data sheet names the field rx_pkts_128to255octets.";

        field {
            name = "rx_pkts_128to255_oct_cnt";
            desc = "Count of RX frames ranging from 128 bytes to 255 bytes in length, including bad frames";
            sw = r;
            hw = w;
            onread = rclr;
            reset = 0x0;
        } rx_pkts_128to255_oct_cnt[31:0];
    } RX_PKTS_128TO255OCTETS @ 0x9C;

    reg {
        name = "Frame count register for RX frames TETS ranging from 256 bytes to 511 bytes in length";
        desc = "RX_PKTS_255TO511OCTETS is a frame count register for RX frames ranging from 256 bytes to 511 bytes in length.

Data sheet 5.7 RX_PKTS_255TO511OCTETS (offset 0xA0, printed page 5-30, `Hi3516AV200-Datasheet.txt` line 31463).
Hi3516 V100 data sheet (Chinese original) 5.6 RX_PKTS_255TO511OCTETS (offset 0xA0, printed page 5-34, `Hi3516-Datasheet.txt` line 29955). The Hi3516 V100 data sheet names the field rx_pkts_256to511octets.";

        field {
            name = "rx_pkts_256to511_oct_cnt";
            desc = "Count of RX frames ranging from 256 bytes to 511 bytes in length, including bad frames";
            sw = r;
            hw = w;
            onread = rclr;
            reset = 0x0;
        } rx_pkts_256to511_oct_cnt[31:0];
    } RX_PKTS_255TO511OCTETS @ 0xA0;

    reg {
        name = "Frame count register for RX frames TETS ranging from 512 bytes to 1023 bytes in length";
        desc = "RX_PKTS_512TO1023OCTETS is a frame count register for RX frames ranging from 512 bytes to 1023 bytes in length.

Data sheet 5.7 RX_PKTS_512TO1023OCTETS (offset 0xA4, printed page 5-31, `Hi3516AV200-Datasheet.txt` line 31494).
Hi3516 V100 data sheet (Chinese original) 5.6 RX_PKTS_512TO1023OCTETS (offset 0xA4, printed page 5-35, `Hi3516-Datasheet.txt` line 29986). The Hi3516 V100 data sheet names the field rx_pkts_512to1023octets.";

        field {
            name = "rx_pkts_512to1023_oct_cnt";
            desc = "Count of RX frames ranging from 512 bytes to 1023 bytes in length, including bad frames";
            sw = r;
            hw = w;
            onread = rclr;
            reset = 0x0;
        } rx_pkts_512to1023_oct_cnt[31:0];
    } RX_PKTS_512TO1023OCTETS @ 0xA4;

    reg {
        name = "Frame count register for RX frames CTETS ranging from 1024 bytes to 1518 bytes in length";
        desc = "RX_PKTS_1024TO1518OCTETS is a frame count register for RX frames ranging from 1024 bytes to 1518 bytes in length.

Data sheet 5.7 RX_PKTS_1024TO1518OCTETS (offset 0xA8, printed page 5-31, `Hi3516AV200-Datasheet.txt` line 31515).
Hi3516 V100 data sheet (Chinese original) 5.6 RX_PKTS_1024TO1518OCTETS (offset 0xA8, printed page 5-35, `Hi3516-Datasheet.txt` line 30007).";

        field {
            name = "rx_pkts_1024to151";
            desc = "Count of RX frames ranging from 1024 bytes to 1518 bytes in length, including bad frames";
            sw = r;
            hw = w;
            onread = rclr;
            reset = 0x0;
        } rx_pkts_1024to151[31:0];
    } RX_PKTS_1024TO1518OCTETS @ 0xA8;

    reg {
        name = "Frame count register for RX frames OCTETS ranging from 1519 bytes to the maximum in length";
        desc = "RX_PKTS_1519TOMAXOCTETS is a frame count register for RX frames ranging from 1519 bytes to the maximum in length.

Data sheet 5.7 RX_PKTS_1519TOMAXOCTETS (offset 0xAC, printed page 5-31, `Hi3516AV200-Datasheet.txt` line 31536).
Hi3516 V100 data sheet (Chinese original) 5.6 RX_PKTS_1519TOMAXOCTETS (offset 0xAC, printed page 5-35, `Hi3516-Datasheet.txt` line 30029). The Hi3516 V100 data sheet names the field rx_pkts_1519tomaxoctes.";

        field {
            name = "rx_pkts_1519tomax_oct_cnt";
            desc = "Count of RX frames ranging from 1519 bytes to the maximum in length, including bad frames";
            sw = r;
            hw = w;
            onread = rclr;
            reset = 0x0;
        } rx_pkts_1519tomax_oct_cnt[31:0];
    } RX_PKTS_1519TOMAXOCTETS @ 0xAC;

    reg {
        name = "Frame count register for RX frames with CRC errors";
        desc = "RX_FCS_ERRORS is a frame count register for RX frames with CRC errors.

Data sheet 5.7 RX_FCS_ERRORS (offset 0xB0, printed page 5-32, `Hi3516AV200-Datasheet.txt` line 31561).
Hi3516 V100 data sheet (Chinese original) 5.6 RX_FCS_ERRORS (offset 0xB0, printed page 5-36, `Hi3516-Datasheet.txt` line 30056).";

        field {
            name = "rx_fcs_errors";
            desc = "Count of RX frames with CRC errors, excluding short frames";
            sw = r;
            hw = w;
            onread = rclr;
            reset = 0x0;
        } rx_fcs_errors[31:0];
    } RX_FCS_ERRORS @ 0xB0;

    reg {
        name = "Frame count register for RX frames with tags";
        desc = "RX_TAGGED is a frame count register for RX frames with tags.

Data sheet 5.7 RX_TAGGED (offset 0xB4, printed page 5-32, `Hi3516AV200-Datasheet.txt` line 31580).
Hi3516 V100 data sheet (Chinese original) 5.6 RX_TAGGED (offset 0xB4, printed page 5-36, `Hi3516-Datasheet.txt` line 30075).";

        field {
            name = "rx_tagged";
            desc = "Count of RX frames with tags";
            sw = r;
            hw = w;
            onread = rclr;
            reset = 0x0;
        } rx_tagged[31:0];
    } RX_TAGGED @ 0xB4;

    reg {
        name = "Frame count register for RX frames with data errors";
        desc = "RX_DATA_ERR is a frame count register for RX frames with data errors.

Data sheet 5.7 RX_DATA_ERR (offset 0xB8, printed page 5-32, `Hi3516AV200-Datasheet.txt` line 31599).
Hi3516 V100 data sheet (Chinese original) 5.6 RX_DATA_ERR (offset 0xB8, printed page 5-36, `Hi3516-Datasheet.txt` line 30094).";

        field {
            name = "rx_data_err";
            desc = "Count of RX frames with data errors";
            sw = r;
            hw = w;
            onread = rclr;
            reset = 0x0;
        } rx_data_err[31:0];
    } RX_DATA_ERR @ 0xB8;

    reg {
        name = "Frame count register for RX frames with byte-alignment errors";
        desc = "RX_ALIGN_ERRORS is a frame count register for RX frames with byte-alignment errors.

Data sheet 5.7 RX_ALIGN_ERRORS (offset 0xBC, printed page 5-33, `Hi3516AV200-Datasheet.txt` line 31623).
Hi3516 V100 data sheet (Chinese original) 5.6 RX_ALIGN_ERRORS (offset 0xBC, printed page 5-37, `Hi3516-Datasheet.txt` line 30119).";

        field {
            name = "rx_align_errors";
            desc = "Count of RX frames with byte-alignment errors";
            sw = r;
            hw = w;
            onread = rclr;
            reset = 0x0;
        } rx_align_errors[31:0];
    } RX_ALIGN_ERRORS @ 0xBC;

    reg {
        name = "Frame count register for RX oversized frames";
        desc = "RX_LONG_ERRORS is a frame count register for RX oversized frames.

Data sheet 5.7 RX_LONG_ERRORS (offset 0xC0, printed page 5-33, `Hi3516AV200-Datasheet.txt` line 31642).
Hi3516 V100 data sheet (Chinese original) 5.6 RX_LONG_ERRORS (offset 0xC0, printed page 5-37, `Hi3516-Datasheet.txt` line 30138).";

        field {
            name = "rx_long_errors";
            desc = "Count of RX oversized frames (without CRC errors)";
            sw = r;
            hw = w;
            onread = rclr;
            reset = 0x0;
        } rx_long_errors[31:0];
    } RX_LONG_ERRORS @ 0xC0;

`ifndef HISI_GMAC_HI3516V100
    reg {
        name = "Frame count register for RX oversized frames";
        desc = "RX_JABBER_ERRORS is a frame count register for RX oversized frames.

Data sheet 5.7 RX_JABBER_ERRORS (offset 0xC4, printed page 5-33, `Hi3516AV200-Datasheet.txt` line 31661).";

        field {
            name = "rx_jabber_errors";
            desc = "Count of RX oversized frames with CRC errors or non-integer byte count";
            sw = r;
            hw = w;
            onread = rclr;
            reset = 0x0;
        } rx_jabber_errors[31:0];
    } RX_JABBER_ERRORS @ 0xC4;
`endif

    reg {
        name = "Frame count register for RX flow ROL_FRAMCOUNTER control frames";
        desc = "RX_PAUSE_MACCONTROL_FRAMCOUNTER is a frame count register for RX flow control frames.

Data sheet 5.7 RX_PAUSE_MACCONTROL_FRAMCOUNTER (offset 0xC8, printed page 5-34, `Hi3516AV200-Datasheet.txt` line 31690).";

        field {
            name = "rx_pause_maccontrol_framecounter";
            desc = "Count of RX flow control frames. The CRC must be correct when it is valid.";
            sw = r;
            hw = w;
            onread = rclr;
            reset = 0x0;
        } rx_pause_maccontrol_framecounter[31:0];
    } RX_PAUSE_MACCONTROL_FRAMCOUNTER @ 0xC8;

    reg {
        name = "Frame count register for RX non- ONTROL_FRAMCOUNT flow-control frames ER";
        desc = "RX_UNKNOWN_MACCONTROL_FRAMCOUNTER is a frame count register for RX non-flow-control frames.

Data sheet 5.7 RX_UNKNOWN_MACCONTROL_FRAMCOUNTER (offset 0xCC, printed page 5-34, `Hi3516AV200-Datasheet.txt` line 31715).";

        field {
            name = "rx_unknown_maccontrol_framecounter";
            desc = "Count of RX non-flow control frames";
            sw = r;
            hw = w;
            onread = rclr;
            reset = 0x0;
        } rx_unknown_maccontrol_framecounter[31:0];
    } RX_UNKNOWN_MACCONTROL_FRAMCOUNTER @ 0xCC;

    reg {
        name = "Frame count register for RX long CNT frames";
        desc = "RX_VERY_LONG_ERR_CNT is a frame count register for RX long frames.

Data sheet 5.7 RX_VERY_LONG_ERR_CNT (offset 0xD0, printed page 5-35, `Hi3516AV200-Datasheet.txt` line 31741).
Hi3516 V100 data sheet (Chinese original) 5.6 RX_VERY_LONG_ERR_CNT (offset 0xD0, printed page 5-38, `Hi3516-Datasheet.txt` line 30214).";

        field {
            name = "rx_very_long_err_cnt";
            desc = "Count of RX long frames (with the length more than twice the maximum frame length)";
            sw = r;
            hw = w;
            onread = rclr;
            reset = 0x0;
        } rx_very_long_err_cnt[31:0];
    } RX_VERY_LONG_ERR_CNT @ 0xD0;

    reg {
        name = "Frame count register for RX frames less than 64 bytes but greater than or equal to 12 bytes in length";
        desc = "RX_RUNT_ERR_CNT is a frame count register for RX frames less than 64 bytes but greater than or equal to 12 bytes in length.

Data sheet 5.7 RX_RUNT_ERR_CNT (offset 0xD4, printed page 5-35, `Hi3516AV200-Datasheet.txt` line 31763).
Hi3516 V100 data sheet (Chinese original) 5.6 RX_RUNT_ERR_CNT (offset 0xD4, printed page 5-39, `Hi3516-Datasheet.txt` line 30245).";

        field {
            name = "rx_runt_err_cnt";
            desc = "Count of RX frames less than 64 bytes but greater than or equal to 12 bytes in length";
            sw = r;
            hw = w;
            onread = rclr;
            reset = 0x0;
        } rx_runt_err_cnt[31:0];
    } RX_RUNT_ERR_CNT @ 0xD4;

    reg {
        name = "Frame count register for RX frames less than 96 bits in length";
        desc = "RX_SHORT_ERR_CNT is a frame count register for RX frames less than 12 bytes in length.

Data sheet 5.7 RX_SHORT_ERR_CNT (offset 0xD8, printed page 5-36, `Hi3516AV200-Datasheet.txt` line 31789).
Hi3516 V100 data sheet (Chinese original) 5.6 RX_SHORT_ERR_CNT (offset 0xD8, printed page 5-39, `Hi3516-Datasheet.txt` line 30264).";

        field {
            name = "rx_short_err_cnt";
            desc = "Count of RX frames less than 12 bytes in length.";
            sw = r;
            hw = w;
            onread = rclr;
            reset = 0x0;
        } rx_short_err_cnt[31:0];
    } RX_SHORT_ERR_CNT @ 0xD8;

    reg {
        name = "Byte count register for TX normal D_OK packets";
        desc = "OCTETS_TRANSMITTED_OK is a byte count register for TX normal packets.

Data sheet 5.7 OCTETS_TRANSMITTED_OK (offset 0x100, printed page 5-36, `Hi3516AV200-Datasheet.txt` line 31808).
Hi3516 V100 data sheet (Chinese original) 5.6 OCTETS_TRANSMITTED_OK (offset 0x100, printed page 5-39, `Hi3516-Datasheet.txt` line 30283).";

        field {
            name = "octets_transmitted_ok";
            desc = "Count of bytes of the transmitted normal packets, excluding the preambles and SFDs";
            sw = r;
            hw = w;
            onread = rclr;
            reset = 0x0;
        } octets_transmitted_ok[31:0];
    } OCTETS_TRANSMITTED_OK @ 0x100;

    reg {
        name = "Byte count register for TX bad D_BAD packets";
        desc = "OCTETS_TRANSMITTED_BAD is a byte count register for TX bad packets.

Data sheet 5.7 OCTETS_TRANSMITTED_BAD (offset 0x104, printed page 5-36, `Hi3516AV200-Datasheet.txt` line 31829).
Hi3516 V100 data sheet (Chinese original) 5.6 OCTETS_TRANSMITTED_BAD (offset 0x104, printed page 5-40, `Hi3516-Datasheet.txt` line 30312).";

        field {
            name = "octets_transmitted_bad";
            desc = "Count of bytes of the TX bad packets";
            sw = r;
            hw = w;
            onread = rclr;
            reset = 0x0;
        } octets_transmitted_bad[31:0];
    } OCTETS_TRANSMITTED_BAD @ 0x104;

    reg {
        name = "Frame count register for TX unicast frames";
        desc = "TX_UC_PKTS is a frame count register for TX unicast frames.

Data sheet 5.7 TX_UC_PKTS (offset 0x108, printed page 5-37, `Hi3516AV200-Datasheet.txt` line 31855).
Hi3516 V100 data sheet (Chinese original) 5.6 TX_UC_PKTS (offset 0x108, printed page 5-40, `Hi3516-Datasheet.txt` line 30333).";

        field {
            name = "tx_uc_pkts";
            desc = "Count of TX unicast frames, excluding bad packets";
            sw = r;
            hw = w;
            onread = rclr;
            reset = 0x0;
        } tx_uc_pkts[31:0];
    } TX_UC_PKTS @ 0x108;

    reg {
        name = "Frame count register for TX multicast frames";
        desc = "TX_MC_PKTS is a frame count register for TX multicast frames.

Data sheet 5.7 TX_MC_PKTS (offset 0x10C, printed page 5-37, `Hi3516AV200-Datasheet.txt` line 31874).
Hi3516 V100 data sheet (Chinese original) 5.6 TX_MC_PKTS (offset 0x10C, printed page 5-40, `Hi3516-Datasheet.txt` line 30352).";

        field {
            name = "tx_mc_pkts";
            desc = "Count of TX multicast frames, excluding bad packets";
            sw = r;
            hw = w;
            onread = rclr;
            reset = 0x0;
        } tx_mc_pkts[31:0];
    } TX_MC_PKTS @ 0x10C;

    reg {
        name = "Frame count register for TX broadcast frames";
        desc = "TX_BC_PKTS is a frame count register for TX broadcast frames.

Data sheet 5.7 TX_BC_PKTS (offset 0x110, printed page 5-37, `Hi3516AV200-Datasheet.txt` line 31893).
Hi3516 V100 data sheet (Chinese original) 5.6 TX_BC_PKTS (offset 0x110, printed page 5-41, `Hi3516-Datasheet.txt` line 30379).";

        field {
            name = "tx_bc_pkts";
            desc = "Count of TX broadcast frames, excluding bad packets";
            sw = r;
            hw = w;
            onread = rclr;
            reset = 0x0;
        } tx_bc_pkts[31:0];
    } TX_BC_PKTS @ 0x110;

    reg {
        name = "Frame count register for TX 64- byte frames";
        desc = "TX_PKTS_64OCTETS is a frame count register for TX 64-byte frames.

Data sheet 5.7 TX_PKTS_64OCTETS (offset 0x114, printed page 5-38, `Hi3516AV200-Datasheet.txt` line 31917).
Hi3516 V100 data sheet (Chinese original) 5.6 TX_PKTS_64OCTETS (offset 0x114, printed page 5-41, `Hi3516-Datasheet.txt` line 30398).";

        field {
            name = "tx_pkts_64octets";
            desc = "Count of TX 64-byte frames, including bad packets";
            sw = r;
            hw = w;
            onread = rclr;
            reset = 0x0;
        } tx_pkts_64octets[31:0];
    } TX_PKTS_64OCTETS @ 0x114;

    reg {
        name = "Frame count register for TX frames ETS ranging from 65 bytes to 127 bytes in length";
        desc = "TX_PKTS_65TO127OCTETS is a frame count register for TX frames ranging from 65 bytes to 127 bytes in length.

Data sheet 5.7 TX_PKTS_65TO127OCTETS (offset 0x118, printed page 5-38, `Hi3516AV200-Datasheet.txt` line 31937).
Hi3516 V100 data sheet (Chinese original) 5.6 TX_PKTS_65TO127OCTETS (offset 0x118, printed page 5-41, `Hi3516-Datasheet.txt` line 30417).";

        field {
            name = "tx_pkts_65to127octets";
            desc = "Count of TX frames ranging from 65 bytes to 127 bytes in length, including bad packets";
            sw = r;
            hw = w;
            onread = rclr;
            reset = 0x0;
        } tx_pkts_65to127octets[31:0];
    } TX_PKTS_65TO127OCTETS @ 0x118;

    reg {
        name = "Frame count register for TX frames ETS ranging from 128 bytes to 255 bytes in length";
        desc = "TX_PKTS_128TO255OCTETS is a frame count register for TX frames ranging from 128 bytes to 255 bytes in length.

Data sheet 5.7 TX_PKTS_128TO255OCTETS (offset 0x11C, printed page 5-39, `Hi3516AV200-Datasheet.txt` line 31963).
Hi3516 V100 data sheet (Chinese original) 5.6 TX_PKTS_128TO255OCTETS (offset 0x11C, printed page 5-42, `Hi3516-Datasheet.txt` line 30446).";

        field {
            name = "tx_pkts_128to255octets";
            desc = "Count of TX frames ranging from 128 bytes to 255 bytes in length, including bad packets";
            sw = r;
            hw = w;
            onread = rclr;
            reset = 0x0;
        } tx_pkts_128to255octets[31:0];
    } TX_PKTS_128TO255OCTETS @ 0x11C;

    reg {
        name = "Frame count register for TX frames ETS ranging from 256 bytes to 511 bytes in length";
        desc = "TX_PKTS_255TO511OCTETS is a frame count register for TX frames ranging from 256 bytes to 511 bytes in length.

Data sheet 5.7 TX_PKTS_255TO511OCTETS (offset 0x120, printed page 5-39, `Hi3516AV200-Datasheet.txt` line 31985).
Hi3516 V100 data sheet (Chinese original) 5.6 TX_PKTS_255TO511OCTETS (offset 0x120, printed page 5-42, `Hi3516-Datasheet.txt` line 30467).";

        field {
            name = "tx_pkts_256to511octets";
            desc = "Count of TX frames ranging from 256 bytes to 511 bytes in length, including bad packets";
            sw = r;
            hw = w;
            onread = rclr;
            reset = 0x0;
        } tx_pkts_256to511octets[31:0];
    } TX_PKTS_255TO511OCTETS @ 0x120;

    reg {
        name = "Frame count register for TX frames TETS ranging from 512 bytes to 1023 bytes in length";
        desc = "TX_PKTS_512TO1023OCTETS is a frame count register for TX frames ranging from 512 bytes to 1023 bytes in length.

Data sheet 5.7 TX_PKTS_512TO1023OCTETS (offset 0x124, printed page 5-40, `Hi3516AV200-Datasheet.txt` line 32012).
Hi3516 V100 data sheet (Chinese original) 5.6 TX_PKTS_512TO1023OCTETS (offset 0x124, printed page 5-42, `Hi3516-Datasheet.txt` line 30488).";

        field {
            name = "tx_pkts_512to1023octets";
            desc = "Count of TX frames ranging from 512 bytes to 1023 bytes in length, including bad packets";
            sw = r;
            hw = w;
            onread = rclr;
            reset = 0x0;
        } tx_pkts_512to1023octets[31:0];
    } TX_PKTS_512TO1023OCTETS @ 0x124;

    reg {
        name = "Frame count register for TX frames CTETS ranging from 1024 bytes to 1518 bytes in length";
        desc = "TX_PKTS_1024TO1518OCTETS is a frame count register for TX frames ranging from 1024 bytes to 1518 bytes in length.

Data sheet 5.7 TX_PKTS_1024TO1518OCTETS (offset 0x128, printed page 5-40, `Hi3516AV200-Datasheet.txt` line 32034).
Hi3516 V100 data sheet (Chinese original) 5.6 TX_PKTS_1024TO1518OCTETS (offset 0x128, printed page 5-43, `Hi3516-Datasheet.txt` line 30515).";

        field {
            name = "tx_pkts_1024to151";
            desc = "Count of TX frames ranging from 1024 bytes to 1518 bytes in length, including bad packets";
            sw = r;
            hw = w;
            onread = rclr;
            reset = 0x0;
        } tx_pkts_1024to151[31:0];
    } TX_PKTS_1024TO1518OCTETS @ 0x128;

    reg {
        name = "Frame count register for TX frames OCTETS greater than 1519 bytes in length";
        desc = "TX_PKTS_1519TOMAXOCTETS is a frame count register for TX frames greater than 1519 bytes in length.

Data sheet 5.7 TX_PKTS_1519TOMAXOCTETS (offset 0x12C, printed page 5-41, `Hi3516AV200-Datasheet.txt` line 32061).
Hi3516 V100 data sheet (Chinese original) 5.6 TX_PKTS_1519TOMAXOCTETS (offset 0x12C, printed page 5-43, `Hi3516-Datasheet.txt` line 30536).";

        field {
            name = "tx_pkts_1519tomaxoctes";
            desc = "Count of TX frames greater than 1519 bytes in length, including bad packets";
            sw = r;
            hw = w;
            onread = rclr;
            reset = 0x0;
        } tx_pkts_1519tomaxoctes[31:0];
    } TX_PKTS_1519TOMAXOCTETS @ 0x12C;

`ifndef HISI_GMAC_HI3516V100
    reg {
        name = "Count register for packets whose T number reaches the maximum retransmission number threshold";
        desc = "TX_EXC_COL_ERR_CNT is a count register for packets whose number reaches the maximum retransmission number threshold.

The data sheet marks this counter RW (all other statistics counters are RC, read-to-clear); modelled as read/write with hardware update.

Data sheet 5.7 TX_EXC_COL_ERR_CNT (offset 0x144, printed page 5-41, `Hi3516AV200-Datasheet.txt` line 32083).";

        field {
            name = "tx_exc_col_err_cnt";
            desc = "Count of packets whose number reaches the maximum retransmission number threshold";
            sw = rw;
            hw = w;
            reset = 0x0;
        } tx_exc_col_err_cnt[31:0];
    } TX_EXC_COL_ERR_CNT @ 0x144;
`endif

    reg {
        name = "Count register for transmission H_DROP failures caused by oversized frames";
        desc = "TX_EXCESSIVE_LENGTH_DROP is a count register for transmission failures caused by oversized frames.

Data sheet 5.7 TX_EXCESSIVE_LENGTH_DROP (offset 0x14C, printed page 5-42, `Hi3516AV200-Datasheet.txt` line 32110).
Hi3516 V100 data sheet (Chinese original) 5.6 TX_EXCESSIVE_LENGTH_DROP (offset 0x14C, printed page 5-44, `Hi3516-Datasheet.txt` line 30568).";

        field {
            name = "tx_excessive_length_drop";
            desc = "Count of transmission failures caused by oversized frames";
            sw = r;
            hw = w;
            onread = rclr;
            reset = 0x0;
        } tx_excessive_length_drop[31:0];
    } TX_EXCESSIVE_LENGTH_DROP @ 0x14C;

    reg {
        name = "Count register for transmission failures caused by internal errors";
        desc = "TX_UNDERRUN is a count register for transmission failures caused by internal errors.

Data sheet 5.7 TX_UNDERRUN (offset 0x150, printed page 5-42, `Hi3516AV200-Datasheet.txt` line 32131).
Hi3516 V100 data sheet (Chinese original) 5.6 TX_UNDERRUN (offset 0x150, printed page 5-44, `Hi3516-Datasheet.txt` line 30589).";

        field {
            name = "tx_underrun";
            desc = "Count of transmission failures caused by internal errors";
            sw = r;
            hw = w;
            onread = rclr;
            reset = 0x0;
        } tx_underrun[31:0];
    } TX_UNDERRUN @ 0x150;

`ifndef HISI_GMAC_HI3516V100
    reg {
        name = "Frame count register for TX VLAN frames";
        desc = "TX_TAGGED is a frame count register for TX VLAN frames.

Data sheet 5.7 TX_TAGGED (offset 0x154, printed page 5-43, `Hi3516AV200-Datasheet.txt` line 32154).";

        field {
            name = "tx_tagged";
            desc = "Count of TX VLAN frames The value of the Type field equals to that of the 0x8100 packet.";
            sw = r;
            hw = w;
            onread = rclr;
            reset = 0x0;
        } tx_tagged[31:0];
    } TX_TAGGED @ 0x154;
`endif

    reg {
        name = "Frame count register for TX frames with valid lengths and CRC errors";
        desc = "TX_CRC_ERROR is a frame count register for TX frames with valid lengths and CRC errors.

Data sheet 5.7 TX_CRC_ERROR (offset 0x158, printed page 5-43, `Hi3516AV200-Datasheet.txt` line 32175).
Hi3516 V100 data sheet (Chinese original) 5.6 TX_CRC_ERROR (offset 0x158, printed page 5-44, `Hi3516-Datasheet.txt` line 30608).";

        field {
            name = "tx_crc_error";
            desc = "Count of TX frames with valid lengths and CRC errors";
            sw = r;
            hw = w;
            onread = rclr;
            reset = 0x0;
        } tx_crc_error[31:0];
    } TX_CRC_ERROR @ 0x158;

    reg {
        name = "Frame count register for TX PAUSE frames";
        desc = "TX_PAUSE_FRAMES is a frame count register for TX PAUSE frames.

Data sheet 5.7 TX_PAUSE_FRAMES (offset 0x15C, printed page 5-43, `Hi3516AV200-Datasheet.txt` line 32193).
Hi3516 V100 data sheet (Chinese original) 5.6 TX_PAUSE_FRAMES (offset 0x15C, printed page 5-45, `Hi3516-Datasheet.txt` line 30635).";

        field {
            name = "tx_pause_frames";
            desc = "Count of TX PAUSE frames";
            sw = r;
            hw = w;
            onread = rclr;
            reset = 0x0;
        } tx_pause_frames[31:0];
    } TX_PAUSE_FRAMES @ 0x15C;

    reg {
        name = "Loopback register on the MAC line side";
        desc = "LINE_LOOP_BACK is a loopback register on the MAC line side.

Data sheet 5.7 LINE_LOOP_BACK (offset 0x1A8, printed page 5-44, `Hi3516AV200-Datasheet.txt` line 32217).
Hi3516 V100 data sheet (Chinese original) 5.6 LINE_LOOP_BACK (offset 0x1A8, printed page 5-28, `Hi3516-Datasheet.txt` line 29540).";

        enum LINE_LOOP_BACK_line_loop_back_enum {
            DISABLED = 0 { name = "Disabled"; desc = "disabled"; };
            ENABLED = 1 { name = "Enabled"; desc = "enabled"; };
        };

        field {
            name = "line_loop_back";
            desc = "MAC line-side loopback enable";
            sw = rw;
            hw = r;
            encode = LINE_LOOP_BACK_line_loop_back_enum;
            reset = 0x0;
        } line_loop_back[0:0];
    } LINE_LOOP_BACK @ 0x1A8;

    reg {
        name = "CRC strip enable register";
        desc = "CF_CRC_STRIP is a CRC strip enable register.

Linux defines the offset (0x1B0) only; the vendor U-Boot drivers define it and BIT_CF_CRC_STRIP (bit 0).

Data sheet 5.7 CF_CRC_STRIP (offset 0x1B0, printed page 5-44, `Hi3516AV200-Datasheet.txt` line 32246).
Hi3516 V100 data sheet (Chinese original) 5.6 CF_CRC_STRIP (offset 0x1B0, printed page 5-28, `Hi3516-Datasheet.txt` line 29570).";

        enum CF_CRC_STRIP_cf_crc_strip_enum {
            DISABLED_FOUR_BYTES = 0 { name = "Disabled Four Bytes"; desc = "disabled. The four bytes of the CRC are regarded as part of the packet."; };
            ENABLED_FOUR_BYTES = 1 { name = "Enabled Four Bytes"; desc = "enabled. The four bytes of the CRC are stripped from the packet."; };
        };

        field {
            name = "cf_crc_strip";
            desc = "RX CRC strip enable on the MAC side";
            sw = rw;
            hw = r;
            encode = CF_CRC_STRIP_cf_crc_strip_enum;
            reset = 0x1;
        } cf_crc_strip[0:0];
    } CF_CRC_STRIP @ 0x1B0;

    reg {
        name = "Port mode change enable register";
        desc = "MODE_CHANGE_EN is a port mode change enable register.

Linux/U-Boot: set to 1 before writing PORT_MODE and back to 0 afterwards (BIT_MODE_CHANGE_EN, bit 0).

Data sheet 5.7 MODE_CHANGE_EN (offset 0x1B4, printed page 5-45, `Hi3516AV200-Datasheet.txt` line 32282).
Hi3516 V100 data sheet (Chinese original) 5.6 MODE_CHANGE_EN (offset 0x1B4, printed page 5-29, `Hi3516-Datasheet.txt` line 29606).";

        enum MODE_CHANGE_EN_mode_change_en_enum {
            DISABLED = 0 { name = "Disabled"; desc = "disabled"; };
            ENABLED = 1 { name = "Enabled"; desc = "enabled"; };
        };

        field {
            name = "mode_change_en";
            desc = "port_mode change enable";
            sw = rw;
            hw = r;
            encode = MODE_CHANGE_EN_mode_change_en_enum;
            reset = 0x0;
        } mode_change_en[0:0];
    } MODE_CHANGE_EN @ 0x1B4;

`ifndef HISI_GMAC_HI3516V100
    reg {
        name = "Count register for half-duplex collision retransmission intervals";
        desc = "COL_SLOT_TIME is a count register for half-duplex collision retransmission intervals.

The data sheet joins the name and the description of the low field (cf2bc_random_seedRandom multiple radix ...). Linux hix5hd2_gmac.c writes 0 to this register at init. Not present on the Hi3516 V100.

Data sheet 5.7 COL_SLOT_TIME (offset 0x1C0, printed page 5-45, `Hi3516AV200-Datasheet.txt` line 32311).";

        field {
            name = "cf2bc_slottime";
            desc = "Interval for half-duplex collision retransmission";
            sw = rw;
            hw = r;
            reset = 0x40;
        } cf2bc_slottime[23:8];

        field {
            name = "cf2bc_random_seed";
            desc = "Random multiple radix for half-duplex collision retransmission";
            sw = rw;
            hw = r;
            reset = 0xFF;
        } cf2bc_random_seed[7:0];
    } COL_SLOT_TIME @ 0x1C0;
`endif

    reg {
        name = "Loopback supplement register";
        desc = "LOOP_REG is a loopback supplement register.

Data sheet 5.7 LOOP_REG (offset 0x1DC, printed page 5-46, `Hi3516AV200-Datasheet.txt` line 32337).
Hi3516 V100 data sheet (Chinese original) 5.6 LOOP_REG (offset 0x1DC, printed page 5-29, `Hi3516-Datasheet.txt` line 29636).";

        enum LOOP_REG_cf_ext_drive_lp_enum {
            FROM_MAC = 0 { name = "Generated in the MAC"; desc = "The read/write enable signals are generated in the MAC."; };
            FROM_FIFO = 1 { name = "From downlink FIFO"; desc = "The read/write enable signals are generated based on the MAC enable signals read by the downlink FIFO."; };
        };

        field {
            name = "cf_ext_drive_lp";
            desc = "Generation of the read/write enable signals of the MAC data during loopback on the line side";
            sw = rw;
            hw = r;
            encode = LOOP_REG_cf_ext_drive_lp_enum;
            reset = 0x1;
        } cf_ext_drive_lp[1:1];
    } LOOP_REG @ 0x1DC;

    reg {
        name = "RX control register";
        desc = "RECV_CONTROL is an RX control register.

Linux/U-Boot: BIT_STRIP_PAD_EN = bit 3, BIT_RUNT_PKT_EN = bit 4.

Data sheet 5.7 RECV_CONTROL (offset 0x1E0, printed page 5-46, `Hi3516AV200-Datasheet.txt` line 32369).
Hi3516 V100 data sheet (Chinese original) 5.6 RECV_CONTROL (offset 0x1E0, printed page 5-30, `Hi3516-Datasheet.txt` line 29674).";

        enum RECV_CONTROL_runt_pkt_en_enum {
            DISCARD = 0 { name = "Discard"; desc = "discarded and not transmitted to the software"; };
            PASS_TO_SOFTWARE = 1 { name = "Pass to software"; desc = "transmitted to the software"; };
        };

        field {
            name = "runt_pkt_en";
            desc = "Transparent transmission enable of the RX short frames";
            sw = rw;
            hw = r;
            encode = RECV_CONTROL_runt_pkt_en_enum;
            reset = 0x0;
        } runt_pkt_en[4:4];

        enum RECV_CONTROL_strip_pad_en_enum {
            DISABLED = 0 { name = "Disabled"; desc = "disabled"; };
            ENABLED = 1 { name = "Enabled"; desc = "enabled"; };
        };

        field {
            name = "strip_pad_en";
            desc = "PAD for stripping RX frames enable";
            sw = rw;
            hw = r;
            encode = RECV_CONTROL_strip_pad_en_enum;
            reset = 0x0;
        } strip_pad_en[3:3];
    } RECV_CONTROL @ 0x1E0;

`ifndef HISI_GMAC_HI3516V100
    reg {
        name = "VLAN code register";
        desc = "VLAN_CODE is a VLAN code register.

Data sheet 5.7 VLAN_CODE (offset 0x1E8, printed page 5-47, `Hi3516AV200-Datasheet.txt` line 32412).";

        field {
            name = "cf_vlan_code";
            desc = "Ethernet Type field configuration";
            sw = rw;
            hw = r;
            reset = 0x8100;
        } cf_vlan_code[15:0];
    } VLAN_CODE @ 0x1E8;
`endif

    reg {
        name = "FIFO overrun count register";
        desc = "RX_OVERRUN_CNT is a FIFO overrun count register.

Data sheet 5.7 RX_OVERRUN_CNT (offset 0x1EC, printed page 5-47, `Hi3516AV200-Datasheet.txt` line 32432).
Hi3516 V100 data sheet (Chinese original) 5.6 RX_OVERRUN_CNT (offset 0x1EC, printed page 5-30, `Hi3516-Datasheet.txt` line 29709).";

        field {
            name = "rx_overrun_cnt";
            desc = "Count of FIFO overruns on the MAC application side";
            sw = r;
            hw = w;
            onread = rclr;
            reset = 0x0;
        } rx_overrun_cnt[31:0];
    } RX_OVERRUN_CNT @ 0x1EC;

    reg {
        name = "Frame count register for RX frames R_CNT containing PADs";
        desc = "RX_LENGTHFIELD_ERR_CNT is a frame count register for RX frames containing PADs.

Data sheet 5.7 RX_LENGTHFIELD_ERR_CNT (offset 0x1F4, printed page 5-48, `Hi3516AV200-Datasheet.txt` line 32458).
Hi3516 V100 data sheet (Chinese original) 5.6 RX_LENGTHFIELD_ERR_CNT (offset 0x1F4, printed page 5-31, `Hi3516-Datasheet.txt` line 29734).";

        field {
            name = "rx_lengthfield_err_cnt";
            desc = "Count of RX frames containing PADs and with the length of not 64 bytes when the PAD strip enable is valid";
            sw = r;
            hw = w;
            onread = rclr;
            reset = 0x0;
        } rx_lengthfield_err_cnt[31:0];
    } RX_LENGTHFIELD_ERR_CNT @ 0x1F4;

    reg {
        name = "COMMA count register for byte delimitation";
        desc = "RX_FAIL_COMMA_CNT is a COMMA count register for byte delimitation.

Data sheet 5.7 RX_FAIL_COMMA_CNT (offset 0x1F8, printed page 5-48, `Hi3516AV200-Datasheet.txt` line 32478).
Hi3516 V100 data sheet (Chinese original) 5.6 RX_FAIL_COMMA_CNT (offset 0x1F8, printed page 5-31, `Hi3516-Datasheet.txt` line 29755).";

        field {
            name = "rx_fail_comma_cnt";
            desc = "Count of COMMA codes when two or more COMMA codes exist during byte delimitation";
            sw = r;
            hw = w;
            onread = rclr;
            reset = 0x0;
        } rx_fail_comma_cnt[31:0];
    } RX_FAIL_COMMA_CNT @ 0x1F8;

    reg {
        name = "Source MAC address register";
        desc = "MAC_SA_ADDR_L is a source MAC address register.

Data sheet 5.7 MAC_SA_ADDR_L (offset 0x200, printed page 5-48, `Hi3516AV200-Datasheet.txt` line 32498).
Hi3516 V100 data sheet (Chinese original) 5.6 MAC_SA_ADDR_L (offset 0x200, printed page 5-45, `Hi3516-Datasheet.txt` line 30654).";

        field {
            name = "mac_sa_addr_l";
            desc = "Lower 32 bits of the source MAC address used by the PMU, which are inserted into the lower 32 bits of the source address (SA) field";
            sw = rw;
            hw = r;
            reset = 0x0;
        } mac_sa_addr_l[31:0];
    } MAC_SA_ADDR_L @ 0x200;

    reg {
        name = "Source MAC address register";
        desc = "MAC_SA_ADDR_H is a source MAC address register.

Data sheet 5.7 MAC_SA_ADDR_H (offset 0x204, printed page 5-49, `Hi3516AV200-Datasheet.txt` line 32523).
Hi3516 V100 data sheet (Chinese original) 5.6 MAC_SA_ADDR_H (offset 0x204, printed page 5-45, `Hi3516-Datasheet.txt` line 30675).";

        field {
            name = "mac_sa_addr_h";
            desc = "Upper 16 bits of the source MAC address used by the PMU";
            sw = rw;
            hw = r;
            reset = 0x0;
        } mac_sa_addr_h[15:0];
    } MAC_SA_ADDR_H @ 0x204;

    reg {
        name = "Destination MAC address register";
        desc = "MAC_DA_ADDR_L is a destination MAC address register.

Data sheet 5.7 MAC_DA_ADDR_L (offset 0x208, printed page 5-49, `Hi3516AV200-Datasheet.txt` line 32543).
Hi3516 V100 data sheet (Chinese original) 5.6 MAC_DA_ADDR_L (offset 0x208, printed page 5-46, `Hi3516-Datasheet.txt` line 30702).";

        field {
            name = "mac_da_addr_l";
            desc = "Lower 32 bits of the destination MAC address used by the PMU, which are inserted into the lower 32 bits of the destination address field";
            sw = rw;
            hw = r;
            reset = 0x0;
        } mac_da_addr_l[31:0];
    } MAC_DA_ADDR_L @ 0x208;

    reg {
        name = "Destination MAC address register";
        desc = "MAC_DA_ADDR_H is a destination MAC address register.

The data sheet places crf_tx_max_packet (bits 26:16) in this register; the Hi3516 V100 data sheet has no such field.

Data sheet 5.7 MAC_DA_ADDR_H (offset 0x20C, printed page 5-49, `Hi3516AV200-Datasheet.txt` line 32563).
Hi3516 V100 data sheet (Chinese original) 5.6 MAC_DA_ADDR_H (offset 0x20C, printed page 5-46, `Hi3516-Datasheet.txt` line 30723).";

`ifndef HISI_GMAC_HI3516V100
        field {
            name = "crf_tx_max_packet";
            desc = "Maximum length of the normal and SG packets allowed by the PMU";
            sw = rw;
            hw = r;
            reset = 0x0;
        } crf_tx_max_packet[26:16];
`endif

        field {
            name = "mac_da_addr_h";
            desc = "Upper 16 bits of the destination MAC address used by the PMU";
            sw = rw;
            hw = r;
            reset = 0x0;
        } mac_da_addr_h[15:0];
    } MAC_DA_ADDR_H @ 0x20C;

    reg {
        name = "Minimum filter packet length register";
        desc = "CRF_MIN_PACKET is a minimum filter packet length register.

Vendor U-Boot: BIT_TSO_VERSION = MK_BITS(20, 12), i.e. bits 31:20. Not present on the Hi3516 V100 (reserved there).

Data sheet 5.7 CRF_MIN_PACKET (offset 0x210, printed page 5-50, `Hi3516AV200-Datasheet.txt` line 32595).
Hi3516 V100 data sheet (Chinese original) 5.6 CRF_MIN_PACKET (offset 0x210, printed page 5-47, `Hi3516-Datasheet.txt` line 30754).";

`ifndef HISI_GMAC_HI3516V100
        field {
            name = "tso_version";
            desc = "TSO version 100: single-byte combination version 200: SG or COE version 300: TSO version";
            sw = r;
            hw = w;
            reset = 0x0;
        } tso_version[31:20];
`endif

        field {
            name = "crf_tx_min_packet";
            desc = "Minimum length of the TX packet. The default length is 15 bytes.";
            sw = rw;
            hw = r;
            reset = 0xF;
        } crf_tx_min_packet[13:8];

        field {
            name = "crf_rx_min_packet";
            desc = "Minimum length of the RX packet. The default length is 42 bytes.";
            sw = rw;
            hw = r;
            reset = 0x2A;
        } crf_rx_min_packet[5:0];
    } CRF_MIN_PACKET @ 0x210;

    reg {
        name = "Control register";
        desc = "CONTROL_WORD is a control register.

Linux hix5hd2_gmac.c writes the plain maximum frame size (MAC_MAX_FRAME_SIZE = 1600) to the whole register at init. The reserved bits read 1 where shown by the data sheet total reset value; the set of such bits differs between the Hi3516A-class data sheets (bits 23:22) and the Hi3516 V100 (bits 30, 27, 26, 22).

Data sheet 5.7 CONTROL_WORD (offset 0x214, printed page 5-51, `Hi3516AV200-Datasheet.txt` line 32635).
Hi3516 V100 data sheet (Chinese original) 5.6 CONTROL_WORD (offset 0x214, printed page 5-47, `Hi3516-Datasheet.txt` line 30783).";

`ifdef HISI_GMAC_HI3516V100
        field {
            name = "reserved_nz";
            desc = "Reserved (RO); reads 1: the Hi3516 V100 data sheet total reset value is 0x4C40_0640 and its bit table shows bits 30, 27, 26 and 22 set (not read on hardware).";
            sw = r;
            hw = w;
            reset = 0x1;
        } reserved_nz[30:30];
`endif

`ifdef HISI_GMAC_HI3516V100
        field {
            name = "reserved_nz";
            desc = "Reserved (RO); reads 3 (see the bit 30 field; Hi3516 V100).";
            sw = r;
            hw = w;
            reset = 0x3;
        } reserved_nz_2[27:26];
`endif

        enum CONTROL_WORD_crf_tx_standard_enum {
            PACKET_AND_EMPTY_THRESHOLD = 0 { name = "Packet and empty threshold"; desc = "The standard is set based on the packet and empty threshold. If the TX FIFO contains a complete packet or the number of valid data items in the TX FIFO is equal to or greater than the threshold multiplied by 4, a read request is sent to the MAC."; };
            PACKET = 1 { name = "Packet"; desc = "The standard is set based on the packet. If the TX FIFO contains a complete packet, a read request is sent to the MAC."; };
        };

        field {
            name = "crf_tx_standard";
            desc = "Configuration standard for the transmit waterline of the TX FIFO";
            sw = rw;
            hw = r;
            encode = CONTROL_WORD_crf_tx_standard_enum;
            reset = 0x0;
        } crf_tx_standard[25:25];

`ifdef HISI_GMAC_HI3516V100
        field {
            name = "hrdy_sel";
            desc = "hrdy selection bit. 0: hreadym is selected (default); 1: hrdy is selected. (Hi3516 V100 data sheet, Chinese original; reserved on the later chips.)";
            sw = rw;
            hw = r;
            reset = 0x0;
        } hrdy_sel[24:24];
`endif

`ifndef HISI_GMAC_HI3516V100
        field {
            name = "reserved_nz";
            desc = "Reserved (RO); reads 3: the data sheet total reset value is 0x00C0_0640 (Hi3516A/AV200/Hi3519; the Hi3516 V100 has other bits set; not read on hardware).";
            sw = r;
            hw = w;
            reset = 0x3;
        } reserved_nz[23:22];
`endif

`ifdef HISI_GMAC_HI3516V100
        field {
            name = "reserved_nz";
            desc = "Reserved (RO); reads 1 (see the bit 30 field; Hi3516 V100).";
            sw = r;
            hw = w;
            reset = 0x1;
        } reserved_nz_3[22:22];
`endif

        enum CONTROL_WORD_crf_ip_flow_ctrl_enum {
            DISABLED = 0 { name = "Disabled"; desc = "disabled"; };
            ENABLED = 1 { name = "Enabled"; desc = "enabled"; };
        };

        field {
            name = "crf_ip_flow_ctrl";
            desc = "IP packet flow control enable";
            sw = rw;
            hw = r;
            encode = CONTROL_WORD_crf_ip_flow_ctrl_enum;
            reset = 0x0;
        } crf_ip_flow_ctrl[21:21];

        enum CONTROL_WORD_crf_ctrl_flow_ctrl_enum {
            DISABLED = 0 { name = "Disabled"; desc = "disabled"; };
            ENABLED = 1 { name = "Enabled"; desc = "enabled"; };
        };

        field {
            name = "crf_ctrl_flow_ctrl";
            desc = "Control packet flow control enable";
            sw = rw;
            hw = r;
            encode = CONTROL_WORD_crf_ctrl_flow_ctrl_enum;
            reset = 0x0;
        } crf_ctrl_flow_ctrl[20:20];

        enum CONTROL_WORD_crf_filt_unused_pkg_enum {
            DISABLED = 0 { name = "Disabled"; desc = "disabled"; };
            ENABLED = 1 { name = "Enabled"; desc = "enabled"; };
        };

        field {
            name = "crf_filt_unused_pkg";
            desc = "Invalid packets filter enable";
            sw = rw;
            hw = r;
            encode = CONTROL_WORD_crf_filt_unused_pkg_enum;
            reset = 0x0;
        } crf_filt_unused_pkg[17:17];

        enum CONTROL_WORD_crf_bm_flow_ctrl_enum {
            DISABLED = 0 { name = "Disabled"; desc = "disabled"; };
            ENABLED = 1 { name = "Enabled"; desc = "enabled"; };
        };

        field {
            name = "crf_bm_flow_ctrl";
            desc = "Multicast/broadcast packet flow control enable";
            sw = rw;
            hw = r;
            encode = CONTROL_WORD_crf_bm_flow_ctrl_enum;
            reset = 0x0;
        } crf_bm_flow_ctrl[16:16];

        enum CONTROL_WORD_crf_peel_dsa_enum {
            DISABLED = 0 { name = "Disabled"; desc = "disabled"; };
            ENABLED = 1 { name = "Enabled"; desc = "enabled"; };
        };

        field {
            name = "crf_peel_dsa";
            desc = "DA/SA stripping control enable";
            sw = rw;
            hw = r;
            encode = CONTROL_WORD_crf_peel_dsa_enum;
            reset = 0x0;
        } crf_peel_dsa[15:15];

        enum CONTROL_WORD_crf_add_da_sa_enum {
            DISABLED = 0 { name = "Disabled"; desc = "disabled"; };
            ENABLE_F = 1 { name = "Enable F"; desc = "enable"; };
        };

        field {
            name = "crf_add_da_sa";
            desc = "DA/SA addition control enable";
            sw = rw;
            hw = r;
            encode = CONTROL_WORD_crf_add_da_sa_enum;
            reset = 0x0;
        } crf_add_da_sa[14:14];

        field {
            name = "crf_large_packet";
            desc = "Maximum length configured for packets. The default length is 1600 bytes (maximum length of packets used by the PMU).";
            sw = rw;
            hw = r;
            reset = 0x640;
        } crf_large_packet[13:0];
    } CONTROL_WORD @ 0x214;

    reg {
        name = "Flow control packet count register SLD";
        desc = "FLOW_CTRL_PKG_THRSLD is a flow control packet number threshold register.

Data sheet 5.7 FLOW_CTRL_PKG_THRSLD (offset 0x218, printed page 5-52, `Hi3516AV200-Datasheet.txt` line 32703).
Hi3516 V100 data sheet (Chinese original) 5.6 FLOW_CTRL_PKG_THRSLD (offset 0x218, printed page 5-49, `Hi3516-Datasheet.txt` line 30876).";

        field {
            name = "crf_ip_pkg_thrsld";
            desc = "Upper threshold of the number of IP packets. When the number of IP packets that are received within period T exceeds the configured value, the flow is controlled. Otherwise, the flow is not controlled.";
            sw = rw;
            hw = r;
            reset = 0xFFFF;
        } crf_ip_pkg_thrsld[31:16];

        field {
            name = "crf_ctrl_pkg_thrsld";
            desc = "Upper threshold of the number of control packets. When the number of control packets that are received within period T exceeds the configured value, the flow is controlled. Otherwise, the flow is not controlled.";
            sw = rw;
            hw = r;
            reset = 0xFFFF;
        } crf_ctrl_pkg_thrsld[15:0];
    } FLOW_CTRL_PKG_THRSLD @ 0x218;

    reg {
        name = "Flow control time register SLD 0x00000220+ FILTER_LISTm (m Filter list register 4*m ranging from 0 to 15)";
        desc = "CRF_FLOW_TIME_THRSLD is a flow control time register.

Data sheet 5.7 CRF_FLOW_TIME_THRSLD (offset 0x21C, printed page 5-52, `Hi3516AV200-Datasheet.txt` line 32730).
Hi3516 V100 data sheet (Chinese original) 5.6 CRF_FLOW_TIME_THRSLD (offset 0x21C, printed page 5-49, `Hi3516-Datasheet.txt` line 30901).";

        field {
            name = "crf_flow_time_thrsld";
            desc = "Flow control time, measured by 125 µs Flow control time T = (crf_flow_time_thrsld + 1) x 125 µs";
            sw = rw;
            hw = r;
            reset = 0xFF;
        } crf_flow_time_thrsld[7:0];
    } CRF_FLOW_TIME_THRSLD @ 0x21C;

    reg {
        name = "FILTER_LISTm (m ranging from 0 to 15) is a filter list register";
        desc = "FILTER_LISTm (m ranging from 0 to 15) is a filter list register.

Sixteen registers at 0x220 + 4 x m (m = 0..15). The Hi3516 V100 data sheet prints them as sixteen separate registers FILTER_LIST0..FILTER_LIST15 (0x220..0x25C). The data sheet names the fields crf_filt_cfg0/crf_filt_id0/crf_filt_frm_type0 (the suffix 0 is dropped here, the description text uses the names without suffix).

Data sheet 5.7 FILTER_LISTm (offset 0x220, printed page 5-53, `Hi3516AV200-Datasheet.txt` line 32760).
Hi3516 V100 data sheet (Chinese original) 5.6 FILTER_LIST0..FILTER_LIST15 (offset 0x220, printed page 5-50, `Hi3516-Datasheet.txt` line 30934).";

        enum FILTER_LIST_crf_filt_cfg_enum {
            NOT_CONFIGURED = 0 { name = "Not configured"; desc = "not configured"; };
            CONFIGURED = 1 { name = "Configured"; desc = "configured; the content of this list needs to be parsed only when crf_filt_cfg is set to 1, otherwise it can be ignored"; };
        };

        field {
            name = "crf_filt_cfg";
            desc = "Configured row or not";
            sw = rw;
            hw = r;
            encode = FILTER_LIST_crf_filt_cfg_enum;
            reset = 0x0;
        } crf_filt_cfg[17:17];

        enum FILTER_LIST_crf_filt_id_enum {
            MAC_FRAME = 0 { name = "MAC frame"; desc = "MAC frame"; };
            IP = 1 { name = "IP"; desc = "IP"; };
        };

        field {
            name = "crf_filt_id";
            desc = "Type of the list";
            sw = rw;
            hw = r;
            encode = FILTER_LIST_crf_filt_id_enum;
            reset = 0x0;
        } crf_filt_id[16:16];

        field {
            name = "crf_filt_frm_type";
            desc = "Configured filter type When the ID is 0, 16 bits of crf_filt_frm_type are valid. When the ID is 1, the lower 8 bits of crf_filt_frm_type are valid, and the upper 8 bits are ignored.";
            sw = rw;
            hw = r;
            reset = 0x0;
        } crf_filt_frm_type[15:0];
    } FILTER_LIST[16] @ 0x220 += 0x4;

    reg {
        name = "UDP port number register";
        desc = "CRF_UDP_NO is a UDP port number register.

Data sheet 5.7 CRF_UDP_NO (offset 0x260, printed page 5-54, `Hi3516AV200-Datasheet.txt` line 32808).
Hi3516 V100 data sheet (Chinese original) 5.6 CRF_UDP_NO (offset 0x260, printed page 5-65, `Hi3516-Datasheet.txt` line 31726).";

        field {
            name = "crf_udp_max_no";
            desc = "Maximum number of the UDP ports";
            sw = rw;
            hw = r;
            reset = 0xFFFF;
        } crf_udp_max_no[31:16];
    } CRF_UDP_NO @ 0x260;

    reg {
        name = "TX FIFO threshold register";
        desc = "CRF_TX_FIFO_THRSLD is a TX FIFO threshold register.

The data sheet text of crf_tx_p_empty_th says \"quadruples crf_tx_p_full_th\" (copy-paste, it means crf_tx_p_empty_th) and \"FX FIFO\".

Data sheet 5.7 CRF_TX_FIFO_THRSLD (offset 0x264, printed page 5-54, `Hi3516AV200-Datasheet.txt` line 32827).
Hi3516 V100 data sheet (Chinese original) 5.6 CRF_TX_FIFO_THRSLD (offset 0x264, printed page 5-66, `Hi3516-Datasheet.txt` line 31755).";

        field {
            name = "crf_tx_p_full_th";
            desc = "Upper threshold of the TX FIFO When the number of valid data packets in the TX FIFO quadruples crf_tx_p_full_th, packets are not transferred from the SDRAM. After the threshold is set, the TX FIFO has sufficient space to receive a packet with the longest frame. The maximum frame length of the packet can be set in CONTROL_WORD bit[13:0] and must meet the following formula: CONTROL_WORD bit[13:0] < 8192 - 4(crf_tx_p_full_th)";
            sw = rw;
            hw = r;
            reset = 0x271;
        } crf_tx_p_full_th[26:16];

        field {
            name = "crf_tx_p_empty_th";
            desc = "Lower threshold of the TX FIFO When the number of valid data packets in the TX FIFO quadruples crf_tx_p_full_th, data can be read from the FX FIFO. It is recommended that this threshold be set to 0x14.";
            sw = rw;
            hw = r;
            reset = 0x17C;
        } crf_tx_p_empty_th[10:0];
    } CRF_TX_FIFO_THRSLD @ 0x264;

    reg {
        name = "RX FIFO threshold register";
        desc = "CRF_RX_FIFO_THRSLD is an RX FIFO threshold register.

Differs between data sheets: Hi3516A/AV200/Hi3519 crf_rx_p_full_th is 12 bits (27:16, reset 3600) and crf_rx_p_empty_th 12 bits (11:0); the Hi3516 V100 has 11-bit fields (26:16 reset 1600 and 10:0) and total reset 0x0640_0200 instead of 0x0E10_0200.

Data sheet 5.7 CRF_RX_FIFO_THRSLD (offset 0x268, printed page 5-55, `Hi3516AV200-Datasheet.txt` line 32868).
Hi3516 V100 data sheet (Chinese original) 5.6 CRF_RX_FIFO_THRSLD (offset 0x268, printed page 5-66, `Hi3516-Datasheet.txt` line 31790).";

`ifndef HISI_GMAC_HI3516V100
        field {
            name = "crf_rx_p_full_th";
            desc = "Upper threshold of the RX FIFO When the number of valid data packets in the RX FIFO quadruples crf_rx_p_full_th, new packets are not written to the RX FIFO. After the threshold is set, the RX FIFO has sufficient space to receive a packet with the longest frame. The maximum frame length of the packet can be set in CONTROL_WORD bit[13:0] and must meet the following formula: CONTROL_WORD[13:0] < (8192 - 4(crf_rx_p_full_th)";
            sw = rw;
            hw = r;
            reset = 0xE10;
        } crf_rx_p_full_th[27:16];
`endif

`ifdef HISI_GMAC_HI3516V100
        field {
            name = "crf_rx_p_full_th";
            desc = "Upper threshold of the RX FIFO (Hi3516 V100: 11 bits, default 1600). When the number of valid data items in the RX FIFO reaches 4 x crf_rx_p_full_th, no new packet is written to the RX FIFO. After the threshold is set, the RX FIFO must keep enough space for one packet of the maximum frame length (CONTROL_WORD[13:0]): CONTROL_WORD[13:0] < 8192 - 4 x crf_rx_p_full_th.";
            sw = rw;
            hw = r;
            reset = 0x640;
        } crf_rx_p_full_th[26:16];
`endif

`ifndef HISI_GMAC_HI3516V100
        field {
            name = "crf_rx_p_empty_th";
            desc = "Lower threshold of the RX FIFO. When the number of valid data packets in the RX FIFO quadruples crf_rx_p_empty_th, data can be read from the RX FIFO. This threshold must be set to 0x200 at least.";
            sw = rw;
            hw = r;
            reset = 0x200;
        } crf_rx_p_empty_th[11:0];
`endif

`ifdef HISI_GMAC_HI3516V100
        field {
            name = "crf_rx_p_empty_th";
            desc = "Lower threshold of the RX FIFO (Hi3516 V100: 11 bits). When the number of valid data items in the RX FIFO reaches 4 x crf_rx_p_empty_th, data can be read from the RX FIFO. The threshold must be set to 0x200 at least.";
            sw = rw;
            hw = r;
            reset = 0x200;
        } crf_rx_p_empty_th[10:0];
`endif
    } CRF_RX_FIFO_THRSLD @ 0x268;

`ifdef HISI_GMAC_HI3516V100
    reg {
        name = "Application-side loopback enable register";
        desc = "APP_LOOP_EN is the application-side loopback enable register. It is described in the data sheet but missing from its register summary table.

Hi3516 V100 data sheet (Chinese original) 5.6 APP_LOOP_EN (offset 0x27C, printed page 5-67, `Hi3516-Datasheet.txt` line 31833). Hi3516 V100 only (not in the Hi3516A, Hi3516A V200 and Hi3519 V101 data sheets).";

        field {
            name = "burst_sel";
            desc = "Burst selection for writing back descriptors. 1: write back with 4-beat bursts; 0: write back with 8-beat bursts.";
            sw = rw;
            hw = r;
            reset = 0x0;
        } burst_sel[8:8];

        field {
            name = "app_lp_en";
            desc = "Application-side loopback enable. 0xBC: enabled; any other value: not enabled.";
            sw = rw;
            hw = r;
            reset = 0x0;
        } app_lp_en[7:0];
    } APP_LOOP_EN @ 0x27C;
`endif

    reg {
        name = "Count register for dropped packets caused by the frame tailors marked as errors";
        desc = "ERR_GIVEN_PKG_CNT is a count register for dropped packets caused by the frame tailors marked as errors.

Data sheet 5.7 ERR_GIVEN_PKG_CNT (offset 0x280, printed page 5-55, `Hi3516AV200-Datasheet.txt` line 32901).
Hi3516 V100 data sheet (Chinese original) 5.6 ERR_GIVEN_PKG_CNT (offset 0x280, printed page 5-68, `Hi3516-Datasheet.txt` line 31876).";

        field {
            name = "err_given_pkg_cnt";
            desc = "Count of dropped packets caused by the frame tailors marked as errors";
            sw = r;
            hw = w;
            onread = rclr;
            reset = 0x0;
        } err_given_pkg_cnt[31:0];
    } ERR_GIVEN_PKG_CNT @ 0x280;

`ifndef HISI_GMAC_HI3516V100
    reg {
        name = "Short error packet count register";
        desc = "SHORT_ERR_PKT_CNT is a short error packet count register.

The data sheet marks this counter RW (read/write); modelled read/write with hardware update.

Data sheet 5.7 SHORT_ERR_PKT_CNT (offset 0x284, printed page 5-56, `Hi3516AV200-Datasheet.txt` line 32930).";

        field {
            name = "short_err_pkt_cnt";
            desc = "Count of short error packets";
            sw = rw;
            hw = w;
            reset = 0x0;
        } short_err_pkt_cnt[31:0];
    } SHORT_ERR_PKT_CNT @ 0x284;
`endif

    reg {
        name = "Count register for dropped packets caused by the frame types not listed in the filter list";
        desc = "ERR_FRM_TYPE_CNT is a count register for dropped packets caused by the frame types not listed in the filter list.

Data sheet 5.7 ERR_FRM_TYPE_CNT (offset 0x288, printed page 5-56, `Hi3516AV200-Datasheet.txt` line 32949).
Hi3516 V100 data sheet (Chinese original) 5.6 ERR_FRM_TYPE_CNT (offset 0x288, printed page 5-68, `Hi3516-Datasheet.txt` line 31895).";

        field {
            name = "err_frm_type_cnt";
            desc = "Count of dropped packets caused by the frame types not listed in the filter list";
            sw = r;
            hw = w;
            onread = rclr;
            reset = 0x0;
        } err_frm_type_cnt[31:0];
    } ERR_FRM_TYPE_CNT @ 0x288;

    reg {
        name = "Count register for dropped packets caused by the IP types not listed in the filter list";
        desc = "ERR_IP_TYPE_CNT is a count register for dropped packets caused by the IP types not listed in the filter list.

Data sheet 5.7 ERR_IP_TYPE_CNT (offset 0x28C, printed page 5-56, `Hi3516AV200-Datasheet.txt` line 32970).
Hi3516 V100 data sheet (Chinese original) 5.6 ERR_IP_TYPE_CNT (offset 0x28C, printed page 5-68, `Hi3516-Datasheet.txt` line 31914).";

        field {
            name = "err_ip_type_cnt";
            desc = "Count of the dropped packets caused by the IP types not listed in the filter list";
            sw = r;
            hw = w;
            onread = rclr;
            reset = 0x0;
        } err_ip_type_cnt[31:0];
    } ERR_IP_TYPE_CNT @ 0x28C;

    reg {
        name = "Count register for filtered packets caused by UDP port numbers beyond the specified range";
        desc = "ERR_UDP_CNT is a count register for filtered packets caused by UDP port numbers beyond the specified range.

Data sheet 5.7 ERR_UDP_CNT (offset 0x290, printed page 5-57, `Hi3516AV200-Datasheet.txt` line 32996).
Hi3516 V100 data sheet (Chinese original) 5.6 ERR_UDP_CNT (offset 0x290, printed page 5-69, `Hi3516-Datasheet.txt` line 31942).";

        field {
            name = "err_udp_cnt";
            desc = "Count of filtered packets caused by UDP port numbers beyond the specified range";
            sw = r;
            hw = w;
            onread = rclr;
            reset = 0x0;
        } err_udp_cnt[31:0];
    } ERR_UDP_CNT @ 0x290;

    reg {
        name = "Count register for dropped packets caused by the full RX FIFO";
        desc = "OVER_FLOW_CNT is a count register for dropped packets caused by the full RX FIFO.

Data sheet 5.7 OVER_FLOW_CNT (offset 0x294, printed page 5-57, `Hi3516AV200-Datasheet.txt` line 33017).
Hi3516 V100 data sheet (Chinese original) 5.6 OVER_FLOW_CNT (offset 0x294, printed page 5-69, `Hi3516-Datasheet.txt` line 31961).";

        field {
            name = "over_flow_cnt";
            desc = "Count of dropped packets caused by the full RX FIFO";
            sw = r;
            hw = w;
            onread = rclr;
            reset = 0x0;
        } over_flow_cnt[31:0];
    } OVER_FLOW_CNT @ 0x294;

    reg {
        name = "Count register for dropped packets whose sizes exceed the upper threshold of the PMU";
        desc = "OVER_LENGTH_CNT is a count register for dropped packets whose size exceeds the upper threshold of the PMU.

Data sheet 5.7 OVER_LENGTH_CNT (offset 0x298, printed page 5-57, `Hi3516AV200-Datasheet.txt` line 33036).
Hi3516 V100 data sheet (Chinese original) 5.6 OVER_LENGTH_CNT (offset 0x298, printed page 5-69, `Hi3516-Datasheet.txt` line 31980).";

        field {
            name = "over_length_cnt";
            desc = "Count of dropped packets whose size exceeds the upper threshold of the PMU";
            sw = r;
            hw = w;
            onread = rclr;
            reset = 0x0;
        } over_length_cnt[31:0];
    } OVER_LENGTH_CNT @ 0x298;

    reg {
        name = "Flow control frame enable register in the RX direction";
        desc = "RX_PAUSE_EN is a flow control frame enable register in the RX direction.

Data sheet 5.7 RX_PAUSE_EN (offset 0x2A4, printed page 5-58, `Hi3516AV200-Datasheet.txt` line 33059).
Hi3516 V100 data sheet (Chinese original) 5.6 RX_PAUSE_EN (offset 0x2A4, printed page 5-70, `Hi3516-Datasheet.txt` line 32008).";

        enum RX_PAUSE_EN_rx_fifo_pause_en_enum {
            DISABLED = 0 { name = "Disabled"; desc = "disabled"; };
            ENABLED = 1 { name = "Enabled"; desc = "enabled"; };
        };

        field {
            name = "rx_fifo_pause_en";
            desc = "rx_fifo flow control frame enable";
            sw = rw;
            hw = r;
            encode = RX_PAUSE_EN_rx_fifo_pause_en_enum;
            reset = 0x0;
        } rx_fifo_pause_en[2:2];

        enum RX_PAUSE_EN_rx_bq_pause_en_enum {
            DISABLED = 0 { name = "Disabled"; desc = "disabled"; };
            ENABLED = 1 { name = "Enabled"; desc = "enabled"; };
        };

        field {
            name = "rx_bq_pause_en";
            desc = "rx_bq flow control frame enable";
            sw = rw;
            hw = r;
            encode = RX_PAUSE_EN_rx_bq_pause_en_enum;
            reset = 0x0;
        } rx_bq_pause_en[1:1];

        enum RX_PAUSE_EN_rx_fq_pause_en_enum {
            DISABLED = 0 { name = "Disabled"; desc = "disabled"; };
            ENABLED = 1 { name = "Enabled"; desc = "enabled"; };
        };

        field {
            name = "rx_fq_pause_en";
            desc = "rx_fq flow control frame enable";
            sw = rw;
            hw = r;
            encode = RX_PAUSE_EN_rx_fq_pause_en_enum;
            reset = 0x0;
        } rx_fq_pause_en[0:0];
    } RX_PAUSE_EN @ 0x2A4;

    reg {
        name = "Configuration FIFO data count register";
        desc = "CRF_CFF_DATA_NUM is a configuration FIFO data count register.

Data sheet 5.7 CRF_CFF_DATA_NUM (offset 0x2A8, printed page 5-58, `Hi3516AV200-Datasheet.txt` line 33093).
Hi3516 V100 data sheet (Chinese original) 5.6 CRF_CFF_DATA_NUM (offset 0x2A8, printed page 5-70, `Hi3516-Datasheet.txt` line 32046).";

        field {
            name = "crf_rx_cfg_num";
            desc = "Count of valid descriptors remained in the rx_fq FIFO";
            sw = rw;
            hw = w;
            reset = 0x0;
        } crf_rx_cfg_num[31:16];

        field {
            name = "crf_tx_cfg_num";
            desc = "Count of valid descriptors remained in the tx_bq FIFO";
            sw = rw;
            hw = w;
            reset = 0x0;
        } crf_tx_cfg_num[15:0];
    } CRF_CFF_DATA_NUM @ 0x2A8;

    reg {
        name = "Count register for dropped IP packets caused by flow control";
        desc = "FLOW_OUT_IP_CNT is a count register for dropped IP packets caused by flow control.

Data sheet 5.7 FLOW_OUT_IP_CNT (offset 0x2AC, printed page 5-59, `Hi3516AV200-Datasheet.txt` line 33118).
Hi3516 V100 data sheet (Chinese original) 5.6 FLOW_OUT_IP_CNT (offset 0x2AC, printed page 5-71, `Hi3516-Datasheet.txt` line 32073).";

        field {
            name = "flow_out_ip_cnt";
            desc = "Count of dropped IP packets caused by flow control";
            sw = r;
            hw = w;
            onread = rclr;
            reset = 0x0;
        } flow_out_ip_cnt[31:0];
    } FLOW_OUT_IP_CNT @ 0x2AC;

    reg {
        name = "Count register for dropped control packets caused by flow control";
        desc = "FLOW_OUT_CTRL_CNT is a count register for dropped control packets caused by flow control.

Data sheet 5.7 FLOW_OUT_CTRL_CNT (offset 0x2B0, printed page 5-59, `Hi3516AV200-Datasheet.txt` line 33138).
Hi3516 V100 data sheet (Chinese original) 5.6 FLOW_OUT_CTRL_CNT (offset 0x2B0, printed page 5-71, `Hi3516-Datasheet.txt` line 32092).";

        field {
            name = "flow_out_ctrl_cnt";
            desc = "Count of dropped control packets caused by flow control";
            sw = r;
            hw = w;
            onread = rclr;
            reset = 0x0;
        } flow_out_ctrl_cnt[31:0];
    } FLOW_OUT_CTRL_CNT @ 0x2B0;

`ifdef HISI_GMAC_HI3516V100
    reg {
        name = "Counter of packets dropped because of IP header checksum errors";
        desc = "IP_CHK_ERR_CNT is counter of packets dropped because of IP header checksum errors.

Hi3516 V100 data sheet (Chinese original) 5.6 IP_CHK_ERR_CNT (offset 0x2B4, printed page 5-71, `Hi3516-Datasheet.txt` line 32111). Hi3516 V100 only (not in the Hi3516A, Hi3516A V200 and Hi3519 V101 data sheets).";

        field {
            name = "ip_chk_err_cnt";
            desc = "Count of packets dropped because of IP header checksum errors. (A received packet whose IP header is incomplete, or that has a header only and no payload, is also regarded as an IP header checksum error.)";
            sw = r;
            hw = w;
            onread = rclr;
            reset = 0x0;
        } ip_chk_err_cnt[31:0];
    } IP_CHK_ERR_CNT @ 0x2B4;
`endif

`ifdef HISI_GMAC_HI3516V100
    reg {
        name = "Counter of packets dropped because of UDP checksum errors";
        desc = "UDP_CHK_ERR_CNT is counter of packets dropped because of UDP checksum errors.

Hi3516 V100 data sheet (Chinese original) 5.6 UDP_CHK_ERR_CNT (offset 0x2B8, printed page 5-72, `Hi3516-Datasheet.txt` line 32138). Hi3516 V100 only (not in the Hi3516A, Hi3516A V200 and Hi3519 V101 data sheets).";

        field {
            name = "udp_chk_err_cnt";
            desc = "Count of packets dropped because of UDP checksum errors.";
            sw = r;
            hw = w;
            onread = rclr;
            reset = 0x0;
        } udp_chk_err_cnt[31:0];
    } UDP_CHK_ERR_CNT @ 0x2B8;
`endif

`ifdef HISI_GMAC_HI3516V100
    reg {
        name = "Counter of uplink packets dropped because the FIFO was full";
        desc = "TX_RUNT_ERR_PKG_CNT is counter of uplink packets dropped because the FIFO was full.

Hi3516 V100 data sheet (Chinese original) 5.6 TX_RUNT_ERR_PKG_CNT (offset 0x2BC, printed page 5-72, `Hi3516-Datasheet.txt` line 32157). Hi3516 V100 only (not in the Hi3516A, Hi3516A V200 and Hi3519 V101 data sheets).";

        field {
            name = "tx_runt_err_pkg_cnt";
            desc = "Count of uplink (TX) packets dropped because the FIFO was full.";
            sw = r;
            hw = w;
            onread = rclr;
            reset = 0x0;
        } tx_runt_err_pkg_cnt[31:0];
    } TX_RUNT_ERR_PKG_CNT @ 0x2BC;
`endif

`ifdef HISI_GMAC_HI3516V100
    reg {
        name = "Counter of the total number of dropped downlink packets";
        desc = "RX_ERR_TOTAL_CNT is counter of the total number of dropped downlink packets.

Hi3516 V100 data sheet (Chinese original) 5.6 RX_ERR_TOTAL_CNT (offset 0x2C0, printed page 5-72, `Hi3516-Datasheet.txt` line 32178). Hi3516 V100 only (not in the Hi3516A, Hi3516A V200 and Hi3519 V101 data sheets).";

        field {
            name = "rx_err_total_cnt";
            desc = "Total count of dropped downlink (RX) packets.";
            sw = r;
            hw = w;
            onread = rclr;
            reset = 0x0;
        } rx_err_total_cnt[31:0];
    } RX_ERR_TOTAL_CNT @ 0x2C0;
`endif

`ifdef HISI_GMAC_HI3516V100
    reg {
        name = "Counter of downlink packets moved successfully";
        desc = "RX_TRANS_PKG_CNT is counter of downlink packets moved successfully.

Hi3516 V100 data sheet (Chinese original) 5.6 RX_TRANS_PKG_CNT (offset 0x2C8, printed page 5-73, `Hi3516-Datasheet.txt` line 32203). Hi3516 V100 only (not in the Hi3516A, Hi3516A V200 and Hi3519 V101 data sheets).";

        field {
            name = "rx_trans_pkg_cnt";
            desc = "Count of downlink (RX) packets that were moved successfully.";
            sw = r;
            hw = w;
            onread = rclr;
            reset = 0x0;
        } rx_trans_pkg_cnt[31:0];
    } RX_TRANS_PKG_CNT @ 0x2C8;
`endif

`ifdef HISI_GMAC_HI3516V100
    reg {
        name = "Counter of uplink packets moved successfully";
        desc = "TX_TRANS_PKG_CNT is counter of uplink packets moved successfully.

Hi3516 V100 data sheet (Chinese original) 5.6 TX_TRANS_PKG_CNT (offset 0x2CC, printed page 5-73, `Hi3516-Datasheet.txt` line 32222). Hi3516 V100 only (not in the Hi3516A, Hi3516A V200 and Hi3519 V101 data sheets).";

        field {
            name = "tx_trans_pkg_cnt";
            desc = "Count of uplink (TX) packets that were moved successfully.";
            sw = r;
            hw = w;
            onread = rclr;
            reset = 0x0;
        } tx_trans_pkg_cnt[31:0];
    } TX_TRANS_PKG_CNT @ 0x2CC;
`endif

`ifdef HISI_GMAC_HI3516V100
    reg {
        name = "Counter of broadcast or multicast packets dropped by rate limiting";
        desc = "RX_BM_OVERFLOW is counter of broadcast or multicast packets dropped by rate limiting.

Hi3516 V100 data sheet (Chinese original) 5.6 RX_BM_OVERFLOW (offset 0x2D0, printed page 5-73, `Hi3516-Datasheet.txt` line 32241). Hi3516 V100 only (not in the Hi3516A, Hi3516A V200 and Hi3519 V101 data sheets).";

        field {
            name = "rx_bm_overflow";
            desc = "Count of broadcast or multicast packets dropped because of rate limiting. (This counter is indicative only, not exact.)";
            sw = r;
            hw = w;
            onread = rclr;
            reset = 0x0;
        } rx_bm_overflow[31:0];
    } RX_BM_OVERFLOW @ 0x2D0;
`endif

    reg {
        name = "TX flow control frame control register";
        desc = "CRF_TX_PAUSE is a TX flow control frame control register.

Data sheet 5.7 CRF_TX_PAUSE (offset 0x340, printed page 5-60, `Hi3516AV200-Datasheet.txt` line 33161).
Hi3516 V100 data sheet (Chinese original) 5.6 CRF_TX_PAUSE (offset 0x340, printed page 5-74, `Hi3516-Datasheet.txt` line 32268).";

        enum CRF_TX_PAUSE_crf_tx_pause_auto_enum {
            AUTOMATIC = 0 { name = "Automatic"; desc = "The MAC determines whether to transmit flow control frames according to the actual traffic. When the RX FIFO of the PMU is full or to be full, the MAC transmits flow control frames automatically."; };
            FORCED = 1 { name = "Forced"; desc = "The MAC is forced to transmit flow control frames."; };
        };

        field {
            name = "crf_tx_pause_auto";
            desc = "Flow control frame control register, specifying the way in which the MAC transmits flow control frames";
            sw = rw;
            hw = r;
            encode = CRF_TX_PAUSE_crf_tx_pause_auto_enum;
            reset = 0x0;
        } crf_tx_pause_auto[0:0];
    } CRF_TX_PAUSE @ 0x340;

`ifndef HISI_GMAC_HI3516V100
    reg {
        name = "Flow control RX address count register";
        desc = "CRF_RX_LEFT_NUM is a flow control RX address count register.

Named CRF_RX_ADDR_NUM on the Hi3516 V100 (see there).

Data sheet 5.7 CRF_RX_LEFT_NUM (offset 0x344, printed page 5-60, `Hi3516AV200-Datasheet.txt` line 33193).
Hi3516 V100 data sheet (Chinese original) 5.6 CRF_RX_ADDR_NUM (offset 0x344, printed page 5-74, `Hi3516-Datasheet.txt` line 32300).";

        field {
            name = "crf_rx_left_num";
            desc = "When the remaining count of addresses in the RX configuration FIFO is less than the configured value, the control packets are allowed to pass only. The data packets are filtered out.";
            sw = rw;
            hw = r;
            reset = 0xA;
        } crf_rx_left_num[7:0];
    } CRF_RX_LEFT_NUM @ 0x344;
`else
    reg {
        name = "Flow control RX address count register";
        desc = "CRF_RX_LEFT_NUM is a flow control RX address count register.

Same register as CRF_RX_LEFT_NUM of the other chips; only the name differs.

Hi3516 V100 data sheet (Chinese original) 5.6 CRF_RX_ADDR_NUM (offset 0x344, printed page 5-74, `Hi3516-Datasheet.txt` line 32300). The later data sheets (Hi3516A, AV200, Hi3519) call this register CRF_RX_LEFT_NUM and the field crf_rx_left_num.";

        field {
            name = "crf_rx_addr_num";
            desc = "When the remaining count of addresses in the RX configuration FIFO is less than the configured value, the control packets are allowed to pass only. The data packets are filtered out.";
            sw = rw;
            hw = r;
            reset = 0xA;
        } crf_rx_addr_num[7:0];
    } CRF_RX_ADDR_NUM @ 0x344;
`endif

    reg {
        name = "Control packet type 0 register";
        desc = "CRF_CTRL_0_TYPE is a control packet type 0 register.

The data sheet marks CRF_CTRL_0_TYPE..CRF_CTRL_2_TYPE as RO and CRF_CTRL_3_TYPE as RW; this is a data sheet typo (the Hi3516 V100 data sheet shows all four as RW, they are configuration registers) and all four are modelled as read/write.

Data sheet 5.7 CRF_CTRL_0_TYPE (offset 0x348, printed page 5-61, `Hi3516AV200-Datasheet.txt` line 33220).
Hi3516 V100 data sheet (Chinese original) 5.6 CRF_CTRL_0_TYPE (offset 0x348, printed page 5-75, `Hi3516-Datasheet.txt` line 32329).";

        field {
            name = "crf_ctrl_0_type";
            desc = "Control packet type 0. When the frame type of an RX packet matches the configured type, the RX packet is the control packet.";
            sw = rw;
            hw = r;
            reset = 0x0;
        } crf_ctrl_0_type[15:0];
    } CRF_CTRL_0_TYPE @ 0x348;

    reg {
        name = "Control packet type 1 register";
        desc = "CRF_CTRL_1_TYPE is a control packet type 1 register.

RO in the data sheet text; modelled read/write (see CRF_CTRL_0_TYPE).

Data sheet 5.7 CRF_CTRL_1_TYPE (offset 0x34C, printed page 5-61, `Hi3516AV200-Datasheet.txt` line 33242).
Hi3516 V100 data sheet (Chinese original) 5.6 CRF_CTRL_1_TYPE (offset 0x34C, printed page 5-75, `Hi3516-Datasheet.txt` line 32352).";

        field {
            name = "crf_ctrl_1_type";
            desc = "Control packet type 1. When the frame type of an RX packet matches the configured type, the RX packet is the control packet.";
            sw = rw;
            hw = r;
            reset = 0x0;
        } crf_ctrl_1_type[15:0];
    } CRF_CTRL_1_TYPE @ 0x34C;

    reg {
        name = "Control packet type 2 register";
        desc = "CRF_CTRL_2_TYPE is a control packet type 2 register.

RO in the data sheet text; modelled read/write (see CRF_CTRL_0_TYPE).

Data sheet 5.7 CRF_CTRL_2_TYPE (offset 0x350, printed page 5-62, `Hi3516AV200-Datasheet.txt` line 33272).
Hi3516 V100 data sheet (Chinese original) 5.6 CRF_CTRL_2_TYPE (offset 0x350, printed page 5-76, `Hi3516-Datasheet.txt` line 32385).";

        field {
            name = "crf_ctrl_2_type";
            desc = "Control packet type 2. When the frame type of an RX packet matches the configured type, the RX packet is the control packet.";
            sw = rw;
            hw = r;
            reset = 0x0;
        } crf_ctrl_2_type[15:0];
    } CRF_CTRL_2_TYPE @ 0x350;

    reg {
        name = "Control packet type 3 register";
        desc = "CRF_CTRL_3_TYPE is a control packet type 3 register.

Data sheet 5.7 CRF_CTRL_3_TYPE (offset 0x354, printed page 5-62, `Hi3516AV200-Datasheet.txt` line 33293).
Hi3516 V100 data sheet (Chinese original) 5.6 CRF_CTRL_3_TYPE (offset 0x354, printed page 5-76, `Hi3516-Datasheet.txt` line 32408).";

        field {
            name = "crf_ctrl_3_type";
            desc = "Control packet type 3. When the frame type of an RX packet matches the configured type, the RX packet is the control packet.";
            sw = rw;
            hw = r;
            reset = 0x0;
        } crf_ctrl_3_type[15:0];
    } CRF_CTRL_3_TYPE @ 0x354;

    reg {
        name = "Count threshold register for broadcast/multicast packets under flow control";
        desc = "CRF_BM_PKT_THRSLD is a count threshold register for broadcast/multicast packets under flow control.

Data sheet 5.7 CRF_BM_PKT_THRSLD (offset 0x358, printed page 5-62, `Hi3516AV200-Datasheet.txt` line 33315).
Hi3516 V100 data sheet (Chinese original) 5.6 CRF_BM_PKT_THRSLD (offset 0x358, printed page 5-76, `Hi3516-Datasheet.txt` line 32431).";

        field {
            name = "crf_bm_pkt_thrsld";
            desc = "Upper threshold of the number of broadcast/multicast packets under flow control. When the number of broadcast/multicast packets that are received during the flow control time exceeds the configured value, the flow is controlled; otherwise, the flow is not controlled.";
            sw = rw;
            hw = r;
            reset = 0x1;
        } crf_bm_pkt_thrsld[15:0];
    } CRF_BM_PKT_THRSLD @ 0x358;

    reg {
        name = "Flow control time threshold register D for broadcast and multicast packets";
        desc = "CRF_BM_TIME_THRSLD is a flow control time threshold register for broadcast and multicast packets.

Data sheet 5.7 CRF_BM_TIME_THRSLD (offset 0x35C, printed page 5-63, `Hi3516AV200-Datasheet.txt` line 33350).
Hi3516 V100 data sheet (Chinese original) 5.6 CRF_BM_TIME_THRSLD (offset 0x35C, printed page 5-77, `Hi3516-Datasheet.txt` line 32463).";

        field {
            name = "crf_bm_time_thrsld";
            desc = "Flow control time threshold for broadcast and multicast packets, measured by 1 µs. When the count equals the configured threshold, a time limit is reached.";
            sw = rw;
            hw = r;
            reset = 0x2710;
        } crf_bm_time_thrsld[19:0];
    } CRF_BM_TIME_THRSLD @ 0x35C;

    reg {
        name = "MDIO single operation register";
        desc = "MDIO_SINGLE_CMD is an MDIO single operation register.

Linux MDIO_START = bit 20, MDIO_READ = start | bit 17 (op_code 2), MDIO_WRITE = start | bit 16 (op_code 1); the PHY address goes into bits 12:8 (the data sheet text in 5.4.5 says bit[9:8] for the write sequence, a typo; the older vendor U-Boot higmac masks the PHY address with 0x3 only and cannot address PHYs above 3). mdio_cmd is set by software and cleared by the MDIO logic when the operation completes.

Data sheet 5.7 MDIO_SINGLE_CMD (offset 0x3C0, printed page 5-63, `Hi3516AV200-Datasheet.txt` line 33372).
Hi3516 V100 data sheet (Chinese original) 5.6 MDIO_SINGLE_CMD (offset 0x3C0, printed page 5-77, `Hi3516-Datasheet.txt` line 32486).";

        enum MDIO_SINGLE_CMD_mdio_cmd_enum {
            COMPLETE = 0 { name = "Complete"; desc = "The operation through the MDIO is complete."; };
            START = 1 { name = "Start"; desc = "The operation through the MDIO starts."; };
        };

        field {
            name = "mdio_cmd";
            desc = "Operation completion through the MDIO indicator";
            sw = rw;
            hw = w;
            encode = MDIO_SINGLE_CMD_mdio_cmd_enum;
            reset = 0x0;
        } mdio_cmd[20:20];

        enum MDIO_SINGLE_CMD_op_code_enum {
            RESERVED_0 = 0 { name = "Reserved"; desc = "Reserved"; };
            WRITE = 1 { name = "Write"; desc = "Write"; };
            READ = 2 { name = "Read"; desc = "Read"; };
            RESERVED_3 = 3 { name = "Reserved"; desc = "Reserved"; };
        };

        field {
            name = "op_code";
            desc = "MDIO operation type";
            sw = rw;
            hw = r;
            encode = MDIO_SINGLE_CMD_op_code_enum;
            reset = 0x0;
        } op_code[17:16];

        field {
            name = "phy_addr";
            desc = "5 bits of the external PHY address";
            sw = rw;
            hw = r;
            reset = 0x0;
        } phy_addr[12:8];

        field {
            name = "reg_addr";
            desc = "Internal address of the PHY component";
            sw = rw;
            hw = r;
            reset = 0x0;
        } reg_addr[4:0];
    } MDIO_SINGLE_CMD @ 0x3C0;

    reg {
        name = "MDIO read/write data register";
        desc = "MDIO_SINGLE_DATA is an MDIO read/write data register.

Linux reads the PHY register data from bits 31:16 after mdio_cmd returns to 0.

Data sheet 5.7 MDIO_SINGLE_DATA (offset 0x3C4, printed page 5-64, `Hi3516AV200-Datasheet.txt` line 33420).
Hi3516 V100 data sheet (Chinese original) 5.6 MDIO_SINGLE_DATA (offset 0x3C4, printed page 5-78, `Hi3516-Datasheet.txt` line 32540).";

        field {
            name = "mdio_rd_data";
            desc = "Data that is read back from the external PHY through the MDIO";
            sw = r;
            hw = w;
            reset = 0x0;
        } mdio_rd_data[31:16];

        field {
            name = "mdio_wr_data";
            desc = "Data that is written through the MDIO";
            sw = rw;
            hw = r;
            reset = 0x0;
        } mdio_wr_data[15:0];
    } MDIO_SINGLE_DATA @ 0x3C4;

`ifdef HISI_GMAC_HI3516V100
    reg {
        name = "MDIO automatic scan register";
        desc = "MDIO_SCAN_EN is mDIO automatic scan register.

Hi3516 V100 data sheet (Chinese original) 5.6 MDIO_SCAN_EN (offset 0x3C8, printed page 5-78, `Hi3516-Datasheet.txt` line 32561). Hi3516 V100 only (not in the Hi3516A, Hi3516A V200 and Hi3519 V101 data sheets).";

        field {
            name = "mdio_scan_en";
            desc = "Automatic scan enable for the PHY addresses, 1 = valid. (The note in the data sheet says the code was changed so that only one PHY can be attached.)";
            sw = rw;
            hw = r;
            reset = 0xF;
        } mdio_scan_en[3:0];
    } MDIO_SCAN_EN @ 0x3C8;
`endif

    reg {
        name = "MDIO control register";
        desc = "MDIO_CTL is an MDIO control register.

Data sheet 5.7 MDIO_CTL (offset 0x3CC, printed page 5-65, `Hi3516AV200-Datasheet.txt` line 33448).
Hi3516 V100 data sheet (Chinese original) 5.6 MDIO_CTL (offset 0x3CC, printed page 5-79, `Hi3516-Datasheet.txt` line 32591).";

        enum MDIO_CTL_mdio_in_work_enum {
            IDLE = 0 { name = "Idle"; desc = "The single operation is not performed."; };
            IN_PROGRESS = 1 { name = "In progress"; desc = "The single operation is performed."; };
        };

        field {
            name = "mdio_in_work";
            desc = "Single operation through the MDIO indicator";
            sw = r;
            hw = w;
            encode = MDIO_CTL_mdio_in_work_enum;
            reset = 0x0;
        } mdio_in_work[3:3];

        enum MDIO_CTL_mdio_in_work_en_enum {
            INVALID = 0 { name = "Invalid"; desc = "The MDIO_IN_WORK bit is invalid."; };
            VALID = 1 { name = "Valid"; desc = "The MDIO_IN_WORK bit is valid."; };
        };

        field {
            name = "mdio_in_work_en";
            desc = "MDIO_IN_WORK bit validity indicator";
            sw = rw;
            hw = r;
            encode = MDIO_CTL_mdio_in_work_en_enum;
            reset = 0x0;
        } mdio_in_work_en[2:2];

        enum MDIO_CTL_autoscan_en_enum {
            DISABLED = 0 { name = "Disabled"; desc = "disabled"; };
            ENABLED = 1 { name = "Enabled"; desc = "enabled (It controls the automatic scanning enable for all the PHY addresses. The value can be set to 1 because there is only one PHY currently.)"; };
        };

        field {
            name = "autoscan_en";
            desc = "Automatic detection enable";
            sw = rw;
            hw = r;
            encode = MDIO_CTL_autoscan_en_enum;
            reset = 0x0;
        } autoscan_en[1:1];

        enum MDIO_CTL_mdc_speed_enum {
            MDC_2_5_MHZ = 0 { name = "2.5 MHz"; desc = "The frequency of the MDIO interface clock is 2.5 MHz."; };
            MDC_18_MHZ = 1 { name = "18 MHz"; desc = "The frequency of the MDIO interface clock is 18 MHz."; };
        };

        field {
            name = "mdc_speed";
            desc = "Frequency of the MDIO interface clock";
            sw = rw;
            hw = r;
            encode = MDIO_CTL_mdc_speed_enum;
            reset = 0x0;
        } mdc_speed[0:0];
    } MDIO_CTL @ 0x3CC;

    reg {
        name = "MDIO read data status register";
        desc = "MDIO_RDATA_STATUS is an MDIO read data status register.

Linux (MDIO_R_VALID, bit 0 set = \"SMI bus read not valid\", an error) and the vendor U-Boot (test_mdio_read_data_done: status == 0) agree with the data sheet that 0 means valid read data.

Data sheet 5.7 MDIO_RDATA_STATUS (offset 0x3D0, printed page 5-66, `Hi3516AV200-Datasheet.txt` line 33493).
Hi3516 V100 data sheet (Chinese original) 5.6 MDIO_RDATA_STATUS (offset 0x3D0, printed page 5-80, `Hi3516-Datasheet.txt` line 32646).";

        enum MDIO_RDATA_STATUS_mdio_rdata_status_enum {
            VALID = 0 { name = "Valid"; desc = "valid"; };
            INVALID = 1 { name = "Invalid"; desc = "invalid"; };
        };

        field {
            name = "mdio_rdata_status";
            desc = "Whether the data read by the MDIO is valid";
            sw = r;
            hw = w;
            onread = rclr;
            encode = MDIO_RDATA_STATUS_mdio_rdata_status_enum;
            reset = 0x0;
        } mdio_rdata_status[0:0];
    } MDIO_RDATA_STATUS @ 0x3D0;

    reg {
        name = "Start address register for the idle descriptor queue";
        desc = "RX_FQ_START_ADDR is a start address register for the idle descriptor queue.

Queue registers RX_FQ (idle descriptor queue: software writes empty buffers, the MAC reads), RX_BQ (RX buffer queue: the MAC writes received-frame descriptors, software reads), TX_BQ (TX buffer queue: software writes, the MAC reads) and TX_RQ (TX recycle queue: the MAC writes completed descriptors, software reads) form four rings of 32-byte descriptors in DDR; Linux hix5hd2_gmac.c programs all of them with the same offsets (0x500..0x5BC).

Data sheet 5.7 RX_FQ_START_ADDR (offset 0x500, printed page 5-66, `Hi3516AV200-Datasheet.txt` line 33522).
Hi3516 V100 data sheet (Chinese original) 5.6 RX_FQ_START_ADDR (offset 0x500, printed page 5-80, `Hi3516-Datasheet.txt` line 32676).";

        field {
            name = "fq_start_addr";
            desc = "Start address of the idle descriptor queue. When rx_fq_start_addr_en of the RX_FQ_REG_EN register is set to 1, the register can be read and written. When rx_fq_start_addr_en is set to 0, the register is read-only. Only word addresses are supported.";
            sw = rw;
            hw = r;
            reset = 0x0;
        } fq_start_addr[31:0];
    } RX_FQ_START_ADDR @ 0x500;

    reg {
        name = "Depth register for the idle descriptor queue";
        desc = "RX_FQ_DEPTH is a depth register for the idle descriptor queue.

Data sheet 5.7 RX_FQ_DEPTH (offset 0x504, printed page 5-67, `Hi3516AV200-Datasheet.txt` line 33553).
Hi3516 V100 data sheet (Chinese original) 5.6 RX_FQ_DEPTH (offset 0x504, printed page 5-81, `Hi3516-Datasheet.txt` line 32709).";

        field {
            name = "fq_depth";
            desc = "Depth of the idle descriptor queue in the RX direction. It indicates the number of words, not the number of descriptors. When rx_fq_depth_en of the RX_FQ_REG_EN register is set to 1, the register can be read and written. When rx_fq_depth_en is set to 0, the register is read-only. The depth must be set to an integral multiple of 8. It is recommended that this field be set to at least 0x400.";
            sw = rw;
            hw = r;
            reset = 0x400;
        } fq_depth[18:0];
    } RX_FQ_DEPTH @ 0x504;

    reg {
        name = "Write address register for the idle descriptor queue";
        desc = "RX_FQ_WR_ADDR is a write address register for the idle descriptor queue.

Data sheet 5.7 RX_FQ_WR_ADDR (offset 0x508, printed page 5-67, `Hi3516AV200-Datasheet.txt` line 33578).
Hi3516 V100 data sheet (Chinese original) 5.6 RX_FQ_WR_ADDR (offset 0x508, printed page 5-81, `Hi3516-Datasheet.txt` line 32734).";

        field {
            name = "fq_wr_addr";
            desc = "Write address of the idle descriptor queue in the RX direction.";
            sw = rw;
            hw = r;
            reset = 0x0;
        } fq_wr_addr[20:0];
    } RX_FQ_WR_ADDR @ 0x508;

    reg {
        name = "Read address register for the idle descriptor queue";
        desc = "RX_FQ_RD_ADDR is a read address register for the idle descriptor queue.

The data sheet text says RX_FQ_WR_ADDR in the introduction of this register (copy-paste typo).

Data sheet 5.7 RX_FQ_RD_ADDR (offset 0x50C, printed page 5-68, `Hi3516AV200-Datasheet.txt` line 33602).
Hi3516 V100 data sheet (Chinese original) 5.6 RX_FQ_RD_ADDR (offset 0x50C, printed page 5-82, `Hi3516-Datasheet.txt` line 32765).";

        field {
            name = "fq_rd_addr";
            desc = "Read address of the idle descriptor queue in the RX direction. When rx_fq_rd_addr_en of the RX_FQ_REG_EN register is set to 1, the register can be read and written. When rx_fq_rd_addr_en is set to 0, the register is read-only.";
            sw = rw;
            hw = w;
            reset = 0x0;
        } fq_rd_addr[20:0];
    } RX_FQ_RD_ADDR @ 0x50C;

    reg {
        name = "Valid descriptor number register for the idle descriptor queue";
        desc = "RX_FQ_VLDDESC_CNT is a valid descriptor number register for the idle descriptor queue.

Data sheet 5.7 RX_FQ_VLDDESC_CNT (offset 0x510, printed page 5-68, `Hi3516AV200-Datasheet.txt` line 33626).
Hi3516 V100 data sheet (Chinese original) 5.6 RX_FQ_VLDDESC_CNT (offset 0x510, printed page 5-82, `Hi3516-Datasheet.txt` line 32788).";

        field {
            name = "fq_vlddesc_cnt";
            desc = "Count of valid descriptors in the idle descriptor queue in the RX direction";
            sw = r;
            hw = w;
            reset = 0x0;
        } fq_vlddesc_cnt[15:0];
    } RX_FQ_VLDDESC_CNT @ 0x510;

    reg {
        name = "Almost-empty threshold register for the idle descriptor queue";
        desc = "RX_FQ_ALRMPTY_TH is an almost-empty threshold register for the idle descriptor queue.

The data sheet spells the register name RX_FQ_ALRMPTY_TH; the Linux/U-Boot drivers (and the sibling RX_BQ/TX_BQ/TX_RQ registers) use ALEMPTY, so the name RX_FQ_ALEMPTY_TH is used here.

Data sheet 5.7 RX_FQ_ALRMPTY_TH (offset 0x514, printed page 5-69, `Hi3516AV200-Datasheet.txt` line 33653).
Hi3516 V100 data sheet (Chinese original) 5.6 RX_FQ_ALRMPTY_TH (offset 0x514, printed page 5-82, `Hi3516-Datasheet.txt` line 32809).";

        field {
            name = "fq_pause_low_th";
            desc = "Lower flow control threshold of the rx_fq queue. If the count of valid descriptors is less than or equal to the value of fq_pause_low_th, a signal for sending flow control frames is generated.";
            sw = rw;
            hw = r;
            reset = 0x10;
        } fq_pause_low_th[31:16];

        field {
            name = "fq_alempty_th";
            desc = "Almost-empty threshold of the idle descriptor queue in the RX direction";
            sw = rw;
            hw = r;
            reset = 0x10;
        } fq_alempty_th[15:0];
    } RX_FQ_ALEMPTY_TH @ 0x514;

    reg {
        name = "Enable register related to idle descriptor queue in the RX direction";
        desc = "RX_FQ_REG_EN is an enable register related to the idle descriptor queue in the RX direction.

Data sheet 5.7 RX_FQ_REG_EN (offset 0x518, printed page 5-69, `Hi3516AV200-Datasheet.txt` line 33678).
Hi3516 V100 data sheet (Chinese original) 5.6 RX_FQ_REG_EN (offset 0x518, printed page 5-83, `Hi3516-Datasheet.txt` line 32840).";

        enum RX_FQ_REG_EN_rx_fq_start_addr_en_enum {
            WRITE_PROTECTED = 0 { name = "Write protected"; desc = "The RX_FQ_START_ADDR register is protected, and software cannot be written."; };
            WRITABLE = 1 { name = "Writable"; desc = "Software of the RX_FQ_START_ADDR register can be written."; };
        };

        field {
            name = "rx_fq_start_addr_en";
            desc = "Software write enable for the RX_FQ_START_ADDR register";
            sw = rw;
            hw = r;
            encode = RX_FQ_REG_EN_rx_fq_start_addr_en_enum;
            reset = 0x0;
        } rx_fq_start_addr_en[2:2];

        enum RX_FQ_REG_EN_rx_fq_depth_en_enum {
            WRITE_PROTECTED = 0 { name = "Write protected"; desc = "The RX_FQ_DEPTH register is protected, and software cannot be written."; };
            WRITABLE = 1 { name = "Writable"; desc = "Software of the RX_FQ_DEPTH register can be written."; };
        };

        field {
            name = "rx_fq_depth_en";
            desc = "Software write enable for the RX_FQ_DEPTH register";
            sw = rw;
            hw = r;
            encode = RX_FQ_REG_EN_rx_fq_depth_en_enum;
            reset = 0x0;
        } rx_fq_depth_en[1:1];

        enum RX_FQ_REG_EN_rx_fq_rd_addr_en_enum {
            WRITE_PROTECTED = 0 { name = "Write protected"; desc = "The RX_FQ read address register is protected, and software cannot be written."; };
            WRITABLE = 1 { name = "Writable"; desc = "Software of the RX_FQ read address register can be written."; };
        };

        field {
            name = "rx_fq_rd_addr_en";
            desc = "Software write enable for the RX_FQ read address register";
            sw = rw;
            hw = r;
            encode = RX_FQ_REG_EN_rx_fq_rd_addr_en_enum;
            reset = 0x0;
        } rx_fq_rd_addr_en[0:0];
    } RX_FQ_REG_EN @ 0x518;

    reg {
        name = "Almost-full threshold register for the idle descriptor queue";
        desc = "RX_FQ_ALFULL_TH is an almost-full threshold register for the idle descriptor queue.

Data sheet 5.7 RX_FQ_ALFULL_TH (offset 0x51C, printed page 5-70, `Hi3516AV200-Datasheet.txt` line 33731).
Hi3516 V100 data sheet (Chinese original) 5.6 RX_FQ_ALFULL_TH (offset 0x51C, printed page 5-84, `Hi3516-Datasheet.txt` line 32890).";

        field {
            name = "fq_pause_hi_th";
            desc = "Upper flow control threshold for the rx_fq queue. If the count of valid descriptors is greater than or equal to the value of fq_pause_hi_th, a signal for sending flow control frames is set to 0, indicating that the flow control frames are not transmitted.";
            sw = rw;
            hw = r;
            reset = 0x10;
        } fq_pause_hi_th[31:16];

        field {
            name = "fq_alfull_th";
            desc = "Almost-full threshold of the idle descriptor queue in the RX direction";
            sw = rw;
            hw = r;
            reset = 0x10;
        } fq_alfull_th[15:0];
    } RX_FQ_ALFULL_TH @ 0x51C;

    reg {
        name = "Start address register for the rx_buff descriptor queue";
        desc = "RX_BQ_START_ADDR is a start address register for the rx_buff descriptor queue.

Data sheet 5.7 RX_BQ_START_ADDR (offset 0x520, printed page 5-71, `Hi3516AV200-Datasheet.txt` line 33765).
Hi3516 V100 data sheet (Chinese original) 5.6 RX_BQ_START_ADDR (offset 0x520, printed page 5-84, `Hi3516-Datasheet.txt` line 32913).";

        field {
            name = "rx_bq_start_addr";
            desc = "Start address of the buff descriptor queue in the RX direction. When rx_bq_start_addr_en in the RX_BQ_REG_EN register is set to 1, the register can be read and written. When rx_bq_start_addr_en is set to 0, the register is read-only. Only word addresses are supported.";
            sw = rw;
            hw = r;
            reset = 0x0;
        } rx_bq_start_addr[31:0];
    } RX_BQ_START_ADDR @ 0x520;

    reg {
        name = "Depth register for the rx_buff descriptor queue";
        desc = "RX_BQ_DEPTH is a depth register for the rx_buff descriptor queue.

Data sheet 5.7 RX_BQ_DEPTH (offset 0x524, printed page 5-71, `Hi3516AV200-Datasheet.txt` line 33787).
Hi3516 V100 data sheet (Chinese original) 5.6 RX_BQ_DEPTH (offset 0x524, printed page 5-84, `Hi3516-Datasheet.txt` line 32934).";

        field {
            name = "rx_bq_depth";
            desc = "Depth of the buff descriptor queue in the RX direction. It indicates the number of words, not the number of descriptors. When rx_bq_depth_en of the RX_BQ_REG_EN register is set to 1, the register can be read and written. When rx_bq_depth_en is set to 0, the register is read-only. The depth must be set to an integral multiple of 8. It is recommended that this field be set to at least 0x400.";
            sw = rw;
            hw = r;
            reset = 0x400;
        } rx_bq_depth[18:0];
    } RX_BQ_DEPTH @ 0x524;

    reg {
        name = "Write address register for the rx_buff descriptor queue";
        desc = "RX_BQ_WR_ADDR is a write address register for the rx_buff descriptor queue.

Data sheet 5.7 RX_BQ_WR_ADDR (offset 0x528, printed page 5-72, `Hi3516AV200-Datasheet.txt` line 33818).
Hi3516 V100 data sheet (Chinese original) 5.6 RX_BQ_WR_ADDR (offset 0x528, printed page 5-85, `Hi3516-Datasheet.txt` line 32967).";

        field {
            name = "rx_bq_wr_addr";
            desc = "Write address of the buff descriptor queue in the RX direction. When rx_bq_wr_addr_en of the RX_BQ_REG_EN register is set to 1, the register can be read and written. When rx_bq_wr_addr_en is set to 0, the register is read-only.";
            sw = rw;
            hw = w;
            reset = 0x0;
        } rx_bq_wr_addr[20:0];
    } RX_BQ_WR_ADDR @ 0x528;

    reg {
        name = "Read address register for the rx_buff descriptor queue";
        desc = "RX_BQ_RD_ADDR is a read address register for the rx_buff descriptor queue.

Data sheet 5.7 RX_BQ_RD_ADDR (offset 0x52C, printed page 5-72, `Hi3516AV200-Datasheet.txt` line 33842).
Hi3516 V100 data sheet (Chinese original) 5.6 RX_BQ_RD_ADDR (offset 0x52C, printed page 5-85, `Hi3516-Datasheet.txt` line 32990).";

        field {
            name = "rx_bq_rd_addr";
            desc = "Read address of the buff descriptor queue in the RX direction";
            sw = rw;
            hw = r;
            reset = 0x0;
        } rx_bq_rd_addr[20:0];
    } RX_BQ_RD_ADDR @ 0x52C;

    reg {
        name = "Writable descriptor count register NT for the rx_buff descriptor queue";
        desc = "RX_BQ_FREE_DESC_CNT is a writable descriptor count register for the rx_buff descriptor queue.

Data sheet 5.7 RX_BQ_FREE_DESC_CNT (offset 0x530, printed page 5-73, `Hi3516AV200-Datasheet.txt` line 33868).
Hi3516 V100 data sheet (Chinese original) 5.6 RX_BQ_FREE_DESC_CNT (offset 0x530, printed page 5-86, `Hi3516-Datasheet.txt` line 33020).";

        field {
            name = "rx_bq_free_desc_cnt";
            desc = "Count of writable descriptors in the buff descriptor queue in the RX direction";
            sw = rw;
            hw = w;
            reset = 0x80;
        } rx_bq_free_desc_cnt[15:0];
    } RX_BQ_FREE_DESC_CNT @ 0x530;

    reg {
        name = "Almost-empty threshold register for the rx_buff descriptor queue";
        desc = "RX_BQ_ALEMPTY_TH is an almost-empty threshold register for the rx_buff descriptor queue.

Data sheet 5.7 RX_BQ_ALEMPTY_TH (offset 0x534, printed page 5-73, `Hi3516AV200-Datasheet.txt` line 33891).
Hi3516 V100 data sheet (Chinese original) 5.6 RX_BQ_ALEMPTY_TH (offset 0x534, printed page 5-86, `Hi3516-Datasheet.txt` line 33043).";

        field {
            name = "rx_bq_pause_low_th";
            desc = "Flow control threshold of the rx_bq queue. If the count of writable descriptors is less than or equal to the value of bq_pause_low_th, an indicator for sending flow control frames is generated.";
            sw = rw;
            hw = r;
            reset = 0x10;
        } rx_bq_pause_low_th[31:16];

        field {
            name = "rx_bq_alempty_th";
            desc = "Almost-empty threshold of the buff descriptor queue in the RX direction";
            sw = rw;
            hw = r;
            reset = 0x10;
        } rx_bq_alempty_th[15:0];
    } RX_BQ_ALEMPTY_TH @ 0x534;

    reg {
        name = "Enable register related to rx_buff descriptor queue";
        desc = "RX_BQ_REG_EN is an enable register related to the buff descriptor queue in the RX direction.

Data sheet 5.7 RX_BQ_REG_EN (offset 0x538, printed page 5-74, `Hi3516AV200-Datasheet.txt` line 33923).
Hi3516 V100 data sheet (Chinese original) 5.6 RX_BQ_REG_EN (offset 0x538, printed page 5-87, `Hi3516-Datasheet.txt` line 33078).";

        enum RX_BQ_REG_EN_rx_bq_start_addr_en_enum {
            WRITE_PROTECTED = 0 { name = "Write protected"; desc = "The RX_BQ_START_ADDR register is protected, and software cannot be written."; };
            WRITABLE = 1 { name = "Writable"; desc = "Software of the RX_BQ_START_ADDR register can be written."; };
        };

        field {
            name = "rx_bq_start_addr_en";
            desc = "Software write enable for the RX_BQ_START_ADDR register";
            sw = rw;
            hw = r;
            encode = RX_BQ_REG_EN_rx_bq_start_addr_en_enum;
            reset = 0x0;
        } rx_bq_start_addr_en[2:2];

        enum RX_BQ_REG_EN_rx_bq_depth_en_enum {
            WRITE_PROTECTED = 0 { name = "Write protected"; desc = "The RX_BQ_DEPTH register is protected, and software cannot be written."; };
            WRITABLE = 1 { name = "Writable"; desc = "Software of the RX_BQ_DEPTH register can be written."; };
        };

        field {
            name = "rx_bq_depth_en";
            desc = "Software write enable for the RX_BQ_DEPTH register";
            sw = rw;
            hw = r;
            encode = RX_BQ_REG_EN_rx_bq_depth_en_enum;
            reset = 0x0;
        } rx_bq_depth_en[1:1];

        enum RX_BQ_REG_EN_rx_bq_wr_addr_en_enum {
            WRITE_PROTECTED = 0 { name = "Write protected"; desc = "The RX_BQ write address register is protected, and software cannot be written."; };
            WRITABLE = 1 { name = "Writable"; desc = "Software of the RX_BQ write address register can be written."; };
        };

        field {
            name = "rx_bq_wr_addr_en";
            desc = "Software write enable for the RX_BQ write address register";
            sw = rw;
            hw = r;
            encode = RX_BQ_REG_EN_rx_bq_wr_addr_en_enum;
            reset = 0x0;
        } rx_bq_wr_addr_en[0:0];
    } RX_BQ_REG_EN @ 0x538;

    reg {
        name = "Almost-full threshold register for the rx_buff descriptor queue";
        desc = "RX_BQ_ALFULL_TH is an almost-full threshold register for the rx_buff descriptor queue.

Data sheet 5.7 RX_BQ_ALFULL_TH (offset 0x53C, printed page 5-75, `Hi3516AV200-Datasheet.txt` line 33970).
Hi3516 V100 data sheet (Chinese original) 5.6 RX_BQ_ALFULL_TH (offset 0x53C, printed page 5-87, `Hi3516-Datasheet.txt` line 33118).";

        field {
            name = "rx_bq_pause_hi_th";
            desc = "Upper flow control threshold for the rx_bq queue. If the count of writable descriptors is greater than or equal to the value of bq_pause_hi_th, the indicator for sending flow control frames is set to 0, indicating that the flow control frames are not transmitted.";
            sw = rw;
            hw = r;
            reset = 0x10;
        } rx_bq_pause_hi_th[31:16];

        field {
            name = "rx_bq_alfull_th";
            desc = "Almost-full threshold of the buff descriptor queue in the RX direction";
            sw = rw;
            hw = r;
            reset = 0x10;
        } rx_bq_alfull_th[15:0];
    } RX_BQ_ALFULL_TH @ 0x53C;

    reg {
        name = "Start address register for the tx_buff descriptor queue";
        desc = "TX_BQ_START_ADDR is a start address register for the tx_buff descriptor queue.

Data sheet 5.7 TX_BQ_START_ADDR (offset 0x580, printed page 5-75, `Hi3516AV200-Datasheet.txt` line 33995).
Hi3516 V100 data sheet (Chinese original) 5.6 TX_BQ_START_ADDR (offset 0x580, printed page 5-88, `Hi3516-Datasheet.txt` line 33148).";

        field {
            name = "tx_bq_start_addr";
            desc = "Start address of the buff descriptor queue in the TX direction. When tx_bq_start_addr_en in the TX_BQ_REG_EN register is set to 1, the register can be read and written. When tx_bq_start_addr_en is set to 0, the register is read-only. Only word addresses are supported.";
            sw = rw;
            hw = r;
            reset = 0x0;
        } tx_bq_start_addr[31:0];
    } TX_BQ_START_ADDR @ 0x580;

    reg {
        name = "Depth register for the tx_buff descriptor queue";
        desc = "TX_BQ_DEPTH is a depth register for the tx_buff descriptor queue.

Data sheet 5.7 TX_BQ_DEPTH (offset 0x584, printed page 5-76, `Hi3516AV200-Datasheet.txt` line 34023).
Hi3516 V100 data sheet (Chinese original) 5.6 TX_BQ_DEPTH (offset 0x584, printed page 5-88, `Hi3516-Datasheet.txt` line 33169).";

        field {
            name = "tx_bq_depth";
            desc = "Depth of the buff descriptor queue in the TX direction. It indicates the number of words, not the number of descriptors. When tx_bq_depth_en of the TX_BQ_REG_EN register is set to 1, the register can be read and written. When tx_bq_depth_en is set to 0, the register is read-only. The depth must be set to an integral multiple of 8. It is recommended that this field be set to at least 0x400.";
            sw = rw;
            hw = r;
            reset = 0x400;
        } tx_bq_depth[18:0];
    } TX_BQ_DEPTH @ 0x584;

    reg {
        name = "Write address register for the tx_buff descriptor queue";
        desc = "TX_BQ_WR_ADDR is a write address register for the tx_buff descriptor queue.

Data sheet 5.7 TX_BQ_WR_ADDR (offset 0x588, printed page 5-76, `Hi3516AV200-Datasheet.txt` line 34049).
Hi3516 V100 data sheet (Chinese original) 5.6 TX_BQ_WR_ADDR (offset 0x588, printed page 5-89, `Hi3516-Datasheet.txt` line 33204).";

        field {
            name = "tx_bq_wr_addr";
            desc = "Write address of the buff descriptor queue in the TX direction";
            sw = rw;
            hw = r;
            reset = 0x0;
        } tx_bq_wr_addr[20:0];
    } TX_BQ_WR_ADDR @ 0x588;

    reg {
        name = "Read address register for the tx_buff descriptor queue";
        desc = "TX_BQ_RD_ADDR is a read address register for the tx_buff descriptor queue.

The first sentence of the Hi3516A V200 and Hi3519 V101 text says rx_bq_rd_addr_en of TX_BQ_REG_EN (typo; the Hi3516A edition and the register layout say tx_bq_rd_addr_en, bit 0 of TX_BQ_REG_EN).

Data sheet 5.7 TX_BQ_RD_ADDR (offset 0x58C, printed page 5-77, `Hi3516AV200-Datasheet.txt` line 34073).
Hi3516 V100 data sheet (Chinese original) 5.6 TX_BQ_RD_ADDR (offset 0x58C, printed page 5-89, `Hi3516-Datasheet.txt` line 33225).";

        field {
            name = "tx_bq_rd_addr";
            desc = "Read address of the buff descriptor queue in the TX direction. When rx_bq_rd_addr_en of the TX_BQ_REG_EN register is set to 1, the register can be read and written. When tx_bq_rd_addr_en is set to 0, the register is read-only.";
            sw = rw;
            hw = w;
            reset = 0x0;
        } tx_bq_rd_addr[20:0];
    } TX_BQ_RD_ADDR @ 0x58C;

    reg {
        name = "Valid descriptor number register for the tx_buff descriptor queue";
        desc = "TX_BQ_VLDDESC_CNT is a valid descriptor number register for the tx_buff descriptor queue.

Data sheet 5.7 TX_BQ_VLDDESC_CNT (offset 0x590, printed page 5-77, `Hi3516AV200-Datasheet.txt` line 34098).
Hi3516 V100 data sheet (Chinese original) 5.6 TX_BQ_VLDDESC_CNT (offset 0x590, printed page 5-89, `Hi3516-Datasheet.txt` line 33248).";

        field {
            name = "tx_bq_vlddesc_cnt";
            desc = "Count of valid descriptors in the buff descriptor queue in the TX direction";
            sw = rw;
            hw = w;
            reset = 0x0;
        } tx_bq_vlddesc_cnt[15:0];
    } TX_BQ_VLDDESC_CNT @ 0x590;

    reg {
        name = "Almost-empty threshold register for the tx_buff descriptor queue";
        desc = "TX_BQ_ALEMPTY_TH is an almost-empty threshold register for the tx_buff descriptor queue.

Data sheet 5.7 TX_BQ_ALEMPTY_TH (offset 0x594, printed page 5-78, `Hi3516AV200-Datasheet.txt` line 34125).
Hi3516 V100 data sheet (Chinese original) 5.6 TX_BQ_ALEMPTY_TH (offset 0x594, printed page 5-90, `Hi3516-Datasheet.txt` line 33278).";

        field {
            name = "tx_bq_alempty_th";
            desc = "Almost-empty threshold of the buff descriptor queue in the TX direction";
            sw = rw;
            hw = r;
            reset = 0x10;
        } tx_bq_alempty_th[15:0];
    } TX_BQ_ALEMPTY_TH @ 0x594;

    reg {
        name = "Enable register related to tx_buff descriptor queue";
        desc = "TX_BQ_REG_EN is an enable register related to the buff descriptor queue in the TX direction.

Data sheet 5.7 TX_BQ_REG_EN (offset 0x598, printed page 5-78, `Hi3516AV200-Datasheet.txt` line 34148).
Hi3516 V100 data sheet (Chinese original) 5.6 TX_BQ_REG_EN (offset 0x598, printed page 5-90, `Hi3516-Datasheet.txt` line 33299).";

        enum TX_BQ_REG_EN_tx_bq_start_addr_en_enum {
            WRITE_PROTECTED = 0 { name = "Write protected"; desc = "The TX_BQ_START_ADDR register is protected, and software cannot be written."; };
            WRITABLE = 1 { name = "Writable"; desc = "Software of the TX_BQ_START_ADDR register can be written."; };
        };

        field {
            name = "tx_bq_start_addr_en";
            desc = "Software write enable for the TX_BQ_START_ADDR register";
            sw = rw;
            hw = r;
            encode = TX_BQ_REG_EN_tx_bq_start_addr_en_enum;
            reset = 0x0;
        } tx_bq_start_addr_en[2:2];

        enum TX_BQ_REG_EN_tx_bq_depth_en_enum {
            WRITE_PROTECTED = 0 { name = "Write protected"; desc = "The TX_BQ_DEPTH register is protected, and software cannot be written."; };
            WRITABLE = 1 { name = "Writable"; desc = "Software of the TX_BQ_DEPTH register can be written."; };
        };

        field {
            name = "tx_bq_depth_en";
            desc = "Software write enable for the TX_BQ_DEPTH register";
            sw = rw;
            hw = r;
            encode = TX_BQ_REG_EN_tx_bq_depth_en_enum;
            reset = 0x0;
        } tx_bq_depth_en[1:1];

        enum TX_BQ_REG_EN_tx_bq_rd_addr_en_enum {
            WRITE_PROTECTED = 0 { name = "Write protected"; desc = "The TX_BQ read address register is protected, and software cannot be written."; };
            WRITABLE = 1 { name = "Writable"; desc = "Software of the TX_BQ read address register can be written."; };
        };

        field {
            name = "tx_bq_rd_addr_en";
            desc = "Software write enable for the TX_BQ read address register";
            sw = rw;
            hw = r;
            encode = TX_BQ_REG_EN_tx_bq_rd_addr_en_enum;
            reset = 0x0;
        } tx_bq_rd_addr_en[0:0];
    } TX_BQ_REG_EN @ 0x598;

    reg {
        name = "Almost-full threshold register for the tx_buff descriptor queue";
        desc = "BQ1_ALFULL_TH is an almost-full threshold register for the buff1 descriptor queue.

Data sheet 5.7 BQ1_ALFULL_TH (offset 0x59C, printed page 5-79, `Hi3516AV200-Datasheet.txt` line 34200).
Hi3516 V100 data sheet (Chinese original) 5.6 BQ1_ALFULL_TH (offset 0x59C, printed page 5-91, `Hi3516-Datasheet.txt` line 33349).";

`ifndef HISI_GMAC_HI3516V100
        field {
            name = "bq1_alfull_th";
            desc = "Almost-full threshold of the buff1 descriptor queue in the TX direction";
            sw = rw;
            hw = r;
            reset = 0x0;
        } bq1_alfull_th[15:0];
`endif

`ifdef HISI_GMAC_HI3516V100
        field {
            name = "bq1_alfull_th";
            desc = "Almost-full threshold of the buff1 (valid) descriptor queue in the TX direction. Hi3516 V100 data sheet (Chinese original) reset value 16.";
            sw = rw;
            hw = r;
            reset = 0x10;
        } bq1_alfull_th[15:0];
`endif
    } BQ1_ALFULL_TH @ 0x59C;

    reg {
        name = "Start address register for the tx_rq descriptor queue";
        desc = "TX_RQ_START_ADDR is a start address register for the tx_rq descriptor queue.

Data sheet 5.7 TX_RQ_START_ADDR (offset 0x5A0, printed page 5-79, `Hi3516AV200-Datasheet.txt` line 34221).
Hi3516 V100 data sheet (Chinese original) 5.6 TX_RQ_START_ADDR (offset 0x5A0, printed page 5-91, `Hi3516-Datasheet.txt` line 33370).";

        field {
            name = "tx_rq_start_addr";
            desc = "Start address of the recycle descriptor queue in the TX direction. When tx_rq_start_addr_en of the TX_RQ_REG_EN register is set to 1, the register can be read and written. When tx_rq_start_addr_en is set to 0, the register is read-only. Only word addresses are supported.";
            sw = rw;
            hw = r;
            reset = 0x0;
        } tx_rq_start_addr[31:0];
    } TX_RQ_START_ADDR @ 0x5A0;

    reg {
        name = "Depth register for the tx_rq descriptor queue";
        desc = "TX_RQ_DEPTH is a depth register for the tx_rq descriptor queue.

Data sheet 5.7 TX_RQ_DEPTH (offset 0x5A4, printed page 5-80, `Hi3516AV200-Datasheet.txt` line 34249).
Hi3516 V100 data sheet (Chinese original) 5.6 TX_RQ_DEPTH (offset 0x5A4, printed page 5-92, `Hi3516-Datasheet.txt` line 33397).";

        field {
            name = "tx_rq_depth";
            desc = "Depth of the recycle descriptor queue in the TX direction. It indicates the number of words, not the number of descriptors. When tx_rq_depth_en of the TX_RQ_REG_EN register is set to 1, the register can be read and written. When tx_rq_depth_en is set to 0, the register is read-only. The depth must be set to an integral multiple of 8. It is recommended that this field be set to at least 0x400.";
            sw = rw;
            hw = r;
            reset = 0x400;
        } tx_rq_depth[18:0];
    } TX_RQ_DEPTH @ 0x5A4;

    reg {
        name = "Write address register for the tx_rq descriptor queue";
        desc = "TX_RQ_WR_ADDR is a write address register for the tx_rq descriptor queue.

Data sheet 5.7 TX_RQ_WR_ADDR (offset 0x5A8, printed page 5-80, `Hi3516AV200-Datasheet.txt` line 34275).
Hi3516 V100 data sheet (Chinese original) 5.6 TX_RQ_WR_ADDR (offset 0x5A8, printed page 5-92, `Hi3516-Datasheet.txt` line 33422).";

        field {
            name = "tx_rq_wr_addr";
            desc = "Write address of the recycle descriptor queue in the TX direction. When tx_rq_wr_addr_en of the TX_RQ_REG_EN register is set to 1, the register can be read and written. When tx_rq_wr_addr_en is set to 0, the register is read-only.";
            sw = rw;
            hw = w;
            reset = 0x0;
        } tx_rq_wr_addr[20:0];
    } TX_RQ_WR_ADDR @ 0x5A8;

    reg {
        name = "Read address register for the tx_rq descriptor queue";
        desc = "TX_RQ_RD_ADDR is a read address register for the tx_rq descriptor queue.

Data sheet 5.7 TX_RQ_RD_ADDR (offset 0x5AC, printed page 5-81, `Hi3516AV200-Datasheet.txt` line 34307).
Hi3516 V100 data sheet (Chinese original) 5.6 TX_RQ_RD_ADDR (offset 0x5AC, printed page 5-93, `Hi3516-Datasheet.txt` line 33455).";

        field {
            name = "tx_rq_rd_addr";
            desc = "Read address of the recycle descriptor queue in the TX direction.";
            sw = rw;
            hw = r;
            reset = 0x0;
        } tx_rq_rd_addr[20:0];
    } TX_RQ_RD_ADDR @ 0x5AC;

    reg {
        name = "Writable descriptor count register T for the tx_rq descriptor queue";
        desc = "TX_RQ_FREE_DESC_CNT is a writable descriptor count register for the tx_rq descriptor queue.

Data sheet 5.7 TX_RQ_FREE_DESC_CNT (offset 0x5B0, printed page 5-81, `Hi3516AV200-Datasheet.txt` line 34327).
Hi3516 V100 data sheet (Chinese original) 5.6 TX_RQ_FREE_DESC_CNT (offset 0x5B0, printed page 5-93, `Hi3516-Datasheet.txt` line 33477).";

        field {
            name = "tx_rq_free_desc_cnt";
            desc = "Count of writable descriptors in the recycle descriptor queue in the TX direction";
            sw = rw;
            hw = w;
            reset = 0x80;
        } tx_rq_free_desc_cnt[15:0];
    } TX_RQ_FREE_DESC_CNT @ 0x5B0;

    reg {
        name = "Almost-empty threshold register for the tx_rq descriptor queue";
        desc = "TX_RQ_ALEMPTY_TH is an almost-empty threshold register for the tx_rq descriptor queue.

Data sheet 5.7 TX_RQ_ALEMPTY_TH (offset 0x5B4, printed page 5-81, `Hi3516AV200-Datasheet.txt` line 34348).
Hi3516 V100 data sheet (Chinese original) 5.6 TX_RQ_ALEMPTY_TH (offset 0x5B4, printed page 5-93, `Hi3516-Datasheet.txt` line 33500).";

        field {
            name = "tx_rq_alempty_th";
            desc = "Almost-empty threshold of the recycle descriptor queue in the TX direction";
            sw = rw;
            hw = r;
            reset = 0x10;
        } tx_rq_alempty_th[15:0];
    } TX_RQ_ALEMPTY_TH @ 0x5B4;

    reg {
        name = "Enable register related to the tx_rq descriptor queue";
        desc = "TX_RQ_REG_EN is an enable register related to the tx_rq descriptor queue

Data sheet 5.7 TX_RQ_REG_EN (offset 0x5B8, printed page 5-82, `Hi3516AV200-Datasheet.txt` line 34380).
Hi3516 V100 data sheet (Chinese original) 5.6 TX_RQ_REG_EN (offset 0x5B8, printed page 5-94, `Hi3516-Datasheet.txt` line 33531).";

        enum TX_RQ_REG_EN_tx_rq_start_addr_en_enum {
            WRITE_PROTECTED = 0 { name = "Write protected"; desc = "The TX_RQ_START_ADDR register is protected, and software cannot be written."; };
            WRITABLE = 1 { name = "Writable"; desc = "Software of the TX_RQ_START_ADDR register can be written."; };
        };

        field {
            name = "tx_rq_start_addr_en";
            desc = "Software write enable for the TX_RQ_START_ADDR register";
            sw = rw;
            hw = r;
            encode = TX_RQ_REG_EN_tx_rq_start_addr_en_enum;
            reset = 0x0;
        } tx_rq_start_addr_en[2:2];

        enum TX_RQ_REG_EN_tx_rq_depth_en_enum {
            WRITE_PROTECTED = 0 { name = "Write protected"; desc = "The TX_RQ_DEPTH register is protected, and software cannot be written."; };
            WRITABLE = 1 { name = "Writable"; desc = "Software of the TX_RQ_DEPTH register can be written."; };
        };

        field {
            name = "tx_rq_depth_en";
            desc = "Software write enable for the TX_RQ_DEPTH register";
            sw = rw;
            hw = r;
            encode = TX_RQ_REG_EN_tx_rq_depth_en_enum;
            reset = 0x0;
        } tx_rq_depth_en[1:1];

        enum TX_RQ_REG_EN_tx_rq_wr_addr_en_enum {
            WRITE_PROTECTED = 0 { name = "Write protected"; desc = "The TX_RQ write address register is protected, and software cannot be written."; };
            WRITABLE = 1 { name = "Writable"; desc = "Software of the TX_RQ write address register can be written."; };
        };

        field {
            name = "tx_rq_wr_addr_en";
            desc = "Software write enable for the TX_RQ write address register";
            sw = rw;
            hw = r;
            encode = TX_RQ_REG_EN_tx_rq_wr_addr_en_enum;
            reset = 0x0;
        } tx_rq_wr_addr_en[0:0];
    } TX_RQ_REG_EN @ 0x5B8;

    reg {
        name = "Almost-full threshold register for the tx_rq descriptor queue";
        desc = "TX_RQ_ALFULL_TH is an almost-full threshold register for the tx_rq descriptor queue.

Data sheet 5.7 TX_RQ_ALFULL_TH (offset 0x5BC, printed page 5-83, `Hi3516AV200-Datasheet.txt` line 34427).
Hi3516 V100 data sheet (Chinese original) 5.6 TX_RQ_ALFULL_TH (offset 0x5BC, printed page 5-95, `Hi3516-Datasheet.txt` line 33581).";

        field {
            name = "tx_rq_alfull_th";
            desc = "Almost-full threshold of the recycle descriptor queue in the TX direction";
            sw = rw;
            hw = r;
            reset = 0x10;
        } tx_rq_alfull_th[15:0];
    } TX_RQ_ALFULL_TH @ 0x5BC;

    reg {
        name = "PMU raw interrupt status register";
        desc = "RAW_PMU_INT is a PMU raw interrupt status register.

The data sheet lists the bits as RW with the text \"cleared by writing 1 to this bit\"; Linux hix5hd2_gmac.c (writel(ints, RAW_PMU_INT), writel(~0, ...)) and the vendor U-Boot (higmac_clear_irqstatus) clear it by writing 1 (write-1-to-clear); the bit assignment equals the ENA_PMU_INT/STATUS_PMU_INT bit assignment and the Linux *_INT masks. Linux DEF_INT_MASK enables RX_BQ_IN_INT, RX_BQ_IN_TIMEOUT_INT, TX_RQ_IN_INT and TX_RQ_IN_TIMEOUT_INT (bits 17, 28, 19, 29).

Data sheet 5.7 RAW_PMU_INT (offset 0x5C0, printed page 5-83, `Hi3516AV200-Datasheet.txt` line 34449).
Hi3516 V100 data sheet (Chinese original) 5.6 RAW_PMU_INT (offset 0x5C0, printed page 5-95, `Hi3516-Datasheet.txt` line 33602).";

        enum RAW_PMU_INT_raw_mac_fifo_err_int_enum {
            NO_RAW_INTERRUPT = 0 { name = "No Raw Interrupt"; desc = "No raw interrupt is generated."; };
            RAW_INTERRUPT_GENERATED = 1 { name = "Raw Interrupt Generated"; desc = "A raw interrupt is generated."; };
        };

        field {
            name = "raw_mac_fifo_err_int";
            desc = "Raw interrupt of FIFO empty and full errors in the MAC address, cleared by writing 1 to this bit";
            sw = rw;
            hw = w;
            onwrite = woclr;
            encode = RAW_PMU_INT_raw_mac_fifo_err_int_enum;
            reset = 0x0;
        } raw_mac_fifo_err_int[30:30];

        enum RAW_PMU_INT_raw_tx_rq_in_timeout_int_enum {
            NO_RAW_INTERRUPT = 0 { name = "No Raw Interrupt"; desc = "No raw interrupt is generated."; };
            RAW_INTERRUPT_GENERATED = 1 { name = "Raw Interrupt Generated"; desc = "A raw interrupt is generated."; };
        };

        field {
            name = "raw_tx_rq_in_timeout_int";
            desc = "Raw interrupt of descriptor enqueue timeout in the RQ queue in the TX direction, cleared by writing 1 to this bit";
            sw = rw;
            hw = w;
            onwrite = woclr;
            encode = RAW_PMU_INT_raw_tx_rq_in_timeout_int_enum;
            reset = 0x0;
        } raw_tx_rq_in_timeout_int[29:29];

        enum RAW_PMU_INT_raw_rx_bq_in_timeout_int_enum {
            NO_RAW_INTERRUPT = 0 { name = "No Raw Interrupt"; desc = "No raw interrupt is generated."; };
            RAW_INTERRUPT_GENERATED = 1 { name = "Raw Interrupt Generated"; desc = "A raw interrupt is generated."; };
        };

        field {
            name = "raw_rx_bq_in_timeout_int";
            desc = "Raw interrupt of descriptor enqueue timeout in the BQ queue in the RX direction, cleared by writing 1 to this bit";
            sw = rw;
            hw = w;
            onwrite = woclr;
            encode = RAW_PMU_INT_raw_rx_bq_in_timeout_int_enum;
            reset = 0x0;
        } raw_rx_bq_in_timeout_int[28:28];

        enum RAW_PMU_INT_raw_txoutcff_full_int_enum {
            NO_RAW_INTERRUPT = 0 { name = "No Raw Interrupt"; desc = "No raw interrupt is generated."; };
            RAW_INTERRUPT_GENERATED = 1 { name = "Raw Interrupt Generated"; desc = "A raw interrupt is generated."; };
        };

        field {
            name = "raw_txoutcff_full_int";
            desc = "Raw interrupt of full DESC_OUTCFF in the TX direction, cleared by writing 1 to this bit";
            sw = rw;
            hw = w;
            onwrite = woclr;
            encode = RAW_PMU_INT_raw_txoutcff_full_int_enum;
            reset = 0x0;
        } raw_txoutcff_full_int[27:27];

        enum RAW_PMU_INT_raw_txoutcff_empty_int_enum {
            NO_RAW_INTERRUPT = 0 { name = "No Raw Interrupt"; desc = "No raw interrupt is generated."; };
            RAW_INTERRUPT_GENERATED = 1 { name = "Raw Interrupt Generated"; desc = "A raw interrupt is generated."; };
        };

        field {
            name = "raw_txoutcff_empty_int";
            desc = "Raw interrupt of empty DESC_OUTCFF in the TX direction, cleared by writing 1 to this bit";
            sw = rw;
            hw = w;
            onwrite = woclr;
            encode = RAW_PMU_INT_raw_txoutcff_empty_int_enum;
            reset = 0x0;
        } raw_txoutcff_empty_int[26:26];

        enum RAW_PMU_INT_raw_txcff_full_int_enum {
            NO_RAW_INTERRUPT = 0 { name = "No Raw Interrupt"; desc = "No raw interrupt is generated."; };
            RAW_INTERRUPT_GENERATED = 1 { name = "Raw Interrupt Generated"; desc = "A raw interrupt is generated."; };
        };

        field {
            name = "raw_txcff_full_int";
            desc = "Raw interrupt of full DESC_FIFO in the TX direction, cleared by writing 1 to this bit";
            sw = rw;
            hw = w;
            onwrite = woclr;
            encode = RAW_PMU_INT_raw_txcff_full_int_enum;
            reset = 0x0;
        } raw_txcff_full_int[25:25];

        enum RAW_PMU_INT_raw_txcff_empty_int_enum {
            NO_RAW_INTERRUPT = 0 { name = "No Raw Interrupt"; desc = "No raw interrupt is generated."; };
            RAW_INTERRUPT_GENERATED = 1 { name = "Raw Interrupt Generated"; desc = "A raw interrupt is generated."; };
        };

        field {
            name = "raw_txcff_empty_int";
            desc = "Raw interrupt of empty DESC_FIFO in the TX direction, cleared by writing 1 to this bit";
            sw = rw;
            hw = w;
            onwrite = woclr;
            encode = RAW_PMU_INT_raw_txcff_empty_int_enum;
            reset = 0x0;
        } raw_txcff_empty_int[24:24];

        enum RAW_PMU_INT_raw_rxoutcff_full_int_enum {
            NO_RAW_INTERRUPT = 0 { name = "No Raw Interrupt"; desc = "No raw interrupt is generated."; };
            RAW_INTERRUPT_GENERATED = 1 { name = "Raw Interrupt Generated"; desc = "A raw interrupt is generated."; };
        };

        field {
            name = "raw_rxoutcff_full_int";
            desc = "Raw interrupt of full DESC_OUTCFF in the RX direction, cleared by writing 1 to this bit";
            sw = rw;
            hw = w;
            onwrite = woclr;
            encode = RAW_PMU_INT_raw_rxoutcff_full_int_enum;
            reset = 0x0;
        } raw_rxoutcff_full_int[23:23];

        enum RAW_PMU_INT_raw_rxoutcff_empty_int_enum {
            NO_RAW_INTERRUPT = 0 { name = "No Raw Interrupt"; desc = "No raw interrupt is generated."; };
            RAW_INTERRUPT_GENERATED = 1 { name = "Raw Interrupt Generated"; desc = "A raw interrupt is generated."; };
        };

        field {
            name = "raw_rxoutcff_empty_int";
            desc = "Raw interrupt of empty DESC_OUTCFF in the RX direction, cleared by writing 1 to this bit";
            sw = rw;
            hw = w;
            onwrite = woclr;
            encode = RAW_PMU_INT_raw_rxoutcff_empty_int_enum;
            reset = 0x0;
        } raw_rxoutcff_empty_int[22:22];

        enum RAW_PMU_INT_raw_rxcff_full_int_enum {
            NO_RAW_INTERRUPT = 0 { name = "No Raw Interrupt"; desc = "No raw interrupt is generated."; };
            RAW_INTERRUPT_GENERATED = 1 { name = "Raw Interrupt Generated"; desc = "A raw interrupt is generated."; };
        };

        field {
            name = "raw_rxcff_full_int";
            desc = "Raw interrupt of full DESC_FIFO in the RX direction, cleared by writing 1 to this bit";
            sw = rw;
            hw = w;
            onwrite = woclr;
            encode = RAW_PMU_INT_raw_rxcff_full_int_enum;
            reset = 0x0;
        } raw_rxcff_full_int[21:21];

        enum RAW_PMU_INT_raw_rxcff_empty_int_enum {
            NO_RAW_INTERRUPT = 0 { name = "No Raw Interrupt"; desc = "No raw interrupt is generated."; };
            RAW_INTERRUPT_GENERATED = 1 { name = "Raw Interrupt Generated"; desc = "A raw interrupt is generated."; };
        };

        field {
            name = "raw_rxcff_empty_int";
            desc = "Raw interrupt of empty DESC_FIFO in the RX direction, cleared by writing 1 to this bit";
            sw = rw;
            hw = w;
            onwrite = woclr;
            encode = RAW_PMU_INT_raw_rxcff_empty_int_enum;
            reset = 0x0;
        } raw_rxcff_empty_int[20:20];

        enum RAW_PMU_INT_raw_tx_rq_in_int_enum {
            NO_RAW_INTERRUPT = 0 { name = "No Raw Interrupt"; desc = "No raw interrupt is generated."; };
            RAW_INTERRUPT_GENERATED = 1 { name = "Raw Interrupt Generated"; desc = "A raw interrupt is generated."; };
        };

        field {
            name = "raw_tx_rq_in_int";
            desc = "Raw interrupt of descriptor (multiple or single) enqueue in the tx_rq queue in the TX direction, cleared by writing 1 to this bit";
            sw = rw;
            hw = w;
            onwrite = woclr;
            encode = RAW_PMU_INT_raw_tx_rq_in_int_enum;
            reset = 0x0;
        } raw_tx_rq_in_int[19:19];

        enum RAW_PMU_INT_raw_tx_bq_out_int_enum {
            NO_RAW_INTERRUPT = 0 { name = "No Raw Interrupt"; desc = "No raw interrupt is generated."; };
            RAW_INTERRUPT_GENERATED = 1 { name = "Raw Interrupt Generated"; desc = "A raw interrupt is generated."; };
        };

        field {
            name = "raw_tx_bq_out_int";
            desc = "Raw interrupt of descriptor (multiple or single) dequeue in the tx_bq queue in the TX direction, cleared by writing 1 to this bit";
            sw = rw;
            hw = w;
            onwrite = woclr;
            encode = RAW_PMU_INT_raw_tx_bq_out_int_enum;
            reset = 0x0;
        } raw_tx_bq_out_int[18:18];

        enum RAW_PMU_INT_raw_rx_bq_in_int_enum {
            NO_RAW_INTERRUPT = 0 { name = "No Raw Interrupt"; desc = "No raw interrupt is generated."; };
            RAW_INTERRUPT_GENERATED = 1 { name = "Raw Interrupt Generated"; desc = "A raw interrupt is generated."; };
        };

        field {
            name = "raw_rx_bq_in_int";
            desc = "Raw interrupt of descriptor (multiple or single) enqueue in the rx_bq queue in the RX direction, cleared by writing 1 to this bit";
            sw = rw;
            hw = w;
            onwrite = woclr;
            encode = RAW_PMU_INT_raw_rx_bq_in_int_enum;
            reset = 0x0;
        } raw_rx_bq_in_int[17:17];

        enum RAW_PMU_INT_raw_rx_fq_out_int_enum {
            NO_RAW_INTERRUPT = 0 { name = "No Raw Interrupt"; desc = "No raw interrupt is generated."; };
            RAW_INTERRUPT_GENERATED = 1 { name = "Raw Interrupt Generated"; desc = "A raw interrupt is generated."; };
        };

        field {
            name = "raw_rx_fq_out_int";
            desc = "Raw interrupt of descriptor (multiple or single) dequeue in the rx_fq queue in the RX direction, cleared by writing 1 to this bit";
            sw = rw;
            hw = w;
            onwrite = woclr;
            encode = RAW_PMU_INT_raw_rx_fq_out_int_enum;
            reset = 0x0;
        } raw_rx_fq_out_int[16:16];

        enum RAW_PMU_INT_raw_tx_rq_empty_int_enum {
            NO_RAW_INTERRUPT = 0 { name = "No Raw Interrupt"; desc = "No raw interrupt is generated."; };
            RAW_INTERRUPT_GENERATED = 1 { name = "Raw Interrupt Generated"; desc = "A raw interrupt is generated."; };
        };

        field {
            name = "raw_tx_rq_empty_int";
            desc = "Raw interrupt of the empty recycle descriptor queue in the TX direction, cleared by writing 1 to this bit";
            sw = rw;
            hw = w;
            onwrite = woclr;
            encode = RAW_PMU_INT_raw_tx_rq_empty_int_enum;
            reset = 0x0;
        } raw_tx_rq_empty_int[15:15];

        enum RAW_PMU_INT_raw_tx_rq_full_int_enum {
            NO_RAW_INTERRUPT = 0 { name = "No Raw Interrupt"; desc = "No raw interrupt is generated."; };
            RAW_INTERRUPT_GENERATED = 1 { name = "Raw Interrupt Generated"; desc = "A raw interrupt is generated."; };
        };

        field {
            name = "raw_tx_rq_full_int";
            desc = "Raw interrupt of the full recycle descriptor queue in the TX direction, cleared by writing 1 to this bit";
            sw = rw;
            hw = w;
            onwrite = woclr;
            encode = RAW_PMU_INT_raw_tx_rq_full_int_enum;
            reset = 0x0;
        } raw_tx_rq_full_int[14:14];

        enum RAW_PMU_INT_raw_tx_rq_alempty_int_enum {
            NO_RAW_INTERRUPT = 0 { name = "No Raw Interrupt"; desc = "No raw interrupt is generated."; };
            RAW_INTERRUPT_GENERATED = 1 { name = "Raw Interrupt Generated"; desc = "A raw interrupt is generated."; };
        };

        field {
            name = "raw_tx_rq_alempty_int";
            desc = "Raw interrupt of the almost-empty recycle descriptor queue in the TX direction, cleared by writing 1 to this bit";
            sw = rw;
            hw = w;
            onwrite = woclr;
            encode = RAW_PMU_INT_raw_tx_rq_alempty_int_enum;
            reset = 0x0;
        } raw_tx_rq_alempty_int[13:13];

        enum RAW_PMU_INT_raw_tx_rq_alfull_int_enum {
            NO_RAW_INTERRUPT = 0 { name = "No Raw Interrupt"; desc = "No raw interrupt is generated."; };
            RAW_INTERRUPT_GENERATED = 1 { name = "Raw Interrupt Generated"; desc = "A raw interrupt is generated."; };
        };

        field {
            name = "raw_tx_rq_alfull_int";
            desc = "Raw interrupt of the almost-full recycle descriptor queue in the TX direction, cleared by writing 1 to this bit";
            sw = rw;
            hw = w;
            onwrite = woclr;
            encode = RAW_PMU_INT_raw_tx_rq_alfull_int_enum;
            reset = 0x0;
        } raw_tx_rq_alfull_int[12:12];

        enum RAW_PMU_INT_raw_tx_bq_empty_int_enum {
            NO_RAW_INTERRUPT = 0 { name = "No Raw Interrupt"; desc = "No raw interrupt is generated."; };
            RAW_INTERRUPT_GENERATED = 1 { name = "Raw Interrupt Generated"; desc = "A raw interrupt is generated."; };
        };

        field {
            name = "raw_tx_bq_empty_int";
            desc = "Raw interrupt of the empty buff descriptor queue in the TX direction, cleared by writing 1 to this bit";
            sw = rw;
            hw = w;
            onwrite = woclr;
            encode = RAW_PMU_INT_raw_tx_bq_empty_int_enum;
            reset = 0x0;
        } raw_tx_bq_empty_int[11:11];

        enum RAW_PMU_INT_raw_tx_bq_full_int_enum {
            NO_RAW_INTERRUPT = 0 { name = "No Raw Interrupt"; desc = "No raw interrupt is generated."; };
            RAW_INTERRUPT_GENERATED = 1 { name = "Raw Interrupt Generated"; desc = "A raw interrupt is generated."; };
        };

        field {
            name = "raw_tx_bq_full_int";
            desc = "Raw interrupt of the full buff descriptor queue in the TX direction, cleared by writing 1 to this bit";
            sw = rw;
            hw = w;
            onwrite = woclr;
            encode = RAW_PMU_INT_raw_tx_bq_full_int_enum;
            reset = 0x0;
        } raw_tx_bq_full_int[10:10];

        enum RAW_PMU_INT_raw_tx_bq_alempty_int_enum {
            NO_RAW_INTERRUPT = 0 { name = "No Raw Interrupt"; desc = "No raw interrupt is generated."; };
            RAW_INTERRUPT_GENERATED = 1 { name = "Raw Interrupt Generated"; desc = "A raw interrupt is generated."; };
        };

        field {
            name = "raw_tx_bq_alempty_int";
            desc = "Raw interrupt of the almost-empty buff descriptor queue in the TX direction, cleared by writing 1 to this bit";
            sw = rw;
            hw = w;
            onwrite = woclr;
            encode = RAW_PMU_INT_raw_tx_bq_alempty_int_enum;
            reset = 0x0;
        } raw_tx_bq_alempty_int[9:9];

        enum RAW_PMU_INT_raw_tx_bq_alfull_int_enum {
            NO_RAW_INTERRUPT = 0 { name = "No Raw Interrupt"; desc = "No raw interrupt is generated."; };
            RAW_INTERRUPT_GENERATED = 1 { name = "Raw Interrupt Generated"; desc = "A raw interrupt is generated."; };
        };

        field {
            name = "raw_tx_bq_alfull_int";
            desc = "Raw interrupt of the almost-full buff descriptor queue in the TX direction, cleared by writing 1 to this bit";
            sw = rw;
            hw = w;
            onwrite = woclr;
            encode = RAW_PMU_INT_raw_tx_bq_alfull_int_enum;
            reset = 0x0;
        } raw_tx_bq_alfull_int[8:8];

        enum RAW_PMU_INT_raw_rx_bq_empty_int_enum {
            NO_RAW_INTERRUPT = 0 { name = "No Raw Interrupt"; desc = "No raw interrupt is generated."; };
            RAW_INTERRUPT_GENERATED = 1 { name = "Raw Interrupt Generated"; desc = "A raw interrupt is generated."; };
        };

        field {
            name = "raw_rx_bq_empty_int";
            desc = "Raw interrupt of the empty buff descriptor queue in the RX direction, cleared by writing 1 to this bit";
            sw = rw;
            hw = w;
            onwrite = woclr;
            encode = RAW_PMU_INT_raw_rx_bq_empty_int_enum;
            reset = 0x0;
        } raw_rx_bq_empty_int[7:7];

        enum RAW_PMU_INT_raw_rx_bq_full_int_enum {
            NO_RAW_INTERRUPT = 0 { name = "No Raw Interrupt"; desc = "No raw interrupt is generated."; };
            RAW_INTERRUPT_GENERATED = 1 { name = "Raw Interrupt Generated"; desc = "A raw interrupt is generated."; };
        };

        field {
            name = "raw_rx_bq_full_int";
            desc = "Raw interrupt of the full buff descriptor queue in the RX direction, cleared by writing 1 to this bit";
            sw = rw;
            hw = w;
            onwrite = woclr;
            encode = RAW_PMU_INT_raw_rx_bq_full_int_enum;
            reset = 0x0;
        } raw_rx_bq_full_int[6:6];

        enum RAW_PMU_INT_raw_rx_bq_alempty_int_enum {
            NO_RAW_INTERRUPT = 0 { name = "No Raw Interrupt"; desc = "No raw interrupt is generated."; };
            RAW_INTERRUPT_GENERATED = 1 { name = "Raw Interrupt Generated"; desc = "A raw interrupt is generated."; };
        };

        field {
            name = "raw_rx_bq_alempty_int";
            desc = "Raw interrupt of the almost-empty buff descriptor queue in the RX direction, cleared by writing 1 to this bit";
            sw = rw;
            hw = w;
            onwrite = woclr;
            encode = RAW_PMU_INT_raw_rx_bq_alempty_int_enum;
            reset = 0x0;
        } raw_rx_bq_alempty_int[5:5];

        enum RAW_PMU_INT_raw_rx_bq_alfull_int_enum {
            NO_RAW_INTERRUPT = 0 { name = "No Raw Interrupt"; desc = "No raw interrupt is generated."; };
            RAW_INTERRUPT_GENERATED = 1 { name = "Raw Interrupt Generated"; desc = "A raw interrupt is generated."; };
        };

        field {
            name = "raw_rx_bq_alfull_int";
            desc = "Raw interrupt of the almost-full buff descriptor queue in the RX direction, cleared by writing 1 to this bit";
            sw = rw;
            hw = w;
            onwrite = woclr;
            encode = RAW_PMU_INT_raw_rx_bq_alfull_int_enum;
            reset = 0x0;
        } raw_rx_bq_alfull_int[4:4];

        enum RAW_PMU_INT_raw_rx_fq_empty_int_enum {
            NO_RAW_INTERRUPT = 0 { name = "No Raw Interrupt"; desc = "No raw interrupt is generated."; };
            RAW_INTERRUPT_GENERATED = 1 { name = "Raw Interrupt Generated"; desc = "A raw interrupt is generated."; };
        };

        field {
            name = "raw_rx_fq_empty_int";
            desc = "Raw interrupt of the empty idle descriptor queue in the RX direction, cleared by writing 1 to this bit";
            sw = rw;
            hw = w;
            onwrite = woclr;
            encode = RAW_PMU_INT_raw_rx_fq_empty_int_enum;
            reset = 0x0;
        } raw_rx_fq_empty_int[3:3];

        enum RAW_PMU_INT_raw_rx_fq_full_int_enum {
            NO_RAW_INTERRUPT = 0 { name = "No Raw Interrupt"; desc = "No raw interrupt is generated."; };
            RAW_INTERRUPT_GENERATED = 1 { name = "Raw Interrupt Generated"; desc = "A raw interrupt is generated."; };
        };

        field {
            name = "raw_rx_fq_full_int";
            desc = "Raw interrupt of the full idle descriptor queue in the RX direction, cleared by writing 1 to this bit";
            sw = rw;
            hw = w;
            onwrite = woclr;
            encode = RAW_PMU_INT_raw_rx_fq_full_int_enum;
            reset = 0x0;
        } raw_rx_fq_full_int[2:2];

        enum RAW_PMU_INT_raw_rx_fq_alempty_int_enum {
            NO_RAW_INTERRUPT = 0 { name = "No Raw Interrupt"; desc = "No raw interrupt is generated."; };
            RAW_INTERRUPT_GENERATED = 1 { name = "Raw Interrupt Generated"; desc = "A raw interrupt is generated."; };
        };

        field {
            name = "raw_rx_fq_alempty_int";
            desc = "Raw interrupt of the almost-empty idle descriptor queue in the RX direction, cleared by writing 1 to this bit";
            sw = rw;
            hw = w;
            onwrite = woclr;
            encode = RAW_PMU_INT_raw_rx_fq_alempty_int_enum;
            reset = 0x0;
        } raw_rx_fq_alempty_int[1:1];

        enum RAW_PMU_INT_raw_rx_fq_alfull_int_enum {
            NO_RAW_INTERRUPT = 0 { name = "No Raw Interrupt"; desc = "No raw interrupt is generated."; };
            RAW_INTERRUPT_GENERATED = 1 { name = "Raw Interrupt Generated"; desc = "A raw interrupt is generated."; };
        };

        field {
            name = "raw_rx_fq_alfull_int";
            desc = "Raw interrupt of the almost-full idle descriptor queue in the RX direction, cleared by writing 1 to this bit";
            sw = rw;
            hw = w;
            onwrite = woclr;
            encode = RAW_PMU_INT_raw_rx_fq_alfull_int_enum;
            reset = 0x0;
        } raw_rx_fq_alfull_int[0:0];
    } RAW_PMU_INT @ 0x5C0;

    reg {
        name = "PMU raw interrupt enable register";
        desc = "ENA_PMU_INT is a PMU raw interrupt enable register.

Bit assignment identical to RAW_PMU_INT. Linux hix5hd2_gmac.c writes 0 at init (all disabled), vendor U-Boot writes 0 (~RAW_INT_ALL_MASK).

Data sheet 5.7 ENA_PMU_INT (offset 0x5C4, printed page 5-87, `Hi3516AV200-Datasheet.txt` line 34668).
Hi3516 V100 data sheet (Chinese original) 5.6 ENA_PMU_INT (offset 0x5C4, printed page 5-99, `Hi3516-Datasheet.txt` line 33843).";

        enum ENA_PMU_INT_ena_mac_fifo_err_int_enum {
            DISABLED = 0 { name = "Disabled"; desc = "disabled"; };
            ENABLED = 1 { name = "Enabled"; desc = "enabled"; };
        };

        field {
            name = "ena_mac_fifo_err_int";
            desc = "Internal FIFO empty and full error interrupt enable in the MAC address";
            sw = rw;
            hw = r;
            encode = ENA_PMU_INT_ena_mac_fifo_err_int_enum;
            reset = 0x0;
        } ena_mac_fifo_err_int[30:30];

        enum ENA_PMU_INT_ena_tx_rq_in_timeout_int_enum {
            DISABLED = 0 { name = "Disabled"; desc = "disabled"; };
            ENABLED = 1 { name = "Enabled"; desc = "enabled"; };
        };

        field {
            name = "ena_tx_rq_in_timeout_int";
            desc = "Descriptor enqueue timeout interrupt enable in the RQ queue in the TX direction";
            sw = rw;
            hw = r;
            encode = ENA_PMU_INT_ena_tx_rq_in_timeout_int_enum;
            reset = 0x0;
        } ena_tx_rq_in_timeout_int[29:29];

        enum ENA_PMU_INT_ena_rx_bq_in_timeout_int_enum {
            DISABLED = 0 { name = "Disabled"; desc = "disabled"; };
            ENABLED = 1 { name = "Enabled"; desc = "enabled"; };
        };

        field {
            name = "ena_rx_bq_in_timeout_int";
            desc = "Descriptor enqueue timeout interrupt enable in the BQ queue in the RX direction";
            sw = rw;
            hw = r;
            encode = ENA_PMU_INT_ena_rx_bq_in_timeout_int_enum;
            reset = 0x0;
        } ena_rx_bq_in_timeout_int[28:28];

        enum ENA_PMU_INT_ena_txoutcff_full_int_enum {
            DISABLED = 0 { name = "Disabled"; desc = "disabled"; };
            ENABLED = 1 { name = "Enabled"; desc = "enabled"; };
        };

        field {
            name = "ena_txoutcff_full_int";
            desc = "Full DESC_OUTCFF interrupt enable in the TX direction";
            sw = rw;
            hw = r;
            encode = ENA_PMU_INT_ena_txoutcff_full_int_enum;
            reset = 0x0;
        } ena_txoutcff_full_int[27:27];

        enum ENA_PMU_INT_ena_txoutcff_empty_int_enum {
            DISABLED = 0 { name = "Disabled"; desc = "disabled"; };
            ENABLED = 1 { name = "Enabled"; desc = "enabled"; };
        };

        field {
            name = "ena_txoutcff_empty_int";
            desc = "Empty DESC_OUTCFF interrupt enable in the TX direction";
            sw = rw;
            hw = r;
            encode = ENA_PMU_INT_ena_txoutcff_empty_int_enum;
            reset = 0x0;
        } ena_txoutcff_empty_int[26:26];

        enum ENA_PMU_INT_ena_txcff_full_int_enum {
            DISABLED = 0 { name = "Disabled"; desc = "disabled"; };
            ENABLED = 1 { name = "Enabled"; desc = "enabled"; };
        };

        field {
            name = "ena_txcff_full_int";
            desc = "Full DESC_FIFO interrupt enable in the TX direction";
            sw = rw;
            hw = r;
            encode = ENA_PMU_INT_ena_txcff_full_int_enum;
            reset = 0x0;
        } ena_txcff_full_int[25:25];

        enum ENA_PMU_INT_ena_txcff_empty_int_enum {
            DISABLED = 0 { name = "Disabled"; desc = "disabled"; };
            ENABLED = 1 { name = "Enabled"; desc = "enabled"; };
        };

        field {
            name = "ena_txcff_empty_int";
            desc = "Empty DESC_FIFO interrupt enable in the TX direction";
            sw = rw;
            hw = r;
            encode = ENA_PMU_INT_ena_txcff_empty_int_enum;
            reset = 0x0;
        } ena_txcff_empty_int[24:24];

        enum ENA_PMU_INT_ena_rxoutcff_full_int_enum {
            DISABLED = 0 { name = "Disabled"; desc = "disabled"; };
            ENABLED = 1 { name = "Enabled"; desc = "enabled"; };
        };

        field {
            name = "ena_rxoutcff_full_int";
            desc = "Full DESC_OUTCFF interrupt enable in the RX direction";
            sw = rw;
            hw = r;
            encode = ENA_PMU_INT_ena_rxoutcff_full_int_enum;
            reset = 0x0;
        } ena_rxoutcff_full_int[23:23];

        enum ENA_PMU_INT_ena_rxoutcff_empty_int_enum {
            DISABLED = 0 { name = "Disabled"; desc = "disabled"; };
            ENABLED = 1 { name = "Enabled"; desc = "enabled"; };
        };

        field {
            name = "ena_rxoutcff_empty_int";
            desc = "Empty DESC_OUTCFF interrupt enable in the RX direction";
            sw = rw;
            hw = r;
            encode = ENA_PMU_INT_ena_rxoutcff_empty_int_enum;
            reset = 0x0;
        } ena_rxoutcff_empty_int[22:22];

        enum ENA_PMU_INT_ena_rxcff_full_int_enum {
            DISABLED = 0 { name = "Disabled"; desc = "disabled"; };
            ENABLED = 1 { name = "Enabled"; desc = "enabled"; };
        };

        field {
            name = "ena_rxcff_full_int";
            desc = "Full DESC_FIFO interrupt enable in the RX direction";
            sw = rw;
            hw = r;
            encode = ENA_PMU_INT_ena_rxcff_full_int_enum;
            reset = 0x0;
        } ena_rxcff_full_int[21:21];

        enum ENA_PMU_INT_ena_rxcff_empty_int_enum {
            DISABLED = 0 { name = "Disabled"; desc = "disabled"; };
            ENABLED = 1 { name = "Enabled"; desc = "enabled"; };
        };

        field {
            name = "ena_rxcff_empty_int";
            desc = "Empty DESC_FIFO interrupt enable in the RX direction";
            sw = rw;
            hw = r;
            encode = ENA_PMU_INT_ena_rxcff_empty_int_enum;
            reset = 0x0;
        } ena_rxcff_empty_int[20:20];

        enum ENA_PMU_INT_ena_tx_rq_in_int_enum {
            DISABLED = 0 { name = "Disabled"; desc = "disabled"; };
            ENABLED = 1 { name = "Enabled"; desc = "enabled"; };
        };

        field {
            name = "ena_tx_rq_in_int";
            desc = "Descriptor (multiple or single) enqueue interrupt enable in the tx_rq queue in the TX direction";
            sw = rw;
            hw = r;
            encode = ENA_PMU_INT_ena_tx_rq_in_int_enum;
            reset = 0x0;
        } ena_tx_rq_in_int[19:19];

        enum ENA_PMU_INT_ena_tx_bq_out_int_enum {
            DISABLED = 0 { name = "Disabled"; desc = "disabled"; };
            ENABLED = 1 { name = "Enabled"; desc = "enabled"; };
        };

        field {
            name = "ena_tx_bq_out_int";
            desc = "Descriptor (multiple or single) dequeue interrupt enable in the tx_bq queue in the TX direction";
            sw = rw;
            hw = r;
            encode = ENA_PMU_INT_ena_tx_bq_out_int_enum;
            reset = 0x0;
        } ena_tx_bq_out_int[18:18];

        enum ENA_PMU_INT_ena_rx_bq_in_int_enum {
            DISABLED = 0 { name = "Disabled"; desc = "disabled"; };
            ENABLED = 1 { name = "Enabled"; desc = "enabled"; };
        };

        field {
            name = "ena_rx_bq_in_int";
            desc = "Descriptor (multiple or single) enqueue interrupt enable in the rx_bq queue in the RX direction";
            sw = rw;
            hw = r;
            encode = ENA_PMU_INT_ena_rx_bq_in_int_enum;
            reset = 0x0;
        } ena_rx_bq_in_int[17:17];

        enum ENA_PMU_INT_ena_rx_fq_out_int_enum {
            DISABLED = 0 { name = "Disabled"; desc = "disabled"; };
            ENABLED = 1 { name = "Enabled"; desc = "enabled"; };
        };

        field {
            name = "ena_rx_fq_out_int";
            desc = "Descriptor (multiple or single) dequeue interrupt enable in the rx_fq queue in the RX direction";
            sw = rw;
            hw = r;
            encode = ENA_PMU_INT_ena_rx_fq_out_int_enum;
            reset = 0x0;
        } ena_rx_fq_out_int[16:16];

        enum ENA_PMU_INT_ena_tx_rq_empty_int_enum {
            DISABLED = 0 { name = "Disabled"; desc = "disabled"; };
            ENABLED = 1 { name = "Enabled"; desc = "enabled"; };
        };

        field {
            name = "ena_tx_rq_empty_int";
            desc = "Empty recycle descriptor queue interrupt enable in the TX direction";
            sw = rw;
            hw = r;
            encode = ENA_PMU_INT_ena_tx_rq_empty_int_enum;
            reset = 0x0;
        } ena_tx_rq_empty_int[15:15];

        enum ENA_PMU_INT_ena_tx_rq_full_int_enum {
            DISABLED = 0 { name = "Disabled"; desc = "disabled"; };
            ENABLED = 1 { name = "Enabled"; desc = "enabled"; };
        };

        field {
            name = "ena_tx_rq_full_int";
            desc = "Full recycle descriptor queue interrupt enable in the TX direction";
            sw = rw;
            hw = r;
            encode = ENA_PMU_INT_ena_tx_rq_full_int_enum;
            reset = 0x0;
        } ena_tx_rq_full_int[14:14];

        enum ENA_PMU_INT_ena_tx_rq_alempty_int_enum {
            DISABLED = 0 { name = "Disabled"; desc = "disabled"; };
            ENABLED = 1 { name = "Enabled"; desc = "enabled"; };
        };

        field {
            name = "ena_tx_rq_alempty_int";
            desc = "Almost-empty recycle descriptor queue interrupt enable in the TX direction";
            sw = rw;
            hw = r;
            encode = ENA_PMU_INT_ena_tx_rq_alempty_int_enum;
            reset = 0x0;
        } ena_tx_rq_alempty_int[13:13];

        enum ENA_PMU_INT_ena_tx_rq_alfull_int_enum {
            DISABLED = 0 { name = "Disabled"; desc = "disabled"; };
            ENABLED = 1 { name = "Enabled"; desc = "enabled"; };
        };

        field {
            name = "ena_tx_rq_alfull_int";
            desc = "Almost-full recycle descriptor queue interrupt enable in the TX direction";
            sw = rw;
            hw = r;
            encode = ENA_PMU_INT_ena_tx_rq_alfull_int_enum;
            reset = 0x0;
        } ena_tx_rq_alfull_int[12:12];

        enum ENA_PMU_INT_ena_tx_bq_empty_int_enum {
            DISABLED = 0 { name = "Disabled"; desc = "disabled"; };
            ENABLED = 1 { name = "Enabled"; desc = "enabled"; };
        };

        field {
            name = "ena_tx_bq_empty_int";
            desc = "Empty buff descriptor queue interrupt enable in the TX direction";
            sw = rw;
            hw = r;
            encode = ENA_PMU_INT_ena_tx_bq_empty_int_enum;
            reset = 0x0;
        } ena_tx_bq_empty_int[11:11];

        enum ENA_PMU_INT_ena_tx_bq_full_int_enum {
            ENABLED = 1 { name = "Enabled"; desc = "enabled"; };
            DISABLED = 0 { name = "Disabled"; desc = "disabled"; };
        };

        field {
            name = "ena_tx_bq_full_int";
            desc = "Full buff descriptor queue interrupt enable in the TX direction";
            sw = rw;
            hw = r;
            encode = ENA_PMU_INT_ena_tx_bq_full_int_enum;
            reset = 0x0;
        } ena_tx_bq_full_int[10:10];

        enum ENA_PMU_INT_ena_tx_bq_alempty_int_enum {
            DISABLED = 0 { name = "Disabled"; desc = "disabled"; };
            ENABLED = 1 { name = "Enabled"; desc = "enabled"; };
        };

        field {
            name = "ena_tx_bq_alempty_int";
            desc = "Almost-empty buff descriptor queue interrupt enable in the TX direction";
            sw = rw;
            hw = r;
            encode = ENA_PMU_INT_ena_tx_bq_alempty_int_enum;
            reset = 0x0;
        } ena_tx_bq_alempty_int[9:9];

        enum ENA_PMU_INT_ena_tx_bq_alfull_int_enum {
            DISABLED = 0 { name = "Disabled"; desc = "disabled"; };
            ENABLED = 1 { name = "Enabled"; desc = "enabled"; };
        };

        field {
            name = "ena_tx_bq_alfull_int";
            desc = "Almost-full buff descriptor queue interrupt enable in the TX direction";
            sw = rw;
            hw = r;
            encode = ENA_PMU_INT_ena_tx_bq_alfull_int_enum;
            reset = 0x0;
        } ena_tx_bq_alfull_int[8:8];

        enum ENA_PMU_INT_ena_rx_bq_empty_int_enum {
            DISABLED = 0 { name = "Disabled"; desc = "disabled"; };
            ENABLED = 1 { name = "Enabled"; desc = "enabled"; };
        };

        field {
            name = "ena_rx_bq_empty_int";
            desc = "Empty buff descriptor queue interrupt enable in the RX direction";
            sw = rw;
            hw = r;
            encode = ENA_PMU_INT_ena_rx_bq_empty_int_enum;
            reset = 0x0;
        } ena_rx_bq_empty_int[7:7];

        enum ENA_PMU_INT_ena_rx_bq_full_int_enum {
            DISABLED = 0 { name = "Disabled"; desc = "disabled"; };
            ENABLED = 1 { name = "Enabled"; desc = "enabled"; };
        };

        field {
            name = "ena_rx_bq_full_int";
            desc = "Full buff descriptor queue interrupt enable in the RX direction";
            sw = rw;
            hw = r;
            encode = ENA_PMU_INT_ena_rx_bq_full_int_enum;
            reset = 0x0;
        } ena_rx_bq_full_int[6:6];

        enum ENA_PMU_INT_ena_rx_bq_alempty_int_enum {
            DISABLED = 0 { name = "Disabled"; desc = "disabled"; };
            ENABLED = 1 { name = "Enabled"; desc = "enabled"; };
        };

        field {
            name = "ena_rx_bq_alempty_int";
            desc = "Almost-empty buff descriptor queue interrupt enable in the RX direction";
            sw = rw;
            hw = r;
            encode = ENA_PMU_INT_ena_rx_bq_alempty_int_enum;
            reset = 0x0;
        } ena_rx_bq_alempty_int[5:5];

        enum ENA_PMU_INT_ena_rx_bq_alfull_int_enum {
            DISABLED = 0 { name = "Disabled"; desc = "disabled"; };
            ENABLED = 1 { name = "Enabled"; desc = "enabled"; };
        };

        field {
            name = "ena_rx_bq_alfull_int";
            desc = "Almost-full buff descriptor queue interrupt enable in the RX direction";
            sw = rw;
            hw = r;
            encode = ENA_PMU_INT_ena_rx_bq_alfull_int_enum;
            reset = 0x0;
        } ena_rx_bq_alfull_int[4:4];

        enum ENA_PMU_INT_ena_rx_fq_empty_int_enum {
            DISABLED = 0 { name = "Disabled"; desc = "disabled"; };
            ENABLED = 1 { name = "Enabled"; desc = "enabled"; };
        };

        field {
            name = "ena_rx_fq_empty_int";
            desc = "Empty idle descriptor queue interrupt enable in the RX direction";
            sw = rw;
            hw = r;
            encode = ENA_PMU_INT_ena_rx_fq_empty_int_enum;
            reset = 0x0;
        } ena_rx_fq_empty_int[3:3];

        enum ENA_PMU_INT_ena_rx_fq_full_int_enum {
            DISABLED = 0 { name = "Disabled"; desc = "disabled"; };
            ENABLED = 1 { name = "Enabled"; desc = "enabled"; };
        };

        field {
            name = "ena_rx_fq_full_int";
            desc = "Full idle descriptor queue interrupt enable in the RX direction";
            sw = rw;
            hw = r;
            encode = ENA_PMU_INT_ena_rx_fq_full_int_enum;
            reset = 0x0;
        } ena_rx_fq_full_int[2:2];

        enum ENA_PMU_INT_ena_rx_fq_alempty_int_enum {
            DISABLED = 0 { name = "Disabled"; desc = "disabled"; };
            ENABLED = 1 { name = "Enabled"; desc = "enabled"; };
        };

        field {
            name = "ena_rx_fq_alempty_int";
            desc = "Almost-empty idle descriptor queue interrupt enable in the RX direction";
            sw = rw;
            hw = r;
            encode = ENA_PMU_INT_ena_rx_fq_alempty_int_enum;
            reset = 0x0;
        } ena_rx_fq_alempty_int[1:1];

        enum ENA_PMU_INT_ena_rx_fq_alfull_int_enum {
            DISABLED = 0 { name = "Disabled"; desc = "disabled"; };
            ENABLED = 1 { name = "Enabled"; desc = "enabled"; };
        };

        field {
            name = "ena_rx_fq_alfull_int";
            desc = "Almost-full idle descriptor queue interrupt enable in the RX direction";
            sw = rw;
            hw = r;
            encode = ENA_PMU_INT_ena_rx_fq_alfull_int_enum;
            reset = 0x0;
        } ena_rx_fq_alfull_int[0:0];
    } ENA_PMU_INT @ 0x5C4;

    reg {
        name = "PMU interrupt status register";
        desc = "STATUS_PMU_INT is a PMU interrupt status register.

Masked interrupt status (RAW_PMU_INT AND ENA_PMU_INT); read by the vendor U-Boot (higmac_read_irqstatus). The data sheet lists the bits as RW; modelled read-only. On the Hi3516 V100 the data sheet text for this register is a copy of the ENA_PMU_INT text (\"interrupt enable\") but it keeps the bit names status_*.

Data sheet 5.7 STATUS_PMU_INT (offset 0x5C8, printed page 5-90, `Hi3516AV200-Datasheet.txt` line 34867).";

        enum STATUS_PMU_INT_status_mac_fifo_err_int_enum {
            NO_INTERRUPT_GENERATED = 0 { name = "No Interrupt Generated"; desc = "No interrupt is generated."; };
            INTERRUPT_GENERATED = 1 { name = "Interrupt Generated"; desc = "An interrupt is generated."; };
        };

        field {
            name = "status_mac_fifo_err_int";
            desc = "Status of the MAC internal FIFO empty and full error interrupt";
            sw = r;
            hw = w;
            encode = STATUS_PMU_INT_status_mac_fifo_err_int_enum;
            reset = 0x0;
        } status_mac_fifo_err_int[30:30];

        enum STATUS_PMU_INT_status_tx_rq_in_timeout_int_enum {
            NO_INTERRUPT_GENERATED = 0 { name = "No Interrupt Generated"; desc = "No interrupt is generated."; };
            INTERRUPT_GENERATED = 1 { name = "Interrupt Generated"; desc = "An interrupt is generated."; };
        };

        field {
            name = "status_tx_rq_in_timeout_int";
            desc = "Status of the TX RQ queue descriptor enqueue timeout interrupt";
            sw = r;
            hw = w;
            encode = STATUS_PMU_INT_status_tx_rq_in_timeout_int_enum;
            reset = 0x0;
        } status_tx_rq_in_timeout_int[29:29];

        enum STATUS_PMU_INT_status_rx_bq_in_timeout_int_enum {
            NO_INTERRUPT_GENERATED = 0 { name = "No Interrupt Generated"; desc = "No interrupt is generated."; };
            INTERRUPT_GENERATED = 1 { name = "Interrupt Generated"; desc = "An interrupt is generated."; };
        };

        field {
            name = "status_rx_bq_in_timeout_int";
            desc = "Status of the RX BQ queue descriptor enqueue timeout interrupt";
            sw = r;
            hw = w;
            encode = STATUS_PMU_INT_status_rx_bq_in_timeout_int_enum;
            reset = 0x0;
        } status_rx_bq_in_timeout_int[28:28];

        enum STATUS_PMU_INT_status_txoutcff_full_int_enum {
            NO_INTERRUPT_GENERATED = 0 { name = "No Interrupt Generated"; desc = "No interrupt is generated."; };
            INTERRUPT_GENERATED = 1 { name = "Interrupt Generated"; desc = "An interrupt is generated."; };
        };

        field {
            name = "status_txoutcff_full_int";
            desc = "Status of the TX DESC_OUTCFF full interrupt";
            sw = r;
            hw = w;
            encode = STATUS_PMU_INT_status_txoutcff_full_int_enum;
            reset = 0x0;
        } status_txoutcff_full_int[27:27];

        enum STATUS_PMU_INT_status_txoutcff_empty_int_enum {
            NO_INTERRUPT_GENERATED = 0 { name = "No Interrupt Generated"; desc = "No interrupt is generated."; };
            INTERRUPT_GENERATED = 1 { name = "Interrupt Generated"; desc = "An interrupt is generated."; };
        };

        field {
            name = "status_txoutcff_empty_int";
            desc = "Status of the TX DESC_OUTCFF empty interrupt";
            sw = r;
            hw = w;
            encode = STATUS_PMU_INT_status_txoutcff_empty_int_enum;
            reset = 0x0;
        } status_txoutcff_empty_int[26:26];

        enum STATUS_PMU_INT_status_txcff_full_int_enum {
            NO_INTERRUPT_GENERATED = 0 { name = "No Interrupt Generated"; desc = "No interrupt is generated."; };
            INTERRUPT_GENERATED = 1 { name = "Interrupt Generated"; desc = "An interrupt is generated."; };
        };

        field {
            name = "status_txcff_full_int";
            desc = "Status of the TX DESC_FIFO full interrupt";
            sw = r;
            hw = w;
            encode = STATUS_PMU_INT_status_txcff_full_int_enum;
            reset = 0x0;
        } status_txcff_full_int[25:25];

        enum STATUS_PMU_INT_status_txcff_empty_int_enum {
            NO_INTERRUPT_GENERATED = 0 { name = "No Interrupt Generated"; desc = "No interrupt is generated."; };
            INTERRUPT_GENERATED = 1 { name = "Interrupt Generated"; desc = "An interrupt is generated."; };
        };

        field {
            name = "status_txcff_empty_int";
            desc = "Status of the TX DESC_FIFO empty interrupt";
            sw = r;
            hw = w;
            encode = STATUS_PMU_INT_status_txcff_empty_int_enum;
            reset = 0x0;
        } status_txcff_empty_int[24:24];

        enum STATUS_PMU_INT_status_rxoutcff_full_int_enum {
            NO_INTERRUPT_GENERATED = 0 { name = "No Interrupt Generated"; desc = "No interrupt is generated."; };
            INTERRUPT_GENERATED = 1 { name = "Interrupt Generated"; desc = "An interrupt is generated."; };
        };

        field {
            name = "status_rxoutcff_full_int";
            desc = "Status of the RX DESC_OUTCFF full interrupt";
            sw = r;
            hw = w;
            encode = STATUS_PMU_INT_status_rxoutcff_full_int_enum;
            reset = 0x0;
        } status_rxoutcff_full_int[23:23];

        enum STATUS_PMU_INT_status_rxoutcff_empty_int_enum {
            NO_INTERRUPT_GENERATED = 0 { name = "No Interrupt Generated"; desc = "No interrupt is generated."; };
            INTERRUPT_GENERATED = 1 { name = "Interrupt Generated"; desc = "An interrupt is generated."; };
        };

        field {
            name = "status_rxoutcff_empty_int";
            desc = "Status of the RX DESC_OUTCFF empty interrupt";
            sw = r;
            hw = w;
            encode = STATUS_PMU_INT_status_rxoutcff_empty_int_enum;
            reset = 0x0;
        } status_rxoutcff_empty_int[22:22];

        enum STATUS_PMU_INT_status_rxcff_full_int_enum {
            NO_INTERRUPT_GENERATED = 0 { name = "No Interrupt Generated"; desc = "No interrupt is generated."; };
            INTERRUPT_GENERATED = 1 { name = "Interrupt Generated"; desc = "An interrupt is generated."; };
        };

        field {
            name = "status_rxcff_full_int";
            desc = "Status of the RX DESC_FIFO full interrupt";
            sw = r;
            hw = w;
            encode = STATUS_PMU_INT_status_rxcff_full_int_enum;
            reset = 0x0;
        } status_rxcff_full_int[21:21];

        enum STATUS_PMU_INT_status_rxcff_empty_int_enum {
            NO_INTERRUPT_GENERATED = 0 { name = "No Interrupt Generated"; desc = "No interrupt is generated."; };
            INTERRUPT_GENERATED = 1 { name = "Interrupt Generated"; desc = "An interrupt is generated."; };
        };

        field {
            name = "status_rxcff_empty_int";
            desc = "Status of the RX DESC_FIFO empty interrupt";
            sw = r;
            hw = w;
            encode = STATUS_PMU_INT_status_rxcff_empty_int_enum;
            reset = 0x0;
        } status_rxcff_empty_int[20:20];

        enum STATUS_PMU_INT_status_tx_rq_in_int_enum {
            NO_INTERRUPT_GENERATED = 0 { name = "No Interrupt Generated"; desc = "No interrupt is generated."; };
            INTERRUPT_GENERATED = 1 { name = "Interrupt Generated"; desc = "An interrupt is generated."; };
        };

        field {
            name = "status_tx_rq_in_int";
            desc = "Status of the tx_rq queue descriptor (multiple or single) enqueue interrupt";
            sw = r;
            hw = w;
            encode = STATUS_PMU_INT_status_tx_rq_in_int_enum;
            reset = 0x0;
        } status_tx_rq_in_int[19:19];

        enum STATUS_PMU_INT_status_tx_bq_out_int_enum {
            NO_INTERRUPT_GENERATED = 0 { name = "No Interrupt Generated"; desc = "No interrupt is generated."; };
            INTERRUPT_GENERATED = 1 { name = "Interrupt Generated"; desc = "An interrupt is generated."; };
        };

        field {
            name = "status_tx_bq_out_int";
            desc = "Status of the tx_bq queue descriptor (multiple or single) dequeue interrupt";
            sw = r;
            hw = w;
            encode = STATUS_PMU_INT_status_tx_bq_out_int_enum;
            reset = 0x0;
        } status_tx_bq_out_int[18:18];

        enum STATUS_PMU_INT_status_rx_bq_in_int_enum {
            NO_INTERRUPT_GENERATED = 0 { name = "No Interrupt Generated"; desc = "No interrupt is generated."; };
            INTERRUPT_GENERATED = 1 { name = "Interrupt Generated"; desc = "An interrupt is generated."; };
        };

        field {
            name = "status_rx_bq_in_int";
            desc = "Status of the rx_bq queue descriptor (multiple or single) enqueue interrupt";
            sw = r;
            hw = w;
            encode = STATUS_PMU_INT_status_rx_bq_in_int_enum;
            reset = 0x0;
        } status_rx_bq_in_int[17:17];

        enum STATUS_PMU_INT_status_rx_fq_out_int_enum {
            NO_INTERRUPT_GENERATED = 0 { name = "No Interrupt Generated"; desc = "No interrupt is generated."; };
            INTERRUPT_GENERATED = 1 { name = "Interrupt Generated"; desc = "An interrupt is generated."; };
        };

        field {
            name = "status_rx_fq_out_int";
            desc = "Status of the rx_fq queue descriptor (multiple or single) dequeue interrupt";
            sw = r;
            hw = w;
            encode = STATUS_PMU_INT_status_rx_fq_out_int_enum;
            reset = 0x0;
        } status_rx_fq_out_int[16:16];

        enum STATUS_PMU_INT_status_tx_rq_empty_int_enum {
            NO_INTERRUPT_GENERATED = 0 { name = "No Interrupt Generated"; desc = "No interrupt is generated."; };
            INTERRUPT_GENERATED = 1 { name = "Interrupt Generated"; desc = "An interrupt is generated."; };
        };

        field {
            name = "status_tx_rq_empty_int";
            desc = "Status of the TX recycle descriptor queue empty interrupt";
            sw = r;
            hw = w;
            encode = STATUS_PMU_INT_status_tx_rq_empty_int_enum;
            reset = 0x0;
        } status_tx_rq_empty_int[15:15];

        enum STATUS_PMU_INT_status_tx_rq_full_int_enum {
            NO_INTERRUPT_GENERATED = 0 { name = "No Interrupt Generated"; desc = "No interrupt is generated."; };
            INTERRUPT_GENERATED = 1 { name = "Interrupt Generated"; desc = "An interrupt is generated."; };
        };

        field {
            name = "status_tx_rq_full_int";
            desc = "Status of the TX recycle descriptor queue full interrupt";
            sw = r;
            hw = w;
            encode = STATUS_PMU_INT_status_tx_rq_full_int_enum;
            reset = 0x0;
        } status_tx_rq_full_int[14:14];

        enum STATUS_PMU_INT_status_tx_rq_alempty_int_enum {
            NO_INTERRUPT_GENERATED = 0 { name = "No Interrupt Generated"; desc = "No interrupt is generated."; };
            INTERRUPT_GENERATED = 1 { name = "Interrupt Generated"; desc = "An interrupt is generated."; };
        };

        field {
            name = "status_tx_rq_alempty_int";
            desc = "Status of the TX recycle descriptor queue almost-empty interrupt";
            sw = r;
            hw = w;
            encode = STATUS_PMU_INT_status_tx_rq_alempty_int_enum;
            reset = 0x0;
        } status_tx_rq_alempty_int[13:13];

        enum STATUS_PMU_INT_status_tx_rq_alfull_int_enum {
            NO_INTERRUPT_GENERATED = 0 { name = "No Interrupt Generated"; desc = "No interrupt is generated."; };
            INTERRUPT_GENERATED = 1 { name = "Interrupt Generated"; desc = "An interrupt is generated."; };
        };

        field {
            name = "status_tx_rq_alfull_int";
            desc = "Status of the TX recycle descriptor queue almost-full interrupt";
            sw = r;
            hw = w;
            encode = STATUS_PMU_INT_status_tx_rq_alfull_int_enum;
            reset = 0x0;
        } status_tx_rq_alfull_int[12:12];

        enum STATUS_PMU_INT_status_tx_bq_empty_int_enum {
            NO_INTERRUPT_GENERATED = 0 { name = "No Interrupt Generated"; desc = "No interrupt is generated."; };
            INTERRUPT_GENERATED = 1 { name = "Interrupt Generated"; desc = "An interrupt is generated."; };
        };

        field {
            name = "status_tx_bq_empty_int";
            desc = "Status of the TX buff descriptor queue empty interrupt";
            sw = r;
            hw = w;
            encode = STATUS_PMU_INT_status_tx_bq_empty_int_enum;
            reset = 0x0;
        } status_tx_bq_empty_int[11:11];

        enum STATUS_PMU_INT_status_tx_bq_full_int_enum {
            NO_INTERRUPT_GENERATED = 0 { name = "No Interrupt Generated"; desc = "No interrupt is generated."; };
            INTERRUPT_GENERATED = 1 { name = "Interrupt Generated"; desc = "An interrupt is generated."; };
        };

        field {
            name = "status_tx_bq_full_int";
            desc = "Status of the TX buff descriptor queue full interrupt";
            sw = r;
            hw = w;
            encode = STATUS_PMU_INT_status_tx_bq_full_int_enum;
            reset = 0x0;
        } status_tx_bq_full_int[10:10];

        enum STATUS_PMU_INT_status_tx_bq_alempty_int_enum {
            NO_INTERRUPT_GENERATED = 0 { name = "No Interrupt Generated"; desc = "No interrupt is generated."; };
            INTERRUPT_GENERATED = 1 { name = "Interrupt Generated"; desc = "An interrupt is generated."; };
        };

        field {
            name = "status_tx_bq_alempty_int";
            desc = "Status of the TX buff descriptor queue almost-empty interrupt";
            sw = r;
            hw = w;
            encode = STATUS_PMU_INT_status_tx_bq_alempty_int_enum;
            reset = 0x0;
        } status_tx_bq_alempty_int[9:9];

        enum STATUS_PMU_INT_status_tx_bq_alfull_int_enum {
            INTERRUPT_GENERATED = 1 { name = "Interrupt Generated"; desc = "An interrupt is generated."; };
            NO_INTERRUPT_GENERATED = 0 { name = "No Interrupt Generated"; desc = "No interrupt is generated."; };
        };

        field {
            name = "status_tx_bq_alfull_int";
            desc = "Status of the TX buff descriptor queue almost-full interrupt";
            sw = r;
            hw = w;
            encode = STATUS_PMU_INT_status_tx_bq_alfull_int_enum;
            reset = 0x0;
        } status_tx_bq_alfull_int[8:8];

        enum STATUS_PMU_INT_status_rx_bq_empty_int_enum {
            INTERRUPT_GENERATED = 1 { name = "Interrupt Generated"; desc = "An interrupt is generated."; };
            NO_INTERRUPT_GENERATED = 0 { name = "No Interrupt Generated"; desc = "No interrupt is generated."; };
        };

        field {
            name = "status_rx_bq_empty_int";
            desc = "Status of the RX buff descriptor queue empty interrupt";
            sw = r;
            hw = w;
            encode = STATUS_PMU_INT_status_rx_bq_empty_int_enum;
            reset = 0x0;
        } status_rx_bq_empty_int[7:7];

        enum STATUS_PMU_INT_status_rx_bq_full_int_enum {
            NO_INTERRUPT_GENERATED = 0 { name = "No Interrupt Generated"; desc = "No interrupt is generated."; };
            INTERRUPT_GENERATED = 1 { name = "Interrupt Generated"; desc = "An interrupt is generated."; };
        };

        field {
            name = "status_rx_bq_full_int";
            desc = "Status of the RX buff descriptor queue full interrupt";
            sw = r;
            hw = w;
            encode = STATUS_PMU_INT_status_rx_bq_full_int_enum;
            reset = 0x0;
        } status_rx_bq_full_int[6:6];

        enum STATUS_PMU_INT_status_rx_bq_alempty_int_enum {
            NO_INTERRUPT_GENERATED = 0 { name = "No Interrupt Generated"; desc = "No interrupt is generated."; };
            INTERRUPT_GENERATED = 1 { name = "Interrupt Generated"; desc = "An interrupt is generated."; };
        };

        field {
            name = "status_rx_bq_alempty_int";
            desc = "Status of the RX buff descriptor queue almost-empty interrupt";
            sw = r;
            hw = w;
            encode = STATUS_PMU_INT_status_rx_bq_alempty_int_enum;
            reset = 0x0;
        } status_rx_bq_alempty_int[5:5];

        enum STATUS_PMU_INT_status_rx_bq_alfull_int_enum {
            NO_INTERRUPT_GENERATED = 0 { name = "No Interrupt Generated"; desc = "No interrupt is generated."; };
            INTERRUPT_GENERATED = 1 { name = "Interrupt Generated"; desc = "An interrupt is generated."; };
        };

        field {
            name = "status_rx_bq_alfull_int";
            desc = "Status of the RX buff descriptor queue almost-full interrupt";
            sw = r;
            hw = w;
            encode = STATUS_PMU_INT_status_rx_bq_alfull_int_enum;
            reset = 0x0;
        } status_rx_bq_alfull_int[4:4];

        enum STATUS_PMU_INT_status_rx_fq_empty_int_enum {
            NO_INTERRUPT_GENERATED = 0 { name = "No Interrupt Generated"; desc = "No interrupt is generated."; };
            INTERRUPT_GENERATED = 1 { name = "Interrupt Generated"; desc = "An interrupt is generated."; };
        };

        field {
            name = "status_rx_fq_empty_int";
            desc = "Status of the RX idle descriptor queue empty interrupt";
            sw = r;
            hw = w;
            encode = STATUS_PMU_INT_status_rx_fq_empty_int_enum;
            reset = 0x0;
        } status_rx_fq_empty_int[3:3];

        enum STATUS_PMU_INT_status_rx_fq_full_int_enum {
            NO_INTERRUPT_GENERATED = 0 { name = "No Interrupt Generated"; desc = "No interrupt is generated."; };
            INTERRUPT_GENERATED = 1 { name = "Interrupt Generated"; desc = "An interrupt is generated."; };
        };

        field {
            name = "status_rx_fq_full_int";
            desc = "Status of the RX idle descriptor queue full interrupt";
            sw = r;
            hw = w;
            encode = STATUS_PMU_INT_status_rx_fq_full_int_enum;
            reset = 0x0;
        } status_rx_fq_full_int[2:2];

        enum STATUS_PMU_INT_status_rx_fq_alempty_int_enum {
            NO_INTERRUPT_GENERATED = 0 { name = "No Interrupt Generated"; desc = "No interrupt is generated."; };
            INTERRUPT_GENERATED = 1 { name = "Interrupt Generated"; desc = "An interrupt is generated."; };
        };

        field {
            name = "status_rx_fq_alempty_int";
            desc = "Status of the RX idle descriptor queue almost-empty interrupt";
            sw = r;
            hw = w;
            encode = STATUS_PMU_INT_status_rx_fq_alempty_int_enum;
            reset = 0x0;
        } status_rx_fq_alempty_int[1:1];

        enum STATUS_PMU_INT_status_rx_fq_alfull_int_enum {
            NO_INTERRUPT_GENERATED = 0 { name = "No Interrupt Generated"; desc = "No interrupt is generated."; };
            INTERRUPT_GENERATED = 1 { name = "Interrupt Generated"; desc = "An interrupt is generated."; };
        };

        field {
            name = "status_rx_fq_alfull_int";
            desc = "Status of the RX idle descriptor queue almost-full interrupt";
            sw = r;
            hw = w;
            encode = STATUS_PMU_INT_status_rx_fq_alfull_int_enum;
            reset = 0x0;
        } status_rx_fq_alfull_int[0:0];
    } STATUS_PMU_INT @ 0x5C8;

    reg {
        name = "Cff read/write descriptor enable register";
        desc = "DESC_WR_RD_ENA is a cff read/write descriptor enable register.

Linux writes 0xF to enable all four descriptor engines and 0 to disable them; vendor U-Boot higmac_desc_enable sets the same four bits.

Data sheet 5.7 DESC_WR_RD_ENA (offset 0x5CC, printed page 5-93, `Hi3516AV200-Datasheet.txt` line 35076).
Hi3516 V100 data sheet (Chinese original) 5.6 DESC_WR_RD_ENA (offset 0x5CC, printed page 5-106, `Hi3516-Datasheet.txt` line 34349).";

        enum DESC_WR_RD_ENA_rx_outcff_wr_desc_ena_enum {
            DISABLED = 0 { name = "Disabled"; desc = "disabled"; };
            ENABLED = 1 { name = "Enabled"; desc = "enabled"; };
        };

        field {
            name = "rx_outcff_wr_desc_ena";
            desc = "RX_OUTCFF write descriptor to RX_BQ enable in the RX direction";
            sw = rw;
            hw = r;
            encode = DESC_WR_RD_ENA_rx_outcff_wr_desc_ena_enum;
            reset = 0x0;
        } rx_outcff_wr_desc_ena[3:3];

        enum DESC_WR_RD_ENA_rx_cff_rd_desc_ena_enum {
            DISABLED = 0 { name = "Disabled"; desc = "disabled"; };
            ENABLED = 1 { name = "Enabled"; desc = "enabled"; };
        };

        field {
            name = "rx_cff_rd_desc_ena";
            desc = "RX_CFF read descriptor from the idle descriptor queue enable in the RX direction";
            sw = rw;
            hw = r;
            encode = DESC_WR_RD_ENA_rx_cff_rd_desc_ena_enum;
            reset = 0x0;
        } rx_cff_rd_desc_ena[2:2];

        enum DESC_WR_RD_ENA_tx_outcff_wr_desc_ena_enum {
            DISABLED = 0 { name = "Disabled"; desc = "disabled"; };
            ENABLED = 1 { name = "Enabled"; desc = "enabled"; };
        };

        field {
            name = "tx_outcff_wr_desc_ena";
            desc = "TX_OUTCFF write descriptor to TX_RQ enable in the TX direction";
            sw = rw;
            hw = r;
            encode = DESC_WR_RD_ENA_tx_outcff_wr_desc_ena_enum;
            reset = 0x0;
        } tx_outcff_wr_desc_ena[1:1];

        enum DESC_WR_RD_ENA_tx_cff_rd_desc_ena_enum {
            DISABLED = 0 { name = "Disabled"; desc = "disabled"; };
            ENABLED = 1 { name = "Enabled"; desc = "enabled"; };
        };

        field {
            name = "tx_cff_rd_desc_ena";
            desc = "TX_CFF read descriptor from TX_BQ enable in the TX direction";
            sw = rw;
            hw = r;
            encode = DESC_WR_RD_ENA_tx_cff_rd_desc_ena_enum;
            reset = 0x0;
        } tx_cff_rd_desc_ena[0:0];
    } DESC_WR_RD_ENA @ 0x5CC;

    reg {
        name = "Rx_bq or tx_rq enqueue interrupt threshold register";
        desc = "IN_QUEUE_TH is an rx_bq or tx_rq enqueue interrupt threshold register.

Linux writes 1 for both thresholds (RX_BQ_INT_THRESHOLD, TX_RQ_INT_THRESHOLD).

Data sheet 5.7 IN_QUEUE_TH (offset 0x5D8, printed page 5-94, `Hi3516AV200-Datasheet.txt` line 35129).
Hi3516 V100 data sheet (Chinese original) 5.6 IN_QUEUE_TH (offset 0x5D8, printed page 5-107, `Hi3516-Datasheet.txt` line 34410).";

        field {
            name = "tx_rq_in_th";
            desc = "Threshold for reporting descriptor enqueue interrupts in the TX direction. The threshold must be greater than or equal to 1.";
            sw = rw;
            hw = r;
            reset = 0x1;
        } tx_rq_in_th[23:16];

        field {
            name = "rx_bq_in_th";
            desc = "Threshold for reporting descriptor enqueue interrupts in the RX direction. The threshold must be greater than or equal to 1.";
            sw = rw;
            hw = r;
            reset = 0x1;
        } rx_bq_in_th[7:0];
    } IN_QUEUE_TH @ 0x5D8;

    reg {
        name = "Rx_fq or tx_bq dequeue interrupt threshold register";
        desc = "OUT_QUEUE_TH is an rx_fq or tx_bq dequeue interrupt threshold register.

Data sheet 5.7 OUT_QUEUE_TH (offset 0x5DC, printed page 5-94, `Hi3516AV200-Datasheet.txt` line 35155).
Hi3516 V100 data sheet (Chinese original) 5.6 OUT_QUEUE_TH (offset 0x5DC, printed page 5-107, `Hi3516-Datasheet.txt` line 34436).";

        field {
            name = "tx_bq_out_th";
            desc = "Threshold for reporting descriptor dequeue interrupts in the TX direction";
            sw = rw;
            hw = r;
            reset = 0x1;
        } tx_bq_out_th[23:16];

        field {
            name = "rx_fq_out_th";
            desc = "Threshold for reporting descriptor dequeue interrupts in the RX direction";
            sw = rw;
            hw = r;
            reset = 0x1;
        } rx_fq_out_th[7:0];
    } OUT_QUEUE_TH @ 0x5DC;

    reg {
        name = "Rx_bq enqueue timeout raw H interrupt threshold register";
        desc = "RX_BQ_IN_TIMEOUT_TH is an rx_bq enqueue timeout raw interrupt threshold register.

Linux programs 0x10000.

Data sheet 5.7 RX_BQ_IN_TIMEOUT_TH (offset 0x5E0, printed page 5-95, `Hi3516AV200-Datasheet.txt` line 35191).
Hi3516 V100 data sheet (Chinese original) 5.6 RX_BQ_IN_TIMEOUT_TH (offset 0x5E0, printed page 5-108, `Hi3516-Datasheet.txt` line 34472).";

        field {
            name = "rx_bq_in_timeout_th";
            desc = "Threshold for reporting descriptor enqueue timeout interrupts in the BQ queue in the RX direction";
            sw = rw;
            hw = r;
            reset = 0x8000;
        } rx_bq_in_timeout_th[23:0];
    } RX_BQ_IN_TIMEOUT_TH @ 0x5E0;

    reg {
        name = "Tx_rq enqueue timeout raw interrupt H threshold register";
        desc = "TX_RQ_IN_TIMEOUT_TH is a tx_rq enqueue timeout raw interrupt threshold register.

Linux programs 0x50000.

Data sheet 5.7 TX_RQ_IN_TIMEOUT_TH (offset 0x5E4, printed page 5-95, `Hi3516AV200-Datasheet.txt` line 35213).
Hi3516 V100 data sheet (Chinese original) 5.6 TX_RQ_IN_TIMEOUT_TH (offset 0x5E4, printed page 5-108, `Hi3516-Datasheet.txt` line 34496).";

        field {
            name = "tx_rq_in_timeout_th";
            desc = "Threshold for reporting descriptor enqueue timeout interrupts in the RQ queue in the TX direction";
            sw = rw;
            hw = r;
            reset = 0x8000;
        } tx_rq_in_timeout_th[23:0];
    } TX_RQ_IN_TIMEOUT_TH @ 0x5E4;

    reg {
        name = "RX and TX packet control stop register";
        desc = "STOP_CMD is an RX and TX packet control stop register.

Vendor U-Boot (higmac_desc_flush) sets the stop bit, waits for the flush flag, issues the flush command and then clears both again.

Data sheet 5.7 STOP_CMD (offset 0x5E8, printed page 5-96, `Hi3516AV200-Datasheet.txt` line 35239).
Hi3516 V100 data sheet (Chinese original) 5.6 STOP_CMD (offset 0x5E8, printed page 5-109, `Hi3516-Datasheet.txt` line 34529).";

        enum STOP_CMD_tx_stop_en_enum {
            DISABLED = 0 { name = "Disabled"; desc = "disabled"; };
            ENABLED = 1 { name = "Enabled"; desc = "enabled"; };
        };

        field {
            name = "tx_stop_en";
            desc = "Packet TX stop enable";
            sw = rw;
            hw = r;
            encode = STOP_CMD_tx_stop_en_enum;
            reset = 0x0;
        } tx_stop_en[1:1];

        enum STOP_CMD_rx_stop_en_enum {
            DISABLED = 0 { name = "Disabled"; desc = "disabled"; };
            ENABLED = 1 { name = "Enabled"; desc = "enabled"; };
        };

        field {
            name = "rx_stop_en";
            desc = "Packet RX stop enable";
            sw = rw;
            hw = r;
            encode = STOP_CMD_rx_stop_en_enum;
            reset = 0x0;
        } rx_stop_en[0:0];
    } STOP_CMD @ 0x5E8;

    reg {
        name = "Recycle descriptor enable register";
        desc = "FLUSH_CMD is a recycle descriptor enable register.

DISAGREEMENT: the data sheets (all four editions: this layout, bits 5:0, with tx/rx_flush_cmd at 5:4 and the four flush flags at 3:0) and Linux hix5hd2_gmac.c (BITS_TX_FLUSH_CMD = bit 5, BITS_RX_FLUSH_CMD = bit 4, BITS_TX_FLUSH_FLAG_DOWN = bit 3, ..._UP = bit 2, BITS_RX_FLUSH_FLAG_DOWN = bit 1, ..._UP = bit 0, defined but never used) agree; the vendor U-Boot drivers higmac and higmacv300 use a 4-bit layout (TX_FLUSH_CMD bit 3, RX_FLUSH_CMD bit 2, TX_FLUSH_FLAG bit 1, RX_FLUSH_FLAG bit 0) and poll the flag bit while writing the command bit. The data sheet layout is modelled (the flags are write-1-to-clear as the text says); the vendor layout is not hardware verified either.

Data sheet 5.7 FLUSH_CMD (offset 0x5EC, printed page 5-97, `Hi3516AV200-Datasheet.txt` line 35280).
Hi3516 V100 data sheet (Chinese original) 5.6 FLUSH_CMD (offset 0x5EC, printed page 5-109, `Hi3516-Datasheet.txt` line 34562).";

        enum FLUSH_CMD_tx_flush_cmd_enum {
            INVALID = 0 { name = "Invalid"; desc = "The recycle descriptor configuration command is invalid."; };
            VALID = 1 { name = "Valid"; desc = "The recycle descriptor configuration command is valid."; };
        };

        field {
            name = "tx_flush_cmd";
            desc = "Recycle descriptor command in the TX direction, instructing the descriptors to enter the tx_rq queue";
            sw = rw;
            hw = r;
            encode = FLUSH_CMD_tx_flush_cmd_enum;
            reset = 0x0;
        } tx_flush_cmd[5:5];

        enum FLUSH_CMD_rx_flush_cmd_enum {
            INVALID = 0 { name = "Invalid"; desc = "The recycle descriptor configuration command is invalid."; };
            VALID = 1 { name = "Valid"; desc = "The recycle descriptor configuration command is valid."; };
        };

        field {
            name = "rx_flush_cmd";
            desc = "Recycle descriptor command in the RX direction, instructing the descriptors to enter the rx_bq queue";
            sw = rw;
            hw = r;
            encode = FLUSH_CMD_rx_flush_cmd_enum;
            reset = 0x0;
        } rx_flush_cmd[4:4];

        field {
            name = "tx_flush_flag_down";
            desc = "Recycle descriptor stop indicator in the TX direction. After descriptors are recycled, the logic sets tx_flush_flag to 1, and the software writes 1 to clear the register.";
            sw = rw;
            hw = w;
            onwrite = woclr;
            reset = 0x0;
        } tx_flush_flag_down[3:3];

        field {
            name = "tx_flush_flag_up";
            desc = "Recycle descriptor stop indicator in the TX direction. After RX and TX packets are stopped, the logic sets tx_flush_flag to 1, indicating that the software can recycle the descriptors. The software writes 1 to clear the register.";
            sw = rw;
            hw = w;
            onwrite = woclr;
            reset = 0x0;
        } tx_flush_flag_up[2:2];

        field {
            name = "rx_flush_flag_down";
            desc = "Recycle descriptor stop indicator in the RX direction. After descriptors are recycled, the logic sets rx_flush_flag_down to 1, and the software writes 1 to clear the register.";
            sw = rw;
            hw = w;
            onwrite = woclr;
            reset = 0x0;
        } rx_flush_flag_down[1:1];

        field {
            name = "rx_flush_flag_up";
            desc = "Recycle descriptor indicator in the RX direction. After RX packets are stopped, the logic sets rx_flush_flag_up to 1, indicating that the software can recycle the descriptors. The software writes 1 to clear the register.";
            sw = rw;
            hw = w;
            onwrite = woclr;
            reset = 0x0;
        } rx_flush_flag_up[0:0];
    } FLUSH_CMD @ 0x5EC;

`ifndef HISI_GMAC_HI3516V100
    reg {
        name = "LPI status register in the RX and TX directions";
        desc = "U_EEE_INTR_SRC is an LPI status register in the RX and TX directions.

The data sheet lists the bits as RW with no clear description; they are set by hardware. Not used by Linux hix5hd2_gmac.c.

Data sheet 5.7 U_EEE_INTR_SRC (offset 0x800, printed page 5-98, `Hi3516AV200-Datasheet.txt` line 35345).";

        enum U_EEE_INTR_SRC_tx_lpi_cond_enum {
            NOT_BOTH_EMPTY = 0 { name = "Not both empty"; desc = "The TX FIFO and TX descriptors cannot be empty simultaneously."; };
            BOTH_EMPTY = 1 { name = "Both empty"; desc = "The TX FIFO and TX descriptors are empty simultaneously."; };
        };

        field {
            name = "tx_lpi_cond";
            desc = "LPI status in the TX direction";
            sw = rw;
            hw = w;
            encode = U_EEE_INTR_SRC_tx_lpi_cond_enum;
            reset = 0x0;
        } tx_lpi_cond[4:4];

        enum U_EEE_INTR_SRC_rx_leave_lpi_enum {
            NOT_EXITED = 0 { name = "Not Exited"; desc = "not exited"; };
            EXITED = 1 { name = "Exited"; desc = "exited"; };
        };

        field {
            name = "rx_leave_lpi";
            desc = "LPI exit in the RX direction";
            sw = rw;
            hw = w;
            encode = U_EEE_INTR_SRC_rx_leave_lpi_enum;
            reset = 0x0;
        } rx_leave_lpi[3:3];

        enum U_EEE_INTR_SRC_rx_entry_lpi_enum {
            NOT_ENTERED = 0 { name = "Not Entered"; desc = "not entered"; };
            ENTERED = 1 { name = "Entered"; desc = "entered"; };
        };

        field {
            name = "rx_entry_lpi";
            desc = "LPI enter in the RX direction";
            sw = rw;
            hw = w;
            encode = U_EEE_INTR_SRC_rx_entry_lpi_enum;
            reset = 0x0;
        } rx_entry_lpi[2:2];

        enum U_EEE_INTR_SRC_tx_leave_lpi_enum {
            NOT_EXITED = 0 { name = "Not Exited"; desc = "not exited"; };
            EXITED = 1 { name = "Exited"; desc = "exited"; };
        };

        field {
            name = "tx_leave_lpi";
            desc = "LPI exit in the TX direction";
            sw = rw;
            hw = w;
            encode = U_EEE_INTR_SRC_tx_leave_lpi_enum;
            reset = 0x0;
        } tx_leave_lpi[1:1];

        enum U_EEE_INTR_SRC_tx_entry_lpi_enum {
            NOT_ENTERED = 0 { name = "Not Entered"; desc = "not entered"; };
            ENTERED = 1 { name = "Entered"; desc = "entered"; };
        };

        field {
            name = "tx_entry_lpi";
            desc = "LPI enter in the TX direction";
            sw = rw;
            hw = w;
            encode = U_EEE_INTR_SRC_tx_entry_lpi_enum;
            reset = 0x0;
        } tx_entry_lpi[0:0];
    } U_EEE_INTR_SRC @ 0x800;
`endif

`ifndef HISI_GMAC_HI3516V100
    reg {
        name = "Interrupt mask and enable register in the RX and TX directions";
        desc = "U_EEE_INTR_EN is an interrupt mask and enable register in the RX and TX directions.

Data sheet 5.7 U_EEE_INTR_EN (offset 0x804, printed page 5-99, `Hi3516AV200-Datasheet.txt` line 35397).";

        enum U_EEE_INTR_EN_tx_lpi_cond_msk_enum {
            NOT_MASKED = 0 { name = "Not Masked"; desc = "not masked"; };
            MASKED = 1 { name = "Masked"; desc = "masked"; };
        };

        field {
            name = "tx_lpi_cond_msk";
            desc = "LPI status interrupt mask in the TX direction";
            sw = rw;
            hw = r;
            encode = U_EEE_INTR_EN_tx_lpi_cond_msk_enum;
            reset = 0x0;
        } tx_lpi_cond_msk[9:9];

        enum U_EEE_INTR_EN_rx_leave_lpi_msk_enum {
            NOT_MASKED = 0 { name = "Not Masked"; desc = "not masked"; };
            MASKED = 1 { name = "Masked"; desc = "masked"; };
        };

        field {
            name = "rx_leave_lpi_msk";
            desc = "LPI status exit interrupt mask in the RX direction";
            sw = rw;
            hw = r;
            encode = U_EEE_INTR_EN_rx_leave_lpi_msk_enum;
            reset = 0x0;
        } rx_leave_lpi_msk[8:8];

        enum U_EEE_INTR_EN_rx_entry_lpi_msk_enum {
            NOT_MASKED = 0 { name = "Not Masked"; desc = "not masked"; };
            MASKED = 1 { name = "Masked"; desc = "masked"; };
        };

        field {
            name = "rx_entry_lpi_msk";
            desc = "LPI status enter interrupt mask in the RX direction";
            sw = rw;
            hw = r;
            encode = U_EEE_INTR_EN_rx_entry_lpi_msk_enum;
            reset = 0x0;
        } rx_entry_lpi_msk[7:7];

        enum U_EEE_INTR_EN_tx_leave_lpi_msk_enum {
            NOT_MASKED = 0 { name = "Not Masked"; desc = "not masked"; };
            MASKED = 1 { name = "Masked"; desc = "masked"; };
        };

        field {
            name = "tx_leave_lpi_msk";
            desc = "LPI status exit interrupt mask in the TX direction";
            sw = rw;
            hw = r;
            encode = U_EEE_INTR_EN_tx_leave_lpi_msk_enum;
            reset = 0x0;
        } tx_leave_lpi_msk[6:6];

        enum U_EEE_INTR_EN_tx_entry_lpi_msk_enum {
            NOT_MASKED = 0 { name = "Not Masked"; desc = "not masked"; };
            MASKED = 1 { name = "Masked"; desc = "masked"; };
        };

        field {
            name = "tx_entry_lpi_msk";
            desc = "LPI status enter interrupt mask in the TX direction";
            sw = rw;
            hw = r;
            encode = U_EEE_INTR_EN_tx_entry_lpi_msk_enum;
            reset = 0x0;
        } tx_entry_lpi_msk[5:5];

        enum U_EEE_INTR_EN_tx_lpi_cond_en_enum {
            DISABLE_INTERRUPTS = 0 { name = "Disable Interrupts"; desc = "Disable interrupts."; };
            ENABLE_INTERRUPTS = 1 { name = "Enable Interrupts"; desc = "Enable interrupts."; };
        };

        field {
            name = "tx_lpi_cond_en";
            desc = "LPI status interrupt enable in the TX direction";
            sw = rw;
            hw = r;
            encode = U_EEE_INTR_EN_tx_lpi_cond_en_enum;
            reset = 0x0;
        } tx_lpi_cond_en[4:4];

        enum U_EEE_INTR_EN_rx_leave_lpi_en_enum {
            DISABLE_INTERRUPTS = 0 { name = "Disable Interrupts"; desc = "Disable interrupts."; };
            ENABLE_INTERRUPTS = 1 { name = "Enable Interrupts"; desc = "Enable interrupts."; };
        };

        field {
            name = "rx_leave_lpi_en";
            desc = "LPI status interrupt enable exit in the RX direction";
            sw = rw;
            hw = r;
            encode = U_EEE_INTR_EN_rx_leave_lpi_en_enum;
            reset = 0x0;
        } rx_leave_lpi_en[3:3];

        enum U_EEE_INTR_EN_rx_entry_lpi_en_enum {
            DISABLE_INTERRUPTS = 0 { name = "Disable Interrupts"; desc = "Disable interrupts."; };
            ENABLE_INTERRUPTS = 1 { name = "Enable Interrupts"; desc = "Enable interrupts."; };
        };

        field {
            name = "rx_entry_lpi_en";
            desc = "LPI status interrupt enable enter in the RX direction";
            sw = rw;
            hw = r;
            encode = U_EEE_INTR_EN_rx_entry_lpi_en_enum;
            reset = 0x0;
        } rx_entry_lpi_en[2:2];

        enum U_EEE_INTR_EN_tx_leave_lpi_en_enum {
            DISABLE_INTERRUPTS = 0 { name = "Disable Interrupts"; desc = "Disable interrupts."; };
            ENABLE_INTERRUPTS = 1 { name = "Enable Interrupts"; desc = "Enable interrupts."; };
        };

        field {
            name = "tx_leave_lpi_en";
            desc = "LPI status interrupt enable exit in the TX direction";
            sw = rw;
            hw = r;
            encode = U_EEE_INTR_EN_tx_leave_lpi_en_enum;
            reset = 0x0;
        } tx_leave_lpi_en[1:1];

        enum U_EEE_INTR_EN_tx_entry_lpi_en_enum {
            DISABLE_INTERRUPTS = 0 { name = "Disable Interrupts"; desc = "Disable interrupts."; };
            ENABLE_INTERRUPTS = 1 { name = "Enable Interrupts"; desc = "Enable interrupts."; };
        };

        field {
            name = "tx_entry_lpi_en";
            desc = "LPI status interrupt enable enter in the TX direction";
            sw = rw;
            hw = r;
            encode = U_EEE_INTR_EN_tx_entry_lpi_en_enum;
            reset = 0x0;
        } tx_entry_lpi_en[0:0];
    } U_EEE_INTR_EN @ 0x804;
`endif

`ifndef HISI_GMAC_HI3516V100
    reg {
        name = "EEE enable signal register";
        desc = "U_EEE_ENABLE is an EEE enable signal register.

Data sheet 5.7 U_EEE_ENABLE (offset 0x808, printed page 5-100, `Hi3516AV200-Datasheet.txt` line 35462).";

        field {
            name = "eee_ls_timer";
            desc = "Buffer time for the buffer software to enable the hardware to enter the LPI when phy_link_sts is set to 1. The default time is 1s.";
            sw = rw;
            hw = r;
            reset = 0x000F4240;
        } eee_ls_timer[31:4];

        enum U_EEE_ENABLE_gmii_mode_enum {
            MII = 0 { name = "MII"; desc = "MII mode"; };
            GMII = 1 { name = "GMII"; desc = "GMII mode"; };
        };

        field {
            name = "gmii_mode";
            desc = "GMII mode select";
            sw = rw;
            hw = r;
            encode = U_EEE_ENABLE_gmii_mode_enum;
            reset = 0x0;
        } gmii_mode[3:3];

        enum U_EEE_ENABLE_cond_intr_keep_enum {
            ONCE = 0 { name = "Once"; desc = "The hardware sends only one tx_lpi_cond interrupt."; };
            EVERY_CLOCK = 1 { name = "Every clock"; desc = "The interrupt is enabled on the rising edge of each clock in LPI mode in the TX direction."; };
        };

        field {
            name = "cond_intr_keep";
            desc = "Interrupt signal TX frequency";
            sw = rw;
            hw = r;
            encode = U_EEE_ENABLE_cond_intr_keep_enum;
            reset = 0x0;
        } cond_intr_keep[2:2];

        enum U_EEE_ENABLE_tx_lpi_assert_enum {
            NO_LPI = 0 { name = "No LPI"; desc = "The hardware does not enter the LPI state."; };
            ENTER_LPI = 1 { name = "Enter LPI"; desc = "The hardware enters the LPI state."; };
        };

        field {
            name = "tx_lpi_assert";
            desc = "Software configuring the hardware to enter the LPI state";
            sw = rw;
            hw = r;
            encode = U_EEE_ENABLE_tx_lpi_assert_enum;
            reset = 0x0;
        } tx_lpi_assert[1:1];

        enum U_EEE_ENABLE_eee_enable_enum {
            DISABLED = 0 { name = "Disabled"; desc = "disabled"; };
            ENABLED = 1 { name = "Enabled"; desc = "enabled"; };
        };

        field {
            name = "eee_enable";
            desc = "EEE module enable";
            sw = rw;
            hw = r;
            encode = U_EEE_ENABLE_eee_enable_enum;
            reset = 0x0;
        } eee_enable[0:0];
    } U_EEE_ENABLE @ 0x808;
`endif

`ifndef HISI_GMAC_HI3516V100
    reg {
        name = "LPI time threshold register";
        desc = "U_EEE_TIMER is an LPI time threshold register.

Data sheet 5.7 U_EEE_TIMER (offset 0x80C, printed page 5-101, `Hi3516AV200-Datasheet.txt` line 35508).";

        field {
            name = "lpi_tw_timer";
            desc = "Wake-up time of the register from the LPI mode to normal mode. The default time is 30 µs.";
            sw = rw;
            hw = r;
            reset = 0x1E;
        } lpi_tw_timer[31:16];

        field {
            name = "lpi_cond_timer";
            desc = "Duration when the TX FIFO and EX_DESC are empty at the same time. When the duration is equal to the value of lpi_cond_timer, the register enters the LPI mode.";
            sw = rw;
            hw = r;
            reset = 0xA;
        } lpi_cond_timer[15:0];
    } U_EEE_TIMER @ 0x80C;
`endif

`ifndef HISI_GMAC_HI3516V100
    reg {
        name = "EEE status register";
        desc = "U_EEE_LINK_STATUS is an EEE status register.

Reset 0x3F20: version = 0x3F2 (1010). The description of eee_rx_lpi_stay says TX in the data sheet (copy-paste).

Data sheet 5.7 U_EEE_LINK_STATUS (offset 0x810, printed page 5-101, `Hi3516AV200-Datasheet.txt` line 35532).";

        field {
            name = "intr_cnt";
            desc = "EEE interrupt count";
            sw = rw;
            hw = w;
            reset = 0x0;
        } intr_cnt[31:16];

        enum U_EEE_LINK_STATUS_eee_tx_lpi_stay_enum {
            NOT_IN_LPI = 0 { name = "Not in LPI"; desc = "The TX register is not in LPI state."; };
            IN_LPI = 1 { name = "In LPI"; desc = "The TX register is in LPI state."; };
        };

        field {
            name = "eee_tx_lpi_stay";
            desc = "Whether the TX register is in LPI state";
            sw = r;
            hw = w;
            encode = U_EEE_LINK_STATUS_eee_tx_lpi_stay_enum;
            reset = 0x0;
        } eee_tx_lpi_stay[15:15];

        enum U_EEE_LINK_STATUS_eee_rx_lpi_stay_ff3_enum {
            NOT_IN_LPI = 0 { name = "Not in LPI"; desc = "The RX register is not in LPI state (the data sheet text says TX, a copy-paste error)."; };
            IN_LPI = 1 { name = "In LPI"; desc = "The RX register is in LPI state (the data sheet text says TX, a copy-paste error)."; };
        };

        field {
            name = "eee_rx_lpi_stay_ff3";
            desc = "Whether the RX register is in LPI state";
            sw = r;
            hw = w;
            encode = U_EEE_LINK_STATUS_eee_rx_lpi_stay_ff3_enum;
            reset = 0x0;
        } eee_rx_lpi_stay_ff3[14:14];

        field {
            name = "version";
            desc = "Logical version number";
            sw = r;
            hw = w;
            reset = 0x3F2;
        } version[13:4];

        enum U_EEE_LINK_STATUS_eee_auto_enum {
            SOFTWARE = 0 { name = "Software assisted"; desc = "The logic enters or exits the EEE mode by using the software and logic interrupt."; };
            AUTOMATIC = 1 { name = "Automatic"; desc = "The logic automatically enters or exits the EEE without the intervention of software."; };
        };

        field {
            name = "eee_auto";
            desc = "Automatic EEE entry and exit";
            sw = rw;
            hw = w;
            encode = U_EEE_LINK_STATUS_eee_auto_enum;
            reset = 0x0;
        } eee_auto[2:2];

        enum U_EEE_LINK_STATUS_eee_hold_txdesc_read_enum {
            YES = 0 { name = "Yes"; desc = "yes"; };
            NO = 1 { name = "No"; desc = "no"; };
        };

        field {
            name = "eee_hold_txdesc_read";
            desc = "Whether the MAC can obtain packets from the TX FIFO in LPI status";
            sw = rw;
            hw = w;
            encode = U_EEE_LINK_STATUS_eee_hold_txdesc_read_enum;
            reset = 0x0;
        } eee_hold_txdesc_read[1:1];

        enum U_EEE_LINK_STATUS_phy_link_sts_enum {
            LINK_DOWN = 0 { name = "Link Down"; desc = "link_down"; };
            LINK_UP = 1 { name = "Link Up"; desc = "link_up"; };
        };

        field {
            name = "phy_link_sts";
            desc = "PHY connection state";
            sw = rw;
            hw = w;
            encode = U_EEE_LINK_STATUS_phy_link_sts_enum;
            reset = 0x0;
        } phy_link_sts[0:0];
    } U_EEE_LINK_STATUS @ 0x810;
`endif

`ifndef HISI_GMAC_HI3516V100
    reg {
        name = "Timing pulse count register";
        desc = "U_EEE_TIME_CLK_CNT is a timing pulse count register.

Data sheet 5.7 U_EEE_TIME_CLK_CNT (offset 0x814, printed page 5-102, `Hi3516AV200-Datasheet.txt` line 35590).";

        field {
            name = "clk_period_cnt";
            desc = "Count register used to generate a 1 µs timing pulse in the hardware. The clock cycle is 8 ns when the clock frequency is 125 MHz.";
            sw = rw;
            hw = r;
            reset = 0x7D;
        } clk_period_cnt[31:0];
    } U_EEE_TIME_CLK_CNT @ 0x814;
`endif

`ifndef HISI_GMAC_HI3516V100
    reg {
        name = "PMT control and status register";
        desc = "PMT_CTRL_STAUTS is a PMT control and status register.

The data sheet spells the register name PMT_CTRL_STAUTS; the corrected spelling PMT_CTRL_STATUS is used here. The two RCVD_* bits are set by hardware (the data sheet gives no clear mechanism; WoL text in 5.5.2: leave the power-down mode by clearing scr_power_down, or automatically when a magic packet arrives).

Data sheet 5.7 PMT_CTRL_STAUTS (offset 0xA00, printed page 5-103, `Hi3516AV200-Datasheet.txt` line 35619).";

        enum PMT_CTRL_STATUS_scr_wkupfrm_glbucast_enum {
            NOT_WAKEUP_FRAME = 0 { name = "Not a wake-up frame"; desc = "The unicast frame is not regarded as the wake-up frame."; };
            WAKEUP_FRAME = 1 { name = "Wake-up frame"; desc = "The unicast frame used to configure the MAC address is regarded as the valid wake-up frame."; };
        };

        field {
            name = "scr_wkupfrm_glbucast";
            desc = "Whether the unicast frame used to configure the MAC address is the wake-up frame";
            sw = rw;
            hw = r;
            encode = PMT_CTRL_STATUS_scr_wkupfrm_glbucast_enum;
            reset = 0x0;
        } scr_wkupfrm_glbucast[9:9];

        enum PMT_CTRL_STATUS_rcvd_wkup_frm_enum {
            NO = 0 { name = "No"; desc = "no"; };
            YES = 1 { name = "Yes"; desc = "yes"; };
        };

        field {
            name = "rcvd_wkup_frm";
            desc = "Whether a wake_up frame is received";
            sw = rw;
            hw = w;
            encode = PMT_CTRL_STATUS_rcvd_wkup_frm_enum;
            reset = 0x0;
        } rcvd_wkup_frm[6:6];

        enum PMT_CTRL_STATUS_rcvd_mgk_pkt_enum {
            NO = 0 { name = "No"; desc = "no"; };
            YES = 1 { name = "Yes"; desc = "yes"; };
        };

        field {
            name = "rcvd_mgk_pkt";
            desc = "Whether the magic packet is received.";
            sw = rw;
            hw = w;
            encode = PMT_CTRL_STATUS_rcvd_mgk_pkt_enum;
            reset = 0x0;
        } rcvd_mgk_pkt[5:5];

        enum PMT_CTRL_STATUS_scr_intr_en_enum {
            DISABLED = 0 { name = "Disabled"; desc = "disabled"; };
            ENABLED = 1 { name = "Enabled"; desc = "enabled"; };
        };

        field {
            name = "scr_intr_en";
            desc = "PMT interrupt enable";
            sw = rw;
            hw = r;
            encode = PMT_CTRL_STATUS_scr_intr_en_enum;
            reset = 0x0;
        } scr_intr_en[3:3];

        enum PMT_CTRL_STATUS_scr_wkupfrm_en_enum {
            DISABLED = 0 { name = "Disabled"; desc = "disabled"; };
            ENABLED = 1 { name = "Enabled"; desc = "enabled"; };
        };

        field {
            name = "scr_wkupfrm_en";
            desc = "wake_up frame receive enable";
            sw = rw;
            hw = r;
            encode = PMT_CTRL_STATUS_scr_wkupfrm_en_enum;
            reset = 0x0;
        } scr_wkupfrm_en[2:2];

        enum PMT_CTRL_STATUS_scr_mgkpkt_en_enum {
            DISABLED = 0 { name = "Disabled"; desc = "disabled"; };
            ENABLED = 1 { name = "Enabled"; desc = "enabled"; };
        };

        field {
            name = "scr_mgkpkt_en";
            desc = "Magic packet receive enable";
            sw = rw;
            hw = r;
            encode = PMT_CTRL_STATUS_scr_mgkpkt_en_enum;
            reset = 0x0;
        } scr_mgkpkt_en[1:1];

        enum PMT_CTRL_STATUS_scr_power_down_enum {
            EXIT_POWER_DOWN = 0 { name = "Exit Power Down"; desc = "Exit the power-down mode."; };
            ENTER_POWER_DOWN = 1 { name = "Enter Power Down"; desc = "Enter the power-down mode."; };
        };

        field {
            name = "scr_power_down";
            desc = "Power-down mode enable";
            sw = rw;
            hw = r;
            encode = PMT_CTRL_STATUS_scr_power_down_enum;
            reset = 0x0;
        } scr_power_down[0:0];
    } PMT_CTRL_STATUS @ 0xA00;
`endif

`ifndef HISI_GMAC_HI3516V100
    reg {
        name = "PMT valid byte selection register 0";
        desc = "FILTER_0_BYTE_MASK is PMT valid byte selection register 0.

Data sheet 5.7 FILTER_0_BYTE_MASK (offset 0xA04, printed page 5-104, `Hi3516AV200-Datasheet.txt` line 35681).";

        field {
            name = "wkupfrm_filter0bytemsk";
            desc = "Bit[31] must be set to low, indicating that the mask is valid. Bit[30:0] are used for byte mask. If a bit is 1, the corresponding byte is valid.";
            sw = rw;
            hw = r;
            reset = 0x0;
        } wkupfrm_filter0bytemsk[31:0];
    } FILTER_0_BYTE_MASK @ 0xA04;
`endif

`ifndef HISI_GMAC_HI3516V100
    reg {
        name = "PMT valid byte selection register 1";
        desc = "FILTER_1_BYTE_MASK is PMT valid byte selection register 1.

Data sheet 5.7 FILTER_1_BYTE_MASK (offset 0xA08, printed page 5-104, `Hi3516AV200-Datasheet.txt` line 35704).";

        field {
            name = "wkupfrm_filter1bytemsk";
            desc = "Bit[31] must be set to low, indicating that the mask is valid. Bit[30:0] are used for byte mask.";
            sw = rw;
            hw = r;
            reset = 0x0;
        } wkupfrm_filter1bytemsk[31:0];
    } FILTER_1_BYTE_MASK @ 0xA08;
`endif

`ifndef HISI_GMAC_HI3516V100
    reg {
        name = "PMT valid byte selection register 2";
        desc = "FILTER_2_BYTE_MASK is PMT valid byte selection register 2.

Data sheet 5.7 FILTER_2_BYTE_MASK (offset 0xA0C, printed page 5-105, `Hi3516AV200-Datasheet.txt` line 35730).";

        field {
            name = "wkupfrm_filter2bytemsk";
            desc = "Bit[31] must be set to low, indicating that the mask is valid. Bit[30:0] are used for byte mask.";
            sw = rw;
            hw = r;
            reset = 0x0;
        } wkupfrm_filter2bytemsk[31:0];
    } FILTER_2_BYTE_MASK @ 0xA0C;
`endif

`ifndef HISI_GMAC_HI3516V100
    reg {
        name = "PMT valid byte selection register 3";
        desc = "FILTER_3_BYTE_MASK is PMT valid byte selection register 3.

Data sheet 5.7 FILTER_3_BYTE_MASK (offset 0xA10, printed page 5-105, `Hi3516AV200-Datasheet.txt` line 35751).";

        field {
            name = "wkupfrm_filter3bytemsk";
            desc = "Bit[31] must be set to low, indicating that the mask is valid. Bit[30:0] are used for byte mask.";
            sw = rw;
            hw = r;
            reset = 0x0;
        } wkupfrm_filter3bytemsk[31:0];
    } FILTER_3_BYTE_MASK @ 0xA10;
`endif

`ifndef HISI_GMAC_HI3516V100
    reg {
        name = "PMT template selection and multicast enable register";
        desc = "FILTER_COMMAND is a PMT template selection and multicast enable register.

Data sheet 5.7 FILTER_COMMAND (offset 0xA14, printed page 5-106, `Hi3516AV200-Datasheet.txt` line 35776).";

        enum FILTER_COMMAND_wkupfrm_filter3mcast_enum {
            TEMPLATE_MATCH = 0 { name = "Template match"; desc = "The match of address type is determined based on the valid bytes of the corresponding template and CRC offset address."; };
            ANY_MULTICAST = 1 { name = "Any multicast"; desc = "The address is successfully filtered when the destination address is a valid multicast address."; };
        };

        field {
            name = "wkupfrm_filter3mcast";
            desc = "Address type specified by template 3";
            sw = rw;
            hw = r;
            encode = FILTER_COMMAND_wkupfrm_filter3mcast_enum;
            reset = 0x0;
        } wkupfrm_filter3mcast[27:27];

        enum FILTER_COMMAND_wkupfrm_filter3en_enum {
            DISABLED = 0 { name = "Disabled"; desc = "disabled"; };
            ENABLED = 1 { name = "Enabled"; desc = "enabled"; };
        };

        field {
            name = "wkupfrm_filter3en";
            desc = "Filter template 3 enable";
            sw = rw;
            hw = r;
            encode = FILTER_COMMAND_wkupfrm_filter3en_enum;
            reset = 0x0;
        } wkupfrm_filter3en[24:24];

        enum FILTER_COMMAND_wkupfrm_filter2mcast_enum {
            TEMPLATE_MATCH = 0 { name = "Template match"; desc = "The match of address type is determined based on the valid bytes of the corresponding template and CRC offset address."; };
            ANY_MULTICAST = 1 { name = "Any multicast"; desc = "The address is successfully filtered when the destination address is a valid multicast address."; };
        };

        field {
            name = "wkupfrm_filter2mcast";
            desc = "Address type specified by template 2";
            sw = rw;
            hw = r;
            encode = FILTER_COMMAND_wkupfrm_filter2mcast_enum;
            reset = 0x0;
        } wkupfrm_filter2mcast[19:19];

        enum FILTER_COMMAND_wkupfrm_filter2en_enum {
            DISABLED = 0 { name = "Disabled"; desc = "disabled"; };
            ENABLED = 1 { name = "Enabled"; desc = "enabled"; };
        };

        field {
            name = "wkupfrm_filter2en";
            desc = "Filter template 2 enable";
            sw = rw;
            hw = r;
            encode = FILTER_COMMAND_wkupfrm_filter2en_enum;
            reset = 0x0;
        } wkupfrm_filter2en[16:16];

        enum FILTER_COMMAND_wkupfrm_filter1mcast_enum {
            TEMPLATE_MATCH = 0 { name = "Template match"; desc = "The match of address type is determined based on the valid bytes of the corresponding template and CRC offset address."; };
            ANY_MULTICAST = 1 { name = "Any multicast"; desc = "The address is successfully filtered when the destination address is a valid multicast address."; };
        };

        field {
            name = "wkupfrm_filter1mcast";
            desc = "Address type specified by template 1";
            sw = rw;
            hw = r;
            encode = FILTER_COMMAND_wkupfrm_filter1mcast_enum;
            reset = 0x0;
        } wkupfrm_filter1mcast[11:11];

        enum FILTER_COMMAND_wkupfrm_filter1en_enum {
            DISABLED = 0 { name = "Disabled"; desc = "disabled"; };
            ENABLED = 1 { name = "Enabled"; desc = "enabled"; };
        };

        field {
            name = "wkupfrm_filter1en";
            desc = "Filter template 1 enable";
            sw = rw;
            hw = r;
            encode = FILTER_COMMAND_wkupfrm_filter1en_enum;
            reset = 0x0;
        } wkupfrm_filter1en[8:8];

        enum FILTER_COMMAND_wkupfrm_filter0mcast_enum {
            TEMPLATE_MATCH = 0 { name = "Template match"; desc = "The match of address type is determined based on the valid bytes of the corresponding template and CRC offset address."; };
            ANY_MULTICAST = 1 { name = "Any multicast"; desc = "The address is successfully filtered when the destination address is a valid multicast address."; };
        };

        field {
            name = "wkupfrm_filter0mcast";
            desc = "Address type specified by template 0";
            sw = rw;
            hw = r;
            encode = FILTER_COMMAND_wkupfrm_filter0mcast_enum;
            reset = 0x0;
        } wkupfrm_filter0mcast[3:3];

        enum FILTER_COMMAND_wkupfrm_filter0en_enum {
            DISABLED = 0 { name = "Disabled"; desc = "disabled"; };
            ENABLED = 1 { name = "Enabled"; desc = "enabled"; };
        };

        field {
            name = "wkupfrm_filter0en";
            desc = "Filter template 0 enable";
            sw = rw;
            hw = r;
            encode = FILTER_COMMAND_wkupfrm_filter0en_enum;
            reset = 0x0;
        } wkupfrm_filter0en[0:0];
    } FILTER_COMMAND @ 0xA14;
`endif

`ifndef HISI_GMAC_HI3516V100
    reg {
        name = "CRC position offset register";
        desc = "FILTER_OFFSET is a CRC position offset register.

Data sheet 5.7 FILTER_OFFSET (offset 0xA18, printed page 5-107, `Hi3516AV200-Datasheet.txt` line 35859).";

        field {
            name = "wkupfrm_filter3offset";
            desc = "Template 3 of the four templates, used to calculate the CRC position offset";
            sw = rw;
            hw = r;
            reset = 0x0;
        } wkupfrm_filter3offset[31:24];

        field {
            name = "wkupfrm_filter2offset";
            desc = "Template 2 of the four templates, used to calculate the CRC position offset";
            sw = rw;
            hw = r;
            reset = 0x0;
        } wkupfrm_filter2offset[23:16];

        field {
            name = "wkupfrm_filter1offset";
            desc = "Template 1 of the four templates, used to calculate the CRC position offset";
            sw = rw;
            hw = r;
            reset = 0x0;
        } wkupfrm_filter1offset[15:8];

        field {
            name = "wkupfrm_filter0offset";
            desc = "Template 0 of the four templates, used to calculate the CRC position offset";
            sw = rw;
            hw = r;
            reset = 0x0;
        } wkupfrm_filter0offset[7:0];
    } FILTER_OFFSET @ 0xA18;
`endif

`ifndef HISI_GMAC_HI3516V100
    reg {
        name = "Software-expected CRC value 0 and 1 register";
        desc = "FILTER0_1_CRC is a software-expected CRC value 0 and 1 register.

Data sheet 5.7 FILTER0_1_CRC (offset 0xA1C, printed page 5-108, `Hi3516AV200-Datasheet.txt` line 35894).";

        field {
            name = "wkupfrm_filter1crc";
            desc = "CRC value expected by software of template 1 in the four templates";
            sw = rw;
            hw = r;
            reset = 0x0;
        } wkupfrm_filter1crc[31:16];

        field {
            name = "wkupfrm_filter0crc";
            desc = "CRC value expected by software of template 1";
            sw = rw;
            hw = r;
            reset = 0x0;
        } wkupfrm_filter0crc[15:0];
    } FILTER0_1_CRC @ 0xA1C;
`endif

`ifndef HISI_GMAC_HI3516V100
    reg {
        name = "Software-expected CRC value 2 and 3 register";
        desc = "FILTER2_3_CRC is a software-expected CRC value 2 and 3 register.

Data sheet 5.7 FILTER2_3_CRC (offset 0xA20, printed page 5-108, `Hi3516AV200-Datasheet.txt` line 35916).";

        field {
            name = "wkupfrm_filter3crc";
            desc = "CRC value expected by software of template 3";
            sw = rw;
            hw = r;
            reset = 0x0;
        } wkupfrm_filter3crc[31:16];

        field {
            name = "wkupfrm_filter2crc";
            desc = "CRC value expected by software of template 2";
            sw = rw;
            hw = r;
            reset = 0x0;
        } wkupfrm_filter2crc[15:0];
    } FILTER2_3_CRC @ 0xA20;
`endif
};

`endif
