`ifndef HISI_ISP_AV200_RDL
`define HISI_ISP_AV200_RDL


regfile eHISI_ISP_AV200 {
    name = "ISP (image signal processor, Hi3516A V200 / Hi3519 V101)";
    desc = "Image signal processor (ISP0) of the Hi3516A V200 and Hi3519 V101 (data sheet ISP chapter; the ISP registers are listed as offsets inside the VICAP0 window, base 0x11380000, from 0x12200 to 0x63AF0; the Hi3516A V200 and Hi3519 V101 data sheets list the same 605 registers). This regfile is rebased by -0x10000: instantiate it at 0x11390000 (VICAP0 base + 0x10000), like `eHISI_ISP_CV300`. Different generation from `eHISI_ISP_CV300`: only 81 of the 605 registers share offset and name with the Hi3516C V300 ISP, 165 names appear at other offsets. The data sheet text says ISP1 shares the base address 0x11380000 (typo for VICAP1, 0x11480000). 53 rows of the data sheet register summary table have no description block (INPUT_FORMATTER_S*, VIDEO_TEST_RGB_GR* at 0x20184-0x2018C, NP_RAW_FRONTEND1..4_* at 0x201B0-0x201E8, RAW_FRONTEND1/2_DP/GE/TH* at 0x2020C-0x20270, WDR_SHORT_STITCH_* 0x202CC, DEMOSAIC_SHARPEN_* 0x204F8, COLOR_MATRIX_COEF* 0x20534-0x2053C, STATISTICS_* 0x207D0-0x20838, FRAME_STATS_ACTIV* 0x20910-0x2092C, NOISE_PROFILE_FRAME_*/RAW_* 0x21200-0x21700, ISP_FPN_CTRL_I 0x63AE4) and are not transcribed. Generated 2026-11-15 by scripts/rdl-extract/gen_m_cells.py from the data sheet register tables (ds_extract2 + description extraction from the PDF); PROVENANCE: PROVEN = offsets, names, bit fields, access and reset values from the data sheet tables; nothing here is hardware verified.

    Register sources: 605 registers from the data sheet (hi3516av200--Hi3516AV200-Datasheet.txt, section 10.6). Name differences, data sheet kept: 0x20154 INPUT_FORMATTER_KNEEPOINT2: overlapping data-sheet fields dropped: slope1select[11:8], slope0select[3:0]; 0x20180 VIDEO_TEST_RGB_GRADIENT: overlapping data-sheet fields dropped: rgbgradient4[31:16], rgbgradient3[15:0], rgb_gradient_start_[31:16], rgb_gradient_start[15:0], rgb_gradient_start_[31:16], rgb_gradient_start_[15:0]; 0x201AC SENSOR_OFFSET_BLACK11: overlapping data-sheet fields dropped: expthresh[15:0], shortratio[7:0], longratio[7:0]; 0x201BC NP_RAW_FRONTEND1_OFF: overlapping data-sheet fields dropped: expthresh[15:0], shortratio[7:0], longratio[7:0]; 0x201CC NP_RAW_FRONTEND2_OFF: overlapping data-sheet fields dropped: expthresh[15:0], shortratio[7:0], longratio[7:0]; 0x201DC NP_RAW_FRONTEND3_OFF: overlapping data-sheet fields dropped: exp_thresh[15:0], short_ratio[7:0], long_ratio[7:0]; 0x20208 RAW_FRONTEND1_DEBUG_SEL: overlapping data-sheet fields dropped: dp_threshold[11:0], ge_threshold[11:0]; 0x2021C RAW_FRONTEND1_GE_SENS: overlapping data-sheet fields dropped: dpdev_threshold[11:0]; 0x2022C RAW_FRONTEND1_SIGMA_IN: overlapping data-sheet fields dropped: thresh_short[7:0]; 0x20244 RAW_FRONTEND2_GE_STRENGTH: overlapping data-sheet fields dropped: dp_threshold[11:0], ge_threshold[11:0]; 0x2025C RAW_FRONTEND2_GE_SENS: overlapping data-sheet fields dropped: dpdev_threshold[11:0]; 0x2026C RAW_FRONTEND2_SIGMA_IN: overlapping data-sheet fields dropped: thresh_short[7:0]; 0x202C8 WDR_SHORT_CTRL3: overlapping data-sheet fields dropped: short_stitch_error_limit[19:0]; 0x204F4 DEMOSAIC_MIN_THRESHOLD: overlapping data-sheet fields dropped: sharpen_alg_select[0:0]; 0x20530 COLOR_MATRIX_COEFFT_WBB: overlapping data-sheet fields dropped: coefft_fog_offset_r[11:0], coefft_fog_offset_g[11:0], coefft_fog_offset_b[11:0]; 0x207CC STATISTICS_COUNTED_PIXELS: overlapping data-sheet fields dropped: aexp_nodes_used_vert_peaexp_nodes_used_[31:24], vert_peaexp_nodes_used_horiz_pe[23:16], plane_mode_pe[10:8], offset_y_pe[7:7], skip_y_pe[6:4], offset_x_pe[3:3], skip_x_pe[2:0]; 0x207EC STATISTICS_PLANE_TOTAL_PE_3: overlapping data-sheet fields dropped: plane_counted_pe_[26:0], plane_counted_pe_[26:0], plane_counted_pe_[26:0], plane_counted_pe_[26:0]; 0x2080C STATISTICS_SUM_B: overlapping data-sheet fields dropped: ae_sum_nodes_used_vertae_sum_nodes_use[15:8], d_vertae_sum_nodes_used_horiz[7:0]; 0x20834 STATISTICS_COUNT_MAX: overlapping data-sheet fields dropped: awb_sum_nodes_used_vertawb_sum_nodes_u[15:8], sed_vertawb_sum_nodes_used_horiz[7:0]; 0x20904 FRAME_STATS_STATS_HOLD: overlapping data-sheet fields dropped: active_width_min[31:0], active_width_max[31:0], active_width_sum[31:0], active_width_num[31:0], active_height_min[31:0], active_height_max[31:0], active_height_sum[31:0], active_height_num[31:0]; 0x21034 NOISE_PROFILE_WDR_1: overlapping data-sheet fields dropped: weight_lut_1[15:8], weight_lut_0[7:0], weight_lut_3[31:24], weight_lut_2[23:16], weight_lut_1[15:8], weight_lut_0[7:0], weight_lut_3[31:24], weight_lut_2[23:16], weight_lut_1[15:8], weight_lut_0[7:0], weight_lut_3[31:24], weight_lut_2[23:16], weight_lut_1[15:8], weight_lut_0[7:0]; 0x21560 DNR_SHADING_LAST: overlapping data-sheet fields dropped: weight_lut_0[7:0], weight_lut_3[31:24], weight_lut_2[23:16], weight_lut_1[15:8], weight_lut_0[7:0], weight_lut_3[31:24], weight_lut_2[23:16], weight_lut_1[15:8], weight_lut_0[7:0], weight_lut_3[31:24], weight_lut_2[23:16], weight_lut_1[15:8], weight_lut_0[7:0]; 0x63AE0 ISP_FPN_CTRL_F: overlapping data-sheet fields dropped: update_mode[0:0].";

    reg {
        name = "AF control register";
        desc = "ISP_AF_CFG is an AF control register. Hi3516A V200 Professional HD IP Camera SoC

Data sheet 10.6 ISP_AF_CFG (offset 0x12200, printed page 10-56, `hi3516av200--Hi3516AV200-Datasheet.txt` line 68279).";

        enum ISP_AF_CFG_ck_gt_en_enum {
            DISABLED = 0 { name = "Disabled"; desc = "disabled"; };
            ENABLED = 1 { name = "Enabled"; desc = "enabled"; };
        };

        field {
            name = "ck_gt_en";
            desc = "AF clock gating enable";
            sw = rw;
            hw = r;
            encode = ISP_AF_CFG_ck_gt_en_enum;
            reset = 0x0;
        } ck_gt_en[31:31];

        enum ISP_AF_CFG_fir1_ldg_en_enum {
            DISABLED = 0 { name = "Disabled"; desc = "disabled"; };
            ENABLED = 1 { name = "Enabled"; desc = "enabled"; };
        };

        field {
            name = "fir1_ldg_en";
            desc = "Vertical FIR filter luma dependent gain (LDG) enable 1";
            sw = rw;
            hw = r;
            encode = ISP_AF_CFG_fir1_ldg_en_enum;
            reset = 0x0;
        } fir1_ldg_en[24:24];

        enum ISP_AF_CFG_fir0_ldg_en_enum {
            DISABLED = 0 { name = "Disabled"; desc = "disabled"; };
            ENABLED = 1 { name = "Enabled"; desc = "enabled"; };
        };

        field {
            name = "fir0_ldg_en";
            desc = "Vertical FIR filter LDG enable 0";
            sw = rw;
            hw = r;
            encode = ISP_AF_CFG_fir0_ldg_en_enum;
            reset = 0x0;
        } fir0_ldg_en[23:23];

        enum ISP_AF_CFG_iir1_ldg_en_enum {
            DISABLED = 0 { name = "Disabled"; desc = "disabled"; };
            ENABLED = 1 { name = "Enabled"; desc = "enabled"; };
        };

        field {
            name = "iir1_ldg_en";
            desc = "Horizontal IIR filter LDG enable 1";
            sw = rw;
            hw = r;
            encode = ISP_AF_CFG_iir1_ldg_en_enum;
            reset = 0x0;
        } iir1_ldg_en[22:22];

        enum ISP_AF_CFG_iir0_ldg_en_enum {
            DISABLED = 0 { name = "Disabled"; desc = "disabled"; };
            ENABLED = 1 { name = "Enabled"; desc = "enabled"; };
        };

        field {
            name = "iir0_ldg_en";
            desc = "Horizontal IIR filter LDG enable 0";
            sw = rw;
            hw = r;
            encode = ISP_AF_CFG_iir0_ldg_en_enum;
            reset = 0x0;
        } iir0_ldg_en[21:21];

        enum ISP_AF_CFG_fir1_lpf_en_enum {
            DISABLED = 0 { name = "Disabled"; desc = "disabled"; };
            ENABLED = 1 { name = "Enabled"; desc = "enabled"; };
        };

        field {
            name = "fir1_lpf_en";
            desc = "Vertical FIR low-pass filter (LPF) enable 1";
            sw = rw;
            hw = r;
            encode = ISP_AF_CFG_fir1_lpf_en_enum;
            reset = 0x0;
        } fir1_lpf_en[20:20];

        enum ISP_AF_CFG_fir0_lpf_en_enum {
            DISABLED = 0 { name = "Disabled"; desc = "disabled"; };
            ENABLED = 1 { name = "Enabled"; desc = "enabled"; };
        };

        field {
            name = "fir0_lpf_en";
            desc = "Vertical FIR LPF enable 0";
            sw = rw;
            hw = r;
            encode = ISP_AF_CFG_fir0_lpf_en_enum;
            reset = 0x0;
        } fir0_lpf_en[19:19];

        enum ISP_AF_CFG_iir1_ds_en_enum {
            DISABLED = 0 { name = "Disabled"; desc = "disabled"; };
            ENABLED = 1 { name = "Enabled"; desc = "enabled"; };
        };

        field {
            name = "iir1_ds_en";
            desc = "Horizontal IIR filter down sampling (DS) enable 1";
            sw = rw;
            hw = r;
            encode = ISP_AF_CFG_iir1_ds_en_enum;
            reset = 0x0;
        } iir1_ds_en[18:18];

        enum ISP_AF_CFG_iir0_ds_en_enum {
            DISABLED = 0 { name = "Disabled"; desc = "disabled"; };
            ENABLED = 1 { name = "Enabled"; desc = "enabled"; };
        };

        field {
            name = "iir0_ds_en";
            desc = "Horizontal IIR filter DS enable 0";
            sw = rw;
            hw = r;
            encode = ISP_AF_CFG_iir0_ds_en_enum;
            reset = 0x0;
        } iir0_ds_en[17:17];

        enum ISP_AF_CFG_bayer_mode_enum {
            RGGB = 0 { name = "Rggb"; desc = "RGGB"; };
            GRBG = 1 { name = "Grbg"; desc = "GRBG"; };
            GBRG = 2 { name = "Gbrg"; desc = "GBRG"; };
            BGGR = 3 { name = "Bggr"; desc = "BGGR"; };
        };

        field {
            name = "bayer_mode";
            desc = "AF raw format";
            sw = rw;
            hw = r;
            encode = ISP_AF_CFG_bayer_mode_enum;
            reset = 0x0;
        } bayer_mode[16:15];

        enum ISP_AF_CFG_raw_mode_enum {
            YUV_DATA = 0 { name = "Yuv Data"; desc = "YUV data"; };
            RAW_DATA = 1 { name = "Raw Data"; desc = "raw data"; };
        };

        field {
            name = "raw_mode";
            desc = "AF data format";
            sw = rw;
            hw = r;
            encode = ISP_AF_CFG_raw_mode_enum;
            reset = 0x0;
        } raw_mode[14:14];

        enum ISP_AF_CFG_sqrt_en_enum {
            DISABLED = 0 { name = "Disabled"; desc = "disabled"; };
            ENABLED = 1 { name = "Enabled"; desc = "enabled"; };
        };

        field {
            name = "sqrt_en";
            desc = "AF gamma enable";
            sw = rw;
            hw = r;
            encode = ISP_AF_CFG_sqrt_en_enum;
            reset = 0x0;
        } sqrt_en[13:13];

        enum ISP_AF_CFG_mean_en_enum {
            DISABLED = 0 { name = "Disabled"; desc = "disabled"; };
            ENABLED = 1 { name = "Enabled"; desc = "enabled"; };
        };

        field {
            name = "mean_en";
            desc = "AF median filtering enable";
            sw = rw;
            hw = r;
            encode = ISP_AF_CFG_mean_en_enum;
            reset = 0x0;
        } mean_en[12:12];

        enum ISP_AF_CFG_lpf_en_enum {
            DISABLED = 0 { name = "Disabled"; desc = "disabled"; };
            ENABLED = 1 { name = "Enabled"; desc = "enabled"; };
        };

        field {
            name = "lpf_en";
            desc = "AF low-pass filter enable";
            sw = rw;
            hw = r;
            encode = ISP_AF_CFG_lpf_en_enum;
            reset = 0x0;
        } lpf_en[11:11];

        enum ISP_AF_CFG_crop_en_enum {
            DISABLED = 0 { name = "Disabled"; desc = "disabled"; };
            ENABLED = 1 { name = "Enabled"; desc = "enabled"; };
        };

        field {
            name = "crop_en";
            desc = "AF crop enable";
            sw = rw;
            hw = r;
            encode = ISP_AF_CFG_crop_en_enum;
            reset = 0x0;
        } crop_en[10:10];

        enum ISP_AF_CFG_offset_en_enum {
            DISABLED = 0 { name = "Disabled"; desc = "disabled"; };
            ENABLED = 1 { name = "Enabled"; desc = "enabled"; };
        };

        field {
            name = "offset_en";
            desc = "offset enable";
            sw = rw;
            hw = r;
            encode = ISP_AF_CFG_offset_en_enum;
            reset = 0x0;
        } offset_en[9:9];

        enum ISP_AF_CFG_squ_mode_enum {
            STATISTICS_DIRECTLY_ACCUMULATE = 0 { name = "Statistics Directly Accumulate"; desc = "Statistics are directly accumulated."; };
            STATISTICS_ACCUMULATED_AFTER = 1 { name = "Statistics Accumulated After"; desc = "Statistics are accumulated after the square operation."; };
        };

        field {
            name = "squ_mode";
            desc = "Square mode of AF statistics";
            sw = rw;
            hw = r;
            encode = ISP_AF_CFG_squ_mode_enum;
            reset = 0x1;
        } squ_mode[8:8];

        enum ISP_AF_CFG_peak_mode_enum {
            ALL_VALUES_BLOCK = 0 { name = "All Values Block"; desc = "All values of a block are selected for statistics."; };
            MAXIMUM_VALUE_EACH = 1 { name = "Maximum Value Each"; desc = "The maximum value in each line of a block is selected for statistics."; };
        };

        field {
            name = "peak_mode";
            desc = "Peak value mode of AF statistics";
            sw = rw;
            hw = r;
            encode = ISP_AF_CFG_peak_mode_enum;
            reset = 0x1;
        } peak_mode[7:7];

        enum ISP_AF_CFG_iir1_en2_enum {
            DISABLED = 0 { name = "Disabled"; desc = "disabled"; };
            ENABLED = 1 { name = "Enabled"; desc = "enabled"; };
        };

        field {
            name = "iir1_en2";
            desc = "Enable for IIR2 among the three cascaded IIRs in group 2";
            sw = rw;
            hw = r;
            encode = ISP_AF_CFG_iir1_en2_enum;
            reset = 0x1;
        } iir1_en2[6:6];

        enum ISP_AF_CFG_iir1_en1_enum {
            DISABLED = 0 { name = "Disabled"; desc = "disabled"; };
            ENABLED = 1 { name = "Enabled"; desc = "enabled"; };
        };

        field {
            name = "iir1_en1";
            desc = "Enable for IIR1 among the three cascaded IIRs in group 2";
            sw = rw;
            hw = r;
            encode = ISP_AF_CFG_iir1_en1_enum;
            reset = 0x0;
        } iir1_en1[5:5];

        enum ISP_AF_CFG_iir1_en0_enum {
            DISABLED = 0 { name = "Disabled"; desc = "disabled"; };
            ENABLED = 1 { name = "Enabled"; desc = "enabled"; };
        };

        field {
            name = "iir1_en0";
            desc = "Enable for IIR0 among the three cascaded IIRs in group 2";
            sw = rw;
            hw = r;
            encode = ISP_AF_CFG_iir1_en0_enum;
            reset = 0x1;
        } iir1_en0[4:4];

        enum ISP_AF_CFG_iir0_en2_enum {
            DISABLED = 0 { name = "Disabled"; desc = "disabled"; };
            ENABLED = 1 { name = "Enabled"; desc = "enabled"; };
        };

        field {
            name = "iir0_en2";
            desc = "Enable for IIR2 among the three cascaded IIRs in group 1";
            sw = rw;
            hw = r;
            encode = ISP_AF_CFG_iir0_en2_enum;
            reset = 0x1;
        } iir0_en2[3:3];

        enum ISP_AF_CFG_iir0_en1_enum {
            DISABLED = 0 { name = "Disabled"; desc = "disabled"; };
            ENABLED = 1 { name = "Enabled"; desc = "enabled"; };
        };

        field {
            name = "iir0_en1";
            desc = "Enable for IIR1 among the three cascaded IIRs in group 1";
            sw = rw;
            hw = r;
            encode = ISP_AF_CFG_iir0_en1_enum;
            reset = 0x0;
        } iir0_en1[2:2];

        enum ISP_AF_CFG_iir0_en0_enum {
            DISABLED = 0 { name = "Disabled"; desc = "disabled"; };
            ENABLED = 1 { name = "Enabled"; desc = "enabled"; };
        };

        field {
            name = "iir0_en0";
            desc = "Enable for IIR0 among the three cascaded IIRs in group 1";
            sw = rw;
            hw = r;
            encode = ISP_AF_CFG_iir0_en0_enum;
            reset = 0x1;
        } iir0_en0[1:1];

        enum ISP_AF_CFG_en_enum {
            DISABLED = 0 { name = "Disabled"; desc = "disabled"; };
            ENABLED = 1 { name = "Enabled"; desc = "enabled"; };
        };

        field {
            name = "en";
            desc = "AF enable";
            sw = rw;
            hw = r;
            encode = ISP_AF_CFG_en_enum;
            reset = 0x0;
        } en[0:0];
    } ISP_AF_CFG @ 0x2200;

    reg {
        name = "AF block configuration register";
        desc = "ISP_AF_ZONE is an AF block configuration register.

Data sheet 10.6 ISP_AF_ZONE (offset 0x12210, printed page 10-58, `hi3516av200--Hi3516AV200-Datasheet.txt` line 68401).";

        field {
            name = "vnum";
            desc = "Number of vertical AF blocks (15 blocks at most) Blocks are in the CH_AF_CROP_SIZE region when crop_en is 1. Blocks are in the CH_AF_SIZE region when crop_en is 0.";
            sw = rw;
            hw = r;
            reset = 0xF;
        } vnum[12:8];

        field {
            name = "hnum";
            desc = "Number of horizontal AF blocks (17 blocks at most) Blocks are in the CH_AF_CROP_SIZE region when crop_en is 1. Blocks are in the CH_AF_SIZE region when crop_en is 0.";
            sw = rw;
            hw = r;
            reset = 0x11;
        } hnum[4:0];
    } ISP_AF_ZONE @ 0x2210;

    reg {
        name = "AF picture crop start coordinate register";
        desc = "ISP_AF_CROP_START is an AF picture crop start coordinate register.

Data sheet 10.6 ISP_AF_CROP_START (offset 0x12214, printed page 10-59, `hi3516av200--Hi3516AV200-Datasheet.txt` line 68436).";

        field {
            name = "pos_y";
            desc = "Vertical coordinate of the crop start point";
            sw = rw;
            hw = r;
            reset = 0x0;
        } pos_y[28:16];

        field {
            name = "pos_x";
            desc = "Horizontal coordinate of the crop start point";
            sw = rw;
            hw = r;
            reset = 0x0;
        } pos_x[12:0];
    } ISP_AF_CROP_START @ 0x2214;

    reg {
        name = "AF picture crop size register";
        desc = "ISP_AF_CROP_SIZE is an AF picture crop size register.

Data sheet 10.6 ISP_AF_CROP_SIZE (offset 0x12218, printed page 10-59, `hi3516av200--Hi3516AV200-Datasheet.txt` line 68461).";

        field {
            name = "vsize";
            desc = "Picture height after AF cropping";
            sw = rw;
            hw = r;
            reset = 0x0;
        } vsize[28:16];

        field {
            name = "hsize";
            desc = "Picture width after AF cropping";
            sw = rw;
            hw = r;
            reset = 0x0;
        } hsize[12:0];
    } ISP_AF_CROP_SIZE @ 0x2218;

    reg {
        name = "AF median filtering threshold register";
        desc = "ISP_AF_MEAN_THRES is an AF median filtering threshold register.

Data sheet 10.6 ISP_AF_MEAN_THRES (offset 0x1221C, printed page 10-60, `hi3516av200--Hi3516AV200-Datasheet.txt` line 68500).";

        field {
            name = "mean_thres";
            desc = "Threshold for AF median filtering";
            sw = rw;
            hw = r;
            reset = 0x0;
        } mean_thres[15:0];
    } ISP_AF_MEAN_THRES @ 0x221C;

    reg {
        name = "AF IIR filtering parameter register 1";
        desc = "ISP_AF_IIRG0 is AF IIR filtering parameter register 1.

Data sheet 10.6 ISP_AF_IIRG0 (offset 0x12220, printed page 10-60, `hi3516av200--Hi3516AV200-Datasheet.txt` line 68519).";

        field {
            name = "iirg0_1";
            desc = "g0 gain of AF IIR filtering group 1";
            sw = rw;
            hw = r;
            reset = 0xA1;
        } iirg0_1[23:16];

        field {
            name = "iirg0_0";
            desc = "g0 gain of AF IIR filtering group 0";
            sw = rw;
            hw = r;
            reset = 0xA0;
        } iirg0_0[7:0];
    } ISP_AF_IIRG0 @ 0x2220;

    reg {
        name = "AF IIR filtering parameter register 1";
        desc = "ISP_AF_IIRG1 is AF IIR filtering parameter register 1. Hi3516A V200 Professional HD IP Camera SoC

Data sheet 10.6 ISP_AF_IIRG1 (offset 0x12224, printed page 10-61, `hi3516av200--Hi3516AV200-Datasheet.txt` line 68557).";

        field {
            name = "iirg1_1";
            desc = "g1 gain of AF IIR filtering group 1";
            sw = rw;
            hw = r;
            reset = 0x244;
        } iirg1_1[25:16];

        field {
            name = "iirg1_0";
            desc = "g1 gain of AF IIR filtering group 0";
            sw = rw;
            hw = r;
            reset = 0x1BC;
        } iirg1_0[9:0];
    } ISP_AF_IIRG1 @ 0x2224;

    reg {
        name = "AF IIR filtering parameter register 2";
        desc = "ISP_AF_IIRG2 is AF IIR filtering parameter register 2.

Data sheet 10.6 ISP_AF_IIRG2 (offset 0x12228, printed page 10-61, `hi3516av200--Hi3516AV200-Datasheet.txt` line 68588).";

        field {
            name = "iirg2_1";
            desc = "g2 gain of AF IIR filtering group 1";
            sw = rw;
            hw = r;
            reset = 0x328;
        } iirg2_1[25:16];

        field {
            name = "iirg2_0";
            desc = "g2 gain of AF IIR filtering group 0";
            sw = rw;
            hw = r;
            reset = 0x328;
        } iirg2_0[9:0];
    } ISP_AF_IIRG2 @ 0x2228;

    reg {
        name = "AF IIR filtering parameter register 3";
        desc = "ISP_AF_IIRG3 is AF IIR filtering parameter register 3.

Data sheet 10.6 ISP_AF_IIRG3 (offset 0x1222C, printed page 10-62, `hi3516av200--Hi3516AV200-Datasheet.txt` line 68627).";

        field {
            name = "iirg3_1";
            desc = "g3 gain of AF IIR filtering group 1";
            sw = rw;
            hw = r;
            reset = 0x0;
        } iirg3_1[25:16];

        field {
            name = "iirg3_0";
            desc = "g3 gain of AF IIR filtering group 0";
            sw = rw;
            hw = r;
            reset = 0x0;
        } iirg3_0[9:0];
    } ISP_AF_IIRG3 @ 0x222C;

    reg {
        name = "AF IIR filtering parameter register 4";
        desc = "ISP_AF_IIRG4 is AF IIR filtering parameter register 4.

Data sheet 10.6 ISP_AF_IIRG4 (offset 0x12230, printed page 10-62, `hi3516av200--Hi3516AV200-Datasheet.txt` line 68657).";

        field {
            name = "iirg4_1";
            desc = "g4 gain of AF IIR filtering group 1";
            sw = rw;
            hw = r;
            reset = 0x0;
        } iirg4_1[25:16];

        field {
            name = "iirg4_0";
            desc = "g4 gain of AF IIR filtering group 0";
            sw = rw;
            hw = r;
            reset = 0x0;
        } iirg4_0[9:0];
    } ISP_AF_IIRG4 @ 0x2230;

    reg {
        name = "AF IIR filtering parameter register 5";
        desc = "ISP_AF_IIRG5 is AF IIR filtering parameter register 5.

Data sheet 10.6 ISP_AF_IIRG5 (offset 0x12234, printed page 10-63, `hi3516av200--Hi3516AV200-Datasheet.txt` line 68696).";

        field {
            name = "iirg5_1";
            desc = "g5 gain of AF IIR filtering group 1";
            sw = rw;
            hw = r;
            reset = 0x284;
        } iirg5_1[25:16];

        field {
            name = "iirg5_0";
            desc = "g5 gain of AF IIR filtering group 0";
            sw = rw;
            hw = r;
            reset = 0x17C;
        } iirg5_0[9:0];
    } ISP_AF_IIRG5 @ 0x2234;

    reg {
        name = "AF IIR filtering parameter register 6";
        desc = "ISP_AF_IIRG6 is AF IIR filtering parameter register 6.

Data sheet 10.6 ISP_AF_IIRG6 (offset 0x12238, printed page 10-63, `hi3516av200--Hi3516AV200-Datasheet.txt` line 68727).";

        field {
            name = "iirg6_1";
            desc = "g6 gain of AF IIR filtering group 1";
            sw = rw;
            hw = r;
            reset = 0x33C;
        } iirg6_1[25:16];

        field {
            name = "iirg6_0";
            desc = "g6 gain of AF IIR filtering group 0";
            sw = rw;
            hw = r;
            reset = 0x33C;
        } iirg6_0[9:0];
    } ISP_AF_IIRG6 @ 0x2238;

    reg {
        name = "AF IIR filter preset register";
        desc = "ISP_AF_IIRPL is an AF IIR filter preset register.

Data sheet 10.6 ISP_AF_IIRPL (offset 0x1223C, printed page 10-64, `hi3516av200--Hi3516AV200-Datasheet.txt` line 68767).";

        field {
            name = "iirpls_1";
            desc = "Preset shift for AF IIR filter group 1";
            sw = rw;
            hw = r;
            reset = 0x0;
        } iirpls_1[26:24];

        field {
            name = "iirplg_1";
            desc = "Preset gain for AF IIR filter group 1";
            sw = rw;
            hw = r;
            reset = 0x0;
        } iirplg_1[23:16];

        field {
            name = "iirpls_0";
            desc = "Preset shift for AF IIR filter group 0";
            sw = rw;
            hw = r;
            reset = 0x0;
        } iirpls_0[10:8];

        field {
            name = "iirplg_0";
            desc = "Preset gain for AF IIR filter group 0";
            sw = rw;
            hw = r;
            reset = 0x0;
        } iirplg_0[7:0];
    } ISP_AF_IIRPL @ 0x223C;

    reg {
        name = "AF IIR filtering shift parameter register";
        desc = "ISP_AF_SHIFT is an AF IIR filtering shift parameter register. Hi3516A V200 Professional HD IP Camera SoC

Data sheet 10.6 ISP_AF_SHIFT (offset 0x12240, printed page 10-65, `hi3516av200--Hi3516AV200-Datasheet.txt` line 68804).";

        field {
            name = "iirshift1_3";
            desc = "Shift adjustment for IIR2 in AF IIR filtering group 1";
            sw = rw;
            hw = r;
            reset = 0x0;
        } iirshift1_3[30:28];

        field {
            name = "iirshift1_2";
            desc = "Shift adjustment for IIR1 in AF IIR filtering group 1";
            sw = rw;
            hw = r;
            reset = 0x0;
        } iirshift1_2[26:24];

        field {
            name = "iirshift1_1";
            desc = "Shift adjustment for IIR0 in AF IIR filtering group 1";
            sw = rw;
            hw = r;
            reset = 0x2;
        } iirshift1_1[22:20];

        field {
            name = "iirshift1_0";
            desc = "Input shift adjustment for AF IIR filtering group 1 Note the following: iirg0_1 >= 128, iirshift0_0 >= 4 iirg0_1 >= 64, iirshift0_0 >= 3 iirg0_1 >= 32, iirshift0_0 >= 2 iirg0_1 >= 16, iirshift0_0 >= 1";
            sw = rw;
            hw = r;
            reset = 0x7;
        } iirshift1_0[18:16];

        field {
            name = "iirshift0_3";
            desc = "Shift adjustment for IIR2 in AF IIR filtering group 0";
            sw = rw;
            hw = r;
            reset = 0x1;
        } iirshift0_3[14:12];

        field {
            name = "iirshift0_2";
            desc = "Shift adjustment for IIR1 in AF IIR filtering group 0";
            sw = rw;
            hw = r;
            reset = 0x0;
        } iirshift0_2[10:8];

        field {
            name = "iirshift0_1";
            desc = "Shift adjustment for IIR0 in AF IIR filtering group 0";
            sw = rw;
            hw = r;
            reset = 0x2;
        } iirshift0_1[6:4];

        field {
            name = "iirshift0_0";
            desc = "Input shift adjustment for AF IIR filtering group 0 Note the following: iirg0_1 >= 128, iirshift0_0 >= 4 iirg0_1 >= 64, iirshift0_0 >= 3 iirg0_1 >= 32, iirshift0_0 >= 2 iirg0_1 >= 16, iirshift0_0 >= 1";
            sw = rw;
            hw = r;
            reset = 0x7;
        } iirshift0_0[2:0];
    } ISP_AF_SHIFT @ 0x2240;

    reg {
        name = "AF FIR filtering parameter register 0";
        desc = "ISP_AF_FIRH0 is AF FIR filtering parameter register 0.

Data sheet 10.6 ISP_AF_FIRH0 (offset 0x12250, printed page 10-66, `hi3516av200--Hi3516AV200-Datasheet.txt` line 68863).";

        field {
            name = "firh0_1";
            desc = "h0 gain of AF FIR filtering group 1";
            sw = rw;
            hw = r;
            reset = 0x30;
        } firh0_1[21:16];

        field {
            name = "firh0_0";
            desc = "h0 gain of AF FIR filtering group 0";
            sw = rw;
            hw = r;
            reset = 0x30;
        } firh0_0[5:0];
    } ISP_AF_FIRH0 @ 0x2250;

    reg {
        name = "AF FIR filtering parameter register 1";
        desc = "ISP_AF_FIRH1 is AF FIR filtering parameter register 1.

Data sheet 10.6 ISP_AF_FIRH1 (offset 0x12254, printed page 10-66, `hi3516av200--Hi3516AV200-Datasheet.txt` line 68893).";

        field {
            name = "firh1_1";
            desc = "h1 gain of AF FIR filtering group 1";
            sw = rw;
            hw = r;
            reset = 0x15;
        } firh1_1[21:16];

        field {
            name = "firh1_0";
            desc = "h1 gain of AF FIR filtering group 0";
            sw = rw;
            hw = r;
            reset = 0x2B;
        } firh1_0[5:0];
    } ISP_AF_FIRH1 @ 0x2254;

    reg {
        name = "AF FIR filtering parameter register 1";
        desc = "ISP_AF_FIRH2 is AF FIR filtering parameter register 1.

Data sheet 10.6 ISP_AF_FIRH2 (offset 0x12258, printed page 10-67, `hi3516av200--Hi3516AV200-Datasheet.txt` line 68932).";

        field {
            name = "firh2_1";
            desc = "h2 gain of AF FIR filtering group 1";
            sw = rw;
            hw = r;
            reset = 0x0;
        } firh2_1[21:16];

        field {
            name = "firh2_0";
            desc = "h2 gain of AF FIR filtering group 0";
            sw = rw;
            hw = r;
            reset = 0x0;
        } firh2_0[5:0];
    } ISP_AF_FIRH2 @ 0x2258;

    reg {
        name = "AF FIR filtering parameter register 3";
        desc = "ISP_AF_FIRH3 is AF FIR filtering parameter register 3.

Data sheet 10.6 ISP_AF_FIRH3 (offset 0x1225C, printed page 10-67, `hi3516av200--Hi3516AV200-Datasheet.txt` line 68963).";

        field {
            name = "firh3_1";
            desc = "h3 gain of AF FIR filtering group 1";
            sw = rw;
            hw = r;
            reset = 0x2B;
        } firh3_1[21:16];

        field {
            name = "firh3_0";
            desc = "h3 gain of AF FIR filtering group 0";
            sw = rw;
            hw = r;
            reset = 0x15;
        } firh3_0[5:0];
    } ISP_AF_FIRH3 @ 0x225C;

    reg {
        name = "AF FIR filtering parameter register 4";
        desc = "ISP_AF_FIRH4 is AF FIR filtering parameter register 4.

Data sheet 10.6 ISP_AF_FIRH4 (offset 0x12260, printed page 10-68, `hi3516av200--Hi3516AV200-Datasheet.txt` line 69004).";

        field {
            name = "firh4_1";
            desc = "h4 gain of AF FIR filtering group 1";
            sw = rw;
            hw = r;
            reset = 0x10;
        } firh4_1[21:16];

        field {
            name = "firh4_0";
            desc = "h4 gain of AF FIR filtering group 0";
            sw = rw;
            hw = r;
            reset = 0x10;
        } firh4_0[5:0];
    } ISP_AF_FIRH4 @ 0x2260;

    reg {
        name = "AF cumulative statistics shift register";
        desc = "ISP_AF_ACC_SHIFT is an AF cumulative statistics shift register. Hi3516A V200 Professional HD IP Camera SoC

Data sheet 10.6 ISP_AF_ACC_SHIFT (offset 0x12278, printed page 10-69, `hi3516av200--Hi3516AV200-Datasheet.txt` line 69044).";

        field {
            name = "acc_shift_y";
            desc = "Luminance Y statistics shift (0-15). Y in CH_AF_STAT_RDATA is shifted.";
            sw = rw;
            hw = r;
            reset = 0x2;
        } acc_shift_y[19:16];

        field {
            name = "acc_shift1_v";
            desc = "Shift of vertical FIR filtering statistics in group 1 (0-15). V2 in CH_AF_STAT_RDATA is shifted.";
            sw = rw;
            hw = r;
            reset = 0x0;
        } acc_shift1_v[15:12];

        field {
            name = "acc_shift0_v";
            desc = "Shift of vertical FIR filtering statistics in group 0 (0-15). V1 in CH_AF_STAT_RDATA is shifted.";
            sw = rw;
            hw = r;
            reset = 0x2;
        } acc_shift0_v[11:8];

        field {
            name = "acc_shift1_h";
            desc = "Shift of horizontal IIR filtering statistics in group 1 (0-15). H2 in CH_AF_STAT_RDATA is shifted.";
            sw = rw;
            hw = r;
            reset = 0x0;
        } acc_shift1_h[7:4];

        field {
            name = "acc_shift0_h";
            desc = "Shift of horizontal IIR filtering statistics in group 0 (0-15). H1 in CH_AF_STAT_RDATA is shifted.";
            sw = rw;
            hw = r;
            reset = 0x0;
        } acc_shift0_h[3:0];
    } ISP_AF_ACC_SHIFT @ 0x2278;

    reg {
        name = "AF count statistics shift register";
        desc = "ISP_AF_CNT_SHIFT is an AF count statistics shift register.

Data sheet 10.6 ISP_AF_CNT_SHIFT (offset 0x1227C, printed page 10-69, `hi3516av200--Hi3516AV200-Datasheet.txt` line 69078).";

        field {
            name = "cnt_shift_y";
            desc = "Luminance (Y) count value shift";
            sw = rw;
            hw = r;
            reset = 0x0;
        } cnt_shift_y[19:16];

        field {
            name = "cnt_shift1_v";
            desc = "Shift of the vertical FIR filtering statistics in group 1 (0-15). vcnt2 in CH_AF_STAT_RDATA is shifted.";
            sw = rw;
            hw = r;
            reset = 0x0;
        } cnt_shift1_v[15:12];

        field {
            name = "cnt_shift0_v";
            desc = "Shift of the vertical FIR filtering statistics in group 0 (0-15). vcnt1 in CH_AF_STAT_RDATA is shifted.";
            sw = rw;
            hw = r;
            reset = 0x2;
        } cnt_shift0_v[11:8];

        field {
            name = "cnt_shift1_h";
            desc = "Shift of the horizontal IIR filtering statistics in group 1 (0-15). hcnt2 in CH_AF_STAT_RDATA is shifted.";
            sw = rw;
            hw = r;
            reset = 0x0;
        } cnt_shift1_h[7:4];

        field {
            name = "cnt_shift0_h";
            desc = "Shift of the horizontal IIR filtering statistics in group 0 (0-15). hcnt1 in CH_AF_STAT_RDATA is shifted.";
            sw = rw;
            hw = r;
            reset = 0x0;
        } cnt_shift0_h[3:0];
    } ISP_AF_CNT_SHIFT @ 0x227C;

    reg {
        name = "Statistics indirect read address register for AF blocks";
        desc = "ISP_AF_STAT_IND_RADDR is a statistics indirect read address register for AF blocks.

Data sheet 10.6 ISP_AF_STAT_IND_RADDR (offset 0x12288, printed page 10-70, `hi3516av200--Hi3516AV200-Datasheet.txt` line 69117).";

        field {
            name = "af_stat_ind_raddr";
            desc = "Statistics indirect read address register for AF blocks";
            sw = rw;
            hw = r;
            reset = 0x0;
        } af_stat_ind_raddr[31:0];
    } ISP_AF_STAT_IND_RADDR @ 0x2288;

    reg {
        name = "Statistics indirect read data register for AF blocks";
        desc = "ISP_AF_STAT_IND_RDATA is a statistics indirect read data register for AF blocks. Hi3516A V200 Professional HD IP Camera SoC

Data sheet 10.6 ISP_AF_STAT_IND_RDATA (offset 0x1228C, printed page 10-71, `hi3516av200--Hi3516AV200-Datasheet.txt` line 69144).";

        enum ISP_AF_STAT_IND_RDATA_af_stat_ind_rdata_enum {
            V1_H1_BLOCK = 0x1 { name = "V1 H1 Block"; desc = "{V1 (16 bits), H1 (16 bits)} of block 1"; };
            V2_H2_BLOCK = 0x2 { name = "V2 H2 Block"; desc = "{V2 (16 bits), H2 (16 bits)} of block 1"; };
            YCNT_Y_BLOCK = 0x3 { name = "Ycnt Y Block"; desc = "{ycnt (16 bits), Y (16 bits)} of block 1"; };
            VCNT2_VCNT1_HCNT2 = 0x4 { name = "Vcnt2 Vcnt1 Hcnt2"; desc = "{vcnt2 (8 bits), vcnt1 (8 bits), hcnt2 (8 bits), cnt1(8bit)} of block 1"; };
            V1_H1_BLOCK_2 = 0x5 { name = "V1 H1 Block 2"; desc = "{V1 (16 bits), H1 (16 bits)} of block 2 … The same rule applies to other values. Note the following: V1 indicates the vertical FIR filtering statistics of group 1. V2 indicates the vertical FIR filtering statistics of group 2. H1 indicates the horizontal IIR filtering statistics of group 1. H2 indicates the horizontal IIR filtering statistics of group 2. Y indicates luminance statistics. vcnt1 indicates the number of times that the FIR filtering value is above the threshold. vcnt2 indicates the number of times that the FIR filtering value is above the threshold. hcnt1 indicates the number of times that the IIR filtering value is above the threshold. hcnt2 indicates the number of times that the IIR filtering value is above the threshold."; };
        };

        field {
            name = "af_stat_ind_rdata";
            desc = "Statistics indirect read data register for AF blocks V1, H1, V2, H2, Y, hcnt1, hcnt2, vcnt1, vcnt2, and ycnt information about each block is collected for statistics. The following is the information for each address:";
            sw = r;
            hw = w;
            encode = ISP_AF_STAT_IND_RDATA_af_stat_ind_rdata_enum;
            reset = 0x0;
        } af_stat_ind_rdata[31:0];
    } ISP_AF_STAT_IND_RDATA @ 0x228C;

    reg {
        name = "Immediate update control register";
        desc = "ISP_AF_CTRL_I is an immediate update control register. Hi3516A V200 Professional HD IP Camera SoC

Data sheet 10.6 ISP_AF_CTRL_I (offset 0x122E4, printed page 10-72, `hi3516av200--Hi3516AV200-Datasheet.txt` line 69199).";

        enum ISP_AF_CTRL_I_update_mode_enum {
            UPDATE_MODE_SPECIFIED = 0 { name = "Update Mode Specified"; desc = "update mode specified in ISP_AF_UPDATE"; };
            FRAME_UPDATE_MODE = 1 { name = "Frame Update Mode"; desc = "frame update mode"; };
        };

        field {
            name = "update_mode";
            desc = "ISP update mode";
            sw = rw;
            hw = r;
            encode = ISP_AF_CTRL_I_update_mode_enum;
            reset = 0x0;
        } update_mode[0:0];
    } ISP_AF_CTRL_I @ 0x22E4;

    reg {
        name = "Configuration update register";
        desc = "ISP_AF_UPDATE is a configuration update register.

Data sheet 10.6 ISP_AF_UPDATE (offset 0x122EC, printed page 10-72, `hi3516av200--Hi3516AV200-Datasheet.txt` line 69227).";

        field {
            name = "update";
            desc = "ISP update. This bit is automatically cleared for each frame.";
            sw = rw;
            hw = r;
            reset = 0x0;
        } update[0:0];
    } ISP_AF_UPDATE @ 0x22EC;

    reg {
        name = "AF picture size register";
        desc = "ISP_AF_SIZE is an AF picture size register. Hi3516A V200 Professional HD IP Camera SoC

Data sheet 10.6 ISP_AF_SIZE (offset 0x122F0, printed page 10-73, `hi3516av200--Hi3516AV200-Datasheet.txt` line 69258).";

        field {
            name = "vsize";
            desc = "Height of the AF input picture. The configured value is the actual value minus 1.";
            sw = rw;
            hw = r;
            reset = 0x437;
        } vsize[28:16];

        field {
            name = "hsize";
            desc = "Width of the AF input picture. The configured value is the actual value minus 1.";
            sw = rw;
            hw = r;
            reset = 0x77F;
        } hsize[12:0];
    } ISP_AF_SIZE @ 0x22F0;

    reg {
        name = "AF IIR filtering threshold register";
        desc = "ISP_AF_IIRTHRE is an AF IIR filtering threshold register.

Data sheet 10.6 ISP_AF_IIRTHRE (offset 0x12300, printed page 10-73, `hi3516av200--Hi3516AV200-Datasheet.txt` line 69287).";

        field {
            name = "iir_thre1_h";
            desc = "Luma dependent high threshold for AF IIR filter group 1";
            sw = rw;
            hw = r;
            reset = 0x0;
        } iir_thre1_h[31:24];

        field {
            name = "iir_thre1_l";
            desc = "Luma dependent low threshold for AF IIR filter group 1";
            sw = rw;
            hw = r;
            reset = 0x0;
        } iir_thre1_l[23:16];

        field {
            name = "iir_thre0_h";
            desc = "Luma dependent high threshold for AF IIR filter group 0";
            sw = rw;
            hw = r;
            reset = 0x0;
        } iir_thre0_h[15:8];

        field {
            name = "iir_thre0_l";
            desc = "Luma dependent low threshold for AF IIR filter group 0";
            sw = rw;
            hw = r;
            reset = 0x0;
        } iir_thre0_l[7:0];
    } ISP_AF_IIRTHRE @ 0x2300;

    reg {
        name = "AF IIR filtering gain register";
        desc = "ISP_AF_IIRGAIN is an AF IIR filtering gain register. Hi3516A V200 Professional HD IP Camera SoC

Data sheet 10.6 ISP_AF_IIRGAIN (offset 0x12304, printed page 10-74, `hi3516av200--Hi3516AV200-Datasheet.txt` line 69318).";

        field {
            name = "iir_gain1_h";
            desc = "Luma dependent high gain for AF IIR filter group 1";
            sw = rw;
            hw = r;
            reset = 0x0;
        } iir_gain1_h[31:24];

        field {
            name = "iir_gain1_l";
            desc = "Luma dependent low gain for AF IIR filter group 1";
            sw = rw;
            hw = r;
            reset = 0x0;
        } iir_gain1_l[23:16];

        field {
            name = "iir_gain0_h";
            desc = "Luma dependent high gain for AF IIR filter group 0";
            sw = rw;
            hw = r;
            reset = 0x0;
        } iir_gain0_h[15:8];

        field {
            name = "iir_gain0_l";
            desc = "Luma dependent low gain for AF IIR filter group 0";
            sw = rw;
            hw = r;
            reset = 0x0;
        } iir_gain0_l[7:0];
    } ISP_AF_IIRGAIN @ 0x2304;

    reg {
        name = "AF IIR filtering slope register";
        desc = "ISP_AF_IIRSLOPE is an AF IIR filtering slope register.

Data sheet 10.6 ISP_AF_IIRSLOPE (offset 0x12308, printed page 10-74, `hi3516av200--Hi3516AV200-Datasheet.txt` line 69340).";

        field {
            name = "iir_slope1_h";
            desc = "Luma dependent high slope for AF IIR filter group 1";
            sw = rw;
            hw = r;
            reset = 0x0;
        } iir_slope1_h[23:20];

        field {
            name = "iir_slope1_l";
            desc = "Luma dependent low slope for AF IIR filter group 1";
            sw = rw;
            hw = r;
            reset = 0x0;
        } iir_slope1_l[19:16];

        field {
            name = "iir_slope0_h";
            desc = "Luma dependent high slope for AF IIR filter group 0";
            sw = rw;
            hw = r;
            reset = 0x0;
        } iir_slope0_h[7:4];

        field {
            name = "iir_slope0_l";
            desc = "Luma dependent low slope for AF IIR filter group 0";
            sw = rw;
            hw = r;
            reset = 0x0;
        } iir_slope0_l[3:0];
    } ISP_AF_IIRSLOPE @ 0x2308;

    reg {
        name = "AF IIR filtering dilate register";
        desc = "ISP_AF_IIRDILATE is an AF IIR filtering dilate register. Hi3516A V200 Professional HD IP Camera SoC

Data sheet 10.6 ISP_AF_IIRDILATE (offset 0x1230C, printed page 10-75, `hi3516av200--Hi3516AV200-Datasheet.txt` line 69373).";

        enum ISP_AF_IIRDILATE_iir_dilate1_enum {
            MAXIMUM_VALUE_AMONG = 0 { name = "Maximum Value Among"; desc = "The maximum value among eight surrounding pixels is used."; };
            MAXIMUM_VALUE_AMONG_2 = 1 { name = "Maximum Value Among 2"; desc = "The maximum value among 16 surrounding pixels is used."; };
            MAXIMUM_VALUE_AMONG_3 = 2 { name = "Maximum Value Among 3"; desc = "The maximum value among 24 surrounding pixels is used."; };
            MAXIMUM_VALUE_AMONG_4 = 3 { name = "Maximum Value Among 4"; desc = "The maximum value among 32 surrounding pixels is used."; };
            MAXIMUM_VALUE_AMONG_5 = 4 { name = "Maximum Value Among 5"; desc = "The maximum value among 40 surrounding pixels is used."; };
            MAXIMUM_VALUE_AMONG_6 = 5 { name = "Maximum Value Among 6"; desc = "The maximum value among 48 surrounding pixels is used."; };
            MAXIMUM_VALUE_AMONG_7 = 6 { name = "Maximum Value Among 7"; desc = "The maximum value among 56 surrounding pixels is used."; };
            MAXIMUM_VALUE_AMONG_8 = 7 { name = "Maximum Value Among 8"; desc = "The maximum value among 64 surrounding pixels is used."; };
        };

        field {
            name = "iir_dilate1";
            desc = "Obtaining the maximum value among n surrounding pixels for calculating the IIR1 luma dependent gain DILATE:";
            sw = rw;
            hw = r;
            encode = ISP_AF_IIRDILATE_iir_dilate1_enum;
            reset = 0x0;
        } iir_dilate1[10:8];

        enum ISP_AF_IIRDILATE_iir_dilate0_enum {
            MAXIMUM_VALUE_AMONG = 0 { name = "Maximum Value Among"; desc = "The maximum value among eight surrounding pixels is used."; };
            MAXIMUM_VALUE_AMONG_2 = 1 { name = "Maximum Value Among 2"; desc = "The maximum value among 16 surrounding pixels is used."; };
            MAXIMUM_VALUE_AMONG_3 = 2 { name = "Maximum Value Among 3"; desc = "The maximum value among 24 surrounding pixels is used."; };
            MAXIMUM_VALUE_AMONG_4 = 3 { name = "Maximum Value Among 4"; desc = "The maximum value among 32 surrounding pixels is used."; };
            MAXIMUM_VALUE_AMONG_5 = 4 { name = "Maximum Value Among 5"; desc = "The maximum value among 40 surrounding pixels is used."; };
            MAXIMUM_VALUE_AMONG_6 = 5 { name = "Maximum Value Among 6"; desc = "The maximum value among 48 surrounding pixels is used."; };
            MAXIMUM_VALUE_AMONG_7 = 6 { name = "Maximum Value Among 7"; desc = "The maximum value among 56 surrounding pixels is used."; };
            MAXIMUM_VALUE_AMONG_8 = 7 { name = "Maximum Value Among 8"; desc = "The maximum value among 64 surrounding pixels is used."; };
        };

        field {
            name = "iir_dilate0";
            desc = "Obtaining the maximum value among n surrounding pixels for calculating the IIR0 luma dependent gain DILATE:";
            sw = rw;
            hw = r;
            encode = ISP_AF_IIRDILATE_iir_dilate0_enum;
            reset = 0x0;
        } iir_dilate0[2:0];
    } ISP_AF_IIRDILATE @ 0x230C;

    reg {
        name = "AF FIR filtering threshold register";
        desc = "ISP_AF_FIRTHRE is an AF FIR filtering threshold register. Hi3516A V200 Professional HD IP Camera SoC

Data sheet 10.6 ISP_AF_FIRTHRE (offset 0x12310, printed page 10-76, `hi3516av200--Hi3516AV200-Datasheet.txt` line 69430).";

        field {
            name = "fir_thre1_h";
            desc = "Luma dependent high threshold for AF FIR filter group 1";
            sw = rw;
            hw = r;
            reset = 0x0;
        } fir_thre1_h[31:24];

        field {
            name = "fir_thre1_l";
            desc = "Luma dependent low threshold for AF FIR filter group 1";
            sw = rw;
            hw = r;
            reset = 0x0;
        } fir_thre1_l[23:16];

        field {
            name = "fir_thre0_h";
            desc = "Luma dependent high threshold for AF FIR filter group 0";
            sw = rw;
            hw = r;
            reset = 0x0;
        } fir_thre0_h[15:8];

        field {
            name = "fir_thre0_l";
            desc = "Luma dependent low threshold for AF FIR filter group 0";
            sw = rw;
            hw = r;
            reset = 0x0;
        } fir_thre0_l[7:0];
    } ISP_AF_FIRTHRE @ 0x2310;

    reg {
        name = "AF FIR filtering gain register";
        desc = "ISP_AF_FIRGAIN is an AF FIR filtering gain register.

Data sheet 10.6 ISP_AF_FIRGAIN (offset 0x12314, printed page 10-76, `hi3516av200--Hi3516AV200-Datasheet.txt` line 69452).";

        field {
            name = "fir_gain1_h";
            desc = "Luma dependent high gain for AF FIR filter group 1";
            sw = rw;
            hw = r;
            reset = 0x0;
        } fir_gain1_h[31:24];

        field {
            name = "fir_gain1_l";
            desc = "Luma dependent low gain for AF FIR filter group 1";
            sw = rw;
            hw = r;
            reset = 0x0;
        } fir_gain1_l[23:16];

        field {
            name = "fir_gain0_h";
            desc = "Luma dependent high gain for AF FIR filter group 0";
            sw = rw;
            hw = r;
            reset = 0x0;
        } fir_gain0_h[15:8];

        field {
            name = "fir_gain0_l";
            desc = "Luma dependent low gain for AF FIR filter group 0";
            sw = rw;
            hw = r;
            reset = 0x0;
        } fir_gain0_l[7:0];
    } ISP_AF_FIRGAIN @ 0x2314;

    reg {
        name = "AF FIR filtering slope register";
        desc = "ISP_AF_FIRSLOPE is an AF FIR filtering slope register. Hi3516A V200 Professional HD IP Camera SoC

Data sheet 10.6 ISP_AF_FIRSLOPE (offset 0x12318, printed page 10-77, `hi3516av200--Hi3516AV200-Datasheet.txt` line 69483).";

        field {
            name = "fir_slope1_h";
            desc = "Luma dependent high slope for AF FIR filter group 1";
            sw = rw;
            hw = r;
            reset = 0x0;
        } fir_slope1_h[23:20];

        field {
            name = "fir_slope1_l";
            desc = "Luma dependent low slope for AF FIR filter group 1";
            sw = rw;
            hw = r;
            reset = 0x0;
        } fir_slope1_l[19:16];

        field {
            name = "fir_slope0_h";
            desc = "Luma dependent high slope for AF FIR filter group 0";
            sw = rw;
            hw = r;
            reset = 0x0;
        } fir_slope0_h[7:4];

        field {
            name = "fir_slope0_l";
            desc = "Luma dependent low slope for AF FIR filter group 0";
            sw = rw;
            hw = r;
            reset = 0x0;
        } fir_slope0_l[3:0];
    } ISP_AF_FIRSLOPE @ 0x2318;

    reg {
        name = "AF IIR filter coring threshold register";
        desc = "ISP_AF_IIRTHRE_CORING is an AF IIR filter coring threshold register.

Data sheet 10.6 ISP_AF_IIRTHRE_CORING (offset 0x12320, printed page 10-77, `hi3516av200--Hi3516AV200-Datasheet.txt` line 69507).";

        field {
            name = "iir_thre1_c";
            desc = "Coring threshold of AF IIR filter group 1";
            sw = rw;
            hw = r;
            reset = 0x0;
        } iir_thre1_c[26:16];

        field {
            name = "iir_thre0_c";
            desc = "Coring threshold of AF IIR filter group 0";
            sw = rw;
            hw = r;
            reset = 0x0;
        } iir_thre0_c[10:0];
    } ISP_AF_IIRTHRE_CORING @ 0x2320;

    reg {
        name = "AF IIR filter coring peak register";
        desc = "ISP_AF_IIRPEAK_CORING is an AF IIR filter coring peak register. Hi3516A V200 Professional HD IP Camera SoC

Data sheet 10.6 ISP_AF_IIRPEAK_CORING (offset 0x12324, printed page 10-78, `hi3516av200--Hi3516AV200-Datasheet.txt` line 69538).";

        field {
            name = "iir_peak1_c";
            desc = "Coring peak of AF IIR filter group 1";
            sw = rw;
            hw = r;
            reset = 0x0;
        } iir_peak1_c[26:16];

        field {
            name = "iir_peak0_c";
            desc = "Coring peak of AF IIR filter group 0";
            sw = rw;
            hw = r;
            reset = 0x0;
        } iir_peak0_c[10:0];
    } ISP_AF_IIRPEAK_CORING @ 0x2324;

    reg {
        name = "AF IIR filter coring slope register";
        desc = "ISP_AF_IIRSLOPE_CORING is an AF IIR filter coring slope register.

Data sheet 10.6 ISP_AF_IIRSLOPE_CORING (offset 0x12328, printed page 10-78, `hi3516av200--Hi3516AV200-Datasheet.txt` line 69560).";

        field {
            name = "iir_slope1_c";
            desc = "Coring slope of AF IIR filter group 1";
            sw = rw;
            hw = r;
            reset = 0x0;
        } iir_slope1_c[11:8];

        field {
            name = "iir_slope0_c";
            desc = "Coring slope of AF IIR filter group 0";
            sw = rw;
            hw = r;
            reset = 0x0;
        } iir_slope0_c[3:0];
    } ISP_AF_IIRSLOPE_CORING @ 0x2328;

    reg {
        name = "AF FIR filter coring threshold register";
        desc = "ISP_AF_FIRTHRE_CORING is an AF FIR filter coring threshold register. Hi3516A V200 Professional HD IP Camera SoC

Data sheet 10.6 ISP_AF_FIRTHRE_CORING (offset 0x12330, printed page 10-79, `hi3516av200--Hi3516AV200-Datasheet.txt` line 69591).";

        field {
            name = "fir_thre1_c";
            desc = "Coring threshold of AF FIR filter group 1";
            sw = rw;
            hw = r;
            reset = 0x0;
        } fir_thre1_c[26:16];

        field {
            name = "fir_thre0_c";
            desc = "Coring threshold of AF FIR filter group 0";
            sw = rw;
            hw = r;
            reset = 0x0;
        } fir_thre0_c[10:0];
    } ISP_AF_FIRTHRE_CORING @ 0x2330;

    reg {
        name = "AF FIR filter coring peak register";
        desc = "ISP_AF_FIRPEAK_CORING is an AF FIR filter coring peak register.

Data sheet 10.6 ISP_AF_FIRPEAK_CORING (offset 0x12334, printed page 10-79, `hi3516av200--Hi3516AV200-Datasheet.txt` line 69613).";

        field {
            name = "fir_peak1_c";
            desc = "Coring peak of AF FIR filter group 1";
            sw = rw;
            hw = r;
            reset = 0x0;
        } fir_peak1_c[26:16];

        field {
            name = "fir_peak0_c";
            desc = "Coring peak of AF FIR filter group 0";
            sw = rw;
            hw = r;
            reset = 0x0;
        } fir_peak0_c[10:0];
    } ISP_AF_FIRPEAK_CORING @ 0x2334;

    reg {
        name = "AF FIR filter coring slope register";
        desc = "ISP_AF_FIRSLOPE_CORING is an AF FIR filter coring slope register. Hi3516A V200 Professional HD IP Camera SoC

Data sheet 10.6 ISP_AF_FIRSLOPE_CORING (offset 0x12338, printed page 10-80, `hi3516av200--Hi3516AV200-Datasheet.txt` line 69644).";

        field {
            name = "fir_slope1_c";
            desc = "Coring slope of AF FIR filter group 1";
            sw = rw;
            hw = r;
            reset = 0x0;
        } fir_slope1_c[11:8];

        field {
            name = "fir_slope0_c";
            desc = "Coring slope of AF FIR filter group 0";
            sw = rw;
            hw = r;
            reset = 0x0;
        } fir_slope0_c[3:0];
    } ISP_AF_FIRSLOPE_CORING @ 0x2338;

    reg {
        name = "AF highlight threshold register";
        desc = "ISP_AF_HILIGHT is an AF highlight threshold register.

Data sheet 10.6 ISP_AF_HILIGHT (offset 0x12340, printed page 10-80, `hi3516av200--Hi3516AV200-Datasheet.txt` line 69666).";

        field {
            name = "hilight";
            desc = "AF luminance count threshold";
            sw = rw;
            hw = r;
            reset = 0x0;
        } hilight[7:0];
    } ISP_AF_HILIGHT @ 0x2340;

    reg {
        name = "AF offset configuration register";
        desc = "ISP_AF_OFFSET is an AF offset configuration register. Hi3516A V200 Professional HD IP Camera SoC

Data sheet 10.6 ISP_AF_OFFSET (offset 0x12344, printed page 10-81, `hi3516av200--Hi3516AV200-Datasheet.txt` line 69695).";

        field {
            name = "offset_gb";
            desc = "offset_gb";
            sw = rw;
            hw = r;
            reset = 0x0;
        } offset_gb[29:16];

        field {
            name = "offset_gr";
            desc = "offset_gr";
            sw = rw;
            hw = r;
            reset = 0x0;
        } offset_gr[13:0];
    } ISP_AF_OFFSET @ 0x2344;

    reg {
        name = "AF interrupt indicator register";
        desc = "ISP_AF_INT is an AF interrupt indicator register.

Data sheet 10.6 ISP_AF_INT (offset 0x123F0, printed page 10-81, `hi3516av200--Hi3516AV200-Datasheet.txt` line 69720).";

        enum ISP_AF_INT_int_af_enum {
            NO_INTERRUPT_GENERATED = 0 { name = "No Interrupt Generated"; desc = "No interrupt is generated."; };
            INTERRUPT_GENERATED = 1 { name = "Interrupt Generated"; desc = "An interrupt is generated."; };
        };

        field {
            name = "int_af";
            desc = "AF interrupt indicator";
            sw = rw;
            hw = w;
            onwrite = woclr;
            encode = ISP_AF_INT_int_af_enum;
            reset = 0x0;
        } int_af[0:0];
    } ISP_AF_INT @ 0x23F0;

    reg {
        name = "AF interrupt mask register";
        desc = "ISP_AF_INT_MASK is an AF interrupt mask register. Hi3516A V200 Professional HD IP Camera SoC

Data sheet 10.6 ISP_AF_INT_MASK (offset 0x123F8, printed page 10-82, `hi3516av200--Hi3516AV200-Datasheet.txt` line 69753).";

        enum ISP_AF_INT_MASK_int_af_enum {
            MASKED = 0 { name = "Masked"; desc = "masked"; };
            ENABLED = 1 { name = "Enabled"; desc = "enabled"; };
        };

        field {
            name = "int_af";
            desc = "AF interrupt enable";
            sw = rw;
            hw = r;
            encode = ISP_AF_INT_MASK_int_af_enum;
            reset = 0x0;
        } int_af[0:0];
    } ISP_AF_INT_MASK @ 0x23F8;

    reg {
        name = "Picture width register";
        desc = "ISPFE_ACTIVE_WIDTH is a picture width register.

Data sheet 10.6 ISPFE_ACTIVE_WIDTH (offset 0x20010, printed page 10-82, `hi3516av200--Hi3516AV200-Datasheet.txt` line 69776).";

        field {
            name = "active_width";
            desc = "Active video width (unit: pixel)";
            sw = rw;
            hw = r;
            reset = 0x780;
        } active_width[15:0];
    } ISPFE_ACTIVE_WIDTH @ 0x10010;

    reg {
        name = "Picture height register";
        desc = "ISPFE_ACTIVE_HEIGHT is a picture height register.

Data sheet 10.6 ISPFE_ACTIVE_HEIGHT (offset 0x20014, printed page 10-82, `hi3516av200--Hi3516AV200-Datasheet.txt` line 69795).";

        field {
            name = "active_height";
            desc = "Active video height (unit: line)";
            sw = rw;
            hw = r;
            reset = 0x438;
        } active_height[15:0];
    } ISPFE_ACTIVE_HEIGHT @ 0x10014;

    reg {
        name = "RGGB mode register";
        desc = "ISPFE_RGGB_START is an RGGB mode register.

Data sheet 10.6 ISPFE_RGGB_START (offset 0x20018, printed page 10-83, `hi3516av200--Hi3516AV200-Datasheet.txt` line 69823).";

        enum ISPFE_RGGB_START_rggb_start_enum {
            R_GR_GB = 0 { name = "R Gr Gb"; desc = "R Gr Gb B"; };
            GR_R_B = 1 { name = "Gr R B"; desc = "Gr R B Gb"; };
            GB_B_R = 2 { name = "Gb B R"; desc = "Gb B R Gr"; };
            B_GB_GR = 3 { name = "B Gb Gr"; desc = "B Gb Gr R"; };
        };

        field {
            name = "rggb_start";
            desc = "Initial colors of an RGGB picture";
            sw = rw;
            hw = r;
            encode = ISPFE_RGGB_START_rggb_start_enum;
            reset = 0x0;
        } rggb_start[1:0];
    } ISPFE_RGGB_START @ 0x10018;

    reg {
        name = "Module video test gen and raw FE input data channel selection register";
        desc = "ISPFE_CHANNEL_SELECT is a module video test gen and raw FE input data channel selection register.

Data sheet 10.6 ISPFE_CHANNEL_SELECT (offset 0x20020, printed page 10-83, `hi3516av200--Hi3516AV200-Datasheet.txt` line 69855).";

        enum ISPFE_CHANNEL_SELECT_channel4_select_enum {
            CHANNEL_1_DATA = 0 { name = "Channel 1 Data"; desc = "channel 1 data"; };
            CHANNEL_2_DATA = 1 { name = "Channel 2 Data"; desc = "channel 2 data"; };
            CHANNEL_3_DATA = 2 { name = "Channel 3 Data"; desc = "channel 3 data"; };
            CHANNEL_4_DATA = 3 { name = "Channel 4 Data"; desc = "channel 4 data"; };
        };

        field {
            name = "channel4_select";
            desc = "Channel 4 input data select for the module video test gen and raw FE";
            sw = rw;
            hw = r;
            encode = ISPFE_CHANNEL_SELECT_channel4_select_enum;
            reset = 0x3;
        } channel4_select[7:6];

        enum ISPFE_CHANNEL_SELECT_channel3_select_enum {
            CHANNEL_1_DATA = 0 { name = "Channel 1 Data"; desc = "channel 1 data"; };
            CHANNEL_2_DATA = 1 { name = "Channel 2 Data"; desc = "channel 2 data"; };
            CHANNEL_3_DATA = 2 { name = "Channel 3 Data"; desc = "channel 3 data"; };
            CHANNEL_4_DATA = 3 { name = "Channel 4 Data"; desc = "channel 4 data"; };
        };

        field {
            name = "channel3_select";
            desc = "Channel 3 input data select for the module video test gen and raw FE";
            sw = rw;
            hw = r;
            encode = ISPFE_CHANNEL_SELECT_channel3_select_enum;
            reset = 0x2;
        } channel3_select[5:4];

        enum ISPFE_CHANNEL_SELECT_channel2_select_enum {
            CHANNEL_1_DATA = 0 { name = "Channel 1 Data"; desc = "channel 1 data"; };
            CHANNEL_2_DATA = 1 { name = "Channel 2 Data"; desc = "channel 2 data"; };
            CHANNEL_3_DATA = 2 { name = "Channel 3 Data"; desc = "channel 3 data"; };
            CHANNEL_4_DATA = 3 { name = "Channel 4 Data"; desc = "channel 4 data"; };
        };

        field {
            name = "channel2_select";
            desc = "Channel 2 input data select for the module video test gen and raw FE";
            sw = rw;
            hw = r;
            encode = ISPFE_CHANNEL_SELECT_channel2_select_enum;
            reset = 0x1;
        } channel2_select[3:2];

        enum ISPFE_CHANNEL_SELECT_channel1_select_enum {
            CHANNEL_1_DATA = 0 { name = "Channel 1 Data"; desc = "channel 1 data"; };
            CHANNEL_2_DATA = 1 { name = "Channel 2 Data"; desc = "channel 2 data"; };
            CHANNEL_3_DATA = 2 { name = "Channel 3 Data"; desc = "channel 3 data"; };
            CHANNEL_4_DATA = 3 { name = "Channel 4 Data"; desc = "channel 4 data"; };
        };

        field {
            name = "channel1_select";
            desc = "Channel 1 input data select for the module video test gen and raw FE";
            sw = rw;
            hw = r;
            encode = ISPFE_CHANNEL_SELECT_channel1_select_enum;
            reset = 0x0;
        } channel1_select[1:0];
    } ISPFE_CHANNEL_SELECT @ 0x10020;

    reg {
        name = "Module DNR line delay register";
        desc = "ISPFE_DELAY_LINE_MEMORY is a module DNR line delay register. Hi3516A V200 Professional HD IP Camera SoC

Data sheet 10.6 ISPFE_DELAY_LINE_MEMORY (offset 0x20024, printed page 10-85, `hi3516av200--Hi3516AV200-Datasheet.txt` line 69926).";

        enum ISPFE_DELAY_LINE_MEMORY_delay_line_memory_configuration_enum {
            MAXIMUM_NUMBER_LINES = 0 { name = "Maximum Number Lines"; desc = "maximum number of lines; minimum line width"; };
            V_3_4_MAXIMUM = 1 { name = "V 3 4 Maximum"; desc = "3/4 maximum number of lines; 4/3 minimum line width 1X: 1/2 maximum number of lines; twice minimum line width"; };
        };

        field {
            name = "delay_line_memory_configuration";
            desc = "DNR memory line delay control";
            sw = rw;
            hw = r;
            encode = ISPFE_DELAY_LINE_MEMORY_delay_line_memory_configuration_enum;
            reset = 0x2;
        } delay_line_memory_configuration[1:0];
    } ISPFE_DELAY_LINE_MEMORY @ 0x10024;

    reg {
        name = "Line blanking timing configuration register";
        desc = "ISPFE_FLUSH_HBLANK is a line blanking timing configuration register.

Data sheet 10.6 ISPFE_FLUSH_HBLANK (offset 0x20028, printed page 10-85, `hi3516av200--Hi3516AV200-Datasheet.txt` line 69956).";

        field {
            name = "flush_hblank";
            desc = "Horizontal line blanking control for the replication line";
            sw = rw;
            hw = r;
            reset = 0x20;
        } flush_hblank[15:0];
    } ISPFE_FLUSH_HBLANK @ 0x10028;

    reg {
        name = "WDR input data channel selection register";
        desc = "ISPFE_FS_CHANNEL_SELECT is a WDR input data channel selection register. Hi3516A V200 Professional HD IP Camera SoC

Data sheet 10.6 ISPFE_FS_CHANNEL_SELECT (offset 0x2002C, printed page 10-86, `hi3516av200--Hi3516AV200-Datasheet.txt` line 69985).";

        enum ISPFE_FS_CHANNEL_SELECT_fs_channel4_select_enum {
            CHANNEL_1_DATA = 0 { name = "Channel 1 Data"; desc = "channel 1 data"; };
            CHANNEL_2_DATA = 1 { name = "Channel 2 Data"; desc = "channel 2 data"; };
            CHANNEL_3_DATA = 2 { name = "Channel 3 Data"; desc = "channel 3 data"; };
            CHANNEL_4_DATA = 3 { name = "Channel 4 Data"; desc = "channel 4 data"; };
        };

        field {
            name = "fs_channel4_select";
            desc = "Channel 4 input data select for the module frame stitch";
            sw = rw;
            hw = r;
            encode = ISPFE_FS_CHANNEL_SELECT_fs_channel4_select_enum;
            reset = 0x3;
        } fs_channel4_select[7:6];

        enum ISPFE_FS_CHANNEL_SELECT_fs_channel3_select_enum {
            CHANNEL_1_DATA = 0 { name = "Channel 1 Data"; desc = "channel 1 data"; };
            CHANNEL_2_DATA = 1 { name = "Channel 2 Data"; desc = "channel 2 data"; };
            CHANNEL_3_DATA = 2 { name = "Channel 3 Data"; desc = "channel 3 data"; };
            CHANNEL_4_DATA = 3 { name = "Channel 4 Data"; desc = "channel 4 data"; };
        };

        field {
            name = "fs_channel3_select";
            desc = "Channel 3 input data select for the module frame stitch";
            sw = rw;
            hw = r;
            encode = ISPFE_FS_CHANNEL_SELECT_fs_channel3_select_enum;
            reset = 0x2;
        } fs_channel3_select[5:4];

        enum ISPFE_FS_CHANNEL_SELECT_fs_channel2_select_enum {
            CHANNEL_1_DATA = 0 { name = "Channel 1 Data"; desc = "channel 1 data"; };
            CHANNEL_2_DATA = 1 { name = "Channel 2 Data"; desc = "channel 2 data"; };
            CHANNEL_3_DATA = 2 { name = "Channel 3 Data"; desc = "channel 3 data"; };
            CHANNEL_4_DATA = 3 { name = "Channel 4 Data"; desc = "channel 4 data"; };
        };

        field {
            name = "fs_channel2_select";
            desc = "Channel 2 input data select for the module frame stitch";
            sw = rw;
            hw = r;
            encode = ISPFE_FS_CHANNEL_SELECT_fs_channel2_select_enum;
            reset = 0x1;
        } fs_channel2_select[3:2];

        enum ISPFE_FS_CHANNEL_SELECT_fs_channel1_select_enum {
            CHANNEL_1_DATA = 0 { name = "Channel 1 Data"; desc = "channel 1 data"; };
            CHANNEL_2_DATA = 1 { name = "Channel 2 Data"; desc = "channel 2 data"; };
            CHANNEL_3_DATA = 2 { name = "Channel 3 Data"; desc = "channel 3 data"; };
            CHANNEL_4_DATA = 3 { name = "Channel 4 Data"; desc = "channel 4 data"; };
        };

        field {
            name = "fs_channel1_select";
            desc = "Channel 1 input data select for the module frame stitch";
            sw = rw;
            hw = r;
            encode = ISPFE_FS_CHANNEL_SELECT_fs_channel1_select_enum;
            reset = 0x0;
        } fs_channel1_select[1:0];
    } ISPFE_FS_CHANNEL_SELECT @ 0x1002C;

    reg {
        name = "Configuration update mode register";
        desc = "ISPFE_CONFIG_BUFFER_MODE is a configuration update mode register. Hi3516A V200 Professional HD IP Camera SoC

Data sheet 10.6 ISPFE_CONFIG_BUFFER_MODE (offset 0x20030, printed page 10-87, `hi3516av200--Hi3516AV200-Datasheet.txt` line 70039).";

        enum ISPFE_CONFIG_BUFFER_MODE_config_buffer_mode_enum {
            DUAL_BUFFER_MODE = 0 { name = "Dual Buffer Mode"; desc = "The dual-buffer mode is disabled and the configuration is immediately updated."; };
            CONFIGURATION_UPDATE_FORBIDDEN = 1 { name = "Configuration Update Forbidden"; desc = "The configuration update is forbidden, and the configuration is never updated."; };
            MODULE_CONFIGURATION_UPDATED = 2 { name = "Module Configuration Updated"; desc = "The module configuration is updated in the vertical blanking of the corresponding module."; };
            ALL_MODULE_CONFIGURATIONS = 3 { name = "All Module Configurations"; desc = "All module configurations are updated in the ISP FE global vertical blanking."; };
        };

        field {
            name = "config_buffer_mode";
            desc = "ISP FE dual-buffer mode select configuration";
            sw = rw;
            hw = r;
            encode = ISPFE_CONFIG_BUFFER_MODE_config_buffer_mode_enum;
            reset = 0x0;
        } config_buffer_mode[1:0];
    } ISPFE_CONFIG_BUFFER_MODE @ 0x10030;

    reg {
        name = "Module clock enable control register";
        desc = "ISPFE_CLK_DIS is a module clock enable control register. Hi3516A V200 Professional HD IP Camera SoC

Data sheet 10.6 ISPFE_CLK_DIS (offset 0x20034, printed page 10-88, `hi3516av200--Hi3516AV200-Datasheet.txt` line 70084).";

        field {
            name = "clk_dis_awb";
            desc = "The input clock of the AWB statistics module is disabled when this bit is set to 1.";
            sw = rw;
            hw = r;
            reset = 0x0;
        } clk_dis_awb[6:6];

        field {
            name = "clk_dis_mesh_shadingclk_dis_radial_shad";
            desc = "The input clock of the mesh shading module is disabled when this bit is set to 1.";
            sw = rw;
            hw = r;
            reset = 0x0;
        } clk_dis_mesh_shadingclk_dis_radial_shad[5:5];

        field {
            name = "ingclk_dis_radial_shading";
            desc = "The input clock of the radial shading module is disabled when this bit is set to 1.";
            sw = rw;
            hw = r;
            reset = 0x0;
        } ingclk_dis_radial_shading[4:4];

        field {
            name = "clk_dis_drc";
            desc = "The input clock of the DRC module is disabled when this bit is set to 1.";
            sw = rw;
            hw = r;
            reset = 0x0;
        } clk_dis_drc[3:3];

        field {
            name = "clk_dis_hist_1024binclk_dis_hist_pe_3c";
            desc = "The input clock of the 1024-segment histogram statistics module is disabled when this bit is set to 1.";
            sw = rw;
            hw = r;
            reset = 0x0;
        } clk_dis_hist_1024binclk_dis_hist_pe_3c[2:2];

        field {
            name = "inclk_dis_hist_pe_3chclk_dis_frontend_3";
            desc = "The input clock of the 256-segment histogram statistics module in channels 2-4 is disabled when this bit is set to 1.";
            sw = rw;
            hw = r;
            reset = 0x0;
        } inclk_dis_hist_pe_3chclk_dis_frontend_3[1:1];

        field {
            name = "hclk_dis_frontend_3ch";
            desc = "The input clock of the raw front end module in channels 2-4 is disabled when this bit is set to 1.";
            sw = rw;
            hw = r;
            reset = 0x0;
        } hclk_dis_frontend_3ch[0:0];
    } ISPFE_CLK_DIS @ 0x10034;

    reg {
        name = "Module clock gating enable register";
        desc = "ISPFE_CG_DIS is a module clock gating enable register. Hi3516A V200 Professional HD IP Camera SoC

Data sheet 10.6 ISPFE_CG_DIS (offset 0x20038, printed page 10-89, `hi3516av200--Hi3516AV200-Datasheet.txt` line 70140).";

        field {
            name = "clk_dis_awb";
            desc = "The clock gating of the AWB statistics module is disabled when this bit is set to 1.";
            sw = rw;
            hw = r;
            reset = 0x0;
        } clk_dis_awb[6:6];

        field {
            name = "cg_dis_mesh_shadingcg_dis_radial_shadi";
            desc = "The clock gating of the mesh shading module is disabled when this bit is set to 1.";
            sw = rw;
            hw = r;
            reset = 0x0;
        } cg_dis_mesh_shadingcg_dis_radial_shadi[5:5];

        field {
            name = "ngcg_dis_radial_shading";
            desc = "The clock gating of the radial shading module is disabled when this bit is set to 1.";
            sw = rw;
            hw = r;
            reset = 0x0;
        } ngcg_dis_radial_shading[4:4];

        field {
            name = "cg_dis_drc";
            desc = "The clock gating of the DRC module is disabled when this bit is set to 1.";
            sw = rw;
            hw = r;
            reset = 0x0;
        } cg_dis_drc[3:3];

        field {
            name = "cg_dis_hist_1024bin";
            desc = "The clock gating of the 1024-segment histogram statistics module is disabled when this bit is set to 1.";
            sw = rw;
            hw = r;
            reset = 0x0;
        } cg_dis_hist_1024bin[2:2];

        field {
            name = "cg_dis_hist_pe_3ch";
            desc = "The clock gating of the 256-segment histogram statistics module in channels 2-4 is disabled when this bit is set to 1.";
            sw = rw;
            hw = r;
            reset = 0x0;
        } cg_dis_hist_pe_3ch[1:1];

        field {
            name = "cg_dis_frontend_3ch";
            desc = "The clock gating of the raw front end module in channels 2-4 is disabled when this bit is set to 1.";
            sw = rw;
            hw = r;
            reset = 0x0;
        } cg_dis_frontend_3ch[0:0];
    } ISPFE_CG_DIS @ 0x10038;

    reg {
        name = "ISP FE module bypass register";
        desc = "ISPFE_MODULE_BYPASS is an ISP FE module bypass register. Hi3516A V200 Professional HD IP Camera SoC

Data sheet 10.6 ISPFE_MODULE_BYPASS (offset 0x20040, printed page 10-90, `hi3516av200--Hi3516AV200-Datasheet.txt` line 70196).";

        field {
            name = "bypass_wdr_gainbypass_sensor_offs";
            desc = "The module wdr gain is bypassed when this bit is set to 1.";
            sw = rw;
            hw = r;
            reset = 0x0;
        } bypass_wdr_gainbypass_sensor_offs[29:29];

        field {
            name = "bypass_sensor_offset_wdrbypass_sensor_offs";
            desc = "The sensor offset before the module raw front end is bypassed when this bit is set to 1.";
            sw = rw;
            hw = r;
            reset = 0x0;
        } bypass_sensor_offset_wdrbypass_sensor_offs[28:28];

        field {
            name = "et_wdrbypass_sensor_offset";
            desc = "The sensor offset before the module front-end lookup is bypassed when this bit is set to 1.";
            sw = rw;
            hw = r;
            reset = 0x0;
        } et_wdrbypass_sensor_offset[27:27];

        field {
            name = "bypass_gamma_rgb";
            desc = "The module RGB gamma LUT is bypassed when this bit is set to 1.";
            sw = rw;
            hw = r;
            reset = 0x0;
        } bypass_gamma_rgb[21:21];

        field {
            name = "bypass_color_matrix";
            desc = "The module color matrix is bypassed when this bit is set to 1.";
            sw = rw;
            hw = r;
            reset = 0x0;
        } bypass_color_matrix[20:20];

        field {
            name = "bypass_demosaic";
            desc = "The module demosaic (outputting the raw data) is bypassed when this bit is set to 1.";
            sw = rw;
            hw = r;
            reset = 0x0;
        } bypass_demosaic[19:19];

        field {
            name = "bypass_drc";
            desc = "The module DRC is bypassed when this bit is set to 1.";
            sw = rw;
            hw = r;
            reset = 0x0;
        } bypass_drc[18:18];

        field {
            name = "bypass_mesh_shadingbypass_radial_shad";
            desc = "The module mesh shading is bypassed when this bit is set to 1.";
            sw = rw;
            hw = r;
            reset = 0x0;
        } bypass_mesh_shadingbypass_radial_shad[17:17];

        field {
            name = "ngbypass_radial_shadingbypass_white_bala";
            desc = "The module radial shading is bypassed when this bit is set to 1.";
            sw = rw;
            hw = r;
            reset = 0x0;
        } ngbypass_radial_shadingbypass_white_bala[16:16];

        field {
            name = "ingbypass_white_balancebypass_gamma_be";
            desc = "The module static white balance is bypassed when this bit is set to 1.";
            sw = rw;
            hw = r;
            reset = 0x0;
        } ingbypass_white_balancebypass_gamma_be[15:15];

        field {
            name = "ncebypass_gamma_be_dl";
            desc = "The module back-end gamma block is bypassed when this bit is set to 1.";
            sw = rw;
            hw = r;
            reset = 0x1;
        } ncebypass_gamma_be_dl[14:14];

        field {
            name = "bypass_gamma_be";
            desc = "The module back-end gamma LUTs are bypassed when this bit is set to 1.";
            sw = rw;
            hw = r;
            reset = 0x0;
        } bypass_gamma_be[13:13];

        field {
            name = "bypass_dnr";
            desc = "The module DNR is bypassed when this bit is set to 1.";
            sw = rw;
            hw = r;
            reset = 0x0;
        } bypass_dnr[12:12];

        field {
            name = "bypass_fs_channel_switch";
            desc = "The module frame stitch channel switch is bypassed when this bit is set to 1.";
            sw = rw;
            hw = r;
            reset = 0x1;
        } bypass_fs_channel_switch[11:11];

        field {
            name = "bypass_digital_gainThe";
            desc = "bypass_digital_gainThe";
            sw = rw;
            hw = r;
            reset = 0x0;
        } bypass_digital_gainThe[10:10];

        field {
            name = "bypass_gamma_fe_dl";
            desc = "The module front-end gamma block is bypassed when this bit is set to 1.";
            sw = rw;
            hw = r;
            reset = 0x1;
        } bypass_gamma_fe_dl[9:9];

        field {
            name = "bypass_gamma_fe";
            desc = "The module front-end gamma LUTs are bypassed when this bit is set to 1.";
            sw = rw;
            hw = r;
            reset = 0x0;
        } bypass_gamma_fe[8:8];

        field {
            name = "bypass_frame_stitchbypass_defect_pixe";
            desc = "The module frame stitching logic is bypassed when this bit is set to 1.";
            sw = rw;
            hw = r;
            reset = 0x0;
        } bypass_frame_stitchbypass_defect_pixe[7:7];

        field {
            name = "hbypass_defect_pixelbypass_raw_fronte";
            desc = "The module static defect pixels are bypassed when this bit is set to 1.";
            sw = rw;
            hw = r;
            reset = 0x0;
        } hbypass_defect_pixelbypass_raw_fronte[6:6];

        field {
            name = "lbypass_raw_frontendbypass_video_test_";
            desc = "The module raw front end (green equalization and dynamic defect pixel) is bypassed when this bit is set to 1.";
            sw = rw;
            hw = r;
            reset = 0x0;
        } lbypass_raw_frontendbypass_video_test[5:5];

        field {
            name = "ndbypass_video_test_genbypass_channel_sw";
            desc = "The module video test generator is bypassed when this bit is set to 1.";
            sw = rw;
            hw = r;
            reset = 0x0;
        } ndbypass_video_test_genbypass_channel_sw[4:4];

        field {
            name = "genbypass_channel_switchbypass_input_form";
            desc = "The module channel switch is bypassed when this bit is set to 1.";
            sw = rw;
            hw = r;
            reset = 0x0;
        } genbypass_channel_switchbypass_input_form[3:3];

        field {
            name = "itchbypass_input_formatter";
            desc = "The module input formatter is bypassed when this bit is set to 1.";
            sw = rw;
            hw = r;
            reset = 0x0;
        } itchbypass_input_formatter[2:2];

        enum ISPFE_MODULE_BYPASS_position_digital_gain_enum {
            AFTER_MODULE_FE = 0 { name = "After Module Fe"; desc = "after the module FE gamma LUTs"; };
            BEFORE_MODULE_FE = 1 { name = "Before Module Fe"; desc = "before the module FE gamma LUTs"; };
        };

        field {
            name = "position_digital_gain";
            desc = "Digital gain position select";
            sw = rw;
            hw = r;
            encode = ISPFE_MODULE_BYPASS_position_digital_gain_enum;
            reset = 0x0;
        } position_digital_gain[1:1];

        enum ISPFE_MODULE_BYPASS_position_gamma_fe_enum {
            AFTER_WDR_STITCHING = 0 { name = "After Wdr Stitching"; desc = "after the WDR stitching module"; };
            FRONT_PART_ISP = 1 { name = "Front Part Isp"; desc = "in the front part of ISP_FE"; };
        };

        field {
            name = "position_gamma_fe";
            desc = "Module gamma FE/digital gain position select";
            sw = rw;
            hw = r;
            encode = ISPFE_MODULE_BYPASS_position_gamma_fe_enum;
            reset = 0x0;
        } position_gamma_fe[0:0];
    } ISPFE_MODULE_BYPASS @ 0x10040;

    reg {
        name = "ISP FE bypass mode selection register";
        desc = "ISPFE_BYPASS_MODE is an ISP FE bypass mode selection register. Hi3516A V200 Professional HD IP Camera SoC

Data sheet 10.6 ISPFE_BYPASS_MODE (offset 0x20044, printed page 10-92, `hi3516av200--Hi3516AV200-Datasheet.txt` line 70311).";

        enum ISPFE_BYPASS_MODE_isp_raw_bypass_enum {
            NORMAL_MODE = 0 { name = "Normal Mode"; desc = "normal mode"; };
            ISP_RAW_PROCESSING = 1 { name = "Isp Raw Processing"; desc = "The ISP raw processing module is bypassed."; };
        };

        field {
            name = "isp_raw_bypass";
            desc = "Switching between the normal mode and RGB/YUV422 input mode. In RGB/YUV422 input mode, data is directly inserted after the demosaic module, and the module cropping, scaling, gamma, as well as CSC are valid only for RGB inputs.";
            sw = rw;
            hw = r;
            encode = ISPFE_BYPASS_MODE_isp_raw_bypass_enum;
            reset = 0x0;
        } isp_raw_bypass[9:9];
    } ISPFE_BYPASS_MODE @ 0x10044;

    reg {
        name = "AE statistics position control register";
        desc = "ISPFE_AE_SWITCH is an AE statistics position control register.

Data sheet 10.6 ISPFE_AE_SWITCH (offset 0x20048, printed page 10-92, `hi3516av200--Hi3516AV200-Datasheet.txt` line 70343).";

        enum ISPFE_AE_SWITCH_ae_sum_switch_enum {
            AFTER_STATIC_WHITE = 0 { name = "After Static White"; desc = "after the static white balance module"; };
            AFTER_VIDEO_TEST = 1 { name = "After Video Test"; desc = "after the video test gen (channel 1) module"; };
            AFTER_SHADING_MODULE = 2 { name = "After Shading Module"; desc = "after the shading module"; };
            AFTER_WDR_FRAME = 3 { name = "After Wdr Frame"; desc = "after the WDR frame stitch module"; };
        };

        field {
            name = "ae_sum_switch";
            desc = "AE sum statistics position select";
            sw = rw;
            hw = r;
            encode = ISPFE_AE_SWITCH_ae_sum_switch_enum;
            reset = 0x0;
        } ae_sum_switch[17:16];

        enum ISPFE_AE_SWITCH_ae_switch_enum {
            AFTER_STATIC_WHITE = 0 { name = "After Static White"; desc = "after the static white balance module"; };
            AFTER_VIDEO_TEST = 1 { name = "After Video Test"; desc = "after the video test gen (channel 1) module"; };
            AFTER_SHADING_MODULE = 2 { name = "After Shading Module"; desc = "after the shading module"; };
            AFTER_WDR_FRAME = 3 { name = "After Wdr Frame"; desc = "after the WDR frame stitch module"; };
        };

        field {
            name = "ae_switch";
            desc = "AE statistics position select";
            sw = rw;
            hw = r;
            encode = ISPFE_AE_SWITCH_ae_switch_enum;
            reset = 0x0;
        } ae_switch[1:0];
    } ISPFE_AE_SWITCH @ 0x10048;

    reg {
        name = "RGB field AWB statistics module position control register";
        desc = "ISPFE_AWB_SWITCH is an RGB field AWB statistics module position control register.

Data sheet 10.6 ISPFE_AWB_SWITCH (offset 0x2004C, printed page 10-93, `hi3516av200--Hi3516AV200-Datasheet.txt` line 70390).";

        enum ISPFE_AWB_SWITCH_awbsum_switch_enum {
            BEFORE_STATIC_WHITE = 0 { name = "Before Static White"; desc = "before the static white balance module"; };
            BEFORE_LENS_SHADING = 1 { name = "Before Lens Shading"; desc = "before the lens shading module"; };
        };

        field {
            name = "awbsum_switch";
            desc = "AWB sum statistics module pipeline position adjustment register";
            sw = rw;
            hw = r;
            encode = ISPFE_AWB_SWITCH_awbsum_switch_enum;
            reset = 0x0;
        } awbsum_switch[8:8];
    } ISPFE_AWB_SWITCH @ 0x1004C;

    reg {
        name = "AE global histogram position control register";
        desc = "ISPFE_HISTOGRAM_SWITCH is an AE global histogram position control register. Hi3516A V200 Professional HD IP Camera SoC

Data sheet 10.6 ISPFE_HISTOGRAM_SWITCH (offset 0x20050, printed page 10-94, `hi3516av200--Hi3516AV200-Datasheet.txt` line 70429).";

        enum ISPFE_HISTOGRAM_SWITCH_histogram_switch_enum {
            SAME_POSITION_AS = 0 { name = "Same Position As"; desc = "in the same position as the AE module"; };
            AFTER_VIDEO_TEST = 1 { name = "After Video Test"; desc = "after the video test gen (channel 1) module"; };
            AFTER_SHADING_MODULE = 2 { name = "After Shading Module"; desc = "after the shading module"; };
            AFTER_WDR_FRAME = 3 { name = "After Wdr Frame"; desc = "after the WDR frame stitch module"; };
        };

        field {
            name = "histogram_switch";
            desc = "AE global histogram position select";
            sw = rw;
            hw = r;
            encode = ISPFE_HISTOGRAM_SWITCH_histogram_switch_enum;
            reset = 0x0;
        } histogram_switch[1:0];
    } ISPFE_HISTOGRAM_SWITCH @ 0x10050;

    reg {
        name = "Per exposure AE global histogram control register";
        desc = "ISPFE_HISTOGRAM_PE_SWITCH is a per exposure AE global histogram control register.

Data sheet 10.6 ISPFE_HISTOGRAM_PE_SWITCH (offset 0x20058, printed page 10-94, `hi3516av200--Hi3516AV200-Datasheet.txt` line 70459).";

        enum ISPFE_HISTOGRAM_PE_SWITCH_histogram_pe4_switch_enum {
            ENABLED = 0 { name = "Enabled"; desc = "enabled"; };
            DISABLED = 1 { name = "Disabled"; desc = "disabled"; };
        };

        field {
            name = "histogram_pe4_switch";
            desc = "Channel 4 AE global histogram enable";
            sw = rw;
            hw = r;
            encode = ISPFE_HISTOGRAM_PE_SWITCH_histogram_pe4_switch_enum;
            reset = 0x0;
        } histogram_pe4_switch[3:3];

        enum ISPFE_HISTOGRAM_PE_SWITCH_histogram_pe3_switch_enum {
            ENABLED = 0 { name = "Enabled"; desc = "enabled"; };
            DISABLED = 1 { name = "Disabled"; desc = "disabled"; };
        };

        field {
            name = "histogram_pe3_switch";
            desc = "Channel 3 AE global histogram enable";
            sw = rw;
            hw = r;
            encode = ISPFE_HISTOGRAM_PE_SWITCH_histogram_pe3_switch_enum;
            reset = 0x0;
        } histogram_pe3_switch[2:2];

        enum ISPFE_HISTOGRAM_PE_SWITCH_histogram_pe2_switch_enum {
            ENABLED = 0 { name = "Enabled"; desc = "enabled"; };
            DISABLED = 1 { name = "Disabled"; desc = "disabled"; };
        };

        field {
            name = "histogram_pe2_switch";
            desc = "Channel 2 AE global histogram enable";
            sw = rw;
            hw = r;
            encode = ISPFE_HISTOGRAM_PE_SWITCH_histogram_pe2_switch_enum;
            reset = 0x0;
        } histogram_pe2_switch[1:1];

        enum ISPFE_HISTOGRAM_PE_SWITCH_histogram_pe1_switch_enum {
            ENABLED = 0 { name = "Enabled"; desc = "enabled"; };
            DISABLED = 1 { name = "Disabled"; desc = "disabled"; };
        };

        field {
            name = "histogram_pe1_switch";
            desc = "Channel 1 AE global histogram enable";
            sw = rw;
            hw = r;
            encode = ISPFE_HISTOGRAM_PE_SWITCH_histogram_pe1_switch_enum;
            reset = 0x0;
        } histogram_pe1_switch[0:0];
    } ISPFE_HISTOGRAM_PE_SWITCH @ 0x10058;

    reg {
        name = "State machine reset register";
        desc = "ISPFE_GLOBAL_FSM_RESET is a state machine reset register.

Data sheet 10.6 ISPFE_GLOBAL_FSM_RESET (offset 0x20078, printed page 10-95, `hi3516av200--Hi3516AV200-Datasheet.txt` line 70515).";

        field {
            name = "global_fsm_reset";
            desc = "FSM synchronous reset signal";
            sw = rw;
            hw = r;
            reset = 0x0;
        } global_fsm_reset[0:0];
    } ISPFE_GLOBAL_FSM_RESET @ 0x10078;

    reg {
        name = "Field signal status register";
        desc = "ISPFE_FIELD_STATUS is a field signal status register. Hi3516A V200 Professional HD IP Camera SoC

Data sheet 10.6 ISPFE_FIELD_STATUS (offset 0x2007C, printed page 10-96, `hi3516av200--Hi3516AV200-Datasheet.txt` line 70550).";

        field {
            name = "field_status";
            desc = "Field signal status";
            sw = r;
            hw = w;
            reset = 0x0;
        } field_status[0:0];
    } ISPFE_FIELD_STATUS @ 0x1007C;

    reg {
        name = "Interrupt source 0/1 selection register";
        desc = "ISPFE_INTERRUPT01 is an interrupt source 0/1 selection register.

Data sheet 10.6 ISPFE_INTERRUPT01 (offset 0x20080, printed page 10-96, `hi3516av200--Hi3516AV200-Datasheet.txt` line 70576).";

        field {
            name = "interrupt1_source";
            desc = "Interrupt source 1 select";
            sw = rw;
            hw = r;
            reset = 0x0;
        } interrupt1_source[21:16];

        field {
            name = "interrupt0_source";
            desc = "Interrupt source 0 select";
            sw = rw;
            hw = r;
            reset = 0x0;
        } interrupt0_source[5:0];
    } ISPFE_INTERRUPT01 @ 0x10080;

    reg {
        name = "Interrupt source 2/3 selection register";
        desc = "ISPFE_INTERRUPT23 is an interrupt source 2/3 selection register. Hi3516A V200 Professional HD IP Camera SoC

Data sheet 10.6 ISPFE_INTERRUPT23 (offset 0x20084, printed page 10-97, `hi3516av200--Hi3516AV200-Datasheet.txt` line 70606).";

        field {
            name = "interrupt3_source";
            desc = "Interrupt source 3 select";
            sw = rw;
            hw = r;
            reset = 0x0;
        } interrupt3_source[21:16];

        field {
            name = "interrupt2_source";
            desc = "Interrupt source 2 select";
            sw = rw;
            hw = r;
            reset = 0x0;
        } interrupt2_source[5:0];
    } ISPFE_INTERRUPT23 @ 0x10084;

    reg {
        name = "Interrupt source 4/5 selection register";
        desc = "ISPFE_INTERRUPT45 is an interrupt source 4/5 selection register.

Data sheet 10.6 ISPFE_INTERRUPT45 (offset 0x20088, printed page 10-97, `hi3516av200--Hi3516AV200-Datasheet.txt` line 70628).";

        field {
            name = "interrupt5_source";
            desc = "Interrupt source 5 select";
            sw = rw;
            hw = r;
            reset = 0x0;
        } interrupt5_source[21:16];

        field {
            name = "interrupt4_source";
            desc = "Interrupt source 4 select";
            sw = rw;
            hw = r;
            reset = 0x0;
        } interrupt4_source[5:0];
    } ISPFE_INTERRUPT45 @ 0x10088;

    reg {
        name = "Interrupt source 6/7 selection register";
        desc = "ISPFE_INTERRUPT67 is an interrupt source 6/7 selection register. Hi3516A V200 Professional HD IP Camera SoC

Data sheet 10.6 ISPFE_INTERRUPT67 (offset 0x2008C, printed page 10-98, `hi3516av200--Hi3516AV200-Datasheet.txt` line 70659).";

        field {
            name = "interrupt7_source";
            desc = "Interrupt source 7 select";
            sw = rw;
            hw = r;
            reset = 0x0;
        } interrupt7_source[21:16];

        field {
            name = "interrupt6_source";
            desc = "Interrupt source 6 select";
            sw = rw;
            hw = r;
            reset = 0x0;
        } interrupt6_source[5:0];
    } ISPFE_INTERRUPT67 @ 0x1008C;

    reg {
        name = "Interrupt source 8/9 selection register";
        desc = "ISPFE_INTERRUPT89 is an interrupt source 8/9 selection register.

Data sheet 10.6 ISPFE_INTERRUPT89 (offset 0x20090, printed page 10-98, `hi3516av200--Hi3516AV200-Datasheet.txt` line 70681).";

        field {
            name = "interrupt9_source";
            desc = "Interrupt source 9 select";
            sw = rw;
            hw = r;
            reset = 0x0;
        } interrupt9_source[21:16];

        field {
            name = "interrupt8_source";
            desc = "Interrupt source 8 select";
            sw = rw;
            hw = r;
            reset = 0x0;
        } interrupt8_source[5:0];
    } ISPFE_INTERRUPT89 @ 0x10090;

    reg {
        name = "Interrupt source 10/11 selection register";
        desc = "ISPFE_INTERRUPT1011 is an interrupt source 10/11 selection register. Hi3516A V200 Professional HD IP Camera SoC

Data sheet 10.6 ISPFE_INTERRUPT1011 (offset 0x20094, printed page 10-99, `hi3516av200--Hi3516AV200-Datasheet.txt` line 70712).";

        field {
            name = "interrupt11_source";
            desc = "Interrupt source 11 select";
            sw = rw;
            hw = r;
            reset = 0x0;
        } interrupt11_source[21:16];

        field {
            name = "interrupt10_source";
            desc = "Interrupt source 10 select";
            sw = rw;
            hw = r;
            reset = 0x0;
        } interrupt10_source[5:0];
    } ISPFE_INTERRUPT1011 @ 0x10094;

    reg {
        name = "Interrupt source 12/13 selection register";
        desc = "ISPFE_INTERRUPT1213 is an interrupt source 12/13 selection register.

Data sheet 10.6 ISPFE_INTERRUPT1213 (offset 0x20098, printed page 10-99, `hi3516av200--Hi3516AV200-Datasheet.txt` line 70734).";

        field {
            name = "interrupt13_source";
            desc = "Interrupt source 13 select";
            sw = rw;
            hw = r;
            reset = 0x0;
        } interrupt13_source[21:16];

        field {
            name = "interrupt12_source";
            desc = "Interrupt source 12 select";
            sw = rw;
            hw = r;
            reset = 0x0;
        } interrupt12_source[5:0];
    } ISPFE_INTERRUPT1213 @ 0x10098;

    reg {
        name = "Interrupt source 14/15 selection register";
        desc = "ISPFE_INTERRUPT1415 is an interrupt source 14/15 selection register. Hi3516A V200 Professional HD IP Camera SoC

Data sheet 10.6 ISPFE_INTERRUPT1415 (offset 0x2009C, printed page 10-100, `hi3516av200--Hi3516AV200-Datasheet.txt` line 70765).";

        field {
            name = "interrupt15_source";
            desc = "Interrupt source 15 select";
            sw = rw;
            hw = r;
            reset = 0x0;
        } interrupt15_source[21:16];

        field {
            name = "interrupt14_source";
            desc = "Interrupt source 14 select";
            sw = rw;
            hw = r;
            reset = 0x0;
        } interrupt14_source[5:0];
    } ISPFE_INTERRUPT1415 @ 0x1009C;

    reg {
        name = "Interrupt status register";
        desc = "ISPFE_INTERRUPT_STATUS is an interrupt status register.

Data sheet 10.6 ISPFE_INTERRUPT_STATUS (offset 0x200A0, printed page 10-100, `hi3516av200--Hi3516AV200-Datasheet.txt` line 70787).";

        field {
            name = "interrupt_status";
            desc = "Interrupt event flag";
            sw = r;
            hw = w;
            reset = 0x0;
        } interrupt_status[15:0];
    } ISPFE_INTERRUPT_STATUS @ 0x100A0;

    reg {
        name = "Interrupt clear register";
        desc = "ISPFE_INTERRUPT_CLEAR is an interrupt clear register.

Data sheet 10.6 ISPFE_INTERRUPT_CLEAR (offset 0x200A4, printed page 10-100, `hi3516av200--Hi3516AV200-Datasheet.txt` line 70807).";

        field {
            name = "interrupt_clear";
            desc = "Interrupt event clear. Writing 0 and 1 in sequence to a bit clears the interrupt corresponding to this bit.";
            sw = rw;
            hw = r;
            reset = 0x0;
        } interrupt_clear[15:0];
    } ISPFE_INTERRUPT_CLEAR @ 0x100A4;

    reg {
        name = "WDR channel 1/2 gain configuration register";
        desc = "WDR_GAIN_COEF1 is a WDR channel 1/2 gain configuration register.

Data sheet 10.6 WDR_GAIN_COEF1 (offset 0x200B0, printed page 10-101, `hi3516av200--Hi3516AV200-Datasheet.txt` line 70838).";

        field {
            name = "gain_wdr2";
            desc = "Channel 2 gain in 5.8 format";
            sw = rw;
            hw = r;
            reset = 0x100;
        } gain_wdr2[28:16];

        field {
            name = "gain_wdr1";
            desc = "Channel 1 gain in 5.8 format";
            sw = rw;
            hw = r;
            reset = 0x100;
        } gain_wdr1[12:0];
    } WDR_GAIN_COEF1 @ 0x100B0;

    reg {
        name = "WDR channel 3/4 gain configuration register";
        desc = "WDR_GAIN_COEF2 is a WDR channel 3/4 gain configuration register.

Data sheet 10.6 WDR_GAIN_COEF2 (offset 0x200B4, printed page 10-101, `hi3516av200--Hi3516AV200-Datasheet.txt` line 70863).";

        field {
            name = "gain_wdr4";
            desc = "Channel 4 gain in 5.8 format";
            sw = rw;
            hw = r;
            reset = 0x100;
        } gain_wdr4[28:16];

        field {
            name = "gain_wdr3";
            desc = "Channel 3 gain in 5.8 format";
            sw = rw;
            hw = r;
            reset = 0x100;
        } gain_wdr3[12:0];
    } WDR_GAIN_COEF2 @ 0x100B4;

    reg {
        name = "WDR gain channel 1/2 offset configuration register";
        desc = "WDR_GAIN_COEF3 is a WDR gain channel 1/2 offset configuration register.

Data sheet 10.6 WDR_GAIN_COEF3 (offset 0x200B8, printed page 10-102, `hi3516av200--Hi3516AV200-Datasheet.txt` line 70896).";

        field {
            name = "offset_wdr2";
            desc = "Channel 2 offset";
            sw = rw;
            hw = r;
            reset = 0x0;
        } offset_wdr2[29:16];

        field {
            name = "offset_wdr1";
            desc = "Channel 1 offset";
            sw = rw;
            hw = r;
            reset = 0x0;
        } offset_wdr1[13:0];
    } WDR_GAIN_COEF3 @ 0x100B8;

    reg {
        name = "WDR gain channel 3/4 offset configuration register";
        desc = "WDR_GAIN_COEF4 is a WDR gain channel 3/4 offset configuration register.

Data sheet 10.6 WDR_GAIN_COEF4 (offset 0x200BC, printed page 10-102, `hi3516av200--Hi3516AV200-Datasheet.txt` line 70921).";

        field {
            name = "offset_wdr4";
            desc = "Channel 4 offset";
            sw = rw;
            hw = r;
            reset = 0x0;
        } offset_wdr4[29:16];

        field {
            name = "offset_wdr3";
            desc = "Channel 3 offset";
            sw = rw;
            hw = r;
            reset = 0x0;
        } offset_wdr3[13:0];
    } WDR_GAIN_COEF4 @ 0x100BC;

    reg {
        name = "WDR_1 BLC R component black level register";
        desc = "SENSOR_OFFSET_WDR_1_BLACK00 is a WDR_1 BLC R component black level register.

Data sheet 10.6 SENSOR_OFFSET_WDR_1_BLACK00 (offset 0x200C0, printed page 10-103, `hi3516av200--Hi3516AV200-Datasheet.txt` line 70953).";

        field {
            name = "black00";
            desc = "Black level offset of color channel 00 (R)";
            sw = rw;
            hw = r;
            reset = 0x0;
        } black00[11:0];
    } SENSOR_OFFSET_WDR_1_BLACK00 @ 0x100C0;

    reg {
        name = "WDR_1 BLC Gr component black level register";
        desc = "SENSOR_OFFSET_WDR_1_BLACK01 is a WDR_1 BLC Gr component black level register.

Data sheet 10.6 SENSOR_OFFSET_WDR_1_BLACK01 (offset 0x200C4, printed page 10-103, `hi3516av200--Hi3516AV200-Datasheet.txt` line 70974).";

        field {
            name = "black01";
            desc = "Black level offset of color channel 01 (Gr)";
            sw = rw;
            hw = r;
            reset = 0x0;
        } black01[11:0];
    } SENSOR_OFFSET_WDR_1_BLACK01 @ 0x100C4;

    reg {
        name = "WDR_1 BLC Gb component black level register";
        desc = "SENSOR_OFFSET_WDR_1_BLACK10 is a WDR_1 BLC Gb component black level register. Hi3516A V200 Professional HD IP Camera SoC

Data sheet 10.6 SENSOR_OFFSET_WDR_1_BLACK10 (offset 0x200C8, printed page 10-104, `hi3516av200--Hi3516AV200-Datasheet.txt` line 71004).";

        field {
            name = "black10";
            desc = "Black level offset of color channel 10 (Gb)";
            sw = rw;
            hw = r;
            reset = 0x0;
        } black10[11:0];
    } SENSOR_OFFSET_WDR_1_BLACK10 @ 0x100C8;

    reg {
        name = "WDR_1 BLC B component black level register";
        desc = "SENSOR_OFFSET_WDR_1_BLACK11 is a WDR_1 BLC B component black level register.

Data sheet 10.6 SENSOR_OFFSET_WDR_1_BLACK11 (offset 0x200CC, printed page 10-104, `hi3516av200--Hi3516AV200-Datasheet.txt` line 71024).";

        field {
            name = "black11";
            desc = "Black level offset of color channel 11 (B)";
            sw = rw;
            hw = r;
            reset = 0x0;
        } black11[11:0];
    } SENSOR_OFFSET_WDR_1_BLACK11 @ 0x100CC;

    reg {
        name = "WDR_2 BLC R component black level register";
        desc = "SENSOR_OFFSET_WDR_2_BLACK00 is a WDR_2 BLC R component black level register.

Data sheet 10.6 SENSOR_OFFSET_WDR_2_BLACK00 (offset 0x200D0, printed page 10-104, `hi3516av200--Hi3516AV200-Datasheet.txt` line 71043).";

        field {
            name = "black00";
            desc = "Black level offset of color channel 00 (R)";
            sw = rw;
            hw = r;
            reset = 0x0;
        } black00[11:0];
    } SENSOR_OFFSET_WDR_2_BLACK00 @ 0x100D0;

    reg {
        name = "WDR_2 BLC Gr component black level register";
        desc = "SENSOR_OFFSET_WDR_2_BLACK01 is a WDR_2 BLC Gr component black level register.

Data sheet 10.6 SENSOR_OFFSET_WDR_2_BLACK01 (offset 0x200D4, printed page 10-105, `hi3516av200--Hi3516AV200-Datasheet.txt` line 71070).";

        field {
            name = "black01";
            desc = "Black level offset of color channel 01 (Gr)";
            sw = rw;
            hw = r;
            reset = 0x0;
        } black01[11:0];
    } SENSOR_OFFSET_WDR_2_BLACK01 @ 0x100D4;

    reg {
        name = "WDR_2 BLC Gb component black level register";
        desc = "SENSOR_OFFSET_WDR_2_BLACK10 is a WDR_2 BLC Gb component black level register.

Data sheet 10.6 SENSOR_OFFSET_WDR_2_BLACK10 (offset 0x200D8, printed page 10-105, `hi3516av200--Hi3516AV200-Datasheet.txt` line 71090).";

        field {
            name = "black10";
            desc = "Black level offset of color channel 10 (Gb)";
            sw = rw;
            hw = r;
            reset = 0x0;
        } black10[11:0];
    } SENSOR_OFFSET_WDR_2_BLACK10 @ 0x100D8;

    reg {
        name = "WDR_2 BLC B component black level register";
        desc = "SENSOR_OFFSET_WDR_2_BLACK11 is a WDR_2 BLC B component black level register. Hi3516A V200 Professional HD IP Camera SoC

Data sheet 10.6 SENSOR_OFFSET_WDR_2_BLACK11 (offset 0x200DC, printed page 10-106, `hi3516av200--Hi3516AV200-Datasheet.txt` line 71119).";

        field {
            name = "black11";
            desc = "Black level offset of color channel 11 (B)";
            sw = rw;
            hw = r;
            reset = 0x0;
        } black11[11:0];
    } SENSOR_OFFSET_WDR_2_BLACK11 @ 0x100DC;

    reg {
        name = "WDR_3 BLC R component black level register";
        desc = "SENSOR_OFFSET_WDR_3_BLACK00 is a WDR_3 BLC R component black level register.

Data sheet 10.6 SENSOR_OFFSET_WDR_3_BLACK00 (offset 0x200E0, printed page 10-106, `hi3516av200--Hi3516AV200-Datasheet.txt` line 71139).";

        field {
            name = "black00";
            desc = "Black level offset of color channel 00 (R)";
            sw = rw;
            hw = r;
            reset = 0x0;
        } black00[11:0];
    } SENSOR_OFFSET_WDR_3_BLACK00 @ 0x100E0;

    reg {
        name = "WDR_3 BLC Gr component black level register";
        desc = "SENSOR_OFFSET_WDR_3_BLACK01 is a WDR_3 BLC Gr component black level register.

Data sheet 10.6 SENSOR_OFFSET_WDR_3_BLACK01 (offset 0x200E4, printed page 10-106, `hi3516av200--Hi3516AV200-Datasheet.txt` line 71159).";

        field {
            name = "black01";
            desc = "Black level offset of color channel 01 (Gr)";
            sw = rw;
            hw = r;
            reset = 0x0;
        } black01[11:0];
    } SENSOR_OFFSET_WDR_3_BLACK01 @ 0x100E4;

    reg {
        name = "WDR_3 BLC Gb component black level register";
        desc = "SENSOR_OFFSET_WDR_3_BLACK10 is a WDR_3 BLC Gb component black level register.

Data sheet 10.6 SENSOR_OFFSET_WDR_3_BLACK10 (offset 0x200E8, printed page 10-107, `hi3516av200--Hi3516AV200-Datasheet.txt` line 71186).";

        field {
            name = "black10";
            desc = "Black level offset of color channel 10 (Gb)";
            sw = rw;
            hw = r;
            reset = 0x0;
        } black10[11:0];
    } SENSOR_OFFSET_WDR_3_BLACK10 @ 0x100E8;

    reg {
        name = "WDR_3 BLC B component black level register";
        desc = "SENSOR_OFFSET_WDR_3_BLACK11 is a WDR_3 BLC B component black level register.

Data sheet 10.6 SENSOR_OFFSET_WDR_3_BLACK11 (offset 0x200EC, printed page 10-107, `hi3516av200--Hi3516AV200-Datasheet.txt` line 71205).";

        field {
            name = "black11";
            desc = "Black level offset of color channel 11 (B)";
            sw = rw;
            hw = r;
            reset = 0x0;
        } black11[11:0];
    } SENSOR_OFFSET_WDR_3_BLACK11 @ 0x100EC;

    reg {
        name = "WDR_4 BLC R component black level register";
        desc = "SENSOR_OFFSET_WDR_4_BLACK00 is a WDR_4 BLC R component black level register.

Data sheet 10.6 SENSOR_OFFSET_WDR_4_BLACK00 (offset 0x200F0, printed page 10-107, `hi3516av200--Hi3516AV200-Datasheet.txt` line 71225).";

        field {
            name = "black00";
            desc = "Black level offset of color channel 00 (R)";
            sw = rw;
            hw = r;
            reset = 0x0;
        } black00[11:0];
    } SENSOR_OFFSET_WDR_4_BLACK00 @ 0x100F0;

    reg {
        name = "WDR_4 BLC Gr component black level register";
        desc = "SENSOR_OFFSET_WDR_4_BLACK01 is a WDR_4 BLC Gr component black level register.

Data sheet 10.6 SENSOR_OFFSET_WDR_4_BLACK01 (offset 0x200F4, printed page 10-108, `hi3516av200--Hi3516AV200-Datasheet.txt` line 71254).";

        field {
            name = "black01";
            desc = "Black level offset of color channel 01 (Gr)";
            sw = rw;
            hw = r;
            reset = 0x0;
        } black01[11:0];
    } SENSOR_OFFSET_WDR_4_BLACK01 @ 0x100F4;

    reg {
        name = "WDR_4 BLC Gb component black level register";
        desc = "SENSOR_OFFSET_WDR_4_BLACK10 is a WDR_4 BLC Gb component black level register.

Data sheet 10.6 SENSOR_OFFSET_WDR_4_BLACK10 (offset 0x200F8, printed page 10-108, `hi3516av200--Hi3516AV200-Datasheet.txt` line 71275).";

        field {
            name = "black10";
            desc = "Black level offset of color channel 10 (Gb)";
            sw = rw;
            hw = r;
            reset = 0x0;
        } black10[11:0];
    } SENSOR_OFFSET_WDR_4_BLACK10 @ 0x100F8;

    reg {
        name = "WDR_4 BLC B component black level register";
        desc = "SENSOR_OFFSET_WDR_4_BLACK11 is a WDR_4 BLC B component black level register. Hi3516A V200 Professional HD IP Camera SoC

Data sheet 10.6 SENSOR_OFFSET_WDR_4_BLACK11 (offset 0x200FC, printed page 10-109, `hi3516av200--Hi3516AV200-Datasheet.txt` line 71304).";

        field {
            name = "black11";
            desc = "Black level offset of color channel 11 (B)";
            sw = rw;
            hw = r;
            reset = 0x0;
        } black11[11:0];
    } SENSOR_OFFSET_WDR_4_BLACK11 @ 0x100FC;

    reg {
        name = "Input port horizontal count limit configuration register";
        desc = "INPUTPORT_HC_LIMIT is an input port horizontal count limit configuration register.

Data sheet 10.6 INPUTPORT_HC_LIMIT (offset 0x20108, printed page 10-109, `hi3516av200--Hi3516AV200-Datasheet.txt` line 71324).";

        field {
            name = "hc_limit";
            desc = "Horizontal count limit value (for example, 0, 1, …, hc_limit - 1, hc_limit, 0, 1, …)";
            sw = rw;
            hw = r;
            reset = 0xFFFF;
        } hc_limit[15:0];
    } INPUTPORT_HC_LIMIT @ 0x10108;

    reg {
        name = "Input port horizontal start register 0";
        desc = "INPUTPORT_HC_START0 is input port horizontal start register 0.

Data sheet 10.6 INPUTPORT_HC_START0 (offset 0x2010C, printed page 10-109, `hi3516av200--Hi3516AV200-Datasheet.txt` line 71345).";

        field {
            name = "hcstart0";
            desc = "Start value of ACL gating signal window 0";
            sw = rw;
            hw = r;
            reset = 0x0;
        } hcstart0[15:0];
    } INPUTPORT_HC_START0 @ 0x1010C;

    reg {
        name = "Input port horizontal size register 0";
        desc = "INPUTPORT_HC_SIZE0 is input port horizontal size register 0.

Data sheet 10.6 INPUTPORT_HC_SIZE0 (offset 0x20110, printed page 10-110, `hi3516av200--Hi3516AV200-Datasheet.txt` line 71371).";

        field {
            name = "hcsize0";
            desc = "Size of ACL gating signal window 0";
            sw = rw;
            hw = r;
            reset = 0x0;
        } hcsize0[15:0];
    } INPUTPORT_HC_SIZE0 @ 0x10110;

    reg {
        name = "Input port horizontal start register 1";
        desc = "INPUTPORT_HC_START1 is input port horizontal start register 1.

Data sheet 10.6 INPUTPORT_HC_START1 (offset 0x20114, printed page 10-110, `hi3516av200--Hi3516AV200-Datasheet.txt` line 71391).";

        field {
            name = "hcstart1";
            desc = "Start value of HS gating signal window 1";
            sw = rw;
            hw = r;
            reset = 0x0;
        } hcstart1[15:0];
    } INPUTPORT_HC_START1 @ 0x10114;

    reg {
        name = "Input port horizontal size register 1";
        desc = "INPUTPORT_HC_SIZE1 is input port horizontal size register 1.

Data sheet 10.6 INPUTPORT_HC_SIZE1 (offset 0x20118, printed page 10-110, `hi3516av200--Hi3516AV200-Datasheet.txt` line 71410).";

        field {
            name = "hcsize1";
            desc = "Size of HS gating signal window 1";
            sw = rw;
            hw = r;
            reset = 0x0;
        } hcsize1[15:0];
    } INPUTPORT_HC_SIZE1 @ 0x10118;

    reg {
        name = "Input port vertical count limit configuration register";
        desc = "INPUTPORT_VC_LIMIT is an input port vertical count limit configuration register.

Data sheet 10.6 INPUTPORT_VC_LIMIT (offset 0x2011C, printed page 10-111, `hi3516av200--Hi3516AV200-Datasheet.txt` line 71439).";

        field {
            name = "vclimit";
            desc = "Vertical count limit value (for example, 0, 1, …, vclimit - 1, vclimit, 0, 1, …)";
            sw = rw;
            hw = r;
            reset = 0xFFFF;
        } vclimit[15:0];
    } INPUTPORT_VC_LIMIT @ 0x1011C;

    reg {
        name = "Input port vertical start register";
        desc = "INPUTPORT_VC_START is an input port vertical start register.

Data sheet 10.6 INPUTPORT_VC_START (offset 0x20120, printed page 10-111, `hi3516av200--Hi3516AV200-Datasheet.txt` line 71461).";

        field {
            name = "vcstart";
            desc = "Start value of ACL gating signal window 2";
            sw = rw;
            hw = r;
            reset = 0x0;
        } vcstart[15:0];
    } INPUTPORT_VC_START @ 0x10120;

    reg {
        name = "Input port vertical size register";
        desc = "INPUTPORT_VC_SIZE is an input port vertical size register. Hi3516A V200 Professional HD IP Camera SoC

Data sheet 10.6 INPUTPORT_VC_SIZE (offset 0x20124, printed page 10-112, `hi3516av200--Hi3516AV200-Datasheet.txt` line 71489).";

        field {
            name = "vcsize";
            desc = "Size of ACL gating signal window 2";
            sw = rw;
            hw = r;
            reset = 0x0;
        } vcsize[15:0];
    } INPUTPORT_VC_SIZE @ 0x10124;

    reg {
        name = "Input port control register";
        desc = "INPUTPORT_CTRL is an input port control register.

Data sheet 10.6 INPUTPORT_CTRL (offset 0x20130, printed page 10-112, `hi3516av200--Hi3516AV200-Datasheet.txt` line 71509).";

        enum INPUTPORT_CTRL_freezeconfig_enum {
            NORMAL_OPERATION = 0 { name = "Normal Operation"; desc = "normal operation"; };
            PREVIOUS_CONFIGURATION_STATUS = 1 { name = "Previous Configuration Status"; desc = "The previous configuration status is retained."; };
        };

        field {
            name = "freezeconfig";
            desc = "Input port configuration freeze";
            sw = rw;
            hw = r;
            encode = INPUTPORT_CTRL_freezeconfig_enum;
            reset = 0x0;
        } freezeconfig[7:7];

        enum INPUTPORT_CTRL_moderequest_enum {
            SAFE_STOP = 0 { name = "Safe Stop"; desc = "safe stop"; };
            SAFE_START = 1 { name = "Safe Start"; desc = "safe start"; };
            EMERGENCY_STOP = 2 { name = "Emergency Stop"; desc = "emergency stop"; };
            EMERGENCY_START = 3 { name = "Emergency Start"; desc = "emergency start"; };
            RESERVED = 4 { name = "Reserved"; desc = "reserved"; };
            SAFER_START = 5 { name = "Safer Start"; desc = "safer start"; };
            RESERVED_2 = 6 { name = "Reserved 2"; desc = "reserved"; };
            RESERVED_3 = 7 { name = "Reserved 3"; desc = "reserved"; };
        };

        field {
            name = "moderequest";
            desc = "Input port start and stop";
            sw = rw;
            hw = r;
            encode = INPUTPORT_CTRL_moderequest_enum;
            reset = 0x0;
        } moderequest[2:0];
    } INPUTPORT_CTRL @ 0x10130;

    reg {
        name = "Input port status register";
        desc = "INPUTPORT_STATUS is an input port status register.

Data sheet 10.6 INPUTPORT_STATUS (offset 0x20134, printed page 10-113, `hi3516av200--Hi3516AV200-Datasheet.txt` line 71554).";

        enum INPUTPORT_STATUS_modestatus_enum {
            STARTED = 1 { name = "Started"; desc = "started"; };
            STOPPED_BIT_2 = 0 { name = "Stopped Bit 2"; desc = "stopped Bit[2:1]: reserved"; };
        };

        field {
            name = "modestatus";
            desc = "Input port status monitoring Bit[0]";
            sw = r;
            hw = w;
            encode = INPUTPORT_STATUS_modestatus_enum;
            reset = 0x0;
        } modestatus[2:0];
    } INPUTPORT_STATUS @ 0x10134;

    reg {
        name = "Input formatter mode control register";
        desc = "INPUT_FORMATTER_MODE is an input formatter mode control register. Hi3516A V200 Professional HD IP Camera SoC

Data sheet 10.6 INPUT_FORMATTER_MODE (offset 0x20140, printed page 10-114, `hi3516av200--Hi3516AV200-Datasheet.txt` line 71593).";

        enum INPUT_FORMATTER_MODE_input_bitwidth_select_enum {
            V_12_BITS = 0 { name = "V 12 Bits"; desc = "12 bits"; };
            V_14_BITS = 1 { name = "V 14 Bits"; desc = "14 bits"; };
            V_16_BITS = 2 { name = "V 16 Bits"; desc = "16 bits"; };
            V_20_BITS = 3 { name = "V 20 Bits"; desc = "20 bits"; };
        };

        field {
            name = "input_bitwidth_select";
            desc = "Input data width select";
            sw = rw;
            hw = r;
            encode = INPUT_FORMATTER_MODE_input_bitwidth_select_enum;
            reset = 0x0;
        } input_bitwidth_select[17:16];
    } INPUT_FORMATTER_MODE @ 0x10140;

    reg {
        name = "Input formatter exposure ratio";
        desc = "INPUT_FORMATTER_FACTORML is an input formatter exposure ratio (long frame to medium frame) register.

Data sheet 10.6 INPUT_FORMATTER_FACTORML (offset 0x20144, printed page 10-114, `hi3516av200--Hi3516AV200-Datasheet.txt` line 71627).";

        field {
            name = "factorml";
            desc = "Exposure ratio of the long frame to the medium frame, 6.12-bit fixed-point value";
            sw = rw;
            hw = r;
            reset = 0x1000;
        } factorml[17:0];
    } INPUT_FORMATTER_FACTORML @ 0x10144;

    reg {
        name = "Input formatter exposure ratio";
        desc = "INPUT_FORMATTER_FACTORMS is an input formatter exposure ratio (short frame to medium frame) register.

Data sheet 10.6 INPUT_FORMATTER_FACTORMS (offset 0x20148, printed page 10-115, `hi3516av200--Hi3516AV200-Datasheet.txt` line 71655).";

        field {
            name = "factorms";
            desc = "Exposure ratio of the short frame to the medium frame, 1.12-bit fixed-point value";
            sw = rw;
            hw = r;
            reset = 0x1000;
        } factorms[12:0];
    } INPUT_FORMATTER_FACTORMS @ 0x10148;

    reg {
        name = "Input formatter sensor black level register";
        desc = "INPUT_FORMATTER_BLACKLEVEL is an input formatter sensor black level register.

Data sheet 10.6 INPUT_FORMATTER_BLACKLEVEL (offset 0x2014C, printed page 10-115, `hi3516av200--Hi3516AV200-Datasheet.txt` line 71676).";

        field {
            name = "blacklevel";
            desc = "Sensor black level";
            sw = rw;
            hw = r;
            reset = 0x0;
        } blacklevel[11:0];
    } INPUT_FORMATTER_BLACKLEVEL @ 0x1014C;

    reg {
        name = "Input formatter knee point 0/1 register";
        desc = "INPUT_FORMATTER_KNEEPOINT01 is an input formatter knee point 0/1 register. Hi3516A V200 Professional HD IP Camera SoC

Data sheet 10.6 INPUT_FORMATTER_KNEEPOINT01 (offset 0x20150, printed page 10-116, `hi3516av200--Hi3516AV200-Datasheet.txt` line 71705).";

        field {
            name = "kneepoint1";
            desc = "Knee point 1";
            sw = rw;
            hw = r;
            reset = 0x580;
        } kneepoint1[31:16];

        field {
            name = "kneepoint0";
            desc = "Knee point 0";
            sw = rw;
            hw = r;
            reset = 0x200;
        } kneepoint0[15:0];
    } INPUT_FORMATTER_KNEEPOINT01 @ 0x10150;

    reg {
        name = "Input formatter knee point 2 register";
        desc = "INPUT_FORMATTER_KNEEPOINT2 is an input formatter knee point 2 register. [check] The data-sheet table extraction produced overlapping bit fields for this register; the overlapping entries slope1select[11:8], slope0select[3:0] were dropped - verify against the printed page.

Data sheet 10.6 INPUT_FORMATTER_KNEEPOINT2 (offset 0x20154, printed page 10-116, `hi3516av200--Hi3516AV200-Datasheet.txt` line 71725).";

        field {
            name = "slope3select";
            desc = "slope3select";
            sw = rw;
            hw = r;
            reset = 0x0;
        } slope3select[27:24];

        field {
            name = "slope2select";
            desc = "Slope 2 of the compression table (4 bits)";
            sw = rw;
            hw = r;
            reset = 0x0;
        } slope2select[19:16];

        field {
            name = "kneepoint2";
            desc = "Knee point 2";
            sw = rw;
            hw = r;
            reset = 0x881;
        } kneepoint2[15:0];
    } INPUT_FORMATTER_KNEEPOINT2 @ 0x10154;

    reg {
        name = "VIDEO_TEST_GEN control register";
        desc = "VIDEO_TEST_GEN_CTRL is a VIDEO_TEST_GEN control register.

Data sheet 10.6 VIDEO_TEST_GEN_CTRL (offset 0x20160, printed page 10-117, `hi3516av200--Hi3516AV200-Datasheet.txt` line 71783).";

        enum VIDEO_TEST_GEN_CTRL_bayer_rgb_o_sel_enum {
            BAYER = 0 { name = "Bayer"; desc = "Bayer"; };
            RGB = 1 { name = "Rgb"; desc = "RGB"; };
        };

        field {
            name = "bayer_rgb_o_sel";
            desc = "Output format select";
            sw = rw;
            hw = r;
            encode = VIDEO_TEST_GEN_CTRL_bayer_rgb_o_sel_enum;
            reset = 0x0;
        } bayer_rgb_o_sel[2:2];

        enum VIDEO_TEST_GEN_CTRL_bayer_rgb_i_sel_enum {
            BAYER = 0 { name = "Bayer"; desc = "Bayer"; };
            RGB = 1 { name = "Rgb"; desc = "RGB"; };
        };

        field {
            name = "bayer_rgb_i_sel";
            desc = "Input format select";
            sw = rw;
            hw = r;
            encode = VIDEO_TEST_GEN_CTRL_bayer_rgb_i_sel_enum;
            reset = 0x0;
        } bayer_rgb_i_sel[1:1];

        enum VIDEO_TEST_GEN_CTRL_test_pattern_off_on_enum {
            DISABLED = 0 { name = "Disabled"; desc = "disabled"; };
            ENABLED = 1 { name = "Enabled"; desc = "enabled"; };
        };

        field {
            name = "test_pattern_off_on";
            desc = "Test pattern enable";
            sw = rw;
            hw = r;
            encode = VIDEO_TEST_GEN_CTRL_test_pattern_off_on_enum;
            reset = 0x0;
        } test_pattern_off_on[0:0];
    } VIDEO_TEST_GEN_CTRL @ 0x10160;

    reg {
        name = "VIDEO_TEST_GEN mode type selection register";
        desc = "VIDEO_TEST_PATTREN_TYPE is a VIDEO_TEST_GEN mode type selection register. Hi3516A V200 Professional HD IP Camera SoC

Data sheet 10.6 VIDEO_TEST_PATTREN_TYPE (offset 0x20164, printed page 10-118, `hi3516av200--Hi3516AV200-Datasheet.txt` line 71827).";

        enum VIDEO_TEST_PATTREN_TYPE_patterntype_enum {
            PURE_COLOR = 0x0 { name = "Pure Color"; desc = "pure color"; };
            HORIZONTAL_GRADIENT = 0x1 { name = "Horizontal Gradient"; desc = "horizontal gradient"; };
            VERTICAL_GRADIENT = 0x2 { name = "Vertical Gradient"; desc = "vertical gradient"; };
            VERTICAL_STRIPE = 0x3 { name = "Vertical Stripe"; desc = "vertical stripe"; };
            RECTANGLE_OTHER_VALUES = 0x4 { name = "Rectangle Other Values"; desc = "rectangle Other values: white target on a black background"; };
        };

        field {
            name = "patterntype";
            desc = "Mode type select";
            sw = rw;
            hw = r;
            encode = VIDEO_TEST_PATTREN_TYPE_patterntype_enum;
            reset = 0x3;
        } patterntype[7:0];
    } VIDEO_TEST_PATTREN_TYPE @ 0x10164;

    reg {
        name = "VIDEO_TEST_GEN R component background value register";
        desc = "VIDEO_TEST_R_BACKGND is a VIDEO_TEST_GEN R component background value register.

Data sheet 10.6 VIDEO_TEST_R_BACKGND (offset 0x20168, printed page 10-118, `hi3516av200--Hi3516AV200-Datasheet.txt` line 71854).";

        field {
            name = "rbackgnd";
            desc = "16-bit R component background value, aligned with the MSB of the bit width";
            sw = rw;
            hw = r;
            reset = 0xFFFF;
        } rbackgnd[15:0];
    } VIDEO_TEST_R_BACKGND @ 0x10168;

    reg {
        name = "VIDEO_TEST_GEN G component background value register";
        desc = "VIDEO_TEST_G_BACKGND is a VIDEO_TEST_GEN G component background value register. Hi3516A V200 Professional HD IP Camera SoC

Data sheet 10.6 VIDEO_TEST_G_BACKGND (offset 0x2016C, printed page 10-119, `hi3516av200--Hi3516AV200-Datasheet.txt` line 71886).";

        field {
            name = "gbackgnd";
            desc = "16-bit G component background value, aligned with the MSB of the bit width";
            sw = rw;
            hw = r;
            reset = 0xFFFF;
        } gbackgnd[15:0];
    } VIDEO_TEST_G_BACKGND @ 0x1016C;

    reg {
        name = "VIDEO_TEST_GEN B component background value register";
        desc = "VIDEO_TEST_B_BACKGND is a VIDEO_TEST_GEN B component background value register.

Data sheet 10.6 VIDEO_TEST_B_BACKGND (offset 0x20170, printed page 10-119, `hi3516av200--Hi3516AV200-Datasheet.txt` line 71909).";

        field {
            name = "bbackgnd";
            desc = "16-bit B component background value, aligned with the MSB of the bit width";
            sw = rw;
            hw = r;
            reset = 0xFFFF;
        } bbackgnd[15:0];
    } VIDEO_TEST_B_BACKGND @ 0x10170;

    reg {
        name = "VIDEO_TEST_GEN R component foreground value register";
        desc = "VIDEO_TEST_R_FOREGND is a VIDEO_TEST_GEN R component foreground value register.

Data sheet 10.6 VIDEO_TEST_R_FOREGND (offset 0x20174, printed page 10-119, `hi3516av200--Hi3516AV200-Datasheet.txt` line 71932).";

        field {
            name = "rforegnd";
            desc = "16-bit R component foreground value, aligned with the MSB of the bit width";
            sw = rw;
            hw = r;
            reset = 0x8FFF;
        } rforegnd[15:0];
    } VIDEO_TEST_R_FOREGND @ 0x10174;

    reg {
        name = "VIDEO_TEST_GEN G component foreground value register";
        desc = "VIDEO_TEST_G_FOREGND is a VIDEO_TEST_GEN G component foreground value register.

Data sheet 10.6 VIDEO_TEST_G_FOREGND (offset 0x20178, printed page 10-120, `hi3516av200--Hi3516AV200-Datasheet.txt` line 71963).";

        field {
            name = "gforegnd";
            desc = "16-bit G component foreground value, aligned with the MSB of the bit width";
            sw = rw;
            hw = r;
            reset = 0x8FFF;
        } gforegnd[15:0];
    } VIDEO_TEST_G_FOREGND @ 0x10178;

    reg {
        name = "VIDEO_TEST_GEN B component foreground value register";
        desc = "VIDEO_TEST_B_FOREGND is a VIDEO_TEST_GEN B component foreground value register.

Data sheet 10.6 VIDEO_TEST_B_FOREGND (offset 0x2017C, printed page 10-120, `hi3516av200--Hi3516AV200-Datasheet.txt` line 71985).";

        field {
            name = "bforegnd";
            desc = "16-bit B component foreground value, aligned with the MSB of the bit width";
            sw = rw;
            hw = r;
            reset = 0x8FFF;
        } bforegnd[15:0];
    } VIDEO_TEST_B_FOREGND @ 0x1017C;

    reg {
        name = "VIDEO_TEST_GEN channel 1/2 RGB gradient increment register";
        desc = "VIDEO_TEST_RGB_GRADIENT is a VIDEO_TEST_GEN channel 1/2 RGB gradient increment register. Hi3516A V200 Professional HD IP Camera SoC [check] The data-sheet table extraction produced overlapping bit fields for this register; the overlapping entries rgbgradient4[31:16], rgbgradient3[15:0], rgb_gradient_start_[31:16], rgb_gradient_start[15:0], rgb_gradient_start_[31:16], rgb_gradient_start_[15:0] were dropped - verify against the printed page.

Data sheet 10.6 VIDEO_TEST_RGB_GRADIENT (offset 0x20180, printed page 10-121, `hi3516av200--Hi3516AV200-Datasheet.txt` line 72017).";

        field {
            name = "rgbgradient2";
            desc = "rgbgradient2";
            sw = rw;
            hw = r;
            reset = 0x3CAA;
        } rgbgradient2[31:16];

        field {
            name = "rgbgradient";
            desc = "rgbgradient";
            sw = rw;
            hw = r;
            reset = 0x3CAA;
        } rgbgradient[15:0];
    } VIDEO_TEST_RGB_GRADIENT @ 0x10180;

    reg {
        name = "VIDEO_TEST_GEN line ID register for the top and bottom of the rectangle";
        desc = "VIDEO_TEST_RECT_TOP is a VIDEO_TEST_GEN line ID register for the top and bottom of the rectangle. Hi3516A V200 Professional HD IP Camera SoC

Data sheet 10.6 VIDEO_TEST_RECT_TOP (offset 0x20190, printed page 10-123, `hi3516av200--Hi3516AV200-Datasheet.txt` line 72144).";

        field {
            name = "rect_bot";
            desc = "ID of the line where the rectangle bottom is located";
            sw = rw;
            hw = r;
            reset = 0x100;
        } rect_bot[29:16];

        field {
            name = "rect_top";
            desc = "ID of the line where the rectangle top is located";
            sw = rw;
            hw = r;
            reset = 0x1;
        } rect_top[13:0];
    } VIDEO_TEST_RECT_TOP @ 0x10190;

    reg {
        name = "VIDEO_TEST_GEN pixel ID register for the left part of the rectangle";
        desc = "VIDEO_TEST_RECT_LEFT is a VIDEO_TEST_GEN pixel ID register for the left part of the rectangle.

Data sheet 10.6 VIDEO_TEST_RECT_LEFT (offset 0x20194, printed page 10-123, `hi3516av200--Hi3516AV200-Datasheet.txt` line 72170).";

        field {
            name = "rectleft";
            desc = "ID of the pixel where the left part of the rectangle is located";
            sw = rw;
            hw = r;
            reset = 0x1;
        } rectleft[13:0];
    } VIDEO_TEST_RECT_LEFT @ 0x10194;

    reg {
        name = "VIDEO_TEST_GEN pixel ID register for the right part of the rectangle";
        desc = "VIDEO_TEST_RECT_RIGHT is a VIDEO_TEST_GEN pixel ID register for the right part of the rectangle. Hi3516A V200 Professional HD IP Camera SoC

Data sheet 10.6 VIDEO_TEST_RECT_RIGHT (offset 0x20198, printed page 10-124, `hi3516av200--Hi3516AV200-Datasheet.txt` line 72200).";

        field {
            name = "rectright";
            desc = "ID of the pixel where the right part of the rectangle is located";
            sw = rw;
            hw = r;
            reset = 0x100;
        } rectright[13:0];
    } VIDEO_TEST_RECT_RIGHT @ 0x10198;

    reg {
        name = "R component black level register";
        desc = "SENSOR_OFFSET_BLACK00 is an R component black level register.

Data sheet 10.6 SENSOR_OFFSET_BLACK00 (offset 0x201A0, printed page 10-124, `hi3516av200--Hi3516AV200-Datasheet.txt` line 72220).";

        field {
            name = "black00";
            desc = "Black level offset of color channel 00 (R)";
            sw = rw;
            hw = r;
            reset = 0x0;
        } black00[19:0];
    } SENSOR_OFFSET_BLACK00 @ 0x101A0;

    reg {
        name = "Gr component black level register";
        desc = "SENSOR_OFFSET_BLACK01 is a Gr component black level register.

Data sheet 10.6 SENSOR_OFFSET_BLACK01 (offset 0x201A4, printed page 10-124, `hi3516av200--Hi3516AV200-Datasheet.txt` line 72239).";

        field {
            name = "black01";
            desc = "Black level offset of color channel 01 (Gr)";
            sw = rw;
            hw = r;
            reset = 0x0;
        } black01[19:0];
    } SENSOR_OFFSET_BLACK01 @ 0x101A4;

    reg {
        name = "Gb component black level register";
        desc = "SENSOR_OFFSET_BLACK10 is a Gb component black level register.

Data sheet 10.6 SENSOR_OFFSET_BLACK10 (offset 0x201A8, printed page 10-125, `hi3516av200--Hi3516AV200-Datasheet.txt` line 72265).";

        field {
            name = "black10";
            desc = "Black level offset of color channel 10 (Gb)";
            sw = rw;
            hw = r;
            reset = 0x0;
        } black10[19:0];
    } SENSOR_OFFSET_BLACK10 @ 0x101A8;

    reg {
        name = "B component black level register";
        desc = "SENSOR_OFFSET_BLACK11 is a B component black level register. [check] The data-sheet table extraction produced overlapping bit fields for this register; the overlapping entries expthresh[15:0], shortratio[7:0], longratio[7:0] were dropped - verify against the printed page.

Data sheet 10.6 SENSOR_OFFSET_BLACK11 (offset 0x201AC, printed page 10-125, `hi3516av200--Hi3516AV200-Datasheet.txt` line 72285).";

        field {
            name = "black11";
            desc = "Black level offset of color channel 11 (B)";
            sw = rw;
            hw = r;
            reset = 0x0;
        } black11[19:0];
    } SENSOR_OFFSET_BLACK11 @ 0x101AC;

    reg {
        name = "NP_RAW_FRONTEND1 noise black level offset register";
        desc = "NP_RAW_FRONTEND1_OFF is an NP_RAW_FRONTEND1 noise black level offset register. [check] The data-sheet table extraction produced overlapping bit fields for this register; the overlapping entries expthresh[15:0], shortratio[7:0], longratio[7:0] were dropped - verify against the printed page.

Data sheet 10.6 NP_RAW_FRONTEND1_OFF (offset 0x201BC, printed page 10-127, `hi3516av200--Hi3516AV200-Datasheet.txt` line 72394).";

        enum NP_RAW_FRONTEND1_OFF_np_off_reflect_enum {
            INPUT_FIRST_TABLE = 0 { name = "Input First Table"; desc = "The input of the first table is repeated."; };
            PART_BELOW_BLACK = 1 { name = "Part Below Black"; desc = "The part below the black level on the noise curve is mapped."; };
        };

        field {
            name = "np_off_reflect";
            desc = "Method of obtaining values below the black level";
            sw = rw;
            hw = r;
            encode = NP_RAW_FRONTEND1_OFF_np_off_reflect_enum;
            reset = 0x0;
        } np_off_reflect[7:7];

        field {
            name = "np_off";
            desc = "Noise black level offset";
            sw = rw;
            hw = r;
            reset = 0x0;
        } np_off[6:0];
    } NP_RAW_FRONTEND1_OFF @ 0x101BC;

    reg {
        name = "NP_RAW_FRONTEND2 noise black level offset register";
        desc = "NP_RAW_FRONTEND2_OFF is an NP_RAW_FRONTEND2 noise black level offset register. [check] The data-sheet table extraction produced overlapping bit fields for this register; the overlapping entries expthresh[15:0], shortratio[7:0], longratio[7:0] were dropped - verify against the printed page.

Data sheet 10.6 NP_RAW_FRONTEND2_OFF (offset 0x201CC, printed page 10-129, `hi3516av200--Hi3516AV200-Datasheet.txt` line 72513).";

        enum NP_RAW_FRONTEND2_OFF_np_off_reflect_enum {
            INPUT_FIRST_TABLE = 0 { name = "Input First Table"; desc = "The input of the first table is repeated."; };
            PART_BELOW_BLACK = 1 { name = "Part Below Black"; desc = "The part below the black level on the noise curve is mapped."; };
        };

        field {
            name = "np_off_reflect";
            desc = "Method of obtaining values below the black level";
            sw = rw;
            hw = r;
            encode = NP_RAW_FRONTEND2_OFF_np_off_reflect_enum;
            reset = 0x0;
        } np_off_reflect[7:7];

        field {
            name = "np_off";
            desc = "Noise black level offset";
            sw = rw;
            hw = r;
            reset = 0x0;
        } np_off[6:0];
    } NP_RAW_FRONTEND2_OFF @ 0x101CC;

    reg {
        name = "NP_RAW_FRONTEND3 noise black level offset register";
        desc = "NP_RAW_FRONTEND3_OFF is an NP_RAW_FRONTEND3 noise black level offset register. [check] The data-sheet table extraction produced overlapping bit fields for this register; the overlapping entries exp_thresh[15:0], short_ratio[7:0], long_ratio[7:0] were dropped - verify against the printed page.

Data sheet 10.6 NP_RAW_FRONTEND3_OFF (offset 0x201DC, printed page 10-131, `hi3516av200--Hi3516AV200-Datasheet.txt` line 72632).";

        enum NP_RAW_FRONTEND3_OFF_np_off_reflect_enum {
            INPUT_FIRST_TABLE = 0 { name = "Input First Table"; desc = "The input of the first table is repeated."; };
            PART_BELOW_BLACK = 1 { name = "Part Below Black"; desc = "The part below the black level on the noise curve is mapped."; };
        };

        field {
            name = "np_off_reflect";
            desc = "Method of obtaining values below the black level";
            sw = rw;
            hw = r;
            encode = NP_RAW_FRONTEND3_OFF_np_off_reflect_enum;
            reset = 0x0;
        } np_off_reflect[7:7];

        field {
            name = "np_off";
            desc = "Noise black level offset";
            sw = rw;
            hw = r;
            reset = 0x0;
        } np_off[6:0];
    } NP_RAW_FRONTEND3_OFF @ 0x101DC;

    reg {
        name = "NP_RAW_FRONTEND4 noise black level offset register";
        desc = "NP_RAW_FRONTEND4_OFF is an NP_RAW_FRONTEND4 noise black level offset register.

Data sheet 10.6 NP_RAW_FRONTEND4_OFF (offset 0x201EC, printed page 10-133, `hi3516av200--Hi3516AV200-Datasheet.txt` line 72751).";

        enum NP_RAW_FRONTEND4_OFF_np_off_reflect_enum {
            INPUT_FIRST_TABLE = 0 { name = "Input First Table"; desc = "The input of the first table is repeated."; };
            PART_BELOW_BLACK = 1 { name = "Part Below Black"; desc = "The part below the black level on the noise curve is mapped."; };
        };

        field {
            name = "np_off_reflect";
            desc = "Method of obtaining values below the black level";
            sw = rw;
            hw = r;
            encode = NP_RAW_FRONTEND4_OFF_np_off_reflect_enum;
            reset = 0x0;
        } np_off_reflect[7:7];

        field {
            name = "np_off";
            desc = "Noise black level offset";
            sw = rw;
            hw = r;
            reset = 0x0;
        } np_off[6:0];
    } NP_RAW_FRONTEND4_OFF @ 0x101EC;

    reg {
        name = "RAW_FRONTEND1 module control register";
        desc = "RAW_FRONTEND1_CTRL1 is an RAW_FRONTEND1 module control register. Hi3516A V200 Professional HD IP Camera SoC

Data sheet 10.6 RAW_FRONTEND1_CTRL1 (offset 0x20200, printed page 10-134, `hi3516av200--Hi3516AV200-Datasheet.txt` line 72789).";

        enum RAW_FRONTEND1_CTRL1_bright_disable_enum {
            ENABLED = 0 { name = "Enabled"; desc = "enabled"; };
            DISABLED = 1 { name = "Disabled"; desc = "disabled"; };
        };

        field {
            name = "bright_disable";
            desc = "Bright spot detection control";
            sw = rw;
            hw = r;
            encode = RAW_FRONTEND1_CTRL1_bright_disable_enum;
            reset = 0x0;
        } bright_disable[7:7];

        enum RAW_FRONTEND1_CTRL1_dark_disable_enum {
            ENABLED = 0 { name = "Enabled"; desc = "enabled"; };
            DISABLED = 1 { name = "Disabled"; desc = "disabled"; };
        };

        field {
            name = "dark_disable";
            desc = "Dark spot detection control";
            sw = rw;
            hw = r;
            encode = RAW_FRONTEND1_CTRL1_dark_disable_enum;
            reset = 0x0;
        } dark_disable[6:6];

        enum RAW_FRONTEND1_CTRL1_show_dynamic_defect_pixel_enum {
            DISABLED = 0 { name = "Disabled"; desc = "disabled"; };
            ENABLED = 1 { name = "Enabled"; desc = "enabled"; };
        };

        field {
            name = "show_dynamic_defect_pixel";
            desc = "Display of detected defect pixels";
            sw = rw;
            hw = r;
            encode = RAW_FRONTEND1_CTRL1_show_dynamic_defect_pixel_enum;
            reset = 0x0;
        } show_dynamic_defect_pixel[3:3];

        enum RAW_FRONTEND1_CTRL1_dp_enable_enum {
            DISABLED = 0 { name = "Disabled"; desc = "disabled"; };
            ENABLED = 1 { name = "Enabled"; desc = "enabled"; };
        };

        field {
            name = "dp_enable";
            desc = "Dynamic defect pixel detection enable";
            sw = rw;
            hw = r;
            encode = RAW_FRONTEND1_CTRL1_dp_enable_enum;
            reset = 0x0;
        } dp_enable[2:2];

        enum RAW_FRONTEND1_CTRL1_ge_enable_enum {
            DISABLED = 0 { name = "Disabled"; desc = "disabled"; };
            ENABLED = 1 { name = "Enabled"; desc = "enabled"; };
        };

        field {
            name = "ge_enable";
            desc = "Green balance enable";
            sw = rw;
            hw = r;
            encode = RAW_FRONTEND1_CTRL1_ge_enable_enum;
            reset = 0x0;
        } ge_enable[0:0];
    } RAW_FRONTEND1_CTRL1 @ 0x10200;

    reg {
        name = "RAW_FRONTEND1 GE strength register";
        desc = "RAW_FRONTEND1_GE_STRENGTH is an RAW_FRONTEND1 GE strength register. Hi3516A V200 Professional HD IP Camera SoC

Data sheet 10.6 RAW_FRONTEND1_GE_STRENGTH (offset 0x20204, printed page 10-135, `hi3516av200--Hi3516AV200-Datasheet.txt` line 72842).";

        field {
            name = "ge_strength";
            desc = "Green balance strength, configured during calibration";
            sw = rw;
            hw = r;
            reset = 0x0;
        } ge_strength[7:0];
    } RAW_FRONTEND1_GE_STRENGTH @ 0x10204;

    reg {
        name = "RAW_FRONTEND1 debugging register";
        desc = "RAW_FRONTEND1_DEBUG_SEL is an RAW_FRONTEND1 debugging register. [check] The data-sheet table extraction produced overlapping bit fields for this register; the overlapping entries dp_threshold[11:0], ge_threshold[11:0] were dropped - verify against the printed page.

Data sheet 10.6 RAW_FRONTEND1_DEBUG_SEL (offset 0x20208, printed page 10-135, `hi3516av200--Hi3516AV200-Datasheet.txt` line 72862).";

        field {
            name = "debug_sel";
            desc = "Debugging port select";
            sw = rw;
            hw = r;
            reset = 0x0;
        } debug_sel[15:0];
    } RAW_FRONTEND1_DEBUG_SEL @ 0x10208;

    reg {
        name = "RAW_FRONTEND1 HP masking function slope register";
        desc = "RAW_FRONTEND1_DP_SLOPE is an RAW_FRONTEND1 HP masking function slope register.

Data sheet 10.6 RAW_FRONTEND1_DP_SLOPE (offset 0x20214, printed page 10-136, `hi3516av200--Hi3516AV200-Datasheet.txt` line 72936).";

        field {
            name = "dp_slope";
            desc = "Slope of the HP masking function";
            sw = rw;
            hw = r;
            reset = 0x200;
        } dp_slope[11:0];
    } RAW_FRONTEND1_DP_SLOPE @ 0x10214;

    reg {
        name = "RAW_FRONTEND1 GE masking function slope register";
        desc = "RAW_FRONTEND1_GE_SLOPE is an RAW_FRONTEND1 GE masking function slope register. Hi3516A V200 Professional HD IP Camera SoC

Data sheet 10.6 RAW_FRONTEND1_GE_SLOPE (offset 0x20218, printed page 10-137, `hi3516av200--Hi3516AV200-Datasheet.txt` line 72966).";

        field {
            name = "ge_slope";
            desc = "Slope of the GE masking function";
            sw = rw;
            hw = r;
            reset = 0xAA;
        } ge_slope[11:0];
    } RAW_FRONTEND1_GE_SLOPE @ 0x10218;

    reg {
        name = "RAW_FRONTEND1 GE module edge sensitivity control register";
        desc = "RAW_FRONTEND1_GE_SENS is an RAW_FRONTEND1 GE module edge sensitivity control register. [check] The data-sheet table extraction produced overlapping bit fields for this register; the overlapping entries dpdev_threshold[11:0] were dropped - verify against the printed page.

Data sheet 10.6 RAW_FRONTEND1_GE_SENS (offset 0x2021C, printed page 10-137, `hi3516av200--Hi3516AV200-Datasheet.txt` line 72987).";

        field {
            name = "ge_sens";
            desc = "Edge sensitivity control of the green balance module";
            sw = rw;
            hw = r;
            reset = 0x80;
        } ge_sens[7:0];
    } RAW_FRONTEND1_GE_SENS @ 0x1021C;

    reg {
        name = "RAW_FRONTEND1 direction control register for the dynamic DPC near the edges";
        desc = "RAW_FRONTEND1_LINE_THRESH is an RAW_FRONTEND1 direction control register for the dynamic DPC near the edges.

Data sheet 10.6 RAW_FRONTEND1_LINE_THRESH (offset 0x20224, printed page 10-138, `hi3516av200--Hi3516AV200-Datasheet.txt` line 73037).";

        field {
            name = "line_thresh";
            desc = "Direction control for the dynamic DPC near the edges";
            sw = rw;
            hw = r;
            reset = 0x150;
        } line_thresh[11:0];
    } RAW_FRONTEND1_LINE_THRESH @ 0x10224;

    reg {
        name = "RAW_FRONTEND1_DP_BLEND";
        desc = "RAW_FRONTEND1_DP_BLEND is RAW_FRONTEND1 dynamic DPC directional/non- directional replacement value blending control register 10.

Data sheet 10.6 RAW_FRONTEND1_DP_BLEND (offset 0x20228, printed page 10-138, `hi3516av200--Hi3516AV200-Datasheet.txt` line 73057).";

        field {
            name = "dp_blend";
            desc = "Blending control for the directional and non-directional replacement values of dynamic DPC. If this field is set to 0x00, the detected default is replaced by the non-directional replacement value; if this field is set to 0xFF, the detected fault is replaced by the directional replacement value.";
            sw = rw;
            hw = r;
            reset = 0x0;
        } dp_blend[7:0];
    } RAW_FRONTEND1_DP_BLEND @ 0x10228;

    reg {
        name = "RAW_FRONTEND1 artificial noise estimation register";
        desc = "RAW_FRONTEND1_SIGMA_IN is an RAW_FRONTEND1 artificial noise estimation register. Hi3516A V200 Professional HD IP Camera SoC [check] The data-sheet table extraction produced overlapping bit fields for this register; the overlapping entries thresh_short[7:0] were dropped - verify against the printed page.

Data sheet 10.6 RAW_FRONTEND1_SIGMA_IN (offset 0x2022C, printed page 10-139, `hi3516av200--Hi3516AV200-Datasheet.txt` line 73091).";

        field {
            name = "sigma_in";
            desc = "Artificial noise estimation";
            sw = rw;
            hw = r;
            reset = 0x0;
        } sigma_in[11:0];
    } RAW_FRONTEND1_SIGMA_IN @ 0x1022C;

    reg {
        name = "RAW_FRONTEND1 long exposure data noise threshold control register";
        desc = "RAW_FRONTEND1_THRESH_LONG is an RAW_FRONTEND1 long exposure data noise threshold control register.

Data sheet 10.6 RAW_FRONTEND1_THRESH_LONG (offset 0x20234, printed page 10-139, `hi3516av200--Hi3516AV200-Datasheet.txt` line 73137).";

        field {
            name = "thresh_long";
            desc = "Noise threshold of long exposure data, 4.4-bit unsigned floating- point number";
            sw = rw;
            hw = r;
            reset = 0x30;
        } thresh_long[7:0];
    } RAW_FRONTEND1_THRESH_LONG @ 0x10234;

    reg {
        name = "RAW_FRONTEND2 module control register 1";
        desc = "RAW_FRONTEND2_CTRL1 is RAW_FRONTEND2 module control register 1.

Data sheet 10.6 RAW_FRONTEND2_CTRL1 (offset 0x20240, printed page 10-140, `hi3516av200--Hi3516AV200-Datasheet.txt` line 73166).";

        enum RAW_FRONTEND2_CTRL1_bright_disable_enum {
            ENABLED = 0 { name = "Enabled"; desc = "enabled"; };
            DISABLED = 1 { name = "Disabled"; desc = "disabled"; };
        };

        field {
            name = "bright_disable";
            desc = "Bright spot detection control";
            sw = rw;
            hw = r;
            encode = RAW_FRONTEND2_CTRL1_bright_disable_enum;
            reset = 0x0;
        } bright_disable[7:7];

        enum RAW_FRONTEND2_CTRL1_dark_disable_enum {
            ENABLED = 0 { name = "Enabled"; desc = "enabled"; };
            DISABLED = 1 { name = "Disabled"; desc = "disabled"; };
        };

        field {
            name = "dark_disable";
            desc = "Dark spot detection control";
            sw = rw;
            hw = r;
            encode = RAW_FRONTEND2_CTRL1_dark_disable_enum;
            reset = 0x0;
        } dark_disable[6:6];

        enum RAW_FRONTEND2_CTRL1_show_dynamic_defect_pixel_enum {
            DISABLED = 0 { name = "Disabled"; desc = "disabled"; };
            ENABLED = 1 { name = "Enabled"; desc = "enabled"; };
        };

        field {
            name = "show_dynamic_defect_pixel";
            desc = "Display of detected defect pixels";
            sw = rw;
            hw = r;
            encode = RAW_FRONTEND2_CTRL1_show_dynamic_defect_pixel_enum;
            reset = 0x0;
        } show_dynamic_defect_pixel[3:3];

        enum RAW_FRONTEND2_CTRL1_dp_enable_enum {
            DISABLED = 0 { name = "Disabled"; desc = "disabled"; };
            ENABLED = 1 { name = "Enabled"; desc = "enabled"; };
        };

        field {
            name = "dp_enable";
            desc = "Dynamic defect pixel detection enable";
            sw = rw;
            hw = r;
            encode = RAW_FRONTEND2_CTRL1_dp_enable_enum;
            reset = 0x0;
        } dp_enable[2:2];

        enum RAW_FRONTEND2_CTRL1_ge_enable_enum {
            DISABLED = 0 { name = "Disabled"; desc = "disabled"; };
            ENABLED = 1 { name = "Enabled"; desc = "enabled"; };
        };

        field {
            name = "ge_enable";
            desc = "Green balance enable";
            sw = rw;
            hw = r;
            encode = RAW_FRONTEND2_CTRL1_ge_enable_enum;
            reset = 0x0;
        } ge_enable[0:0];
    } RAW_FRONTEND2_CTRL1 @ 0x10240;

    reg {
        name = "RAW_FRONTEND2 GE strength register";
        desc = "RAW_FRONTEND2_GE_STRENGTH is an RAW_FRONTEND2 GE strength register. [check] The data-sheet table extraction produced overlapping bit fields for this register; the overlapping entries dp_threshold[11:0], ge_threshold[11:0] were dropped - verify against the printed page.

Data sheet 10.6 RAW_FRONTEND2_GE_STRENGTH (offset 0x20244, printed page 10-141, `hi3516av200--Hi3516AV200-Datasheet.txt` line 73222).";

        field {
            name = "ge_strength";
            desc = "Green balance strength, configured during calibration";
            sw = rw;
            hw = r;
            reset = 0x0;
        } ge_strength[7:0];
    } RAW_FRONTEND2_GE_STRENGTH @ 0x10244;

    reg {
        name = "RAW_FRONTEND2 HP masking function slope register";
        desc = "RAW_FRONTEND2_DP_SLOPE is an RAW_FRONTEND2 HP masking function slope register.

Data sheet 10.6 RAW_FRONTEND2_DP_SLOPE (offset 0x20254, printed page 10-142, `hi3516av200--Hi3516AV200-Datasheet.txt` line 73298).";

        field {
            name = "dp_slope";
            desc = "Slope of the HP masking function";
            sw = rw;
            hw = r;
            reset = 0x200;
        } dp_slope[11:0];
    } RAW_FRONTEND2_DP_SLOPE @ 0x10254;

    reg {
        name = "RAW_FRONTEND2 GE masking function slope register";
        desc = "RAW_FRONTEND2_GE_SLOPE is an RAW_FRONTEND2 GE masking function slope register.

Data sheet 10.6 RAW_FRONTEND2_GE_SLOPE (offset 0x20258, printed page 10-142, `hi3516av200--Hi3516AV200-Datasheet.txt` line 73318).";

        field {
            name = "ge_slope";
            desc = "Slope of the GE masking function";
            sw = rw;
            hw = r;
            reset = 0xAA;
        } ge_slope[11:0];
    } RAW_FRONTEND2_GE_SLOPE @ 0x10258;

    reg {
        name = "RAW_FRONTEND2 GE module edge sensitivity control register";
        desc = "RAW_FRONTEND2_GE_SENS is an RAW_FRONTEND2 GE module edge sensitivity control register. [check] The data-sheet table extraction produced overlapping bit fields for this register; the overlapping entries dpdev_threshold[11:0] were dropped - verify against the printed page.

Data sheet 10.6 RAW_FRONTEND2_GE_SENS (offset 0x2025C, printed page 10-143, `hi3516av200--Hi3516AV200-Datasheet.txt` line 73345).";

        field {
            name = "ge_sens";
            desc = "Edge sensitivity control of the green balance module";
            sw = rw;
            hw = r;
            reset = 0x80;
        } ge_sens[7:0];
    } RAW_FRONTEND2_GE_SENS @ 0x1025C;

    reg {
        name = "RAW_FRONTEND2 direction control register for the dynamic DPC near the edges";
        desc = "RAW_FRONTEND2_LINE_THRESH is an RAW_FRONTEND2 direction control register for the dynamic DPC near the edges. Hi3516A V200 Professional HD IP Camera SoC

Data sheet 10.6 RAW_FRONTEND2_LINE_THRESH (offset 0x20264, printed page 10-144, `hi3516av200--Hi3516AV200-Datasheet.txt` line 73398).";

        field {
            name = "line_thresh";
            desc = "Direction control for the dynamic DPC near the edges";
            sw = rw;
            hw = r;
            reset = 0x150;
        } line_thresh[11:0];
    } RAW_FRONTEND2_LINE_THRESH @ 0x10264;

    reg {
        name = "RAW_FRONTEND2_DP_BLEND";
        desc = "RAW_FRONTEND2_DP_BLEND is RAW_FRONTEND2 dynamic DPC directional/non- directional replacement value blending control register 10.

Data sheet 10.6 RAW_FRONTEND2_DP_BLEND (offset 0x20268, printed page 10-144, `hi3516av200--Hi3516AV200-Datasheet.txt` line 73419).";

        field {
            name = "dp_blend";
            desc = "Blending control for the directional and non-directional replacement values of dynamic DPC. If this field is set to 0x00, the detected default is replaced by the non-directional replacement value; if this field is set to 0xFF, the detected fault is replaced by the directional replacement value.";
            sw = rw;
            hw = r;
            reset = 0x0;
        } dp_blend[7:0];
    } RAW_FRONTEND2_DP_BLEND @ 0x10268;

    reg {
        name = "RAW_FRONTEND2 artificial noise estimation register";
        desc = "RAW_FRONTEND2_SIGMA_IN is an RAW_FRONTEND2 artificial noise estimation register. Hi3516A V200 Professional HD IP Camera SoC [check] The data-sheet table extraction produced overlapping bit fields for this register; the overlapping entries thresh_short[7:0] were dropped - verify against the printed page.

Data sheet 10.6 RAW_FRONTEND2_SIGMA_IN (offset 0x2026C, printed page 10-145, `hi3516av200--Hi3516AV200-Datasheet.txt` line 73452).";

        field {
            name = "sigma_in";
            desc = "Artificial noise estimation";
            sw = rw;
            hw = r;
            reset = 0x0;
        } sigma_in[11:0];
    } RAW_FRONTEND2_SIGMA_IN @ 0x1026C;

    reg {
        name = "RAW_FRONTEND2 long exposure data noise threshold control register";
        desc = "RAW_FRONTEND2_THRESH_LONG is an RAW_FRONTEND2 long exposure data noise threshold control register.

Data sheet 10.6 RAW_FRONTEND2_THRESH_LONG (offset 0x20274, printed page 10-145, `hi3516av200--Hi3516AV200-Datasheet.txt` line 73498).";

        field {
            name = "thresh_long";
            desc = "Noise threshold of long exposure data, 4.4-bit unsigned floating- point number";
            sw = rw;
            hw = r;
            reset = 0x30;
        } thresh_long[7:0];
    } RAW_FRONTEND2_THRESH_LONG @ 0x10274;

    reg {
        name = "STATIC_DPC static DPC 4K/2K mode selection register";
        desc = "STATIC_DPC_MULTI_CH_MODE is a STATIC_DPC static DPC 4K/2K mode selection register.

Data sheet 10.6 STATIC_DPC_MULTI_CH_MODE (offset 0x20280, printed page 10-146, `hi3516av200--Hi3516AV200-Datasheet.txt` line 73528).";

        enum STATIC_DPC_MULTI_CH_MODE_multi_ch_mode_enum {
            V_4_CHANNEL_4K = 0 { name = "V 4 Channel 4K"; desc = "4-channel 4K mode"; };
            V_2_CHANNEL_4K = 1 { name = "V 2 Channel 4K"; desc = "2-channel 4K mode"; };
            V_2_CHANNEL_2K = 2 { name = "V 2 Channel 2K"; desc = "2-channel 2K mode"; };
            RESERVED = 3 { name = "Reserved"; desc = "reserved"; };
        };

        field {
            name = "multi_ch_mode";
            desc = "4K/2K mode select";
            sw = rw;
            hw = r;
            encode = STATIC_DPC_MULTI_CH_MODE_multi_ch_mode_enum;
            reset = 0x0;
        } multi_ch_mode[1:0];
    } STATIC_DPC_MULTI_CH_MODE @ 0x10280;

    reg {
        name = "Static defect pixel module control register";
        desc = "STATIC_DPC_CTRL is a static defect pixel module control register. Hi3516A V200 Professional HD IP Camera SoC

Data sheet 10.6 STATIC_DPC_CTRL (offset 0x20284, printed page 10-147, `hi3516av200--Hi3516AV200-Datasheet.txt` line 73568).";

        field {
            name = "detection_trigger2";
            desc = "The defect pixel detection is started upon the 0-1 edge jump.";
            sw = rw;
            hw = r;
            reset = 0x0;
        } detection_trigger2[12:12];

        enum STATIC_DPC_CTRL_show_static_defect_pixels2_enum {
            NOT_DISPLAYED = 0 { name = "Not Displayed"; desc = "not displayed"; };
            DISPLAYED = 1 { name = "Displayed"; desc = "displayed"; };
        };

        field {
            name = "show_static_defect_pixels2";
            desc = "Display of the detected defect pixels";
            sw = rw;
            hw = r;
            encode = STATIC_DPC_CTRL_show_static_defect_pixels2_enum;
            reset = 0x0;
        } show_static_defect_pixels2[11:11];

        enum STATIC_DPC_CTRL_enable2_enum {
            DISABLED = 0 { name = "Disabled"; desc = "disabled"; };
            ENABLED = 1 { name = "Enabled"; desc = "enabled"; };
        };

        field {
            name = "enable2";
            desc = "DPC enable";
            sw = rw;
            hw = r;
            encode = STATIC_DPC_CTRL_enable2_enum;
            reset = 0x0;
        } enable2[10:10];

        enum STATIC_DPC_CTRL_show_reference2_enum {
            DISABLED = 0 { name = "Disabled"; desc = "disabled"; };
            ENABLED = 1 { name = "Enabled"; desc = "enabled"; };
        };

        field {
            name = "show_reference2";
            desc = "Display of the reference value (used for comparison with the actual value) for implementing defect pixel detection";
            sw = rw;
            hw = r;
            encode = STATIC_DPC_CTRL_show_reference2_enum;
            reset = 0x0;
        } show_reference2[9:9];

        field {
            name = "pointer_reset2";
            desc = "Set of the defect pixel table pointer for each frame. This field is configured when the slave MCU writes the defect pixel table.";
            sw = rw;
            hw = r;
            reset = 0x0;
        } pointer_reset2[8:8];

        field {
            name = "detection_trigger1";
            desc = "The defect pixel detection is started upon the 0-1 edge jump.";
            sw = rw;
            hw = r;
            reset = 0x0;
        } detection_trigger1[4:4];

        enum STATIC_DPC_CTRL_show_static_defect_pixels1_enum {
            NOT_DISPLAYED = 0 { name = "Not Displayed"; desc = "not displayed"; };
            DISPLAYED = 1 { name = "Displayed"; desc = "displayed"; };
        };

        field {
            name = "show_static_defect_pixels1";
            desc = "Display of the detected defect pixels";
            sw = rw;
            hw = r;
            encode = STATIC_DPC_CTRL_show_static_defect_pixels1_enum;
            reset = 0x0;
        } show_static_defect_pixels1[3:3];

        enum STATIC_DPC_CTRL_enable1_enum {
            DISABLED = 0 { name = "Disabled"; desc = "disabled"; };
            ENABLED = 1 { name = "Enabled"; desc = "enabled"; };
        };

        field {
            name = "enable1";
            desc = "DPC enable";
            sw = rw;
            hw = r;
            encode = STATIC_DPC_CTRL_enable1_enum;
            reset = 0x0;
        } enable1[2:2];

        enum STATIC_DPC_CTRL_show_reference1_enum {
            NOT_DISPLAYED = 0 { name = "Not Displayed"; desc = "not displayed"; };
            DISPLAYED = 1 { name = "Displayed"; desc = "displayed"; };
        };

        field {
            name = "show_reference1";
            desc = "Display of the reference value (used for comparison with the actual value) for implementing defect pixel detection";
            sw = rw;
            hw = r;
            encode = STATIC_DPC_CTRL_show_reference1_enum;
            reset = 0x0;
        } show_reference1[1:1];

        field {
            name = "pointer_reset1";
            desc = "Set of the defect pixel table pointer for each frame. This field is configured when the slave MCU writes the defect pixel table.";
            sw = rw;
            hw = r;
            reset = 0x0;
        } pointer_reset1[0:0];
    } STATIC_DPC_CTRL @ 0x10284;

    reg {
        name = "Static defect pixel module table overflow flag register";
        desc = "STATIC_DPC_OVERFLOW is a static defect pixel module table overflow flag register.

Data sheet 10.6 STATIC_DPC_OVERFLOW (offset 0x20288, printed page 10-148, `hi3516av200--Hi3516AV200-Datasheet.txt` line 73639).";

        enum STATIC_DPC_OVERFLOW_overflow2_enum {
            NO_OVERFLOW = 0 { name = "No Overflow"; desc = "no overflow"; };
            OVERFLOW_V = 1 { name = "Overflow V"; desc = "overflow"; };
        };

        field {
            name = "overflow2";
            desc = "Table 2 overflow flag";
            sw = r;
            hw = w;
            encode = STATIC_DPC_OVERFLOW_overflow2_enum;
            reset = 0x0;
        } overflow2[8:8];

        enum STATIC_DPC_OVERFLOW_overflow1_enum {
            NO_OVERFLOW = 0 { name = "No Overflow"; desc = "no overflow"; };
            OVERFLOW_V = 1 { name = "Overflow V"; desc = "overflow"; };
        };

        field {
            name = "overflow1";
            desc = "Table 1 overflow flag";
            sw = r;
            hw = w;
            encode = STATIC_DPC_OVERFLOW_overflow1_enum;
            reset = 0x0;
        } overflow1[0:0];
    } STATIC_DPC_OVERFLOW @ 0x10288;

    reg {
        name = "Static defect pixel module detected defect pixel quantity register";
        desc = "STATIC_DPC_COUNT is a static defect pixel module detected defect pixel quantity register. Hi3516A V200 Professional HD IP Camera SoC

Data sheet 10.6 STATIC_DPC_COUNT (offset 0x2028C, printed page 10-149, `hi3516av200--Hi3516AV200-Datasheet.txt` line 73679).";

        field {
            name = "defect_pixel_count";
            desc = "Number of detected defect pixels";
            sw = r;
            hw = w;
            reset = 0x0;
        } defect_pixel_count[26:16];

        field {
            name = "defect_pixel_count";
            desc = "Number of detected defect pixels";
            sw = r;
            hw = w;
            reset = 0x0;
        } defect_pixel_count_2[11:0];
    } STATIC_DPC_COUNT @ 0x1028C;

    reg {
        name = "Static defect pixel module defect pixel start address register";
        desc = "STATIC_DPC_TABLE_START is a static defect pixel module defect pixel start address register.

Data sheet 10.6 STATIC_DPC_TABLE_START (offset 0x20290, printed page 10-149, `hi3516av200--Hi3516AV200-Datasheet.txt` line 73706).";

        field {
            name = "table_start2";
            desc = "Address of the first defect pixel in the defect pixel table";
            sw = r;
            hw = w;
            reset = 0x0;
        } table_start2[26:16];

        field {
            name = "table_start1";
            desc = "Address of the first defect pixel in the defect pixel table";
            sw = r;
            hw = w;
            reset = 0x0;
        } table_start1[11:0];
    } STATIC_DPC_TABLE_START @ 0x10290;

    reg {
        name = "Static defect pixel module written defect pixel quantity register";
        desc = "STATIC_DPC_COUNT_IN is a static defect pixel module written defect pixel quantity register. Hi3516A V200 Professional HD IP Camera SoC

Data sheet 10.6 STATIC_DPC_COUNT_IN (offset 0x20294, printed page 10-150, `hi3516av200--Hi3516AV200-Datasheet.txt` line 73738).";

        field {
            name = "defect_pixel_count_in2";
            desc = "Number of defect pixels that are written to the table";
            sw = rw;
            hw = r;
            reset = 0x0;
        } defect_pixel_count_in2[26:16];

        field {
            name = "defect_pixel_count_in1";
            desc = "Number of defect pixels that are written to the table";
            sw = rw;
            hw = r;
            reset = 0x0;
        } defect_pixel_count_in1[11:0];
    } STATIC_DPC_COUNT_IN @ 0x10294;

    reg {
        name = "WDR control register";
        desc = "WDR_CTRL is a WDR control register.

Data sheet 10.6 WDR_CTRL (offset 0x202A0, printed page 10-150, `hi3516av200--Hi3516AV200-Datasheet.txt` line 73764).";

        field {
            name = "long_short_thresh";
            desc = "Threshold. Data above this threshold is obtained from a shorter exposure range.";
            sw = rw;
            hw = r;
            reset = 0xF00;
        } long_short_thresh[27:16];

        field {
            name = "rsvd4";
            desc = "Not configurable";
            sw = rw;
            hw = r;
            reset = 0x6;
        } rsvd4[15:13];

        enum WDR_CTRL_alpha_slope_from_zero_enum {
            V_1_EXPOSURE_RATIO = 0 { name = "V 1 Exposure Ratio"; desc = "1/exposure ratio"; };
            V_0 = 1 { name = "V 0"; desc = "0"; };
        };

        field {
            name = "alpha_slope_from_zero";
            desc = "Starting point of the alpha slope";
            sw = rw;
            hw = r;
            encode = WDR_CTRL_alpha_slope_from_zero_enum;
            reset = 0x0;
        } alpha_slope_from_zero[7:7];

        enum WDR_CTRL_wdr_mode_enum {
            DISABLED = 0 { name = "Disabled"; desc = "disabled"; };
            FRAME_SWITCHING_MODE = 1 { name = "Frame Switching Mode"; desc = "frame switching mode"; };
        };

        field {
            name = "wdr_mode";
            desc = "WDR mode select";
            sw = rw;
            hw = r;
            encode = WDR_CTRL_wdr_mode_enum;
            reset = 0x0;
        } wdr_mode[6:6];

        field {
            name = "rsvd3";
            desc = "Not configurable";
            sw = rw;
            hw = r;
            reset = 0x0;
        } rsvd3[5:5];

        field {
            name = "enable_np";
            desc = "Not configurable";
            sw = rw;
            hw = r;
            reset = 0x0;
        } enable_np[4:4];

        field {
            name = "rsvd2";
            desc = "Not configurable";
            sw = rw;
            hw = r;
            reset = 0x0;
        } rsvd2[2:2];

        field {
            name = "rsvd1";
            desc = "Not configurable";
            sw = rw;
            hw = r;
            reset = 0x0;
        } rsvd1[1:1];

        field {
            name = "rsvd0";
            desc = "Not configurable";
            sw = rw;
            hw = r;
            reset = 0x1;
        } rsvd0[0:0];
    } WDR_CTRL @ 0x102A0;

    reg {
        name = "WDR long exposure control register 1";
        desc = "WDR_LONG_CTRL1 is WDR long exposure control register 1.

Data sheet 10.6 WDR_LONG_CTRL1 (offset 0x202A4, printed page 10-151, `hi3516av200--Hi3516AV200-Datasheet.txt` line 73820).";

        field {
            name = "long_exposure_ratio";
            desc = "Exposure ratio, 6.6-bit unsigned fixed-point number";
            sw = rw;
            hw = r;
            reset = 0x100;
        } long_exposure_ratio[27:16];

        field {
            name = "long_long_thresh";
            desc = "Threshold. Data below this threshold is obtained from a longer exposure range.";
            sw = rw;
            hw = r;
            reset = 0xC00;
        } long_long_thresh[11:0];
    } WDR_LONG_CTRL1 @ 0x102A4;

    reg {
        name = "WDR long exposure control register 2";
        desc = "WDR_LONG_CTRL2 is WDR long exposure control register 2. Hi3516A V200 Professional HD IP Camera SoC

Data sheet 10.6 WDR_LONG_CTRL2 (offset 0x202A8, printed page 10-152, `hi3516av200--Hi3516AV200-Datasheet.txt` line 73855).";

        field {
            name = "long_stitch_correct";
            desc = "Adjustable error range of the sensor exposure ratio for the blending region, 1.7-bit unsigned fixed-point number";
            sw = rw;
            hw = r;
            reset = 0x80;
        } long_stitch_correct[23:16];

        field {
            name = "long_stitch_error_thresh";
            desc = "Detection of the strength of the stitching error caused by motion";
            sw = rw;
            hw = r;
            reset = 0x40;
        } long_stitch_error_thresh[7:0];
    } WDR_LONG_CTRL2 @ 0x102A8;

    reg {
        name = "WDR long exposure strength configuration register";
        desc = "WDR_LONG_STITCH_ERROR_LIMIT is a WDR long exposure strength configuration register.

Data sheet 10.6 WDR_LONG_STITCH_ERROR_LIMIT (offset 0x202AC, printed page 10-152, `hi3516av200--Hi3516AV200-Datasheet.txt` line 73882).";

        field {
            name = "long_stitch_error_limit";
            desc = "Long exposure strength. The detection of the stitching error that is below this strength is disabled.";
            sw = rw;
            hw = r;
            reset = 0x2000;
        } long_stitch_error_limit[19:0];
    } WDR_LONG_STITCH_ERROR_LIMIT @ 0x102AC;

    reg {
        name = "WDR medium exposure control register 1";
        desc = "WDR_MED_CTRL1 is WDR medium exposure control register 1. Hi3516A V200 Professional HD IP Camera SoC

Data sheet 10.6 WDR_MED_CTRL1 (offset 0x202B0, printed page 10-153, `hi3516av200--Hi3516AV200-Datasheet.txt` line 73913).";

        field {
            name = "med_short_thresh";
            desc = "Threshold. Data above this threshold is obtained from a shorter exposure range.";
            sw = rw;
            hw = r;
            reset = 0xF00;
        } med_short_thresh[27:16];

        field {
            name = "rsvd2";
            desc = "Not configurable";
            sw = rw;
            hw = r;
            reset = 0x6;
        } rsvd2[15:13];

        field {
            name = "rsvd1";
            desc = "Not configurable";
            sw = rw;
            hw = r;
            reset = 0x0;
        } rsvd1[5:5];

        field {
            name = "rsvd0";
            desc = "Not configurable";
            sw = rw;
            hw = r;
            reset = 0x0;
        } rsvd0[1:1];
    } WDR_MED_CTRL1 @ 0x102B0;

    reg {
        name = "WDR medium exposure control register 2";
        desc = "WDR_MED_CTRL2 is WDR medium exposure control register 2.

Data sheet 10.6 WDR_MED_CTRL2 (offset 0x202B4, printed page 10-153, `hi3516av200--Hi3516AV200-Datasheet.txt` line 73943).";

        field {
            name = "med_exposure_ratio";
            desc = "Exposure ratio, 6.6-bit unsigned fixed-point number";
            sw = rw;
            hw = r;
            reset = 0x100;
        } med_exposure_ratio[27:16];

        field {
            name = "med_long_thresh";
            desc = "Threshold. Data below this threshold is obtained from a longer exposure range.";
            sw = rw;
            hw = r;
            reset = 0xC00;
        } med_long_thresh[11:0];
    } WDR_MED_CTRL2 @ 0x102B4;

    reg {
        name = "WDR medium exposure control register 3";
        desc = "WDR_MED_CTRL3 is WDR medium exposure control register 3.

Data sheet 10.6 WDR_MED_CTRL3 (offset 0x202B8, printed page 10-154, `hi3516av200--Hi3516AV200-Datasheet.txt` line 73974).";

        field {
            name = "med_stitch_correct";
            desc = "Adjustable error range of the sensor exposure ratio for the blending region, 1.7-bit unsigned fixed-point number";
            sw = rw;
            hw = r;
            reset = 0x80;
        } med_stitch_correct[23:16];

        field {
            name = "med_stitch_error_thresh";
            desc = "Detection of the strength of the stitching error caused by motion";
            sw = rw;
            hw = r;
            reset = 0x40;
        } med_stitch_error_thresh[7:0];
    } WDR_MED_CTRL3 @ 0x102B8;

    reg {
        name = "WDR Medium exposure strength configuration register";
        desc = "WDR_MED_STITCH_ERROR_LIMIT is a WDR Medium exposure strength configuration register.

Data sheet 10.6 WDR_MED_STITCH_ERROR_LIMIT (offset 0x202BC, printed page 10-154, `hi3516av200--Hi3516AV200-Datasheet.txt` line 74001).";

        field {
            name = "med_stitch_error_limit";
            desc = "Medium exposure strength. The detection of the stitching error that is below this strength is disabled.";
            sw = rw;
            hw = r;
            reset = 0x2000;
        } med_stitch_error_limit[19:0];
    } WDR_MED_STITCH_ERROR_LIMIT @ 0x102BC;

    reg {
        name = "WDR short exposure control register 1";
        desc = "WDR_SHORT_CTRL1 is WDR short exposure control register 1. Hi3516A V200 Professional HD IP Camera SoC

Data sheet 10.6 WDR_SHORT_CTRL1 (offset 0x202C0, printed page 10-155, `hi3516av200--Hi3516AV200-Datasheet.txt` line 74032).";

        field {
            name = "short_short_thresh";
            desc = "Threshold. Data above this threshold is obtained from a shorter exposure range.";
            sw = rw;
            hw = r;
            reset = 0xF00;
        } short_short_thresh[27:16];

        field {
            name = "rsvd2";
            desc = "Not configurable";
            sw = rw;
            hw = r;
            reset = 0x6;
        } rsvd2[15:13];

        field {
            name = "rsvd1";
            desc = "Not configurable";
            sw = rw;
            hw = r;
            reset = 0x0;
        } rsvd1[5:5];

        field {
            name = "rsvd0";
            desc = "Not configurable";
            sw = rw;
            hw = r;
            reset = 0x0;
        } rsvd0[1:1];
    } WDR_SHORT_CTRL1 @ 0x102C0;

    reg {
        name = "WDR short exposure control register 2";
        desc = "WDR_SHORT_CTRL2 is WDR short exposure control register 2.

Data sheet 10.6 WDR_SHORT_CTRL2 (offset 0x202C4, printed page 10-155, `hi3516av200--Hi3516AV200-Datasheet.txt` line 74062).";

        field {
            name = "short_exposure_ratio";
            desc = "Exposure ratio, 6.6-bit unsigned fixed-point number";
            sw = rw;
            hw = r;
            reset = 0x100;
        } short_exposure_ratio[27:16];

        field {
            name = "short_long_thresh";
            desc = "Threshold. Data below this threshold is obtained from a longer exposure range.";
            sw = rw;
            hw = r;
            reset = 0xC00;
        } short_long_thresh[11:0];
    } WDR_SHORT_CTRL2 @ 0x102C4;

    reg {
        name = "WDR short exposure control register 3";
        desc = "WDR_SHORT_CTRL3 is WDR short exposure control register 3. [check] The data-sheet table extraction produced overlapping bit fields for this register; the overlapping entries short_stitch_error_limit[19:0] were dropped - verify against the printed page.

Data sheet 10.6 WDR_SHORT_CTRL3 (offset 0x202C8, printed page 10-156, `hi3516av200--Hi3516AV200-Datasheet.txt` line 74093).";

        field {
            name = "short_stitch_correct";
            desc = "Adjustable error range of the sensor exposure ratio for the blending region, 1.7-bit unsigned fixed-point number";
            sw = rw;
            hw = r;
            reset = 0x80;
        } short_stitch_correct[23:16];

        field {
            name = "short_stitch_error_thresh";
            desc = "Detection of the strength of the stitching error caused by motion";
            sw = rw;
            hw = r;
            reset = 0x40;
        } short_stitch_error_thresh[7:0];
    } WDR_SHORT_CTRL3 @ 0x102C8;

    reg {
        name = "WDR long exposure input black level register";
        desc = "WDR_BLACK_LEVEL_LONG is a WDR long exposure input black level register. Hi3516A V200 Professional HD IP Camera SoC

Data sheet 10.6 WDR_BLACK_LEVEL_LONG (offset 0x202D0, printed page 10-157, `hi3516av200--Hi3516AV200-Datasheet.txt` line 74154).";

        field {
            name = "black_level_long";
            desc = "Black level of the input long exposure frame";
            sw = rw;
            hw = r;
            reset = 0x0;
        } black_level_long[11:0];
    } WDR_BLACK_LEVEL_LONG @ 0x102D0;

    reg {
        name = "WDR medium exposure input black level register 1";
        desc = "WDR_BLACK_LEVEL_MEDIUM1 is WDR medium exposure input black level register 1.

Data sheet 10.6 WDR_BLACK_LEVEL_MEDIUM1 (offset 0x202D4, printed page 10-157, `hi3516av200--Hi3516AV200-Datasheet.txt` line 74174).";

        field {
            name = "black_level_medium1";
            desc = "Black level of the input medium exposure frame";
            sw = rw;
            hw = r;
            reset = 0x0;
        } black_level_medium1[11:0];
    } WDR_BLACK_LEVEL_MEDIUM1 @ 0x102D4;

    reg {
        name = "WDR medium exposure input black level register 2";
        desc = "WDR_BLACK_LEVEL_MEDIUM2 is WDR medium exposure input black level register 2.

Data sheet 10.6 WDR_BLACK_LEVEL_MEDIUM2 (offset 0x202D8, printed page 10-157, `hi3516av200--Hi3516AV200-Datasheet.txt` line 74195).";

        field {
            name = "black_level_medium2";
            desc = "Black level of the input medium exposure frame";
            sw = rw;
            hw = r;
            reset = 0x0;
        } black_level_medium2[11:0];
    } WDR_BLACK_LEVEL_MEDIUM2 @ 0x102D8;

    reg {
        name = "WDR short exposure input black level register";
        desc = "WDR_BLACK_LEVEL_SHORT is a WDR short exposure input black level register.

Data sheet 10.6 WDR_BLACK_LEVEL_SHORT (offset 0x202DC, printed page 10-158, `hi3516av200--Hi3516AV200-Datasheet.txt` line 74225).";

        field {
            name = "black_level_short";
            desc = "Black level of the input short exposure frame";
            sw = rw;
            hw = r;
            reset = 0x0;
        } black_level_short[11:0];
    } WDR_BLACK_LEVEL_SHORT @ 0x102DC;

    reg {
        name = "WDR module output black level register";
        desc = "WDR_BLACK_LEVEL_OUT is a WDR module output black level register.

Data sheet 10.6 WDR_BLACK_LEVEL_OUT (offset 0x202E0, printed page 10-158, `hi3516av200--Hi3516AV200-Datasheet.txt` line 74244).";

        field {
            name = "black_level_out";
            desc = "Module output black level";
            sw = rw;
            hw = r;
            reset = 0x0;
        } black_level_out[19:0];
    } WDR_BLACK_LEVEL_OUT @ 0x102E0;

    reg {
        name = "WDR input mode selection register";
        desc = "WDR_MODE_IN is a WDR input mode selection register. Hi3516A V200 Professional HD IP Camera SoC

Data sheet 10.6 WDR_MODE_IN (offset 0x202E4, printed page 10-159, `hi3516av200--Hi3516AV200-Datasheet.txt` line 74273).";

        enum WDR_MODE_IN_mode_in_enum {
            V_4_CHANNEL_INPUT = 0 { name = "V 4 Channel Input"; desc = "4-channel input"; };
            V_2_CHANNEL_INPUT = 1 { name = "V 2 Channel Input"; desc = "2-channel input"; };
            V_3_CHANNEL_INPUT = 2 { name = "V 3 Channel Input"; desc = "3-channel input"; };
            V_4_CHANNEL_INPUT_2 = 3 { name = "V 4 Channel Input 2"; desc = "4-channel input"; };
        };

        field {
            name = "mode_in";
            desc = "WDR input mode select";
            sw = rw;
            hw = r;
            encode = WDR_MODE_IN_mode_in_enum;
            reset = 0x0;
        } mode_in[1:0];
    } WDR_MODE_IN @ 0x102E4;

    reg {
        name = "FRONTEND_LUT control register";
        desc = "FRONTEND_LUT_CTRL is a FRONTEND_LUT control register.

Data sheet 10.6 FRONTEND_LUT_CTRL (offset 0x20300, printed page 10-159, `hi3516av200--Hi3516AV200-Datasheet.txt` line 74301).";

        enum FRONTEND_LUT_CTRL_mcu_priority_enum {
            LOW = 0 { name = "Low"; desc = "low"; };
            HIGH = 1 { name = "High"; desc = "high"; };
        };

        field {
            name = "mcu_priority";
            desc = "CPU port priority";
            sw = rw;
            hw = r;
            encode = FRONTEND_LUT_CTRL_mcu_priority_enum;
            reset = 0x0;
        } mcu_priority[31:31];

        field {
            name = "bank_select_1";
            desc = "Valid memory bank switching for LUT 1";
            sw = rw;
            hw = r;
            reset = 0x0;
        } bank_select_1[13:13];

        field {
            name = "bank_select_0";
            desc = "Valid memory bank switching for LUT 0";
            sw = rw;
            hw = r;
            reset = 0x0;
        } bank_select_0[12:12];

        enum FRONTEND_LUT_CTRL_offset_mode_1_enum {
            MANUAL_CURVE_MAPPING = 0 { name = "Manual Curve Mapping"; desc = "manual curve mapping mode"; };
            AUTOMATIC_CURVE_MAPPING = 1 { name = "Automatic Curve Mapping"; desc = "automatic curve mapping mode"; };
        };

        field {
            name = "offset_mode_1";
            desc = "Mapping mode of the black level offset region for LUT 1";
            sw = rw;
            hw = r;
            encode = FRONTEND_LUT_CTRL_offset_mode_1_enum;
            reset = 0x0;
        } offset_mode_1[9:9];

        enum FRONTEND_LUT_CTRL_offset_mode_0_enum {
            MANUAL_CURVE_MAPPING = 0 { name = "Manual Curve Mapping"; desc = "manual curve mapping mode"; };
            AUTOMATIC_CURVE_MAPPING = 1 { name = "Automatic Curve Mapping"; desc = "automatic curve mapping mode"; };
        };

        field {
            name = "offset_mode_0";
            desc = "Mapping mode of the black level offset region for LUT 0";
            sw = rw;
            hw = r;
            encode = FRONTEND_LUT_CTRL_offset_mode_0_enum;
            reset = 0x0;
        } offset_mode_0[8:8];

        enum FRONTEND_LUT_CTRL_enable_dl_enum {
            DISABLED = 0 { name = "Disabled"; desc = "disabled"; };
            ENABLED = 1 { name = "Enabled"; desc = "enabled"; };
        };

        field {
            name = "enable_dl";
            desc = "Front-end LUT DL enable";
            sw = rw;
            hw = r;
            encode = FRONTEND_LUT_CTRL_enable_dl_enum;
            reset = 0x0;
        } enable_dl[2:2];

        enum FRONTEND_LUT_CTRL_enable1_enum {
            DISABLED = 0 { name = "Disabled"; desc = "disabled"; };
            ENABLED = 1 { name = "Enabled"; desc = "enabled"; };
        };

        field {
            name = "enable1";
            desc = "Front-end LUT 1 enable";
            sw = rw;
            hw = r;
            encode = FRONTEND_LUT_CTRL_enable1_enum;
            reset = 0x0;
        } enable1[1:1];

        enum FRONTEND_LUT_CTRL_enable0_enum {
            DISABLED = 0 { name = "Disabled"; desc = "disabled"; };
            ENABLED = 1 { name = "Enabled"; desc = "enabled"; };
        };

        field {
            name = "enable0";
            desc = "Front-end LUT 0 enable";
            sw = rw;
            hw = r;
            encode = FRONTEND_LUT_CTRL_enable0_enum;
            reset = 0x0;
        } enable0[0:0];
    } FRONTEND_LUT_CTRL @ 0x10300;

    reg {
        name = "FRONTEND_LUT status indicator register";
        desc = "FRONTEND_LUT_MCU_READY is a FRONTEND_LUT status indicator register.

Data sheet 10.6 FRONTEND_LUT_MCU_READY (offset 0x20304, printed page 10-160, `hi3516av200--Hi3516AV200-Datasheet.txt` line 74358).";

        field {
            name = "mcu_ready_1";
            desc = "LUT 1 status indicator. If this bit is set to 1, LUT 1 is ready to receive data from the CPU.";
            sw = r;
            hw = w;
            reset = 0x1;
        } mcu_ready_1[1:1];

        field {
            name = "mcu_ready_0";
            desc = "LUT 0 status indicator. If this bit is set to 1, LUT 0 is ready to receive data from the CPU.";
            sw = r;
            hw = w;
            reset = 0x1;
        } mcu_ready_0[0:0];
    } FRONTEND_LUT_MCU_READY @ 0x10304;

    reg {
        name = "FRONTEND_LUT alpha parameter register";
        desc = "FRONTEND_LUT_ALPHA is a FRONTEND_LUT alpha parameter register.

Data sheet 10.6 FRONTEND_LUT_ALPHA (offset 0x20308, printed page 10-161, `hi3516av200--Hi3516AV200-Datasheet.txt` line 74396).";

        field {
            name = "alpha";
            desc = "Front-end alpha parameter, 6.12-bit fixed-point value";
            sw = rw;
            hw = r;
            reset = 0x1000;
        } alpha[17:0];
    } FRONTEND_LUT_ALPHA @ 0x10308;

    reg {
        name = "Sensor digital gain register";
        desc = "DG_GAIN is a sensor digital gain register.

Data sheet 10.6 DG_GAIN (offset 0x20310, printed page 10-161, `hi3516av200--Hi3516AV200-Datasheet.txt` line 74416).";

        field {
            name = "gain";
            desc = "Sensor digital gain, 5.8-bit unsigned number";
            sw = rw;
            hw = r;
            reset = 0x100;
        } gain[12:0];
    } DG_GAIN @ 0x10310;

    reg {
        name = "DG black level compensation register";
        desc = "DG_OFFSET is a DG black level compensation register.

Data sheet 10.6 DG_OFFSET (offset 0x20314, printed page 10-161, `hi3516av200--Hi3516AV200-Datasheet.txt` line 74435).";

        field {
            name = "offset";
            desc = "Black level compensation";
            sw = rw;
            hw = r;
            reset = 0x0;
        } offset[19:0];
    } DG_OFFSET @ 0x10314;

    reg {
        name = "DNR control register";
        desc = "DNR_CTRL is a DNR control register.

Data sheet 10.6 DNR_CTRL (offset 0x20320, printed page 10-162, `hi3516av200--Hi3516AV200-Datasheet.txt` line 74464).";

        field {
            name = "int_config";
            desc = "Strength blending with the unprocessed mosaic";
            sw = rw;
            hw = r;
            reset = 0x4;
        } int_config[11:8];

        enum DNR_CTRL_rm_enable_enum {
            DISABLED = 0 { name = "Disabled"; desc = "disabled"; };
            ENABLED = 1 { name = "Enabled"; desc = "enabled"; };
        };

        field {
            name = "rm_enable";
            desc = "LSC enable";
            sw = rw;
            hw = r;
            encode = DNR_CTRL_rm_enable_enum;
            reset = 0x0;
        } rm_enable[7:7];

        enum DNR_CTRL_int_select_enum {
            DISABLED = 0 { name = "Disabled"; desc = "disabled"; };
            ENABLED = 1 { name = "Enabled"; desc = "enabled"; };
        };

        field {
            name = "int_select";
            desc = "Strength filter select enable";
            sw = rw;
            hw = r;
            encode = DNR_CTRL_int_select_enum;
            reset = 0x0;
        } int_select[6:6];

        enum DNR_CTRL_filter_select_enum {
            DISABLED = 0 { name = "Disabled"; desc = "disabled"; };
            ENABLED = 1 { name = "Enabled"; desc = "enabled"; };
        };

        field {
            name = "filter_select";
            desc = "NR filter fine-tuning";
            sw = rw;
            hw = r;
            encode = DNR_CTRL_filter_select_enum;
            reset = 0x0;
        } filter_select[5:5];

        enum DNR_CTRL_enable_f_enum {
            DISABLED = 0 { name = "Disabled"; desc = "disabled"; };
            ENABLED = 1 { name = "Enabled"; desc = "enabled"; };
        };

        field {
            name = "enable";
            desc = "NR enable";
            sw = rw;
            hw = r;
            encode = DNR_CTRL_enable_f_enum;
            reset = 0x1;
        } enable_f[4:4];

        field {
            name = "rsvd";
            desc = "Not configurable";
            sw = rw;
            hw = r;
            reset = 0xC;
        } rsvd[3:0];
    } DNR_CTRL @ 0x10320;

    reg {
        name = "DNR shadow graph horizontal coordinate register";
        desc = "DNR_RM_CENTER_X is a DNR shadow graph horizontal coordinate register. Hi3516A V200 Professional HD IP Camera SoC

Data sheet 10.6 DNR_RM_CENTER_X (offset 0x20324, printed page 10-163, `hi3516av200--Hi3516AV200-Datasheet.txt` line 74513).";

        field {
            name = "rm_center_x";
            desc = "Horizontal coordinate of the shadow graph";
            sw = rw;
            hw = r;
            reset = 0x280;
        } rm_center_x[15:0];
    } DNR_RM_CENTER_X @ 0x10324;

    reg {
        name = "DNR shadow graph vertical coordinate register";
        desc = "DNR_RM_CENTER_Y is a DNR shadow graph vertical coordinate register.

Data sheet 10.6 DNR_RM_CENTER_Y (offset 0x20328, printed page 10-163, `hi3516av200--Hi3516AV200-Datasheet.txt` line 74533).";

        field {
            name = "rm_center_y";
            desc = "Vertical coordinate of the shadow graph";
            sw = rw;
            hw = r;
            reset = 0x168;
        } rm_center_y[15:0];
    } DNR_RM_CENTER_Y @ 0x10328;

    reg {
        name = "DNR normalized factor register";
        desc = "DNR_RM_OFF_CENTER_MULT is a DNR normalized factor register.

Data sheet 10.6 DNR_RM_OFF_CENTER_MULT (offset 0x2032C, printed page 10-163, `hi3516av200--Hi3516AV200-Datasheet.txt` line 74552).";

        field {
            name = "rm_off_center_mult";
            desc = "Normalized factor for extending the radial table to the picture edges. The normalized factor is calculated as follows: Normalized factor = 2 31 /R 2 (R indicates the furthest distance between the center coordinates and picture edge pixels)";
            sw = rw;
            hw = r;
            reset = 0x100;
        } rm_off_center_mult[15:0];
    } DNR_RM_OFF_CENTER_MULT @ 0x1032C;

    reg {
        name = "DNR noise threshold register at horizontal spatial-domain high frequencies";
        desc = "DNR_THRESH_H01 is a DNR noise threshold register at horizontal spatial-domain high frequencies.

Data sheet 10.6 DNR_THRESH_H01 (offset 0x20330, printed page 10-164, `hi3516av200--Hi3516AV200-Datasheet.txt` line 74584).";

        field {
            name = "thresh_1h";
            desc = "Noise threshold at horizontal spatial-domain high frequencies";
            sw = rw;
            hw = r;
            reset = 0x0;
        } thresh_1h[23:16];
    } DNR_THRESH_H01 @ 0x10330;

    reg {
        name = "DNR noise threshold register at horizontal spatial-domain low frequencies";
        desc = "DNR_THRESH_H24 is a DNR noise threshold register at horizontal spatial-domain low frequencies.

Data sheet 10.6 DNR_THRESH_H24 (offset 0x20334, printed page 10-164, `hi3516av200--Hi3516AV200-Datasheet.txt` line 74605).";

        field {
            name = "thresh_4h";
            desc = "Noise threshold at horizontal spatial-domain low frequencies";
            sw = rw;
            hw = r;
            reset = 0x0;
        } thresh_4h[23:16];
    } DNR_THRESH_H24 @ 0x10334;

    reg {
        name = "DNR noise threshold register at vertical spatial-domain high frequencies";
        desc = "DNR_THRESH_V01 is a DNR noise threshold register at vertical spatial-domain high frequencies. Hi3516A V200 Professional HD IP Camera SoC

Data sheet 10.6 DNR_THRESH_V01 (offset 0x20338, printed page 10-165, `hi3516av200--Hi3516AV200-Datasheet.txt` line 74636).";

        field {
            name = "thresh_1v";
            desc = "Noise threshold at vertical spatial-domain high frequencies";
            sw = rw;
            hw = r;
            reset = 0x0;
        } thresh_1v[23:16];
    } DNR_THRESH_V01 @ 0x10338;

    reg {
        name = "DNR noise threshold register at vertical spatial-domain low frequencies";
        desc = "DNR_THRESH_V24 is a DNR noise threshold register at vertical spatial-domain low frequencies.

Data sheet 10.6 DNR_THRESH_V24 (offset 0x2033C, printed page 10-165, `hi3516av200--Hi3516AV200-Datasheet.txt` line 74658).";

        field {
            name = "thresh_4v";
            desc = "Noise threshold at vertical spatial-domain low frequencies";
            sw = rw;
            hw = r;
            reset = 0x0;
        } thresh_4v[23:16];
    } DNR_THRESH_V24 @ 0x1033C;

    reg {
        name = "DNR noise threshold adjustment register for short exposure data";
        desc = "DNR_THRESH_SHORT is a DNR noise threshold adjustment register for short exposure data. Hi3516A V200 Professional HD IP Camera SoC

Data sheet 10.6 DNR_THRESH_SHORT (offset 0x20344, printed page 10-166, `hi3516av200--Hi3516AV200-Datasheet.txt` line 74688).";

        field {
            name = "thresh_short";
            desc = "Noise threshold adjustment for short exposure data";
            sw = rw;
            hw = r;
            reset = 0x0;
        } thresh_short[7:0];
    } DNR_THRESH_SHORT @ 0x10344;

    reg {
        name = "DNR noise threshold adjustment register for long exposure data";
        desc = "DNR_THRESH_LONG is a DNR noise threshold adjustment register for long exposure data.

Data sheet 10.6 DNR_THRESH_LONG (offset 0x20348, printed page 10-166, `hi3516av200--Hi3516AV200-Datasheet.txt` line 74708).";

        field {
            name = "thresh_long";
            desc = "Noise threshold adjustment for long exposure data";
            sw = rw;
            hw = r;
            reset = 0x30;
        } thresh_long[7:0];
    } DNR_THRESH_LONG @ 0x10348;

    reg {
        name = "DNR noise suppression effect register for high spatial frequencies";
        desc = "DNR_STRENGTH1 is a DNR noise suppression effect register for high spatial frequencies.

Data sheet 10.6 DNR_STRENGTH1 (offset 0x20350, printed page 10-166, `hi3516av200--Hi3516AV200-Datasheet.txt` line 74727).";

        field {
            name = "strength_1";
            desc = "Noise suppression effect of high spatial frequencies";
            sw = rw;
            hw = r;
            reset = 0xFF;
        } strength_1[7:0];
    } DNR_STRENGTH1 @ 0x10350;

    reg {
        name = "DNR noise suppression effect register for low spatial frequencies";
        desc = "DNR_STRENGTH4 is a DNR noise suppression effect register for low spatial frequencies.

Data sheet 10.6 DNR_STRENGTH4 (offset 0x20358, printed page 10-167, `hi3516av200--Hi3516AV200-Datasheet.txt` line 74753).";

        field {
            name = "strength_4";
            desc = "Noise suppression effect of low spatial frequencies";
            sw = rw;
            hw = r;
            reset = 0xFF;
        } strength_4[7:0];
    } DNR_STRENGTH4 @ 0x10358;

    reg {
        name = "BACKEND_LUT control register";
        desc = "BACKEND_LUT_CRTL is a BACKEND_LUT control register.

Data sheet 10.6 BACKEND_LUT_CRTL (offset 0x20360, printed page 10-167, `hi3516av200--Hi3516AV200-Datasheet.txt` line 74773).";

        enum BACKEND_LUT_CRTL_mcu_priority_enum {
            LOW = 0 { name = "Low"; desc = "low"; };
            HIGH = 1 { name = "High"; desc = "high"; };
        };

        field {
            name = "mcu_priority";
            desc = "CPU port priority";
            sw = rw;
            hw = r;
            encode = BACKEND_LUT_CRTL_mcu_priority_enum;
            reset = 0x0;
        } mcu_priority[31:31];

        enum BACKEND_LUT_CRTL_bank_select_1_enum {
            MEMORY_BANK_0 = 0 { name = "Memory Bank 0"; desc = "memory bank 0"; };
            MEMORY_BANK_1 = 1 { name = "Memory Bank 1"; desc = "memory bank 1"; };
        };

        field {
            name = "bank_select_1";
            desc = "Memory bank select for LUT 1";
            sw = rw;
            hw = r;
            encode = BACKEND_LUT_CRTL_bank_select_1_enum;
            reset = 0x0;
        } bank_select_1[13:13];

        enum BACKEND_LUT_CRTL_bank_select_0_enum {
            MEMORY_BANK_0 = 0 { name = "Memory Bank 0"; desc = "memory bank 0"; };
            MEMORY_BANK_1 = 1 { name = "Memory Bank 1"; desc = "memory bank 1"; };
        };

        field {
            name = "bank_select_0";
            desc = "Memory bank select for LUT 0";
            sw = rw;
            hw = r;
            encode = BACKEND_LUT_CRTL_bank_select_0_enum;
            reset = 0x0;
        } bank_select_0[12:12];

        enum BACKEND_LUT_CRTL_offset_mode_1_enum {
            MANUAL_CURVE_MAPPING = 0 { name = "Manual Curve Mapping"; desc = "manual curve mapping mode"; };
            AUTOMATIC_CURVE_MAPPING = 1 { name = "Automatic Curve Mapping"; desc = "automatic curve mapping mode"; };
        };

        field {
            name = "offset_mode_1";
            desc = "Mapping mode of the black level offset region for LUT 1";
            sw = rw;
            hw = r;
            encode = BACKEND_LUT_CRTL_offset_mode_1_enum;
            reset = 0x0;
        } offset_mode_1[9:9];

        enum BACKEND_LUT_CRTL_offset_mode_0_enum {
            MANUAL_CURVE_MAPPING = 0 { name = "Manual Curve Mapping"; desc = "manual curve mapping mode"; };
            AUTOMATIC_CURVE_MAPPING = 1 { name = "Automatic Curve Mapping"; desc = "automatic curve mapping mode"; };
        };

        field {
            name = "offset_mode_0";
            desc = "Mapping mode of the black level offset region for LUT 0";
            sw = rw;
            hw = r;
            encode = BACKEND_LUT_CRTL_offset_mode_0_enum;
            reset = 0x0;
        } offset_mode_0[8:8];

        enum BACKEND_LUT_CRTL_enable_dl_enum {
            DISABLED = 0 { name = "Disabled"; desc = "disabled"; };
            ENABLED = 1 { name = "Enabled"; desc = "enabled"; };
        };

        field {
            name = "enable_dl";
            desc = "Back-end LUT DL enable";
            sw = rw;
            hw = r;
            encode = BACKEND_LUT_CRTL_enable_dl_enum;
            reset = 0x0;
        } enable_dl[2:2];

        enum BACKEND_LUT_CRTL_enable1_enum {
            DISABLED = 0 { name = "Disabled"; desc = "disabled"; };
            ENABLED = 1 { name = "Enabled"; desc = "enabled"; };
        };

        field {
            name = "enable1";
            desc = "Back-end LUT 1 enable";
            sw = rw;
            hw = r;
            encode = BACKEND_LUT_CRTL_enable1_enum;
            reset = 0x0;
        } enable1[1:1];

        enum BACKEND_LUT_CRTL_enable0_enum {
            DISABLED = 0 { name = "Disabled"; desc = "disabled"; };
            ENABLED = 1 { name = "Enabled"; desc = "enabled"; };
        };

        field {
            name = "enable0";
            desc = "Back-end LUT 0 enable";
            sw = rw;
            hw = r;
            encode = BACKEND_LUT_CRTL_enable0_enum;
            reset = 0x0;
        } enable0[0:0];
    } BACKEND_LUT_CRTL @ 0x10360;

    reg {
        name = "BACKEND_LUT status indicator register";
        desc = "BACKEND_LUT_MCU_READY is a BACKEND_LUT status indicator register.

Data sheet 10.6 BACKEND_LUT_MCU_READY (offset 0x20364, printed page 10-168, `hi3516av200--Hi3516AV200-Datasheet.txt` line 74835).";

        field {
            name = "mcu_ready_1";
            desc = "LUT 1 status indicator. If this bit is set to 1, LUT 1 is ready to receive data from the CPU.";
            sw = r;
            hw = w;
            reset = 0x1;
        } mcu_ready_1[1:1];

        field {
            name = "mcu_ready_0";
            desc = "LUT 0 status indicator. If this bit is set to 1, LUT 0 is ready to receive data from the CPU.";
            sw = r;
            hw = w;
            reset = 0x1;
        } mcu_ready_0[0:0];
    } BACKEND_LUT_MCU_READY @ 0x10364;

    reg {
        name = "BACKEND_LUT alpha parameter register";
        desc = "BACKEND_LUT_ALPHA is a BACKEND_LUT alpha parameter register.

Data sheet 10.6 BACKEND_LUT_ALPHA (offset 0x20368, printed page 10-169, `hi3516av200--Hi3516AV200-Datasheet.txt` line 74872).";

        field {
            name = "alpha";
            desc = "Front-end alpha parameter, 6.12-bit fixed-point value";
            sw = rw;
            hw = r;
            reset = 0x1000;
        } alpha[17:0];
    } BACKEND_LUT_ALPHA @ 0x10368;

    reg {
        name = "NP_FOR_DNR noise threshold register";
        desc = "NP_FOR_DNR_EXP_THRESH is an NP_FOR_DNR noise threshold register.

Data sheet 10.6 NP_FOR_DNR_EXP_THRESH (offset 0x20370, printed page 10-169, `hi3516av200--Hi3516AV200-Datasheet.txt` line 74892).";

        field {
            name = "exp_thresh";
            desc = "Threshold of the long/short exposure data";
            sw = rw;
            hw = r;
            reset = 0xFFFF;
        } exp_thresh[15:0];
    } NP_FOR_DNR_EXP_THRESH @ 0x10370;

    reg {
        name = "NP_FOR_DNR noise short exposure ratio register";
        desc = "NP_FOR_DNR_SHORT_RATIO is an NP_FOR_DNR noise short exposure ratio register.

Data sheet 10.6 NP_FOR_DNR_SHORT_RATIO (offset 0x20374, printed page 10-169, `hi3516av200--Hi3516AV200-Datasheet.txt` line 74911).";

        field {
            name = "short_ratio";
            desc = "Short exposure noise ratio, 6.2-bit unsigned fixed-point number";
            sw = rw;
            hw = r;
            reset = 0x20;
        } short_ratio[7:0];
    } NP_FOR_DNR_SHORT_RATIO @ 0x10374;

    reg {
        name = "NP_FOR_DNR noise long exposure ratio register";
        desc = "NP_FOR_DNR_LONG_RATIO is an NP_FOR_DNR noise long exposure ratio register.

Data sheet 10.6 NP_FOR_DNR_LONG_RATIO (offset 0x20378, printed page 10-170, `hi3516av200--Hi3516AV200-Datasheet.txt` line 74940).";

        field {
            name = "long_ratio";
            desc = "Long exposure noise ratio, 6.2-bit unsigned fixed-point number";
            sw = rw;
            hw = r;
            reset = 0x4;
        } long_ratio[7:0];
    } NP_FOR_DNR_LONG_RATIO @ 0x10378;

    reg {
        name = "NP_FOR_DNR noise black level offset register";
        desc = "NP_FOR_DNR_OFF is an NP_FOR_DNR noise black level offset register.

Data sheet 10.6 NP_FOR_DNR_OFF (offset 0x2037C, printed page 10-170, `hi3516av200--Hi3516AV200-Datasheet.txt` line 74960).";

        enum NP_FOR_DNR_OFF_np_off_reflect_enum {
            INPUT_FIRST_TABLE = 0 { name = "Input First Table"; desc = "The input of the first table is repeated."; };
            PART_BELOW_BLACK = 1 { name = "Part Below Black"; desc = "The part below the black level on the noise curve is mapped."; };
        };

        field {
            name = "np_off_reflect";
            desc = "Method of obtaining values below the black level";
            sw = rw;
            hw = r;
            encode = NP_FOR_DNR_OFF_np_off_reflect_enum;
            reset = 0x0;
        } np_off_reflect[7:7];

        field {
            name = "np_off";
            desc = "Noise black level offset";
            sw = rw;
            hw = r;
            reset = 0x0;
        } np_off[6:0];
    } NP_FOR_DNR_OFF @ 0x1037C;

    reg {
        name = "WB module R component gain register";
        desc = "WB_GAIN00 is a WB module R component gain register.

Data sheet 10.6 WB_GAIN00 (offset 0x20380, printed page 10-171, `hi3516av200--Hi3516AV200-Datasheet.txt` line 74995).";

        field {
            name = "gain00";
            desc = "Multiple of color channel R, 4.8-bit unsigned fixed-point number";
            sw = rw;
            hw = r;
            reset = 0x100;
        } gain00[11:0];
    } WB_GAIN00 @ 0x10380;

    reg {
        name = "WB module Gr component gain register";
        desc = "WB_GAIN01 is a WB module Gr component gain register.

Data sheet 10.6 WB_GAIN01 (offset 0x20384, printed page 10-171, `hi3516av200--Hi3516AV200-Datasheet.txt` line 75015).";

        field {
            name = "gain01";
            desc = "Multiple of color channel Gr, 4.8-bit unsigned fixed-point number";
            sw = rw;
            hw = r;
            reset = 0x100;
        } gain01[11:0];
    } WB_GAIN01 @ 0x10384;

    reg {
        name = "WB module Gb component gain register";
        desc = "WB_GAIN10 is a WB module Gb component gain register.

Data sheet 10.6 WB_GAIN10 (offset 0x20388, printed page 10-171, `hi3516av200--Hi3516AV200-Datasheet.txt` line 75034).";

        field {
            name = "gain10";
            desc = "Multiple of color channel Gb, 4.8-bit unsigned fixed-point number";
            sw = rw;
            hw = r;
            reset = 0x100;
        } gain10[11:0];
    } WB_GAIN10 @ 0x10388;

    reg {
        name = "WB module B component gain register";
        desc = "WB_GAIN11 is a WB module B component gain register.

Data sheet 10.6 WB_GAIN11 (offset 0x2038C, printed page 10-172, `hi3516av200--Hi3516AV200-Datasheet.txt` line 75063).";

        field {
            name = "gain11";
            desc = "Multiple of color channel B, 4.8-bit unsigned fixed-point number";
            sw = rw;
            hw = r;
            reset = 0x100;
        } gain11[11:0];
    } WB_GAIN11 @ 0x1038C;

    reg {
        name = "BLC R component black level offset register";
        desc = "BLC_BLACK00 is a BLC R component black level offset register.

Data sheet 10.6 BLC_BLACK00 (offset 0x203A0, printed page 10-172, `hi3516av200--Hi3516AV200-Datasheet.txt` line 75083).";

        field {
            name = "black00";
            desc = "Black level offset of color channel R";
            sw = rw;
            hw = r;
            reset = 0x0;
        } black00[19:0];
    } BLC_BLACK00 @ 0x103A0;

    reg {
        name = "BLC Gr component black level offset register";
        desc = "BLC_BLACK01 is a BLC Gr component black level offset register. Hi3516A V200 Professional HD IP Camera SoC

Data sheet 10.6 BLC_BLACK01 (offset 0x203A4, printed page 10-173, `hi3516av200--Hi3516AV200-Datasheet.txt` line 75111).";

        field {
            name = "black01";
            desc = "Black level offset of color channel Gr";
            sw = rw;
            hw = r;
            reset = 0x0;
        } black01[19:0];
    } BLC_BLACK01 @ 0x103A4;

    reg {
        name = "BLC Gb component black level offset register";
        desc = "BLC_BLACK10 is a BLC Gb component black level offset register.

Data sheet 10.6 BLC_BLACK10 (offset 0x203A8, printed page 10-173, `hi3516av200--Hi3516AV200-Datasheet.txt` line 75131).";

        field {
            name = "black10";
            desc = "Black level offset of color channel Gb";
            sw = rw;
            hw = r;
            reset = 0x0;
        } black10[19:0];
    } BLC_BLACK10 @ 0x103A8;

    reg {
        name = "BLC B component black level offset register";
        desc = "BLC_BLACK11 is a BLC B component black level offset register.

Data sheet 10.6 BLC_BLACK11 (offset 0x203AC, printed page 10-173, `hi3516av200--Hi3516AV200-Datasheet.txt` line 75150).";

        field {
            name = "black11";
            desc = "Black level offset of color channel B";
            sw = rw;
            hw = r;
            reset = 0x0;
        } black11[19:0];
    } BLC_BLACK11 @ 0x103AC;

    reg {
        name = "Radial_Shading module control register";
        desc = "RADIAL_SHADING_CTRL is a Radial_Shading module control register.

Data sheet 10.6 RADIAL_SHADING_CTRL (offset 0x203B0, printed page 10-174, `hi3516av200--Hi3516AV200-Datasheet.txt` line 75176).";

        enum RADIAL_SHADING_CTRL_mcupriority_enum {
            LOW = 0 { name = "Low"; desc = "low"; };
            HIGH = 1 { name = "High"; desc = "high"; };
        };

        field {
            name = "mcupriority";
            desc = "CPU write priority of the radial shading LUTs";
            sw = rw;
            hw = r;
            encode = RADIAL_SHADING_CTRL_mcupriority_enum;
            reset = 0x0;
        } mcupriority[7:7];

        enum RADIAL_SHADING_CTRL_enable_f_enum {
            DISABLED = 0 { name = "Disabled"; desc = "disabled"; };
            ENABLED = 1 { name = "Enabled"; desc = "enabled"; };
        };

        field {
            name = "enable";
            desc = "LSC enable";
            sw = rw;
            hw = r;
            encode = RADIAL_SHADING_CTRL_enable_f_enum;
            reset = 0x0;
        } enable_f[0:0];
    } RADIAL_SHADING_CTRL @ 0x103B0;

    reg {
        name = "Radial_Shading LUT status register";
        desc = "RADIAL_SHADING_MCU_READY is a Radial_Shading LUT status register.

Data sheet 10.6 RADIAL_SHADING_MCU_READY (offset 0x203B4, printed page 10-174, `hi3516av200--Hi3516AV200-Datasheet.txt` line 75208).";

        field {
            name = "mcuready";
            desc = "If this bit is set to 1, the LUT is ready to receive data from the CPU.";
            sw = r;
            hw = w;
            reset = 0x1;
        } mcuready[0:0];
    } RADIAL_SHADING_MCU_READY @ 0x103B4;

    reg {
        name = "Radial_Shading R component center X coordinate register";
        desc = "RADIAL_SHADING_RX is a Radial_Shading R component center X coordinate register.

Data sheet 10.6 RADIAL_SHADING_RX (offset 0x203B8, printed page 10-175, `hi3516av200--Hi3516AV200-Datasheet.txt` line 75243).";

        field {
            name = "centerr_x";
            desc = "Horizontal coordinate of the center of the red shading map";
            sw = rw;
            hw = r;
            reset = 0x3C0;
        } centerr_x[15:0];
    } RADIAL_SHADING_RX @ 0x103B8;

    reg {
        name = "Radial_Shading R component center Y coordinate register";
        desc = "RADIAL_SHADING_RY is a Radial_Shading R component center Y coordinate register.

Data sheet 10.6 RADIAL_SHADING_RY (offset 0x203BC, printed page 10-175, `hi3516av200--Hi3516AV200-Datasheet.txt` line 75262).";

        field {
            name = "centerr_y";
            desc = "Vertical coordinate of the center of the red shading map";
            sw = rw;
            hw = r;
            reset = 0x21C;
        } centerr_y[15:0];
    } RADIAL_SHADING_RY @ 0x103BC;

    reg {
        name = "Radial_Shading G component center X coordinate register";
        desc = "RADIAL_SHADING_GX is a Radial_Shading G component center X coordinate register. Hi3516A V200 Professional HD IP Camera SoC

Data sheet 10.6 RADIAL_SHADING_GX (offset 0x203C0, printed page 10-176, `hi3516av200--Hi3516AV200-Datasheet.txt` line 75291).";

        field {
            name = "centerg_x";
            desc = "Horizontal coordinate of the center of the green shading map";
            sw = rw;
            hw = r;
            reset = 0x3C0;
        } centerg_x[15:0];
    } RADIAL_SHADING_GX @ 0x103C0;

    reg {
        name = "Radial_Shading G component center Y coordinate register";
        desc = "RADIAL_SHADING_GY is a Radial_Shading G component center Y coordinate register.

Data sheet 10.6 RADIAL_SHADING_GY (offset 0x203C4, printed page 10-176, `hi3516av200--Hi3516AV200-Datasheet.txt` line 75311).";

        field {
            name = "centerg_y";
            desc = "Vertical coordinate of the center of the green shading map";
            sw = rw;
            hw = r;
            reset = 0x21C;
        } centerg_y[15:0];
    } RADIAL_SHADING_GY @ 0x103C4;

    reg {
        name = "Radial_Shading B component center X coordinate register";
        desc = "RADIAL_SHADING_BX is a Radial_Shading B component center X coordinate register.

Data sheet 10.6 RADIAL_SHADING_BX (offset 0x203C8, printed page 10-176, `hi3516av200--Hi3516AV200-Datasheet.txt` line 75330).";

        field {
            name = "centerb_x";
            desc = "Horizontal coordinate of the center of the blue shading map";
            sw = rw;
            hw = r;
            reset = 0x3C0;
        } centerb_x[15:0];
    } RADIAL_SHADING_BX @ 0x103C8;

    reg {
        name = "Radial_Shading B component center Y coordinate register";
        desc = "RADIAL_SHADING_BY is a Radial_Shading B component center Y coordinate register.

Data sheet 10.6 RADIAL_SHADING_BY (offset 0x203CC, printed page 10-177, `hi3516av200--Hi3516AV200-Datasheet.txt` line 75356).";

        field {
            name = "centerb_y";
            desc = "Vertical coordinate of the center of the blue shading map";
            sw = rw;
            hw = r;
            reset = 0x21C;
        } centerb_y[15:0];
    } RADIAL_SHADING_BY @ 0x103CC;

    reg {
        name = "Radial_Shading red radial table normalized factor register";
        desc = "RADIAL_SHADING_MULTR is a Radial_Shading red radial table normalized factor register.

Data sheet 10.6 RADIAL_SHADING_MULTR (offset 0x203D0, printed page 10-177, `hi3516av200--Hi3516AV200-Datasheet.txt` line 75376).";

        field {
            name = "off_center_multr";
            desc = "Normalized factor for extending the red radial table to the picture edges. The normalized factor is calculated as follows: Normalized factor = 2 31 /R 2 (R indicates the furthest distance between the center coordinates and picture edge pixels)";
            sw = rw;
            hw = r;
            reset = 0x6EA;
        } off_center_multr[15:0];
    } RADIAL_SHADING_MULTR @ 0x103D0;

    reg {
        name = "Radial_Shading green radial table normalized factor register";
        desc = "RADIAL_SHADING_MULTG is a Radial_Shading green radial table normalized factor register. Hi3516A V200 Professional HD IP Camera SoC

Data sheet 10.6 RADIAL_SHADING_MULTG (offset 0x203D4, printed page 10-178, `hi3516av200--Hi3516AV200-Datasheet.txt` line 75409).";

        field {
            name = "off_center_multg";
            desc = "Normalized factor for extending the green radial table to the picture edges. The normalized factor is calculated as follows: Normalized factor = 2 31 /R 2 (R indicates the furthest distance between the center coordinates to picture edge pixels)";
            sw = rw;
            hw = r;
            reset = 0x6EA;
        } off_center_multg[15:0];
    } RADIAL_SHADING_MULTG @ 0x103D4;

    reg {
        name = "Radial_Shading blue radial table normalized factor register";
        desc = "RADIAL_SHADING_MULTB is a Radial_Shading blue radial table normalized factor register.

Data sheet 10.6 RADIAL_SHADING_MULTB (offset 0x203D8, printed page 10-178, `hi3516av200--Hi3516AV200-Datasheet.txt` line 75434).";

        field {
            name = "off_center_multb";
            desc = "Normalized factor for extending the blue radial table to the picture edges. The normalized factor is calculated as follows: Normalized factor = 2 31 /R 2 (R indicates the furthest distance between the center coordinates to picture edge pixels)";
            sw = rw;
            hw = r;
            reset = 0x6EA;
        } off_center_multb[15:0];
    } RADIAL_SHADING_MULTB @ 0x103D8;

    reg {
        name = "Mesh_Shading control register";
        desc = "MESH_SHADING_CTRL is a Mesh_Shading control register. Hi3516A V200 Professional HD IP Camera SoC

Data sheet 10.6 MESH_SHADING_CTRL (offset 0x203E0, printed page 10-179, `hi3516av200--Hi3516AV200-Datasheet.txt` line 75466).";

        field {
            name = "mesh_height";
            desc = "Number of vertical nodes minus 1";
            sw = rw;
            hw = r;
            reset = 0x3F;
        } mesh_height[29:24];

        field {
            name = "mesh_width";
            desc = "Number of horizontal nodes minus 1";
            sw = rw;
            hw = r;
            reset = 0x3F;
        } mesh_width[21:16];

        field {
            name = "mesh_page_b";
            desc = "Memory page corresponding to blue component correction";
            sw = rw;
            hw = r;
            reset = 0x0;
        } mesh_page_b[13:12];

        field {
            name = "mesh_page_g";
            desc = "Memory page corresponding to green component correction";
            sw = rw;
            hw = r;
            reset = 0x0;
        } mesh_page_g[11:10];

        field {
            name = "mesh_page_r";
            desc = "Memory page corresponding to red component correction";
            sw = rw;
            hw = r;
            reset = 0x0;
        } mesh_page_r[9:8];

        enum MESH_SHADING_CTRL_mesh_scale_enum {
            V_0_2 = 0 { name = "V 0 2"; desc = "0-2"; };
            V_0_4 = 1 { name = "V 0 4"; desc = "0-4"; };
            V_0_8 = 2 { name = "V 0 8"; desc = "0-8"; };
            V_0_16 = 3 { name = "V 0 16"; desc = "0-16"; };
            V_1_2 = 4 { name = "V 1 2"; desc = "1-2"; };
            V_1_3 = 5 { name = "V 1 3"; desc = "1-3"; };
            V_1_5 = 6 { name = "V 1 5"; desc = "1-5"; };
            V_1_9_NOTE = 7 { name = "V 1 9 Note"; desc = "1-9 Note: The gain is a floating-point value."; };
        };

        field {
            name = "mesh_scale";
            desc = "Precision and maximum gain range";
            sw = rw;
            hw = r;
            encode = MESH_SHADING_CTRL_mesh_scale_enum;
            reset = 0x1;
        } mesh_scale[4:2];

        enum MESH_SHADING_CTRL_mesh_show_enum {
            DISABLED = 0 { name = "Disabled"; desc = "disabled"; };
            ENABLED = 1 { name = "Enabled"; desc = "enabled"; };
        };

        field {
            name = "mesh_show";
            desc = "LSC debugging enable";
            sw = rw;
            hw = r;
            encode = MESH_SHADING_CTRL_mesh_show_enum;
            reset = 0x1;
        } mesh_show[1:1];

        enum MESH_SHADING_CTRL_enable_f_enum {
            DISABLED = 0 { name = "Disabled"; desc = "disabled"; };
            ENABLED = 1 { name = "Enabled"; desc = "enabled"; };
        };

        field {
            name = "enable";
            desc = "LSC enable";
            sw = rw;
            hw = r;
            encode = MESH_SHADING_CTRL_enable_f_enum;
            reset = 0x0;
        } enable_f[0:0];
    } MESH_SHADING_CTRL @ 0x103E0;

    reg {
        name = "Mesh_Shading buffer update register";
        desc = "MESH_SHADING_RELOAD is a Mesh_Shading buffer update register.

Data sheet 10.6 MESH_SHADING_RELOAD (offset 0x203E4, printed page 10-180, `hi3516av200--Hi3516AV200-Datasheet.txt` line 75522).";

        field {
            name = "mesh_reload";
            desc = "Buffer update triggered when the bit value is changed from 0 to 1";
            sw = rw;
            hw = r;
            reset = 0x0;
        } mesh_reload[0:0];
    } MESH_SHADING_RELOAD @ 0x103E4;

    reg {
        name = "Mesh_Shading entry alpha blending mode register";
        desc = "MESH_SHADING_ALPHAMODE is a Mesh_Shading entry alpha blending mode register.

Data sheet 10.6 MESH_SHADING_ALPHAMODE (offset 0x203F0, printed page 10-180, `hi3516av200--Hi3516AV200-Datasheet.txt` line 75548).";

        enum MESH_SHADING_ALPHAMODE_mesh_alpha_mode_enum {
            NO_ALPHA_BLENDING = 0 { name = "No Alpha Blending"; desc = "no alpha blending"; };
            V_2_BANKS = 1 { name = "V 2 Banks"; desc = "2 banks (odd/even byte)"; };
            V_4_BANKS = 2 { name = "V 4 Banks"; desc = "4 banks"; };
            RESERVED = 3 { name = "Reserved"; desc = "reserved"; };
        };

        field {
            name = "mesh_alpha_mode";
            desc = "Alpha blending mode for Mesh_Shading entries";
            sw = rw;
            hw = r;
            encode = MESH_SHADING_ALPHAMODE_mesh_alpha_mode_enum;
            reset = 0x0;
        } mesh_alpha_mode[1:0];
    } MESH_SHADING_ALPHAMODE @ 0x103F0;

    reg {
        name = "Mesh_Shading blending bank selection register";
        desc = "MESH_SHADING_ALPHA_BANK is a Mesh_Shading blending bank selection register.

Data sheet 10.6 MESH_SHADING_ALPHA_BANK (offset 0x203F4, printed page 10-181, `hi3516av200--Hi3516AV200-Datasheet.txt` line 75587).";

        enum MESH_SHADING_ALPHA_BANK_mesh_alpha_bank_b_enum {
            V_0_1 = 0 { name = "V 0 1"; desc = "0 + 1"; };
            V_1_2 = 1 { name = "V 1 2"; desc = "1 + 2"; };
            V_2_3 = 2 { name = "V 2 3"; desc = "2:3"; };
            V_3_0 = 3 { name = "V 3 0"; desc = "3 + 0"; };
            V_0_2 = 4 { name = "V 0 2"; desc = "0 + 2"; };
            V_1_3_11X = 5 { name = "V 1 3 11X"; desc = "1 + 3 11X: reserved"; };
        };

        field {
            name = "mesh_alpha_bank_b";
            desc = "Bank select for B component blending";
            sw = rw;
            hw = r;
            encode = MESH_SHADING_ALPHA_BANK_mesh_alpha_bank_b_enum;
            reset = 0x0;
        } mesh_alpha_bank_b[18:16];

        enum MESH_SHADING_ALPHA_BANK_mesh_alpha_bank_g_enum {
            V_0_1 = 0 { name = "V 0 1"; desc = "0 + 1"; };
            V_1_2 = 1 { name = "V 1 2"; desc = "1 + 2"; };
            V_2_3 = 2 { name = "V 2 3"; desc = "2:3"; };
            V_3_0 = 3 { name = "V 3 0"; desc = "3 + 0"; };
            V_0_2 = 4 { name = "V 0 2"; desc = "0 + 2"; };
            V_1_3_11X = 5 { name = "V 1 3 11X"; desc = "1 + 3 11X: reserved"; };
        };

        field {
            name = "mesh_alpha_bank_g";
            desc = "Bank select for G component blending";
            sw = rw;
            hw = r;
            encode = MESH_SHADING_ALPHA_BANK_mesh_alpha_bank_g_enum;
            reset = 0x0;
        } mesh_alpha_bank_g[10:8];

        enum MESH_SHADING_ALPHA_BANK_mesh_alpha_bank_r_enum {
            V_0_1 = 0 { name = "V 0 1"; desc = "0 + 1"; };
            V_1_2 = 1 { name = "V 1 2"; desc = "1 + 2"; };
            V_2_3 = 2 { name = "V 2 3"; desc = "2:3"; };
            V_3_0 = 3 { name = "V 3 0"; desc = "3 + 0"; };
            V_0_2 = 4 { name = "V 0 2"; desc = "0 + 2"; };
            V_1_3_11X = 5 { name = "V 1 3 11X"; desc = "1 + 3 11X: reserved"; };
        };

        field {
            name = "mesh_alpha_bank_r";
            desc = "Bank select for R component blending";
            sw = rw;
            hw = r;
            encode = MESH_SHADING_ALPHA_BANK_mesh_alpha_bank_r_enum;
            reset = 0x0;
        } mesh_alpha_bank_r[2:0];
    } MESH_SHADING_ALPHA_BANK @ 0x103F4;

    reg {
        name = "Mesh_Shading alpha blending coefficient register";
        desc = "MESH_SHADING_ALPHA is a Mesh_Shading alpha blending coefficient register.

Data sheet 10.6 MESH_SHADING_ALPHA (offset 0x203F8, printed page 10-182, `hi3516av200--Hi3516AV200-Datasheet.txt` line 75651).";

        field {
            name = "mesh_alpha_b";
            desc = "Alpha blending coefficient of the B component";
            sw = rw;
            hw = r;
            reset = 0x0;
        } mesh_alpha_b[23:16];

        field {
            name = "mesh_alpha_g";
            desc = "Alpha blending coefficient of the G component";
            sw = rw;
            hw = r;
            reset = 0x0;
        } mesh_alpha_g[15:8];

        field {
            name = "mesh_alpha_r";
            desc = "Alpha blending coefficient of the R component";
            sw = rw;
            hw = r;
            reset = 0x0;
        } mesh_alpha_r[7:0];
    } MESH_SHADING_ALPHA @ 0x103F8;

    reg {
        name = "Mesh_Shading correction strength control register";
        desc = "MESH_SHADING_STRENGTH is a Mesh_Shading correction strength control register.

Data sheet 10.6 MESH_SHADING_STRENGTH (offset 0x203FC, printed page 10-182, `hi3516av200--Hi3516AV200-Datasheet.txt` line 75673).";

        field {
            name = "mesh_strength";
            desc = "Mesh correction strength, 4.12-bit. For example, the value 0 indicates no correction, and the value 4096 indicates the correction of the matched mesh data. This field can be used to to reduce the shading correction strength based on the AE.";
            sw = rw;
            hw = r;
            reset = 0x1000;
        } mesh_strength[15:0];
    } MESH_SHADING_STRENGTH @ 0x103FC;

    reg {
        name = "DRC enable register";
        desc = "DRC_ENABLE is a DRC enable register.

Data sheet 10.6 DRC_ENABLE (offset 0x20400, printed page 10-183, `hi3516av200--Hi3516AV200-Datasheet.txt` line 75706).";

        field {
            name = "rsvd3";
            desc = "Not configurable";
            sw = rw;
            hw = r;
            reset = 0x1;
        } rsvd3[15:14];

        field {
            name = "rsvd2";
            desc = "Not configurable";
            sw = rw;
            hw = r;
            reset = 0x6;
        } rsvd2[10:8];

        field {
            name = "rsvd1";
            desc = "Not configurable";
            sw = rw;
            hw = r;
            reset = 0x1;
        } rsvd1[6:5];

        field {
            name = "rsvd0";
            desc = "Not configurable";
            sw = rw;
            hw = r;
            reset = 0x1;
        } rsvd0[3:3];

        enum DRC_ENABLE_drc_on_enum {
            DISABLED = 0 { name = "Disabled"; desc = "disabled"; };
            ENABLED = 1 { name = "Enabled"; desc = "enabled"; };
        };

        field {
            name = "drc_on";
            desc = "DRC enable";
            sw = rw;
            hw = r;
            encode = DRC_ENABLE_drc_on_enum;
            reset = 0x1;
        } drc_on[0:0];
    } DRC_ENABLE @ 0x10400;

    reg {
        name = "DRC module control register";
        desc = "DRC_CTRL is a DRC module control register. Hi3516A V200 Professional HD IP Camera SoC

Data sheet 10.6 DRC_CTRL (offset 0x20408, printed page 10-184, `hi3516av200--Hi3516AV200-Datasheet.txt` line 75749).";

        field {
            name = "slope_min";
            desc = "Limit on the minimum slope (gain) generated by the adaptive algorithm";
            sw = rw;
            hw = r;
            reset = 0x40;
        } slope_min[23:16];

        field {
            name = "slope_max";
            desc = "Limit on the maximum slope (gain) generated by the adaptive algorithm";
            sw = rw;
            hw = r;
            reset = 0x80;
        } slope_max[15:8];

        field {
            name = "variance_intensity";
            desc = "Algorithm luminance sensitivity";
            sw = rw;
            hw = r;
            reset = 0x1;
        } variance_intensity[7:4];

        field {
            name = "variance_space";
            desc = "Algorithm spatial-domain sensitivity";
            sw = rw;
            hw = r;
            reset = 0x2;
        } variance_space[3:0];
    } DRC_CTRL @ 0x10408;

    reg {
        name = "DRC black level register";
        desc = "DRC_BLACK_LEVEL is a DRC black level register.

Data sheet 10.6 DRC_BLACK_LEVEL (offset 0x20410, printed page 10-184, `hi3516av200--Hi3516AV200-Datasheet.txt` line 75778).";

        field {
            name = "black_level";
            desc = "DRC black level. DRC is not implemented for pixels with the values below the field value.";
            sw = rw;
            hw = r;
            reset = 0x0;
        } black_level[19:0];
    } DRC_BLACK_LEVEL @ 0x10410;

    reg {
        name = "DRC white level register";
        desc = "DRC_WHITE_LEVEL is a DRC white level register. Hi3516A V200 Professional HD IP Camera SoC

Data sheet 10.6 DRC_WHITE_LEVEL (offset 0x20414, printed page 10-185, `hi3516av200--Hi3516AV200-Datasheet.txt` line 75808).";

        field {
            name = "white_level";
            desc = "DRC white level. DRC is not implemented for pixels with the values above the field value.";
            sw = rw;
            hw = r;
            reset = 0x000FFFFF;
        } white_level[19:0];
    } DRC_WHITE_LEVEL @ 0x10414;

    reg {
        name = "DRC strength register for the ROI";
        desc = "DRC_STRENGTH_INROI is a DRC strength register for the ROI.

Data sheet 10.6 DRC_STRENGTH_INROI (offset 0x20420, printed page 10-185, `hi3516av200--Hi3516AV200-Datasheet.txt` line 75828).";

        field {
            name = "strength_inroi";
            desc = "Strength that is manually configured in the ROI";
            sw = rw;
            hw = r;
            reset = 0x200;
        } strength_inroi[25:16];

        field {
            name = "rsvd";
            desc = "Configuration forbidden";
            sw = rw;
            hw = r;
            reset = 0x3;
        } rsvd[1:0];
    } DRC_STRENGTH_INROI @ 0x10420;

    reg {
        name = "DRC strength and horizontal start point register for the ROI";
        desc = "DRC_STRENGTH_OUTROI is a DRC strength and horizontal start point register for the ROI. Hi3516A V200 Professional HD IP Camera SoC

Data sheet 10.6 DRC_STRENGTH_OUTROI (offset 0x20424, printed page 10-186, `hi3516av200--Hi3516AV200-Datasheet.txt` line 75862).";

        field {
            name = "roihorstart";
            desc = "Horizontal start point of the ROI";
            sw = rw;
            hw = r;
            reset = 0x0;
        } roihorstart[31:16];

        field {
            name = "strength_outroi";
            desc = "Strength that is manually configured outside the ROI";
            sw = rw;
            hw = r;
            reset = 0x200;
        } strength_outroi[9:0];
    } DRC_STRENGTH_OUTROI @ 0x10424;

    reg {
        name = "DRC vertical start point and horizontal end point register for the ROI";
        desc = "DRC_ROI_HOR_START_END is a DRC vertical start point and horizontal end point register for the ROI.

Data sheet 10.6 DRC_ROI_HOR_START_END (offset 0x20428, printed page 10-186, `hi3516av200--Hi3516AV200-Datasheet.txt` line 75884).";

        field {
            name = "roiverstart";
            desc = "Vertical start point of the ROI";
            sw = rw;
            hw = r;
            reset = 0x0;
        } roiverstart[31:16];

        field {
            name = "roi_hor_end";
            desc = "Horizontal end point of the ROI";
            sw = rw;
            hw = r;
            reset = 0xFFFF;
        } roi_hor_end[15:0];
    } DRC_ROI_HOR_START_END @ 0x10428;

    reg {
        name = "DRC vertical end point register for the ROI";
        desc = "DRC_ROI_VER_END is a DRC vertical end point register for the ROI.

Data sheet 10.6 DRC_ROI_VER_END (offset 0x2042C, printed page 10-186, `hi3516av200--Hi3516AV200-Datasheet.txt` line 75903).";

        field {
            name = "roi_ver_end";
            desc = "Vertical end point of the ROI";
            sw = rw;
            hw = r;
            reset = 0xFFFF;
        } roi_ver_end[15:0];
    } DRC_ROI_VER_END @ 0x1042C;

    reg {
        name = "DRC algorithm control register";
        desc = "DRC_FILTER_MUX is a DRC algorithm control register.

Data sheet 10.6 DRC_FILTER_MUX (offset 0x20430, printed page 10-187, `hi3516av200--Hi3516AV200-Datasheet.txt` line 75930).";

        field {
            name = "contrast";
            desc = "Contrast control parameter of DRC algorithm 2";
            sw = rw;
            hw = r;
            reset = 0xB0;
        } contrast[31:24];

        field {
            name = "bright_pr";
            desc = "DRC Bright_Preserve parameter that is manually controlled";
            sw = rw;
            hw = r;
            reset = 0xA0;
        } bright_pr[23:16];

        field {
            name = "svariance";
            desc = "Sensitivity of switching DRC algorithm 2 among different picture regions";
            sw = rw;
            hw = r;
            reset = 0x0;
        } svariance[11:8];

        enum DRC_FILTER_MUX_filter_mux_enum {
            ALGORITHM_1 = 0 { name = "Algorithm 1"; desc = "algorithm 1"; };
            ALGORITHM_2 = 1 { name = "Algorithm 2"; desc = "algorithm 2"; };
        };

        field {
            name = "filter_mux";
            desc = "DRC algorithm select";
            sw = rw;
            hw = r;
            encode = DRC_FILTER_MUX_filter_mux_enum;
            reset = 0x0;
        } filter_mux[0:0];
    } DRC_FILTER_MUX @ 0x10430;

    reg {
        name = "DRC Dark_Enhance parameter configuration register";
        desc = "DRC_DARK_ENH is a DRC Dark_Enhance parameter configuration register.

Data sheet 10.6 DRC_DARK_ENH (offset 0x20434, printed page 10-187, `hi3516av200--Hi3516AV200-Datasheet.txt` line 75964).";

        field {
            name = "dark_enh";
            desc = "DRC Dark_Enhance parameter that is manually controlled";
            sw = rw;
            hw = r;
            reset = 0x1000;
        } dark_enh[15:0];
    } DRC_DARK_ENH @ 0x10434;

    reg {
        name = "DRC LUT status indicator register";
        desc = "DRC_MCU_READY is a DRC LUT status indicator register.

Data sheet 10.6 DRC_MCU_READY (offset 0x20438, printed page 10-188, `hi3516av200--Hi3516AV200-Datasheet.txt` line 75990).";

        field {
            name = "mcu_ready_rev";
            desc = "rev_percept LUT status indicator. If this bit is set to 1, the LUT is ready to receive data from the CPU.";
            sw = r;
            hw = w;
            reset = 0x1;
        } mcu_ready_rev[2:2];

        field {
            name = "mcu_ready_fwd";
            desc = "fwd_percept LUT status indicator. If this bit is set to 1, the LUT is ready to receive data from the CPU.";
            sw = r;
            hw = w;
            reset = 0x1;
        } mcu_ready_fwd[1:1];

        enum DRC_MCU_READY_mcu_priority_enum {
            LOW = 0 { name = "Low"; desc = "low"; };
            HIGH = 1 { name = "High"; desc = "high"; };
        };

        field {
            name = "mcu_priority";
            desc = "CPU write priority of the LUT";
            sw = r;
            hw = w;
            encode = DRC_MCU_READY_mcu_priority_enum;
            reset = 0x0;
        } mcu_priority[0:0];
    } DRC_MCU_READY @ 0x10438;

    reg {
        name = "Demosaic vertical/horizontal blending threshold slope register";
        desc = "DEMOSAIC_VH_SLOPE is a demosaic vertical/horizontal blending threshold slope register.

Data sheet 10.6 DEMOSAIC_VH_SLOPE (offset 0x20480, printed page 10-188, `hi3516av200--Hi3516AV200-Datasheet.txt` line 76024).";

        field {
            name = "vh_slope";
            desc = "Slope of the vertical/horizontal blending threshold, 4.4-bit logarithm";
            sw = rw;
            hw = r;
            reset = 0xC0;
        } vh_slope[7:0];
    } DEMOSAIC_VH_SLOPE @ 0x10480;

    reg {
        name = "Demosaic angle blending threshold slope register";
        desc = "DEMOSAIC_AA_SLOPE is a demosaic angle blending threshold slope register.

Data sheet 10.6 DEMOSAIC_AA_SLOPE (offset 0x20484, printed page 10-189, `hi3516av200--Hi3516AV200-Datasheet.txt` line 76052).";

        field {
            name = "aa_slope";
            desc = "Slope of the angle blending threshold, 4.4-bit logarithm";
            sw = rw;
            hw = r;
            reset = 0xC0;
        } aa_slope[7:0];
    } DEMOSAIC_AA_SLOPE @ 0x10484;

    reg {
        name = "Demosaic VH-AA";
        desc = "DEMOSAIC_VA_SLOPE is a demosaic VH-AA (VA) blending threshold slope register.

Data sheet 10.6 DEMOSAIC_VA_SLOPE (offset 0x20488, printed page 10-189, `hi3516av200--Hi3516AV200-Datasheet.txt` line 76072).";

        field {
            name = "va_slope";
            desc = "Slope of the VH-AA (VA) blending threshold, 4.4-bit logarithm";
            sw = rw;
            hw = r;
            reset = 0xAA;
        } va_slope[7:0];
    } DEMOSAIC_VA_SLOPE @ 0x10488;

    reg {
        name = "Demosaic undefined blending threshold slope register";
        desc = "DEMOSAIC_UU_SLOPE is a demosaic undefined blending threshold slope register.

Data sheet 10.6 DEMOSAIC_UU_SLOPE (offset 0x2048C, printed page 10-189, `hi3516av200--Hi3516AV200-Datasheet.txt` line 76091).";

        field {
            name = "uu_slope";
            desc = "Slope of the undefined blending threshold, 4.4-bit logarithm";
            sw = rw;
            hw = r;
            reset = 0xAD;
        } uu_slope[7:0];
    } DEMOSAIC_UU_SLOPE @ 0x1048C;

    reg {
        name = "Demosaic saturation blending threshold slope register";
        desc = "DEMOSAIC_SAT_SLOPE is a demosaic saturation blending threshold slope register.

Data sheet 10.6 DEMOSAIC_SAT_SLOPE (offset 0x20490, printed page 10-190, `hi3516av200--Hi3516AV200-Datasheet.txt` line 76120).";

        field {
            name = "sat_slope";
            desc = "Slope of the saturation blending threshold, 2.6-bit linear value";
            sw = rw;
            hw = r;
            reset = 0x5D;
        } sat_slope[7:0];
    } DEMOSAIC_SAT_SLOPE @ 0x10490;

    reg {
        name = "Demosaic vertical/horizontal blending range threshold register";
        desc = "DEMOSAIC_VH_THRESH is a demosaic vertical/horizontal blending range threshold register.

Data sheet 10.6 DEMOSAIC_VH_THRESH (offset 0x20494, printed page 10-190, `hi3516av200--Hi3516AV200-Datasheet.txt` line 76141).";

        field {
            name = "vh_thresh";
            desc = "Threshold for the vertical/horizontal blending range";
            sw = rw;
            hw = r;
            reset = 0x131;
        } vh_thresh[11:0];
    } DEMOSAIC_VH_THRESH @ 0x10494;

    reg {
        name = "Demosaic angle blending range threshold register";
        desc = "DEMOSAIC_AA_THRESH is a demosaic angle blending range threshold register. Hi3516A V200 Professional HD IP Camera SoC

Data sheet 10.6 DEMOSAIC_AA_THRESH (offset 0x20498, printed page 10-191, `hi3516av200--Hi3516AV200-Datasheet.txt` line 76169).";

        field {
            name = "aa_thresh";
            desc = "Threshold for the angle blending range";
            sw = rw;
            hw = r;
            reset = 0xA0;
        } aa_thresh[11:0];
    } DEMOSAIC_AA_THRESH @ 0x10498;

    reg {
        name = "Demosaic VA blending range threshold register";
        desc = "DEMOSAIC_VA_THRESH is a demosaic VA blending range threshold register.

Data sheet 10.6 DEMOSAIC_VA_THRESH (offset 0x2049C, printed page 10-191, `hi3516av200--Hi3516AV200-Datasheet.txt` line 76189).";

        field {
            name = "va_thresh";
            desc = "Threshold for the VA blending range";
            sw = rw;
            hw = r;
            reset = 0x70;
        } va_thresh[11:0];
    } DEMOSAIC_VA_THRESH @ 0x1049C;

    reg {
        name = "Demosaic undefined blending range threshold register";
        desc = "DEMOSAIC_UU_THRESH is a demosaic undefined blending range threshold register.

Data sheet 10.6 DEMOSAIC_UU_THRESH (offset 0x204A0, printed page 10-191, `hi3516av200--Hi3516AV200-Datasheet.txt` line 76208).";

        field {
            name = "uu_thresh";
            desc = "Threshold for the undefined blending range";
            sw = rw;
            hw = r;
            reset = 0x171;
        } uu_thresh[11:0];
    } DEMOSAIC_UU_THRESH @ 0x104A0;

    reg {
        name = "Demosaic saturation blending range threshold register";
        desc = "DEMOSAIC_SAT_THRESH is a demosaic saturation blending range threshold register.

Data sheet 10.6 DEMOSAIC_SAT_THRESH (offset 0x204A4, printed page 10-192, `hi3516av200--Hi3516AV200-Datasheet.txt` line 76234).";

        field {
            name = "sat_thresh";
            desc = "Threshold for the saturation blending range, 2.9-bit signed number";
            sw = rw;
            hw = r;
            reset = 0x171;
        } sat_thresh[11:0];
    } DEMOSAIC_SAT_THRESH @ 0x104A4;

    reg {
        name = "Demosaic vertical/horizontal blending threshold offset register";
        desc = "DEMOSAIC_VH_OFFSET is a demosaic vertical/horizontal blending threshold offset register.

Data sheet 10.6 DEMOSAIC_VH_OFFSET (offset 0x204A8, printed page 10-192, `hi3516av200--Hi3516AV200-Datasheet.txt` line 76255).";

        field {
            name = "vh_offset";
            desc = "vh_offset";
            sw = rw;
            hw = r;
            reset = 0x800;
        } vh_offset[11:0];
    } DEMOSAIC_VH_OFFSET @ 0x104A8;

    reg {
        name = "Demosaic angle blending threshold offset register";
        desc = "DEMOSAIC_AA_OFFSET is a demosaic angle blending threshold offset register.

Data sheet 10.6 DEMOSAIC_AA_OFFSET (offset 0x204AC, printed page 10-192, `hi3516av200--Hi3516AV200-Datasheet.txt` line 76275).";

        field {
            name = "aa_offset";
            desc = "aa_offset";
            sw = rw;
            hw = r;
            reset = 0x800;
        } aa_offset[11:0];
    } DEMOSAIC_AA_OFFSET @ 0x104AC;

    reg {
        name = "Demosaic VA blending threshold offset register";
        desc = "DEMOSAIC_VA_OFFSET is a demosaic VA blending threshold offset register.

Data sheet 10.6 DEMOSAIC_VA_OFFSET (offset 0x204B0, printed page 10-193, `hi3516av200--Hi3516AV200-Datasheet.txt` line 76303).";

        field {
            name = "va_offset";
            desc = "va_offset";
            sw = rw;
            hw = r;
            reset = 0x800;
        } va_offset[11:0];
    } DEMOSAIC_VA_OFFSET @ 0x104B0;

    reg {
        name = "Demosaic undefined blending threshold offset register";
        desc = "DEMOSAIC_UU_OFFSET is a demosaic undefined blending threshold offset register.

Data sheet 10.6 DEMOSAIC_UU_OFFSET (offset 0x204B4, printed page 10-193, `hi3516av200--Hi3516AV200-Datasheet.txt` line 76323).";

        field {
            name = "uu_offset";
            desc = "uu_offset";
            sw = rw;
            hw = r;
            reset = 0x0;
        } uu_offset[11:0];
    } DEMOSAIC_UU_OFFSET @ 0x104B4;

    reg {
        name = "Demosaic saturation blending threshold offset register";
        desc = "DEMOSAIC_SAT_OFFSET is a demosaic saturation blending threshold offset register. Hi3516A V200 Professional HD IP Camera SoC

Data sheet 10.6 DEMOSAIC_SAT_OFFSET (offset 0x204B8, printed page 10-194, `hi3516av200--Hi3516AV200-Datasheet.txt` line 76351).";

        field {
            name = "sat_offset";
            desc = "sat_offset";
            sw = rw;
            hw = r;
            reset = 0x0;
        } sat_offset[11:0];
    } DEMOSAIC_SAT_OFFSET @ 0x104B8;

    reg {
        name = "Demosaic directional sharpening mask strength register";
        desc = "DEMOSAIC_SHARP_ALT_D is a demosaic directional sharpening mask strength register.

Data sheet 10.6 DEMOSAIC_SHARP_ALT_D (offset 0x204BC, printed page 10-194, `hi3516av200--Hi3516AV200-Datasheet.txt` line 76371).";

        field {
            name = "sharp_alt_d";
            desc = "Strength of the directional sharpening mask, 4.4-bit signed number";
            sw = rw;
            hw = r;
            reset = 0x30;
        } sharp_alt_d[7:0];
    } DEMOSAIC_SHARP_ALT_D @ 0x104BC;

    reg {
        name = "Demosaic non-directional sharpening mask strength register";
        desc = "DEMOSAIC_SHARP_ALT_UD is a demosaic non-directional sharpening mask strength register.

Data sheet 10.6 DEMOSAIC_SHARP_ALT_UD (offset 0x204C0, printed page 10-194, `hi3516av200--Hi3516AV200-Datasheet.txt` line 76391).";

        field {
            name = "sharp_alt_ud";
            desc = "Strength of the non-directional sharpening mask, 4.4-bit signed number";
            sw = rw;
            hw = r;
            reset = 0x20;
        } sharp_alt_ud[7:0];
    } DEMOSAIC_SHARP_ALT_UD @ 0x104C0;

    reg {
        name = "Demosaic directional sharpening luminance threshold register";
        desc = "DEMOSAIC_LUM_THRESH is a demosaic directional sharpening luminance threshold register.

Data sheet 10.6 DEMOSAIC_LUM_THRESH (offset 0x204C4, printed page 10-195, `hi3516av200--Hi3516AV200-Datasheet.txt` line 76422).";

        field {
            name = "lum_thresh";
            desc = "Threshold for the directional sharpening luminance";
            sw = rw;
            hw = r;
            reset = 0x60;
        } lum_thresh[11:0];
    } DEMOSAIC_LUM_THRESH @ 0x104C4;

    reg {
        name = "Demosaic configured noise offset register";
        desc = "DEMOSAIC_NP_OFFSET is a demosaic configured noise offset register.

Data sheet 10.6 DEMOSAIC_NP_OFFSET (offset 0x204C8, printed page 10-195, `hi3516av200--Hi3516AV200-Datasheet.txt` line 76441).";

        field {
            name = "np_offset";
            desc = "Configured noise offset, 4.4-bit logarithm";
            sw = rw;
            hw = r;
            reset = 0x0;
        } np_offset[7:0];
    } DEMOSAIC_NP_OFFSET @ 0x104C8;

    reg {
        name = "Demosaic debugging output selection register";
        desc = "DEMOSAIC_DMSC_CONFIG is a demosaic debugging output selection register. Hi3516A V200 Professional HD IP Camera SoC

Data sheet 10.6 DEMOSAIC_DMSC_CONFIG (offset 0x204CC, printed page 10-196, `hi3516av200--Hi3516AV200-Datasheet.txt` line 76470).";

        field {
            name = "dmsc_config";
            desc = "Debugging output select. The value 0x00 indicates the normal mode.";
            sw = rw;
            hw = r;
            reset = 0x0;
        } dmsc_config[7:0];
    } DEMOSAIC_DMSC_CONFIG @ 0x104CC;

    reg {
        name = "Demosaic AC blending range threshold register";
        desc = "DEMOSAIC_AC_THRESH is a demosaic AC blending range threshold register.

Data sheet 10.6 DEMOSAIC_AC_THRESH (offset 0x204D0, printed page 10-196, `hi3516av200--Hi3516AV200-Datasheet.txt` line 76492).";

        field {
            name = "ac_thresh";
            desc = "Threshold for the AC blending range, 2.9-bit signed number";
            sw = rw;
            hw = r;
            reset = 0x1B3;
        } ac_thresh[11:0];
    } DEMOSAIC_AC_THRESH @ 0x104D0;

    reg {
        name = "Demosaic AC blending threshold slope register";
        desc = "DEMOSAIC_AC_SLOPE is a demosaic AC blending threshold slope register.

Data sheet 10.6 DEMOSAIC_AC_SLOPE (offset 0x204D4, printed page 10-196, `hi3516av200--Hi3516AV200-Datasheet.txt` line 76511).";

        field {
            name = "ac_slope";
            desc = "Slope of the AC blending threshold, 2.6-bit linear value";
            sw = rw;
            hw = r;
            reset = 0xCF;
        } ac_slope[7:0];
    } DEMOSAIC_AC_SLOPE @ 0x104D4;

    reg {
        name = "Demosaic AC blending threshold offset register";
        desc = "DEMOSAIC_AC_OFFSET is a demosaic AC blending threshold offset register.

Data sheet 10.6 DEMOSAIC_AC_OFFSET (offset 0x204D8, printed page 10-197, `hi3516av200--Hi3516AV200-Datasheet.txt` line 76537).";

        field {
            name = "ac_offset";
            desc = "ac_offset";
            sw = rw;
            hw = r;
            reset = 0x0;
        } ac_offset[11:0];
    } DEMOSAIC_AC_OFFSET @ 0x104D8;

    reg {
        name = "Demosaic false color correction slope";
        desc = "DEMOSAIC_FC_SLPOE is a demosaic false color correction slope (strength) register.

Data sheet 10.6 DEMOSAIC_FC_SLPOE (offset 0x204DC, printed page 10-197, `hi3516av200--Hi3516AV200-Datasheet.txt` line 76557).";

        field {
            name = "fc_slope";
            desc = "False color correction slope (strength)";
            sw = rw;
            hw = r;
            reset = 0x80;
        } fc_slope[7:0];
    } DEMOSAIC_FC_SLPOE @ 0x104DC;

    reg {
        name = "Demosaic false color correction slope";
        desc = "DEMOSAIC_FC_ALIAS_SLPOE is a demosaic false color correction slope (strength) register.

Data sheet 10.6 DEMOSAIC_FC_ALIAS_SLPOE (offset 0x204E0, printed page 10-197, `hi3516av200--Hi3516AV200-Datasheet.txt` line 76577).";

        field {
            name = "fc_alias_slope";
            desc = "False color correction slope (strength) when the saturation value is in U2.6 format";
            sw = rw;
            hw = r;
            reset = 0x55;
        } fc_alias_slope[7:0];
    } DEMOSAIC_FC_ALIAS_SLPOE @ 0x104E0;

    reg {
        name = "Demosaic anti-false color threshold register";
        desc = "DEMOSAIC_FC_ALIAS_THRESH is a demosaic anti-false color threshold register.

Data sheet 10.6 DEMOSAIC_FC_ALIAS_THRESH (offset 0x204E4, printed page 10-198, `hi3516av200--Hi3516AV200-Datasheet.txt` line 76607).";

        field {
            name = "fc_alias_thresh";
            desc = "Anti-false color threshold when the saturation value is in U0.8 format";
            sw = rw;
            hw = r;
            reset = 0x0;
        } fc_alias_thresh[7:0];
    } DEMOSAIC_FC_ALIAS_THRESH @ 0x104E4;

    reg {
        name = "Demosaic noise black level offset register";
        desc = "DEMOSAIC_NP_OFF is a demosaic noise black level offset register.

Data sheet 10.6 DEMOSAIC_NP_OFF (offset 0x204EC, printed page 10-198, `hi3516av200--Hi3516AV200-Datasheet.txt` line 76629).";

        enum DEMOSAIC_NP_OFF_np_off_reflect_enum {
            INPUT_FIRST_TABLE = 0 { name = "Input First Table"; desc = "The input of the first table is repeated."; };
            PART_BELOW_BLACK = 1 { name = "Part Below Black"; desc = "The part below the black level on the noise curve is mapped."; };
        };

        field {
            name = "np_off_reflect";
            desc = "Method of obtaining values below the black level";
            sw = rw;
            hw = r;
            encode = DEMOSAIC_NP_OFF_np_off_reflect_enum;
            reset = 0x0;
        } np_off_reflect[7:7];

        field {
            name = "np_off";
            desc = "Noise black level offset";
            sw = rw;
            hw = r;
            reset = 0x0;
        } np_off[6:0];
    } DEMOSAIC_NP_OFF @ 0x104EC;

    reg {
        name = "Demosaic sharpening strength register";
        desc = "DEMOSAIC_SHARP is a demosaic sharpening strength register.

Data sheet 10.6 DEMOSAIC_SHARP (offset 0x204F0, printed page 10-199, `hi3516av200--Hi3516AV200-Datasheet.txt` line 76663).";

        field {
            name = "sad_amp";
            desc = "SAD amplifier, 4.4-bit unsigned number";
            sw = rw;
            hw = r;
            reset = 0x10;
        } sad_amp[31:24];

        field {
            name = "sharp_alt_lu";
            desc = "L_Lu sharpening strength, 4.4-bit unsigned number";
            sw = rw;
            hw = r;
            reset = 0x10;
        } sharp_alt_lu[23:16];

        field {
            name = "sharp_alt_ldu";
            desc = "L_Ldu sharpening strength, 4.4-bit unsigned number";
            sw = rw;
            hw = r;
            reset = 0x10;
        } sharp_alt_ldu[15:8];

        field {
            name = "sharp_alt_ld";
            desc = "L_Ld sharpening strength, 4.4-bit unsigned number";
            sw = rw;
            hw = r;
            reset = 0x10;
        } sharp_alt_ld[7:0];
    } DEMOSAIC_SHARP @ 0x104F0;

    reg {
        name = "Demosaic threshold register";
        desc = "DEMOSAIC_MIN_THRESHOLD is a demosaic threshold register. [check] The data-sheet table extraction produced overlapping bit fields for this register; the overlapping entries sharpen_alg_select[0:0] were dropped - verify against the printed page.

Data sheet 10.6 DEMOSAIC_MIN_THRESHOLD (offset 0x204F4, printed page 10-199, `hi3516av200--Hi3516AV200-Datasheet.txt` line 76685).";

        field {
            name = "min_ud_strength";
            desc = "L_Lu non-directional minimum threshold, 12-bit signed number, binary complement";
            sw = rw;
            hw = r;
            reset = 0x1F48;
        } min_ud_strength[28:16];

        field {
            name = "min_d_strength";
            desc = "L_L directional minimum threshold, 12-bit signed number, binary complement";
            sw = rw;
            hw = r;
            reset = 0x1F33;
        } min_d_strength[12:0];
    } DEMOSAIC_MIN_THRESHOLD @ 0x104F4;

    reg {
        name = "COLOR_MATRIX R-R multiple matrix coefficient register";
        desc = "COLOR_MATRIX_COEFFT_RR is a COLOR_MATRIX R-R multiple matrix coefficient register.

Data sheet 10.6 COLOR_MATRIX_COEFFT_RR (offset 0x20500, printed page 10-200, `hi3516av200--Hi3516AV200-Datasheet.txt` line 76753).";

        field {
            name = "coefftr_r";
            desc = "R-R multiple matrix coefficient, 4.8-bit signed fixed-point number";
            sw = rw;
            hw = r;
            reset = 0x100;
        } coefftr_r[15:0];
    } COLOR_MATRIX_COEFFT_RR @ 0x10500;

    reg {
        name = "COLOR_MATRIX R-G multiple matrix coefficient register";
        desc = "COLOR_MATRIX_COEFFT_RG is a COLOR_MATRIX R-G multiple matrix coefficient register. Hi3516A V200 Professional HD IP Camera SoC

Data sheet 10.6 COLOR_MATRIX_COEFFT_RG (offset 0x20504, printed page 10-201, `hi3516av200--Hi3516AV200-Datasheet.txt` line 76783).";

        field {
            name = "coefftr_g";
            desc = "R-G multiple matrix coefficient, 4.8-bit signed fixed-point number";
            sw = rw;
            hw = r;
            reset = 0x0;
        } coefftr_g[15:0];
    } COLOR_MATRIX_COEFFT_RG @ 0x10504;

    reg {
        name = "COLOR_MATRIX R-B multiple matrix coefficient register";
        desc = "COLOR_MATRIX_COEFFT_RB is a COLOR_MATRIX R-B multiple matrix coefficient register.

Data sheet 10.6 COLOR_MATRIX_COEFFT_RB (offset 0x20508, printed page 10-201, `hi3516av200--Hi3516AV200-Datasheet.txt` line 76804).";

        field {
            name = "coefftr_b";
            desc = "R-B multiple matrix coefficient, 4.8-bit signed fixed-point number";
            sw = rw;
            hw = r;
            reset = 0x0;
        } coefftr_b[15:0];
    } COLOR_MATRIX_COEFFT_RB @ 0x10508;

    reg {
        name = "COLOR_MATRIX G-R multiple matrix coefficient register";
        desc = "COLOR_MATRIX_COEFFT_GR is a COLOR_MATRIX G-R multiple matrix coefficient register.

Data sheet 10.6 COLOR_MATRIX_COEFFT_GR (offset 0x2050C, printed page 10-201, `hi3516av200--Hi3516AV200-Datasheet.txt` line 76824).";

        field {
            name = "coefftg_r";
            desc = "G-R multiple matrix coefficient, 4.8-bit signed fixed-point number";
            sw = rw;
            hw = r;
            reset = 0x0;
        } coefftg_r[15:0];
    } COLOR_MATRIX_COEFFT_GR @ 0x1050C;

    reg {
        name = "COLOR_MATRIX G-G multiple matrix coefficient register";
        desc = "COLOR_MATRIX_COEFFT_GG is a COLOR_MATRIX G-G multiple matrix coefficient register.

Data sheet 10.6 COLOR_MATRIX_COEFFT_GG (offset 0x20510, printed page 10-202, `hi3516av200--Hi3516AV200-Datasheet.txt` line 76852).";

        field {
            name = "coefftg_g";
            desc = "G-G multiple matrix coefficient, 4.8-bit signed fixed-point number";
            sw = rw;
            hw = r;
            reset = 0x100;
        } coefftg_g[15:0];
    } COLOR_MATRIX_COEFFT_GG @ 0x10510;

    reg {
        name = "COLOR_MATRIX G-B multiple matrix coefficient register";
        desc = "COLOR_MATRIX_COEFFT_GB is a COLOR_MATRIX G-B multiple matrix coefficient register.

Data sheet 10.6 COLOR_MATRIX_COEFFT_GB (offset 0x20514, printed page 10-202, `hi3516av200--Hi3516AV200-Datasheet.txt` line 76872).";

        field {
            name = "coefftg_b";
            desc = "G-B multiple matrix coefficient, 4.8-bit signed fixed-point number";
            sw = rw;
            hw = r;
            reset = 0x0;
        } coefftg_b[15:0];
    } COLOR_MATRIX_COEFFT_GB @ 0x10514;

    reg {
        name = "COLOR_MATRIX B-R multiple matrix coefficient register";
        desc = "COLOR_MATRIX_COEFFT_BR is a COLOR_MATRIX B-R multiple matrix coefficient register. Hi3516A V200 Professional HD IP Camera SoC

Data sheet 10.6 COLOR_MATRIX_COEFFT_BR (offset 0x20518, printed page 10-203, `hi3516av200--Hi3516AV200-Datasheet.txt` line 76902).";

        field {
            name = "coefftb_r";
            desc = "B-R multiple matrix coefficient, 4.8-bit signed fixed-point number";
            sw = rw;
            hw = r;
            reset = 0x0;
        } coefftb_r[15:0];
    } COLOR_MATRIX_COEFFT_BR @ 0x10518;

    reg {
        name = "COLOR_MATRIX B-G multiple matrix coefficient register";
        desc = "COLOR_MATRIX_COEFFT_BG is a COLOR_MATRIX B-G multiple matrix coefficient register.

Data sheet 10.6 COLOR_MATRIX_COEFFT_BG (offset 0x2051C, printed page 10-203, `hi3516av200--Hi3516AV200-Datasheet.txt` line 76923).";

        field {
            name = "coefftb_g";
            desc = "B-G multiple matrix coefficient, 4.8-bit signed fixed-point number";
            sw = rw;
            hw = r;
            reset = 0x0;
        } coefftb_g[15:0];
    } COLOR_MATRIX_COEFFT_BG @ 0x1051C;

    reg {
        name = "COLOR_MATRIX B-B multiple matrix coefficient register";
        desc = "COLOR_MATRIX_COEFFT_BB is a COLOR_MATRIX B-B multiple matrix coefficient register.

Data sheet 10.6 COLOR_MATRIX_COEFFT_BB (offset 0x20520, printed page 10-203, `hi3516av200--Hi3516AV200-Datasheet.txt` line 76943).";

        field {
            name = "coefftb_b";
            desc = "B-B multiple matrix coefficient, 4.8-bit signed fixed-point number";
            sw = rw;
            hw = r;
            reset = 0x100;
        } coefftb_b[15:0];
    } COLOR_MATRIX_COEFFT_BB @ 0x10520;

    reg {
        name = "COLOR_MATRIX enable register";
        desc = "COLOR_MATRIX_CTRL is a COLOR_MATRIX enable register.

Data sheet 10.6 COLOR_MATRIX_CTRL (offset 0x20524, printed page 10-204, `hi3516av200--Hi3516AV200-Datasheet.txt` line 76970).";

        enum COLOR_MATRIX_CTRL_enable_f_enum {
            DISABLED = 0 { name = "Disabled"; desc = "disabled"; };
            ENABLED = 1 { name = "Enabled"; desc = "enabled"; };
        };

        field {
            name = "enable";
            desc = "Color_Matrix enable";
            sw = rw;
            hw = r;
            encode = COLOR_MATRIX_CTRL_enable_f_enum;
            reset = 0x1;
        } enable_f[0:0];
    } COLOR_MATRIX_CTRL @ 0x10524;

    reg {
        name = "COLOR_MATRIX R WB gain register";
        desc = "COLOR_MATRIX_COEFFT_WBR is a COLOR_MATRIX R WB gain register.

Data sheet 10.6 COLOR_MATRIX_COEFFT_WBR (offset 0x20528, printed page 10-204, `hi3516av200--Hi3516AV200-Datasheet.txt` line 76993).";

        field {
            name = "coefft_wb_r";
            desc = "WB gain of the R component, 4.8-bit signed fixed-point number";
            sw = rw;
            hw = r;
            reset = 0x100;
        } coefft_wb_r[15:0];
    } COLOR_MATRIX_COEFFT_WBR @ 0x10528;

    reg {
        name = "COLOR_MATRIX G WB gain register";
        desc = "COLOR_MATRIX_COEFFT_WBG is a COLOR_MATRIX G WB gain register. Hi3516A V200 Professional HD IP Camera SoC

Data sheet 10.6 COLOR_MATRIX_COEFFT_WBG (offset 0x2052C, printed page 10-205, `hi3516av200--Hi3516AV200-Datasheet.txt` line 77022).";

        field {
            name = "coefft_wb_g";
            desc = "WB gain of the G component, 4.8-bit signed fixed-point number";
            sw = rw;
            hw = r;
            reset = 0x100;
        } coefft_wb_g[15:0];
    } COLOR_MATRIX_COEFFT_WBG @ 0x1052C;

    reg {
        name = "COLOR_MATRIX B WB gain register";
        desc = "COLOR_MATRIX_COEFFT_WBB is a COLOR_MATRIX B WB gain register. [check] The data-sheet table extraction produced overlapping bit fields for this register; the overlapping entries coefft_fog_offset_r[11:0], coefft_fog_offset_g[11:0], coefft_fog_offset_b[11:0] were dropped - verify against the printed page.

Data sheet 10.6 COLOR_MATRIX_COEFFT_WBB (offset 0x20530, printed page 10-205, `hi3516av200--Hi3516AV200-Datasheet.txt` line 77042).";

        field {
            name = "coefft_wb_b";
            desc = "WB gain of the B component, 4.8-bit signed fixed-point number";
            sw = rw;
            hw = r;
            reset = 0x100;
        } coefft_wb_b[15:0];
    } COLOR_MATRIX_COEFFT_WBB @ 0x10530;

    reg {
        name = "GAMMA_RGB control register";
        desc = "GAMMA_RGB_CTRL is a GAMMA_RGB control register. Hi3516A V200 Professional HD IP Camera SoC

Data sheet 10.6 GAMMA_RGB_CTRL (offset 0x20580, printed page 10-207, `hi3516av200--Hi3516AV200-Datasheet.txt` line 77144).";

        enum GAMMA_RGB_CTRL_mcu_priority_enum {
            LOW = 0 { name = "Low"; desc = "low"; };
            HIGH = 1 { name = "High"; desc = "high"; };
        };

        field {
            name = "mcu_priority";
            desc = "CPU write priority of the LUT";
            sw = rw;
            hw = r;
            encode = GAMMA_RGB_CTRL_mcu_priority_enum;
            reset = 0x1;
        } mcu_priority[7:7];

        enum GAMMA_RGB_CTRL_bank_select_enum {
            BANK_0 = 0 { name = "Bank 0"; desc = "bank 0"; };
            BANK_1 = 1 { name = "Bank 1"; desc = "bank 1"; };
        };

        field {
            name = "bank_select";
            desc = "LUT RAM bank select for GAMMA_RGB";
            sw = rw;
            hw = r;
            encode = GAMMA_RGB_CTRL_bank_select_enum;
            reset = 0x0;
        } bank_select[4:4];

        enum GAMMA_RGB_CTRL_enable_f_enum {
            DISABLED = 0 { name = "Disabled"; desc = "disabled"; };
            ENABLED = 1 { name = "Enabled"; desc = "enabled"; };
        };

        field {
            name = "enable";
            desc = "Gamma RGB enable";
            sw = rw;
            hw = r;
            encode = GAMMA_RGB_CTRL_enable_f_enum;
            reset = 0x1;
        } enable_f[0:0];
    } GAMMA_RGB_CTRL @ 0x10580;

    reg {
        name = "GAMMA_RGB LUT status indicator register for data reception from the CPU";
        desc = "GAMMA_RGB_MCU_READY is a GAMMA_RGB LUT status indicator register for data reception from the CPU. Hi3516A V200 Professional HD IP Camera SoC

Data sheet 10.6 GAMMA_RGB_MCU_READY (offset 0x20584, printed page 10-208, `hi3516av200--Hi3516AV200-Datasheet.txt` line 77190).";

        field {
            name = "mcu_ready";
            desc = "If this bit is set to 1, the LUT is ready to receive data from the CPU.";
            sw = r;
            hw = w;
            reset = 0x1;
        } mcu_ready[0:0];
    } GAMMA_RGB_MCU_READY @ 0x10584;

    reg {
        name = "Gamma bank selection indicator register";
        desc = "GAMMA_BANK_SELECT is a gamma bank selection indicator register.

Data sheet 10.6 GAMMA_BANK_SELECT (offset 0x20588, printed page 10-208, `hi3516av200--Hi3516AV200-Datasheet.txt` line 77217).";

        enum GAMMA_BANK_SELECT_bank_selected_gamma_be1_enum {
            BANK_0 = 0 { name = "Bank 0"; desc = "bank 0"; };
            BANK_1 = 1 { name = "Bank 1"; desc = "bank 1"; };
        };

        field {
            name = "bank_selected_gamma_be1";
            desc = "Bank in which the gamma BE1 module is working";
            sw = r;
            hw = w;
            encode = GAMMA_BANK_SELECT_bank_selected_gamma_be1_enum;
            reset = 0x0;
        } bank_selected_gamma_be1[4:4];

        enum GAMMA_BANK_SELECT_bank_selected_gamma_be0_enum {
            BANK_0 = 0 { name = "Bank 0"; desc = "bank 0"; };
            BANK_1 = 1 { name = "Bank 1"; desc = "bank 1"; };
        };

        field {
            name = "bank_selected_gamma_be0";
            desc = "Bank in which the gamma BE0 module is working";
            sw = r;
            hw = w;
            encode = GAMMA_BANK_SELECT_bank_selected_gamma_be0_enum;
            reset = 0x0;
        } bank_selected_gamma_be0[3:3];

        enum GAMMA_BANK_SELECT_bank_selected_gamma_fe1_enum {
            BANK_0 = 0 { name = "Bank 0"; desc = "bank 0"; };
            BANK_1 = 1 { name = "Bank 1"; desc = "bank 1"; };
        };

        field {
            name = "bank_selected_gamma_fe1";
            desc = "Bank in which the gamma FE1 module is working";
            sw = r;
            hw = w;
            encode = GAMMA_BANK_SELECT_bank_selected_gamma_fe1_enum;
            reset = 0x0;
        } bank_selected_gamma_fe1[2:2];

        enum GAMMA_BANK_SELECT_bank_selected_gamma_fe0_enum {
            BANK_0 = 0 { name = "Bank 0"; desc = "bank 0"; };
            BANK_1 = 1 { name = "Bank 1"; desc = "bank 1"; };
        };

        field {
            name = "bank_selected_gamma_fe0";
            desc = "Bank in which the gamma FE0 module is working";
            sw = r;
            hw = w;
            encode = GAMMA_BANK_SELECT_bank_selected_gamma_fe0_enum;
            reset = 0x0;
        } bank_selected_gamma_fe0[1:1];

        enum GAMMA_BANK_SELECT_bank_selected_gamma_rgb_enum {
            BANK_0 = 0 { name = "Bank 0"; desc = "bank 0"; };
            BANK_1 = 1 { name = "Bank 1"; desc = "bank 1"; };
        };

        field {
            name = "bank_selected_gamma_rgb";
            desc = "Bank in which the gamma RGB module is working";
            sw = r;
            hw = w;
            encode = GAMMA_BANK_SELECT_bank_selected_gamma_rgb_enum;
            reset = 0x0;
        } bank_selected_gamma_rgb[0:0];
    } GAMMA_BANK_SELECT @ 0x10588;

    reg {
        name = "Dither control register";
        desc = "DITHER_CTRL is a dither control register.

Data sheet 10.6 DITHER_CTRL (offset 0x20680, printed page 10-209, `hi3516av200--Hi3516AV200-Datasheet.txt` line 77276).";

        enum DITHER_CTRL_shift_mode_enum {
            OUTPUT_LSB_ALIGNED = 0 { name = "Output Lsb Aligned"; desc = "The output is LSB-aligned."; };
            OUTPUT_MSB_ALIGNED = 1 { name = "Output Msb Aligned"; desc = "The output is MSB-aligned."; };
        };

        field {
            name = "shift_mode";
            desc = "Output mode select";
            sw = rw;
            hw = r;
            encode = DITHER_CTRL_shift_mode_enum;
            reset = 0x0;
        } shift_mode[4:4];

        enum DITHER_CTRL_dither_amount_enum {
            OUTPUT_BIT_WIDTH = 0 { name = "Output Bit Width"; desc = "The output bit width is adjusted to nine bits."; };
            OUTPUT_BIT_WIDTH_2 = 1 { name = "Output Bit Width 2"; desc = "The output bit width is adjusted to eight bits."; };
            OUTPUT_BIT_WIDTH_3 = 2 { name = "Output Bit Width 3"; desc = "The output bit width is adjusted to seven bits."; };
            OUTPUT_BIT_WIDTH_4 = 3 { name = "Output Bit Width 4"; desc = "The output bit width is adjusted to six bits."; };
        };

        field {
            name = "dither_amount";
            desc = "Mode select";
            sw = rw;
            hw = r;
            encode = DITHER_CTRL_dither_amount_enum;
            reset = 0x0;
        } dither_amount[2:1];

        enum DITHER_CTRL_enable_dither_enum {
            DISABLED = 0 { name = "Disabled"; desc = "disabled"; };
            ENABLED = 1 { name = "Enabled"; desc = "enabled"; };
        };

        field {
            name = "enable_dither";
            desc = "Dither module enable";
            sw = rw;
            hw = r;
            encode = DITHER_CTRL_enable_dither_enum;
            reset = 0x0;
        } enable_dither[0:0];
    } DITHER_CTRL @ 0x10680;

    reg {
        name = "AE active region register";
        desc = "STATISTICS_AEXP_NODES_USED is an AE active region register.

Data sheet 10.6 STATISTICS_AEXP_NODES_USED (offset 0x20730, printed page 10-210, `hi3516av200--Hi3516AV200-Datasheet.txt` line 77320).";

        field {
            name = "aexp_nodes_used_vertaexp_nodes_used_";
            desc = "Number of AE vertical active regions";
            sw = rw;
            hw = r;
            reset = 0xF;
        } aexp_nodes_used_vertaexp_nodes_used[15:8];

        field {
            name = "vertaexp_nodes_used_horiz";
            desc = "Number of AE horizontal active regions";
            sw = rw;
            hw = r;
            reset = 0x11;
        } vertaexp_nodes_used_horiz[7:0];
    } STATISTICS_AEXP_NODES_USED @ 0x10730;

    reg {
        name = "Plane processed pixel quantity register 0";
        desc = "STATISTICS_PLANE_TOTAL_0 is plane processed pixel quantity register 0.

Data sheet 10.6 STATISTICS_PLANE_TOTAL_0 (offset 0x207A0, printed page 10-210, `hi3516av200--Hi3516AV200-Datasheet.txt` line 77344).";

        field {
            name = "plane_total_0";
            desc = "Number of pixels processed by plane 0";
            sw = r;
            hw = w;
            reset = 0x0;
        } plane_total_0[26:0];
    } STATISTICS_PLANE_TOTAL_0 @ 0x107A0;

    reg {
        name = "Plane processed pixel quantity register 1";
        desc = "STATISTICS_PLANE_TOTAL_1 is plane processed pixel quantity register 1. Hi3516A V200 Professional HD IP Camera SoC

Data sheet 10.6 STATISTICS_PLANE_TOTAL_1 (offset 0x207A4, printed page 10-211, `hi3516av200--Hi3516AV200-Datasheet.txt` line 77373).";

        field {
            name = "plane_total_1";
            desc = "Number of pixels processed by plane 1";
            sw = r;
            hw = w;
            reset = 0x0;
        } plane_total_1[26:0];
    } STATISTICS_PLANE_TOTAL_1 @ 0x107A4;

    reg {
        name = "Plane processed pixel quantity register 2";
        desc = "STATISTICS_PLANE_TOTAL_2 is plane processed pixel quantity register 2.

Data sheet 10.6 STATISTICS_PLANE_TOTAL_2 (offset 0x207A8, printed page 10-211, `hi3516av200--Hi3516AV200-Datasheet.txt` line 77393).";

        field {
            name = "plane_total_2";
            desc = "Number of pixels processed by plane 2";
            sw = r;
            hw = w;
            reset = 0x0;
        } plane_total_2[26:0];
    } STATISTICS_PLANE_TOTAL_2 @ 0x107A8;

    reg {
        name = "Plane processed pixel quantity register 3";
        desc = "STATISTICS_PLANE_TOTAL_3 is plane processed pixel quantity register 3.

Data sheet 10.6 STATISTICS_PLANE_TOTAL_3 (offset 0x207AC, printed page 10-211, `hi3516av200--Hi3516AV200-Datasheet.txt` line 77412).";

        field {
            name = "plane_total_3";
            desc = "Number of pixels processed by plane 3";
            sw = r;
            hw = w;
            reset = 0x0;
        } plane_total_3[26:0];
    } STATISTICS_PLANE_TOTAL_3 @ 0x107AC;

    reg {
        name = "Plane pixel cumulative sum register 0";
        desc = "STATISTICS_PLANE_COUNTED_0 is plane pixel cumulative sum register 0.

Data sheet 10.6 STATISTICS_PLANE_COUNTED_0 (offset 0x207B0, printed page 10-212, `hi3516av200--Hi3516AV200-Datasheet.txt` line 77438).";

        field {
            name = "plane_counted_0";
            desc = "Cumulative sum of plane 0 pixels";
            sw = r;
            hw = w;
            reset = 0x0;
        } plane_counted_0[26:0];
    } STATISTICS_PLANE_COUNTED_0 @ 0x107B0;

    reg {
        name = "Plane pixel cumulative sum register 1";
        desc = "STATISTICS_PLANE_COUNTED_1 is plane pixel cumulative sum register 1.

Data sheet 10.6 STATISTICS_PLANE_COUNTED_1 (offset 0x207B4, printed page 10-212, `hi3516av200--Hi3516AV200-Datasheet.txt` line 77458).";

        field {
            name = "plane_counted_1";
            desc = "Cumulative sum of plane 1 pixels";
            sw = r;
            hw = w;
            reset = 0x0;
        } plane_counted_1[26:0];
    } STATISTICS_PLANE_COUNTED_1 @ 0x107B4;

    reg {
        name = "Plane pixel cumulative sum register 2";
        desc = "STATISTICS_PLANE_COUNTED_2 is plane pixel cumulative sum register 2.

Data sheet 10.6 STATISTICS_PLANE_COUNTED_2 (offset 0x207B8, printed page 10-212, `hi3516av200--Hi3516AV200-Datasheet.txt` line 77477).";

        field {
            name = "plane_counted_2";
            desc = "Cumulative sum of plane 2 pixels";
            sw = r;
            hw = w;
            reset = 0x0;
        } plane_counted_2[26:0];
    } STATISTICS_PLANE_COUNTED_2 @ 0x107B8;

    reg {
        name = "Plane pixel cumulative sum register 3";
        desc = "STATISTICS_PLANE_COUNTED_3 is plane pixel cumulative sum register 3.

Data sheet 10.6 STATISTICS_PLANE_COUNTED_3 (offset 0x207BC, printed page 10-213, `hi3516av200--Hi3516AV200-Datasheet.txt` line 77506).";

        field {
            name = "plane_counted_3";
            desc = "Cumulative sum of plane 3 pixels";
            sw = r;
            hw = w;
            reset = 0x0;
        } plane_counted_3[26:0];
    } STATISTICS_PLANE_COUNTED_3 @ 0x107BC;

    reg {
        name = "Histogram control register";
        desc = "STATISTICS_HISTOGRAM_CTRL is a histogram control register.

Data sheet 10.6 STATISTICS_HISTOGRAM_CTRL (offset 0x207C0, printed page 10-213, `hi3516av200--Hi3516AV200-Datasheet.txt` line 77526).";

        enum STATISTICS_HISTOGRAM_CTRL_plane_mode_enum {
            ALL_PLANES_COLLECTED = 0 { name = "All Planes Collected"; desc = "All planes are collected and placed in one histogram."; };
            FOUR_COLLECTED_BAYER = 1 { name = "Four Collected Bayer"; desc = "The four collected Bayer planes are placed in four independent banks respectively."; };
            RESERVED = 2 { name = "Reserved"; desc = "reserved"; };
            RESERVED_2 = 3 { name = "Reserved 2"; desc = "reserved"; };
            COLLECTED_PLANES_WITH = 4 { name = "Collected Planes With"; desc = "The collected planes with the odd horizontal and vertical coordinates are placed in bank 0, and the remaining planes are placed in bank 1."; };
            COLLECTED_PLANES_WITH_2 = 5 { name = "Collected Planes With 2"; desc = "The collected planes with the even horizontal coordinates and odd vertical coordinates are placed in bank 0, and the remaining planes are placed in bank 1."; };
            COLLECTED_PLANES_WITH_3 = 6 { name = "Collected Planes With 3"; desc = "The collected planes with the odd horizontal coordinates and even vertical coordinates are placed in bank 0, and the remaining planes are placed in bank 1."; };
            COLLECTED_PLANES_WITH_4 = 7 { name = "Collected Planes With 4"; desc = "The collected planes with the even horizontal and vertical coordinates are placed in bank 0, and the remaining planes are placed in bank 1."; };
        };

        field {
            name = "plane_mode";
            desc = "Split mode select";
            sw = rw;
            hw = r;
            encode = STATISTICS_HISTOGRAM_CTRL_plane_mode_enum;
            reset = 0x0;
        } plane_mode[10:8];

        enum STATISTICS_HISTOGRAM_CTRL_offsety_enum {
            LINE_1 = 0 { name = "Line 1"; desc = "line 1"; };
            LINE_2 = 1 { name = "Line 2"; desc = "line 2"; };
        };

        field {
            name = "offsety";
            desc = "Start line select";
            sw = rw;
            hw = r;
            encode = STATISTICS_HISTOGRAM_CTRL_offsety_enum;
            reset = 0x0;
        } offsety[7:7];

        enum STATISTICS_HISTOGRAM_CTRL_skipy_enum {
            EVERY_PIXEL = 0 { name = "Every Pixel"; desc = "every pixel"; };
            EVERY_TWO_PIXELS = 1 { name = "Every Two Pixels"; desc = "every two pixels"; };
            EVERY_THREE_PIXELS = 2 { name = "Every Three Pixels"; desc = "every three pixels"; };
            EVERY_FOUR_PIXELS = 3 { name = "Every Four Pixels"; desc = "every four pixels"; };
            EVERY_FIVE_PIXELS = 4 { name = "Every Five Pixels"; desc = "every five pixels"; };
            EVERY_EIGHT_PIXELS = 5 { name = "Every Eight Pixels"; desc = "every eight pixels Other values: every nine pixels"; };
        };

        field {
            name = "skipy";
            desc = "Histogram extraction interval in the vertical direction";
            sw = rw;
            hw = r;
            encode = STATISTICS_HISTOGRAM_CTRL_skipy_enum;
            reset = 0x0;
        } skipy[6:4];

        enum STATISTICS_HISTOGRAM_CTRL_offsetx_enum {
            COLUMN_1 = 0 { name = "Column 1"; desc = "column 1"; };
            COLUMN_2 = 1 { name = "Column 2"; desc = "column 2"; };
        };

        field {
            name = "offsetx";
            desc = "Start column select";
            sw = rw;
            hw = r;
            encode = STATISTICS_HISTOGRAM_CTRL_offsetx_enum;
            reset = 0x0;
        } offsetx[3:3];

        enum STATISTICS_HISTOGRAM_CTRL_skipx_enum {
            EVERY_TWO_PIXELS = 0 { name = "Every Two Pixels"; desc = "every two pixels"; };
            EVERY_THREE_PIXELS = 1 { name = "Every Three Pixels"; desc = "every three pixels"; };
            EVERY_FOUR_PIXELS = 2 { name = "Every Four Pixels"; desc = "every four pixels"; };
            EVERY_FIVE_PIXELS = 3 { name = "Every Five Pixels"; desc = "every five pixels"; };
            EVERY_EIGHT_PIXELS = 4 { name = "Every Eight Pixels"; desc = "every eight pixels Other values: every nine pixels"; };
        };

        field {
            name = "skipx";
            desc = "Histogram extraction interval in the horizontal direction";
            sw = rw;
            hw = r;
            encode = STATISTICS_HISTOGRAM_CTRL_skipx_enum;
            reset = 0x0;
        } skipx[2:0];
    } STATISTICS_HISTOGRAM_CTRL @ 0x107C0;

    reg {
        name = "Scaling control register";
        desc = "STATISTICS_SCALE is a scaling control register.

Data sheet 10.6 STATISTICS_SCALE (offset 0x207C4, printed page 10-215, `hi3516av200--Hi3516AV200-Datasheet.txt` line 77607).";

        field {
            name = "scale_top";
            desc = "Top scaling ratio 000: 1x 001: 2x 010: 4x 011: 8x 100: 16x Other values: reserved";
            sw = rw;
            hw = r;
            reset = 0x0;
        } scale_top[7:4];

        field {
            name = "scale_bottom";
            desc = "Bottom scaling ratio 000: 1x 001: 2x 010: 4x 011: 8x 100: 16x Other values: reserved";
            sw = rw;
            hw = r;
            reset = 0x0;
        } scale_bottom[3:0];
    } STATISTICS_SCALE @ 0x107C4;

    reg {
        name = "Statistics processed pixel quantity register";
        desc = "STATISTICS_TOTAL_PIXELS is a statistics processed pixel quantity register.

Data sheet 10.6 STATISTICS_TOTAL_PIXELS (offset 0x207C8, printed page 10-215, `hi3516av200--Hi3516AV200-Datasheet.txt` line 77640).";

        field {
            name = "total_pixels";
            desc = "Number of processed pixels (the skipped x and y are also counted)";
            sw = r;
            hw = w;
            reset = 0x0;
        } total_pixels[31:0];
    } STATISTICS_TOTAL_PIXELS @ 0x107C8;

    reg {
        name = "Statistics accumulated pixel quantity register";
        desc = "STATISTICS_COUNTED_PIXELS is a statistics accumulated pixel quantity register. [check] The data-sheet table extraction produced overlapping bit fields for this register; the overlapping entries aexp_nodes_used_vert_peaexp_nodes_used_[31:24], vert_peaexp_nodes_used_horiz_pe[23:16], plane_mode_pe[10:8], offset_y_pe[7:7], skip_y_pe[6:4], offset_x_pe[3:3], skip_x_pe[2:0] were dropped - verify against the printed page.

Data sheet 10.6 STATISTICS_COUNTED_PIXELS (offset 0x207CC, printed page 10-216, `hi3516av200--Hi3516AV200-Datasheet.txt` line 77665).";

        field {
            name = "counted_pixels";
            desc = "Number of accumulated pixels (non-zero weight)";
            sw = r;
            hw = w;
            reset = 0x0;
        } counted_pixels[31:0];
    } STATISTICS_COUNTED_PIXELS @ 0x107CC;

    reg {
        name = "PE scaling control register";
        desc = "STATISTICS_PE_SCALE is a PE scaling control register.

Data sheet 10.6 STATISTICS_PE_SCALE (offset 0x207D4, printed page 10-218, `hi3516av200--Hi3516AV200-Datasheet.txt` line 77776).";

        enum STATISTICS_PE_SCALE_scale_top_pe_enum {
            V_1X = 0 { name = "V 1X"; desc = "1x"; };
            V_2X = 1 { name = "V 2X"; desc = "2x"; };
            V_4X = 2 { name = "V 4X"; desc = "4x"; };
            V_8X = 3 { name = "V 8X"; desc = "8x"; };
            V_16X_OTHER_VALUES = 4 { name = "V 16X Other Values"; desc = "16x Other values: reserved"; };
        };

        field {
            name = "scale_top_pe";
            desc = "Top scaling ratio";
            sw = rw;
            hw = r;
            encode = STATISTICS_PE_SCALE_scale_top_pe_enum;
            reset = 0x0;
        } scale_top_pe[7:4];

        enum STATISTICS_PE_SCALE_scale_bottom_pe_enum {
            V_1X = 0 { name = "V 1X"; desc = "1x"; };
            V_2X = 1 { name = "V 2X"; desc = "2x"; };
            V_4X = 2 { name = "V 4X"; desc = "4x"; };
            V_8X = 3 { name = "V 8X"; desc = "8x"; };
            V_16X_OTHER_VALUES = 4 { name = "V 16X Other Values"; desc = "16x Other values: reserved"; };
        };

        field {
            name = "scale_bottom_pe";
            desc = "Bottom scaling ratio";
            sw = rw;
            hw = r;
            encode = STATISTICS_PE_SCALE_scale_bottom_pe_enum;
            reset = 0x0;
        } scale_bottom_pe[3:0];
    } STATISTICS_PE_SCALE @ 0x107D4;

    reg {
        name = "PE processed pixel quantity register";
        desc = "STATISTICS_PE_TOTAL_PIXELS is a PE processed pixel quantity register.

Data sheet 10.6 STATISTICS_PE_TOTAL_PIXELS (offset 0x207D8, printed page 10-218, `hi3516av200--Hi3516AV200-Datasheet.txt` line 77811).";

        field {
            name = "total_pixels_pe";
            desc = "Number of processed pixels (the skipped x and y are also counted)";
            sw = r;
            hw = w;
            reset = 0x0;
        } total_pixels_pe[31:0];
    } STATISTICS_PE_TOTAL_PIXELS @ 0x107D8;

    reg {
        name = "PE accumulated pixel quantity register";
        desc = "STATISTICS_PE_COUNTED_PIXELS is a PE accumulated pixel quantity register.

Data sheet 10.6 STATISTICS_PE_COUNTED_PIXELS (offset 0x207DC, printed page 10-219, `hi3516av200--Hi3516AV200-Datasheet.txt` line 77836).";

        field {
            name = "counted_pixels_pe";
            desc = "Number of accumulated pixels (non-zero weight)";
            sw = r;
            hw = w;
            reset = 0x0;
        } counted_pixels_pe[31:0];
    } STATISTICS_PE_COUNTED_PIXELS @ 0x107DC;

    reg {
        name = "PE plane processed pixel quantity register 0";
        desc = "STATISTICS_PLANE_TOTAL_PE_0 is PE plane processed pixel quantity register 0.

Data sheet 10.6 STATISTICS_PLANE_TOTAL_PE_0 (offset 0x207E0, printed page 10-219, `hi3516av200--Hi3516AV200-Datasheet.txt` line 77855).";

        field {
            name = "plane_total_pe_0";
            desc = "Number of pixels processed by each plane";
            sw = r;
            hw = w;
            reset = 0x0;
        } plane_total_pe_0[26:0];
    } STATISTICS_PLANE_TOTAL_PE_0 @ 0x107E0;

    reg {
        name = "PE plane processed pixel quantity register 1";
        desc = "STATISTICS_PLANE_TOTAL_PE_1 is PE plane processed pixel quantity register 1.

Data sheet 10.6 STATISTICS_PLANE_TOTAL_PE_1 (offset 0x207E4, printed page 10-219, `hi3516av200--Hi3516AV200-Datasheet.txt` line 77874).";

        field {
            name = "plane_total_pe_1";
            desc = "Number of pixels processed by each plane";
            sw = r;
            hw = w;
            reset = 0x0;
        } plane_total_pe_1[26:0];
    } STATISTICS_PLANE_TOTAL_PE_1 @ 0x107E4;

    reg {
        name = "PE plane processed pixel quantity register 2";
        desc = "STATISTICS_PLANE_TOTAL_PE_2 is PE plane processed pixel quantity register 2.

Data sheet 10.6 STATISTICS_PLANE_TOTAL_PE_2 (offset 0x207E8, printed page 10-220, `hi3516av200--Hi3516AV200-Datasheet.txt` line 77902).";

        field {
            name = "plane_total_pe_2";
            desc = "Number of pixels processed by each plane";
            sw = r;
            hw = w;
            reset = 0x0;
        } plane_total_pe_2[26:0];
    } STATISTICS_PLANE_TOTAL_PE_2 @ 0x107E8;

    reg {
        name = "PE plane processed pixel quantity register 3";
        desc = "STATISTICS_PLANE_TOTAL_PE_3 is PE plane processed pixel quantity register 3. [check] The data-sheet table extraction produced overlapping bit fields for this register; the overlapping entries plane_counted_pe_[26:0], plane_counted_pe_[26:0], plane_counted_pe_[26:0], plane_counted_pe_[26:0] were dropped - verify against the printed page.

Data sheet 10.6 STATISTICS_PLANE_TOTAL_PE_3 (offset 0x207EC, printed page 10-220, `hi3516av200--Hi3516AV200-Datasheet.txt` line 77921).";

        field {
            name = "plane_total_pe_3";
            desc = "plane_total_pe_3";
            sw = r;
            hw = w;
            reset = 0x0;
        } plane_total_pe_3[26:0];
    } STATISTICS_PLANE_TOTAL_PE_3 @ 0x107EC;

    reg {
        name = "Normalized R component pixel sum register";
        desc = "STATISTICS_SUM_R is a normalized R component pixel sum register.

Data sheet 10.6 STATISTICS_SUM_R (offset 0x20800, printed page 10-222, `hi3516av200--Hi3516AV200-Datasheet.txt` line 78057).";

        field {
            name = "sum_r";
            desc = "Normalized R component pixel sum";
            sw = r;
            hw = w;
            reset = 0x0;
        } sum_r[15:0];
    } STATISTICS_SUM_R @ 0x10800;

    reg {
        name = "Normalized Gr component pixel sum register";
        desc = "STATISTICS_SUM_RG is a normalized Gr component pixel sum register.

Data sheet 10.6 STATISTICS_SUM_RG (offset 0x20804, printed page 10-223, `hi3516av200--Hi3516AV200-Datasheet.txt` line 78084).";

        field {
            name = "sum_rg";
            desc = "Normalized Gr component pixel sum";
            sw = r;
            hw = w;
            reset = 0x0;
        } sum_rg[15:0];
    } STATISTICS_SUM_RG @ 0x10804;

    reg {
        name = "Normalized Gb component pixel sum register";
        desc = "STATISTICS_SUM_BG is a normalized Gb component pixel sum register.

Data sheet 10.6 STATISTICS_SUM_BG (offset 0x20808, printed page 10-223, `hi3516av200--Hi3516AV200-Datasheet.txt` line 78104).";

        field {
            name = "sum_bg";
            desc = "Normalized Gb component pixel sum";
            sw = r;
            hw = w;
            reset = 0x0;
        } sum_bg[15:0];
    } STATISTICS_SUM_BG @ 0x10808;

    reg {
        name = "Normalized B component pixel sum register";
        desc = "STATISTICS_SUM_B is a normalized B component pixel sum register. Hi3516A V200 Professional HD IP Camera SoC [check] The data-sheet table extraction produced overlapping bit fields for this register; the overlapping entries ae_sum_nodes_used_vertae_sum_nodes_use[15:8], d_vertae_sum_nodes_used_horiz[7:0] were dropped - verify against the printed page.

Data sheet 10.6 STATISTICS_SUM_B (offset 0x2080C, printed page 10-224, `hi3516av200--Hi3516AV200-Datasheet.txt` line 78132).";

        field {
            name = "sum_b";
            desc = "Normalized B component pixel sum";
            sw = r;
            hw = w;
            reset = 0x0;
        } sum_b[15:0];
    } STATISTICS_SUM_B @ 0x1080C;

    reg {
        name = "Bayer field AWB sum statistics R component average value register";
        desc = "STATISTICS_AVG_R is a Bayer field AWB sum statistics R component average value register. Hi3516A V200 Professional HD IP Camera SoC

Data sheet 10.6 STATISTICS_AVG_R (offset 0x20820, printed page 10-225, `hi3516av200--Hi3516AV200-Datasheet.txt` line 78189).";

        field {
            name = "avg_r";
            desc = "Average value of the R component for Bayer field AWB sum statistics";
            sw = r;
            hw = w;
            reset = 0x0;
        } avg_r[15:0];
    } STATISTICS_AVG_R @ 0x10820;

    reg {
        name = "Bayer field AWB sum statistics G component average value register";
        desc = "STATISTICS_AVG_G is a Bayer field AWB sum statistics G component average value register.

Data sheet 10.6 STATISTICS_AVG_G (offset 0x20824, printed page 10-225, `hi3516av200--Hi3516AV200-Datasheet.txt` line 78212).";

        field {
            name = "avg_g";
            desc = "Average value of the G component for Bayer field AWB sum statistics";
            sw = r;
            hw = w;
            reset = 0x0;
        } avg_g[15:0];
    } STATISTICS_AVG_G @ 0x10824;

    reg {
        name = "Bayer field AWB sum statistics B component average value register";
        desc = "STATISTICS_AVG_B is a Bayer field AWB sum statistics B component average value register.

Data sheet 10.6 STATISTICS_AVG_B (offset 0x20828, printed page 10-225, `hi3516av200--Hi3516AV200-Datasheet.txt` line 78235).";

        field {
            name = "avg_b";
            desc = "Average value of the B component for Bayer field AWB sum statistics";
            sw = r;
            hw = w;
            reset = 0x0;
        } avg_b[15:0];
    } STATISTICS_AVG_B @ 0x10828;

    reg {
        name = "STATISTICS_COUNT_ALL";
        desc = "STATISTICS_COUNT_ALL is a Bayer field AWB sum statistics normalized pixel quantity register for pixels that meet the white point conditions.

Data sheet 10.6 STATISTICS_COUNT_ALL (offset 0x2082C, printed page 10-226, `hi3516av200--Hi3516AV200-Datasheet.txt` line 78266).";

        field {
            name = "count_all";
            desc = "Number of pixels that meet the white point conditions (for Bayer field AWB sum statistics)";
            sw = r;
            hw = w;
            reset = 0x0;
        } count_all[15:0];
    } STATISTICS_COUNT_ALL @ 0x1082C;

    reg {
        name = "Bayer field AWB sum statistics pixel quantity register for pixels below the luminance lower limit";
        desc = "STATISTICS_COUNT_MIN is a Bayer field AWB sum statistics pixel quantity register for pixels below the luminance lower limit.

Data sheet 10.6 STATISTICS_COUNT_MIN (offset 0x20830, printed page 10-226, `hi3516av200--Hi3516AV200-Datasheet.txt` line 78288).";

        field {
            name = "count_min";
            desc = "Number of pixels below the luminance lower limit (for Bayer field AWB sum statistics)";
            sw = r;
            hw = w;
            reset = 0x0;
        } count_min[15:0];
    } STATISTICS_COUNT_MIN @ 0x10830;

    reg {
        name = "Bayer field AWB sum statistics pixel quantity register for pixels above the luminance upper limit";
        desc = "STATISTICS_COUNT_MAX is a Bayer field AWB sum statistics pixel quantity register for pixels above the luminance upper limit. Hi3516A V200 Professional HD IP Camera SoC [check] The data-sheet table extraction produced overlapping bit fields for this register; the overlapping entries awb_sum_nodes_used_vertawb_sum_nodes_u[15:8], sed_vertawb_sum_nodes_used_horiz[7:0] were dropped - verify against the printed page.

Data sheet 10.6 STATISTICS_COUNT_MAX (offset 0x20834, printed page 10-227, `hi3516av200--Hi3516AV200-Datasheet.txt` line 78320).";

        field {
            name = "count_max";
            desc = "Number of pixels above the luminance upper limit (for Bayer field AWB sum statistics)";
            sw = r;
            hw = w;
            reset = 0x0;
        } count_max[15:0];
    } STATISTICS_COUNT_MAX @ 0x10834;

    reg {
        name = "Bayer field AWB sum statistics white point luminance lower limit register";
        desc = "STATISTICS_MIN_THRESHOLD is a Bayer field AWB sum statistics white point luminance lower limit register. Hi3516A V200 Professional HD IP Camera SoC

Data sheet 10.6 STATISTICS_MIN_THRESHOLD (offset 0x2083C, printed page 10-228, `hi3516av200--Hi3516AV200-Datasheet.txt` line 78379).";

        field {
            name = "min_threshold";
            desc = "Luminance lower limit for the white points of Bayer field AWB sum statistics";
            sw = rw;
            hw = r;
            reset = 0x10;
        } min_threshold[11:0];
    } STATISTICS_MIN_THRESHOLD @ 0x1083C;

    reg {
        name = "Bayer field AWB sum statistics white point luminance upper limit register";
        desc = "STATISTICS_MAX_THRESHOLD is a Bayer field AWB sum statistics white point luminance upper limit register.

Data sheet 10.6 STATISTICS_MAX_THRESHOLD (offset 0x20840, printed page 10-228, `hi3516av200--Hi3516AV200-Datasheet.txt` line 78402).";

        field {
            name = "max_threshold";
            desc = "Luminance upper limit for the white points of Bayer field AWB sum statistics";
            sw = rw;
            hw = r;
            reset = 0xFF0;
        } max_threshold[11:0];
    } STATISTICS_MAX_THRESHOLD @ 0x10840;

    reg {
        name = "AWB sum clipping register";
        desc = "STATISTICS_AWB_SUM_CLIP is an AWB sum clipping register. Hi3516A V200 Professional HD IP Camera SoC

Data sheet 10.6 STATISTICS_AWB_SUM_CLIP (offset 0x20844, printed page 10-229, `hi3516av200--Hi3516AV200-Datasheet.txt` line 78433).";

        field {
            name = "max_clip";
            desc = "Upper threshold clipping for the AWB sum";
            sw = rw;
            hw = r;
            reset = 0x0;
        } max_clip[1:1];

        field {
            name = "min_clip";
            desc = "Lower threshold clipping for the AWB sum";
            sw = rw;
            hw = r;
            reset = 0x0;
        } min_clip[0:0];
    } STATISTICS_AWB_SUM_CLIP @ 0x10844;

    reg {
        name = "Bayer field AWB statistics white point chrominance R/G upper/lower limit register";
        desc = "STATISTICS_CR_REF is a Bayer field AWB statistics white point chrominance R/G upper/lower limit register.

Data sheet 10.6 STATISTICS_CR_REF (offset 0x20848, printed page 10-229, `hi3516av200--Hi3516AV200-Datasheet.txt` line 78460).";

        field {
            name = "cr_ref_min_awb_sum";
            desc = "Chrominance R/G lower limit for the white points of Bayer field AWB statistics, 4.8-bit unsigned fixed-point number";
            sw = rw;
            hw = r;
            reset = 0x40;
        } cr_ref_min_awb_sum[27:16];

        field {
            name = "cr_ref_max_awb_sum";
            desc = "Chrominance R/G upper limit for the white points of Bayer field AWB statistics, 4.8-bit unsigned fixed-point number";
            sw = rw;
            hw = r;
            reset = 0x1FF;
        } cr_ref_max_awb_sum[11:0];
    } STATISTICS_CR_REF @ 0x10848;

    reg {
        name = "Bayer field AWB statistics white point chrominance B/G upper/lower limit register";
        desc = "STATISTICS_CB_REF is a Bayer field AWB statistics white point chrominance B/G upper/lower limit register. Hi3516A V200 Professional HD IP Camera SoC

Data sheet 10.6 STATISTICS_CB_REF (offset 0x2084C, printed page 10-230, `hi3516av200--Hi3516AV200-Datasheet.txt` line 78495).";

        field {
            name = "cb_ref_min_awb_sum";
            desc = "Chrominance B/G lower limit for the white points of Bayer field AWB statistics, 4.8-bit unsigned fixed-point number";
            sw = rw;
            hw = r;
            reset = 0x40;
        } cb_ref_min_awb_sum[27:16];

        field {
            name = "cb_ref_max_awb_sum";
            desc = "Chrominance B/G upper limit for the white points of Bayer field AWB statistics, 4.8-bit unsigned fixed-point number";
            sw = rw;
            hw = r;
            reset = 0x1FF;
        } cb_ref_max_awb_sum[11:0];
    } STATISTICS_CB_REF @ 0x1084C;

    reg {
        name = "Bayer field AWB statistics white point chrominance R/G hexagon limit register";
        desc = "STATISTICS_CR_HL_REF is a Bayer field AWB statistics white point chrominance R/G hexagon limit register.

Data sheet 10.6 STATISTICS_CR_HL_REF (offset 0x20850, printed page 10-230, `hi3516av200--Hi3516AV200-Datasheet.txt` line 78522).";

        field {
            name = "cr_ref_low_awb_sum";
            desc = "Chrominance R/G hexagon lower limit for the white points of Bayer field AWB statistics, 4.8-bit unsigned fixed-point number";
            sw = rw;
            hw = r;
            reset = 0x0;
        } cr_ref_low_awb_sum[27:16];

        field {
            name = "cr_ref_high_awb_sum";
            desc = "Chrominance R/G hexagon upper limit for the white points of Bayer field AWB statistics, 4.8-bit unsigned fixed-point number";
            sw = rw;
            hw = r;
            reset = 0xFFF;
        } cr_ref_high_awb_sum[11:0];
    } STATISTICS_CR_HL_REF @ 0x10850;

    reg {
        name = "Bayer field AWB statistics white point chrominance B/G hexagon limit register";
        desc = "STATISTICS_CB_HL_REF is a Bayer field AWB statistics white point chrominance B/G hexagon limit register. Hi3516A V200 Professional HD IP Camera SoC

Data sheet 10.6 STATISTICS_CB_HL_REF (offset 0x20854, printed page 10-231, `hi3516av200--Hi3516AV200-Datasheet.txt` line 78558).";

        field {
            name = "cb_ref_low_awb_sum";
            desc = "Chrominance B/G hexagon lower limit for the white points of Bayer field AWB statistics, 4.8-bit unsigned fixed-point number";
            sw = rw;
            hw = r;
            reset = 0x0;
        } cb_ref_low_awb_sum[27:16];

        field {
            name = "cb_ref_high_awb_sum";
            desc = "Chrominance B/G hexagon upper limit for the white points of Bayer field AWB statistics, 4.8-bit unsigned fixed-point number";
            sw = rw;
            hw = r;
            reset = 0xFFF;
        } cb_ref_high_awb_sum[11:0];
    } STATISTICS_CB_HL_REF @ 0x10854;

    reg {
        name = "Status reset register";
        desc = "FRAME_STATS_STATS_RESET is a status reset register.

Data sheet 10.6 FRAME_STATS_STATS_RESET (offset 0x20900, printed page 10-231, `hi3516av200--Hi3516AV200-Datasheet.txt` line 78582).";

        field {
            name = "stats_reset";
            desc = "Reset the frame statistics register and start periodic sampling. The maximum count value for all frames is 2 31 .";
            sw = rw;
            hw = r;
            reset = 0x0;
        } stats_reset[0:0];
    } FRAME_STATS_STATS_RESET @ 0x10900;

    reg {
        name = "Status hold register";
        desc = "FRAME_STATS_STATS_HOLD is a status hold register. Hi3516A V200 Professional HD IP Camera SoC [check] The data-sheet table extraction produced overlapping bit fields for this register; the overlapping entries active_width_min[31:0], active_width_max[31:0], active_width_sum[31:0], active_width_num[31:0], active_height_min[31:0], active_height_max[31:0], active_height_sum[31:0], active_height_num[31:0] were dropped - verify against the printed page.

Data sheet 10.6 FRAME_STATS_STATS_HOLD (offset 0x20904, printed page 10-232, `hi3516av200--Hi3516AV200-Datasheet.txt` line 78619).";

        field {
            name = "stats_hold";
            desc = "When this field is set to 1, the statistics register is forbidden to be updated.";
            sw = rw;
            hw = r;
            reset = 0x0;
        } stats_hold[0:0];
    } FRAME_STATS_STATS_HOLD @ 0x10904;

    reg {
        name = "Minimum horizontal blanking register";
        desc = "FRAME_STATS_HBLANK_MIN is a minimum horizontal blanking register.

Data sheet 10.6 FRAME_STATS_HBLANK_MIN (offset 0x20930, printed page 10-235, `hi3516av200--Hi3516AV200-Datasheet.txt` line 78843).";

        field {
            name = "hblank_min";
            desc = "Minimum horizontal blanking";
            sw = r;
            hw = w;
            reset = 0xFFFFFFFF;
        } hblank_min[31:0];
    } FRAME_STATS_HBLANK_MIN @ 0x10930;

    reg {
        name = "Maximum horizontal blanking register";
        desc = "FRAME_STATS_HBLANK_MAX is a maximum horizontal blanking register.

Data sheet 10.6 FRAME_STATS_HBLANK_MAX (offset 0x20934, printed page 10-235, `hi3516av200--Hi3516AV200-Datasheet.txt` line 78862).";

        field {
            name = "hblank_max";
            desc = "Maximum horizontal blanking";
            sw = r;
            hw = w;
            reset = 0x0;
        } hblank_max[31:0];
    } FRAME_STATS_HBLANK_MAX @ 0x10934;

    reg {
        name = "Horizontal blanking sum register";
        desc = "FRAME_STATS_HBLANK_SUM is a horizontal blanking sum register.

Data sheet 10.6 FRAME_STATS_HBLANK_SUM (offset 0x20938, printed page 10-236, `hi3516av200--Hi3516AV200-Datasheet.txt` line 78888).";

        field {
            name = "hblank_sum";
            desc = "Horizontal blanking sum";
            sw = r;
            hw = w;
            reset = 0x0;
        } hblank_sum[31:0];
    } FRAME_STATS_HBLANK_SUM @ 0x10938;

    reg {
        name = "Horizontal blanking register";
        desc = "FRAME_STATS_HBLANK_NUM is a horizontal blanking register.

Data sheet 10.6 FRAME_STATS_HBLANK_NUM (offset 0x2093C, printed page 10-236, `hi3516av200--Hi3516AV200-Datasheet.txt` line 78906).";

        field {
            name = "hblank_num";
            desc = "Horizontal blanking";
            sw = r;
            hw = w;
            reset = 0x0;
        } hblank_num[31:0];
    } FRAME_STATS_HBLANK_NUM @ 0x1093C;

    reg {
        name = "Minimum vertical blanking register";
        desc = "FRAME_STATS_VBLANK_MIN is a minimum vertical blanking register.

Data sheet 10.6 FRAME_STATS_VBLANK_MIN (offset 0x20940, printed page 10-236, `hi3516av200--Hi3516AV200-Datasheet.txt` line 78925).";

        field {
            name = "vblank_min";
            desc = "Minimum vertical blanking";
            sw = r;
            hw = w;
            reset = 0xFFFFFFFF;
        } vblank_min[31:0];
    } FRAME_STATS_VBLANK_MIN @ 0x10940;

    reg {
        name = "Maximum vertical blanking register";
        desc = "FRAME_STATS_VBLANK_MAX is a maximum vertical blanking register.

Data sheet 10.6 FRAME_STATS_VBLANK_MAX (offset 0x20944, printed page 10-237, `hi3516av200--Hi3516AV200-Datasheet.txt` line 78949).";

        field {
            name = "vblank_max";
            desc = "Maximum vertical blanking";
            sw = r;
            hw = w;
            reset = 0x0;
        } vblank_max[31:0];
    } FRAME_STATS_VBLANK_MAX @ 0x10944;

    reg {
        name = "Vertical blanking sum register";
        desc = "FRAME_STATS_VBLANK_SUM is a vertical blanking sum register.

Data sheet 10.6 FRAME_STATS_VBLANK_SUM (offset 0x20948, printed page 10-237, `hi3516av200--Hi3516AV200-Datasheet.txt` line 78968).";

        field {
            name = "vblank_sum";
            desc = "Vertical blanking sum";
            sw = r;
            hw = w;
            reset = 0x0;
        } vblank_sum[31:0];
    } FRAME_STATS_VBLANK_SUM @ 0x10948;

    reg {
        name = "Vertical blanking register";
        desc = "FRAME_STATS_VBLANK_NUM is a vertical blanking register.

Data sheet 10.6 FRAME_STATS_VBLANK_NUM (offset 0x2094C, printed page 10-237, `hi3516av200--Hi3516AV200-Datasheet.txt` line 78986).";

        field {
            name = "vblank_num";
            desc = "Vertical blanking";
            sw = r;
            hw = w;
            reset = 0x0;
        } vblank_num[31:0];
    } FRAME_STATS_VBLANK_NUM @ 0x1094C;

    reg {
        name = "WDR 4 noise offset register";
        desc = "NOISE_PROFILE_WDR_4 is a WDR 4 noise offset register.

Data sheet 10.6 NOISE_PROFILE_WDR_4 (offset 0x21004, printed page 10-238, `hi3516av200--Hi3516AV200-Datasheet.txt` line 79011).";

        field {
            name = "long_noise_offset";
            desc = "Noise offset, 5.4-bit unsigned floating-point number";
            sw = rw;
            hw = r;
            reset = 0x40;
        } long_noise_offset[8:0];
    } NOISE_PROFILE_WDR_4 @ 0x11004;

    reg {
        name = "WDR 3 noise offset register";
        desc = "NOISE_PROFILE_WDR_3 is a WDR 3 noise offset register.

Data sheet 10.6 NOISE_PROFILE_WDR_3 (offset 0x21014, printed page 10-238, `hi3516av200--Hi3516AV200-Datasheet.txt` line 79031).";

        field {
            name = "med1_noise_offset";
            desc = "Noise offset, 5.4-bit unsigned floating-point number";
            sw = rw;
            hw = r;
            reset = 0x40;
        } med1_noise_offset[8:0];
    } NOISE_PROFILE_WDR_3 @ 0x11014;

    reg {
        name = "WDR 2 noise offset register";
        desc = "NOISE_PROFILE_WDR_2 is a WDR 2 noise offset register.

Data sheet 10.6 NOISE_PROFILE_WDR_2 (offset 0x21024, printed page 10-238, `hi3516av200--Hi3516AV200-Datasheet.txt` line 79050).";

        field {
            name = "med2_noise_offset";
            desc = "Noise offset, 5.4-bit unsigned floating-point number";
            sw = rw;
            hw = r;
            reset = 0x40;
        } med2_noise_offset[8:0];
    } NOISE_PROFILE_WDR_2 @ 0x11024;

    reg {
        name = "WDR 1 noise offset register";
        desc = "NOISE_PROFILE_WDR_1 is a WDR 1 noise offset register. [check] The data-sheet table extraction produced overlapping bit fields for this register; the overlapping entries weight_lut_1[15:8], weight_lut_0[7:0], weight_lut_3[31:24], weight_lut_2[23:16], weight_lut_1[15:8], weight_lut_0[7:0], weight_lut_3[31:24], weight_lut_2[23:16], weight_lut_1[15:8], weight_lut_0[7:0], weight_lut_3[31:24], weight_lut_2[23:16], weight_lut_1[15:8], weight_lut_0[7:0] were dropped - verify against the printed page.

Data sheet 10.6 NOISE_PROFILE_WDR_1 (offset 0x21034, printed page 10-239, `hi3516av200--Hi3516AV200-Datasheet.txt` line 79079).";

        field {
            name = "weight_lut_3";
            desc = "weight_lut_3";
            sw = rw;
            hw = r;
            reset = 0x0;
        } weight_lut_3[31:24];

        field {
            name = "weight_lut_2";
            desc = "weight_lut_2";
            sw = rw;
            hw = r;
            reset = 0x0;
        } weight_lut_2[23:16];

        field {
            name = "short_noise_offset";
            desc = "Noise offset, 5.4-bit unsigned floating-point number";
            sw = rw;
            hw = r;
            reset = 0x40;
        } short_noise_offset[8:0];
    } NOISE_PROFILE_WDR_1 @ 0x11034;

    reg {
        name = "Radial LUT 0 register";
        desc = "DNR_SHADING is a radial LUT 0 register.

Data sheet 10.6 DNR_SHADING (offset 0x21540, printed page 10-241, `hi3516av200--Hi3516AV200-Datasheet.txt` line 79219).";

        field {
            name = "rm_shading_lut_3";
            desc = "Radial LUT data 3 (33 data segments in total)";
            sw = rw;
            hw = r;
            reset = 0x10;
        } rm_shading_lut_3[31:24];

        field {
            name = "rm_shading_lut_2";
            desc = "Radial LUT data 2 (33 data segments in total)";
            sw = rw;
            hw = r;
            reset = 0x10;
        } rm_shading_lut_2[23:16];

        field {
            name = "rm_shading_lut_1";
            desc = "Radial LUT data 1 (33 data segments in total)";
            sw = rw;
            hw = r;
            reset = 0x10;
        } rm_shading_lut_1[15:8];

        field {
            name = "rm_shading_lut_0";
            desc = "Radial LUT data 0 (33 data segments in total)";
            sw = rw;
            hw = r;
            reset = 0x10;
        } rm_shading_lut_0[7:0];
    } DNR_SHADING[8] @ 0x11540 += 0x4;

    reg {
        name = "Radial LUT 1 register";
        desc = "DNR_SHADING_LAST is a radial LUT 1 register. Hi3516A V200 Professional HD IP Camera SoC [check] The data-sheet table extraction produced overlapping bit fields for this register; the overlapping entries weight_lut_0[7:0], weight_lut_3[31:24], weight_lut_2[23:16], weight_lut_1[15:8], weight_lut_0[7:0], weight_lut_3[31:24], weight_lut_2[23:16], weight_lut_1[15:8], weight_lut_0[7:0], weight_lut_3[31:24], weight_lut_2[23:16], weight_lut_1[15:8], weight_lut_0[7:0] were dropped - verify against the printed page.

Data sheet 10.6 DNR_SHADING_LAST (offset 0x21560, printed page 10-242, `hi3516av200--Hi3516AV200-Datasheet.txt` line 79250).";

        field {
            name = "weight_lut_3";
            desc = "weight_lut_3";
            sw = rw;
            hw = r;
            reset = 0x0;
        } weight_lut_3[31:24];

        field {
            name = "weight_lut_2";
            desc = "weight_lut_2";
            sw = rw;
            hw = r;
            reset = 0x0;
        } weight_lut_2[23:16];

        field {
            name = "weight_lut_1";
            desc = "weight_lut_1";
            sw = rw;
            hw = r;
            reset = 0x0;
        } weight_lut_1[15:8];

        field {
            name = "rm_shading_lut_32";
            desc = "rm_shading_lut_32";
            sw = rw;
            hw = r;
            reset = 0x10;
        } rm_shading_lut_32[7:0];
    } DNR_SHADING_LAST @ 0x11560;

    reg {
        name = "DNR noise distribution table register";
        desc = "NOISE_PROFILE_LUT is a DNR noise distribution table register.

Data sheet 10.6 NOISE_PROFILE_LUT (offset 0x21800, printed page 10-244, `hi3516av200--Hi3516AV200-Datasheet.txt` line 79390).";

        field {
            name = "weightlut_3";
            desc = "DNR noise distribution weight 3, calculated during the calibration";
            sw = rw;
            hw = r;
            reset = 0x0;
        } weightlut_3[31:24];

        field {
            name = "weightlut_2";
            desc = "DNR noise distribution weight 2, calculated during the calibration";
            sw = rw;
            hw = r;
            reset = 0x0;
        } weightlut_2[23:16];

        field {
            name = "weightlut_1";
            desc = "DNR noise distribution weight 1, calculated during the calibration";
            sw = rw;
            hw = r;
            reset = 0x0;
        } weightlut_1[15:8];

        field {
            name = "weightlut_0";
            desc = "DNR noise distribution weight 0, calculated during the calibration";
            sw = rw;
            hw = r;
            reset = 0x0;
        } weightlut_0[7:0];
    } NOISE_PROFILE_LUT[32] @ 0x11800 += 0x4;

    reg {
        name = "Demosaic noise distribution table register";
        desc = "NOISE_PROFILE_DEMOSAIC_LUT is a demosaic noise distribution table register. Hi3516A V200 Professional HD IP Camera SoC

Data sheet 10.6 NOISE_PROFILE_DEMOSAIC_LUT (offset 0x21880, printed page 10-245, `hi3516av200--Hi3516AV200-Datasheet.txt` line 79421).";

        field {
            name = "weightlut_3";
            desc = "Demosaic noise distribution weight 3";
            sw = rw;
            hw = r;
            reset = 0x0;
        } weightlut_3[31:24];

        field {
            name = "weightlut_2";
            desc = "Demosaic noise distribution weight 2";
            sw = rw;
            hw = r;
            reset = 0x0;
        } weightlut_2[23:16];

        field {
            name = "weightlut_1";
            desc = "Demosaic noise distribution weight 1";
            sw = rw;
            hw = r;
            reset = 0x0;
        } weightlut_1[15:8];

        field {
            name = "weightlut_0";
            desc = "Demosaic noise distribution weight 0";
            sw = rw;
            hw = r;
            reset = 0x0;
        } weightlut_0[7:0];
    } NOISE_PROFILE_DEMOSAIC_LUT[32] @ 0x11880 += 0x4;

    reg {
        name = "AE block weight register";
        desc = "AEXP_WEIGHT is an AE block weight register.

Data sheet 10.6 AEXP_WEIGHT (offset 0x21900, printed page 10-245, `hi3516av200--Hi3516AV200-Datasheet.txt` line 79443).";

        field {
            name = "aexp_weight0_3";
            desc = "AE block weight 0_3";
            sw = rw;
            hw = r;
            reset = 0xF;
        } aexp_weight0_3[27:24];

        field {
            name = "aexp_weight0_2";
            desc = "AE block weight 0_2";
            sw = rw;
            hw = r;
            reset = 0xF;
        } aexp_weight0_2[19:16];

        field {
            name = "aexp_weight0_1";
            desc = "AE block weight 0_1";
            sw = rw;
            hw = r;
            reset = 0xF;
        } aexp_weight0_1[11:8];

        field {
            name = "aexp_weight0_0";
            desc = "AE block weight 0_0";
            sw = rw;
            hw = r;
            reset = 0xF;
        } aexp_weight0_0[3:0];
    } AEXP_WEIGHT[63] @ 0x11900 += 0x4;

    reg {
        name = "AE last block weight register";
        desc = "AEXP_WEIGHT_LAST is an AE last block weight register. Hi3516A V200 Professional HD IP Camera SoC

Data sheet 10.6 AEXP_WEIGHT_LAST (offset 0x219FC, printed page 10-246, `hi3516av200--Hi3516AV200-Datasheet.txt` line 79480).";

        field {
            name = "aexp_weight16_14";
            desc = "AE block weight 16_14";
            sw = rw;
            hw = r;
            reset = 0xF;
        } aexp_weight16_14[19:16];

        field {
            name = "aexp_weight16_13";
            desc = "AE block weight 16_13";
            sw = rw;
            hw = r;
            reset = 0xF;
        } aexp_weight16_13[11:8];

        field {
            name = "aexp_weight16_12";
            desc = "AE block weight 16_12";
            sw = rw;
            hw = r;
            reset = 0xF;
        } aexp_weight16_12[3:0];
    } AEXP_WEIGHT_LAST @ 0x119FC;

    reg {
        name = "AE PE block weight register";
        desc = "AEXP_PE_WEIGHT is an AE PE block weight register.

Data sheet 10.6 AEXP_PE_WEIGHT (offset 0x21A00, printed page 10-246, `hi3516av200--Hi3516AV200-Datasheet.txt` line 79506).";

        field {
            name = "aexp_pe_weight0_";
            desc = "AE PE block weight 0_3";
            sw = rw;
            hw = r;
            reset = 0xF;
        } aexp_pe_weight0[27:24];

        field {
            name = "aexp_pe_weight0_";
            desc = "AE PE block weight 0_2";
            sw = rw;
            hw = r;
            reset = 0xF;
        } aexp_pe_weight0_2[19:16];

        field {
            name = "aexp_pe_weight0_";
            desc = "AE PE block weight 0_1";
            sw = rw;
            hw = r;
            reset = 0xF;
        } aexp_pe_weight0_3[11:8];

        field {
            name = "aexp_pe_weight0_";
            desc = "AE PE block weight 0_0";
            sw = rw;
            hw = r;
            reset = 0xF;
        } aexp_pe_weight0_4[3:0];
    } AEXP_PE_WEIGHT[63] @ 0x11A00 += 0x4;

    reg {
        name = "AE PE last block weight register";
        desc = "AEXP_PE_WEIGHT_LAST is an AE PE last block weight register.

Data sheet 10.6 AEXP_PE_WEIGHT_LAST (offset 0x21AFC, printed page 10-247, `hi3516av200--Hi3516AV200-Datasheet.txt` line 79552).";

        field {
            name = "aexp_pe_weight16_14";
            desc = "AE PE block weight 16_14";
            sw = rw;
            hw = r;
            reset = 0xF;
        } aexp_pe_weight16_14[19:16];

        field {
            name = "aexp_pe_weight16_13";
            desc = "AE PE block weight 16_13";
            sw = rw;
            hw = r;
            reset = 0xF;
        } aexp_pe_weight16_13[11:8];

        field {
            name = "aexp_pe_weight16_12";
            desc = "AE PE block weight 16_12";
            sw = rw;
            hw = r;
            reset = 0xF;
        } aexp_pe_weight16_12[3:0];
    } AEXP_PE_WEIGHT_LAST @ 0x11AFC;

    reg {
        name = "AWB block weight register";
        desc = "AWB_WEIGHT is an AWB block weight register.

Data sheet 10.6 AWB_WEIGHT (offset 0x21B00, printed page 10-247, `hi3516av200--Hi3516AV200-Datasheet.txt` line 79584).";

        field {
            name = "awb_weight0_3";
            desc = "AWB block weight 0_3";
            sw = rw;
            hw = r;
            reset = 0xF;
        } awb_weight0_3[27:24];

        field {
            name = "awb_weight0_2";
            desc = "AWB block weight 0_2";
            sw = rw;
            hw = r;
            reset = 0xF;
        } awb_weight0_2[19:16];

        field {
            name = "awb_weight0_1";
            desc = "AWB block weight 0_1";
            sw = rw;
            hw = r;
            reset = 0xF;
        } awb_weight0_1[11:8];

        field {
            name = "awb_weight0_0";
            desc = "AWB block weight 0_0";
            sw = rw;
            hw = r;
            reset = 0xF;
        } awb_weight0_0[3:0];
    } AWB_WEIGHT[256] @ 0x11B00 += 0x4;

    reg {
        name = "GAMMA_FE0 bank 0 lookup table register";
        desc = "GAMMA_FE0_MEM0 is a GAMMA_FE0 bank 0 lookup table register.

Data sheet 10.6 GAMMA_FE0_MEM0 (offset 0x22800, printed page 10-248, `hi3516av200--Hi3516AV200-Datasheet.txt` line 79620).";

        field {
            name = "data0";
            desc = "GAMMA_FE0 bank 0 lookup table";
            sw = rw;
            hw = r;
            reset = 0x0;
        } data0[19:0];
    } GAMMA_FE0_MEM0[33] @ 0x12800 += 0x4;

    reg {
        name = "GAMMA_FE0 bank 1 lookup table register";
        desc = "GAMMA_FE0_MEM1 is a GAMMA_FE0 bank 1 lookup table register.

Data sheet 10.6 GAMMA_FE0_MEM1 (offset 0x22900, printed page 10-248, `hi3516av200--Hi3516AV200-Datasheet.txt` line 79639).";

        field {
            name = "data0";
            desc = "GAMMA_FE0 bank 1 lookup table";
            sw = rw;
            hw = r;
            reset = 0x0;
        } data0[19:0];
    } GAMMA_FE0_MEM1[33] @ 0x12900 += 0x4;

    reg {
        name = "GAMMA_FE1 bank 0 lookup table register";
        desc = "GAMMA_FE1_MEM0 is a GAMMA_FE1 bank 0 lookup table register. Hi3516A V200 Professional HD IP Camera SoC

Data sheet 10.6 GAMMA_FE1_MEM0 (offset 0x23000, printed page 10-249, `hi3516av200--Hi3516AV200-Datasheet.txt` line 79667).";

        field {
            name = "data0";
            desc = "GAMMA_FE1 bank 0 lookup table";
            sw = rw;
            hw = r;
            reset = 0x0;
        } data0[19:0];
    } GAMMA_FE1_MEM0[257] @ 0x13000 += 0x4;

    reg {
        name = "GAMMA_FE1 bank 1 lookup table register";
        desc = "GAMMA_FE1_MEM1 is a GAMMA_FE1 bank 1 lookup table register.

Data sheet 10.6 GAMMA_FE1_MEM1 (offset 0x23800, printed page 10-249, `hi3516av200--Hi3516AV200-Datasheet.txt` line 79687).";

        field {
            name = "data0";
            desc = "GAMMA_FE1 bank 1 lookup table";
            sw = rw;
            hw = r;
            reset = 0x0;
        } data0[19:0];
    } GAMMA_FE1_MEM1[257] @ 0x13800 += 0x4;

    reg {
        name = "GAMMA_BE0 bank 0 lookup table register";
        desc = "GAMMA_BE0_MEM0 is a GAMMA_BE0 bank 0 lookup table register.

Data sheet 10.6 GAMMA_BE0_MEM0 (offset 0x24800, printed page 10-249, `hi3516av200--Hi3516AV200-Datasheet.txt` line 79706).";

        field {
            name = "data0";
            desc = "GAMMA_BE0 bank 0 lookup table";
            sw = rw;
            hw = r;
            reset = 0x0;
        } data0[19:0];
    } GAMMA_BE0_MEM0[33] @ 0x14800 += 0x4;

    reg {
        name = "GAMMA_BE0 bank 1 lookup table register";
        desc = "GAMMA_BE0_MEM1 is a GAMMA_BE0 bank 1 lookup table register.

Data sheet 10.6 GAMMA_BE0_MEM1 (offset 0x24900, printed page 10-250, `hi3516av200--Hi3516AV200-Datasheet.txt` line 79732).";

        field {
            name = "data0";
            desc = "GAMMA_BE0 bank 1 lookup table";
            sw = rw;
            hw = r;
            reset = 0x0;
        } data0[19:0];
    } GAMMA_BE0_MEM1[33] @ 0x14900 += 0x4;

    reg {
        name = "GAMMA_BE1 bank 0 lookup table register";
        desc = "GAMMA_BE1_MEM0 is a GAMMA_BE1 bank 0 lookup table register.

Data sheet 10.6 GAMMA_BE1_MEM0 (offset 0x25000, printed page 10-250, `hi3516av200--Hi3516AV200-Datasheet.txt` line 79752).";

        field {
            name = "data0";
            desc = "GAMMA_BE1 bank 0 lookup table";
            sw = rw;
            hw = r;
            reset = 0x0;
        } data0[19:0];
    } GAMMA_BE1_MEM0[257] @ 0x15000 += 0x4;

    reg {
        name = "GAMMA_BE1 bank 1 lookup table register";
        desc = "GAMMA_BE1_MEM1 is a GAMMA_BE1 bank 1 lookup table register.

Data sheet 10.6 GAMMA_BE1_MEM1 (offset 0x25800, printed page 10-250, `hi3516av200--Hi3516AV200-Datasheet.txt` line 79771).";

        field {
            name = "data0";
            desc = "GAMMA_BE1 bank 1 lookup table";
            sw = rw;
            hw = r;
            reset = 0x0;
        } data0[19:0];
    } GAMMA_BE1_MEM1[257] @ 0x15800 += 0x4;

    reg {
        name = "RADIAL_SHADING R component lookup table register";
        desc = "RADIAL_SHADING_MEM_R is a RADIAL_SHADING R component lookup table register.

Data sheet 10.6 RADIAL_SHADING_MEM_R (offset 0x26000, printed page 10-251, `hi3516av200--Hi3516AV200-Datasheet.txt` line 79800).";

        field {
            name = "data0";
            desc = "RADIAL_SHADING R component lookup table";
            sw = rw;
            hw = r;
            reset = 0x1000;
        } data0[15:0];
    } RADIAL_SHADING_MEM_R[129] @ 0x16000 += 0x4;

    reg {
        name = "RADIAL_SHADING G component lookup table register";
        desc = "RADIAL_SHADING_MEM_G is a RADIAL_SHADING G component lookup table register.

Data sheet 10.6 RADIAL_SHADING_MEM_G (offset 0x26400, printed page 10-251, `hi3516av200--Hi3516AV200-Datasheet.txt` line 79820).";

        field {
            name = "data0";
            desc = "RADIAL_SHADING G component lookup table";
            sw = rw;
            hw = r;
            reset = 0x1000;
        } data0[15:0];
    } RADIAL_SHADING_MEM_G[129] @ 0x16400 += 0x4;

    reg {
        name = "RADIAL_SHADING B component lookup table register";
        desc = "RADIAL_SHADING_MEM_B is a RADIAL_SHADING B component lookup table register. Hi3516A V200 Professional HD IP Camera SoC

Data sheet 10.6 RADIAL_SHADING_MEM_B (offset 0x26800, printed page 10-252, `hi3516av200--Hi3516AV200-Datasheet.txt` line 79848).";

        field {
            name = "data0";
            desc = "RADIAL_SHADING B component lookup table";
            sw = rw;
            hw = r;
            reset = 0x1000;
        } data0[15:0];
    } RADIAL_SHADING_MEM_B[129] @ 0x16800 += 0x4;

    reg {
        name = "AE/AWB";
        desc = "METERING_MEM is an AE/AWB (sum) statistics register.

Data sheet 10.6 METERING_MEM (offset 0x28000, printed page 10-252, `hi3516av200--Hi3516AV200-Datasheet.txt` line 79868).";

        field {
            name = "data0";
            desc = "AE/AWB (sum) statistics";
            sw = r;
            hw = w;
            reset = 0x0;
        } data0[31:0];
    } METERING_MEM[6144] @ 0x18000 += 0x4;

    reg {
        name = "Static defect pixel table register";
        desc = "DEFECT_PIXEL_MEM is a static defect pixel table register.

Data sheet 10.6 DEFECT_PIXEL_MEM (offset 0x30000, printed page 10-252, `hi3516av200--Hi3516AV200-Datasheet.txt` line 79886).";

        field {
            name = "data0";
            desc = "Static defect pixel table";
            sw = rw;
            hw = r;
            reset = 0x0;
        } data0[24:0];
    } DEFECT_PIXEL_MEM[4096] @ 0x20000 += 0x4;

    reg {
        name = "1024-segment histogram statistics register";
        desc = "HISTOGRAM_4CH_MEM is a 1024-segment histogram statistics register.

Data sheet 10.6 HISTOGRAM_4CH_MEM (offset 0x34000, printed page 10-253, `hi3516av200--Hi3516AV200-Datasheet.txt` line 79912).";

        field {
            name = "data0";
            desc = "Histogram statistics";
            sw = r;
            hw = w;
            reset = 0x0;
        } data0[31:0];
    } HISTOGRAM_4CH_MEM[1024] @ 0x24000 += 0x4;

    reg {
        name = "Histogram statistics register 1";
        desc = "HISTOGRAM1_MEM is histogram statistics register 1.

Data sheet 10.6 HISTOGRAM1_MEM (offset 0x35000, printed page 10-253, `hi3516av200--Hi3516AV200-Datasheet.txt` line 79931).";

        field {
            name = "data0";
            desc = "Histogram statistics";
            sw = r;
            hw = w;
            reset = 0x0;
        } data0[31:0];
    } HISTOGRAM1_MEM[256] @ 0x25000 += 0x4;

    reg {
        name = "Histogram statistics register 2";
        desc = "HISTOGRAM2_MEM is histogram statistics register 2.

Data sheet 10.6 HISTOGRAM2_MEM (offset 0x35400, printed page 10-253, `hi3516av200--Hi3516AV200-Datasheet.txt` line 79949).";

        field {
            name = "data0";
            desc = "Histogram statistics";
            sw = r;
            hw = w;
            reset = 0x0;
        } data0[31:0];
    } HISTOGRAM2_MEM[256] @ 0x25400 += 0x4;

    reg {
        name = "Histogram statistics register 3";
        desc = "HISTOGRAM3_MEM is histogram statistics register 3.

Data sheet 10.6 HISTOGRAM3_MEM (offset 0x35800, printed page 10-254, `hi3516av200--Hi3516AV200-Datasheet.txt` line 79974).";

        field {
            name = "data0";
            desc = "Histogram statistics";
            sw = r;
            hw = w;
            reset = 0x0;
        } data0[31:0];
    } HISTOGRAM3_MEM[256] @ 0x25800 += 0x4;

    reg {
        name = "Histogram statistics register 4";
        desc = "HISTOGRAM4_MEM is histogram statistics register 4.

Data sheet 10.6 HISTOGRAM4_MEM (offset 0x35C00, printed page 10-254, `hi3516av200--Hi3516AV200-Datasheet.txt` line 79993).";

        field {
            name = "data0";
            desc = "Histogram statistics";
            sw = r;
            hw = w;
            reset = 0x0;
        } data0[31:0];
    } HISTOGRAM4_MEM[256] @ 0x25C00 += 0x4;

    reg {
        name = "GAMMA_RGB bank 0 lookup table register";
        desc = "GAMMA_RGB_MEM0 is a GAMMA_RGB bank 0 lookup table register.

Data sheet 10.6 GAMMA_RGB_MEM0 (offset 0x37000, printed page 10-254, `hi3516av200--Hi3516AV200-Datasheet.txt` line 80011).";

        field {
            name = "data0";
            desc = "257-node lookup table for GAMMA_RGB bank 0";
            sw = rw;
            hw = r;
            reset = 0x0;
        } data0[11:0];
    } GAMMA_RGB_MEM0[257] @ 0x27000 += 0x4;

    reg {
        name = "GAMMA_RGB bank 1 lookup table register";
        desc = "GAMMA_RGB_MEM1 is a GAMMA_RGB bank 1 lookup table register.

Data sheet 10.6 GAMMA_RGB_MEM1 (offset 0x37800, printed page 10-255, `hi3516av200--Hi3516AV200-Datasheet.txt` line 80037).";

        field {
            name = "data0";
            desc = "257-node lookup table for GAMMA_RGB bank 1";
            sw = rw;
            hw = r;
            reset = 0x0;
        } data0[11:0];
    } GAMMA_RGB_MEM1[257] @ 0x27800 += 0x4;

    reg {
        name = "DRC_FWD table register";
        desc = "DRC_FWD_MEM is a DRC_FWD table register.

Data sheet 10.6 DRC_FWD_MEM (offset 0x38000, printed page 10-255, `hi3516av200--Hi3516AV200-Datasheet.txt` line 80057).";

        field {
            name = "data0";
            desc = "DRC_FWD table";
            sw = rw;
            hw = r;
            reset = 0x0;
        } data0[19:0];
    } DRC_FWD_MEM[129] @ 0x28000 += 0x4;

    reg {
        name = "DRC_REV table register";
        desc = "DRC_REV_MEM is a DRC_REV table register.

Data sheet 10.6 DRC_REV_MEM (offset 0x38800, printed page 10-255, `hi3516av200--Hi3516AV200-Datasheet.txt` line 80076).";

        field {
            name = "data0";
            desc = "DRC_REV table";
            sw = rw;
            hw = r;
            reset = 0x0;
        } data0[19:0];
    } DRC_REV_MEM[129] @ 0x28800 += 0x4;

    reg {
        name = "CMD table register";
        desc = "CMD_QUEUES is a CMD table register.

Data sheet 10.6 CMD_QUEUES (offset 0x39000, printed page 10-256, `hi3516av200--Hi3516AV200-Datasheet.txt` line 80105).";

        field {
            name = "data0";
            desc = "CMD table";
            sw = rw;
            hw = r;
            reset = 0x0;
        } data0[31:0];
    } CMD_QUEUES[256] @ 0x29000 += 0x4;

    reg {
        name = "Mesh shading table register";
        desc = "SHADING_MEM is a mesh shading table register.

Data sheet 10.6 SHADING_MEM (offset 0x3C000, printed page 10-256, `hi3516av200--Hi3516AV200-Datasheet.txt` line 80124).";

        field {
            name = "data0";
            desc = "Mesh shading table";
            sw = rw;
            hw = r;
            reset = 0x40404040;
        } data0[31:0];
    } SHADING_MEM[3072] @ 0x2C000 += 0x4;

    reg {
        name = "ISP adjustable interrupt trigger time configuration register";
        desc = "ISP_BE_FSTART_DELAY is an ISP adjustable interrupt trigger time configuration register. Hi3516A V200 Professional HD IP Camera SoC

Data sheet 10.6 ISP_BE_FSTART_DELAY (offset 0x40094, printed page 10-257, `hi3516av200--Hi3516AV200-Datasheet.txt` line 80151).";

        field {
            name = "delay";
            desc = "Trigger time of adjustable interrupts";
            sw = rw;
            hw = r;
            reset = 0x0;
        } delay[31:0];
    } ISP_BE_FSTART_DELAY @ 0x30094;

    reg {
        name = "User-defined register 0";
        desc = "ISP_BE_USER_DEFINE0 is user-defined register 0.

Data sheet 10.6 ISP_BE_USER_DEFINE0 (offset 0x400A0, printed page 10-257, `hi3516av200--Hi3516AV200-Datasheet.txt` line 80170).";

        field {
            name = "user_define0";
            desc = "User-defined register 0";
            sw = rw;
            hw = r;
            reset = 0x0;
        } user_define0[31:0];
    } ISP_BE_USER_DEFINE0 @ 0x300A0;

    reg {
        name = "User-defined register 1";
        desc = "ISP_BE_USER_DEFINE1 is user-defined register 1.

Data sheet 10.6 ISP_BE_USER_DEFINE1 (offset 0x400A4, printed page 10-257, `hi3516av200--Hi3516AV200-Datasheet.txt` line 80188).";

        field {
            name = "user_define1";
            desc = "User-defined register 1";
            sw = rw;
            hw = r;
            reset = 0x0;
        } user_define1[31:0];
    } ISP_BE_USER_DEFINE1 @ 0x300A4;

    reg {
        name = "ISP interrupt indicator register";
        desc = "ISP_BE_INT is an ISP interrupt indicator register. Hi3516A V200 Professional HD IP Camera SoC

Data sheet 10.6 ISP_BE_INT (offset 0x400F0, printed page 10-258, `hi3516av200--Hi3516AV200-Datasheet.txt` line 80216).";

        enum ISP_BE_INT_acm_para_finish_enum {
            NO_INTERRUPT_GENERATED = 0 { name = "No Interrupt Generated"; desc = "No interrupt is generated."; };
            INTERRUPT_GENERATED = 1 { name = "Interrupt Generated"; desc = "An interrupt is generated."; };
        };

        field {
            name = "acm_para_finish";
            desc = "Status of the ACM LUT loading completion interrupt. Writing 1 clears this interrupt.";
            sw = rw;
            hw = w;
            onwrite = woclr;
            encode = ISP_BE_INT_acm_para_finish_enum;
            reset = 0x0;
        } acm_para_finish[16:16];

        enum ISP_BE_INT_fstart_delay_enum {
            NO_INTERRUPT_GENERATED = 0 { name = "No Interrupt Generated"; desc = "No interrupt is generated."; };
            INTERRUPT_GENERATED = 1 { name = "Interrupt Generated"; desc = "An interrupt is generated."; };
        };

        field {
            name = "fstart_delay";
            desc = "Status of the configurable trigger delay interrupt";
            sw = rw;
            hw = w;
            onwrite = woclr;
            encode = ISP_BE_INT_fstart_delay_enum;
            reset = 0x0;
        } fstart_delay[3:3];

        enum ISP_BE_INT_cfg_loss_enum {
            NO_INTERRUPT_GENERATED = 0 { name = "No Interrupt Generated"; desc = "No interrupt is generated."; };
            INTERRUPT_GENERATED = 1 { name = "Interrupt Generated"; desc = "An interrupt is generated."; };
        };

        field {
            name = "cfg_loss";
            desc = "Status of the register configuration loss interrupt. Writing 1 clears this interrupt.";
            sw = rw;
            hw = w;
            onwrite = woclr;
            encode = ISP_BE_INT_cfg_loss_enum;
            reset = 0x0;
        } cfg_loss[2:2];

        enum ISP_BE_INT_update_cfg_enum {
            NO_INTERRUPT_GENERATED = 0 { name = "No Interrupt Generated"; desc = "No interrupt is generated."; };
            INTERRUPT_GENERATED = 1 { name = "Interrupt Generated"; desc = "An interrupt is generated."; };
        };

        field {
            name = "update_cfg";
            desc = "Status of the register update interrupt. Writing 1 clears this interrupt.";
            sw = rw;
            hw = w;
            onwrite = woclr;
            encode = ISP_BE_INT_update_cfg_enum;
            reset = 0x0;
        } update_cfg[1:1];

        enum ISP_BE_INT_fstart_enum {
            NO_INTERRUPT_GENERATED = 0 { name = "No Interrupt Generated"; desc = "No interrupt is generated."; };
            INTERRUPT_GENERATED = 1 { name = "Interrupt Generated"; desc = "An interrupt is generated."; };
        };

        field {
            name = "fstart";
            desc = "Status of the ISP SOF interrupt. Writing 1 clears this interrupt.";
            sw = rw;
            hw = w;
            onwrite = woclr;
            encode = ISP_BE_INT_fstart_enum;
            reset = 0x0;
        } fstart[0:0];
    } ISP_BE_INT @ 0x300F0;

    reg {
        name = "ISP interrupt mask register";
        desc = "ISP_BE_INT_MASK is an ISP interrupt mask register. Hi3516A V200 Professional HD IP Camera SoC

Data sheet 10.6 ISP_BE_INT_MASK (offset 0x400F8, printed page 10-259, `hi3516av200--Hi3516AV200-Datasheet.txt` line 80273).";

        enum ISP_BE_INT_MASK_acm_para_finish_enum {
            MASKED = 0 { name = "Masked"; desc = "masked"; };
            ENABLED = 1 { name = "Enabled"; desc = "enabled"; };
        };

        field {
            name = "acm_para_finish";
            desc = "ACM LUT loading completion interrupt mask register";
            sw = rw;
            hw = r;
            encode = ISP_BE_INT_MASK_acm_para_finish_enum;
            reset = 0x0;
        } acm_para_finish[16:16];

        enum ISP_BE_INT_MASK_int_delay_enum {
            MASKED = 0 { name = "Masked"; desc = "masked"; };
            ENABLED = 1 { name = "Enabled"; desc = "enabled"; };
        };

        field {
            name = "int_delay";
            desc = "Configurable trigger delay interrupt mask register";
            sw = rw;
            hw = r;
            encode = ISP_BE_INT_MASK_int_delay_enum;
            reset = 0x0;
        } int_delay[3:3];

        enum ISP_BE_INT_MASK_cfg_loss_enum {
            MASKED = 0 { name = "Masked"; desc = "masked"; };
            ENABLED = 1 { name = "Enabled"; desc = "enabled"; };
        };

        field {
            name = "cfg_loss";
            desc = "Register configuration loss interrupt mask register";
            sw = rw;
            hw = r;
            encode = ISP_BE_INT_MASK_cfg_loss_enum;
            reset = 0x0;
        } cfg_loss[2:2];

        enum ISP_BE_INT_MASK_update_cfg_enum {
            MASKED = 0 { name = "Masked"; desc = "masked"; };
            ENABLED = 1 { name = "Enabled"; desc = "enabled"; };
        };

        field {
            name = "update_cfg";
            desc = "Register update interrupt mask register";
            sw = rw;
            hw = r;
            encode = ISP_BE_INT_MASK_update_cfg_enum;
            reset = 0x0;
        } update_cfg[1:1];

        enum ISP_BE_INT_MASK_fstart_enum {
            MASKED = 0 { name = "Masked"; desc = "masked"; };
            ENABLED = 1 { name = "Enabled"; desc = "enabled"; };
        };

        field {
            name = "fstart";
            desc = "ISP SOF interrupt mask register";
            sw = rw;
            hw = r;
            encode = ISP_BE_INT_MASK_fstart_enum;
            reset = 0x0;
        } fstart[0:0];
    } ISP_BE_INT_MASK @ 0x300F8;

    reg {
        name = "ISP general update control register";
        desc = "ISP_BE_CTRL_F is an ISP general update control register. Hi3516A V200 Professional HD IP Camera SoC

Data sheet 10.6 ISP_BE_CTRL_F (offset 0x401E0, printed page 10-260, `hi3516av200--Hi3516AV200-Datasheet.txt` line 80324).";

        enum ISP_BE_CTRL_F_rggb_cfg_enum {
            R_GR_GB = 0 { name = "R Gr Gb"; desc = "R Gr Gb B"; };
            GR_R_B = 1 { name = "Gr R B"; desc = "Gr R B Gb"; };
            GB_B_R = 2 { name = "Gb B R"; desc = "Gb B R Gr"; };
            B_GB_GR = 3 { name = "B Gb Gr"; desc = "B Gb Gr R"; };
        };

        field {
            name = "rggb_cfg";
            desc = "RGGB sequence";
            sw = rw;
            hw = r;
            encode = ISP_BE_CTRL_F_rggb_cfg_enum;
            reset = 0x3;
        } rggb_cfg[1:0];
    } ISP_BE_CTRL_F @ 0x301E0;

    reg {
        name = "ISP immediate update control register";
        desc = "ISP_BE_CTRL_I is an ISP immediate update control register.

Data sheet 10.6 ISP_BE_CTRL_I (offset 0x401E4, printed page 10-260, `hi3516av200--Hi3516AV200-Datasheet.txt` line 80353).";

        enum ISP_BE_CTRL_I_update_mode_enum {
            UPDATE_MODE_SPECIFIED = 0 { name = "Update Mode Specified"; desc = "update mode specified in ISP_BE_REG_UPDATE"; };
            FRAME_UPDATE_MODE = 1 { name = "Frame Update Mode"; desc = "frame update mode"; };
        };

        field {
            name = "update_mode";
            desc = "ISP register update mode";
            sw = rw;
            hw = r;
            encode = ISP_BE_CTRL_I_update_mode_enum;
            reset = 0x0;
        } update_mode[0:0];
    } ISP_BE_CTRL_I @ 0x301E4;

    reg {
        name = "Output timing configuration register";
        desc = "ISP_BE_TIMING_CFG is an output timing configuration register. Hi3516A V200 Professional HD IP Camera SoC

Data sheet 10.6 ISP_BE_TIMING_CFG (offset 0x401E8, printed page 10-261, `hi3516av200--Hi3516AV200-Datasheet.txt` line 80389).";

        field {
            name = "fix_timing";
            desc = "Manual timing parameter configuration. The length of the generated line blanking region is configured.";
            sw = rw;
            hw = r;
            reset = 0x40;
        } fix_timing[13:1];
    } ISP_BE_TIMING_CFG @ 0x301E8;

    reg {
        name = "Register update register";
        desc = "ISP_BE_REG_UPDATE is a register update register.

Data sheet 10.6 ISP_BE_REG_UPDATE (offset 0x401EC, printed page 10-261, `hi3516av200--Hi3516AV200-Datasheet.txt` line 80414).";

        field {
            name = "update";
            desc = "ISP update. This bit is automatically cleared for each frame.";
            sw = rw;
            hw = r;
            reset = 0x0;
        } update[0:0];
    } ISP_BE_REG_UPDATE @ 0x301EC;

    reg {
        name = "Luminance clamping configuration register";
        desc = "ISP_CLIP_Y_CFG is a luminance clamping configuration register. Hi3516A V200 Professional HD IP Camera SoC

Data sheet 10.6 ISP_CLIP_Y_CFG (offset 0x40800, printed page 10-262, `hi3516av200--Hi3516AV200-Datasheet.txt` line 80444).";

        field {
            name = "max";
            desc = "Maximum luminance clamping value. When the data bit width is less than 16 bits, the upper bits are valid.";
            sw = rw;
            hw = r;
            reset = 0xFFFF;
        } max[31:16];

        field {
            name = "min";
            desc = "Minimum luminance clamping value. When the data bit width is less than 16 bits, the upper bits are valid.";
            sw = rw;
            hw = r;
            reset = 0x0;
        } min[15:0];
    } ISP_CLIP_Y_CFG @ 0x30800;

    reg {
        name = "Chrominance clamping configuration register";
        desc = "ISP_CLIP_C_CFG is a chrominance clamping configuration register.

Data sheet 10.6 ISP_CLIP_C_CFG (offset 0x40804, printed page 10-262, `hi3516av200--Hi3516AV200-Datasheet.txt` line 80468).";

        field {
            name = "max";
            desc = "Maximum chrominance clamping value. When the data bit width is less than 16 bits, the upper bits are valid.";
            sw = rw;
            hw = r;
            reset = 0xFFFF;
        } max[31:16];

        field {
            name = "min";
            desc = "Minimum chrominance clamping value. When the data bit width is less than 16 bits, the upper bits are valid.";
            sw = rw;
            hw = r;
            reset = 0x0;
        } min[15:0];
    } ISP_CLIP_C_CFG @ 0x30804;

    reg {
        name = "Y component skip configuration register";
        desc = "ISP_SKIP_Y_CFG is a Y component skip configuration register.

Data sheet 10.6 ISP_SKIP_Y_CFG (offset 0x40810, printed page 10-262, `hi3516av200--Hi3516AV200-Datasheet.txt` line 80492).";

        field {
            name = "skip_cfg";
            desc = "Skip configuration for the Y component";
            sw = rw;
            hw = r;
            reset = 0xFFFFFFFF;
        } skip_cfg[31:0];
    } ISP_SKIP_Y_CFG @ 0x30810;

    reg {
        name = "C component skip configuration register";
        desc = "ISP_SKIP_C_CFG is a C component skip configuration register.

Data sheet 10.6 ISP_SKIP_C_CFG (offset 0x40818, printed page 10-263, `hi3516av200--Hi3516AV200-Datasheet.txt` line 80518).";

        field {
            name = "skip_cfg";
            desc = "Skip configuration for the C component";
            sw = rw;
            hw = r;
            reset = 0xFFFFFFFF;
        } skip_cfg[31:0];
    } ISP_SKIP_C_CFG @ 0x30818;

    reg {
        name = "Y component crop enable register";
        desc = "ISP_CROP_Y_CFG is a Y component crop enable register.

Data sheet 10.6 ISP_CROP_Y_CFG (offset 0x40860, printed page 10-263, `hi3516av200--Hi3516AV200-Datasheet.txt` line 80536).";

        enum ISP_CROP_Y_CFG_n0_en_enum {
            DISABLED = 0 { name = "Disabled"; desc = "disabled"; };
            ENABLED = 1 { name = "Enabled"; desc = "enabled"; };
        };

        field {
            name = "n0_en";
            desc = "Region 0 enable";
            sw = rw;
            hw = r;
            encode = ISP_CROP_Y_CFG_n0_en_enum;
            reset = 0x0;
        } n0_en[0:0];
    } ISP_CROP_Y_CFG @ 0x30860;

    reg {
        name = "Y component crop start position register";
        desc = "ISP_CROP_Y_START is a Y component crop start position register. Hi3516A V200 Professional HD IP Camera SoC

Data sheet 10.6 ISP_CROP_Y_START (offset 0x40868, printed page 10-264, `hi3516av200--Hi3516AV200-Datasheet.txt` line 80568).";

        field {
            name = "y_start";
            desc = "ID of the line from which the picture starts to be captured";
            sw = rw;
            hw = r;
            reset = 0x0;
        } y_start[28:16];

        field {
            name = "x_start";
            desc = "ID of the pixel from which the picture starts to be captured";
            sw = rw;
            hw = r;
            reset = 0x0;
        } x_start[12:0];
    } ISP_CROP_Y_START @ 0x30868;

    reg {
        name = "Y component crop size configuration register";
        desc = "ISP_CROP_Y_SIZE is a Y component crop size configuration register.

Data sheet 10.6 ISP_CROP_Y_SIZE (offset 0x4086C, printed page 10-264, `hi3516av200--Hi3516AV200-Datasheet.txt` line 80593).";

        field {
            name = "height";
            desc = "Height (in line) of the obtained picture. The configured value is the actual value minus 1.";
            sw = rw;
            hw = r;
            reset = 0x0;
        } height[28:16];

        field {
            name = "width";
            desc = "Width (in pixel) of the obtained picture. The configured value is the actual value minus 1.";
            sw = rw;
            hw = r;
            reset = 0x0;
        } width[12:0];
    } ISP_CROP_Y_SIZE @ 0x3086C;

    reg {
        name = "C component crop enable register";
        desc = "ISP_CROP_C_CFG is a C component crop enable register. Hi3516A V200 Professional HD IP Camera SoC

Data sheet 10.6 ISP_CROP_C_CFG (offset 0x40870, printed page 10-265, `hi3516av200--Hi3516AV200-Datasheet.txt` line 80631).";

        enum ISP_CROP_C_CFG_n0_en_enum {
            DISABLED = 0 { name = "Disabled"; desc = "disabled"; };
            ENABLED = 1 { name = "Enabled"; desc = "enabled"; };
        };

        field {
            name = "n0_en";
            desc = "Region 0 enable";
            sw = rw;
            hw = r;
            encode = ISP_CROP_C_CFG_n0_en_enum;
            reset = 0x0;
        } n0_en[0:0];
    } ISP_CROP_C_CFG @ 0x30870;

    reg {
        name = "C component crop start position register";
        desc = "ISP_CROP_C_START is a C component crop start position register.

Data sheet 10.6 ISP_CROP_C_START (offset 0x40878, printed page 10-265, `hi3516av200--Hi3516AV200-Datasheet.txt` line 80654).";

        field {
            name = "y_start";
            desc = "ID of the line from which the picture starts to be captured";
            sw = rw;
            hw = r;
            reset = 0x0;
        } y_start[28:16];

        field {
            name = "x_start";
            desc = "ID of the pixel from which the picture starts to be captured";
            sw = rw;
            hw = r;
            reset = 0x0;
        } x_start[12:0];
    } ISP_CROP_C_START @ 0x30878;

    reg {
        name = "C component crop size configuration register";
        desc = "ISP_CROP_C_SIZE is a C component crop size configuration register. Hi3516A V200 Professional HD IP Camera SoC

Data sheet 10.6 ISP_CROP_C_SIZE (offset 0x4087C, printed page 10-266, `hi3516av200--Hi3516AV200-Datasheet.txt` line 80688).";

        field {
            name = "height";
            desc = "Height (in line) of the obtained picture. The configured value is the actual value minus 1.";
            sw = rw;
            hw = r;
            reset = 0x0;
        } height[28:16];

        field {
            name = "width";
            desc = "Width (in pixel) of the obtained picture. The configured value is the actual value minus 1.";
            sw = rw;
            hw = r;
            reset = 0x0;
        } width[12:0];
    } ISP_CROP_C_SIZE @ 0x3087C;

    reg {
        name = "Input picture luminance statistics lower-bit register";
        desc = "ISP_Y_SUM0 is an input picture luminance statistics lower-bit register.

Data sheet 10.6 ISP_Y_SUM0 (offset 0x40880, printed page 10-266, `hi3516av200--Hi3516AV200-Datasheet.txt` line 80717).";

        field {
            name = "sum";
            desc = "Lower 32 bits of the luminance statistics";
            sw = r;
            hw = w;
            reset = 0x0;
        } sum[31:0];
    } ISP_Y_SUM0 @ 0x30880;

    reg {
        name = "Input picture luminance statistics upper-bit register";
        desc = "ISP_Y_SUM1 is an input picture luminance statistics upper-bit register. Hi3516A V200 Professional HD IP Camera SoC

Data sheet 10.6 ISP_Y_SUM1 (offset 0x40884, printed page 10-267, `hi3516av200--Hi3516AV200-Datasheet.txt` line 80745).";

        field {
            name = "sum";
            desc = "Upper 32 bits of the luminance statistics";
            sw = r;
            hw = w;
            reset = 0x0;
        } sum[31:0];
    } ISP_Y_SUM1 @ 0x30884;

    reg {
        name = "CSC enable register";
        desc = "ISP_CSC_CFG is a CSC enable register.

Data sheet 10.6 ISP_CSC_CFG (offset 0x41500, printed page 10-267, `hi3516av200--Hi3516AV200-Datasheet.txt` line 80764).";

        enum ISP_CSC_CFG_en_enum {
            DISABLED = 0 { name = "Disabled"; desc = "disabled"; };
            ENABLED = 1 { name = "Enabled"; desc = "enabled"; };
        };

        field {
            name = "en";
            desc = "CSC enable";
            sw = rw;
            hw = r;
            encode = ISP_CSC_CFG_en_enum;
            reset = 0x0;
        } en[0:0];
    } ISP_CSC_CFG @ 0x31500;

    reg {
        name = "CSC coefficient register 0";
        desc = "ISP_CSC_COEF0 is CSC coefficient register 0. Hi3516A V200 Professional HD IP Camera SoC

Data sheet 10.6 ISP_CSC_COEF0 (offset 0x41510, printed page 10-268, `hi3516av200--Hi3516AV200-Datasheet.txt` line 80794).";

        field {
            name = "coef01";
            desc = "CSC coefficient Its format is S5.10. The value is a signed number consisting of a 4- bit integral part and a 10-bit decimal part.";
            sw = rw;
            hw = r;
            reset = 0x0;
        } coef01[31:17];

        field {
            name = "coef00";
            desc = "CSC coefficient Its format is S5.10. The value is a signed number consisting of a 4- bit integral part and a 10-bit decimal part.";
            sw = rw;
            hw = r;
            reset = 0x0;
        } coef00[15:1];
    } ISP_CSC_COEF0 @ 0x31510;

    reg {
        name = "CSC coefficient register 1";
        desc = "ISP_CSC_COEF1 is CSC coefficient register 1.

Data sheet 10.6 ISP_CSC_COEF1 (offset 0x41514, printed page 10-268, `hi3516av200--Hi3516AV200-Datasheet.txt` line 80822).";

        field {
            name = "coef10";
            desc = "CSC coefficient Its format is S5.10. The value is a signed number consisting of a 4- bit integral part and a 10-bit decimal part.";
            sw = rw;
            hw = r;
            reset = 0x0;
        } coef10[31:17];

        field {
            name = "coef02";
            desc = "CSC coefficient Its format is S5.10. The value is a signed number consisting of a 4- bit integral part and a 10-bit decimal part.";
            sw = rw;
            hw = r;
            reset = 0x0;
        } coef02[15:1];
    } ISP_CSC_COEF1 @ 0x31514;

    reg {
        name = "CSC coefficient register 2";
        desc = "ISP_CSC_COEF2 is CSC coefficient register 2.

Data sheet 10.6 ISP_CSC_COEF2 (offset 0x41518, printed page 10-269, `hi3516av200--Hi3516AV200-Datasheet.txt` line 80858).";

        field {
            name = "coef12";
            desc = "CSC coefficient Its format is S5.10. The value is a signed number consisting of a 4- bit integral part and a 10-bit decimal part.";
            sw = rw;
            hw = r;
            reset = 0x0;
        } coef12[31:17];

        field {
            name = "coef11";
            desc = "CSC coefficient Its format is S5.10. The value is a signed number consisting of a 4- bit integral part and a 10-bit decimal part.";
            sw = rw;
            hw = r;
            reset = 0x0;
        } coef11[15:1];
    } ISP_CSC_COEF2 @ 0x31518;

    reg {
        name = "CSC coefficient register 3";
        desc = "ISP_CSC_COEF3 is CSC coefficient register 3.

Data sheet 10.6 ISP_CSC_COEF3 (offset 0x4151C, printed page 10-269, `hi3516av200--Hi3516AV200-Datasheet.txt` line 80886).";

        field {
            name = "coef21";
            desc = "CSC coefficient Its format is S5.10. The value is a signed number consisting of a 4- bit integral part and a 10-bit decimal part.";
            sw = rw;
            hw = r;
            reset = 0x0;
        } coef21[31:17];

        field {
            name = "coef20";
            desc = "CSC coefficient Its format is S5.10. The value is a signed number consisting of a 4- bit integral part and a 10-bit decimal part.";
            sw = rw;
            hw = r;
            reset = 0x0;
        } coef20[15:1];
    } ISP_CSC_COEF3 @ 0x3151C;

    reg {
        name = "CSC coefficient register 4";
        desc = "ISP_CSC_COEF4 is CSC coefficient register 4.

Data sheet 10.6 ISP_CSC_COEF4 (offset 0x41520, printed page 10-270, `hi3516av200--Hi3516AV200-Datasheet.txt` line 80921).";

        field {
            name = "coef22";
            desc = "CSC coefficient Its format is S5.10. The value is a signed number consisting of a 4- bit integral part and a 10-bit decimal part.";
            sw = rw;
            hw = r;
            reset = 0x0;
        } coef22[15:1];
    } ISP_CSC_COEF4 @ 0x31520;

    reg {
        name = "CSC input DC component register 0";
        desc = "ISP_CSC_IN_DC0 is CSC input DC component register 0.

Data sheet 10.6 ISP_CSC_IN_DC0 (offset 0x41530, printed page 10-270, `hi3516av200--Hi3516AV200-Datasheet.txt` line 80950).";

        field {
            name = "in_dc1";
            desc = "DC offset of the input G component, signed integer";
            sw = rw;
            hw = r;
            reset = 0x0;
        } in_dc1[31:21];

        field {
            name = "in_dc0";
            desc = "DC offset of the input R component, signed integer";
            sw = rw;
            hw = r;
            reset = 0x0;
        } in_dc0[15:5];
    } ISP_CSC_IN_DC0 @ 0x31530;

    reg {
        name = "CSC input DC component register 1";
        desc = "ISP_CSC_IN_DC1 is CSC input DC component register 1.

Data sheet 10.6 ISP_CSC_IN_DC1 (offset 0x41534, printed page 10-271, `hi3516av200--Hi3516AV200-Datasheet.txt` line 80980).";

        field {
            name = "in_dc2";
            desc = "DC offset of the input B component, signed integer";
            sw = rw;
            hw = r;
            reset = 0x0;
        } in_dc2[15:5];
    } ISP_CSC_IN_DC1 @ 0x31534;

    reg {
        name = "CSC output DC component register 0";
        desc = "ISP_CSC_OUT_DC0 is CSC output DC component register 0.

Data sheet 10.6 ISP_CSC_OUT_DC0 (offset 0x41540, printed page 10-271, `hi3516av200--Hi3516AV200-Datasheet.txt` line 81001).";

        field {
            name = "out_dc1";
            desc = "DC offset of the output U component, signed integer";
            sw = rw;
            hw = r;
            reset = 0x0;
        } out_dc1[31:21];

        field {
            name = "out_dc0";
            desc = "DC offset of the output Y component, signed integer";
            sw = rw;
            hw = r;
            reset = 0x0;
        } out_dc0[15:5];
    } ISP_CSC_OUT_DC0 @ 0x31540;

    reg {
        name = "CSC output DC component register 1";
        desc = "ISP_CSC_OUT_DC1 is CSC output DC component register 1. Hi3516A V200 Professional HD IP Camera SoC

Data sheet 10.6 ISP_CSC_OUT_DC1 (offset 0x41544, printed page 10-272, `hi3516av200--Hi3516AV200-Datasheet.txt` line 81029).";

        field {
            name = "out_dc2";
            desc = "DC offset of the output V component, signed integer";
            sw = rw;
            hw = r;
            reset = 0x0;
        } out_dc2[15:5];
    } ISP_CSC_OUT_DC1 @ 0x31544;

    reg {
        name = "MCDS control register";
        desc = "ISP_MCDS_CFG is an MCDS control register.

Data sheet 10.6 ISP_MCDS_CFG (offset 0x41800, printed page 10-272, `hi3516av200--Hi3516AV200-Datasheet.txt` line 81050).";

        enum ISP_MCDS_CFG_midf_en_enum {
            DISABLED = 0 { name = "Disabled"; desc = "disabled"; };
            ENABLED = 1 { name = "Enabled"; desc = "enabled"; };
        };

        field {
            name = "midf_en";
            desc = "MCDSILTER enable";
            sw = rw;
            hw = r;
            encode = ISP_MCDS_CFG_midf_en_enum;
            reset = 0x0;
        } midf_en[4:4];

        enum ISP_MCDS_CFG_uv2c_mode_enum {
            U_COMPONENT_DATA = 0 { name = "U Component Data"; desc = "The U component data is output."; };
            V_COMPONENT_DATA = 1 { name = "V Component Data"; desc = "The V component data is output."; };
        };

        field {
            name = "uv2c_mode";
            desc = "UV2C bypass mode";
            sw = rw;
            hw = r;
            encode = ISP_MCDS_CFG_uv2c_mode_enum;
            reset = 0x0;
        } uv2c_mode[3:3];

        enum ISP_MCDS_CFG_uv2c_en_enum {
            DISABLED = 0 { name = "Disabled"; desc = "disabled"; };
            ENABLED = 1 { name = "Enabled"; desc = "enabled"; };
        };

        field {
            name = "uv2c_en";
            desc = "UV2C enable for converting the internal dual-component (U and V) data into the single component (C) data";
            sw = rw;
            hw = r;
            encode = ISP_MCDS_CFG_uv2c_en_enum;
            reset = 0x0;
        } uv2c_en[2:2];

        enum ISP_MCDS_CFG_vcds_en_enum {
            DISABLED = 0 { name = "Disabled"; desc = "disabled"; };
            ENABLED = 1 { name = "Enabled"; desc = "enabled"; };
        };

        field {
            name = "vcds_en";
            desc = "Vertical chrominance down sampling enable";
            sw = rw;
            hw = r;
            encode = ISP_MCDS_CFG_vcds_en_enum;
            reset = 0x0;
        } vcds_en[1:1];

        enum ISP_MCDS_CFG_hcds_en_enum {
            DISABLED = 0 { name = "Disabled"; desc = "disabled"; };
            ENABLED = 1 { name = "Enabled"; desc = "enabled"; };
        };

        field {
            name = "hcds_en";
            desc = "Horizontal chrominance down sampling enable";
            sw = rw;
            hw = r;
            encode = ISP_MCDS_CFG_hcds_en_enum;
            reset = 0x0;
        } hcds_en[0:0];
    } ISP_MCDS_CFG @ 0x31800;

    reg {
        name = "Horizontal chrominance down sampling input size configuration register";
        desc = "ISP_HCDS_SIZE is a horizontal chrominance down sampling input size configuration register.

Data sheet 10.6 ISP_HCDS_SIZE (offset 0x41814, printed page 10-273, `hi3516av200--Hi3516AV200-Datasheet.txt` line 81100).";

        field {
            name = "width_out";
            desc = "U/V line width (in pixel) of the output picture during horizontal chrominance down sampling. The configured value is the actual value minus 1.";
            sw = rw;
            hw = r;
            reset = 0x77F;
        } width_out[28:16];

        field {
            name = "width_in";
            desc = "U/V line width (in pixel) of the input picture. The configured value is the actual value minus 1.";
            sw = rw;
            hw = r;
            reset = 0x77F;
        } width_in[12:0];
    } ISP_HCDS_SIZE @ 0x31814;

    reg {
        name = "Median filtering input chrominance picture size register";
        desc = "ISP_MIDF_SIZE is a median filtering input chrominance picture size register. Hi3516A V200 Professional HD IP Camera SoC

Data sheet 10.6 ISP_MIDF_SIZE (offset 0x4182C, printed page 10-274, `hi3516av200--Hi3516AV200-Datasheet.txt` line 81139).";

        field {
            name = "height";
            desc = "Picture height after vertical chrominance down sampling. The configured value is the actual height minus 1. For example, if the actual picture height is 720, this field needs to be set to 719.";
            sw = rw;
            hw = r;
            reset = 0x437;
        } height[28:16];

        field {
            name = "width";
            desc = "Picture width after vertical chrominance down sampling (UV-to-C conversion). The configured value is the actual width minus 1. For example, if the actual picture width is 1280, this field needs to be set to 1279.";
            sw = rw;
            hw = r;
            reset = 0x77F;
        } width[12:0];
    } ISP_MIDF_SIZE @ 0x3182C;

    reg {
        name = "NR blending ratio and shift register";
        desc = "ISP_MCDS_PARA is an NR blending ratio and shift register.

Data sheet 10.6 ISP_MCDS_PARA (offset 0x41844, printed page 10-274, `hi3516av200--Hi3516AV200-Datasheet.txt` line 81170).";

        field {
            name = "midf_bldr";
            desc = "MIDF blending ratio, 5-bit unsigned number. The value range is 0 ~ 16.";
            sw = rw;
            hw = r;
            reset = 0x0;
        } midf_bldr[28:24];

        field {
            name = "limit";
            desc = "Limit for the coring function. The value range is 0 ~ 127.";
            sw = rw;
            hw = r;
            reset = 0x0;
        } limit[22:16];
    } ISP_MCDS_PARA @ 0x31844;

    reg {
        name = "MCDS input picture size register";
        desc = "ISP_MCDS_SIZE is an MCDS input picture size register.

Data sheet 10.6 ISP_MCDS_SIZE (offset 0x418F0, printed page 10-275, `hi3516av200--Hi3516AV200-Datasheet.txt` line 81210).";

        field {
            name = "height";
            desc = "Input picture height. The configured value is the actual value minus 1. For example, if the actual picture height is 1080, this field needs to be set to 1079.";
            sw = rw;
            hw = r;
            reset = 0x437;
        } height[28:16];

        field {
            name = "width";
            desc = "Input picture width. The configured value is the actual value minus 1. For example, if the actual picture width is 1920, this field needs to be set to 1919.";
            sw = rw;
            hw = r;
            reset = 0x77F;
        } width[12:0];
    } ISP_MCDS_SIZE @ 0x318F0;

    reg {
        name = "Sharpening control register";
        desc = "ISP_SHARPEN_CFG is a sharpening control register.

Data sheet 10.6 ISP_SHARPEN_CFG (offset 0x45200, printed page 10-275, `hi3516av200--Hi3516AV200-Datasheet.txt` line 81239).";

        enum ISP_SHARPEN_CFG_en_enum {
            DISABLED = 0 { name = "Disabled"; desc = "disabled"; };
            ENABLED = 1 { name = "Enabled"; desc = "enabled"; };
        };

        field {
            name = "en";
            desc = "Sharpening enable";
            sw = rw;
            hw = r;
            encode = ISP_SHARPEN_CFG_en_enum;
            reset = 0x0;
        } en[0:0];
    } ISP_SHARPEN_CFG @ 0x35200;

    reg {
        name = "Sharpening strength register";
        desc = "ISP_SHARPEN_AMT is a sharpening strength register.

Data sheet 10.6 ISP_SHARPEN_AMT (offset 0x45210, printed page 10-276, `hi3516av200--Hi3516AV200-Datasheet.txt` line 81267).";

        field {
            name = "edge_amt";
            desc = "Edge enhancement strength (u, 12.0). (u, 12.0) indicates that the value is an unsigned number consisting of a 12-bit integral part and a 0-bit decimal part. The same rule applies to the meanings of other fields of sharpening registers.";
            sw = rw;
            hw = r;
            reset = 0x0;
        } edge_amt[27:16];

        field {
            name = "sharp_amt";
            desc = "Detail enhancement strength (u, 12.0)";
            sw = rw;
            hw = r;
            reset = 0x0;
        } sharp_amt[11:0];
    } ISP_SHARPEN_AMT @ 0x35210;

    reg {
        name = "Sharpening shoot AMT control register";
        desc = "ISP_SHARPEN_SHOOTAMT is a sharpening shoot AMT control register.

Data sheet 10.6 ISP_SHARPEN_SHOOTAMT (offset 0x4521C, printed page 10-276, `hi3516av200--Hi3516AV200-Datasheet.txt` line 81293).";

        field {
            name = "over_amt";
            desc = "Overshoot control coefficient (u, 8.0)";
            sw = rw;
            hw = r;
            reset = 0x0;
        } over_amt[23:16];

        field {
            name = "under_amt";
            desc = "Undershoot control coefficient (u, 8.0)";
            sw = rw;
            hw = r;
            reset = 0x0;
        } under_amt[7:0];
    } ISP_SHARPEN_SHOOTAMT @ 0x3521C;

    reg {
        name = "Jag high-frequency parameter register";
        desc = "ISP_SHARPEN_EDGEJAG is a jag high-frequency parameter register. Hi3516A V200 Professional HD IP Camera SoC

Data sheet 10.6 ISP_SHARPEN_EDGEJAG (offset 0x45224, printed page 10-277, `hi3516av200--Hi3516AV200-Datasheet.txt` line 81324).";

        field {
            name = "edgejagamt";
            desc = "Jag high-frequency gain, 12-bit unsigned integer";
            sw = rw;
            hw = r;
            reset = 0x0;
        } edgejagamt[11:0];
    } ISP_SHARPEN_EDGEJAG @ 0x35224;

    reg {
        name = "Jag overshoot parameter register";
        desc = "ISP_SHARPEN_OSHTJAG is a jag overshoot parameter register.

Data sheet 10.6 ISP_SHARPEN_OSHTJAG (offset 0x45228, printed page 10-277, `hi3516av200--Hi3516AV200-Datasheet.txt` line 81347).";

        field {
            name = "oshtjagamt";
            desc = "Jag overshoot gain, 8-bit unsigned integer";
            sw = rw;
            hw = r;
            reset = 0x0;
        } oshtjagamt[7:0];
    } ISP_SHARPEN_OSHTJAG @ 0x35228;

    reg {
        name = "Jag undershoot parameter register";
        desc = "ISP_SHARPEN_USHTJAG is a jag undershoot parameter register. Hi3516A V200 Professional HD IP Camera SoC

Data sheet 10.6 ISP_SHARPEN_USHTJAG (offset 0x4522C, printed page 10-278, `hi3516av200--Hi3516AV200-Datasheet.txt` line 81380).";

        field {
            name = "ushtjagamt";
            desc = "Jag undershoot gain, 8-bit unsigned integer";
            sw = rw;
            hw = r;
            reset = 0x0;
        } ushtjagamt[7:0];
    } ISP_SHARPEN_USHTJAG @ 0x3522C;

    reg {
        name = "Sharpening IF filtering coefficient register";
        desc = "ISP_SHARPEN_MID0 is a sharpening IF filtering coefficient register.

Data sheet 10.6 ISP_SHARPEN_MID0 (offset 0x45230, printed page 10-278, `hi3516av200--Hi3516AV200-Datasheet.txt` line 81403).";

        field {
            name = "mid_tmp02";
            desc = "IF filtering coefficient 02 (s, 8.0). (s, 8.0) indicates that the value is a signed number consisting of an 8-bit integral part and a 0-bit decimal part. The same rule applies to the meanings of other fields of sharpening registers.";
            sw = rw;
            hw = r;
            reset = 0x0;
        } mid_tmp02[23:16];

        field {
            name = "mid_tmp01";
            desc = "IF filtering coefficient 01 (s, 8.0)";
            sw = rw;
            hw = r;
            reset = 0x0;
        } mid_tmp01[15:8];

        field {
            name = "mid_tmp00";
            desc = "IF filtering coefficient 00 (s, 8.0)";
            sw = rw;
            hw = r;
            reset = 0x0;
        } mid_tmp00[7:0];
    } ISP_SHARPEN_MID0 @ 0x35230;

    reg {
        name = "Sharpening IF filtering coefficient register";
        desc = "ISP_SHARPEN_MID1 is a sharpening IF filtering coefficient register. Hi3516A V200 Professional HD IP Camera SoC

Data sheet 10.6 ISP_SHARPEN_MID1 (offset 0x45234, printed page 10-279, `hi3516av200--Hi3516AV200-Datasheet.txt` line 81437).";

        field {
            name = "mid_tmp12";
            desc = "IF filtering coefficient 12 (s, 8.0)";
            sw = rw;
            hw = r;
            reset = 0x0;
        } mid_tmp12[23:16];

        field {
            name = "mid_tmp11";
            desc = "IF filtering coefficient 11 (s, 8.0)";
            sw = rw;
            hw = r;
            reset = 0x0;
        } mid_tmp11[15:8];

        field {
            name = "mid_tmp10";
            desc = "IF filtering coefficient 10 (s, 8.0)";
            sw = rw;
            hw = r;
            reset = 0x0;
        } mid_tmp10[7:0];
    } ISP_SHARPEN_MID1 @ 0x35234;

    reg {
        name = "Sharpening IF filtering coefficient register";
        desc = "ISP_SHARPEN_MID2 is a sharpening IF filtering coefficient register.

Data sheet 10.6 ISP_SHARPEN_MID2 (offset 0x45238, printed page 10-279, `hi3516av200--Hi3516AV200-Datasheet.txt` line 81459).";

        field {
            name = "mid_tmp22";
            desc = "IF filtering coefficient 22 (s, 8.0)";
            sw = rw;
            hw = r;
            reset = 0x0;
        } mid_tmp22[23:16];

        field {
            name = "mid_tmp21";
            desc = "IF filtering coefficient 21 (s, 8.0)";
            sw = rw;
            hw = r;
            reset = 0x0;
        } mid_tmp21[15:8];

        field {
            name = "mid_tmp20";
            desc = "IF filtering coefficient 20 (s, 8.0)";
            sw = rw;
            hw = r;
            reset = 0x0;
        } mid_tmp20[7:0];
    } ISP_SHARPEN_MID2 @ 0x35238;

    reg {
        name = "Sharpening line detection threshold register";
        desc = "ISP_SHARPEN_LINETHD is a sharpening line detection threshold register. Hi3516A V200 Professional HD IP Camera SoC

Data sheet 10.6 ISP_SHARPEN_LINETHD (offset 0x4523C, printed page 10-280, `hi3516av200--Hi3516AV200-Datasheet.txt` line 81490).";

        field {
            name = "line_thd2";
            desc = "Line detection threshold 2 (u, 8.0)";
            sw = rw;
            hw = r;
            reset = 0x0;
        } line_thd2[23:16];

        field {
            name = "line_thd1";
            desc = "Line detection threshold 1 (u, 8.0)";
            sw = rw;
            hw = r;
            reset = 0x0;
        } line_thd1[7:0];
    } ISP_SHARPEN_LINETHD @ 0x3523C;

    reg {
        name = "Sharpening threshold register 2";
        desc = "ISP_SHARPEN_THD2 is sharpening threshold register 2.

Data sheet 10.6 ISP_SHARPEN_THD2 (offset 0x45240, printed page 10-280, `hi3516av200--Hi3516AV200-Datasheet.txt` line 81512).";

        field {
            name = "edge_thd2";
            desc = "Edge enhancement threshold (u, 10.0)";
            sw = rw;
            hw = r;
            reset = 0x0;
        } edge_thd2[25:16];

        field {
            name = "sharp_thd2";
            desc = "Detail enhancement threshold (u, 10.0)";
            sw = rw;
            hw = r;
            reset = 0x0;
        } sharp_thd2[9:0];
    } ISP_SHARPEN_THD2 @ 0x35240;

    reg {
        name = "Sharpening control register";
        desc = "ISP_SHARPEN_CTRL is a sharpening control register. Hi3516A V200 Professional HD IP Camera SoC

Data sheet 10.6 ISP_SHARPEN_CTRL (offset 0x45244, printed page 10-281, `hi3516av200--Hi3516AV200-Datasheet.txt` line 81543).";

        enum ISP_SHARPEN_CTRL_jagctrl_enum {
            NO = 0 { name = "No"; desc = "no"; };
            YES = 1 { name = "Yes"; desc = "yes"; };
        };

        field {
            name = "jagctrl";
            desc = "Whether to use the jag control switch";
            sw = rw;
            hw = r;
            encode = ISP_SHARPEN_CTRL_jagctrl_enum;
            reset = 0x0;
        } jagctrl[4:4];

        enum ISP_SHARPEN_CTRL_shtlumamod_enum {
            NO = 0 { name = "No"; desc = "no"; };
            YES = 1 { name = "Yes"; desc = "yes"; };
        };

        field {
            name = "shtlumamod";
            desc = "Whether to use the luminance to control the overshoot";
            sw = rw;
            hw = r;
            encode = ISP_SHARPEN_CTRL_shtlumamod_enum;
            reset = 0x0;
        } shtlumamod[3:3];

        enum ISP_SHARPEN_CTRL_shtvarctrl_enum {
            DISABLED = 0 { name = "Disabled"; desc = "disabled"; };
            ENABLED = 1 { name = "Enabled"; desc = "enabled"; };
        };

        field {
            name = "shtvarctrl";
            desc = "Variance control enable";
            sw = rw;
            hw = r;
            encode = ISP_SHARPEN_CTRL_shtvarctrl_enum;
            reset = 0x0;
        } shtvarctrl[2:2];

        enum ISP_SHARPEN_CTRL_lumactrl_enum {
            DISABLED = 0 { name = "Disabled"; desc = "disabled"; };
            ENABLED = 1 { name = "Enabled"; desc = "enabled"; };
        };

        field {
            name = "lumactrl";
            desc = "Luminance control";
            sw = rw;
            hw = r;
            encode = ISP_SHARPEN_CTRL_lumactrl_enum;
            reset = 0x0;
        } lumactrl[1:1];

        enum ISP_SHARPEN_CTRL_enpixsel_enum {
            ORIGINAL_VALUE_SELECTED = 0 { name = "Original Value Selected"; desc = "The original value is selected."; };
            MAXIMUM_MINIMUM_FIELD = 1 { name = "Maximum Minimum Field"; desc = "The maximum/minimum field value is selected."; };
        };

        field {
            name = "enpixsel";
            desc = "Overshoot suppression";
            sw = rw;
            hw = r;
            encode = ISP_SHARPEN_CTRL_enpixsel_enum;
            reset = 0x0;
        } enpixsel[0:0];
    } ISP_SHARPEN_CTRL @ 0x35244;

    reg {
        name = "Luma threshold parameter register";
        desc = "ISP_SHARPEN_LUMATH is a luma threshold parameter register. Hi3516A V200 Professional HD IP Camera SoC

Data sheet 10.6 ISP_SHARPEN_LUMATH (offset 0x45248, printed page 10-282, `hi3516av200--Hi3516AV200-Datasheet.txt` line 81592).";

        field {
            name = "lumath3";
            desc = "Luminance control threshold 3";
            sw = rw;
            hw = r;
            reset = 0x0;
        } lumath3[31:24];

        field {
            name = "lumath2";
            desc = "Luminance control threshold 2";
            sw = rw;
            hw = r;
            reset = 0x0;
        } lumath2[23:16];

        field {
            name = "lumath1";
            desc = "Luminance control threshold 1";
            sw = rw;
            hw = r;
            reset = 0x0;
        } lumath1[15:8];

        field {
            name = "lumath0";
            desc = "Luminance control threshold 0";
            sw = rw;
            hw = r;
            reset = 0x0;
        } lumath0[7:0];
    } ISP_SHARPEN_LUMATH @ 0x35248;

    reg {
        name = "Luma weight parameter register";
        desc = "ISP_SHARPEN_LUMAWGT is a luma weight parameter register.

Data sheet 10.6 ISP_SHARPEN_LUMAWGT (offset 0x4524C, printed page 10-282, `hi3516av200--Hi3516AV200-Datasheet.txt` line 81614).";

        field {
            name = "lumawgt3";
            desc = "Luminance weight 3";
            sw = rw;
            hw = r;
            reset = 0x0;
        } lumawgt3[31:24];

        field {
            name = "lumawgt2";
            desc = "Luminance weight 2";
            sw = rw;
            hw = r;
            reset = 0x0;
        } lumawgt2[23:16];

        field {
            name = "lumawgt1";
            desc = "Luminance weight 1";
            sw = rw;
            hw = r;
            reset = 0x0;
        } lumawgt1[15:8];

        field {
            name = "lumawgt0";
            desc = "Luminance weight 0";
            sw = rw;
            hw = r;
            reset = 0x0;
        } lumawgt0[7:0];
    } ISP_SHARPEN_LUMAWGT @ 0x3524C;

    reg {
        name = "Variance threshold parameter register 0";
        desc = "ISP_SHARPEN_OSHTVARTH is variance threshold parameter register 0. Hi3516A V200 Professional HD IP Camera SoC

Data sheet 10.6 ISP_SHARPEN_OSHTVARTH (offset 0x45258, printed page 10-283, `hi3516av200--Hi3516AV200-Datasheet.txt` line 81645).";

        field {
            name = "overvarth1";
            desc = "Overshoot variance threshold 1";
            sw = rw;
            hw = r;
            reset = 0x0;
        } overvarth1[25:16];

        field {
            name = "overvarth0";
            desc = "Overshoot variance threshold 0";
            sw = rw;
            hw = r;
            reset = 0x0;
        } overvarth0[9:0];
    } ISP_SHARPEN_OSHTVARTH @ 0x35258;

    reg {
        name = "Overshoot variance parameter register 0";
        desc = "ISP_SHARPEN_OSHTVAR is overshoot variance parameter register 0.

Data sheet 10.6 ISP_SHARPEN_OSHTVAR (offset 0x4525C, printed page 10-283, `hi3516av200--Hi3516AV200-Datasheet.txt` line 81667).";

        field {
            name = "overvaramt";
            desc = "Overshoot variance gain";
            sw = rw;
            hw = r;
            reset = 0x0;
        } overvaramt[7:0];
    } ISP_SHARPEN_OSHTVAR @ 0x3525C;

    reg {
        name = "Variance threshold parameter register 1";
        desc = "ISP_SHARPEN_USHTVARTH is variance threshold parameter register 1. Hi3516A V200 Professional HD IP Camera SoC

Data sheet 10.6 ISP_SHARPEN_USHTVARTH (offset 0x45260, printed page 10-284, `hi3516av200--Hi3516AV200-Datasheet.txt` line 81699).";

        field {
            name = "undervarth1";
            desc = "Undershoot variance threshold 1";
            sw = rw;
            hw = r;
            reset = 0x0;
        } undervarth1[25:16];

        field {
            name = "undervarth0";
            desc = "Undershoot variance threshold 0";
            sw = rw;
            hw = r;
            reset = 0x0;
        } undervarth0[9:0];
    } ISP_SHARPEN_USHTVARTH @ 0x35260;

    reg {
        name = "Overshoot variance parameter register 1";
        desc = "ISP_SHARPEN_USHTVAR is overshoot variance parameter register 1.

Data sheet 10.6 ISP_SHARPEN_USHTVAR (offset 0x45264, printed page 10-284, `hi3516av200--Hi3516AV200-Datasheet.txt` line 81721).";

        field {
            name = "undervaramt";
            desc = "Undershoot variance gain";
            sw = rw;
            hw = r;
            reset = 0x0;
        } undervaramt[7:0];
    } ISP_SHARPEN_USHTVAR @ 0x35264;

    reg {
        name = "Overshoot luminance parameter register 0";
        desc = "ISP_SHARPEN_OSHTLUMA is overshoot luminance parameter register 0. Hi3516A V200 Professional HD IP Camera SoC

Data sheet 10.6 ISP_SHARPEN_OSHTLUMA (offset 0x45268, printed page 10-285, `hi3516av200--Hi3516AV200-Datasheet.txt` line 81753).";

        field {
            name = "overlumawgt1";
            desc = "Luminance weight 1";
            sw = rw;
            hw = r;
            reset = 0x0;
        } overlumawgt1[31:24];

        field {
            name = "overlumawgt0";
            desc = "Luminance weight 0";
            sw = rw;
            hw = r;
            reset = 0x0;
        } overlumawgt0[23:16];

        field {
            name = "overlumath1";
            desc = "Luminance threshold 1";
            sw = rw;
            hw = r;
            reset = 0x0;
        } overlumath1[15:8];

        field {
            name = "overlumath0";
            desc = "Luminance threshold 0";
            sw = rw;
            hw = r;
            reset = 0x0;
        } overlumath0[7:0];
    } ISP_SHARPEN_OSHTLUMA @ 0x35268;

    reg {
        name = "Overshoot luminance parameter register 1";
        desc = "ISP_SHARPEN_USHTLUMA is overshoot luminance parameter register 1.

Data sheet 10.6 ISP_SHARPEN_USHTLUMA (offset 0x4526C, printed page 10-285, `hi3516av200--Hi3516AV200-Datasheet.txt` line 81775).";

        field {
            name = "underlumawgt1";
            desc = "Luminance weight 1";
            sw = rw;
            hw = r;
            reset = 0x0;
        } underlumawgt1[31:24];

        field {
            name = "underlumawgt0";
            desc = "Luminance weight 0";
            sw = rw;
            hw = r;
            reset = 0x0;
        } underlumawgt0[23:16];

        field {
            name = "underlumath1";
            desc = "Luminance threshold 1";
            sw = rw;
            hw = r;
            reset = 0x0;
        } underlumath1[15:8];

        field {
            name = "underlumath0";
            desc = "Luminance threshold 0";
            sw = rw;
            hw = r;
            reset = 0x0;
        } underlumath0[7:0];
    } ISP_SHARPEN_USHTLUMA @ 0x3526C;

    reg {
        name = "Shift parameter register";
        desc = "ISP_SHARPEN_SHIFT is a shift parameter register. Hi3516A V200 Professional HD IP Camera SoC

Data sheet 10.6 ISP_SHARPEN_SHIFT (offset 0x45274, printed page 10-286, `hi3516av200--Hi3516AV200-Datasheet.txt` line 81806).";

        field {
            name = "limit";
            desc = "Limit for the coring function";
            sw = rw;
            hw = r;
            reset = 0x0;
        } limit[19:16];

        field {
            name = "maxshift";
            desc = "Maximum field shift";
            sw = rw;
            hw = r;
            reset = 0x0;
        } maxshift[15:8];

        field {
            name = "minshift";
            desc = "Minimum field shift";
            sw = rw;
            hw = r;
            reset = 0x0;
        } minshift[7:0];
    } ISP_SHARPEN_SHIFT @ 0x35274;

    reg {
        name = "Sharpening picture size register";
        desc = "ISP_SHARPEN_SIZE is a sharpening picture size register.

Data sheet 10.6 ISP_SHARPEN_SIZE (offset 0x452F0, printed page 10-286, `hi3516av200--Hi3516AV200-Datasheet.txt` line 81828).";

        field {
            name = "height";
            desc = "Picture height. The configured value is the actual value minus 1. For example, if the actual picture height is 1080, this field needs to be set to 1079.";
            sw = rw;
            hw = r;
            reset = 0x437;
        } height[28:16];

        field {
            name = "width";
            desc = "Picture width. The configured value is the actual value minus 1. For example, if the actual picture height is 1920, this field needs to be set to 1919.";
            sw = rw;
            hw = r;
            reset = 0x77F;
        } width[12:0];
    } ISP_SHARPEN_SIZE @ 0x352F0;

    reg {
        name = "Dehaze enable register";
        desc = "ISP_DEHAZE_CFG is a dehaze enable register. Hi3516A V200 Professional HD IP Camera SoC

Data sheet 10.6 ISP_DEHAZE_CFG (offset 0x46200, printed page 10-287, `hi3516av200--Hi3516AV200-Datasheet.txt` line 81866).";

        enum ISP_DEHAZE_CFG_en_enum {
            DISABLED = 0 { name = "Disabled"; desc = "disabled"; };
            ENABLED = 1 { name = "Enabled"; desc = "enabled"; };
        };

        field {
            name = "en";
            desc = "Dehaze enable";
            sw = rw;
            hw = r;
            encode = ISP_DEHAZE_CFG_en_enum;
            reset = 0x0;
        } en[0:0];
    } ISP_DEHAZE_CFG @ 0x36200;

    reg {
        name = "Dehaze statistics update register";
        desc = "ISP_DEHAZE_PRE_UPDATE is a dehaze statistics update register.

Data sheet 10.6 ISP_DEHAZE_PRE_UPDATE (offset 0x46210, printed page 10-287, `hi3516av200--Hi3516AV200-Datasheet.txt` line 81888).";

        field {
            name = "pre_update";
            desc = "Dehaze statistics configuration update. This bit is automatically cleared for each frame.";
            sw = rw;
            hw = r;
            reset = 0x0;
        } pre_update[0:0];
    } ISP_DEHAZE_PRE_UPDATE @ 0x36210;

    reg {
        name = "Dehaze block size configuration register";
        desc = "ISP_DEHAZE_BLK_SIZE is a dehaze block size configuration register. Hi3516A V200 Professional HD IP Camera SoC

Data sheet 10.6 ISP_DEHAZE_BLK_SIZE (offset 0x46214, printed page 10-288, `hi3516av200--Hi3516AV200-Datasheet.txt` line 81925).";

        field {
            name = "block_sizeh";
            desc = "Horizontal block size. The configured value is the actual value minus 1.";
            sw = rw;
            hw = r;
            reset = 0x0;
        } block_sizeh[24:16];

        field {
            name = "block_sizev";
            desc = "Vertical block size. The configured value is the actual value minus 1.";
            sw = rw;
            hw = r;
            reset = 0x0;
        } block_sizev[8:0];
    } ISP_DEHAZE_BLK_SIZE @ 0x36214;

    reg {
        name = "Dehaze block quantity register";
        desc = "ISP_DEHAZE_BLK_SUM is a dehaze block quantity register.

Data sheet 10.6 ISP_DEHAZE_BLK_SUM (offset 0x46218, printed page 10-288, `hi3516av200--Hi3516AV200-Datasheet.txt` line 81951).";

        field {
            name = "block_sum";
            desc = "Number of dehaze blocks. The configured value is calculated as follows: Configured value = Number of horizontal blocks x (Number of vertical blocks - 1)";
            sw = rw;
            hw = r;
            reset = 0x0;
        } block_sum[10:0];
    } ISP_DEHAZE_BLK_SUM @ 0x36218;

    reg {
        name = "Dehaze bilinear interpolation point quantity configuration register";
        desc = "ISP_DEHAZE_DC_SIZE is a dehaze bilinear interpolation point quantity configuration register. Hi3516A V200 Professional HD IP Camera SoC

Data sheet 10.6 ISP_DEHAZE_DC_SIZE (offset 0x4621C, printed page 10-289, `hi3516av200--Hi3516AV200-Datasheet.txt` line 81983).";

        field {
            name = "dc_numh";
            desc = "Number of bilinear interpolation horizontal points. The configured value is the actual number of horizontal blocks minus 1.";
            sw = rw;
            hw = r;
            reset = 0x0;
        } dc_numh[9:5];

        field {
            name = "dc_numv";
            desc = "Number of bilinear interpolation vertical points. The configured value is the actual number of vertical blocks minus 1.";
            sw = rw;
            hw = r;
            reset = 0x0;
        } dc_numv[4:0];
    } ISP_DEHAZE_DC_SIZE @ 0x3621C;

    reg {
        name = "ISP_DEHAZE_X";
        desc = "ISP_DEHAZE_X is a configuration register for the horizontal phase difference between the pixels of the dehaze enlarged picture.

Data sheet 10.6 ISP_DEHAZE_X (offset 0x46220, printed page 10-289, `hi3516av200--Hi3516AV200-Datasheet.txt` line 82009).";

        field {
            name = "phase_x";
            desc = "Horizontal phase difference between the pixels of the enlarged picture, unsigned integer. The configured value is calculated as follows: Configured value = Horizontal block size x (1<<22)";
            sw = rw;
            hw = r;
            reset = 0x0;
        } phase_x[23:0];
    } ISP_DEHAZE_X @ 0x36220;

    reg {
        name = "ISP_DEHAZE_Y";
        desc = "ISP_DEHAZE_Y is a configuration register for the vertical phase difference between the pixels of the dehaze enlarged picture. Hi3516A V200 Professional HD IP Camera SoC

Data sheet 10.6 ISP_DEHAZE_Y (offset 0x46224, printed page 10-290, `hi3516av200--Hi3516AV200-Datasheet.txt` line 82041).";

        field {
            name = "phase_y";
            desc = "Vertical phase difference between the pixels of the enlarged picture, unsigned integer. The configured value is calculated as follows: Configured value = Horizontal block size x (1<<22)";
            sw = rw;
            hw = r;
            reset = 0x0;
        } phase_y[23:0];
    } ISP_DEHAZE_Y @ 0x36224;

    reg {
        name = "Dehaze statistics module control register";
        desc = "ISP_DEHAZE_STAT_MODE is a dehaze statistics module control register.

Data sheet 10.6 ISP_DEHAZE_STAT_MODE (offset 0x46228, printed page 10-290, `hi3516av200--Hi3516AV200-Datasheet.txt` line 82063).";

        enum ISP_DEHAZE_STAT_MODE_max_mode_enum {
            MEAN_FILTERING_PERFORMED = 0 { name = "Mean Filtering Performed"; desc = "Mean filtering is performed on RGB components, and then the RGB components corresponding to the maximum RGB sum of each window are counted."; };
            RGB_COMPONENTS_CORRESPONDING = 1 { name = "Rgb Components Corresponding"; desc = "The RGB components corresponding to the maximum RGB sum of each window are counted."; };
        };

        field {
            name = "max_mode";
            desc = "Maximum value statistics control";
            sw = rw;
            hw = r;
            encode = ISP_DEHAZE_STAT_MODE_max_mode_enum;
            reset = 0x0;
        } max_mode[0:0];
    } ISP_DEHAZE_STAT_MODE @ 0x36228;

    reg {
        name = "Dehaze inversion control register";
        desc = "ISP_DEHAZE_NEG_MODE is a dehaze inversion control register. Hi3516A V200 Professional HD IP Camera SoC

Data sheet 10.6 ISP_DEHAZE_NEG_MODE (offset 0x4622C, printed page 10-291, `hi3516av200--Hi3516AV200-Datasheet.txt` line 82104).";

        enum ISP_DEHAZE_NEG_MODE_neg_mode_enum {
            NORMAL_MODE = 0 { name = "Normal Mode"; desc = "normal mode"; };
            INVERSION_MODE = 1 { name = "Inversion Mode"; desc = "inversion mode"; };
        };

        field {
            name = "neg_mode";
            desc = "Inversion mode control";
            sw = rw;
            hw = r;
            encode = ISP_DEHAZE_NEG_MODE_neg_mode_enum;
            reset = 0x0;
        } neg_mode[0:0];
    } ISP_DEHAZE_NEG_MODE @ 0x3622C;

    reg {
        name = "Dehaze airglow configuration register";
        desc = "ISP_DEHAZE_AIR is a dehaze airglow configuration register.

Data sheet 10.6 ISP_DEHAZE_AIR (offset 0x46230, printed page 10-291, `hi3516av200--Hi3516AV200-Datasheet.txt` line 82131).";

        field {
            name = "air_r";
            desc = "Airglow A corresponding to the R channel";
            sw = rw;
            hw = r;
            reset = 0x0;
        } air_r[29:20];

        field {
            name = "air_g";
            desc = "Airglow A corresponding to the G channel";
            sw = rw;
            hw = r;
            reset = 0x0;
        } air_g[19:10];

        field {
            name = "air_b";
            desc = "Airglow A corresponding to the B channel";
            sw = rw;
            hw = r;
            reset = 0x0;
        } air_b[9:0];
    } ISP_DEHAZE_AIR @ 0x36230;

    reg {
        name = "Dehaze T threshold coefficient configuration register";
        desc = "ISP_DEHAZE_THLD is a dehaze T threshold coefficient configuration register. Hi3516A V200 Professional HD IP Camera SoC

Data sheet 10.6 ISP_DEHAZE_THLD (offset 0x46234, printed page 10-292, `hi3516av200--Hi3516AV200-Datasheet.txt` line 82166).";

        field {
            name = "thld";
            desc = "T threshold coefficient, unsigned integer";
            sw = rw;
            hw = r;
            reset = 0x0;
        } thld[9:0];
    } ISP_DEHAZE_THLD @ 0x36234;

    reg {
        name = "Dehaze global strength coefficient register";
        desc = "ISP_DEHAZE_GSTRTH is a dehaze global strength coefficient register.

Data sheet 10.6 ISP_DEHAZE_GSTRTH (offset 0x46238, printed page 10-292, `hi3516av200--Hi3516AV200-Datasheet.txt` line 82186).";

        field {
            name = "gstrth";
            desc = "G calculation coefficient, unsigned integer";
            sw = rw;
            hw = r;
            reset = 0x0;
        } gstrth[7:0];
    } ISP_DEHAZE_GSTRTH @ 0x36238;

    reg {
        name = "Dehaze minimum value filtering threshold coefficient configuration register";
        desc = "ISP_DEHAZE_BLTHLD is a dehaze minimum value filtering threshold coefficient configuration register.

Data sheet 10.6 ISP_DEHAZE_BLTHLD (offset 0x4623C, printed page 10-292, `hi3516av200--Hi3516AV200-Datasheet.txt` line 82206).";

        field {
            name = "blthld";
            desc = "Threshold coefficient of the minimum value filtering, unsigned integer";
            sw = rw;
            hw = r;
            reset = 0x0;
        } blthld[9:0];
    } ISP_DEHAZE_BLTHLD @ 0x3623C;

    reg {
        name = "Dehaze strength table update register";
        desc = "ISP_DEHAZE_STR_LUT_UPDATE is a dehaze strength table update register.

Data sheet 10.6 ISP_DEHAZE_STR_LUT_UPDATE (offset 0x46240, printed page 10-293, `hi3516av200--Hi3516AV200-Datasheet.txt` line 82236).";

        field {
            name = "str_lut_update";
            desc = "Configuration update for the dehaze strength table. This bit is automatically cleared for each frame.";
            sw = rw;
            hw = r;
            reset = 0x0;
        } str_lut_update[0:0];
    } ISP_DEHAZE_STR_LUT_UPDATE @ 0x36240;

    reg {
        name = "Dehaze minimum value statistics write address register";
        desc = "ISP_DEHAZE_MINSTAT_WADDR is a dehaze minimum value statistics write address register.

Data sheet 10.6 ISP_DEHAZE_MINSTAT_WADDR (offset 0x46280, printed page 10-293, `hi3516av200--Hi3516AV200-Datasheet.txt` line 82265).";

        field {
            name = "minstat_waddr";
            desc = "Write address of the dehaze minimum value statistics. The value range is 0-511.";
            sw = rw;
            hw = r;
            reset = 0x0;
        } minstat_waddr[8:0];
    } ISP_DEHAZE_MINSTAT_WADDR @ 0x36280;

    reg {
        name = "Dehaze minimum value statistics write data register";
        desc = "ISP_DEHAZE_MINSTAT_WDATA is a dehaze minimum value statistics write data register. Hi3516A V200 Professional HD IP Camera SoC

Data sheet 10.6 ISP_DEHAZE_MINSTAT_WDATA (offset 0x46284, printed page 10-294, `hi3516av200--Hi3516AV200-Datasheet.txt` line 82293).";

        field {
            name = "minstat_wdata_h";
            desc = "ID of the block with the larger ID between the two blocks to which the dehaze minimum value statistics are written";
            sw = rw;
            hw = r;
            reset = 0x0;
        } minstat_wdata_h[25:16];

        field {
            name = "minstat_wdata_l";
            desc = "ID of the block with the smaller ID between the two blocks to which the dehaze minimum value statistics are written";
            sw = rw;
            hw = r;
            reset = 0x0;
        } minstat_wdata_l[9:0];
    } ISP_DEHAZE_MINSTAT_WDATA @ 0x36284;

    reg {
        name = "Dehaze minimum value statistics read address register";
        desc = "ISP_DEHAZE_MINSTAT_RADDR is a dehaze minimum value statistics read address register.

Data sheet 10.6 ISP_DEHAZE_MINSTAT_RADDR (offset 0x46288, printed page 10-294, `hi3516av200--Hi3516AV200-Datasheet.txt` line 82320).";

        field {
            name = "minstat_raddr";
            desc = "Read address of the dehaze minimum value statistics. The value range is 0-511.";
            sw = rw;
            hw = r;
            reset = 0x0;
        } minstat_raddr[8:0];
    } ISP_DEHAZE_MINSTAT_RADDR @ 0x36288;

    reg {
        name = "Dehaze minimum value statistics read data register";
        desc = "ISP_DEHAZE_MINSTAT_RDATA is a dehaze minimum value statistics read data register. Hi3516A V200 Professional HD IP Camera SoC

Data sheet 10.6 ISP_DEHAZE_MINSTAT_RDATA (offset 0x4628C, printed page 10-295, `hi3516av200--Hi3516AV200-Datasheet.txt` line 82351).";

        field {
            name = "minstat_rdata_h";
            desc = "ID of the block with the larger ID between the two blocks from which the dehaze minimum value statistics are read";
            sw = r;
            hw = w;
            reset = 0x0;
        } minstat_rdata_h[25:16];

        field {
            name = "minstat_rdata_l";
            desc = "ID of the block with the smaller ID between the two blocks from which the dehaze minimum value statistics are read";
            sw = r;
            hw = w;
            reset = 0x0;
        } minstat_rdata_l[9:0];
    } ISP_DEHAZE_MINSTAT_RDATA @ 0x3628C;

    reg {
        name = "Dehaze maximum value statistics write address register";
        desc = "ISP_DEHAZE_MAXSTAT_WADDR is a dehaze maximum value statistics write address register.

Data sheet 10.6 ISP_DEHAZE_MAXSTAT_WADDR (offset 0x46290, printed page 10-295, `hi3516av200--Hi3516AV200-Datasheet.txt` line 82378).";

        field {
            name = "maxstat_waddr";
            desc = "Write address of the dehaze maximum value statistics. The value range is 0-1023.";
            sw = rw;
            hw = r;
            reset = 0x0;
        } maxstat_waddr[9:0];
    } ISP_DEHAZE_MAXSTAT_WADDR @ 0x36290;

    reg {
        name = "Dehaze maximum value statistics write data register";
        desc = "ISP_DEHAZE_MAXSTAT_WDATA is a dehaze maximum value statistics write data register. Hi3516A V200 Professional HD IP Camera SoC

Data sheet 10.6 ISP_DEHAZE_MAXSTAT_WDATA (offset 0x46294, printed page 10-296, `hi3516av200--Hi3516AV200-Datasheet.txt` line 82409).";

        field {
            name = "maxstat_wdata";
            desc = "Write data of the dehaze maximum value statistics";
            sw = rw;
            hw = r;
            reset = 0x0;
        } maxstat_wdata[29:0];
    } ISP_DEHAZE_MAXSTAT_WDATA @ 0x36294;

    reg {
        name = "Dehaze maximum value statistics read address register";
        desc = "ISP_DEHAZE_MAXSTAT_RADDR is a dehaze maximum value statistics read address register.

Data sheet 10.6 ISP_DEHAZE_MAXSTAT_RADDR (offset 0x46298, printed page 10-296, `hi3516av200--Hi3516AV200-Datasheet.txt` line 82433).";

        field {
            name = "maxstat_raddr";
            desc = "Read address of the dehaze maximum value statistics. The value range is 0-1023.";
            sw = rw;
            hw = r;
            reset = 0x0;
        } maxstat_raddr[9:0];
    } ISP_DEHAZE_MAXSTAT_RADDR @ 0x36298;

    reg {
        name = "Dehaze maximum value statistics read data register";
        desc = "ISP_DEHAZE_MAXSTAT_RDATA is a dehaze maximum value statistics read data register. Hi3516A V200 Professional HD IP Camera SoC

Data sheet 10.6 ISP_DEHAZE_MAXSTAT_RDATA (offset 0x4629C, printed page 10-297, `hi3516av200--Hi3516AV200-Datasheet.txt` line 82463).";

        field {
            name = "maxstat_rdata";
            desc = "Read data of the dehaze maximum value statistics (R: bit[29:20]; G: bit[19:10]; B: bit[9:0])";
            sw = r;
            hw = w;
            reset = 0x0;
        } maxstat_rdata[29:0];
    } ISP_DEHAZE_MAXSTAT_RDATA @ 0x3629C;

    reg {
        name = "Dehaze previous frame minimum value statistics write address register";
        desc = "ISP_DEHAZE_PRESTAT_WADDR is a dehaze previous frame minimum value statistics write address register.

Data sheet 10.6 ISP_DEHAZE_PRESTAT_WADDR (offset 0x462A0, printed page 10-297, `hi3516av200--Hi3516AV200-Datasheet.txt` line 82489).";

        field {
            name = "prestat_waddr";
            desc = "Write address of the dehaze previous frame minimum value statistics. The value range is 0-511.";
            sw = rw;
            hw = r;
            reset = 0x0;
        } prestat_waddr[9:0];
    } ISP_DEHAZE_PRESTAT_WADDR @ 0x362A0;

    reg {
        name = "Dehaze previous frame minimum value statistics write data register";
        desc = "ISP_DEHAZE_PRESTAT_WDATA is a dehaze previous frame minimum value statistics write data register. Hi3516A V200 Professional HD IP Camera SoC

Data sheet 10.6 ISP_DEHAZE_PRESTAT_WDATA (offset 0x462A4, printed page 10-298, `hi3516av200--Hi3516AV200-Datasheet.txt` line 82521).";

        field {
            name = "prestat_wdata_h";
            desc = "ID of the block with the larger ID between the two blocks to which the dehaze previous frame minimum value statistics are written";
            sw = rw;
            hw = r;
            reset = 0x0;
        } prestat_wdata_h[25:16];

        field {
            name = "prestat_wdata_l";
            desc = "ID of the block with the smaller ID between the two blocks to which the dehaze previous frame minimum value statistics are written";
            sw = rw;
            hw = r;
            reset = 0x0;
        } prestat_wdata_l[9:0];
    } ISP_DEHAZE_PRESTAT_WDATA @ 0x362A4;

    reg {
        name = "Dehaze previous frame minimum value statistics read address register";
        desc = "ISP_DEHAZE_PRESTAT_RADDR is a dehaze previous frame minimum value statistics read address register.

Data sheet 10.6 ISP_DEHAZE_PRESTAT_RADDR (offset 0x462A8, printed page 10-298, `hi3516av200--Hi3516AV200-Datasheet.txt` line 82548).";

        field {
            name = "prestat_raddr";
            desc = "Read address of the dehaze previous frame minimum value statistics. The value range is 0-511.";
            sw = rw;
            hw = r;
            reset = 0x0;
        } prestat_raddr[9:0];
    } ISP_DEHAZE_PRESTAT_RADDR @ 0x362A8;

    reg {
        name = "Dehaze previous frame minimum value statistics read data register";
        desc = "ISP_DEHAZE_PRESTAT_RDATA is a dehaze previous frame minimum value statistics read data register. Hi3516A V200 Professional HD IP Camera SoC

Data sheet 10.6 ISP_DEHAZE_PRESTAT_RDATA (offset 0x462AC, printed page 10-299, `hi3516av200--Hi3516AV200-Datasheet.txt` line 82580).";

        field {
            name = "prestat_rdata_h";
            desc = "ID of the block with the larger ID between the two blocks from which the dehaze previous frame minimum value statistics are read";
            sw = r;
            hw = w;
            reset = 0x0;
        } prestat_rdata_h[25:16];

        field {
            name = "prestat_rdata_l";
            desc = "ID of the block with the smaller ID between the two blocks from which the dehaze previous frame minimum value statistics are read";
            sw = r;
            hw = w;
            reset = 0x0;
        } prestat_rdata_l[9:0];
    } ISP_DEHAZE_PRESTAT_RDATA @ 0x362AC;

    reg {
        name = "Dehaze strength LUT information write address register";
        desc = "ISP_DEHAZE_LUT_WADDR is a dehaze strength LUT information write address register.

Data sheet 10.6 ISP_DEHAZE_LUT_WADDR (offset 0x462B0, printed page 10-299, `hi3516av200--Hi3516AV200-Datasheet.txt` line 82606).";

        field {
            name = "lut_waddr";
            desc = "Write address of the dehaze strength LUT information. The value range is 0-255.";
            sw = rw;
            hw = r;
            reset = 0x0;
        } lut_waddr[7:0];
    } ISP_DEHAZE_LUT_WADDR @ 0x362B0;

    reg {
        name = "Dehaze strength LUT information write data register";
        desc = "ISP_DEHAZE_LUT_WDATA is a dehaze strength LUT information write data register. Hi3516A V200 Professional HD IP Camera SoC

Data sheet 10.6 ISP_DEHAZE_LUT_WDATA (offset 0x462B4, printed page 10-300, `hi3516av200--Hi3516AV200-Datasheet.txt` line 82637).";

        field {
            name = "lut_wdata";
            desc = "Write data of the dehaze strength LUT information";
            sw = rw;
            hw = r;
            reset = 0x0;
        } lut_wdata[7:0];
    } ISP_DEHAZE_LUT_WDATA @ 0x362B4;

    reg {
        name = "Dehaze strength LUT information read address register";
        desc = "ISP_DEHAZE_LUT_RADDR is a dehaze strength LUT information read address register.

Data sheet 10.6 ISP_DEHAZE_LUT_RADDR (offset 0x462B8, printed page 10-300, `hi3516av200--Hi3516AV200-Datasheet.txt` line 82657).";

        field {
            name = "lut_raddr";
            desc = "Read address of the dehaze strength LUT information. The value range is 0-255.";
            sw = rw;
            hw = r;
            reset = 0x0;
        } lut_raddr[7:0];
    } ISP_DEHAZE_LUT_RADDR @ 0x362B8;

    reg {
        name = "Dehaze strength LUT information read data register";
        desc = "ISP_DEHAZE_LUT_RDATA is a dehaze strength LUT information read data register.

Data sheet 10.6 ISP_DEHAZE_LUT_RDATA (offset 0x462BC, printed page 10-300, `hi3516av200--Hi3516AV200-Datasheet.txt` line 82678).";

        field {
            name = "lut_rdata";
            desc = "Read data of the dehaze strength LUT information";
            sw = r;
            hw = w;
            reset = 0x0;
        } lut_rdata[7:0];
    } ISP_DEHAZE_LUT_RDATA @ 0x362BC;

    reg {
        name = "Dehaze picture size register";
        desc = "ISP_DEHAZE_SIZE is a dehaze picture size register.

Data sheet 10.6 ISP_DEHAZE_SIZE (offset 0x462F0, printed page 10-301, `hi3516av200--Hi3516AV200-Datasheet.txt` line 82704).";

        field {
            name = "height";
            desc = "Window height (in line). The configured value is the actual value minus 1.";
            sw = rw;
            hw = r;
            reset = 0x437;
        } height[28:16];

        field {
            name = "width";
            desc = "Window width (in pixel). The configured value is the actual value minus 1.";
            sw = rw;
            hw = r;
            reset = 0x77F;
        } width[12:0];
    } ISP_DEHAZE_SIZE @ 0x362F0;

    reg {
        name = "DCI enable register";
        desc = "ISP_DCI_CFG is a DCI enable register.

Data sheet 10.6 ISP_DCI_CFG (offset 0x46400, printed page 10-301, `hi3516av200--Hi3516AV200-Datasheet.txt` line 82733).";

        enum ISP_DCI_CFG_dci_en_enum {
            DISABLED = 0 { name = "Disabled"; desc = "disabled (the data output is bypassed)"; };
            ENABLED = 1 { name = "Enabled"; desc = "enabled (the luminance and contrast adjustment is implemented)"; };
        };

        field {
            name = "dci_en";
            desc = "DCI module enable register";
            sw = rw;
            hw = r;
            encode = ISP_DCI_CFG_dci_en_enum;
            reset = 0x0;
        } dci_en[0:0];
    } ISP_DCI_CFG @ 0x36400;

    reg {
        name = "DCI control register";
        desc = "ISP_DCICTRL is a DCI control register. Hi3516A V200 Professional HD IP Camera SoC

Data sheet 10.6 ISP_DCICTRL (offset 0x46410, printed page 10-302, `hi3516av200--Hi3516AV200-Datasheet.txt` line 82762).";

        enum ISP_DCICTRL_dci_histlpf_en_enum {
            DISABLED = 0 { name = "Disabled"; desc = "disabled"; };
            ENABLED = 1 { name = "Enabled"; desc = "enabled"; };
        };

        field {
            name = "dci_histlpf_en";
            desc = "Histogram low-pass filtering enable";
            sw = rw;
            hw = r;
            encode = ISP_DCICTRL_dci_histlpf_en_enum;
            reset = 0x0;
        } dci_histlpf_en[4:4];

        enum ISP_DCICTRL_dci_cbcrcmp_en_enum {
            DCI_ALGORITHM_DOES = 0 { name = "Dci Algorithm Does"; desc = "The DCI algorithm does not adjust the chrominance component."; };
            DCI_ALGORITHM_ADJUSTS = 1 { name = "Dci Algorithm Adjusts"; desc = "The DCI algorithm adjusts the chrominance component."; };
        };

        field {
            name = "dci_cbcrcmp_en";
            desc = "DCI chrominance compensation enable";
            sw = rw;
            hw = r;
            encode = ISP_DCICTRL_dci_cbcrcmp_en_enum;
            reset = 0x0;
        } dci_cbcrcmp_en[3:3];

        enum ISP_DCICTRL_dci_cbcrsta_en_enum {
            HISTOGRAM_STATISTICS_COLLECTED = 0 { name = "Histogram Statistics Collected"; desc = "Histogram statistics are collected only on the luminance component."; };
            HISTOGRAM_STATISTICS_COLLECTED_2 = 1 { name = "Histogram Statistics Collected 2"; desc = "Histogram statistics are collected on the weighted Y, Cb, and Cr components."; };
        };

        field {
            name = "dci_cbcrsta_en";
            desc = "Histogram statistics select";
            sw = rw;
            hw = r;
            encode = ISP_DCICTRL_dci_cbcrsta_en_enum;
            reset = 0x0;
        } dci_cbcrsta_en[2:2];

        enum ISP_DCICTRL_dci_swcfg_en_enum {
            SELECT_CURVE_CALCULATED = 0 { name = "Select Curve Calculated"; desc = "Select the curve calculated by hardware."; };
            SELECT_CURVE_CONFIGURED = 1 { name = "Select Curve Configured"; desc = "Select the curve configured by software"; };
        };

        field {
            name = "dci_swcfg_en";
            desc = "Select of the three curves that are combined to the adjustment curve";
            sw = rw;
            hw = r;
            encode = ISP_DCICTRL_dci_swcfg_en_enum;
            reset = 0x0;
        } dci_swcfg_en[1:1];

        enum ISP_DCICTRL_dci_hist_wgt_en_enum {
            ORIGINAL_HISTOGRAM_USED = 0 { name = "Original Histogram Used"; desc = "The original histogram is used."; };
            WEIGHTED_HISTOGRAM_USED = 1 { name = "Weighted Histogram Used"; desc = "The weighted histogram is used."; };
        };

        field {
            name = "dci_hist_wgt_en";
            desc = "Histogram statistical method select";
            sw = rw;
            hw = r;
            encode = ISP_DCICTRL_dci_hist_wgt_en_enum;
            reset = 0x0;
        } dci_hist_wgt_en[0:0];
    } ISP_DCICTRL @ 0x36410;

    reg {
        name = "DCI histogram statistics weighted coefficient register";
        desc = "ISP_DCIHISBLD is a DCI histogram statistics weighted coefficient register. Hi3516A V200 Professional HD IP Camera SoC

Data sheet 10.6 ISP_DCIHISBLD (offset 0x46414, printed page 10-303, `hi3516av200--Hi3516AV200-Datasheet.txt` line 82815).";

        field {
            name = "dci_cbcrsta_y";
            desc = "Weighted coefficient of the Y component when histogram statistics are added. It is an 8-bit signed number and the MSB is the sign bit.";
            sw = rw;
            hw = r;
            reset = 0x0;
        } dci_cbcrsta_y[23:16];

        field {
            name = "dci_cbcrsta_cb";
            desc = "Weighted coefficient of the Cb component when histogram statistics are added. It is an 8-bit signed number and the MSB is the sign bit.";
            sw = rw;
            hw = r;
            reset = 0x0;
        } dci_cbcrsta_cb[15:8];

        field {
            name = "dci_cbcrsta_cr";
            desc = "Weighted coefficient of the Cr component when histogram statistics are added. It is an 8-bit signed number and the MSB is the sign bit.";
            sw = rw;
            hw = r;
            reset = 0x0;
        } dci_cbcrsta_cr[7:0];
    } ISP_DCIHISBLD @ 0x36414;

    reg {
        name = "DCI histogram statistics offset register";
        desc = "ISP_DCIHISOFT is a DCI histogram statistics offset register.

Data sheet 10.6 ISP_DCIHISOFT (offset 0x46418, printed page 10-303, `hi3516av200--Hi3516AV200-Datasheet.txt` line 82843).";

        field {
            name = "dci_cbcrsta_oft";
            desc = "dci_cbcrsta_oft";
            sw = rw;
            hw = r;
            reset = 0x0;
        } dci_cbcrsta_oft[8:0];
    } ISP_DCIHISOFT @ 0x36418;

    reg {
        name = "DCI histogram coring register";
        desc = "ISP_DCIHISCOR is a DCI histogram coring register. Hi3516A V200 Professional HD IP Camera SoC

Data sheet 10.6 ISP_DCIHISCOR (offset 0x4641C, printed page 10-304, `hi3516av200--Hi3516AV200-Datasheet.txt` line 82873).";

        field {
            name = "dci_histcor_thr2";
            desc = "Coring threshold for histogram 2";
            sw = rw;
            hw = r;
            reset = 0x0;
        } dci_histcor_thr2[23:16];

        field {
            name = "dci_histcor_thr1";
            desc = "Coring threshold for histogram 1";
            sw = rw;
            hw = r;
            reset = 0x0;
        } dci_histcor_thr1[15:8];

        field {
            name = "dci_histcor_thr0";
            desc = "Coring threshold for histogram 0";
            sw = rw;
            hw = r;
            reset = 0x0;
        } dci_histcor_thr0[7:0];
    } ISP_DCIHISCOR @ 0x3641C;

    reg {
        name = "DCI adjustment unit blend value register";
        desc = "ISP_DCIMERBLD is a DCI adjustment unit blend value register.

Data sheet 10.6 ISP_DCIMERBLD (offset 0x46420, printed page 10-304, `hi3516av200--Hi3516AV200-Datasheet.txt` line 82895).";

        field {
            name = "dci_metrc_abld2";
            desc = "Weighted alpha blend value of the current frame for metric 2";
            sw = rw;
            hw = r;
            reset = 0x0;
        } dci_metrc_abld2[21:16];

        field {
            name = "dci_metrc_abld1";
            desc = "Weighted alpha blend value of the current frame for metric 1";
            sw = rw;
            hw = r;
            reset = 0x0;
        } dci_metrc_abld1[13:8];

        field {
            name = "dci_metrc_abld0";
            desc = "Weighted alpha blend value of the current frame for metric 0";
            sw = rw;
            hw = r;
            reset = 0x0;
        } dci_metrc_abld0[5:0];
    } ISP_DCIMERBLD @ 0x36420;

    reg {
        name = "DCI manually configured curve weight register";
        desc = "ISP_DCIADJWGT is a DCI manually configured curve weight register. Hi3516A V200 Professional HD IP Camera SoC

Data sheet 10.6 ISP_DCIADJWGT (offset 0x46424, printed page 10-305, `hi3516av200--Hi3516AV200-Datasheet.txt` line 82931).";

        field {
            name = "dci_man_adjwgt2";
            desc = "Weighted value of curve 2 in manual mode";
            sw = rw;
            hw = r;
            reset = 0x0;
        } dci_man_adjwgt2[23:16];

        field {
            name = "dci_man_adjwgt1";
            desc = "Weighted value of curve 1 in manual mode";
            sw = rw;
            hw = r;
            reset = 0x0;
        } dci_man_adjwgt1[15:8];

        field {
            name = "dci_man_adjwgt0";
            desc = "Weighted value of curve 0 in manual mode";
            sw = rw;
            hw = r;
            reset = 0x0;
        } dci_man_adjwgt0[7:0];
    } ISP_DCIADJWGT @ 0x36424;

    reg {
        name = "DCI curve 0 weight range register";
        desc = "ISP_DCICLIP0 is a DCI curve 0 weight range register.

Data sheet 10.6 ISP_DCICLIP0 (offset 0x46428, printed page 10-305, `hi3516av200--Hi3516AV200-Datasheet.txt` line 82953).";

        field {
            name = "dci_wgt_cliphigh0";
            desc = "Upper limit of the weighted value of curve 0";
            sw = rw;
            hw = r;
            reset = 0x0;
        } dci_wgt_cliphigh0[15:8];

        field {
            name = "dci_wgt_cliplow0";
            desc = "Lower limit of the weighted value of curve 0";
            sw = rw;
            hw = r;
            reset = 0x0;
        } dci_wgt_cliplow0[7:0];
    } ISP_DCICLIP0 @ 0x36428;

    reg {
        name = "DCI curve 1 weight range register";
        desc = "ISP_DCICLIP1 is a DCI curve 1 weight range register. Hi3516A V200 Professional HD IP Camera SoC

Data sheet 10.6 ISP_DCICLIP1 (offset 0x4642C, printed page 10-306, `hi3516av200--Hi3516AV200-Datasheet.txt` line 82983).";

        field {
            name = "dci_wgt_cliphigh1";
            desc = "Upper limit of the weighted value of curve 1";
            sw = rw;
            hw = r;
            reset = 0x0;
        } dci_wgt_cliphigh1[15:8];

        field {
            name = "dci_wgt_cliplow1";
            desc = "Lower limit of the weighted value of curve 1";
            sw = rw;
            hw = r;
            reset = 0x0;
        } dci_wgt_cliplow1[7:0];
    } ISP_DCICLIP1 @ 0x3642C;

    reg {
        name = "DCI curve 2 weight range register";
        desc = "ISP_DCICLIP2 is a DCI curve 2 weight range register.

Data sheet 10.6 ISP_DCICLIP2 (offset 0x46430, printed page 10-306, `hi3516av200--Hi3516AV200-Datasheet.txt` line 83004).";

        field {
            name = "dci_wgt_cliphigh2";
            desc = "Upper limit of the weighted value of curve 2";
            sw = rw;
            hw = r;
            reset = 0x0;
        } dci_wgt_cliphigh2[15:8];

        field {
            name = "dci_wgt_cliplow2";
            desc = "Lower limit of the weighted value of curve 2";
            sw = rw;
            hw = r;
            reset = 0x0;
        } dci_wgt_cliplow2[7:0];
    } ISP_DCICLIP2 @ 0x36430;

    reg {
        name = "DCI luminance adjustment unit global gain register";
        desc = "ISP_DCIGLBGAIN is a DCI luminance adjustment unit global gain register. Hi3516A V200 Professional HD IP Camera SoC

Data sheet 10.6 ISP_DCIGLBGAIN (offset 0x46434, printed page 10-307, `hi3516av200--Hi3516AV200-Datasheet.txt` line 83033).";

        field {
            name = "dci_glb_gain2";
            desc = "Global gain 2 when the luminance component is adjusted";
            sw = rw;
            hw = r;
            reset = 0x0;
        } dci_glb_gain2[21:16];

        field {
            name = "dci_glb_gain1";
            desc = "Global gain 1 when the luminance component is adjusted";
            sw = rw;
            hw = r;
            reset = 0x0;
        } dci_glb_gain1[13:8];

        field {
            name = "dci_glb_gain0";
            desc = "Global gain 0 when the luminance component is adjusted";
            sw = rw;
            hw = r;
            reset = 0x0;
        } dci_glb_gain0[5:0];
    } ISP_DCIGLBGAIN @ 0x36434;

    reg {
        name = "DCI adjustment unit threshold register 0 during positive adjustment";
        desc = "ISP_DCIPOSTHR0 is DCI adjustment unit threshold register 0 during positive adjustment.

Data sheet 10.6 ISP_DCIPOSTHR0 (offset 0x46438, printed page 10-307, `hi3516av200--Hi3516AV200-Datasheet.txt` line 83060).";

        field {
            name = "gainpos_thr1";
            desc = "Threshold 1 for the luminance (Y) when the picture is adjusted from dark to bright";
            sw = rw;
            hw = r;
            reset = 0x0;
        } gainpos_thr1[31:24];

        field {
            name = "gainpos_thr2";
            desc = "Threshold 2 for the luminance (Y) when the picture is adjusted from dark to bright";
            sw = rw;
            hw = r;
            reset = 0x0;
        } gainpos_thr2[23:16];

        field {
            name = "gainpos_thr3";
            desc = "Threshold 3 for the luminance (Y) when the picture is adjusted from dark to bright";
            sw = rw;
            hw = r;
            reset = 0x0;
        } gainpos_thr3[15:8];

        field {
            name = "gainpos_thr4";
            desc = "Threshold 4 for the luminance (Y) when the picture is adjusted from dark to bright";
            sw = rw;
            hw = r;
            reset = 0x0;
        } gainpos_thr4[7:0];
    } ISP_DCIPOSTHR0 @ 0x36438;

    reg {
        name = "DCI adjustment unit threshold register 1 during positive adjustment";
        desc = "ISP_DCIPOSTHR1 is DCI adjustment unit threshold register 1 during positive adjustment.

Data sheet 10.6 ISP_DCIPOSTHR1 (offset 0x4643C, printed page 10-308, `hi3516av200--Hi3516AV200-Datasheet.txt` line 83095).";

        field {
            name = "gainpos_thr5";
            desc = "Threshold 5 for the luminance (Y) when the picture is adjusted from dark to bright";
            sw = rw;
            hw = r;
            reset = 0x0;
        } gainpos_thr5[23:16];

        field {
            name = "gainpos_thr6";
            desc = "Threshold 6 for the luminance (Y) when the picture is adjusted from dark to bright";
            sw = rw;
            hw = r;
            reset = 0x0;
        } gainpos_thr6[15:8];

        field {
            name = "gainpos_thr7";
            desc = "Threshold 7 for the luminance (Y) when the picture is adjusted from dark to bright";
            sw = rw;
            hw = r;
            reset = 0x0;
        } gainpos_thr7[7:0];
    } ISP_DCIPOSTHR1 @ 0x3643C;

    reg {
        name = "DCI adjustment unit gain register 0 during positive adjustment";
        desc = "ISP_DCIPOSGAIN0 is DCI adjustment unit gain register 0 during positive adjustment.

Data sheet 10.6 ISP_DCIPOSGAIN0 (offset 0x46440, printed page 10-308, `hi3516av200--Hi3516AV200-Datasheet.txt` line 83123).";

        field {
            name = "gainpos0";
            desc = "Chrominance compensation gain of threshold 0 when the picture is adjusted from dark to bright This bit is generally set to 0.";
            sw = rw;
            hw = r;
            reset = 0x0;
        } gainpos0[29:25];

        field {
            name = "gainpos1";
            desc = "Chrominance compensation gain of threshold 1 when the picture is adjusted from dark to bright";
            sw = rw;
            hw = r;
            reset = 0x0;
        } gainpos1[24:20];

        field {
            name = "gainpos2";
            desc = "Chrominance compensation gain of threshold 2 when the picture is adjusted from dark to bright";
            sw = rw;
            hw = r;
            reset = 0x0;
        } gainpos2[19:15];

        field {
            name = "gainpos3";
            desc = "Chrominance compensation gain of threshold 3 when the picture is adjusted from dark to bright";
            sw = rw;
            hw = r;
            reset = 0x0;
        } gainpos3[14:10];

        field {
            name = "gainpos4";
            desc = "Chrominance compensation gain of threshold 4 when the picture is adjusted from dark to bright";
            sw = rw;
            hw = r;
            reset = 0x0;
        } gainpos4[9:5];

        field {
            name = "gainpos5";
            desc = "Chrominance compensation gain of threshold 5 when the picture is adjusted from dark to bright";
            sw = rw;
            hw = r;
            reset = 0x0;
        } gainpos5[4:0];
    } ISP_DCIPOSGAIN0 @ 0x36440;

    reg {
        name = "DCI adjustment unit gain register 1 during positive adjustment";
        desc = "ISP_DCIPOSGAIN1 is DCI adjustment unit gain register 1 during positive adjustment.

Data sheet 10.6 ISP_DCIPOSGAIN1 (offset 0x46444, printed page 10-309, `hi3516av200--Hi3516AV200-Datasheet.txt` line 83171).";

        field {
            name = "gainpos6";
            desc = "Chrominance compensation gain of threshold 6 when the picture is adjusted from dark to bright";
            sw = rw;
            hw = r;
            reset = 0x0;
        } gainpos6[14:10];

        field {
            name = "gainpos7";
            desc = "Chrominance compensation gain of threshold 7 when the picture is adjusted from dark to bright";
            sw = rw;
            hw = r;
            reset = 0x0;
        } gainpos7[9:5];

        field {
            name = "gainpos8";
            desc = "Chrominance compensation gain of threshold 8 when the picture is adjusted from dark to bright";
            sw = rw;
            hw = r;
            reset = 0x0;
        } gainpos8[4:0];
    } ISP_DCIPOSGAIN1 @ 0x36444;

    reg {
        name = "DCI adjustment unit slope register 0 during positive adjustment";
        desc = "ISP_DCIPOSSLP0 is DCI adjustment unit slope register 0 during positive adjustment.

Data sheet 10.6 ISP_DCIPOSSLP0 (offset 0x46448, printed page 10-309, `hi3516av200--Hi3516AV200-Datasheet.txt` line 83199).";

        field {
            name = "dci_gainpos_slp0";
            desc = "Slope of region 0 when the picture is adjusted from dark to bright, 10-bit signed number";
            sw = rw;
            hw = r;
            reset = 0x0;
        } dci_gainpos_slp0[29:20];

        field {
            name = "dci_gainpos_slp1";
            desc = "dci_gainpos_slp1";
            sw = rw;
            hw = r;
            reset = 0x0;
        } dci_gainpos_slp1[19:10];

        field {
            name = "dci_gainpos_slp2";
            desc = "dci_gainpos_slp2";
            sw = rw;
            hw = r;
            reset = 0x0;
        } dci_gainpos_slp2[9:0];
    } ISP_DCIPOSSLP0 @ 0x36448;

    reg {
        name = "DCI adjustment unit slope register 1 during positive adjustment";
        desc = "ISP_DCIPOSSLP1 is DCI adjustment unit slope register 1 during positive adjustment.

Data sheet 10.6 ISP_DCIPOSSLP1 (offset 0x4644C, printed page 10-310, `hi3516av200--Hi3516AV200-Datasheet.txt` line 83252).";

        field {
            name = "dci_gainpos_slp3";
            desc = "Slope of region 3 when the picture is adjusted from dark to bright, 10-bit signed number";
            sw = rw;
            hw = r;
            reset = 0x0;
        } dci_gainpos_slp3[29:20];

        field {
            name = "dci_gainpos_slp4";
            desc = "Slope of region 4 when the picture is adjusted from dark to bright, 10-bit signed number";
            sw = rw;
            hw = r;
            reset = 0x0;
        } dci_gainpos_slp4[19:10];

        field {
            name = "dci_gainpos_slp5";
            desc = "Slope of region 5 when the picture is adjusted from dark to bright, 10-bit signed number";
            sw = rw;
            hw = r;
            reset = 0x0;
        } dci_gainpos_slp5[9:0];
    } ISP_DCIPOSSLP1 @ 0x3644C;

    reg {
        name = "DCI adjustment unit slope register 2 during positive adjustment";
        desc = "ISP_DCIPOSSLP2 is DCI adjustment unit slope register 2 during positive adjustment. Hi3516A V200 Professional HD IP Camera SoC

Data sheet 10.6 ISP_DCIPOSSLP2 (offset 0x46450, printed page 10-311, `hi3516av200--Hi3516AV200-Datasheet.txt` line 83291).";

        field {
            name = "dci_gainpos_slp6";
            desc = "Slope of region 6 when the picture is adjusted from dark to bright, 10-bit signed number";
            sw = rw;
            hw = r;
            reset = 0x0;
        } dci_gainpos_slp6[19:10];

        field {
            name = "dci_gainpos_slp7";
            desc = "Slope of region 7 when the picture is adjusted from dark to bright, 10-bit signed number";
            sw = rw;
            hw = r;
            reset = 0x0;
        } dci_gainpos_slp7[9:0];
    } ISP_DCIPOSSLP2 @ 0x36450;

    reg {
        name = "DCI adjustment unit threshold register 0 during negative adjustment";
        desc = "ISP_DCINEGTHR0 is DCI adjustment unit threshold register 0 during negative adjustment.

Data sheet 10.6 ISP_DCINEGTHR0 (offset 0x46454, printed page 10-311, `hi3516av200--Hi3516AV200-Datasheet.txt` line 83316).";

        field {
            name = "dci_gainneg_thr1";
            desc = "Threshold 1 for the luminance (Y) when the picture is adjusted from bright to dark";
            sw = rw;
            hw = r;
            reset = 0x0;
        } dci_gainneg_thr1[31:24];

        field {
            name = "dci_gainneg_thr2";
            desc = "Threshold 2 for the luminance (Y) when the picture is adjusted from bright to dark";
            sw = rw;
            hw = r;
            reset = 0x0;
        } dci_gainneg_thr2[23:16];

        field {
            name = "dci_gainneg_thr3";
            desc = "Threshold 3 for the luminance (Y) when the picture is adjusted from bright to dark";
            sw = rw;
            hw = r;
            reset = 0x0;
        } dci_gainneg_thr3[15:8];

        field {
            name = "dci_gainneg_thr4";
            desc = "Threshold 4 for the luminance (Y) when the picture is adjusted from bright to dark";
            sw = rw;
            hw = r;
            reset = 0x0;
        } dci_gainneg_thr4[7:0];
    } ISP_DCINEGTHR0 @ 0x36454;

    reg {
        name = "DCI adjustment unit threshold register 1 during negative adjustment";
        desc = "ISP_DCINEGTHR1 is DCI adjustment unit threshold register 1 during negative adjustment. Hi3516A V200 Professional HD IP Camera SoC

Data sheet 10.6 ISP_DCINEGTHR1 (offset 0x46458, printed page 10-312, `hi3516av200--Hi3516AV200-Datasheet.txt` line 83355).";

        field {
            name = "dci_gainneg_thr5";
            desc = "Threshold 5 for the luminance (Y) when the picture is adjusted from bright to dark";
            sw = rw;
            hw = r;
            reset = 0x0;
        } dci_gainneg_thr5[23:16];

        field {
            name = "dci_gainneg_thr6";
            desc = "Threshold 6 for the luminance (Y) when the picture is adjusted from bright to dark";
            sw = rw;
            hw = r;
            reset = 0x0;
        } dci_gainneg_thr6[15:8];

        field {
            name = "dci_gainneg_thr7";
            desc = "Threshold 7 for the luminance (Y) when the picture is adjusted from bright to dark";
            sw = rw;
            hw = r;
            reset = 0x0;
        } dci_gainneg_thr7[7:0];
    } ISP_DCINEGTHR1 @ 0x36458;

    reg {
        name = "DCI adjustment unit gain register 0 during negative adjustment";
        desc = "ISP_DCINEGGAIN0 is DCI adjustment unit gain register 0 during negative adjustment.

Data sheet 10.6 ISP_DCINEGGAIN0 (offset 0x4645C, printed page 10-312, `hi3516av200--Hi3516AV200-Datasheet.txt` line 83383).";

        field {
            name = "dci_gainneg_cbcr0";
            desc = "Chrominance compensation gain of threshold 0 when the picture is adjusted from bright to dark";
            sw = rw;
            hw = r;
            reset = 0x0;
        } dci_gainneg_cbcr0[29:25];

        field {
            name = "dci_gainneg_cbcr1";
            desc = "Chrominance compensation gain of threshold 1 when the picture is adjusted from bright to dark";
            sw = rw;
            hw = r;
            reset = 0x0;
        } dci_gainneg_cbcr1[24:20];

        field {
            name = "dci_gainneg_cbcr2";
            desc = "Chrominance compensation gain of threshold 2 when the picture is adjusted from bright to dark";
            sw = rw;
            hw = r;
            reset = 0x0;
        } dci_gainneg_cbcr2[19:15];

        field {
            name = "dci_gainneg_cbcr3";
            desc = "Chrominance compensation gain of threshold 3 when the picture is adjusted from bright to dark";
            sw = rw;
            hw = r;
            reset = 0x0;
        } dci_gainneg_cbcr3[14:10];

        field {
            name = "dci_gainneg_cbcr4";
            desc = "Chrominance compensation gain of threshold 4 when the picture is adjusted from bright to dark";
            sw = rw;
            hw = r;
            reset = 0x0;
        } dci_gainneg_cbcr4[9:5];

        field {
            name = "dci_gainneg_cbcr5";
            desc = "Chrominance compensation gain of threshold 5 when the picture is adjusted from bright to dark";
            sw = rw;
            hw = r;
            reset = 0x0;
        } dci_gainneg_cbcr5[4:0];
    } ISP_DCINEGGAIN0 @ 0x3645C;

    reg {
        name = "DCI adjustment unit gain register 1 during negative adjustment";
        desc = "ISP_DCINEGGAIN1 is DCI adjustment unit gain register 1 during negative adjustment.

Data sheet 10.6 ISP_DCINEGGAIN1 (offset 0x46460, printed page 10-313, `hi3516av200--Hi3516AV200-Datasheet.txt` line 83433).";

        field {
            name = "dci_gainneg_cbcr6";
            desc = "Chrominance compensation gain of threshold 6 when the picture is adjusted from bright to dark";
            sw = rw;
            hw = r;
            reset = 0x0;
        } dci_gainneg_cbcr6[14:10];

        field {
            name = "dci_gainneg_cbcr7";
            desc = "Chrominance compensation gain of threshold 7 when the picture is adjusted from bright to dark";
            sw = rw;
            hw = r;
            reset = 0x0;
        } dci_gainneg_cbcr7[9:5];

        field {
            name = "dci_gainneg_cbcr8";
            desc = "Chrominance compensation gain of threshold 8 when the picture is adjusted from bright to dark";
            sw = rw;
            hw = r;
            reset = 0x0;
        } dci_gainneg_cbcr8[4:0];
    } ISP_DCINEGGAIN1 @ 0x36460;

    reg {
        name = "DCI adjustment unit slope register 0 during negative adjustment";
        desc = "ISP_DCINEGSLP0 is DCI adjustment unit slope register 0 during negative adjustment.

Data sheet 10.6 ISP_DCINEGSLP0 (offset 0x46464, printed page 10-313, `hi3516av200--Hi3516AV200-Datasheet.txt` line 83461).";

        field {
            name = "dci_gainneg_slp0";
            desc = "Slope of region 0 when the picture is adjusted from bright to dark, 10-bit signed number";
            sw = rw;
            hw = r;
            reset = 0x0;
        } dci_gainneg_slp0[29:20];

        field {
            name = "dci_gainneg_slp1";
            desc = "Slope of region 1 when the picture is adjusted from bright to dark, 10-bit signed number";
            sw = rw;
            hw = r;
            reset = 0x0;
        } dci_gainneg_slp1[19:10];

        field {
            name = "dci_gainneg_slp2";
            desc = "Slope of region 2 when the picture is adjusted from bright to dark, 10-bit signed number";
            sw = rw;
            hw = r;
            reset = 0x0;
        } dci_gainneg_slp2[9:0];
    } ISP_DCINEGSLP0 @ 0x36464;

    reg {
        name = "DCI adjustment unit slope register 1 during negative adjustment";
        desc = "ISP_DCINEGSLP1 is DCI adjustment unit slope register 1 during negative adjustment.

Data sheet 10.6 ISP_DCINEGSLP1 (offset 0x46468, printed page 10-314, `hi3516av200--Hi3516AV200-Datasheet.txt` line 83500).";

        field {
            name = "dci_gainneg_slp3";
            desc = "Slope of region 3 when the picture is adjusted from bright to dark, 10-bit signed number";
            sw = rw;
            hw = r;
            reset = 0x0;
        } dci_gainneg_slp3[29:20];

        field {
            name = "dci_gainneg_slp4";
            desc = "Slope of region 4 when the picture is adjusted from bright to dark, 10-bit signed number";
            sw = rw;
            hw = r;
            reset = 0x0;
        } dci_gainneg_slp4[19:10];

        field {
            name = "dci_gainneg_slp5";
            desc = "Slope of region 5 when the picture is adjusted from bright to dark, 10-bit signed number";
            sw = rw;
            hw = r;
            reset = 0x0;
        } dci_gainneg_slp5[9:0];
    } ISP_DCINEGSLP1 @ 0x36468;

    reg {
        name = "DCI adjustment unit slope register 2 during negative adjustment";
        desc = "ISP_DCINEGSLP2 is DCI adjustment unit slope register 2 during negative adjustment.

Data sheet 10.6 ISP_DCINEGSLP2 (offset 0x4646C, printed page 10-314, `hi3516av200--Hi3516AV200-Datasheet.txt` line 83531).";

        field {
            name = "dci_gainneg_slp6";
            desc = "Slope of region 6 when the picture is adjusted from bright to dark, 10-bit signed number";
            sw = rw;
            hw = r;
            reset = 0x0;
        } dci_gainneg_slp6[19:10];

        field {
            name = "dci_gainneg_slp7";
            desc = "Slope of region 7 when the picture is adjusted from bright to dark, 10-bit signed number";
            sw = rw;
            hw = r;
            reset = 0x0;
        } dci_gainneg_slp7[9:0];
    } ISP_DCINEGSLP2 @ 0x3646C;

    reg {
        name = "Write address register for the histogram 0 weight lookup table register";
        desc = "ISP_BINWGT0_WADDR is a write address register for the histogram 0 weight lookup table register.

Data sheet 10.6 ISP_BINWGT0_WADDR (offset 0x46480, printed page 10-315, `hi3516av200--Hi3516AV200-Datasheet.txt` line 83563).";

        field {
            name = "wgt0_waddr";
            desc = "Write address for collecting pixels in the dark region";
            sw = rw;
            hw = r;
            reset = 0x0;
        } wgt0_waddr[31:0];
    } ISP_BINWGT0_WADDR @ 0x36480;

    reg {
        name = "Histogram 0 weight lookup table register";
        desc = "ISP_VDDCIBINWGT0 is a histogram 0 weight lookup table register.

Data sheet 10.6 ISP_VDDCIBINWGT0 (offset 0x46484, printed page 10-315, `hi3516av200--Hi3516AV200-Datasheet.txt` line 83581).";

        field {
            name = "wgt_lut0";
            desc = "Write data for collecting pixels in the dark region. The depth of the lookup table is 32.";
            sw = rw;
            hw = r;
            reset = 0x0;
        } wgt_lut0[4:0];
    } ISP_VDDCIBINWGT0 @ 0x36484;

    reg {
        name = "Read address register for the histogram 0 weight lookup table register";
        desc = "ISP_BINWGT0_RADDR is a read address register for the histogram 0 weight lookup table register. Hi3516A V200 Professional HD IP Camera SoC

Data sheet 10.6 ISP_BINWGT0_RADDR (offset 0x46488, printed page 10-316, `hi3516av200--Hi3516AV200-Datasheet.txt` line 83613).";

        field {
            name = "wgt0_raddr";
            desc = "Write address for collecting pixels in the dark region";
            sw = rw;
            hw = r;
            reset = 0x0;
        } wgt0_raddr[31:0];
    } ISP_BINWGT0_RADDR @ 0x36488;

    reg {
        name = "Read data register for the histogram 0 weight lookup table register";
        desc = "ISP_VDDCIBINWGT0_RDATA is a read data register for the histogram 0 weight lookup table register.

Data sheet 10.6 ISP_VDDCIBINWGT0_RDATA (offset 0x4648C, printed page 10-316, `hi3516av200--Hi3516AV200-Datasheet.txt` line 83633).";

        field {
            name = "wgt_lut0_rdatat";
            desc = "Write data for collecting pixels in the dark region. The depth of the lookup table is 32.";
            sw = r;
            hw = w;
            reset = 0x0;
        } wgt_lut0_rdatat[4:0];
    } ISP_VDDCIBINWGT0_RDATA @ 0x3648C;

    reg {
        name = "Write address register for the histogram 1 weight lookup table register";
        desc = "ISP_BINWGT1_WADDR is a write address register for the histogram 1 weight lookup table register.

Data sheet 10.6 ISP_BINWGT1_WADDR (offset 0x46490, printed page 10-316, `hi3516av200--Hi3516AV200-Datasheet.txt` line 83656).";

        field {
            name = "wgt1_waddr";
            desc = "Write address for collecting pixels in the middle region";
            sw = rw;
            hw = r;
            reset = 0x0;
        } wgt1_waddr[31:0];
    } ISP_BINWGT1_WADDR @ 0x36490;

    reg {
        name = "Histogram 1 weight lookup table register";
        desc = "ISP_VDDCIBINWGT1 is a histogram 1 weight lookup table register.

Data sheet 10.6 ISP_VDDCIBINWGT1 (offset 0x46494, printed page 10-317, `hi3516av200--Hi3516AV200-Datasheet.txt` line 83681).";

        field {
            name = "wgt_lut1";
            desc = "Write data for collecting pixels in the middle region. The depth of the lookup table is 32.";
            sw = rw;
            hw = r;
            reset = 0x0;
        } wgt_lut1[4:0];
    } ISP_VDDCIBINWGT1 @ 0x36494;

    reg {
        name = "Read address register for the histogram 1 weight lookup table register";
        desc = "ISP_BINWGT1_RADDR is a read address register for the histogram 1 weight lookup table register.

Data sheet 10.6 ISP_BINWGT1_RADDR (offset 0x46498, printed page 10-317, `hi3516av200--Hi3516AV200-Datasheet.txt` line 83704).";

        field {
            name = "wgt1_raddr";
            desc = "wgt1_raddr";
            sw = rw;
            hw = r;
            reset = 0x0;
        } wgt1_raddr[31:0];
    } ISP_BINWGT1_RADDR @ 0x36498;

    reg {
        name = "Read data register for the histogram 1 weight lookup table register";
        desc = "ISP_VDDCIBINWGT1_RDATA is a read data register for the histogram 1 weight lookup table register. Hi3516A V200 Professional HD IP Camera SoC

Data sheet 10.6 ISP_VDDCIBINWGT1_RDATA (offset 0x4649C, printed page 10-318, `hi3516av200--Hi3516AV200-Datasheet.txt` line 83733).";

        field {
            name = "wgt_lut1_rdata";
            desc = "Write data for collecting pixels in the middle region. The depth of the lookup table is 32.";
            sw = r;
            hw = w;
            reset = 0x0;
        } wgt_lut1_rdata[4:0];
    } ISP_VDDCIBINWGT1_RDATA @ 0x3649C;

    reg {
        name = "Write address register for the histogram 2 weight lookup table register";
        desc = "ISP_BINWGT2_WADDR is a write address register for the histogram 2 weight lookup table register.

Data sheet 10.6 ISP_BINWGT2_WADDR (offset 0x464A0, printed page 10-318, `hi3516av200--Hi3516AV200-Datasheet.txt` line 83756).";

        field {
            name = "wgt2_waddr";
            desc = "Write address for collecting pixels in the bright region";
            sw = rw;
            hw = r;
            reset = 0x0;
        } wgt2_waddr[31:0];
    } ISP_BINWGT2_WADDR @ 0x364A0;

    reg {
        name = "Histogram 2 weight lookup table register";
        desc = "ISP_VDDCIBINWGT2 is a histogram 2 weight lookup table register.

Data sheet 10.6 ISP_VDDCIBINWGT2 (offset 0x464A4, printed page 10-318, `hi3516av200--Hi3516AV200-Datasheet.txt` line 83775).";

        field {
            name = "wgt_lut2";
            desc = "Write data for collecting pixels in the bright region. The depth of the lookup table is 32.";
            sw = rw;
            hw = r;
            reset = 0x0;
        } wgt_lut2[4:0];
    } ISP_VDDCIBINWGT2 @ 0x364A4;

    reg {
        name = "Read address register for the histogram 2 weight lookup table register";
        desc = "ISP_BINWGT2_RADDR is a read address register for the histogram 2 weight lookup table register.

Data sheet 10.6 ISP_BINWGT2_RADDR (offset 0x464A8, printed page 10-319, `hi3516av200--Hi3516AV200-Datasheet.txt` line 83802).";

        field {
            name = "wgt2_raddr";
            desc = "Read address for collecting pixels in the bright region";
            sw = rw;
            hw = r;
            reset = 0x0;
        } wgt2_raddr[31:0];
    } ISP_BINWGT2_RADDR @ 0x364A8;

    reg {
        name = "Read data register for the histogram 2 weight lookup table register";
        desc = "ISP_VDDCIBINWGT2_RDATA is a read data register for the histogram 2 weight lookup table register.

Data sheet 10.6 ISP_VDDCIBINWGT2_RDATA (offset 0x464AC, printed page 10-319, `hi3516av200--Hi3516AV200-Datasheet.txt` line 83821).";

        field {
            name = "wgt_lut2_rdata";
            desc = "Read data for collecting pixels in the bright region. The depth of the lookup table is 32.";
            sw = r;
            hw = w;
            reset = 0x0;
        } wgt_lut2_rdata[4:0];
    } ISP_VDDCIBINWGT2_RDATA @ 0x364AC;

    reg {
        name = "Write address register for the adjustment curve 0 register";
        desc = "ISP_ADJLUT0_WADDR is a write address register for the adjustment curve 0 register. Hi3516A V200 Professional HD IP Camera SoC

Data sheet 10.6 ISP_ADJLUT0_WADDR (offset 0x464B0, printed page 10-320, `hi3516av200--Hi3516AV200-Datasheet.txt` line 83852).";

        field {
            name = "adjlut0_waddr";
            desc = "Write address for collecting adjustment curves in the dark region";
            sw = rw;
            hw = r;
            reset = 0x0;
        } adjlut0_waddr[31:0];
    } ISP_ADJLUT0_WADDR @ 0x364B0;

    reg {
        name = "Adjustment curve 0 register";
        desc = "ISP_VDDCIADJLUT0 is an adjustment curve 0 register.

Data sheet 10.6 ISP_VDDCIADJLUT0 (offset 0x464B4, printed page 10-320, `hi3516av200--Hi3516AV200-Datasheet.txt` line 83871).";

        field {
            name = "adj0_0";
            desc = "Write data for adjustment curves in the dark region. The depth of the lookup table is 33.";
            sw = rw;
            hw = r;
            reset = 0x0;
        } adj0_0[9:0];
    } ISP_VDDCIADJLUT0 @ 0x364B4;

    reg {
        name = "Read address register for the adjustment curve 0 register";
        desc = "ISP_ADJLUT0_RADDR is a read address register for the adjustment curve 0 register.

Data sheet 10.6 ISP_ADJLUT0_RADDR (offset 0x464B8, printed page 10-320, `hi3516av200--Hi3516AV200-Datasheet.txt` line 83892).";

        field {
            name = "adjlut0_raddr";
            desc = "Read address for collecting adjustment curves in the dark region";
            sw = rw;
            hw = r;
            reset = 0x0;
        } adjlut0_raddr[31:0];
    } ISP_ADJLUT0_RADDR @ 0x364B8;

    reg {
        name = "Read data register for the adjustment curve 0 register";
        desc = "ISP_VDDCIADJLUT0_RDATA is a read data register for the adjustment curve 0 register.

Data sheet 10.6 ISP_VDDCIADJLUT0_RDATA (offset 0x464BC, printed page 10-321, `hi3516av200--Hi3516AV200-Datasheet.txt` line 83917).";

        field {
            name = "adj0_0_rdata";
            desc = "Write data for adjustment curves in the dark region. The depth of the lookup table is 33.";
            sw = r;
            hw = w;
            reset = 0x0;
        } adj0_0_rdata[9:0];
    } ISP_VDDCIADJLUT0_RDATA @ 0x364BC;

    reg {
        name = "Write address register for the adjustment curve 1 register";
        desc = "ISP_ADJLUT1_WADDR is a write address register for the adjustment curve 1 register.

Data sheet 10.6 ISP_ADJLUT1_WADDR (offset 0x464C0, printed page 10-321, `hi3516av200--Hi3516AV200-Datasheet.txt` line 83939).";

        field {
            name = "adjlut1_waddr";
            desc = "Write address for collecting adjustment curves in the middle region";
            sw = rw;
            hw = r;
            reset = 0x0;
        } adjlut1_waddr[31:0];
    } ISP_ADJLUT1_WADDR @ 0x364C0;

    reg {
        name = "Adjustment curve 1 register";
        desc = "ISP_VDDCIADJLUT1 is an adjustment curve 1 register.

Data sheet 10.6 ISP_VDDCIADJLUT1 (offset 0x464C4, printed page 10-321, `hi3516av200--Hi3516AV200-Datasheet.txt` line 83960).";

        field {
            name = "adj1_0";
            desc = "adj1_0";
            sw = rw;
            hw = r;
            reset = 0x0;
        } adj1_0[9:0];
    } ISP_VDDCIADJLUT1 @ 0x364C4;

    reg {
        name = "Read address of adjustment curve 1 register";
        desc = "ISP_ADJLUT1_RADDR is a read address of adjustment curve 1 register.

Data sheet 10.6 ISP_ADJLUT1_RADDR (offset 0x464C8, printed page 10-322, `hi3516av200--Hi3516AV200-Datasheet.txt` line 84000).";

        field {
            name = "adjlut1_raddr";
            desc = "Read address for collecting adjustment curves in the middle region";
            sw = rw;
            hw = r;
            reset = 0x0;
        } adjlut1_raddr[31:0];
    } ISP_ADJLUT1_RADDR @ 0x364C8;

    reg {
        name = "Read data register for the adjustment curve 1 register";
        desc = "ISP_VDDCIADJLUT1_RDATA is a read data register for the adjustment curve 1 register.

Data sheet 10.6 ISP_VDDCIADJLUT1_RDATA (offset 0x464CC, printed page 10-322, `hi3516av200--Hi3516AV200-Datasheet.txt` line 84019).";

        field {
            name = "adj1_0_rdtata";
            desc = "Read data for adjustment curves in the middle region. The depth of the lookup table is 33.";
            sw = r;
            hw = w;
            reset = 0x0;
        } adj1_0_rdtata[9:0];
    } ISP_VDDCIADJLUT1_RDATA @ 0x364CC;

    reg {
        name = "Write address register for the adjustment curve 2 register";
        desc = "ISP_ADJLUT2_WADDR is a write address register for the adjustment curve 2 register.

Data sheet 10.6 ISP_ADJLUT2_WADDR (offset 0x464D0, printed page 10-323, `hi3516av200--Hi3516AV200-Datasheet.txt` line 84047).";

        field {
            name = "adjlut2_waddr";
            desc = "Write address for collecting adjustment curves in the bright region";
            sw = rw;
            hw = r;
            reset = 0x0;
        } adjlut2_waddr[31:0];
    } ISP_ADJLUT2_WADDR @ 0x364D0;

    reg {
        name = "Adjustment curve 2 register";
        desc = "ISP_VDDCIADJLUT2 is an adjustment curve 2 register.

Data sheet 10.6 ISP_VDDCIADJLUT2 (offset 0x464D4, printed page 10-323, `hi3516av200--Hi3516AV200-Datasheet.txt` line 84066).";

        field {
            name = "adj2_0";
            desc = "Write data for adjustment curves in the bright region. The depth of the lookup table is 33.";
            sw = rw;
            hw = r;
            reset = 0x0;
        } adj2_0[9:0];
    } ISP_VDDCIADJLUT2 @ 0x364D4;

    reg {
        name = "Read address register for the adjustment curve 2 register";
        desc = "ISP_ADJLUT2_RADDR is a read address register for the adjustment curve 2 register.

Data sheet 10.6 ISP_ADJLUT2_RADDR (offset 0x464D8, printed page 10-323, `hi3516av200--Hi3516AV200-Datasheet.txt` line 84087).";

        field {
            name = "adjlut2_raddr";
            desc = "Read address for collecting adjustment curves in the bright region";
            sw = rw;
            hw = r;
            reset = 0x0;
        } adjlut2_raddr[31:0];
    } ISP_ADJLUT2_RADDR @ 0x364D8;

    reg {
        name = "Read data register for the adjustment curve 2 register";
        desc = "ISP_VDDCIADJLUT2_RDATA is a read data register for the adjustment curve 2 register.

Data sheet 10.6 ISP_VDDCIADJLUT2_RDATA (offset 0x464DC, printed page 10-324, `hi3516av200--Hi3516AV200-Datasheet.txt` line 84112).";

        field {
            name = "adj2_0_rdata";
            desc = "Read data for adjustment curves in the bright region. The depth of the lookup table is 33.";
            sw = r;
            hw = w;
            reset = 0x0;
        } adj2_0_rdata[9:0];
    } ISP_VDDCIADJLUT2_RDATA @ 0x364DC;

    reg {
        name = "DCI register update control register";
        desc = "ISP_DCI_CTRL_I is a DCI register update control register.

Data sheet 10.6 ISP_DCI_CTRL_I (offset 0x464E4, printed page 10-324, `hi3516av200--Hi3516AV200-Datasheet.txt` line 84134).";

        enum ISP_DCI_CTRL_I_update_mode_enum {
            UPDATE_MODE_SPECIFIED = 0 { name = "Update Mode Specified"; desc = "update mode specified in ISP_DCI_UPDATE"; };
            FRAME_UPDATE_MODE = 1 { name = "Frame Update Mode"; desc = "frame update mode"; };
        };

        field {
            name = "update_mode";
            desc = "DCI register update mode register";
            sw = rw;
            hw = r;
            encode = ISP_DCI_CTRL_I_update_mode_enum;
            reset = 0x0;
        } update_mode[0:0];
    } ISP_DCI_CTRL_I @ 0x364E4;

    reg {
        name = "DCI register update register";
        desc = "ISP_DCI_UPDATE is a DCI register update register. Hi3516A V200 Professional HD IP Camera SoC

Data sheet 10.6 ISP_DCI_UPDATE (offset 0x464EC, printed page 10-325, `hi3516av200--Hi3516AV200-Datasheet.txt` line 84172).";

        field {
            name = "newer";
            desc = "DCI register update register. This bit is automatically cleared for each frame.";
            sw = rw;
            hw = r;
            reset = 0x0;
        } newer[0:0];
    } ISP_DCI_UPDATE @ 0x364EC;

    reg {
        name = "DCI picture size register";
        desc = "ISP_DCI_SIZE is a DCI picture size register.

Data sheet 10.6 ISP_DCI_SIZE (offset 0x464F0, printed page 10-325, `hi3516av200--Hi3516AV200-Datasheet.txt` line 84195).";

        field {
            name = "height";
            desc = "Window height (in line). The configured value is the actual value minus 1.";
            sw = rw;
            hw = r;
            reset = 0x437;
        } height[28:16];

        field {
            name = "width";
            desc = "Window width (in pixel). The configured value is the actual value minus 1.";
            sw = rw;
            hw = r;
            reset = 0x77F;
        } width[12:0];
    } ISP_DCI_SIZE @ 0x364F0;

    reg {
        name = "DCI manually configured curve threshold register 0";
        desc = "ISP_DCIADJSW0 is a DCI manually configured curve threshold register 0. Hi3516A V200 Professional HD IP Camera SoC

Data sheet 10.6 ISP_DCIADJSW0 (offset 0x46510, printed page 10-326, `hi3516av200--Hi3516AV200-Datasheet.txt` line 84233).";

        field {
            name = "dci_adj_sw0";
            desc = "Manually configured adjustment curve threshold 0, 10-bit signed number";
            sw = rw;
            hw = r;
            reset = 0x0;
        } dci_adj_sw0[29:20];

        field {
            name = "dci_adj_sw1";
            desc = "Manually configured adjustment curve threshold 1, 10-bit signed number";
            sw = rw;
            hw = r;
            reset = 0x0;
        } dci_adj_sw1[19:10];

        field {
            name = "dci_adj_sw2";
            desc = "Manually configured adjustment curve threshold 2, 10-bit signed number";
            sw = rw;
            hw = r;
            reset = 0x0;
        } dci_adj_sw2[9:0];
    } ISP_DCIADJSW0 @ 0x36510;

    reg {
        name = "DCI manually configured curve threshold register 1";
        desc = "ISP_DCIADJSW1 is a DCI manually configured curve threshold register 1.

Data sheet 10.6 ISP_DCIADJSW1 (offset 0x46514, printed page 10-326, `hi3516av200--Hi3516AV200-Datasheet.txt` line 84264).";

        field {
            name = "dci_adj_sw3";
            desc = "Manually configured adjustment curve threshold 3, 10-bit signed number";
            sw = rw;
            hw = r;
            reset = 0x0;
        } dci_adj_sw3[29:20];

        field {
            name = "dci_adj_sw4";
            desc = "Manually configured adjustment curve threshold 4, 10-bit signed number";
            sw = rw;
            hw = r;
            reset = 0x0;
        } dci_adj_sw4[19:10];

        field {
            name = "dci_adj_sw5";
            desc = "Manually configured adjustment curve threshold 5, 10-bit signed number";
            sw = rw;
            hw = r;
            reset = 0x0;
        } dci_adj_sw5[9:0];
    } ISP_DCIADJSW1 @ 0x36514;

    reg {
        name = "DCI manually configured curve threshold register 2";
        desc = "ISP_DCIADJSW2 is a DCI manually configured curve threshold register 2.

Data sheet 10.6 ISP_DCIADJSW2 (offset 0x46518, printed page 10-327, `hi3516av200--Hi3516AV200-Datasheet.txt` line 84301).";

        field {
            name = "dci_adj_sw6";
            desc = "Manually configured adjustment curve threshold 6, 10-bit signed number";
            sw = rw;
            hw = r;
            reset = 0x0;
        } dci_adj_sw6[29:20];

        field {
            name = "dci_adj_sw7";
            desc = "Manually configured adjustment curve threshold 7, 10-bit signed number";
            sw = rw;
            hw = r;
            reset = 0x0;
        } dci_adj_sw7[19:10];

        field {
            name = "dci_adj_sw8";
            desc = "Manually configured adjustment curve threshold 8, 10-bit signed number";
            sw = rw;
            hw = r;
            reset = 0x0;
        } dci_adj_sw8[9:0];
    } ISP_DCIADJSW2 @ 0x36518;

    reg {
        name = "DCI manually configured curve threshold register 3";
        desc = "ISP_DCIADJSW3 is a DCI manually configured curve threshold register 3.

Data sheet 10.6 ISP_DCIADJSW3 (offset 0x4651C, printed page 10-327, `hi3516av200--Hi3516AV200-Datasheet.txt` line 84332).";

        field {
            name = "dci_adj_sw9";
            desc = "Manually configured adjustment curve threshold 9, 10-bit signed number";
            sw = rw;
            hw = r;
            reset = 0x0;
        } dci_adj_sw9[29:20];

        field {
            name = "dci_adj_sw10";
            desc = "Manually configured adjustment curve threshold 10, 10-bit signed number";
            sw = rw;
            hw = r;
            reset = 0x0;
        } dci_adj_sw10[19:10];

        field {
            name = "dci_adj_sw11";
            desc = "dci_adj_sw11";
            sw = rw;
            hw = r;
            reset = 0x0;
        } dci_adj_sw11[9:0];
    } ISP_DCIADJSW3 @ 0x3651C;

    reg {
        name = "DCI manually configured curve threshold register 4";
        desc = "ISP_DCIADJSW4 is a DCI manually configured curve threshold register 4.

Data sheet 10.6 ISP_DCIADJSW4 (offset 0x46520, printed page 10-328, `hi3516av200--Hi3516AV200-Datasheet.txt` line 84388).";

        field {
            name = "dci_adj_sw12";
            desc = "Manually configured adjustment curve threshold 12, 10-bit signed number";
            sw = rw;
            hw = r;
            reset = 0x0;
        } dci_adj_sw12[29:20];

        field {
            name = "dci_adj_sw13";
            desc = "Manually configured adjustment curve threshold 13, 10-bit signed number";
            sw = rw;
            hw = r;
            reset = 0x0;
        } dci_adj_sw13[19:10];

        field {
            name = "dci_adj_sw14";
            desc = "Manually configured adjustment curve threshold 14, 10-bit signed number";
            sw = rw;
            hw = r;
            reset = 0x0;
        } dci_adj_sw14[9:0];
    } ISP_DCIADJSW4 @ 0x36520;

    reg {
        name = "DCI manually configured curve threshold register 5";
        desc = "ISP_DCIADJSW5 is a DCI manually configured curve threshold register 5. Hi3516A V200 Professional HD IP Camera SoC

Data sheet 10.6 ISP_DCIADJSW5 (offset 0x46524, printed page 10-329, `hi3516av200--Hi3516AV200-Datasheet.txt` line 84428).";

        field {
            name = "dci_adj_sw15";
            desc = "Manually configured adjustment curve threshold 15, 10-bit signed number";
            sw = rw;
            hw = r;
            reset = 0x0;
        } dci_adj_sw15[29:20];

        field {
            name = "dci_adj_sw16";
            desc = "Manually configured adjustment curve threshold 16, 10-bit signed number";
            sw = rw;
            hw = r;
            reset = 0x0;
        } dci_adj_sw16[19:10];

        field {
            name = "dci_adj_sw17";
            desc = "Manually configured adjustment curve threshold 17, 10-bit signed number";
            sw = rw;
            hw = r;
            reset = 0x0;
        } dci_adj_sw17[9:0];
    } ISP_DCIADJSW5 @ 0x36524;

    reg {
        name = "DCI manually configured curve threshold register 6";
        desc = "ISP_DCIADJSW6 is a DCI manually configured curve threshold register 6.

Data sheet 10.6 ISP_DCIADJSW6 (offset 0x46528, printed page 10-329, `hi3516av200--Hi3516AV200-Datasheet.txt` line 84459).";

        field {
            name = "dci_adj_sw18";
            desc = "Manually configured adjustment curve threshold 18, 10-bit signed number";
            sw = rw;
            hw = r;
            reset = 0x0;
        } dci_adj_sw18[29:20];

        field {
            name = "dci_adj_sw19";
            desc = "Manually configured adjustment curve threshold 19, 10-bit signed number";
            sw = rw;
            hw = r;
            reset = 0x0;
        } dci_adj_sw19[19:10];

        field {
            name = "dci_adj_sw20";
            desc = "Manually configured adjustment curve threshold 20, 10-bit signed number";
            sw = rw;
            hw = r;
            reset = 0x0;
        } dci_adj_sw20[9:0];
    } ISP_DCIADJSW6 @ 0x36528;

    reg {
        name = "DCI manually configured curve threshold register 7";
        desc = "ISP_DCIADJSW7 is a DCI manually configured curve threshold register 7.

Data sheet 10.6 ISP_DCIADJSW7 (offset 0x4652C, printed page 10-330, `hi3516av200--Hi3516AV200-Datasheet.txt` line 84496).";

        field {
            name = "dci_adj_sw21";
            desc = "Manually configured adjustment curve threshold 21, 10-bit signed number";
            sw = rw;
            hw = r;
            reset = 0x0;
        } dci_adj_sw21[29:20];

        field {
            name = "dci_adj_sw22";
            desc = "Manually configured adjustment curve threshold 22, 10-bit signed number";
            sw = rw;
            hw = r;
            reset = 0x0;
        } dci_adj_sw22[19:10];

        field {
            name = "dci_adj_sw23";
            desc = "Manually configured adjustment curve threshold 23, 10-bit signed number";
            sw = rw;
            hw = r;
            reset = 0x0;
        } dci_adj_sw23[9:0];
    } ISP_DCIADJSW7 @ 0x3652C;

    reg {
        name = "DCI manually configured curve threshold register 8";
        desc = "ISP_DCIADJSW8 is a DCI manually configured curve threshold register 8.

Data sheet 10.6 ISP_DCIADJSW8 (offset 0x46530, printed page 10-330, `hi3516av200--Hi3516AV200-Datasheet.txt` line 84527).";

        field {
            name = "dci_adj_sw24";
            desc = "Manually configured adjustment curve threshold 24, 10-bit signed number";
            sw = rw;
            hw = r;
            reset = 0x0;
        } dci_adj_sw24[29:20];

        field {
            name = "dci_adj_sw25";
            desc = "Manually configured adjustment curve threshold 25, 10-bit signed number";
            sw = rw;
            hw = r;
            reset = 0x0;
        } dci_adj_sw25[19:10];

        field {
            name = "dci_adj_sw26";
            desc = "Manually configured adjustment curve threshold 26, 10-bit signed number";
            sw = rw;
            hw = r;
            reset = 0x0;
        } dci_adj_sw26[9:0];
    } ISP_DCIADJSW8 @ 0x36530;

    reg {
        name = "DCI manually configured curve threshold register 9";
        desc = "ISP_DCIADJSW9 is a DCI manually configured curve threshold register 9.

Data sheet 10.6 ISP_DCIADJSW9 (offset 0x46534, printed page 10-331, `hi3516av200--Hi3516AV200-Datasheet.txt` line 84569).";

        field {
            name = "dci_adj_sw27";
            desc = "Manually configured adjustment curve threshold 27, 10-bit signed number";
            sw = rw;
            hw = r;
            reset = 0x0;
        } dci_adj_sw27[29:20];

        field {
            name = "dci_adj_sw28";
            desc = "Manually configured adjustment curve threshold 28, 10-bit signed number";
            sw = rw;
            hw = r;
            reset = 0x0;
        } dci_adj_sw28[19:10];

        field {
            name = "dci_adj_sw29";
            desc = "Manually configured adjustment curve threshold 29, 10-bit signed number";
            sw = rw;
            hw = r;
            reset = 0x0;
        } dci_adj_sw29[9:0];
    } ISP_DCIADJSW9 @ 0x36534;

    reg {
        name = "DCI manually configured curve threshold register 10";
        desc = "ISP_DCIADJSW10 is a DCI manually configured curve threshold register 10.

Data sheet 10.6 ISP_DCIADJSW10 (offset 0x46538, printed page 10-331, `hi3516av200--Hi3516AV200-Datasheet.txt` line 84600).";

        field {
            name = "dci_adj_sw30";
            desc = "dci_adj_sw30";
            sw = rw;
            hw = r;
            reset = 0x0;
        } dci_adj_sw30[29:20];

        field {
            name = "dci_adj_sw31";
            desc = "dci_adj_sw31";
            sw = rw;
            hw = r;
            reset = 0x0;
        } dci_adj_sw31[19:10];

        field {
            name = "dci_adj_sw32";
            desc = "dci_adj_sw32";
            sw = rw;
            hw = r;
            reset = 0x0;
        } dci_adj_sw32[9:0];
    } ISP_DCIADJSW10 @ 0x36538;

    reg {
        name = "DCI split point generation register";
        desc = "ISP_DCI_SPLIT is a DCI split point generation register.

Data sheet 10.6 ISP_DCI_SPLIT (offset 0x46540, printed page 10-332, `hi3516av200--Hi3516AV200-Datasheet.txt` line 84656).";

        field {
            name = "dci_split_point";
            desc = "Split point position when the result of dci_split_hist_mode is 0";
            sw = rw;
            hw = r;
            reset = 0x0;
        } dci_split_point[31:24];

        field {
            name = "dci_split_type";
            desc = "dci_split_type";
            sw = rw;
            hw = r;
            reset = 0x0;
        } dci_split_type[19:18];

        field {
            name = "dci_split_hist_mode";
            desc = "dci_split_hist_mode";
            sw = rw;
            hw = r;
            reset = 0x0;
        } dci_split_hist_mode[17:16];

        field {
            name = "dci_flat_mode";
            desc = "dci_flat_mode";
            sw = rw;
            hw = r;
            reset = 0x0;
        } dci_flat_mode[9:8];

        field {
            name = "dci_flat_thrsh";
            desc = "dci_flat_thrsh";
            sw = rw;
            hw = r;
            reset = 0x0;
        } dci_flat_thrsh[7:0];
    } ISP_DCI_SPLIT @ 0x36540;

    reg {
        name = "DCI blending coefficient register";
        desc = "ISP_DCI_MBLEND is a DCI blending coefficient register. Hi3516A V200 Professional HD IP Camera SoC

Data sheet 10.6 ISP_DCI_MBLEND (offset 0x46544, printed page 10-334, `hi3516av200--Hi3516AV200-Datasheet.txt` line 84740).";

        field {
            name = "dci_hist_map_blend";
            desc = "Weight of the current frame for the histogram match function";
            sw = rw;
            hw = r;
            reset = 0x0;
        } dci_hist_map_blend[23:16];

        field {
            name = "dci_man_alg_blend";
            desc = "Blending coefficient for two algorithms";
            sw = rw;
            hw = r;
            reset = 0x0;
        } dci_man_alg_blend[14:8];

        enum ISP_DCI_MBLEND_dci_man_alg_blend_en_enum {
            DISABLED = 0 { name = "Disabled"; desc = "disabled"; };
            ENABLED = 1 { name = "Enabled"; desc = "enabled"; };
        };

        field {
            name = "dci_man_alg_blend_en";
            desc = "Enable for the blending coefficient for two algorithms";
            sw = rw;
            hw = r;
            encode = ISP_DCI_MBLEND_dci_man_alg_blend_en_enum;
            reset = 0x0;
        } dci_man_alg_blend_en[0:0];
    } ISP_DCI_MBLEND @ 0x36544;

    reg {
        name = "DCI histogram clip register";
        desc = "ISP_DCI_HIST_CLIP is a DCI histogram clip register.

Data sheet 10.6 ISP_DCI_HIST_CLIP (offset 0x46548, printed page 10-334, `hi3516av200--Hi3516AV200-Datasheet.txt` line 84777).";

        field {
            name = "dci_clip_limit_r";
            desc = "Clip coefficient of the right histogram";
            sw = rw;
            hw = r;
            reset = 0x0;
        } dci_clip_limit_r[25:16];

        field {
            name = "dci_clip_limit_l";
            desc = "dci_clip_limit_l";
            sw = rw;
            hw = r;
            reset = 0x0;
        } dci_clip_limit_l[9:0];
    } ISP_DCI_HIST_CLIP @ 0x36548;

    reg {
        name = "DCI control register 2";
        desc = "ISP_DCICTRL2 is DCI control register 2.

Data sheet 10.6 ISP_DCICTRL2 (offset 0x4654C, printed page 10-335, `hi3516av200--Hi3516AV200-Datasheet.txt` line 84819).";

        enum ISP_DCICTRL2_dci_shift_ctrl_enum {
            SHIFTED_RIGHTWARDS_NINE = 0 { name = "Shifted Rightwards Nine"; desc = "shifted rightwards by nine bits"; };
            SHIFTED_RIGHTWARDS_10 = 1 { name = "Shifted Rightwards 10"; desc = "shifted rightwards by 10 bits"; };
            SHIFTED_RIGHTWARDS_11 = 2 { name = "Shifted Rightwards 11"; desc = "shifted rightwards by 11 bits"; };
            SHIFTED_RIGHTWARDS_12 = 3 { name = "Shifted Rightwards 12"; desc = "shifted rightwards by 12 bits"; };
            SHIFTED_RIGHTWARDS_13 = 4 { name = "Shifted Rightwards 13"; desc = "shifted rightwards by 13 bits"; };
            SHIFTED_RIGHTWARDS_14 = 5 { name = "Shifted Rightwards 14"; desc = "shifted rightwards by 14 bits Other values: invalid"; };
        };

        field {
            name = "dci_shift_ctrl";
            desc = "DCI histogram statistics shift control";
            sw = rw;
            hw = r;
            encode = ISP_DCICTRL2_dci_shift_ctrl_enum;
            reset = 0x0;
        } dci_shift_ctrl[8:6];

        enum ISP_DCICTRL2_dci_scene_flg_enum {
            DISABLED = 0 { name = "Disabled"; desc = "disabled"; };
            ENABLED = 1 { name = "Enabled"; desc = "enabled"; };
        };

        field {
            name = "dci_scene_flg";
            desc = "DCI scenario switch enable";
            sw = rw;
            hw = r;
            encode = ISP_DCICTRL2_dci_scene_flg_enum;
            reset = 0x0;
        } dci_scene_flg[5:5];

        enum ISP_DCICTRL2_dci_in_range_enum {
            LIMITED_RANGE = 0 { name = "Limited Range"; desc = "limited range (Y ranges from 64 to 940 and C ranges from 64 to 960 for the input 10-bit pixel data)"; };
            FULL_RANGE = 1 { name = "Full Range"; desc = "full range (Y ranges from 0 to 1023 and C ranges from 0 to 1023 for the input 10-bit pixel data)"; };
        };

        field {
            name = "dci_in_range";
            desc = "Input range";
            sw = rw;
            hw = r;
            encode = ISP_DCICTRL2_dci_in_range_enum;
            reset = 0x0;
        } dci_in_range[4:4];

        enum ISP_DCICTRL2_dci_out_range_enum {
            LIMITED_RANGE = 0 { name = "Limited Range"; desc = "limited range (Y ranges from 64 to 940 and C ranges from 64 to 960 for the output 10-bit pixel data)"; };
            FULL_RANGE = 1 { name = "Full Range"; desc = "full range (Y ranges from 0 to 1023 and C ranges from 0 to 1023 for the output 10-bit pixel data)"; };
        };

        field {
            name = "dci_out_range";
            desc = "Output range";
            sw = rw;
            hw = r;
            encode = ISP_DCICTRL2_dci_out_range_enum;
            reset = 0x0;
        } dci_out_range[3:3];

        enum ISP_DCICTRL2_dci_man_adj0_enum {
            AUTOMATIC_MODE_RESULT = 0 { name = "Automatic Mode Result"; desc = "automatic mode. The result calculated by hardware is used."; };
            MANUAL_MODE_RESULT = 1 { name = "Manual Mode Result"; desc = "manual mode. The result configured by software is used."; };
        };

        field {
            name = "dci_man_adj0";
            desc = "Adjustment mode of curve 0";
            sw = rw;
            hw = r;
            encode = ISP_DCICTRL2_dci_man_adj0_enum;
            reset = 0x0;
        } dci_man_adj0[2:2];

        enum ISP_DCICTRL2_dci_man_adj1_enum {
            AUTOMATIC_MODE_RESULT = 0 { name = "Automatic Mode Result"; desc = "automatic mode. The result calculated by hardware is used."; };
            MANUAL_MODE_RESULT = 1 { name = "Manual Mode Result"; desc = "manual mode. The result configured by software is used."; };
        };

        field {
            name = "dci_man_adj1";
            desc = "Adjustment mode of curve 1";
            sw = rw;
            hw = r;
            encode = ISP_DCICTRL2_dci_man_adj1_enum;
            reset = 0x0;
        } dci_man_adj1[1:1];

        enum ISP_DCICTRL2_dci_man_adj2_enum {
            AUTOMATIC_MODE_RESULT = 0 { name = "Automatic Mode Result"; desc = "automatic mode. The result calculated by hardware is used."; };
            MANUAL_MODE_RESULT = 1 { name = "Manual Mode Result"; desc = "manual mode. The result configured by software is used."; };
        };

        field {
            name = "dci_man_adj2";
            desc = "Adjustment mode of curve 2";
            sw = rw;
            hw = r;
            encode = ISP_DCICTRL2_dci_man_adj2_enum;
            reset = 0x0;
        } dci_man_adj2[0:0];
    } ISP_DCICTRL2 @ 0x3654C;

    reg {
        name = "DCI pixel statistics adjustment register";
        desc = "ISP_DCI_TOTAL_PIX_BS is a DCI pixel statistics adjustment register.

Data sheet 10.6 ISP_DCI_TOTAL_PIX_BS (offset 0x46554, printed page 10-336, `hi3516av200--Hi3516AV200-Datasheet.txt` line 84886).";

        field {
            name = "dci_bs_min_num";
            desc = "DCI pixel statistics adjustment register";
            sw = rw;
            hw = r;
            reset = 0x0;
        } dci_bs_min_num[7:0];
    } ISP_DCI_TOTAL_PIX_BS @ 0x36554;

    reg {
        name = "DCI algorithm horizontal adjustment region register";
        desc = "ISP_DCIHPOS is a DCI algorithm horizontal adjustment region register. Hi3516A V200 Professional HD IP Camera SoC

Data sheet 10.6 ISP_DCIHPOS (offset 0x46558, printed page 10-337, `hi3516av200--Hi3516AV200-Datasheet.txt` line 84914).";

        field {
            name = "dci_hend";
            desc = "End value of the horizontal active region of the DCI algorithm. The configured value is the actual value minus 1.";
            sw = rw;
            hw = r;
            reset = 0x0;
        } dci_hend[28:16];

        field {
            name = "dci_hstart";
            desc = "Start value of the horizontal active region of the DCI algorithm. The configured value is the actual value minus 1.";
            sw = rw;
            hw = r;
            reset = 0x0;
        } dci_hstart[12:0];
    } ISP_DCIHPOS @ 0x36558;

    reg {
        name = "DCI algorithm vertical adjustment region register";
        desc = "ISP_DCIVPOS is a DCI algorithm vertical adjustment region register.

Data sheet 10.6 ISP_DCIVPOS (offset 0x4655C, printed page 10-337, `hi3516av200--Hi3516AV200-Datasheet.txt` line 84943).";

        field {
            name = "dci_vend";
            desc = "End value of the vertical active region of the DCI algorithm. The configured value is the actual value minus 1.";
            sw = rw;
            hw = r;
            reset = 0x0;
        } dci_vend[28:16];

        field {
            name = "dci_vstart";
            desc = "Start value of the vertical active region of the DCI algorithm. The configured value is the actual value minus 1.";
            sw = rw;
            hw = r;
            reset = 0x0;
        } dci_vstart[12:0];
    } ISP_DCIVPOS @ 0x3655C;

    reg {
        name = "DCI horizontal region register";
        desc = "ISP_DCI_OUT_HREGION is a DCI horizontal region register.

Data sheet 10.6 ISP_DCI_OUT_HREGION (offset 0x46560, printed page 10-338, `hi3516av200--Hi3516AV200-Datasheet.txt` line 84978).";

        field {
            name = "dci_out_hend";
            desc = "Horizontal end coordinate of the DCI region. The configured value is the actual value minus 1.";
            sw = rw;
            hw = r;
            reset = 0x0;
        } dci_out_hend[28:16];

        field {
            name = "dci_out_hstart";
            desc = "Horizontal start coordinate of the DCI region. The configured value is the actual value minus 1.";
            sw = rw;
            hw = r;
            reset = 0x0;
        } dci_out_hstart[12:0];
    } ISP_DCI_OUT_HREGION @ 0x36560;

    reg {
        name = "DCI vertical region register";
        desc = "ISP_DCI_OUT_VREGION is a DCI vertical region register.

Data sheet 10.6 ISP_DCI_OUT_VREGION (offset 0x46564, printed page 10-338, `hi3516av200--Hi3516AV200-Datasheet.txt` line 85007).";

        field {
            name = "dci_out_vend";
            desc = "Vertical end coordinate of the DCI region. The configured value is the actual value minus 1.";
            sw = rw;
            hw = r;
            reset = 0x0;
        } dci_out_vend[28:16];

        field {
            name = "dci_out_vstart";
            desc = "Vertical start coordinate of the DCI region. The configured value is the actual value minus 1.";
            sw = rw;
            hw = r;
            reset = 0x0;
        } dci_out_vstart[12:0];
    } ISP_DCI_OUT_VREGION @ 0x36564;

    reg {
        name = "DCI adjustment unit hist blend value register";
        desc = "ISP_DCI_BLEND is a DCI adjustment unit hist blend value register.

Data sheet 10.6 ISP_DCI_BLEND (offset 0x46568, printed page 10-339, `hi3516av200--Hi3516AV200-Datasheet.txt` line 85042).";

        field {
            name = "dci_hist_abld";
            desc = "Weighted alpha blend value of the current histogram and the previous histogram";
            sw = rw;
            hw = r;
            reset = 0x0;
        } dci_hist_abld[13:8];

        field {
            name = "dci_org_abld";
            desc = "Alpha blend value when the luminance component is adjusted Value range: 0-32";
            sw = rw;
            hw = r;
            reset = 0x0;
        } dci_org_abld[5:0];
    } ISP_DCI_BLEND @ 0x36568;

    reg {
        name = "DCI black stretch enable register";
        desc = "ISP_DCI_BS_EN is a DCI black stretch enable register.

Data sheet 10.6 ISP_DCI_BS_EN (offset 0x4656C, printed page 10-339, `hi3516av200--Hi3516AV200-Datasheet.txt` line 85071).";

        enum ISP_DCI_BS_EN_dci_bs_en_enum {
            DISABLED = 0 { name = "Disabled"; desc = "disabled"; };
            ENABLED = 1 { name = "Enabled"; desc = "enabled"; };
        };

        field {
            name = "dci_bs_en";
            desc = "DCI black stretch enable";
            sw = rw;
            hw = r;
            encode = ISP_DCI_BS_EN_dci_bs_en_enum;
            reset = 0x0;
        } dci_bs_en[0:0];
    } ISP_DCI_BS_EN @ 0x3656C;

    reg {
        name = "DCI black stretch register 0";
        desc = "ISP_DCI_BLACK0_STRETCH is DCI black stretch register 0.

Data sheet 10.6 ISP_DCI_BLACK0_STRETCH (offset 0x46570, printed page 10-340, `hi3516av200--Hi3516AV200-Datasheet.txt` line 85105).";

        field {
            name = "dci_bs_min_black_blend";
            desc = "Weight of the current frame when the minblack of the current frame is blended with that of the previous frame";
            sw = rw;
            hw = r;
            reset = 0x0;
        } dci_bs_min_black_blend[28:24];

        field {
            name = "dci_bs_limit_thr";
            desc = "Dark pixel minblack accumulation threshold. When histogram statistics are added, the number of pixels whose values less than bs_limit_thr (pixel value) are counted. Value range: 0-127";
            sw = rw;
            hw = r;
            reset = 0x0;
        } dci_bs_limit_thr[22:16];

        field {
            name = "dci_bs_max_level";
            desc = "Maximum range of active black stretch Value range: 1-160";
            sw = rw;
            hw = r;
            reset = 0x0;
        } dci_bs_max_level[7:0];
    } ISP_DCI_BLACK0_STRETCH @ 0x36570;

    reg {
        name = "DCI black stretch register 1";
        desc = "ISP_DCI_BLACK1_STRETCH is DCI black stretch register 1.

Data sheet 10.6 ISP_DCI_BLACK1_STRETCH (offset 0x46574, printed page 10-340, `hi3516av200--Hi3516AV200-Datasheet.txt` line 85141).";

        field {
            name = "dci_bs_deta_inv";
            desc = "Weighted value of black stretch offset";
            sw = rw;
            hw = r;
            reset = 0x0;
        } dci_bs_deta_inv[31:16];

        field {
            name = "dci_bs_black_wgt_thr";
            desc = "dci_bs_black_wgt_thr";
            sw = rw;
            hw = r;
            reset = 0x0;
        } dci_bs_black_wgt_thr[12:7];

        field {
            name = "dci_bs_l_offset";
            desc = "dci_bs_l_offset";
            sw = rw;
            hw = r;
            reset = 0x0;
        } dci_bs_l_offset[5:0];
    } ISP_DCI_BLACK1_STRETCH @ 0x36574;

    reg {
        name = "DCI black stretch register 2";
        desc = "ISP_DCI_BLACK2_STRETCH is DCI black stretch register 2.

Data sheet 10.6 ISP_DCI_BLACK2_STRETCH (offset 0x46578, printed page 10-341, `hi3516av200--Hi3516AV200-Datasheet.txt` line 85194).";

        field {
            name = "dci_bs_blending_level";
            desc = "Maximum range of active black stretch Value range: 0-320";
            sw = rw;
            hw = r;
            reset = 0x0;
        } dci_bs_blending_level[8:0];
    } ISP_DCI_BLACK2_STRETCH @ 0x36578;

    reg {
        name = "DCI split point threshold and scenario change enable register";
        desc = "ISP_DCI_NEW_POINT is a DCI split point threshold and scenario change enable register. Hi3516A V200 Professional HD IP Camera SoC

Data sheet 10.6 ISP_DCI_NEW_POINT (offset 0x4657C, printed page 10-342, `hi3516av200--Hi3516AV200-Datasheet.txt` line 85226).";

        field {
            name = "dci_point_thr";
            desc = "Split point re-judgment threshold";
            sw = rw;
            hw = r;
            reset = 0x0;
        } dci_point_thr[15:8];

        enum ISP_DCI_NEW_POINT_dci_scd_flg_enum {
            UNCHANGED = 0 { name = "Unchanged"; desc = "unchanged"; };
            CHANGED = 1 { name = "Changed"; desc = "changed"; };
        };

        field {
            name = "dci_scd_flg";
            desc = "Whether the scenario is changed";
            sw = rw;
            hw = r;
            encode = ISP_DCI_NEW_POINT_dci_scd_flg_enum;
            reset = 0x0;
        } dci_scd_flg[0:0];
    } ISP_DCI_NEW_POINT @ 0x3657C;

    reg {
        name = "Write address register for the division lookup table register";
        desc = "ISP_DIVLUT_WADDR is a write address register for the division lookup table register.

Data sheet 10.6 ISP_DIVLUT_WADDR (offset 0x46580, printed page 10-342, `hi3516av200--Hi3516AV200-Datasheet.txt` line 85256).";

        field {
            name = "div_waddr";
            desc = "Write address of the division lookup table";
            sw = rw;
            hw = r;
            reset = 0x0;
        } div_waddr[31:0];
    } ISP_DIVLUT_WADDR @ 0x36580;

    reg {
        name = "Division lookup table register";
        desc = "ISP_VDDCIDIVLUT is a division lookup table register. Hi3516A V200 Professional HD IP Camera SoC

Data sheet 10.6 ISP_VDDCIDIVLUT (offset 0x46584, printed page 10-343, `hi3516av200--Hi3516AV200-Datasheet.txt` line 85283).";

        field {
            name = "dci_lut_data";
            desc = "Write data of the division lookup table. The depth of the lookup table is 64.";
            sw = rw;
            hw = r;
            reset = 0x0;
        } dci_lut_data[11:0];
    } ISP_VDDCIDIVLUT @ 0x36584;

    reg {
        name = "Read address register for the division lookup table register";
        desc = "ISP_DIVLUT_RADDR is a read address register for the division lookup table register.

Data sheet 10.6 ISP_DIVLUT_RADDR (offset 0x46588, printed page 10-343, `hi3516av200--Hi3516AV200-Datasheet.txt` line 85305).";

        field {
            name = "div_raddr";
            desc = "Read address of the division lookup table";
            sw = rw;
            hw = r;
            reset = 0x0;
        } div_raddr[31:0];
    } ISP_DIVLUT_RADDR @ 0x36588;

    reg {
        name = "Read data register for the division lookup table register";
        desc = "ISP_VDDCIDIVLUT_RDATA is a read data register for the division lookup table register.

Data sheet 10.6 ISP_VDDCIDIVLUT_RDATA (offset 0x4658C, printed page 10-343, `hi3516av200--Hi3516AV200-Datasheet.txt` line 85323).";

        field {
            name = "dci_lut_rdata";
            desc = "Read data of the division lookup table. The depth of the lookup table is 64.";
            sw = r;
            hw = w;
            reset = 0x0;
        } dci_lut_rdata[11:0];
    } ISP_VDDCIDIVLUT_RDATA @ 0x3658C;

    reg {
        name = "Black address register for the black stretch register";
        desc = "ISP_BSDELTA_WADDR is a black address register for the black stretch register.

Data sheet 10.6 ISP_BSDELTA_WADDR (offset 0x46590, printed page 10-344, `hi3516av200--Hi3516AV200-Datasheet.txt` line 85351).";

        field {
            name = "lut_bs_waddr";
            desc = "Write address of the black stretch calculation lookup table";
            sw = rw;
            hw = r;
            reset = 0x0;
        } lut_bs_waddr[31:0];
    } ISP_BSDELTA_WADDR @ 0x36590;

    reg {
        name = "Black stretch data register";
        desc = "ISP_DCIBSDELTA is a black stretch data register.

Data sheet 10.6 ISP_DCIBSDELTA (offset 0x46594, printed page 10-344, `hi3516av200--Hi3516AV200-Datasheet.txt` line 85370).";

        field {
            name = "lut_bs_data";
            desc = "Black stretch calculation lookup table. The depth of the lookup table is 320.";
            sw = rw;
            hw = r;
            reset = 0x0;
        } lut_bs_data[9:0];
    } ISP_DCIBSDELTA @ 0x36594;

    reg {
        name = "Read address register for the black stretch register";
        desc = "ISP_BSDELTA_RADDR is a read address register for the black stretch register.

Data sheet 10.6 ISP_BSDELTA_RADDR (offset 0x46598, printed page 10-344, `hi3516av200--Hi3516AV200-Datasheet.txt` line 85391).";

        field {
            name = "lut_bs_raddr";
            desc = "Read address of the black stretch calculation lookup table";
            sw = rw;
            hw = r;
            reset = 0x0;
        } lut_bs_raddr[31:0];
    } ISP_BSDELTA_RADDR @ 0x36598;

    reg {
        name = "Read data register for the black stretch data register";
        desc = "ISP_DCIBSDELTA_RDATA is a read data register for the black stretch data register.

Data sheet 10.6 ISP_DCIBSDELTA_RDATA (offset 0x4659C, printed page 10-345, `hi3516av200--Hi3516AV200-Datasheet.txt` line 85416).";

        field {
            name = "lut_bs_rdata";
            desc = "Read data of the black stretch calculation lookup table";
            sw = r;
            hw = w;
            reset = 0x0;
        } lut_bs_rdata[9:0];
    } ISP_DCIBSDELTA_RDATA @ 0x3659C;

    reg {
        name = "Read address register for the histogram 32 data uploading register";
        desc = "ISP_HIST32_RADDR is a read address register for the histogram 32 data uploading register.

Data sheet 10.6 ISP_HIST32_RADDR (offset 0x465B8, printed page 10-345, `hi3516av200--Hi3516AV200-Datasheet.txt` line 85436).";

        field {
            name = "lut_hist32_raddr";
            desc = "Read address of the 32-segment histogram report table";
            sw = rw;
            hw = r;
            reset = 0x0;
        } lut_hist32_raddr[31:0];
    } ISP_HIST32_RADDR @ 0x365B8;

    reg {
        name = "Read data register for the histogram 32 uploading register";
        desc = "ISP_HIST32_RDATA is a read data register for the histogram 32 uploading register.

Data sheet 10.6 ISP_HIST32_RDATA (offset 0x465BC, printed page 10-345, `hi3516av200--Hi3516AV200-Datasheet.txt` line 85454).";

        field {
            name = "lut_hist32_rdata";
            desc = "32-segment histogram report table. The depth of the lookup table is 32.";
            sw = r;
            hw = w;
            reset = 0x0;
        } lut_hist32_rdata[26:0];
    } ISP_HIST32_RDATA @ 0x365BC;

    reg {
        name = "ACM control register";
        desc = "ISP_ACM_CTRL is an ACM control register.

Data sheet 10.6 ISP_ACM_CTRL (offset 0x51400, printed page 10-346, `hi3516av200--Hi3516AV200-Datasheet.txt` line 85483).";

        enum ISP_ACM_CTRL_acm_en_enum {
            DISABLED = 0 { name = "Disabled"; desc = "disabled (the data output is bypassed)"; };
            ENABLED = 1 { name = "Enabled"; desc = "enabled (luminance and contrast adjustment is implemented)"; };
        };

        field {
            name = "acm_en";
            desc = "ACM module enable";
            sw = rw;
            hw = r;
            encode = ISP_ACM_CTRL_acm_en_enum;
            reset = 0x0;
        } acm_en[31:31];

        field {
            name = "acm_dbg_en";
            desc = "ACM debugging enable. When acm_dbg_en is valid, the original picture is displayed on the left part of the screen, and the picture processed by ABC is displayed on the right part of the screen.";
            sw = rw;
            hw = r;
            reset = 0x0;
        } acm_dbg_en[30:30];

        enum ISP_ACM_CTRL_acm_stretch_enum {
            Y_64_940 = 0 { name = "Y 64 940"; desc = "Y 64-940, C 64-960"; };
            Y_0_1023 = 1 { name = "Y 0 1023"; desc = "Y 0-1023, C 0-1023"; };
        };

        field {
            name = "acm_stretch";
            desc = "Input pixel range";
            sw = rw;
            hw = r;
            encode = ISP_ACM_CTRL_acm_stretch_enum;
            reset = 0x0;
        } acm_stretch[29:29];

        enum ISP_ACM_CTRL_acm_cliprange_enum {
            Y_64_940 = 0 { name = "Y 64 940"; desc = "Y 64-940, C 64-960"; };
            Y_0_1023 = 1 { name = "Y 0 1023"; desc = "Y 0-1023, C 0-1023"; };
        };

        field {
            name = "acm_cliprange";
            desc = "Output pixel range";
            sw = rw;
            hw = r;
            encode = ISP_ACM_CTRL_acm_cliprange_enum;
            reset = 0x0;
        } acm_cliprange[28:28];

        enum ISP_ACM_CTRL_acm_cliporwrap_enum {
            HUE_COMPONENT_WRAPPED = 0 { name = "Hue Component Wrapped"; desc = "The hue component is wrapped around to fall within [0, 1023]."; };
            HUE_COMPONENT_CLIPPED = 1 { name = "Hue Component Clipped"; desc = "The hue component is clipped to fall within [0, 1023]."; };
        };

        field {
            name = "acm_cliporwrap";
            desc = "Hue component value limit after ACM";
            sw = rw;
            hw = r;
            encode = ISP_ACM_CTRL_acm_cliporwrap_enum;
            reset = 0x0;
        } acm_cliporwrap[27:27];

        field {
            name = "acm_dbg_pos";
            desc = "ACM debugging position";
            sw = rw;
            hw = r;
            reset = 0x0;
        } acm_dbg_pos[22:10];

        enum ISP_ACM_CTRL_acm_dbg_mode_enum {
            ORIGINAL_PICTURE_DISPLAYED = 0 { name = "Original Picture Displayed"; desc = "The original picture is displayed on the left part, and the picture processed by ACM is displayed on the right part."; };
            PICTURE_PROCESSED_ACM = 1 { name = "Picture Processed Acm"; desc = "The picture processed by ACM is displayed on the left part, and the original picture is displayed on the right part."; };
        };

        field {
            name = "acm_dbg_mode";
            desc = "ACM debugging mode";
            sw = rw;
            hw = r;
            encode = ISP_ACM_CTRL_acm_dbg_mode_enum;
            reset = 0x0;
        } acm_dbg_mode[9:9];

        field {
            name = "acm_cbcrthr";
            desc = "ACM algorithm enable threshold, 9-bit unsigned number (ranging from 0 to 255)";
            sw = rw;
            hw = r;
            reset = 0x0;
        } acm_cbcrthr[8:0];
    } ISP_ACM_CTRL @ 0x41400;

    reg {
        name = "ACM processed pixel change register";
        desc = "ISP_ACM_ADJ is an ACM processed pixel change register.

Data sheet 10.6 ISP_ACM_ADJ (offset 0x51404, printed page 10-347, `hi3516av200--Hi3516AV200-Datasheet.txt` line 85542).";

        field {
            name = "acm_gain0";
            desc = "Control coefficient of the luminance adjustment range. The value range is 0-512.";
            sw = rw;
            hw = r;
            reset = 0x0;
        } acm_gain0[29:20];

        field {
            name = "acm_gain1";
            desc = "Control coefficient of the hue adjustment range. The value range is 0-512.";
            sw = rw;
            hw = r;
            reset = 0x0;
        } acm_gain1[19:10];

        field {
            name = "acm_gain2";
            desc = "Control coefficient of the saturation adjustment range. The value range is 0-512.";
            sw = rw;
            hw = r;
            reset = 0x0;
        } acm_gain2[9:0];
    } ISP_ACM_ADJ @ 0x41404;

    reg {
        name = "ACM processed picture size register";
        desc = "ISP_ACM_SIZE is an ACM processed picture size register.

Data sheet 10.6 ISP_ACM_SIZE (offset 0x51410, printed page 10-347, `hi3516av200--Hi3516AV200-Datasheet.txt` line 85573).";

        field {
            name = "height";
            desc = "Picture height (in pixel). The configured value is the actual value minus 1.";
            sw = rw;
            hw = r;
            reset = 0x0;
        } height[28:16];

        field {
            name = "width";
            desc = "Picture width (in pixel). The configured value is the actual value minus 1.";
            sw = rw;
            hw = r;
            reset = 0x0;
        } width[12:0];
    } ISP_ACM_SIZE @ 0x41410;

    reg {
        name = "ACM coefficient configuration loading address register";
        desc = "ISP_ACM_PARA_ADDR is an ACM coefficient configuration loading address register.

Data sheet 10.6 ISP_ACM_PARA_ADDR (offset 0x51414, printed page 10-348, `hi3516av200--Hi3516AV200-Datasheet.txt` line 85613).";

        field {
            name = "acm_para_addr";
            desc = "Address for loading ACM coefficients";
            sw = rw;
            hw = r;
            reset = 0x0;
        } acm_para_addr[31:0];
    } ISP_ACM_PARA_ADDR @ 0x41414;

    reg {
        name = "ACM coefficient configuration update register";
        desc = "ISP_ACM_PARA_UP is an ACM coefficient configuration update register.

Data sheet 10.6 ISP_ACM_PARA_UP (offset 0x51420, printed page 10-348, `hi3516av200--Hi3516AV200-Datasheet.txt` line 85632).";

        field {
            name = "para_up";
            desc = "Parameter update. This bit is automatically cleared for each frame.";
            sw = rw;
            hw = r;
            reset = 0x0;
        } para_up[0:0];
    } ISP_ACM_PARA_UP @ 0x41420;

    reg {
        name = "ISPFE_MAX_ADDR";
        desc = "ISPFE_MAX_ADDR.

Data sheet 10.6 ISPFE_MAX_ADDR (offset 0x60000, printed page 10-349, `hi3516av200--Hi3516AV200-Datasheet.txt` line 85668).";

        field {
            name = "max_addr";
            desc = "Maximum address for the ISP FE buffer";
            sw = rw;
            hw = r;
            reset = 0x90F;
        } max_addr[11:0];
    } ISPFE_MAX_ADDR @ 0x50000;

    reg {
        name = "ISP buffer maximum address register 2";
        desc = "ISPFE_MAX_ADDR2 is ISP buffer maximum address register 2. The default value of this register corresponding to ISP1 is 0x80F.

Data sheet 10.6 ISPFE_MAX_ADDR2 (offset 0x60004, printed page 10-349, `hi3516av200--Hi3516AV200-Datasheet.txt` line 85690).";

        field {
            name = "max_addr2";
            desc = "Maximum address for ISP FE buffer 2";
            sw = rw;
            hw = r;
            reset = 0x90F;
        } max_addr2[11:0];
    } ISPFE_MAX_ADDR2 @ 0x50004;

    reg {
        name = "ISPFE_MAX_ADDR_NR1";
        desc = "ISPFE_MAX_ADDR_NR1.

Data sheet 10.6 ISPFE_MAX_ADDR_NR1 (offset 0x60008, printed page 10-350, `hi3516av200--Hi3516AV200-Datasheet.txt` line 85721).";

        field {
            name = "max_addr_nr1";
            desc = "Maximum address for nr buffer 1";
            sw = rw;
            hw = r;
            reset = 0x60F;
        } max_addr_nr1[11:0];
    } ISPFE_MAX_ADDR_NR1 @ 0x50008;

    reg {
        name = "ISP nr buffer 2 maximum address register";
        desc = "ISPFE_MAX_ADDR_NR2 is an ISP nr buffer 2 maximum address register. The default value of this register corresponding to ISP1 is 0x2BA.

Data sheet 10.6 ISPFE_MAX_ADDR_NR2 (offset 0x6000C, printed page 10-350, `hi3516av200--Hi3516AV200-Datasheet.txt` line 85744).";

        field {
            name = "max_addr_nr2";
            desc = "Maximum address for nr buffer 2";
            sw = rw;
            hw = r;
            reset = 0x30F;
        } max_addr_nr2[11:0];
    } ISPFE_MAX_ADDR_NR2 @ 0x5000C;

    reg {
        name = "ISP timing configuration register";
        desc = "ISPFE_TIMING is an ISP timing configuration register. Hi3516A V200 Professional HD IP Camera SoC

Data sheet 10.6 ISPFE_TIMING (offset 0x60010, printed page 10-351, `hi3516av200--Hi3516AV200-Datasheet.txt` line 85772).";

        enum ISPFE_TIMING_vsync_sel_enum {
            NOT_PROCESSED = 0 { name = "Not Processed"; desc = "not processed"; };
            PROCESSED = 1 { name = "Processed"; desc = "processed"; };
        };

        field {
            name = "vsync_sel";
            desc = "Toggle processing control for vsync";
            sw = rw;
            hw = r;
            encode = ISPFE_TIMING_vsync_sel_enum;
            reset = 0x0;
        } vsync_sel[1:1];

        enum ISPFE_TIMING_hsync_sel_enum {
            INPUT_HSYNC = 0 { name = "Input Hsync"; desc = "input hsync"; };
            INPUT_DE = 1 { name = "Input De"; desc = "input de"; };
        };

        field {
            name = "hsync_sel";
            desc = "hsync source select";
            sw = rw;
            hw = r;
            encode = ISPFE_TIMING_hsync_sel_enum;
            reset = 0x1;
        } hsync_sel[0:0];
    } ISPFE_TIMING @ 0x50010;

    reg {
        name = "ISP buffer maximum address register 3";
        desc = "ISPFE_MAX_ADDR3 is ISP buffer maximum address register 3.

Data sheet 10.6 ISPFE_MAX_ADDR3 (offset 0x60014, printed page 10-351, `hi3516av200--Hi3516AV200-Datasheet.txt` line 85802).";

        field {
            name = "max_addr3";
            desc = "Maximum address for ISP FE buffer 3";
            sw = rw;
            hw = r;
            reset = 0x51F;
        } max_addr3[11:0];
    } ISPFE_MAX_ADDR3 @ 0x50014;

    reg {
        name = "ISP buffer maximum address register 4";
        desc = "ISPFE_MAX_ADDR4 is ISP buffer maximum address register 4. Hi3516A V200 Professional HD IP Camera SoC

Data sheet 10.6 ISPFE_MAX_ADDR4 (offset 0x60018, printed page 10-352, `hi3516av200--Hi3516AV200-Datasheet.txt` line 85830).";

        field {
            name = "max_addr4";
            desc = "Maximum address for ISP FE buffer 4";
            sw = rw;
            hw = r;
            reset = 0x51F;
        } max_addr4[11:0];
    } ISPFE_MAX_ADDR4 @ 0x50018;

    reg {
        name = "ISP byte enable register";
        desc = "ISPFE_BYTE_EN is an ISP byte enable register.

Data sheet 10.6 ISPFE_BYTE_EN (offset 0x60020, printed page 10-352, `hi3516av200--Hi3516AV200-Datasheet.txt` line 85850).";

        enum ISPFE_BYTE_EN_byte_en_enum {
            DISABLED = 0 { name = "Disabled"; desc = "disabled"; };
            ENABLED = 1 { name = "Enabled"; desc = "enabled"; };
        };

        field {
            name = "byte_en";
            desc = "Byte enable";
            sw = rw;
            hw = r;
            encode = ISPFE_BYTE_EN_byte_en_enum;
            reset = 0xF;
        } byte_en[3:0];
    } ISPFE_BYTE_EN @ 0x50020;

    reg {
        name = "ISP input switch register";
        desc = "ISPFE_CH_SWITCH is an ISP input switch register. Hi3516A V200 Professional HD IP Camera SoC

Data sheet 10.6 ISPFE_CH_SWITCH (offset 0x60028, printed page 10-353, `hi3516av200--Hi3516AV200-Datasheet.txt` line 85880).";

        enum ISPFE_CH_SWITCH_isp_ch_switch_4_enum {
            CHANNEL_0_INPUT = 0 { name = "Channel 0 Input"; desc = "channel 0 input"; };
            CHANNEL_1_INPUT = 1 { name = "Channel 1 Input"; desc = "channel 1 input"; };
            CHANNEL_2_INPUT = 2 { name = "Channel 2 Input"; desc = "channel 2 input"; };
            CHANNEL_3_INPUT = 3 { name = "Channel 3 Input"; desc = "channel 3 input"; };
            FPN_BLACK_FRAME = 4 { name = "Fpn Black Frame"; desc = "FPN black frame input Other values: FPN black frame input"; };
        };

        field {
            name = "isp_ch_switch_4";
            desc = "ISP FPN black frame input data select";
            sw = rw;
            hw = r;
            encode = ISPFE_CH_SWITCH_isp_ch_switch_4_enum;
            reset = 0x0;
        } isp_ch_switch_4[22:20];

        enum ISPFE_CH_SWITCH_isp_ch_switch_3_enum {
            CHANNEL_0_INPUT = 0 { name = "Channel 0 Input"; desc = "channel 0 input"; };
            CHANNEL_1_INPUT = 1 { name = "Channel 1 Input"; desc = "channel 1 input"; };
            CHANNEL_2_INPUT = 2 { name = "Channel 2 Input"; desc = "channel 2 input"; };
            CHANNEL_3_INPUT = 3 { name = "Channel 3 Input"; desc = "channel 3 input"; };
            FPN_BLACK_FRAME = 4 { name = "Fpn Black Frame"; desc = "FPN black frame input Other values: channel 3 input"; };
        };

        field {
            name = "isp_ch_switch_3";
            desc = "Input data select for ISP channel 3";
            sw = rw;
            hw = r;
            encode = ISPFE_CH_SWITCH_isp_ch_switch_3_enum;
            reset = 0x0;
        } isp_ch_switch_3[18:16];

        enum ISPFE_CH_SWITCH_isp_ch_switch_2_enum {
            CHANNEL_0_INPUT = 0 { name = "Channel 0 Input"; desc = "channel 0 input"; };
            CHANNEL_1_INPUT = 1 { name = "Channel 1 Input"; desc = "channel 1 input"; };
            CHANNEL_2_INPUT = 2 { name = "Channel 2 Input"; desc = "channel 2 input"; };
            CHANNEL_3_INPUT = 3 { name = "Channel 3 Input"; desc = "channel 3 input"; };
            FPN_BLACK_FRAME = 4 { name = "Fpn Black Frame"; desc = "FPN black frame input Other values: channel 2 input"; };
        };

        field {
            name = "isp_ch_switch_2";
            desc = "Input data select for ISP channel 2";
            sw = rw;
            hw = r;
            encode = ISPFE_CH_SWITCH_isp_ch_switch_2_enum;
            reset = 0x0;
        } isp_ch_switch_2[14:12];

        enum ISPFE_CH_SWITCH_isp_ch_switch_1_enum {
            CHANNEL_0_INPUT = 0 { name = "Channel 0 Input"; desc = "channel 0 input"; };
            CHANNEL_1_INPUT = 1 { name = "Channel 1 Input"; desc = "channel 1 input"; };
            CHANNEL_2_INPUT = 2 { name = "Channel 2 Input"; desc = "channel 2 input"; };
            CHANNEL_3_INPUT = 3 { name = "Channel 3 Input"; desc = "channel 3 input"; };
            FPN_BLACK_FRAME = 4 { name = "Fpn Black Frame"; desc = "FPN black frame input Other values: channel 1 input"; };
        };

        field {
            name = "isp_ch_switch_1";
            desc = "Input data select for ISP channel 1";
            sw = rw;
            hw = r;
            encode = ISPFE_CH_SWITCH_isp_ch_switch_1_enum;
            reset = 0x0;
        } isp_ch_switch_1[10:8];

        enum ISPFE_CH_SWITCH_isp_ch_switch_0_enum {
            CHANNEL_0_INPUT = 0 { name = "Channel 0 Input"; desc = "channel 0 input"; };
            CHANNEL_1_INPUT = 1 { name = "Channel 1 Input"; desc = "channel 1 input"; };
            CHANNEL_2_INPUT = 2 { name = "Channel 2 Input"; desc = "channel 2 input"; };
            CHANNEL_3_INPUT = 3 { name = "Channel 3 Input"; desc = "channel 3 input"; };
            FPN_BLACK_FRAME = 4 { name = "Fpn Black Frame"; desc = "FPN black frame input Other values: channel 0 input"; };
        };

        field {
            name = "isp_ch_switch_0";
            desc = "Input data select for ISP channel 0";
            sw = rw;
            hw = r;
            encode = ISPFE_CH_SWITCH_isp_ch_switch_0_enum;
            reset = 0x0;
        } isp_ch_switch_0[6:4];

        enum ISPFE_CH_SWITCH_isp_ch_switch_en_enum {
            DISABLED = 0 { name = "Disabled"; desc = "disabled"; };
            ENABLED = 1 { name = "Enabled"; desc = "enabled"; };
        };

        field {
            name = "isp_ch_switch_en";
            desc = "ISP input switch enable";
            sw = rw;
            hw = r;
            encode = ISPFE_CH_SWITCH_isp_ch_switch_en_enum;
            reset = 0x0;
        } isp_ch_switch_en[0:0];
    } ISPFE_CH_SWITCH @ 0x50028;

    reg {
        name = "ISP FE bypass register";
        desc = "ISPFE_FE_BYPASS_CFG is an ISP FE bypass register. Hi3516A V200 Professional HD IP Camera SoC

Data sheet 10.6 ISPFE_FE_BYPASS_CFG (offset 0x6002C, printed page 10-355, `hi3516av200--Hi3516AV200-Datasheet.txt` line 85967).";

        enum ISPFE_FE_BYPASS_CFG_input_mode_enum {
            V_16_BIT_LINEAR = 0 { name = "V 16 Bit Linear"; desc = "16-bit linear input (channel 0 data is valid after channel switch)"; };
            V_12_BIT_WDR = 1 { name = "V 12 Bit Wdr"; desc = "12-bit WDR input for each channel"; };
            ONE_16_BIT = 2 { name = "One 16 Bit"; desc = "one 16-bit extended input (channel 0 is valid after ch_switch), or one 12-bit input (channel 3 is valid after ch_switch)"; };
            TWO_12_BIT = 3 { name = "Two 12 Bit"; desc = "two 12-bit inputs (channels 0 and 3 are valid after ch_switch)"; };
        };

        field {
            name = "input_mode";
            desc = "ISP input mode select";
            sw = rw;
            hw = r;
            encode = ISPFE_FE_BYPASS_CFG_input_mode_enum;
            reset = 0x0;
        } input_mode[31:30];

        enum ISPFE_FE_BYPASS_CFG_bypass_en_enum {
            DATA_PASSES_ISP = 0 { name = "Data Passes Isp"; desc = "Data passes the ISP FE module."; };
            DATA_BYPASSES_ISP = 1 { name = "Data Bypasses Isp"; desc = "Data bypasses the ISP FE module."; };
        };

        field {
            name = "bypass_en";
            desc = "ISP FE bypass enable";
            sw = rw;
            hw = r;
            encode = ISPFE_FE_BYPASS_CFG_bypass_en_enum;
            reset = 0x0;
        } bypass_en[0:0];
    } ISPFE_FE_BYPASS_CFG @ 0x5002C;

    reg {
        name = "Crop enable register";
        desc = "ISPFE_CROP_CFG is a crop enable register.

Data sheet 10.6 ISPFE_CROP_CFG (offset 0x60030, printed page 10-355, `hi3516av200--Hi3516AV200-Datasheet.txt` line 86002).";

        enum ISPFE_CROP_CFG_n1_en_enum {
            DISABLED = 0 { name = "Disabled"; desc = "disabled"; };
            ENABLED = 1 { name = "Enabled"; desc = "enabled"; };
        };

        field {
            name = "n1_en";
            desc = "Region 1 enable";
            sw = rw;
            hw = r;
            encode = ISPFE_CROP_CFG_n1_en_enum;
            reset = 0x0;
        } n1_en[1:1];

        enum ISPFE_CROP_CFG_n0_en_enum {
            DISABLED = 0 { name = "Disabled"; desc = "disabled"; };
            ENABLED = 1 { name = "Enabled"; desc = "enabled"; };
        };

        field {
            name = "n0_en";
            desc = "Region 0 enable";
            sw = rw;
            hw = r;
            encode = ISPFE_CROP_CFG_n0_en_enum;
            reset = 0x0;
        } n0_en[0:0];
    } ISPFE_CROP_CFG @ 0x50030;

    reg {
        name = "Crop window register";
        desc = "ISPFE_CROP_WIN is a crop window register.

Data sheet 10.6 ISPFE_CROP_WIN (offset 0x60034, printed page 10-356, `hi3516av200--Hi3516AV200-Datasheet.txt` line 86038).";

        field {
            name = "height";
            desc = "Window height (in line). The configured value is the actual value minus 1.";
            sw = rw;
            hw = r;
            reset = 0xFFFF;
        } height[31:16];

        field {
            name = "width";
            desc = "Window width (in pixel). The configured value is the actual value minus 1.";
            sw = rw;
            hw = r;
            reset = 0xFFFF;
        } width[15:0];
    } ISPFE_CROP_WIN @ 0x50034;

    reg {
        name = "Crop start position register for region 0";
        desc = "ISPFE_CROP0_START is a crop start position register for region 0.

Data sheet 10.6 ISPFE_CROP0_START (offset 0x60038, printed page 10-356, `hi3516av200--Hi3516AV200-Datasheet.txt` line 86062).";

        field {
            name = "y_start";
            desc = "ID of the line from which the picture starts to be captured";
            sw = rw;
            hw = r;
            reset = 0x0;
        } y_start[31:16];

        field {
            name = "x_start";
            desc = "ID of the pixel from which the picture starts to be captured";
            sw = rw;
            hw = r;
            reset = 0x0;
        } x_start[15:0];
    } ISPFE_CROP0_START @ 0x50038;

    reg {
        name = "Crop size configuration register for region 0";
        desc = "ISPFE_CROP0_SIZE is a crop size configuration register for region 0. Hi3516A V200 Professional HD IP Camera SoC

Data sheet 10.6 ISPFE_CROP0_SIZE (offset 0x6003C, printed page 10-357, `hi3516av200--Hi3516AV200-Datasheet.txt` line 86090).";

        field {
            name = "height";
            desc = "Height (in line) of the obtained picture. The configured value is the actual value minus 1.";
            sw = rw;
            hw = r;
            reset = 0xFFFF;
        } height[31:16];

        field {
            name = "width";
            desc = "Width (in pixel) of a line in the obtained picture. The configured value is the actual value minus 1.";
            sw = rw;
            hw = r;
            reset = 0xFFFF;
        } width[15:0];
    } ISPFE_CROP0_SIZE @ 0x5003C;

    reg {
        name = "ISP FE delay interrupt register in line";
        desc = "ISPFE_HSYNC_INT_CFG is an ISP FE delay interrupt register in line.

Data sheet 10.6 ISPFE_HSYNC_INT_CFG (offset 0x60050, printed page 10-357, `hi3516av200--Hi3516AV200-Datasheet.txt` line 86114).";

        field {
            name = "hsync_delay_cnt";
            desc = "Delay interrupt counting (in line). This bit indicates that the interrupt is reported after the hsync_delay_cnt lines are delayed.";
            sw = rw;
            hw = r;
            reset = 0x80;
        } hsync_delay_cnt[12:0];
    } ISPFE_HSYNC_INT_CFG @ 0x50050;

    reg {
        name = "ISP interrupt indicator register";
        desc = "ISPFE_INT is an ISP interrupt indicator register. Hi3516A V200 Professional HD IP Camera SoC

Data sheet 10.6 ISPFE_INT (offset 0x600F0, printed page 10-358, `hi3516av200--Hi3516AV200-Datasheet.txt` line 86145).";

        enum ISPFE_INT_hsync_int_enum {
            NO_INTERRUPT_GENERATED = 0 { name = "No Interrupt Generated"; desc = "No interrupt is generated."; };
            INTERRUPT_GENERATED = 1 { name = "Interrupt Generated"; desc = "An interrupt is generated."; };
        };

        field {
            name = "hsync_int";
            desc = "ISP FE adjustable position interrupt. The reported interrupt position is configured through the ISPFE_HSYNC_INT_CFG register. The adjustment step is in the unit of line. Writing 1 clears this interrupt.";
            sw = rw;
            hw = w;
            onwrite = woclr;
            encode = ISPFE_INT_hsync_int_enum;
            reset = 0x0;
        } hsync_int[18:18];

        enum ISPFE_INT_fe_fstart_enum {
            NO_INTERRUPT_GENERATED = 0 { name = "No Interrupt Generated"; desc = "No interrupt is generated."; };
            INTERRUPT_GENERATED = 1 { name = "Interrupt Generated"; desc = "An interrupt is generated."; };
        };

        field {
            name = "fe_fstart";
            desc = "ISP FE SOF interrupt. Writing 1 clears the interrupt.";
            sw = rw;
            hw = w;
            onwrite = woclr;
            encode = ISPFE_INT_fe_fstart_enum;
            reset = 0x0;
        } fe_fstart[17:17];

        enum ISPFE_INT_int_dis_stat_enum {
            NO_INTERRUPT_GENERATED = 0 { name = "No Interrupt Generated"; desc = "No interrupt is generated."; };
            INTERRUPT_GENERATED = 1 { name = "Interrupt Generated"; desc = "An interrupt is generated."; };
        };

        field {
            name = "int_dis_stat";
            desc = "DIS current frame statistics completion interrupt. Writing 1 clears the interrupt.";
            sw = rw;
            hw = w;
            onwrite = woclr;
            encode = ISPFE_INT_int_dis_stat_enum;
            reset = 0x0;
        } int_dis_stat[16:16];

        enum ISPFE_INT_int15_enum {
            NO_INTERRUPT_GENERATED = 0 { name = "No Interrupt Generated"; desc = "No interrupt is generated."; };
            INTERRUPT_GENERATED = 1 { name = "Interrupt Generated"; desc = "An interrupt is generated."; };
        };

        field {
            name = "int15";
            desc = "ISP interrupt 15. Writing 1 clears the interrupt.";
            sw = rw;
            hw = w;
            onwrite = woclr;
            encode = ISPFE_INT_int15_enum;
            reset = 0x0;
        } int15[15:15];

        enum ISPFE_INT_int14_enum {
            NO_INTERRUPT_GENERATED = 0 { name = "No Interrupt Generated"; desc = "No interrupt is generated."; };
            INTERRUPT_GENERATED = 1 { name = "Interrupt Generated"; desc = "An interrupt is generated."; };
        };

        field {
            name = "int14";
            desc = "ISP interrupt 14. Writing 1 clears the interrupt.";
            sw = rw;
            hw = w;
            onwrite = woclr;
            encode = ISPFE_INT_int14_enum;
            reset = 0x0;
        } int14[14:14];

        enum ISPFE_INT_int13_enum {
            NO_INTERRUPT_GENERATED = 0 { name = "No Interrupt Generated"; desc = "No interrupt is generated."; };
            INTERRUPT_GENERATED = 1 { name = "Interrupt Generated"; desc = "An interrupt is generated."; };
        };

        field {
            name = "int13";
            desc = "ISP interrupt 13. Writing 1 clears the interrupt.";
            sw = rw;
            hw = w;
            onwrite = woclr;
            encode = ISPFE_INT_int13_enum;
            reset = 0x0;
        } int13[13:13];

        enum ISPFE_INT_int12_enum {
            NO_INTERRUPT_GENERATED = 0 { name = "No Interrupt Generated"; desc = "No interrupt is generated."; };
            INTERRUPT_GENERATED = 1 { name = "Interrupt Generated"; desc = "An interrupt is generated."; };
        };

        field {
            name = "int12";
            desc = "ISP interrupt 12. Writing 1 clears the interrupt.";
            sw = rw;
            hw = w;
            onwrite = woclr;
            encode = ISPFE_INT_int12_enum;
            reset = 0x0;
        } int12[12:12];

        enum ISPFE_INT_int11_enum {
            NO_INTERRUPT_GENERATED = 0 { name = "No Interrupt Generated"; desc = "No interrupt is generated."; };
            INTERRUPT_GENERATED = 1 { name = "Interrupt Generated"; desc = "An interrupt is generated."; };
        };

        field {
            name = "int11";
            desc = "ISP interrupt 11. Writing 1 clears the interrupt.";
            sw = rw;
            hw = w;
            onwrite = woclr;
            encode = ISPFE_INT_int11_enum;
            reset = 0x0;
        } int11[11:11];

        enum ISPFE_INT_int10_enum {
            NO_INTERRUPT_GENERATED = 0 { name = "No Interrupt Generated"; desc = "No interrupt is generated."; };
            INTERRUPT_GENERATED = 1 { name = "Interrupt Generated"; desc = "An interrupt is generated."; };
        };

        field {
            name = "int10";
            desc = "ISP interrupt 10. Writing 1 clears the interrupt.";
            sw = rw;
            hw = w;
            onwrite = woclr;
            encode = ISPFE_INT_int10_enum;
            reset = 0x0;
        } int10[10:10];

        enum ISPFE_INT_int9_enum {
            NO_INTERRUPT_GENERATED = 0 { name = "No Interrupt Generated"; desc = "No interrupt is generated."; };
            INTERRUPT_GENERATED = 1 { name = "Interrupt Generated"; desc = "An interrupt is generated."; };
        };

        field {
            name = "int9";
            desc = "ISP interrupt 9. Writing 1 clears the interrupt.";
            sw = rw;
            hw = w;
            onwrite = woclr;
            encode = ISPFE_INT_int9_enum;
            reset = 0x0;
        } int9[9:9];

        enum ISPFE_INT_int8_enum {
            NO_INTERRUPT_GENERATED = 0 { name = "No Interrupt Generated"; desc = "No interrupt is generated."; };
            INTERRUPT_GENERATED = 1 { name = "Interrupt Generated"; desc = "An interrupt is generated."; };
        };

        field {
            name = "int8";
            desc = "ISP interrupt 8. Writing 1 clears the interrupt.";
            sw = rw;
            hw = w;
            onwrite = woclr;
            encode = ISPFE_INT_int8_enum;
            reset = 0x0;
        } int8[8:8];

        enum ISPFE_INT_int7_enum {
            NO_INTERRUPT_GENERATED = 0 { name = "No Interrupt Generated"; desc = "No interrupt is generated."; };
            INTERRUPT_GENERATED = 1 { name = "Interrupt Generated"; desc = "An interrupt is generated."; };
        };

        field {
            name = "int7";
            desc = "ISP interrupt 7. Writing 1 clears the interrupt.";
            sw = rw;
            hw = w;
            onwrite = woclr;
            encode = ISPFE_INT_int7_enum;
            reset = 0x0;
        } int7[7:7];

        enum ISPFE_INT_int6_enum {
            NO_INTERRUPT_GENERATED = 0 { name = "No Interrupt Generated"; desc = "No interrupt is generated."; };
            INTERRUPT_GENERATED = 1 { name = "Interrupt Generated"; desc = "An interrupt is generated."; };
        };

        field {
            name = "int6";
            desc = "ISP interrupt 6. Writing 1 clears the interrupt.";
            sw = rw;
            hw = w;
            onwrite = woclr;
            encode = ISPFE_INT_int6_enum;
            reset = 0x0;
        } int6[6:6];

        enum ISPFE_INT_int5_enum {
            NO_INTERRUPT_GENERATED = 0 { name = "No Interrupt Generated"; desc = "No interrupt is generated."; };
            INTERRUPT_GENERATED = 1 { name = "Interrupt Generated"; desc = "An interrupt is generated."; };
        };

        field {
            name = "int5";
            desc = "ISP interrupt 5. Writing 1 clears the interrupt.";
            sw = rw;
            hw = w;
            onwrite = woclr;
            encode = ISPFE_INT_int5_enum;
            reset = 0x0;
        } int5[5:5];

        enum ISPFE_INT_int4_enum {
            NO_INTERRUPT_GENERATED = 0 { name = "No Interrupt Generated"; desc = "No interrupt is generated."; };
            INTERRUPT_GENERATED = 1 { name = "Interrupt Generated"; desc = "An interrupt is generated."; };
        };

        field {
            name = "int4";
            desc = "ISP interrupt 4. Writing 1 clears the interrupt.";
            sw = rw;
            hw = w;
            onwrite = woclr;
            encode = ISPFE_INT_int4_enum;
            reset = 0x0;
        } int4[4:4];

        enum ISPFE_INT_int3_enum {
            NO_INTERRUPT_GENERATED = 0 { name = "No Interrupt Generated"; desc = "No interrupt is generated."; };
            INTERRUPT_GENERATED = 1 { name = "Interrupt Generated"; desc = "An interrupt is generated."; };
        };

        field {
            name = "int3";
            desc = "ISP interrupt 3. Writing 1 clears the interrupt.";
            sw = rw;
            hw = w;
            onwrite = woclr;
            encode = ISPFE_INT_int3_enum;
            reset = 0x0;
        } int3[3:3];

        enum ISPFE_INT_int2_enum {
            NO_INTERRUPT_GENERATED = 0 { name = "No Interrupt Generated"; desc = "No interrupt is generated."; };
            INTERRUPT_GENERATED = 1 { name = "Interrupt Generated"; desc = "An interrupt is generated."; };
        };

        field {
            name = "int2";
            desc = "ISP interrupt 2. Writing 1 clears the interrupt.";
            sw = rw;
            hw = w;
            onwrite = woclr;
            encode = ISPFE_INT_int2_enum;
            reset = 0x0;
        } int2[2:2];

        enum ISPFE_INT_int1_enum {
            NO_INTERRUPT_GENERATED = 0 { name = "No Interrupt Generated"; desc = "No interrupt is generated."; };
            INTERRUPT_GENERATED = 1 { name = "Interrupt Generated"; desc = "An interrupt is generated."; };
        };

        field {
            name = "int1";
            desc = "ISP interrupt 1. Writing 1 clears the interrupt.";
            sw = rw;
            hw = w;
            onwrite = woclr;
            encode = ISPFE_INT_int1_enum;
            reset = 0x0;
        } int1[1:1];

        enum ISPFE_INT_int0_enum {
            NO_INTERRUPT_GENERATED = 0 { name = "No Interrupt Generated"; desc = "No interrupt is generated."; };
            INTERRUPT_GENERATED = 1 { name = "Interrupt Generated"; desc = "An interrupt is generated."; };
        };

        field {
            name = "int0";
            desc = "ISP interrupt 0. Writing 1 clears the interrupt.";
            sw = rw;
            hw = w;
            onwrite = woclr;
            encode = ISPFE_INT_int0_enum;
            reset = 0x0;
        } int0[0:0];
    } ISPFE_INT @ 0x500F0;

    reg {
        name = "ISP interrupt mask register";
        desc = "ISPFE_INT_MASK is an ISP interrupt mask register. Hi3516A V200 Professional HD IP Camera SoC

Data sheet 10.6 ISPFE_INT_MASK (offset 0x600F8, printed page 10-360, `hi3516av200--Hi3516AV200-Datasheet.txt` line 86248).";

        enum ISPFE_INT_MASK_hsync_int_en_enum {
            MASKED = 0 { name = "Masked"; desc = "masked"; };
            ENABLED = 1 { name = "Enabled"; desc = "enabled"; };
        };

        field {
            name = "hsync_int_en";
            desc = "ISP FE SOF adjustable location interrupt mask";
            sw = rw;
            hw = r;
            encode = ISPFE_INT_MASK_hsync_int_en_enum;
            reset = 0x0;
        } hsync_int_en[18:18];

        enum ISPFE_INT_MASK_fe_fstart_en_enum {
            MASKED = 0 { name = "Masked"; desc = "masked"; };
            ENABLED = 1 { name = "Enabled"; desc = "enabled"; };
        };

        field {
            name = "fe_fstart_en";
            desc = "ISP FE SOF interrupt mask";
            sw = rw;
            hw = r;
            encode = ISPFE_INT_MASK_fe_fstart_en_enum;
            reset = 0x0;
        } fe_fstart_en[17:17];

        enum ISPFE_INT_MASK_int_dis_stat_en_enum {
            MASKED = 0 { name = "Masked"; desc = "masked"; };
            ENABLED = 1 { name = "Enabled"; desc = "enabled"; };
        };

        field {
            name = "int_dis_stat_en";
            desc = "DIS current frame statistics completion interrupt mask";
            sw = rw;
            hw = r;
            encode = ISPFE_INT_MASK_int_dis_stat_en_enum;
            reset = 0x0;
        } int_dis_stat_en[16:16];

        enum ISPFE_INT_MASK_int15_en_enum {
            MASKED = 0 { name = "Masked"; desc = "masked"; };
            ENABLED = 1 { name = "Enabled"; desc = "enabled"; };
        };

        field {
            name = "int15_en";
            desc = "ISP interrupt 15 mask";
            sw = rw;
            hw = r;
            encode = ISPFE_INT_MASK_int15_en_enum;
            reset = 0x0;
        } int15_en[15:15];

        enum ISPFE_INT_MASK_int14_en_enum {
            MASKED = 0 { name = "Masked"; desc = "masked"; };
            ENABLED = 1 { name = "Enabled"; desc = "enabled"; };
        };

        field {
            name = "int14_en";
            desc = "ISP interrupt 14 mask";
            sw = rw;
            hw = r;
            encode = ISPFE_INT_MASK_int14_en_enum;
            reset = 0x0;
        } int14_en[14:14];

        enum ISPFE_INT_MASK_int13_en_enum {
            MASKED = 0 { name = "Masked"; desc = "masked"; };
            ENABLED = 1 { name = "Enabled"; desc = "enabled"; };
        };

        field {
            name = "int13_en";
            desc = "ISP interrupt 13 mask";
            sw = rw;
            hw = r;
            encode = ISPFE_INT_MASK_int13_en_enum;
            reset = 0x0;
        } int13_en[13:13];

        enum ISPFE_INT_MASK_int12_en_enum {
            MASKED = 0 { name = "Masked"; desc = "masked"; };
            ENABLED = 1 { name = "Enabled"; desc = "enabled"; };
        };

        field {
            name = "int12_en";
            desc = "ISP interrupt 12 mask";
            sw = rw;
            hw = r;
            encode = ISPFE_INT_MASK_int12_en_enum;
            reset = 0x0;
        } int12_en[12:12];

        enum ISPFE_INT_MASK_int11_en_enum {
            MASKED = 0 { name = "Masked"; desc = "masked"; };
            ENABLED = 1 { name = "Enabled"; desc = "enabled"; };
        };

        field {
            name = "int11_en";
            desc = "ISP interrupt 11 mask";
            sw = rw;
            hw = r;
            encode = ISPFE_INT_MASK_int11_en_enum;
            reset = 0x0;
        } int11_en[11:11];

        enum ISPFE_INT_MASK_int10_en_enum {
            MASKED = 0 { name = "Masked"; desc = "masked"; };
            ENABLED = 1 { name = "Enabled"; desc = "enabled"; };
        };

        field {
            name = "int10_en";
            desc = "ISP interrupt 10 mask";
            sw = rw;
            hw = r;
            encode = ISPFE_INT_MASK_int10_en_enum;
            reset = 0x0;
        } int10_en[10:10];

        enum ISPFE_INT_MASK_int9_en_enum {
            MASKED = 0 { name = "Masked"; desc = "masked"; };
            ENABLED = 1 { name = "Enabled"; desc = "enabled"; };
        };

        field {
            name = "int9_en";
            desc = "ISP interrupt 9 mask";
            sw = rw;
            hw = r;
            encode = ISPFE_INT_MASK_int9_en_enum;
            reset = 0x0;
        } int9_en[9:9];

        enum ISPFE_INT_MASK_int8_en_enum {
            MASKED = 0 { name = "Masked"; desc = "masked"; };
            ENABLED = 1 { name = "Enabled"; desc = "enabled"; };
        };

        field {
            name = "int8_en";
            desc = "ISP interrupt 8 mask";
            sw = rw;
            hw = r;
            encode = ISPFE_INT_MASK_int8_en_enum;
            reset = 0x0;
        } int8_en[8:8];

        enum ISPFE_INT_MASK_int7_en_enum {
            MASKED = 0 { name = "Masked"; desc = "masked"; };
            ENABLED = 1 { name = "Enabled"; desc = "enabled"; };
        };

        field {
            name = "int7_en";
            desc = "ISP interrupt 7 mask";
            sw = rw;
            hw = r;
            encode = ISPFE_INT_MASK_int7_en_enum;
            reset = 0x0;
        } int7_en[7:7];

        enum ISPFE_INT_MASK_int6_en_enum {
            MASKED = 0 { name = "Masked"; desc = "masked"; };
            ENABLED = 1 { name = "Enabled"; desc = "enabled"; };
        };

        field {
            name = "int6_en";
            desc = "ISP interrupt 6 mask";
            sw = rw;
            hw = r;
            encode = ISPFE_INT_MASK_int6_en_enum;
            reset = 0x0;
        } int6_en[6:6];

        enum ISPFE_INT_MASK_int5_en_enum {
            MASKED = 0 { name = "Masked"; desc = "masked"; };
            ENABLED = 1 { name = "Enabled"; desc = "enabled"; };
        };

        field {
            name = "int5_en";
            desc = "ISP interrupt 5 mask";
            sw = rw;
            hw = r;
            encode = ISPFE_INT_MASK_int5_en_enum;
            reset = 0x0;
        } int5_en[5:5];

        enum ISPFE_INT_MASK_int4_en_enum {
            MASKED = 0 { name = "Masked"; desc = "masked"; };
            ENABLED = 1 { name = "Enabled"; desc = "enabled"; };
        };

        field {
            name = "int4_en";
            desc = "ISP interrupt 4 mask";
            sw = rw;
            hw = r;
            encode = ISPFE_INT_MASK_int4_en_enum;
            reset = 0x0;
        } int4_en[4:4];

        enum ISPFE_INT_MASK_int3_en_enum {
            MASKED = 0 { name = "Masked"; desc = "masked"; };
            ENABLED = 1 { name = "Enabled"; desc = "enabled"; };
        };

        field {
            name = "int3_en";
            desc = "ISP interrupt 3 mask";
            sw = rw;
            hw = r;
            encode = ISPFE_INT_MASK_int3_en_enum;
            reset = 0x0;
        } int3_en[3:3];

        enum ISPFE_INT_MASK_int2_en_enum {
            MASKED = 0 { name = "Masked"; desc = "masked"; };
            ENABLED = 1 { name = "Enabled"; desc = "enabled"; };
        };

        field {
            name = "int2_en";
            desc = "ISP interrupt 2 mask";
            sw = rw;
            hw = r;
            encode = ISPFE_INT_MASK_int2_en_enum;
            reset = 0x0;
        } int2_en[2:2];

        enum ISPFE_INT_MASK_int1_en_enum {
            MASKED = 0 { name = "Masked"; desc = "masked"; };
            ENABLED = 1 { name = "Enabled"; desc = "enabled"; };
        };

        field {
            name = "int1_en";
            desc = "ISP interrupt 1 mask";
            sw = rw;
            hw = r;
            encode = ISPFE_INT_MASK_int1_en_enum;
            reset = 0x0;
        } int1_en[1:1];

        enum ISPFE_INT_MASK_int0_en_enum {
            MASKED = 0 { name = "Masked"; desc = "masked"; };
            ENABLED = 1 { name = "Enabled"; desc = "enabled"; };
        };

        field {
            name = "int0_en";
            desc = "ISP interrupt 0 mask";
            sw = rw;
            hw = r;
            encode = ISPFE_INT_MASK_int0_en_enum;
            reset = 0x0;
        } int0_en[0:0];
    } ISPFE_INT_MASK @ 0x500F8;

    reg {
        name = "DIS enable register";
        desc = "ISP_DIS_CFG is a DIS enable register. Hi3516A V200 Professional HD IP Camera SoC

Data sheet 10.6 ISP_DIS_CFG (offset 0x62400, printed page 10-362, `hi3516av200--Hi3516AV200-Datasheet.txt` line 86349).";

        enum ISP_DIS_CFG_work_en_enum {
            DISABLED = 0 { name = "Disabled"; desc = "disabled"; };
            ENABLED = 1 { name = "Enabled"; desc = "enabled"; };
        };

        field {
            name = "work_en";
            desc = "DIS enable";
            sw = rw;
            hw = r;
            encode = ISP_DIS_CFG_work_en_enum;
            reset = 0x0;
        } work_en[0:0];
    } ISP_DIS_CFG @ 0x52400;

    reg {
        name = "Block configuration register";
        desc = "ISP_DIS_BLK is a block configuration register.

Data sheet 10.6 ISP_DIS_BLK (offset 0x62404, printed page 10-362, `hi3516av200--Hi3516AV200-Datasheet.txt` line 86375).";

        field {
            name = "srch_range";
            desc = "Upper seven bits of the search range. The value range is 4-64.";
            sw = rw;
            hw = r;
            reset = 0x0;
        } srch_range[23:17];

        field {
            name = "srch_range_0";
            desc = "Lowest bit of the search range, fixed at 0";
            sw = r;
            hw = w;
            reset = 0x0;
        } srch_range_0[16:16];

        field {
            name = "blk_size";
            desc = "Upper eight bits of the side length of the square block. The value range is 8-128.";
            sw = rw;
            hw = r;
            reset = 0x0;
        } blk_size[8:1];

        field {
            name = "blk_size_0";
            desc = "Lowest bit of the side length of the square block, fixed at 0";
            sw = r;
            hw = w;
            reset = 0x0;
        } blk_size_0[0:0];
    } ISP_DIS_BLK @ 0x52404;

    reg {
        name = "Vertical PRJ0 block address register";
        desc = "ISP_DIS_V0POS is a vertical PRJ0 block address register.

Data sheet 10.6 ISP_DIS_V0POS (offset 0x62410, printed page 10-363, `hi3516av200--Hi3516AV200-Datasheet.txt` line 86414).";

        field {
            name = "ver";
            desc = "Vertical coordinate of the vertical PRJ0 block. The lowest bit of the coordinate value is excluded, and therefore the number of register bits is reduced by 1.";
            sw = rw;
            hw = r;
            reset = 0x0;
        } ver[26:16];

        field {
            name = "hor";
            desc = "Horizontal coordinate of the vertical PRJ0 block. The lowest bit of the coordinate value is excluded, and therefore the number of register bits is reduced by 1.";
            sw = rw;
            hw = r;
            reset = 0x0;
        } hor[11:0];
    } ISP_DIS_V0POS @ 0x52410;

    reg {
        name = "Vertical PRJ4 block address register";
        desc = "ISP_DIS_V4POS is a vertical PRJ4 block address register.

Data sheet 10.6 ISP_DIS_V4POS (offset 0x62414, printed page 10-363, `hi3516av200--Hi3516AV200-Datasheet.txt` line 86440).";

        field {
            name = "ver";
            desc = "Vertical coordinate of the vertical PRJ4 block. The lowest bit of the coordinate value is excluded, and therefore the number of register bits is reduced by 1.";
            sw = rw;
            hw = r;
            reset = 0x0;
        } ver[26:16];

        field {
            name = "hor";
            desc = "Horizontal coordinate of the vertical PRJ4 block. The lowest bit of the coordinate value is excluded, and therefore the number of register bits is reduced by 1.";
            sw = rw;
            hw = r;
            reset = 0x0;
        } hor[11:0];
    } ISP_DIS_V4POS @ 0x52414;

    reg {
        name = "Vertical PRJ8 block address register";
        desc = "ISP_DIS_V8POS is a vertical PRJ8 block address register.

Data sheet 10.6 ISP_DIS_V8POS (offset 0x62418, printed page 10-364, `hi3516av200--Hi3516AV200-Datasheet.txt` line 86472).";

        field {
            name = "ver";
            desc = "Vertical coordinate of the vertical PRJ8 block. The lowest bit of the coordinate value is excluded, and therefore the number of register bits is reduced by 1.";
            sw = rw;
            hw = r;
            reset = 0x0;
        } ver[26:16];

        field {
            name = "hor";
            desc = "Horizontal coordinate of the vertical PRJ8 block. The lowest bit of the coordinate value is excluded, and therefore the number of register bits is reduced by 1.";
            sw = rw;
            hw = r;
            reset = 0x0;
        } hor[11:0];
    } ISP_DIS_V8POS @ 0x52418;

    reg {
        name = "Vertical PRJ0 block address register";
        desc = "ISP_DIS_V0POSE is a vertical PRJ0 block address register.

Data sheet 10.6 ISP_DIS_V0POSE (offset 0x62420, printed page 10-364, `hi3516av200--Hi3516AV200-Datasheet.txt` line 86498).";

        field {
            name = "ver";
            desc = "Vertical coordinate of the end point of the vertical PRJ0 block. The lowest bit of the coordinate value is excluded, and therefore the number of register bits is reduced by 1.";
            sw = rw;
            hw = r;
            reset = 0x0;
        } ver[26:16];

        field {
            name = "hor";
            desc = "Horizontal coordinate of the end point of the vertical PRJ0 block. The lowest bit of the coordinate value is excluded, and therefore the number of register bits is reduced by 1.";
            sw = rw;
            hw = r;
            reset = 0x0;
        } hor[11:0];
    } ISP_DIS_V0POSE @ 0x52420;

    reg {
        name = "Vertical PRJ4 block address register";
        desc = "ISP_DIS_V4POSE is a vertical PRJ4 block address register.

Data sheet 10.6 ISP_DIS_V4POSE (offset 0x62424, printed page 10-365, `hi3516av200--Hi3516AV200-Datasheet.txt` line 86530).";

        field {
            name = "ver";
            desc = "Vertical coordinate of the end point of the vertical PRJ4 block. The lowest bit of the coordinate value is excluded, and therefore the number of register bits is reduced by 1.";
            sw = rw;
            hw = r;
            reset = 0x0;
        } ver[26:16];

        field {
            name = "hor";
            desc = "Horizontal coordinate of the end point of the vertical PRJ4 block. The lowest bit of the coordinate value is excluded, and therefore the number of register bits is reduced by 1.";
            sw = rw;
            hw = r;
            reset = 0x0;
        } hor[11:0];
    } ISP_DIS_V4POSE @ 0x52424;

    reg {
        name = "Vertical PRJ8 block address register";
        desc = "ISP_DIS_V8POSE is a vertical PRJ8 block address register.

Data sheet 10.6 ISP_DIS_V8POSE (offset 0x62428, printed page 10-365, `hi3516av200--Hi3516AV200-Datasheet.txt` line 86556).";

        field {
            name = "ver";
            desc = "Vertical coordinate of the end point of the vertical PRJ8 block. The lowest bit of the coordinate value is excluded, and therefore the number of register bits is reduced by 1.";
            sw = rw;
            hw = r;
            reset = 0x0;
        } ver[26:16];

        field {
            name = "hor";
            desc = "Horizontal coordinate of the end point of the vertical PRJ8 block. The lowest bit of the coordinate value is excluded, and therefore the number of register bits is reduced by 1.";
            sw = rw;
            hw = r;
            reset = 0x0;
        } hor[11:0];
    } ISP_DIS_V8POSE @ 0x52428;

    reg {
        name = "Horizontal PRJ0 block address register";
        desc = "ISP_DIS_H0POS is a horizontal PRJ0 block address register.

Data sheet 10.6 ISP_DIS_H0POS (offset 0x62430, printed page 10-366, `hi3516av200--Hi3516AV200-Datasheet.txt` line 86588).";

        field {
            name = "ver";
            desc = "Vertical coordinate of the horizontal PRJ0 block. The lowest bit of the coordinate value is excluded, and therefore the number of register bits is reduced by 1.";
            sw = rw;
            hw = r;
            reset = 0x0;
        } ver[26:16];

        field {
            name = "hor";
            desc = "Horizontal coordinate of the horizontal PRJ0 block. The lowest bit of the coordinate value is excluded, and therefore the number of register bits is reduced by 1.";
            sw = rw;
            hw = r;
            reset = 0x0;
        } hor[11:0];
    } ISP_DIS_H0POS @ 0x52430;

    reg {
        name = "Horizontal PRJ4 block address register";
        desc = "ISP_DIS_H4POS is a horizontal PRJ4 block address register.

Data sheet 10.6 ISP_DIS_H4POS (offset 0x62434, printed page 10-366, `hi3516av200--Hi3516AV200-Datasheet.txt` line 86614).";

        field {
            name = "ver";
            desc = "Vertical coordinate of the horizontal PRJ4 block. The lowest bit of the coordinate value is excluded, and therefore the number of register bits is reduced by 1.";
            sw = rw;
            hw = r;
            reset = 0x0;
        } ver[26:16];

        field {
            name = "hor";
            desc = "Horizontal coordinate of the horizontal PRJ4 block. The lowest bit of the coordinate value is excluded, and therefore the number of register bits is reduced by 1.";
            sw = rw;
            hw = r;
            reset = 0x0;
        } hor[11:0];
    } ISP_DIS_H4POS @ 0x52434;

    reg {
        name = "Horizontal PRJ8 block address register";
        desc = "ISP_DIS_H8POS is a horizontal PRJ8 block address register.

Data sheet 10.6 ISP_DIS_H8POS (offset 0x62438, printed page 10-367, `hi3516av200--Hi3516AV200-Datasheet.txt` line 86646).";

        field {
            name = "ver";
            desc = "Vertical coordinate of the horizontal PRJ8 block. The lowest bit of the coordinate value is excluded, and therefore the number of register bits is reduced by 1.";
            sw = rw;
            hw = r;
            reset = 0x0;
        } ver[26:16];

        field {
            name = "hor";
            desc = "Horizontal coordinate of the horizontal PRJ8 block. The lowest bit of the coordinate value is excluded, and therefore the number of register bits is reduced by 1.";
            sw = rw;
            hw = r;
            reset = 0x0;
        } hor[11:0];
    } ISP_DIS_H8POS @ 0x52438;

    reg {
        name = "Horizontal PRJ0 block address register";
        desc = "ISP_DIS_H0POSE is a horizontal PRJ0 block address register.

Data sheet 10.6 ISP_DIS_H0POSE (offset 0x62440, printed page 10-367, `hi3516av200--Hi3516AV200-Datasheet.txt` line 86672).";

        field {
            name = "ver";
            desc = "Vertical coordinate of the end point of the horizontal PRJ0 block. The lowest bit of the coordinate value is excluded, and therefore the number of register bits is reduced by 1.";
            sw = rw;
            hw = r;
            reset = 0x0;
        } ver[26:16];

        field {
            name = "hor";
            desc = "Horizontal coordinate of the end point of the horizontal PRJ0 block. The lowest bit of the coordinate value is excluded, and therefore the number of register bits is reduced by 1.";
            sw = rw;
            hw = r;
            reset = 0x0;
        } hor[11:0];
    } ISP_DIS_H0POSE @ 0x52440;

    reg {
        name = "Horizontal PRJ4 block address register";
        desc = "ISP_DIS_H4POSE is a horizontal PRJ4 block address register.

Data sheet 10.6 ISP_DIS_H4POSE (offset 0x62444, printed page 10-368, `hi3516av200--Hi3516AV200-Datasheet.txt` line 86704).";

        field {
            name = "ver";
            desc = "Vertical coordinate of the end point of the horizontal PRJ4 block. The lowest bit of the coordinate value is excluded, and therefore the number of register bits is reduced by 1.";
            sw = rw;
            hw = r;
            reset = 0x0;
        } ver[26:16];

        field {
            name = "hor";
            desc = "Horizontal coordinate of the end point of the horizontal PRJ4 block. The lowest bit of the coordinate value is excluded, and therefore the number of register bits is reduced by 1.";
            sw = rw;
            hw = r;
            reset = 0x0;
        } hor[11:0];
    } ISP_DIS_H4POSE @ 0x52444;

    reg {
        name = "Horizontal PRJ8 block address register";
        desc = "ISP_DIS_H8POSE is a horizontal PRJ8 block address register.

Data sheet 10.6 ISP_DIS_H8POSE (offset 0x62448, printed page 10-368, `hi3516av200--Hi3516AV200-Datasheet.txt` line 86730).";

        field {
            name = "ver";
            desc = "Vertical coordinate of the end point of the horizontal PRJ8 block. The lowest bit of the coordinate value is excluded, and therefore the number of register bits is reduced by 1.";
            sw = rw;
            hw = r;
            reset = 0x0;
        } ver[26:16];

        field {
            name = "hor";
            desc = "Horizontal coordinate of the end point of the horizontal PRJ8 block. The lowest bit of the coordinate value is excluded, and therefore the number of register bits is reduced by 1.";
            sw = rw;
            hw = r;
            reset = 0x0;
        } hor[11:0];
    } ISP_DIS_H8POSE @ 0x52448;

    reg {
        name = "Data type register";
        desc = "ISP_DIS_RAW_LUMA is a data type register.

Data sheet 10.6 ISP_DIS_RAW_LUMA (offset 0x62450, printed page 10-369, `hi3516av200--Hi3516AV200-Datasheet.txt` line 86762).";

        enum ISP_DIS_RAW_LUMA_raw_luma_enum {
            YUV = 0 { name = "Yuv"; desc = "YUV"; };
            RAW = 1 { name = "Raw"; desc = "RAW"; };
        };

        field {
            name = "raw_luma";
            desc = "Input data type";
            sw = rw;
            hw = r;
            encode = ISP_DIS_RAW_LUMA_raw_luma_enum;
            reset = 0x0;
        } raw_luma[0:0];
    } ISP_DIS_RAW_LUMA @ 0x52450;

    reg {
        name = "Gamma enable register";
        desc = "ISP_DIS_GAMMA_EN is a gamma enable register.

Data sheet 10.6 ISP_DIS_GAMMA_EN (offset 0x62454, printed page 10-369, `hi3516av200--Hi3516AV200-Datasheet.txt` line 86789).";

        enum ISP_DIS_GAMMA_EN_gamma_en_enum {
            DISABLED = 0 { name = "Disabled"; desc = "disabled"; };
            ENABLED = 1 { name = "Enabled"; desc = "enabled"; };
        };

        field {
            name = "gamma_en";
            desc = "Gamma enable";
            sw = rw;
            hw = r;
            encode = ISP_DIS_GAMMA_EN_gamma_en_enum;
            reset = 0x0;
        } gamma_en[0:0];
    } ISP_DIS_GAMMA_EN @ 0x52454;

    reg {
        name = "Horizontal statistics read address register";
        desc = "ISP_DIS_H_STAT_RADDR is a horizontal statistics read address register. Hi3516A V200 Professional HD IP Camera SoC

Data sheet 10.6 ISP_DIS_H_STAT_RADDR (offset 0x62488, printed page 10-370, `hi3516av200--Hi3516AV200-Datasheet.txt` line 86825).";

        enum ISP_DIS_H_STAT_RADDR_h_stat_raddr_enum {
            H_DELTA_15 = 0x0 { name = "H Delta 15"; desc = "h_delta[15:0] of block 0"; };
            H_SAD_23 = 0x1 { name = "H Sad 23"; desc = "h_sad[23:0] of block 0"; };
            H_MV_8 = 0x2 { name = "H Mv 8"; desc = "h_mv[8:0] of block 0 … The same rule applies to other values."; };
        };

        field {
            name = "h_stat_raddr";
            desc = "h_delta, h_sad, and h_mv information about each block. Each address contains only one piece of information. For example:";
            sw = rw;
            hw = r;
            encode = ISP_DIS_H_STAT_RADDR_h_stat_raddr_enum;
            reset = 0x0;
        } h_stat_raddr[31:0];
    } ISP_DIS_H_STAT_RADDR @ 0x52488;

    reg {
        name = "Horizontal statistics read data register";
        desc = "ISP_DIS_H_STAT_RDATA is a horizontal statistics read data register.

Data sheet 10.6 ISP_DIS_H_STAT_RDATA (offset 0x6248C, printed page 10-370, `hi3516av200--Hi3516AV200-Datasheet.txt` line 86849).";

        field {
            name = "h_stat_rdata";
            desc = "Horizontal statistics";
            sw = r;
            hw = w;
            reset = 0x0;
        } h_stat_rdata[31:0];
    } ISP_DIS_H_STAT_RDATA @ 0x5248C;

    reg {
        name = "Vertical statistics read address register";
        desc = "ISP_DIS_V_STAT_RADDR is a vertical statistics read address register. Hi3516A V200 Professional HD IP Camera SoC

Data sheet 10.6 ISP_DIS_V_STAT_RADDR (offset 0x62498, printed page 10-371, `hi3516av200--Hi3516AV200-Datasheet.txt` line 86877).";

        enum ISP_DIS_V_STAT_RADDR_v_stat_raddr_enum {
            V_DELTA_15 = 0x0 { name = "V Delta 15"; desc = "v_delta[15:0] of block 0"; };
            V_SAD_23 = 0x1 { name = "V Sad 23"; desc = "v_sad[23:0] of block 0"; };
            V_MV_8 = 0x2 { name = "V Mv 8"; desc = "v_mv[8:0] of block 0 … The same rule applies to other values."; };
        };

        field {
            name = "v_stat_raddr";
            desc = "v_delta, v_sad, and v_mv information about each block. Each address contains only one piece of information. For example:";
            sw = rw;
            hw = r;
            encode = ISP_DIS_V_STAT_RADDR_v_stat_raddr_enum;
            reset = 0x0;
        } v_stat_raddr[31:0];
    } ISP_DIS_V_STAT_RADDR @ 0x52498;

    reg {
        name = "Vertical statistics read data register";
        desc = "ISP_DIS_V_STAT_RDATA is a vertical statistics read data register.

Data sheet 10.6 ISP_DIS_V_STAT_RDATA (offset 0x6249C, printed page 10-371, `hi3516av200--Hi3516AV200-Datasheet.txt` line 86901).";

        field {
            name = "v_stat_rdata";
            desc = "Vertical statistics";
            sw = r;
            hw = w;
            reset = 0x0;
        } v_stat_rdata[31:0];
    } ISP_DIS_V_STAT_RDATA @ 0x5249C;

    reg {
        name = "DIS general control register";
        desc = "ISP_DIS_CTRL_F is a DIS general control register. Hi3516A V200 Professional HD IP Camera SoC

Data sheet 10.6 ISP_DIS_CTRL_F (offset 0x624E0, printed page 10-372, `hi3516av200--Hi3516AV200-Datasheet.txt` line 86929).";

        enum ISP_DIS_CTRL_F_rggb_cfg_enum {
            R_GR_GB = 0 { name = "R Gr Gb"; desc = "R Gr Gb B"; };
            GR_R_B = 1 { name = "Gr R B"; desc = "Gr R B Gb"; };
            GB_B_R = 2 { name = "Gb B R"; desc = "Gb B R Gr"; };
            B_GB_GR = 3 { name = "B Gb Gr"; desc = "B Gb Gr R"; };
        };

        field {
            name = "rggb_cfg";
            desc = "RGGB sequence";
            sw = rw;
            hw = r;
            encode = ISP_DIS_CTRL_F_rggb_cfg_enum;
            reset = 0x3;
        } rggb_cfg[1:0];
    } ISP_DIS_CTRL_F @ 0x524E0;

    reg {
        name = "DIS immediate update register";
        desc = "ISP_DIS_CTRL_I is a DIS immediate update register.

Data sheet 10.6 ISP_DIS_CTRL_I (offset 0x624E4, printed page 10-372, `hi3516av200--Hi3516AV200-Datasheet.txt` line 86958).";

        enum ISP_DIS_CTRL_I_update_mode_enum {
            REG_NEWER_UPDATE = 0 { name = "Reg Newer Update"; desc = "reg_newer update mode (update through ISP_DIS_UPDATE)"; };
            FRAME_UPDATE_MODE = 1 { name = "Frame Update Mode"; desc = "frame update mode"; };
        };

        field {
            name = "update_mode";
            desc = "ISP update mode";
            sw = rw;
            hw = r;
            encode = ISP_DIS_CTRL_I_update_mode_enum;
            reset = 0x0;
        } update_mode[0:0];
    } ISP_DIS_CTRL_I @ 0x524E4;

    reg {
        name = "DIS register update register";
        desc = "ISP_DIS_UPDATE is a DIS register update register. Hi3516A V200 Professional HD IP Camera SoC

Data sheet 10.6 ISP_DIS_UPDATE (offset 0x624EC, printed page 10-373, `hi3516av200--Hi3516AV200-Datasheet.txt` line 86994).";

        field {
            name = "update";
            desc = "ISP update. This bit is automatically cleared for each frame.";
            sw = rw;
            hw = r;
            reset = 0x0;
        } update[0:0];
    } ISP_DIS_UPDATE @ 0x524EC;

    reg {
        name = "FPN configuration register";
        desc = "ISP_FPN_CFG is an FPN configuration register.

Data sheet 10.6 ISP_FPN_CFG (offset 0x63A00, printed page 10-373, `hi3516av200--Hi3516AV200-Datasheet.txt` line 87015).";

        enum ISP_FPN_CFG_line_frame_enum {
            FRAME_MODE = 0 { name = "Frame Mode"; desc = "frame mode"; };
            LINE_MODE = 1 { name = "Line Mode"; desc = "line mode"; };
        };

        field {
            name = "line_frame";
            desc = "FPN frame/line mode select";
            sw = rw;
            hw = r;
            encode = ISP_FPN_CFG_line_frame_enum;
            reset = 0x0;
        } line_frame[9:9];

        enum ISP_FPN_CFG_calib_corr_enum {
            CORRECTION_MODE = 0 { name = "Correction Mode"; desc = "correction mode"; };
            CALIBRATION_MODE = 1 { name = "Calibration Mode"; desc = "calibration mode"; };
        };

        field {
            name = "calib_corr";
            desc = "FPN correction/calibration mode select";
            sw = rw;
            hw = r;
            encode = ISP_FPN_CFG_calib_corr_enum;
            reset = 0x0;
        } calib_corr[8:8];

        enum ISP_FPN_CFG_enable_f_enum {
            DISABLED = 0 { name = "Disabled"; desc = "disabled"; };
            ENABLED = 1 { name = "Enabled"; desc = "enabled"; };
        };

        field {
            name = "enable";
            desc = "FPN enable";
            sw = rw;
            hw = r;
            encode = ISP_FPN_CFG_enable_f_enum;
            reset = 0x0;
        } enable_f[0:0];
    } ISP_FPN_CFG @ 0x53A00;

    reg {
        name = "FPN calibration start signal register";
        desc = "ISP_FPN_CALIB_START is an FPN calibration start signal register.

Data sheet 10.6 ISP_FPN_CALIB_START (offset 0x63A04, printed page 10-374, `hi3516av200--Hi3516AV200-Datasheet.txt` line 87057).";

        field {
            name = "calib_start";
            desc = "FPN calibration start signal. This bit is automatically cleared.";
            sw = rw;
            hw = r;
            reset = 0x0;
        } calib_start[0:0];
    } ISP_FPN_CALIB_START @ 0x53A04;

    reg {
        name = "FPN correction configuration register";
        desc = "ISP_FPN_CORR_CFG is an FPN correction configuration register.

Data sheet 10.6 ISP_FPN_CORR_CFG (offset 0x63A08, printed page 10-374, `hi3516av200--Hi3516AV200-Datasheet.txt` line 87083).";

        enum ISP_FPN_CORR_CFG_correct3_en_enum {
            DISABLED = 0 { name = "Disabled"; desc = "disabled"; };
            ENABLED = 1 { name = "Enabled"; desc = "enabled"; };
        };

        field {
            name = "correct3_en";
            desc = "FPN correction enable for channel 3";
            sw = rw;
            hw = r;
            encode = ISP_FPN_CORR_CFG_correct3_en_enum;
            reset = 0x1;
        } correct3_en[3:3];

        enum ISP_FPN_CORR_CFG_correct2_en_enum {
            DISABLED = 0 { name = "Disabled"; desc = "disabled"; };
            ENABLED = 1 { name = "Enabled"; desc = "enabled"; };
        };

        field {
            name = "correct2_en";
            desc = "FPN correction enable for channel 2";
            sw = rw;
            hw = r;
            encode = ISP_FPN_CORR_CFG_correct2_en_enum;
            reset = 0x1;
        } correct2_en[2:2];

        enum ISP_FPN_CORR_CFG_correct1_en_enum {
            DISABLED = 0 { name = "Disabled"; desc = "disabled"; };
            ENABLED = 1 { name = "Enabled"; desc = "enabled"; };
        };

        field {
            name = "correct1_en";
            desc = "FPN correction enable for channel 1";
            sw = rw;
            hw = r;
            encode = ISP_FPN_CORR_CFG_correct1_en_enum;
            reset = 0x1;
        } correct1_en[1:1];

        enum ISP_FPN_CORR_CFG_correct0_en_enum {
            DISABLED = 0 { name = "Disabled"; desc = "disabled"; };
            ENABLED = 1 { name = "Enabled"; desc = "enabled"; };
        };

        field {
            name = "correct0_en";
            desc = "FPN correction enable for channel 0";
            sw = rw;
            hw = r;
            encode = ISP_FPN_CORR_CFG_correct0_en_enum;
            reset = 0x1;
        } correct0_en[0:0];
    } ISP_FPN_CORR_CFG @ 0x53A08;

    reg {
        name = "FPN calibration status register";
        desc = "ISP_FPN_STAT is an FPN calibration status register.

Data sheet 10.6 ISP_FPN_STAT (offset 0x63A0C, printed page 10-375, `hi3516av200--Hi3516AV200-Datasheet.txt` line 87131).";

        field {
            name = "hcnt";
            desc = "Number of lines";
            sw = r;
            hw = w;
            reset = 0xFFFF;
        } hcnt[31:16];

        field {
            name = "vcnt";
            desc = "Number of calibrated frames";
            sw = r;
            hw = w;
            reset = 0x0;
        } vcnt[13:8];

        enum ISP_FPN_STAT_busy_enum {
            IDLE = 0 { name = "Idle"; desc = "idle"; };
            CALIBRATED = 1 { name = "Calibrated"; desc = "calibrated"; };
        };

        field {
            name = "busy";
            desc = "FPN calibration status";
            sw = r;
            hw = w;
            encode = ISP_FPN_STAT_busy_enum;
            reset = 0x0;
        } busy[0:0];
    } ISP_FPN_STAT @ 0x53A0C;

    reg {
        name = "FPN calibration white point configuration register";
        desc = "ISP_FPN_WHITE_LEVEL is an FPN calibration white point configuration register. Hi3516A V200 Professional HD IP Camera SoC

Data sheet 10.6 ISP_FPN_WHITE_LEVEL (offset 0x63A10, printed page 10-376, `hi3516av200--Hi3516AV200-Datasheet.txt` line 87169).";

        field {
            name = "white_level";
            desc = "FPN calibration white point configuration";
            sw = rw;
            hw = r;
            reset = 0x0;
        } white_level[13:0];
    } ISP_FPN_WHITE_LEVEL @ 0x53A10;

    reg {
        name = "FPN calibration division coefficient register";
        desc = "ISP_FPN_DIVCOEF is an FPN calibration division coefficient register.

Data sheet 10.6 ISP_FPN_DIVCOEF (offset 0x63A18, printed page 10-376, `hi3516av200--Hi3516AV200-Datasheet.txt` line 87189).";

        field {
            name = "divcoef";
            desc = "FPN calibration division coefficient";
            sw = rw;
            hw = r;
            reset = 0x0;
        } divcoef[11:0];
    } ISP_FPN_DIVCOEF @ 0x53A18;

    reg {
        name = "FPN calibrated frame quantity register";
        desc = "ISP_FPN_FRAMELOG2 is an FPN calibrated frame quantity register. Hi3516A V200 Professional HD IP Camera SoC

Data sheet 10.6 ISP_FPN_FRAMELOG2 (offset 0x63A1C, printed page 10-377, `hi3516av200--Hi3516AV200-Datasheet.txt` line 87217).";

        field {
            name = "cpi_fpn_framelog2";
            desc = "Number of FPN calibrated frames. The configured value is obtained by taking the logarithm of the number of frames to 2.";
            sw = rw;
            hw = r;
            reset = 0x0;
        } cpi_fpn_framelog2[2:0];
    } ISP_FPN_FRAMELOG2 @ 0x53A1C;

    reg {
        name = "FPN calibration cumulative sum lower-bit register";
        desc = "ISP_FPN_SUM0 is an FPN calibration cumulative sum lower-bit register.

Data sheet 10.6 ISP_FPN_SUM0 (offset 0x63A20, printed page 10-377, `hi3516av200--Hi3516AV200-Datasheet.txt` line 87246).";

        field {
            name = "sum";
            desc = "Lower bits of the FPN calibration cumulative sum";
            sw = r;
            hw = w;
            reset = 0x0;
        } sum[31:0];
    } ISP_FPN_SUM0 @ 0x53A20;

    reg {
        name = "FPN calibration cumulative sum upper-bit register";
        desc = "ISP_FPN_SUM1 is an FPN calibration cumulative sum upper-bit register. Hi3516A V200 Professional HD IP Camera SoC

Data sheet 10.6 ISP_FPN_SUM1 (offset 0x63A24, printed page 10-378, `hi3516av200--Hi3516AV200-Datasheet.txt` line 87273).";

        field {
            name = "sum";
            desc = "Upper bits of the FPN calibration cumulative sum";
            sw = r;
            hw = w;
            reset = 0x0;
        } sum[31:0];
    } ISP_FPN_SUM1 @ 0x53A24;

    reg {
        name = "FPN correction configuration register 0";
        desc = "ISP_FPN_CORR0 is FPN correction configuration register 0.

Data sheet 10.6 ISP_FPN_CORR0 (offset 0x63A30, printed page 10-378, `hi3516av200--Hi3516AV200-Datasheet.txt` line 87292).";

        field {
            name = "strength";
            desc = "FPN correction strength, U8.8";
            sw = rw;
            hw = r;
            reset = 0x0;
        } strength[31:16];

        field {
            name = "offset";
            desc = "FPN correction offset";
            sw = rw;
            hw = r;
            reset = 0x0;
        } offset[11:0];
    } ISP_FPN_CORR0 @ 0x53A30;

    reg {
        name = "FPN correction configuration register 1";
        desc = "ISP_FPN_CORR1 is FPN correction configuration register 1.

Data sheet 10.6 ISP_FPN_CORR1 (offset 0x63A34, printed page 10-378, `hi3516av200--Hi3516AV200-Datasheet.txt` line 87312).";

        field {
            name = "strength";
            desc = "FPN correction strength, U8.8";
            sw = rw;
            hw = r;
            reset = 0x0;
        } strength[31:16];

        field {
            name = "offset";
            desc = "FPN correction offset";
            sw = rw;
            hw = r;
            reset = 0x0;
        } offset[11:0];
    } ISP_FPN_CORR1 @ 0x53A34;

    reg {
        name = "FPN correction configuration register 2";
        desc = "ISP_FPN_CORR2 is FPN correction configuration register 2.

Data sheet 10.6 ISP_FPN_CORR2 (offset 0x63A38, printed page 10-379, `hi3516av200--Hi3516AV200-Datasheet.txt` line 87341).";

        field {
            name = "strength";
            desc = "FPN correction strength, U8.8";
            sw = rw;
            hw = r;
            reset = 0x0;
        } strength[31:16];

        field {
            name = "offset";
            desc = "FPN correction offset";
            sw = rw;
            hw = r;
            reset = 0x0;
        } offset[11:0];
    } ISP_FPN_CORR2 @ 0x53A38;

    reg {
        name = "FPN correction configuration register 3";
        desc = "ISP_FPN_CORR3 is FPN correction configuration register 3.

Data sheet 10.6 ISP_FPN_CORR3 (offset 0x63A3C, printed page 10-379, `hi3516av200--Hi3516AV200-Datasheet.txt` line 87361).";

        field {
            name = "strength";
            desc = "FPN correction strength, U8.8";
            sw = rw;
            hw = r;
            reset = 0x0;
        } strength[31:16];

        field {
            name = "offset";
            desc = "FPN correction offset";
            sw = rw;
            hw = r;
            reset = 0x0;
        } offset[11:0];
    } ISP_FPN_CORR3 @ 0x53A3C;

    reg {
        name = "FPN shift configuration register";
        desc = "ISP_FPN_SHIFT is an FPN shift configuration register. Hi3516A V200 Professional HD IP Camera SoC

Data sheet 10.6 ISP_FPN_SHIFT (offset 0x63A40, printed page 10-380, `hi3516av200--Hi3516AV200-Datasheet.txt` line 87390).";

        field {
            name = "frame_calib_shift";
            desc = "Number of left shift bits for the last output frame during frame calibration";
            sw = rw;
            hw = r;
            reset = 0x0;
        } frame_calib_shift[27:24];

        field {
            name = "out_shift";
            desc = "Number of left shift bits for the output";
            sw = rw;
            hw = r;
            reset = 0x0;
        } out_shift[19:16];

        field {
            name = "in_shift";
            desc = "Number of right shift bits for the input";
            sw = rw;
            hw = r;
            reset = 0x0;
        } in_shift[11:8];

        field {
            name = "fpn_shift";
            desc = "Number of right shift bits for the input FPN";
            sw = rw;
            hw = r;
            reset = 0x0;
        } fpn_shift[3:0];
    } ISP_FPN_SHIFT @ 0x53A40;

    reg {
        name = "FPN maximum output value register";
        desc = "ISP_FPN_MAX_O is an FPN maximum output value register.

Data sheet 10.6 ISP_FPN_MAX_O (offset 0x63A50, printed page 10-380, `hi3516av200--Hi3516AV200-Datasheet.txt` line 87420).";

        field {
            name = "max_o";
            desc = "Maximum value of the FPN output";
            sw = rw;
            hw = r;
            reset = 0x3FFF;
        } max_o[15:0];
    } ISP_FPN_MAX_O @ 0x53A50;

    reg {
        name = "FPN correction threshold register";
        desc = "ISP_FPN_OVERFLOWTHR is an FPN correction threshold register. Hi3516A V200 Professional HD IP Camera SoC

Data sheet 10.6 ISP_FPN_OVERFLOWTHR (offset 0x63A54, printed page 10-381, `hi3516av200--Hi3516AV200-Datasheet.txt` line 87449).";

        field {
            name = "overflowthr";
            desc = "FPN correction threshold";
            sw = rw;
            hw = r;
            reset = 0x3FFF;
        } overflowthr[13:0];
    } ISP_FPN_OVERFLOWTHR @ 0x53A54;

    reg {
        name = "FPN line mode black line write address register";
        desc = "ISP_FPN_LINE_WADDR is an FPN line mode black line write address register.

Data sheet 10.6 ISP_FPN_LINE_WADDR (offset 0x63A80, printed page 10-381, `hi3516av200--Hi3516AV200-Datasheet.txt` line 87469).";

        field {
            name = "fpn_line_waddr";
            desc = "Write address of the black line in FPN line mode";
            sw = rw;
            hw = r;
            reset = 0x0;
        } fpn_line_waddr[31:0];
    } ISP_FPN_LINE_WADDR @ 0x53A80;

    reg {
        name = "FPN line mode black line write data register";
        desc = "ISP_FPN_LINE_WDATA is an FPN line mode black line write data register.

Data sheet 10.6 ISP_FPN_LINE_WDATA (offset 0x63A84, printed page 10-381, `hi3516av200--Hi3516AV200-Datasheet.txt` line 87487).";

        field {
            name = "fpn_line_wdata";
            desc = "Write data of the black line in FPN line mode";
            sw = rw;
            hw = r;
            reset = 0x0;
        } fpn_line_wdata[31:0];
    } ISP_FPN_LINE_WDATA @ 0x53A84;

    reg {
        name = "FPN line mode black line read address register";
        desc = "ISP_FPN_LINE_RADDR is an FPN line mode black line read address register. Hi3516A V200 Professional HD IP Camera SoC

Data sheet 10.6 ISP_FPN_LINE_RADDR (offset 0x63A88, printed page 10-382, `hi3516av200--Hi3516AV200-Datasheet.txt` line 87512).";

        field {
            name = "fpn_line_raddr";
            desc = "Read address of the black line in FPN line mode";
            sw = rw;
            hw = r;
            reset = 0x0;
        } fpn_line_raddr[31:0];
    } ISP_FPN_LINE_RADDR @ 0x53A88;

    reg {
        name = "FPN line mode black line read data register";
        desc = "ISP_FPN_LINE_RDATA is an FPN line mode black line read data register.

Data sheet 10.6 ISP_FPN_LINE_RDATA (offset 0x63A8C, printed page 10-382, `hi3516av200--Hi3516AV200-Datasheet.txt` line 87531).";

        field {
            name = "fpn_line_rdata";
            desc = "Read data of the black line in FPN line mode";
            sw = rw;
            hw = r;
            reset = 0x0;
        } fpn_line_rdata[31:0];
    } ISP_FPN_LINE_RDATA @ 0x53A8C;

    reg {
        name = "FPN general control register";
        desc = "ISP_FPN_CTRL_F is an FPN general control register. [check] The data-sheet table extraction produced overlapping bit fields for this register; the overlapping entries update_mode[0:0] were dropped - verify against the printed page.

Data sheet 10.6 ISP_FPN_CTRL_F (offset 0x63AE0, printed page 10-382, `hi3516av200--Hi3516AV200-Datasheet.txt` line 87549).";

        enum ISP_FPN_CTRL_F_rggb_cfg_enum {
            R_GR_GB = 0 { name = "R Gr Gb"; desc = "R Gr Gb B"; };
            GR_R_B = 1 { name = "Gr R B"; desc = "Gr R B Gb"; };
            GB_B_R = 2 { name = "Gb B R"; desc = "Gb B R Gr"; };
            B_GB_GR = 3 { name = "B Gb Gr"; desc = "B Gb Gr R"; };
        };

        field {
            name = "rggb_cfg";
            desc = "RGGB sequence";
            sw = rw;
            hw = r;
            encode = ISP_FPN_CTRL_F_rggb_cfg_enum;
            reset = 0x3;
        } rggb_cfg[1:0];
    } ISP_FPN_CTRL_F @ 0x53AE0;

    reg {
        name = "FPN output timing configuration register";
        desc = "ISP_FPN_TIMING is an FPN output timing configuration register. Hi3516A V200 Professional HD IP Camera SoC

Data sheet 10.6 ISP_FPN_TIMING (offset 0x63AE8, printed page 10-384, `hi3516av200--Hi3516AV200-Datasheet.txt` line 87626).";

        field {
            name = "cpi_fix_timing_stat";
            desc = "Manual timing parameter configuration. The length of the generated line blanking region is configured.";
            sw = rw;
            hw = r;
            reset = 0x40;
        } cpi_fix_timing_stat[13:1];
    } ISP_FPN_TIMING @ 0x53AE8;

    reg {
        name = "FPN register update register";
        desc = "ISP_FPN_UPDATE is an FPN register update register.

Data sheet 10.6 ISP_FPN_UPDATE (offset 0x63AEC, printed page 10-384, `hi3516av200--Hi3516AV200-Datasheet.txt` line 87651).";

        field {
            name = "update";
            desc = "ISP update. This bit is automatically cleared for each frame.";
            sw = rw;
            hw = r;
            reset = 0x0;
        } update[0:0];
    } ISP_FPN_UPDATE @ 0x53AEC;

    reg {
        name = "FPN picture size register";
        desc = "ISP_FPN_SIZE is an FPN picture size register. Hi3516A V200 Professional HD IP Camera SoC

Data sheet 10.6 ISP_FPN_SIZE (offset 0x63AF0, printed page 10-385, `hi3516av200--Hi3516AV200-Datasheet.txt` line 87681).";

        field {
            name = "height";
            desc = "Picture height. The configured value is the actual value minus 1. For example, if the actual picture height is 1080, this field needs to be set to 1079.";
            sw = rw;
            hw = r;
            reset = 0x437;
        } height[28:16];

        field {
            name = "width";
            desc = "Picture width. The configured value is the actual value minus 1. For example, if the actual picture width is 1920, this field needs to be set to 1919.";
            sw = rw;
            hw = r;
            reset = 0x77F;
        } width[12:0];
    } ISP_FPN_SIZE @ 0x53AF0;
};

`endif
