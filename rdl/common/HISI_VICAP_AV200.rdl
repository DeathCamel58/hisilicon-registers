`ifndef HISI_VICAP_AV200_RDL
`define HISI_VICAP_AV200_RDL


regfile eHISI_VICAP_AV200 {
    name = "VICAP (video capture, Hi3516A V200 / Hi3519 V101)";
    desc = "Video capture unit (VICAP0) of the Hi3516A V200 and Hi3519 V101 at 0x11380000 (448 KB window; the memory map lists a second window VICAP1 at 0x11480000 whose register layout the data sheet does not describe separately). The Hi3516A V200 and Hi3519 V101 data sheets list the same 100 registers (identical names, offsets, bit fields). Generated 2026-11-15 by scripts/rdl-extract/gen_m_cells.py from the data sheet register tables (ds_extract2 + description extraction from the PDF); PROVENANCE: PROVEN = offsets, names, bit fields, access and reset values from the data sheet tables; nothing here is hardware verified.

    Register sources: 100 registers from the data sheet (hi3516av200--Hi3516AV200-Datasheet.txt, section 9.1.6). ";

    reg {
        name = "Bus configuration register";
        desc = "AXI_CFG is a bus configuration register. Hi3516A V200 Professional HD IP Camera SoC

Data sheet 9.1.6 AXI_CFG (offset 0x10, printed page 9-18, `hi3516av200--Hi3516AV200-Datasheet.txt` line 38295).";

        field {
            name = "r_outstanding";
            desc = "Number of read request outstandings Value range: [1, 16]";
            sw = rw;
            hw = r;
            reset = 0x0;
        } r_outstanding[16:12];

        field {
            name = "w_outstanding";
            desc = "Number of write request outstandings Value range: [1, 8]";
            sw = rw;
            hw = r;
            reset = 0x0;
        } w_outstanding[8:4];
    } AXI_CFG @ 0x10;

    reg {
        name = "ISP input data selection register";
        desc = "ISP_SEL is an ISP input data selection register.

Data sheet 9.1.6 ISP_SEL (offset 0x50, printed page 9-18, `hi3516av200--Hi3516AV200-Datasheet.txt` line 38327).";

        enum ISP_SEL_af_sel_enum {
            AF_CONNECTS_ISP = 0 { name = "Af Connects Isp"; desc = "The AF connects to ISP_FE."; };
            AF_CONNECTS_ISP_2 = 1 { name = "Af Connects Isp 2"; desc = "The AF connects to ISP_BE. Other values: reserved"; };
        };

        field {
            name = "af_sel";
            desc = "AF input data select";
            sw = rw;
            hw = r;
            encode = ISP_SEL_af_sel_enum;
            reset = 0x0;
        } af_sel[16:16];

        enum ISP_SEL_isp_be_sel_enum {
            ISP_CONNECTS_ISP = 0 { name = "Isp Connects Isp"; desc = "ISP_BE connects to ISP_FE (for the raw input)."; };
            ISP_CONNECTS_LINE = 1 { name = "Isp Connects Line"; desc = "ISP_BE connects to LINE_BUF (for the YUV input). Other values: reserved"; };
        };

        field {
            name = "isp_be_sel";
            desc = "ISP_BE input data select";
            sw = rw;
            hw = r;
            encode = ISP_SEL_isp_be_sel_enum;
            reset = 0x0;
        } isp_be_sel[6:4];

        enum ISP_SEL_isp_fe_sel_enum {
            ISP_FE_CONNECTS = 0 { name = "Isp Fe Connects"; desc = "ISP_FE connects to LINE_BUF (for the raw input)."; };
            ISP_FE_CONNECTS_2 = 1 { name = "Isp Fe Connects 2"; desc = "ISP_FE connects to SRC0."; };
            ISP_FE_CONNECTS_3 = 2 { name = "Isp Fe Connects 3"; desc = "ISP_FE connects to SRC1."; };
            ISP_FE_CONNECTS_4 = 3 { name = "Isp Fe Connects 4"; desc = "ISP_FE connects to SRC2."; };
            ISP_FE_CONNECTS_5 = 4 { name = "Isp Fe Connects 5"; desc = "ISP_FE connects to SRC3. Other values: reserved"; };
        };

        field {
            name = "isp_fe_sel";
            desc = "ISP_FE input data select";
            sw = rw;
            hw = r;
            encode = ISP_SEL_isp_fe_sel_enum;
            reset = 0x0;
        } isp_fe_sel[2:0];
    } ISP_SEL @ 0x50;

    reg {
        name = "LINE_BUF input data selection register";
        desc = "BUF_MODE is a LINE_BUF input data selection register.

Data sheet 9.1.6 BUF_MODE (offset 0x70, printed page 9-19, `hi3516av200--Hi3516AV200-Datasheet.txt` line 38382).";

        enum BUF_MODE_buf_mode_enum {
            RAW_DATA = 0 { name = "Raw Data"; desc = "raw data"; };
            YUV422 = 1 { name = "Yuv422"; desc = "YUV422"; };
        };

        field {
            name = "buf_mode";
            desc = "Input data mode of LINE_BUF";
            sw = rw;
            hw = r;
            encode = BUF_MODE_buf_mode_enum;
            reset = 0x0;
        } buf_mode[0:0];
    } BUF_MODE @ 0x70;

    reg {
        name = "Sensor slave mode configuration register";
        desc = "SLAVE_MODE_CFG is a sensor slave mode configuration register. Hi3516A V200 Professional HD IP Camera SoC

Data sheet 9.1.6 SLAVE_MODE_CFG (offset 0xA0, printed page 9-20, `hi3516av200--Hi3516AV200-Datasheet.txt` line 38420).";

        enum SLAVE_MODE_CFG_vs_enable_enum {
            DISABLED = 0 { name = "Disabled"; desc = "disabled"; };
            ENABLED = 1 { name = "Enabled"; desc = "enabled"; };
        };

        field {
            name = "vs_enable";
            desc = "VS output enable";
            sw = rw;
            hw = r;
            encode = SLAVE_MODE_CFG_vs_enable_enum;
            reset = 0x0;
        } vs_enable[31:31];

        enum SLAVE_MODE_CFG_hs_enable_enum {
            DISABLED = 0 { name = "Disabled"; desc = "disabled"; };
            ENABLED = 1 { name = "Enabled"; desc = "enabled"; };
        };

        field {
            name = "hs_enable";
            desc = "HS output enable";
            sw = rw;
            hw = r;
            encode = SLAVE_MODE_CFG_hs_enable_enum;
            reset = 0x0;
        } hs_enable[30:30];

        enum SLAVE_MODE_CFG_vs_inv_enum {
            ACTIVE_HIGH = 0 { name = "Active High"; desc = "active high"; };
            ACTIVE_LOW = 1 { name = "Active Low"; desc = "active low"; };
        };

        field {
            name = "vs_inv";
            desc = "VS output polarity";
            sw = rw;
            hw = r;
            encode = SLAVE_MODE_CFG_vs_inv_enum;
            reset = 0x0;
        } vs_inv[17:17];

        enum SLAVE_MODE_CFG_hs_inv_enum {
            ACTIVE_HIGH = 0 { name = "Active High"; desc = "active high"; };
            ACTIVE_LOW = 1 { name = "Active Low"; desc = "active low"; };
        };

        field {
            name = "hs_inv";
            desc = "HS output polarity";
            sw = rw;
            hw = r;
            encode = SLAVE_MODE_CFG_hs_inv_enum;
            reset = 0x0;
        } hs_inv[16:16];

        field {
            name = "hs_dly_cyc";
            desc = "Delay period of the HS output relative to the VS output (unit: cycle of the sensor reference clock)";
            sw = rw;
            hw = r;
            reset = 0x0;
        } hs_dly_cyc[15:0];
    } SLAVE_MODE_CFG @ 0xA0;

    reg {
        name = "VS output period configuration register in sensor slave mode";
        desc = "SLAVE_MODE_VS_TIME is a VS output period configuration register in sensor slave mode.

Data sheet 9.1.6 SLAVE_MODE_VS_TIME (offset 0xB0, printed page 9-20, `hi3516av200--Hi3516AV200-Datasheet.txt` line 38460).";

        field {
            name = "vs_time";
            desc = "VS output period (unit: cycle of the sensor reference clock)";
            sw = rw;
            hw = r;
            reset = 0x0;
        } vs_time[31:0];
    } SLAVE_MODE_VS_TIME @ 0xB0;

    reg {
        name = "HS output period configuration register in sensor slave mode";
        desc = "SLAVE_MODE_HS_TIME is an HS output period configuration register in sensor slave mode.

Data sheet 9.1.6 SLAVE_MODE_HS_TIME (offset 0xB4, printed page 9-21, `hi3516av200--Hi3516AV200-Datasheet.txt` line 38485).";

        field {
            name = "hs_time";
            desc = "HS output period (unit: cycle of the sensor reference clock)";
            sw = rw;
            hw = r;
            reset = 0x0;
        } hs_time[31:0];
    } SLAVE_MODE_HS_TIME @ 0xB4;

    reg {
        name = "VS output pulse validity signal duration configuration register in sensor slave mode";
        desc = "SLAVE_MODE_VS_CYC is a VS output pulse validity signal duration configuration register in sensor slave mode.

Data sheet 9.1.6 SLAVE_MODE_VS_CYC (offset 0xB8, printed page 9-21, `hi3516av200--Hi3516AV200-Datasheet.txt` line 38505).";

        field {
            name = "vs_cyc";
            desc = "Duration of the VS output validity signal (unit: cycle of the sensor reference clock)";
            sw = rw;
            hw = r;
            reset = 0x0;
        } vs_cyc[31:0];
    } SLAVE_MODE_VS_CYC @ 0xB8;

    reg {
        name = "HS output pulse validity signal duration configuration register in sensor slave mode";
        desc = "SLAVE_MODE_HS_CYC is an HS output pulse validity signal duration configuration register in sensor slave mode. Hi3516A V200 Professional HD IP Camera SoC

Data sheet 9.1.6 SLAVE_MODE_HS_CYC (offset 0xBC, printed page 9-22, `hi3516av200--Hi3516AV200-Datasheet.txt` line 38537).";

        field {
            name = "hs_cyc";
            desc = "Duration of the HS output validity signal (unit: cycle of the sensor reference clock)";
            sw = rw;
            hw = r;
            reset = 0x0;
        } hs_cyc[31:0];
    } SLAVE_MODE_HS_CYC @ 0xBC;

    reg {
        name = "Interrupt indicator register";
        desc = "VICAP_INT is an interrupt indicator register.

Data sheet 9.1.6 VICAP_INT (offset 0xF0, printed page 9-22, `hi3516av200--Hi3516AV200-Datasheet.txt` line 38557).";

        enum VICAP_INT_int_af_enum {
            NO_INTERRUPT_GENERATED = 0 { name = "No Interrupt Generated"; desc = "No interrupt is generated."; };
            INTERRUPT_GENERATED = 1 { name = "Interrupt Generated"; desc = "An interrupt is generated."; };
        };

        field {
            name = "int_af";
            desc = "AF interrupt status";
            sw = r;
            hw = w;
            encode = VICAP_INT_int_af_enum;
            reset = 0x0;
        } int_af[18:18];

        enum VICAP_INT_int_isp_be_enum {
            NO_INTERRUPT_GENERATED = 0 { name = "No Interrupt Generated"; desc = "No interrupt is generated."; };
            INTERRUPT_GENERATED = 1 { name = "Interrupt Generated"; desc = "An interrupt is generated."; };
        };

        field {
            name = "int_isp_be";
            desc = "ISP_BE interrupt status";
            sw = r;
            hw = w;
            encode = VICAP_INT_int_isp_be_enum;
            reset = 0x0;
        } int_isp_be[17:17];

        enum VICAP_INT_int_isp_fe_enum {
            NO_INTERRUPT_GENERATED = 0 { name = "No Interrupt Generated"; desc = "No interrupt is generated."; };
            INTERRUPT_GENERATED = 1 { name = "Interrupt Generated"; desc = "An interrupt is generated."; };
        };

        field {
            name = "int_isp_fe";
            desc = "ISP_FE interrupt status";
            sw = r;
            hw = w;
            encode = VICAP_INT_int_isp_fe_enum;
            reset = 0x0;
        } int_isp_fe[16:16];

        enum VICAP_INT_int_bas_enum {
            NO_INTERRUPT_GENERATED = 0 { name = "No Interrupt Generated"; desc = "No interrupt is generated."; };
            INTERRUPT_GENERATED = 1 { name = "Interrupt Generated"; desc = "An interrupt is generated."; };
        };

        field {
            name = "int_bas";
            desc = "BAS interrupt status";
            sw = r;
            hw = w;
            encode = VICAP_INT_int_bas_enum;
            reset = 0x0;
        } int_bas[10:10];

        enum VICAP_INT_int_buf_enum {
            NO_INTERRUPT_GENERATED = 0 { name = "No Interrupt Generated"; desc = "No interrupt is generated."; };
            INTERRUPT_GENERATED = 1 { name = "Interrupt Generated"; desc = "An interrupt is generated."; };
        };

        field {
            name = "int_buf";
            desc = "LINE_BUF interrupt status";
            sw = r;
            hw = w;
            encode = VICAP_INT_int_buf_enum;
            reset = 0x0;
        } int_buf[9:9];

        enum VICAP_INT_int_src3_enum {
            NO_INTERRUPT_GENERATED = 0 { name = "No Interrupt Generated"; desc = "No interrupt is generated."; };
            INTERRUPT_GENERATED = 1 { name = "Interrupt Generated"; desc = "An interrupt is generated."; };
        };

        field {
            name = "int_src3";
            desc = "SRC3 interrupt status";
            sw = r;
            hw = w;
            encode = VICAP_INT_int_src3_enum;
            reset = 0x0;
        } int_src3[8:8];

        enum VICAP_INT_int_src2_enum {
            NO_INTERRUPT_GENERATED = 0 { name = "No Interrupt Generated"; desc = "No interrupt is generated."; };
            INTERRUPT_GENERATED = 1 { name = "Interrupt Generated"; desc = "An interrupt is generated."; };
        };

        field {
            name = "int_src2";
            desc = "SRC2 interrupt status";
            sw = r;
            hw = w;
            encode = VICAP_INT_int_src2_enum;
            reset = 0x0;
        } int_src2[7:7];

        enum VICAP_INT_int_src1_enum {
            NO_INTERRUPT_GENERATED = 0 { name = "No Interrupt Generated"; desc = "No interrupt is generated."; };
            INTERRUPT_GENERATED = 1 { name = "Interrupt Generated"; desc = "An interrupt is generated."; };
        };

        field {
            name = "int_src1";
            desc = "SRC1 interrupt status";
            sw = r;
            hw = w;
            encode = VICAP_INT_int_src1_enum;
            reset = 0x0;
        } int_src1[6:6];

        enum VICAP_INT_int_src0_enum {
            NO_INTERRUPT_GENERATED = 0 { name = "No Interrupt Generated"; desc = "No interrupt is generated."; };
            INTERRUPT_GENERATED = 1 { name = "Interrupt Generated"; desc = "An interrupt is generated."; };
        };

        field {
            name = "int_src0";
            desc = "SRC0 interrupt status";
            sw = r;
            hw = w;
            encode = VICAP_INT_int_src0_enum;
            reset = 0x0;
        } int_src0[5:5];

        enum VICAP_INT_int_des2_enum {
            NO_INTERRUPT_GENERATED = 0 { name = "No Interrupt Generated"; desc = "No interrupt is generated."; };
            INTERRUPT_GENERATED = 1 { name = "Interrupt Generated"; desc = "An interrupt is generated."; };
        };

        field {
            name = "int_des2";
            desc = "DES2 interrupt status";
            sw = r;
            hw = w;
            encode = VICAP_INT_int_des2_enum;
            reset = 0x0;
        } int_des2[4:4];

        enum VICAP_INT_int_des1_enum {
            NO_INTERRUPT_GENERATED = 0 { name = "No Interrupt Generated"; desc = "No interrupt is generated."; };
            INTERRUPT_GENERATED = 1 { name = "Interrupt Generated"; desc = "An interrupt is generated."; };
        };

        field {
            name = "int_des1";
            desc = "DES1 interrupt status";
            sw = r;
            hw = w;
            encode = VICAP_INT_int_des1_enum;
            reset = 0x0;
        } int_des1[3:3];

        enum VICAP_INT_int_des0_enum {
            NO_INTERRUPT_GENERATED = 0 { name = "No Interrupt Generated"; desc = "No interrupt is generated."; };
            INTERRUPT_GENERATED = 1 { name = "Interrupt Generated"; desc = "An interrupt is generated."; };
        };

        field {
            name = "int_des0";
            desc = "DES0 interrupt status";
            sw = r;
            hw = w;
            encode = VICAP_INT_int_des0_enum;
            reset = 0x0;
        } int_des0[2:2];

        enum VICAP_INT_int_ch_enum {
            NO_INTERRUPT_GENERATED = 0 { name = "No Interrupt Generated"; desc = "No interrupt is generated."; };
            INTERRUPT_GENERATED = 1 { name = "Interrupt Generated"; desc = "An interrupt is generated."; };
        };

        field {
            name = "int_ch";
            desc = "Channel interrupt status";
            sw = r;
            hw = w;
            encode = VICAP_INT_int_ch_enum;
            reset = 0x0;
        } int_ch[1:1];

        enum VICAP_INT_int_pt_enum {
            NO_INTERRUPT_GENERATED = 0 { name = "No Interrupt Generated"; desc = "No interrupt is generated."; };
            INTERRUPT_GENERATED = 1 { name = "Interrupt Generated"; desc = "An interrupt is generated."; };
        };

        field {
            name = "int_pt";
            desc = "Port interrupt status";
            sw = r;
            hw = w;
            encode = VICAP_INT_int_pt_enum;
            reset = 0x0;
        } int_pt[0:0];
    } VICAP_INT @ 0xF0;

    reg {
        name = "Interrupt mask register";
        desc = "VICAP_INT_MASK is an interrupt mask register. Hi3516A V200 Professional HD IP Camera SoC

Data sheet 9.1.6 VICAP_INT_MASK (offset 0xF8, printed page 9-24, `hi3516av200--Hi3516AV200-Datasheet.txt` line 38645).";

        enum VICAP_INT_MASK_int_af_enum {
            MASKED = 0 { name = "Masked"; desc = "masked"; };
            ENABLED = 1 { name = "Enabled"; desc = "enabled"; };
        };

        field {
            name = "int_af";
            desc = "AF interrupt enable";
            sw = rw;
            hw = r;
            encode = VICAP_INT_MASK_int_af_enum;
            reset = 0x0;
        } int_af[18:18];

        enum VICAP_INT_MASK_int_isp_be_enum {
            MASKED = 0 { name = "Masked"; desc = "masked"; };
            ENABLED = 1 { name = "Enabled"; desc = "enabled"; };
        };

        field {
            name = "int_isp_be";
            desc = "ISP_BE interrupt enable";
            sw = rw;
            hw = r;
            encode = VICAP_INT_MASK_int_isp_be_enum;
            reset = 0x0;
        } int_isp_be[17:17];

        enum VICAP_INT_MASK_int_isp_fe_enum {
            MASKED = 0 { name = "Masked"; desc = "masked"; };
            ENABLED = 1 { name = "Enabled"; desc = "enabled"; };
        };

        field {
            name = "int_isp_fe";
            desc = "ISP_FE interrupt enable";
            sw = rw;
            hw = r;
            encode = VICAP_INT_MASK_int_isp_fe_enum;
            reset = 0x0;
        } int_isp_fe[16:16];

        enum VICAP_INT_MASK_int_bas_enum {
            MASKED = 0 { name = "Masked"; desc = "masked"; };
            ENABLED = 1 { name = "Enabled"; desc = "enabled"; };
        };

        field {
            name = "int_bas";
            desc = "BAS interrupt enable";
            sw = rw;
            hw = r;
            encode = VICAP_INT_MASK_int_bas_enum;
            reset = 0x0;
        } int_bas[10:10];

        enum VICAP_INT_MASK_int_buf_enum {
            MASKED = 0 { name = "Masked"; desc = "masked"; };
            ENABLED = 1 { name = "Enabled"; desc = "enabled"; };
        };

        field {
            name = "int_buf";
            desc = "LINE_BUF interrupt enable";
            sw = rw;
            hw = r;
            encode = VICAP_INT_MASK_int_buf_enum;
            reset = 0x0;
        } int_buf[9:9];

        enum VICAP_INT_MASK_int_src3_enum {
            MASKED = 0 { name = "Masked"; desc = "masked"; };
            ENABLED = 1 { name = "Enabled"; desc = "enabled"; };
        };

        field {
            name = "int_src3";
            desc = "SRC3 interrupt enable";
            sw = rw;
            hw = r;
            encode = VICAP_INT_MASK_int_src3_enum;
            reset = 0x0;
        } int_src3[8:8];

        enum VICAP_INT_MASK_int_src2_enum {
            MASKED = 0 { name = "Masked"; desc = "masked"; };
            ENABLED = 1 { name = "Enabled"; desc = "enabled"; };
        };

        field {
            name = "int_src2";
            desc = "SRC2 interrupt enable";
            sw = rw;
            hw = r;
            encode = VICAP_INT_MASK_int_src2_enum;
            reset = 0x0;
        } int_src2[7:7];

        enum VICAP_INT_MASK_int_src1_enum {
            MASKED = 0 { name = "Masked"; desc = "masked"; };
            ENABLED = 1 { name = "Enabled"; desc = "enabled"; };
        };

        field {
            name = "int_src1";
            desc = "SRC1 interrupt enable";
            sw = rw;
            hw = r;
            encode = VICAP_INT_MASK_int_src1_enum;
            reset = 0x0;
        } int_src1[6:6];

        enum VICAP_INT_MASK_int_src0_enum {
            MASKED = 0 { name = "Masked"; desc = "masked"; };
            ENABLED = 1 { name = "Enabled"; desc = "enabled"; };
        };

        field {
            name = "int_src0";
            desc = "SRC0 interrupt enable";
            sw = rw;
            hw = r;
            encode = VICAP_INT_MASK_int_src0_enum;
            reset = 0x0;
        } int_src0[5:5];

        enum VICAP_INT_MASK_int_des2_enum {
            MASKED = 0 { name = "Masked"; desc = "masked"; };
            ENABLED = 1 { name = "Enabled"; desc = "enabled"; };
        };

        field {
            name = "int_des2";
            desc = "DES2 interrupt enable";
            sw = rw;
            hw = r;
            encode = VICAP_INT_MASK_int_des2_enum;
            reset = 0x0;
        } int_des2[4:4];

        enum VICAP_INT_MASK_int_des1_enum {
            MASKED = 0 { name = "Masked"; desc = "masked"; };
            ENABLED = 1 { name = "Enabled"; desc = "enabled"; };
        };

        field {
            name = "int_des1";
            desc = "DES1 interrupt enable";
            sw = rw;
            hw = r;
            encode = VICAP_INT_MASK_int_des1_enum;
            reset = 0x0;
        } int_des1[3:3];

        enum VICAP_INT_MASK_int_des0_enum {
            MASKED = 0 { name = "Masked"; desc = "masked"; };
            ENABLED = 1 { name = "Enabled"; desc = "enabled"; };
        };

        field {
            name = "int_des0";
            desc = "DES0 interrupt enable";
            sw = rw;
            hw = r;
            encode = VICAP_INT_MASK_int_des0_enum;
            reset = 0x0;
        } int_des0[2:2];

        enum VICAP_INT_MASK_int_ch_enum {
            MASKED = 0 { name = "Masked"; desc = "masked"; };
            ENABLED = 1 { name = "Enabled"; desc = "enabled"; };
        };

        field {
            name = "int_ch";
            desc = "Channel interrupt enable";
            sw = rw;
            hw = r;
            encode = VICAP_INT_MASK_int_ch_enum;
            reset = 0x0;
        } int_ch[1:1];

        enum VICAP_INT_MASK_int_pt_enum {
            MASKED = 0 { name = "Masked"; desc = "masked"; };
            ENABLED = 1 { name = "Enabled"; desc = "enabled"; };
        };

        field {
            name = "int_pt";
            desc = "Port interrupt enable";
            sw = rw;
            hw = r;
            encode = VICAP_INT_MASK_int_pt_enum;
            reset = 0x0;
        } int_pt[0:0];
    } VICAP_INT_MASK @ 0xF8;

    reg {
        name = "Port mode register";
        desc = "PT_INTF_MOD is a port mode register.

Data sheet 9.1.6 PT_INTF_MOD (offset 0x100, printed page 9-25, `hi3516av200--Hi3516AV200-Datasheet.txt` line 38721).";

        enum PT_INTF_MOD_enable_f_enum {
            DISABLED = 0 { name = "Disabled"; desc = "disabled"; };
            ENABLED = 1 { name = "Enabled"; desc = "enabled"; };
        };

        field {
            name = "enable";
            desc = "Port enable";
            sw = rw;
            hw = r;
            encode = PT_INTF_MOD_enable_f_enum;
            reset = 0x0;
        } enable_f[31:31];

        enum PT_INTF_MOD_mode_enum {
            EXTERNAL_SYNC = 0 { name = "External Sync"; desc = "external sync"; };
            INTERNAL_SYNC = 1 { name = "Internal Sync"; desc = "internal sync"; };
        };

        field {
            name = "mode";
            desc = "Timing mode";
            sw = rw;
            hw = r;
            encode = PT_INTF_MOD_mode_enum;
            reset = 0x0;
        } mode[0:0];
    } PT_INTF_MOD @ 0x100;

    reg {
        name = "Component 0 offset register";
        desc = "PT_OFFSET0 is a component 0 offset register.

Data sheet 9.1.6 PT_OFFSET0 (offset 0x110, printed page 9-26, `hi3516av200--Hi3516AV200-Datasheet.txt` line 38752).";

        field {
            name = "mask";
            desc = "Component 0 mask";
            sw = rw;
            hw = r;
            reset = 0xFFF0;
        } mask_f[31:16];

        enum PT_OFFSET0_rev_enum {
            NO = 0 { name = "No"; desc = "no"; };
            YES = 1 { name = "Yes"; desc = "yes"; };
        };

        field {
            name = "rev";
            desc = "Whether the sequence of the data line is reversed";
            sw = rw;
            hw = r;
            encode = PT_OFFSET0_rev_enum;
            reset = 0x0;
        } rev[15:15];

        field {
            name = "offset";
            desc = "Component 0 offset";
            sw = rw;
            hw = r;
            reset = 0x0;
        } offset[5:0];
    } PT_OFFSET0 @ 0x110;

    reg {
        name = "Component 1 offset register";
        desc = "PT_OFFSET1 is a component 1 offset register.

Data sheet 9.1.6 PT_OFFSET1 (offset 0x114, printed page 9-26, `hi3516av200--Hi3516AV200-Datasheet.txt` line 38777).";

        field {
            name = "mask";
            desc = "Component 1 mask";
            sw = rw;
            hw = r;
            reset = 0xFFF0;
        } mask_f[31:16];

        enum PT_OFFSET1_rev_enum {
            NO = 0 { name = "No"; desc = "no"; };
            YES = 1 { name = "Yes"; desc = "yes"; };
        };

        field {
            name = "rev";
            desc = "Whether the sequence of the data line is reversed";
            sw = rw;
            hw = r;
            encode = PT_OFFSET1_rev_enum;
            reset = 0x0;
        } rev[15:15];

        field {
            name = "offset";
            desc = "Component 1 offset";
            sw = rw;
            hw = r;
            reset = 0x10;
        } offset[5:0];
    } PT_OFFSET1 @ 0x114;

    reg {
        name = "Component 2 offset register";
        desc = "PT_OFFSET2 is a component 2 offset register.

Data sheet 9.1.6 PT_OFFSET2 (offset 0x118, printed page 9-27, `hi3516av200--Hi3516AV200-Datasheet.txt` line 38806).";

        field {
            name = "mask";
            desc = "Component 2 mask";
            sw = rw;
            hw = r;
            reset = 0xFFF0;
        } mask_f[31:16];

        enum PT_OFFSET2_rev_enum {
            NO = 0 { name = "No"; desc = "no"; };
            YES = 1 { name = "Yes"; desc = "yes"; };
        };

        field {
            name = "rev";
            desc = "Whether the sequence of the data line is reversed";
            sw = rw;
            hw = r;
            encode = PT_OFFSET2_rev_enum;
            reset = 0x0;
        } rev[15:15];

        field {
            name = "offset";
            desc = "Component 2 offset";
            sw = rw;
            hw = r;
            reset = 0x20;
        } offset[5:0];
    } PT_OFFSET2 @ 0x118;

    reg {
        name = "PT_BT656_CFG";
        desc = "PT_BT656_CFG is a BT.656 configuration register.

Data sheet 9.1.6 PT_BT656_CFG (offset 0x120, printed page 9-27, `hi3516av200--Hi3516AV200-Datasheet.txt` line 38830).";

        enum PT_BT656_CFG_enable_f_enum {
            DISABLED = 0 { name = "Disabled"; desc = "disabled"; };
            ENABLED = 1 { name = "Enabled"; desc = "enabled"; };
        };

        field {
            name = "enable";
            desc = "BT.656 enable";
            sw = rw;
            hw = r;
            encode = PT_BT656_CFG_enable_f_enum;
            reset = 0x0;
        } enable_f[31:31];

        enum PT_BT656_CFG_vsync_inv_enum {
            NOT_REVERSED = 0 { name = "Not Reversed"; desc = "not reversed"; };
            REVERSED = 1 { name = "Reversed"; desc = "reversed"; };
        };

        field {
            name = "vsync_inv";
            desc = "vsync reverse control";
            sw = rw;
            hw = r;
            encode = PT_BT656_CFG_vsync_inv_enum;
            reset = 0x1;
        } vsync_inv[9:9];

        enum PT_BT656_CFG_hsync_inv_enum {
            NOT_REVERSED = 0 { name = "Not Reversed"; desc = "not reversed"; };
            REVERSED = 1 { name = "Reversed"; desc = "reversed"; };
        };

        field {
            name = "hsync_inv";
            desc = "hsync reverse control";
            sw = rw;
            hw = r;
            encode = PT_BT656_CFG_hsync_inv_enum;
            reset = 0x1;
        } hsync_inv[8:8];

        field {
            name = "mode";
            desc = "Mode select mode[0] 0: hsync is not an active signal. 1: hsync is an active signal. mode[1] 0: The hsync output is active low. 1: The hsync output is active high. mode[3:2] 00: Component 0 is parsed. 01: Component 1 is parsed. 10: Component 2 is parsed. 11: reserved";
            sw = rw;
            hw = r;
            reset = 0x3;
        } mode[3:0];
    } PT_BT656_CFG @ 0x120;

    reg {
        name = "Timing configuration register";
        desc = "PT_UNIFY_TIMING_CFG is a timing configuration register.

Data sheet 9.1.6 PT_UNIFY_TIMING_CFG (offset 0x130, printed page 9-28, `hi3516av200--Hi3516AV200-Datasheet.txt` line 38888).";

        enum PT_UNIFY_TIMING_CFG_vsync_mode_enum {
            NOT_PROCESSED = 0 { name = "Not Processed"; desc = "not processed"; };
            DETECT_RISING_EDGE = 1 { name = "Detect Rising Edge"; desc = "detect the rising edge"; };
            DETECT_RISING_EDGE_2 = 2 { name = "Detect Rising Edge 2"; desc = "detect the rising edge and falling edge"; };
            RESERVED = 3 { name = "Reserved"; desc = "reserved"; };
        };

        field {
            name = "vsync_mode";
            desc = "vsync processing mode (level-2 vsync processing)";
            sw = rw;
            hw = r;
            encode = PT_UNIFY_TIMING_CFG_vsync_mode_enum;
            reset = 0x0;
        } vsync_mode[20:19];

        enum PT_UNIFY_TIMING_CFG_vsync_inv_enum {
            NOT_INVERTED = 0 { name = "Not Inverted"; desc = "not inverted"; };
            INVERTED = 1 { name = "Inverted"; desc = "inverted"; };
        };

        field {
            name = "vsync_inv";
            desc = "vsync inversion (level-1 vsync processing)";
            sw = rw;
            hw = r;
            encode = PT_UNIFY_TIMING_CFG_vsync_inv_enum;
            reset = 0x0;
        } vsync_inv[18:18];

        enum PT_UNIFY_TIMING_CFG_vsync_sel_enum {
            INPUT_VSYNC = 0 { name = "Input Vsync"; desc = "input vsync"; };
            INPUT_FIELD = 1 { name = "Input Field"; desc = "input field"; };
            FIXED_AT_0 = 2 { name = "Fixed At 0"; desc = "fixed at 0"; };
            RESERVED = 3 { name = "Reserved"; desc = "reserved"; };
        };

        field {
            name = "vsync_sel";
            desc = "vsync source select (level-0 vsync processing)";
            sw = rw;
            hw = r;
            encode = PT_UNIFY_TIMING_CFG_vsync_sel_enum;
            reset = 0x0;
        } vsync_sel[17:16];

        enum PT_UNIFY_TIMING_CFG_hsync_mode_enum {
            NOT_PROCESSED = 0 { name = "Not Processed"; desc = "not processed"; };
            DETECT_RISING_EDGE = 1 { name = "Detect Rising Edge"; desc = "detect the rising edge"; };
        };

        field {
            name = "hsync_mode";
            desc = "hsync processing mode (level-3 hsync processing)";
            sw = rw;
            hw = r;
            encode = PT_UNIFY_TIMING_CFG_hsync_mode_enum;
            reset = 0x0;
        } hsync_mode[14:13];

        enum PT_UNIFY_TIMING_CFG_hsync_and_enum {
            NOT_PROCESSED = 0 { name = "Not Processed"; desc = "not processed"; };
            ANDED = 1 { name = "Anded"; desc = "ANDed"; };
            EXCLUSIVE_ORED = 2 { name = "Exclusive Ored"; desc = "exclusive ORed"; };
            RESERVED = 3 { name = "Reserved"; desc = "reserved"; };
        };

        field {
            name = "hsync_and";
            desc = "Whether hsync is operated with the result of level-1 vsync processing (level-2 hsync processing)";
            sw = rw;
            hw = r;
            encode = PT_UNIFY_TIMING_CFG_hsync_and_enum;
            reset = 0x0;
        } hsync_and[12:11];

        enum PT_UNIFY_TIMING_CFG_hsync_inv_enum {
            NOT_INVERTED = 0 { name = "Not Inverted"; desc = "not inverted"; };
            INVERTED = 1 { name = "Inverted"; desc = "inverted"; };
        };

        field {
            name = "hsync_inv";
            desc = "hsync inversion (level-1 hsync processing)";
            sw = rw;
            hw = r;
            encode = PT_UNIFY_TIMING_CFG_hsync_inv_enum;
            reset = 0x0;
        } hsync_inv[10:10];

        enum PT_UNIFY_TIMING_CFG_hsync_sel_enum {
            INPUT_HSYNC = 0 { name = "Input Hsync"; desc = "input hsync"; };
            INPUT_DE = 1 { name = "Input De"; desc = "input de"; };
            FIXED_AT_0 = 2 { name = "Fixed At 0"; desc = "fixed at 0"; };
            RESERVED = 3 { name = "Reserved"; desc = "reserved"; };
        };

        field {
            name = "hsync_sel";
            desc = "hsync source select (level-0 hsync processing)";
            sw = rw;
            hw = r;
            encode = PT_UNIFY_TIMING_CFG_hsync_sel_enum;
            reset = 0x0;
        } hsync_sel[9:8];

        enum PT_UNIFY_TIMING_CFG_de_inv_enum {
            NOT_INVERTED = 0 { name = "Not Inverted"; desc = "not inverted"; };
            INVERTED = 1 { name = "Inverted"; desc = "inverted"; };
        };

        field {
            name = "de_inv";
            desc = "de inversion (level-1 de processing)";
            sw = rw;
            hw = r;
            encode = PT_UNIFY_TIMING_CFG_de_inv_enum;
            reset = 0x0;
        } de_inv[2:2];

        enum PT_UNIFY_TIMING_CFG_de_sel_enum {
            INPUT_DE = 0 { name = "Input De"; desc = "input de"; };
            RESULT_LEVEL_2 = 1 { name = "Result Level 2"; desc = "result of level-2 hsync processing"; };
            FIXED_AT_1 = 2 { name = "Fixed At 1"; desc = "fixed at 1"; };
            FIXED_AT_0 = 3 { name = "Fixed At 0"; desc = "fixed at 0"; };
        };

        field {
            name = "de_sel";
            desc = "de source select (level-0 de processing)";
            sw = rw;
            hw = r;
            encode = PT_UNIFY_TIMING_CFG_de_sel_enum;
            reset = 0x0;
        } de_sel[1:0];
    } PT_UNIFY_TIMING_CFG @ 0x130;

    reg {
        name = "Timing recovery module configuration register";
        desc = "PT_GEN_TIMING_CFG is a timing recovery module configuration register. Hi3516A V200 Professional HD IP Camera SoC

Data sheet 9.1.6 PT_GEN_TIMING_CFG (offset 0x134, printed page 9-30, `hi3516av200--Hi3516AV200-Datasheet.txt` line 38973).";

        enum PT_GEN_TIMING_CFG_enable_f_enum {
            DISABLED = 0 { name = "Disabled"; desc = "disabled"; };
            ENABLED = 1 { name = "Enabled"; desc = "enabled"; };
        };

        field {
            name = "enable";
            desc = "Timing recovery enable (timings are recovered based on timing parameters)";
            sw = rw;
            hw = r;
            encode = PT_GEN_TIMING_CFG_enable_f_enum;
            reset = 0x0;
        } enable_f[31:31];

        enum PT_GEN_TIMING_CFG_mode_enum {
            TIMINGS_GENERATED_BASED = 0 { name = "Timings Generated Based"; desc = "Timings are generated based on the input valid signal of PT."; };
            TIMINGS_INTERNALLY_CALCULATED = 1 { name = "Timings Internally Calculated"; desc = "Timings are internally calculated and generated."; };
        };

        field {
            name = "mode";
            desc = "Timing recovery mode (timings are recovered based on timing parameters)";
            sw = rw;
            hw = r;
            encode = PT_GEN_TIMING_CFG_mode_enum;
            reset = 0x0;
        } mode[30:30];

        enum PT_GEN_TIMING_CFG_vsync_mode_enum {
            NOT_RECOVERED = 0 { name = "Not Recovered"; desc = "not recovered"; };
            RECOVERED = 1 { name = "Recovered"; desc = "recovered"; };
        };

        field {
            name = "vsync_mode";
            desc = "vsync recovery";
            sw = rw;
            hw = r;
            encode = PT_GEN_TIMING_CFG_vsync_mode_enum;
            reset = 0x0;
        } vsync_mode[2:2];

        enum PT_GEN_TIMING_CFG_hsync_mode_enum {
            NOT_RECOVERED = 0 { name = "Not Recovered"; desc = "not recovered"; };
            RECOVERED = 1 { name = "Recovered"; desc = "recovered"; };
        };

        field {
            name = "hsync_mode";
            desc = "hsync recovery";
            sw = rw;
            hw = r;
            encode = PT_GEN_TIMING_CFG_hsync_mode_enum;
            reset = 0x0;
        } hsync_mode[1:1];
    } PT_GEN_TIMING_CFG @ 0x134;

    reg {
        name = "Data configuration register";
        desc = "PT_UNIFY_DATA_CFG is a data configuration register. Hi3516A V200 Professional HD IP Camera SoC

Data sheet 9.1.6 PT_UNIFY_DATA_CFG (offset 0x140, printed page 9-31, `hi3516av200--Hi3516AV200-Datasheet.txt` line 39024).";

        enum PT_UNIFY_DATA_CFG_enable_f_enum {
            DISABLED = 0 { name = "Disabled"; desc = "disabled"; };
            ENABLED = 1 { name = "Enabled"; desc = "enabled"; };
        };

        field {
            name = "enable";
            desc = "Data separation enable";
            sw = rw;
            hw = r;
            encode = PT_UNIFY_DATA_CFG_enable_f_enum;
            reset = 0x0;
        } enable_f[31:31];

        enum PT_UNIFY_DATA_CFG_uv_seq_enum {
            CBCR = 0 { name = "Cbcr"; desc = "CbCr"; };
            CRCB = 1 { name = "Crcb"; desc = "CrCb"; };
        };

        field {
            name = "uv_seq";
            desc = "CbCr sequence";
            sw = rw;
            hw = r;
            encode = PT_UNIFY_DATA_CFG_uv_seq_enum;
            reset = 0x0;
        } uv_seq[3:3];

        enum PT_UNIFY_DATA_CFG_yc_seq_enum {
            CY = 0 { name = "Cy"; desc = "CY"; };
            YC = 1 { name = "Yc"; desc = "YC"; };
        };

        field {
            name = "yc_seq";
            desc = "YC sequence";
            sw = rw;
            hw = r;
            encode = PT_UNIFY_DATA_CFG_yc_seq_enum;
            reset = 0x0;
        } yc_seq[2:2];

        enum PT_UNIFY_DATA_CFG_comp_num_enum {
            COMPONENT_1 = 0 { name = "Component 1"; desc = "component 1"; };
            COMPONENT_2 = 1 { name = "Component 2"; desc = "component 2"; };
            COMPONENT_3 = 2 { name = "Component 3"; desc = "component 3"; };
            RESERVED = 3 { name = "Reserved"; desc = "reserved"; };
        };

        field {
            name = "comp_num";
            desc = "Data component select";
            sw = rw;
            hw = r;
            encode = PT_UNIFY_DATA_CFG_comp_num_enum;
            reset = 0x0;
        } comp_num[1:0];
    } PT_UNIFY_DATA_CFG @ 0x140;

    reg {
        name = "Data generation module configuration register";
        desc = "PT_GEN_DATA_CFG is a data generation module configuration register. Hi3516A V200 Professional HD IP Camera SoC

Data sheet 9.1.6 PT_GEN_DATA_CFG (offset 0x144, printed page 9-32, `hi3516av200--Hi3516AV200-Datasheet.txt` line 39072).";

        enum PT_GEN_DATA_CFG_enable_f_enum {
            DISABLED = 0 { name = "Disabled"; desc = "disabled"; };
            ENABLED = 1 { name = "Enabled"; desc = "enabled"; };
        };

        field {
            name = "enable";
            desc = "Data generation enable. Data is generated based on the data generation parameter.";
            sw = rw;
            hw = r;
            encode = PT_GEN_DATA_CFG_enable_f_enum;
            reset = 0x0;
        } enable_f[31:31];

        enum PT_GEN_DATA_CFG_data0_move_enum {
            NO = 0 { name = "No"; desc = "no"; };
            YES = 1 { name = "Yes"; desc = "yes"; };
        };

        field {
            name = "data0_move";
            desc = "Whether data 0 is incremented progressively";
            sw = rw;
            hw = r;
            encode = PT_GEN_DATA_CFG_data0_move_enum;
            reset = 0x1;
        } data0_move[7:7];

        enum PT_GEN_DATA_CFG_data1_move_enum {
            NO = 0 { name = "No"; desc = "no"; };
            YES = 1 { name = "Yes"; desc = "yes"; };
        };

        field {
            name = "data1_move";
            desc = "Whether data 1 is incremented progressively";
            sw = rw;
            hw = r;
            encode = PT_GEN_DATA_CFG_data1_move_enum;
            reset = 0x1;
        } data1_move[6:6];

        enum PT_GEN_DATA_CFG_data2_move_enum {
            NO = 0 { name = "No"; desc = "no"; };
            YES = 1 { name = "Yes"; desc = "yes"; };
        };

        field {
            name = "data2_move";
            desc = "Whether data 2 is incremented progressively";
            sw = rw;
            hw = r;
            encode = PT_GEN_DATA_CFG_data2_move_enum;
            reset = 0x1;
        } data2_move[5:5];

        enum PT_GEN_DATA_CFG_vsync_reset_enum {
            NOT_RESET = 0 { name = "Not Reset"; desc = "not reset"; };
            RESET_F = 1 { name = "Reset F"; desc = "reset"; };
        };

        field {
            name = "vsync_reset";
            desc = "Whether to reset data based on the VS signal";
            sw = rw;
            hw = r;
            encode = PT_GEN_DATA_CFG_vsync_reset_enum;
            reset = 0x0;
        } vsync_reset[4:4];

        enum PT_GEN_DATA_CFG_hsync_reset_enum {
            NOT_RESET = 0 { name = "Not Reset"; desc = "not reset"; };
            RESET_F = 1 { name = "Reset F"; desc = "reset"; };
        };

        field {
            name = "hsync_reset";
            desc = "Whether to reset data based on the HS signal";
            sw = rw;
            hw = r;
            encode = PT_GEN_DATA_CFG_hsync_reset_enum;
            reset = 0x1;
        } hsync_reset[3:3];

        enum PT_GEN_DATA_CFG_vsync_move_enum {
            NO = 0 { name = "No"; desc = "no"; };
            YES = 1 { name = "Yes"; desc = "yes"; };
        };

        field {
            name = "vsync_move";
            desc = "Whether data is incremented progressively based on the VS signal";
            sw = rw;
            hw = r;
            encode = PT_GEN_DATA_CFG_vsync_move_enum;
            reset = 0x0;
        } vsync_move[2:2];

        enum PT_GEN_DATA_CFG_hsync_move_enum {
            NO = 0 { name = "No"; desc = "no"; };
            YES = 1 { name = "Yes"; desc = "yes"; };
        };

        field {
            name = "hsync_move";
            desc = "Whether data is incremented progressively based on the HS signal";
            sw = rw;
            hw = r;
            encode = PT_GEN_DATA_CFG_hsync_move_enum;
            reset = 0x0;
        } hsync_move[1:1];

        enum PT_GEN_DATA_CFG_de_move_enum {
            NO = 0 { name = "No"; desc = "no"; };
            YES = 1 { name = "Yes"; desc = "yes"; };
        };

        field {
            name = "de_move";
            desc = "Whether data is incremented progressively based on the de signal";
            sw = rw;
            hw = r;
            encode = PT_GEN_DATA_CFG_de_move_enum;
            reset = 0x1;
        } de_move[0:0];
    } PT_GEN_DATA_CFG @ 0x144;

    reg {
        name = "Data generation module coefficient register";
        desc = "PT_GEN_DATA_COEF is a data generation module coefficient register.

Data sheet 9.1.6 PT_GEN_DATA_COEF (offset 0x148, printed page 9-33, `hi3516av200--Hi3516AV200-Datasheet.txt` line 39137).";

        field {
            name = "inc_frame";
            desc = "Incremental value between data frames. The incremental values are accumulated in the upper eight bits of data.";
            sw = rw;
            hw = r;
            reset = 0x1;
        } inc_frame[31:24];

        field {
            name = "step_frame";
            desc = "Interval for data frame increment. The configured value is the actual value minus 1. The value 0 indicates the increment by frame.";
            sw = rw;
            hw = r;
            reset = 0x0;
        } step_frame[23:16];

        field {
            name = "inc_space";
            desc = "Incremental value between data pixels. The incremental values are accumulated in the upper 10 bits of data.";
            sw = rw;
            hw = r;
            reset = 0x1;
        } inc_space[15:8];

        field {
            name = "step_space";
            desc = "Interval for data pixel increment. The value 0 indicates the increment by pixel.";
            sw = rw;
            hw = r;
            reset = 0x0;
        } step_space[7:0];
    } PT_GEN_DATA_COEF @ 0x148;

    reg {
        name = "Data generation module initial value configuration register";
        desc = "PT_GEN_DATA_INIT is a data generation module initial value configuration register.

Data sheet 9.1.6 PT_GEN_DATA_INIT (offset 0x14C, printed page 9-33, `hi3516av200--Hi3516AV200-Datasheet.txt` line 39166).";

        field {
            name = "data2";
            desc = "Initial V/B value";
            sw = rw;
            hw = r;
            reset = 0x0;
        } data2[23:16];

        field {
            name = "data1";
            desc = "Initial U/G value";
            sw = rw;
            hw = r;
            reset = 0x0;
        } data1[15:8];

        field {
            name = "data0";
            desc = "Initial Y/R value";
            sw = rw;
            hw = r;
            reset = 0x0;
        } data0[7:0];
    } PT_GEN_DATA_INIT @ 0x14C;

    reg {
        name = "Horizontal front blanking width register";
        desc = "PT_INTF_HFB is a horizontal front blanking width register.

Data sheet 9.1.6 PT_INTF_HFB (offset 0x180, printed page 9-34, `hi3516av200--Hi3516AV200-Datasheet.txt` line 39199).";

        field {
            name = "hfb";
            desc = "Horizontal front blanking width (unit: cycle clock)";
            sw = rw;
            hw = r;
            reset = 0x10;
        } hfb[15:0];
    } PT_INTF_HFB @ 0x180;

    reg {
        name = "Horizontal active width register";
        desc = "PT_INTF_HACT is a horizontal active width register.

Data sheet 9.1.6 PT_INTF_HACT (offset 0x184, printed page 9-34, `hi3516av200--Hi3516AV200-Datasheet.txt` line 39218).";

        field {
            name = "hact";
            desc = "Horizontal active width (unit: cycle clock)";
            sw = rw;
            hw = r;
            reset = 0x10;
        } hact[31:0];
    } PT_INTF_HACT @ 0x184;

    reg {
        name = "Horizontal back blanking width register";
        desc = "PT_INTF_HBB is a horizontal back blanking width register. Hi3516A V200 Professional HD IP Camera SoC

Data sheet 9.1.6 PT_INTF_HBB (offset 0x188, printed page 9-35, `hi3516av200--Hi3516AV200-Datasheet.txt` line 39247).";

        field {
            name = "hbb";
            desc = "Horizontal back blanking width (unit: cycle clock)";
            sw = rw;
            hw = r;
            reset = 0x10;
        } hbb[15:0];
    } PT_INTF_HBB @ 0x188;

    reg {
        name = "Vertical front blanking width register";
        desc = "PT_INTF_VFB is a vertical front blanking width register.

Data sheet 9.1.6 PT_INTF_VFB (offset 0x18C, printed page 9-35, `hi3516av200--Hi3516AV200-Datasheet.txt` line 39266).";

        field {
            name = "vfb";
            desc = "Vertical front blanking width (unit: cycle clock)";
            sw = rw;
            hw = r;
            reset = 0x10;
        } vfb[15:0];
    } PT_INTF_VFB @ 0x18C;

    reg {
        name = "Vertical active width register";
        desc = "PT_INTF_VACT is a vertical active width register.

Data sheet 9.1.6 PT_INTF_VACT (offset 0x190, printed page 9-35, `hi3516av200--Hi3516AV200-Datasheet.txt` line 39286).";

        field {
            name = "vact";
            desc = "Vertical active width (unit: cycle clock)";
            sw = rw;
            hw = r;
            reset = 0x10;
        } vact[15:0];
    } PT_INTF_VACT @ 0x190;

    reg {
        name = "Vertical back blanking width register";
        desc = "PT_INTF_VBB is a vertical back blanking width register.

Data sheet 9.1.6 PT_INTF_VBB (offset 0x194, printed page 9-36, `hi3516av200--Hi3516AV200-Datasheet.txt` line 39311).";

        field {
            name = "vbb";
            desc = "Vertical back blanking width (unit: cycle clock)";
            sw = rw;
            hw = r;
            reset = 0x10;
        } vbb[15:0];
    } PT_INTF_VBB @ 0x194;

    reg {
        name = "Vertical bottom front blanking width register";
        desc = "PT_INTF_VBFB is a vertical bottom front blanking width register.

Data sheet 9.1.6 PT_INTF_VBFB (offset 0x198, printed page 9-36, `hi3516av200--Hi3516AV200-Datasheet.txt` line 39331).";

        field {
            name = "vbfb";
            desc = "Vertical bottom front blanking width (unit: cycle clock)";
            sw = rw;
            hw = r;
            reset = 0x10;
        } vbfb[15:0];
    } PT_INTF_VBFB @ 0x198;

    reg {
        name = "Vertical bottom active width register";
        desc = "PT_INTF_VBACT is a vertical bottom active width register.

Data sheet 9.1.6 PT_INTF_VBACT (offset 0x19C, printed page 9-36, `hi3516av200--Hi3516AV200-Datasheet.txt` line 39350).";

        field {
            name = "vbact";
            desc = "Vertical bottom active width (unit: cycle clock)";
            sw = rw;
            hw = r;
            reset = 0x10;
        } vbact[15:0];
    } PT_INTF_VBACT @ 0x19C;

    reg {
        name = "Vertical bottom back blanking width register";
        desc = "PT_INTF_VBBB is a vertical bottom back blanking width register.

Data sheet 9.1.6 PT_INTF_VBBB (offset 0x1A0, printed page 9-37, `hi3516av200--Hi3516AV200-Datasheet.txt` line 39379).";

        field {
            name = "vbbb";
            desc = "Vertical bottom back blanking width (unit: cycle clock)";
            sw = rw;
            hw = r;
            reset = 0x10;
        } vbbb[15:0];
    } PT_INTF_VBBB @ 0x1A0;

    reg {
        name = "WDR ID configuration register";
        desc = "PT_ID_CFG is an WDR ID configuration register.

Data sheet 9.1.6 PT_ID_CFG (offset 0x1A4, printed page 9-37, `hi3516av200--Hi3516AV200-Datasheet.txt` line 39398).";

        enum PT_ID_CFG_enable_f_enum {
            DISABLED = 0 { name = "Disabled"; desc = "disabled"; };
            ENABLED = 1 { name = "Enabled"; desc = "enabled"; };
        };

        field {
            name = "enable";
            desc = "WDR ID generation enable";
            sw = rw;
            hw = r;
            encode = PT_ID_CFG_enable_f_enum;
            reset = 0x0;
        } enable_f[31:31];

        enum PT_ID_CFG_mode_enum {
            AUTOMATIC_MODE = 0 { name = "Automatic Mode"; desc = "automatic mode (the WDR ID automatically increases for each frame)"; };
            NON_AUTOMATIC_MODE = 1 { name = "Non Automatic Mode"; desc = "non-automatic mode (the WDR ID depends on the configured value)"; };
        };

        field {
            name = "mode";
            desc = "ID generation mode";
            sw = rw;
            hw = r;
            encode = PT_ID_CFG_mode_enum;
            reset = 0x0;
        } mode[30:30];

        field {
            name = "reset";
            desc = "In automatic mode, setting this field to 1 restores the WDR ID of the next frame to the initial value. This field is automatically cleared after restoration.";
            sw = w;
            hw = r;
            reset = 0x0;
        } reset_f[29:29];

        field {
            name = "id_det";
            desc = "WDR ID of the frame whose width and height are detected";
            sw = rw;
            hw = r;
            reset = 0x0;
        } id_det[5:4];

        field {
            name = "id_max";
            desc = "Maximum WDR ID in automatic mode";
            sw = rw;
            hw = r;
            reset = 0x0;
        } id_max[3:2];

        field {
            name = "id";
            desc = "Initial WDR ID in automatic mode or generated WDR ID in non- automatic mode";
            sw = rw;
            hw = r;
            reset = 0x0;
        } id[1:0];
    } PT_ID_CFG @ 0x1A4;

    reg {
        name = "Flash configuration register";
        desc = "PT_FLASH_CFG is a flash configuration register.

Data sheet 9.1.6 PT_FLASH_CFG (offset 0x1B0, printed page 9-38, `hi3516av200--Hi3516AV200-Datasheet.txt` line 39444).";

        enum PT_FLASH_CFG_id_sel_enum {
            TRIGGERED_USING_START = 1 { name = "Triggered Using Start"; desc = "triggered by using the start interrupt of the frame whose WDR ID is 0"; };
            TRIGGERED_USING_START_2 = 2 { name = "Triggered Using Start 2"; desc = "triggered by using the start interrupt of the frame whose WDR ID is 1"; };
            TRIGGERED_USING_START_3 = 4 { name = "Triggered Using Start 3"; desc = "triggered by using the start interrupt of the frame whose WDR ID is 2"; };
            TRIGGERED_USING_START_4 = 8 { name = "Triggered Using Start 4"; desc = "triggered by using the start interrupt of the frame whose WDR ID is 3 Other values: reserved"; };
        };

        field {
            name = "id_sel";
            desc = "Trigger frame WDR ID";
            sw = rw;
            hw = r;
            encode = PT_FLASH_CFG_id_sel_enum;
            reset = 0x1;
        } id_sel[31:28];

        enum PT_FLASH_CFG_shutter_times_enum {
            TWICE = 0 { name = "Twice"; desc = "twice"; };
            ONCE = 1 { name = "Once"; desc = "once"; };
        };

        field {
            name = "shutter_times";
            desc = "Shutter pulse times";
            sw = rw;
            hw = r;
            encode = PT_FLASH_CFG_shutter_times_enum;
            reset = 0x0;
        } shutter_times[18:18];

        enum PT_FLASH_CFG_shutter_phase_enum {
            NOT_REVERSED = 0 { name = "Not Reversed"; desc = "not reversed"; };
            REVERSED = 1 { name = "Reversed"; desc = "reversed"; };
        };

        field {
            name = "shutter_phase";
            desc = "Shutter signal reverse";
            sw = rw;
            hw = r;
            encode = PT_FLASH_CFG_shutter_phase_enum;
            reset = 0x0;
        } shutter_phase[17:17];

        enum PT_FLASH_CFG_shutter_en_enum {
            DISABLE = 0 { name = "Disable"; desc = "disable"; };
            ENABLE_F = 1 { name = "Enable F"; desc = "enable"; };
        };

        field {
            name = "shutter_en";
            desc = "Shutter trigger enable. This field is automatically cleared.";
            sw = w;
            hw = r;
            encode = PT_FLASH_CFG_shutter_en_enum;
            reset = 0x0;
        } shutter_en[16:16];

        enum PT_FLASH_CFG_flash_phase_enum {
            NOT_REVERSED = 0 { name = "Not Reversed"; desc = "not reversed"; };
            REVERSED = 1 { name = "Reversed"; desc = "reversed"; };
        };

        field {
            name = "flash_phase";
            desc = "Flash signal reverse";
            sw = rw;
            hw = r;
            encode = PT_FLASH_CFG_flash_phase_enum;
            reset = 0x0;
        } flash_phase[1:1];

        enum PT_FLASH_CFG_flash_en_enum {
            DISABLE = 0 { name = "Disable"; desc = "disable"; };
            ENABLE_F = 1 { name = "Enable F"; desc = "enable"; };
        };

        field {
            name = "flash_en";
            desc = "Flash trigger enable. This field is automatically cleared.";
            sw = w;
            hw = r;
            encode = PT_FLASH_CFG_flash_en_enum;
            reset = 0x0;
        } flash_en[0:0];
    } PT_FLASH_CFG @ 0x1B0;

    reg {
        name = "Flash timing 0 width register";
        desc = "PT_FLASH_CYC0 is a flash timing 0 width register.

Data sheet 9.1.6 PT_FLASH_CYC0 (offset 0x1C0, printed page 9-39, `hi3516av200--Hi3516AV200-Datasheet.txt` line 39505).";

        field {
            name = "cyc";
            desc = "Duration of flash timing 0 (unit: VICAP working clock). The configured value is the actual value minus 1.";
            sw = rw;
            hw = r;
            reset = 0x0;
        } cyc[31:0];
    } PT_FLASH_CYC0 @ 0x1C0;

    reg {
        name = "Flash timing 1 width register";
        desc = "PT_FLASH_CYC1 is a flash timing 1 width register.

Data sheet 9.1.6 PT_FLASH_CYC1 (offset 0x1C4, printed page 9-39, `hi3516av200--Hi3516AV200-Datasheet.txt` line 39526).";

        field {
            name = "cyc";
            desc = "Duration of flash timing 1 (in VICAP working clock). The configured value is the actual value minus 1.";
            sw = rw;
            hw = r;
            reset = 0x0;
        } cyc[31:0];
    } PT_FLASH_CYC1 @ 0x1C4;

    reg {
        name = "Shutter timing 0 width register";
        desc = "PT_SHUTTER_CYC0 is a shutter timing 0 width register. Hi3516A V200 Professional HD IP Camera SoC

Data sheet 9.1.6 PT_SHUTTER_CYC0 (offset 0x1D0, printed page 9-40, `hi3516av200--Hi3516AV200-Datasheet.txt` line 39556).";

        field {
            name = "cyc";
            desc = "Duration of shutter timing 0 (in VICAP working clock). The configured value is the actual value minus 1.";
            sw = rw;
            hw = r;
            reset = 0x0;
        } cyc[31:0];
    } PT_SHUTTER_CYC0 @ 0x1D0;

    reg {
        name = "Shutter timing 1 width register";
        desc = "PT_SHUTTER_CYC1 is a shutter timing 1 width register.

Data sheet 9.1.6 PT_SHUTTER_CYC1 (offset 0x1D4, printed page 9-40, `hi3516av200--Hi3516AV200-Datasheet.txt` line 39576).";

        field {
            name = "cyc";
            desc = "Duration of shutter timing 1 (in VICAP working clock). The configured value is the actual value minus 1.";
            sw = rw;
            hw = r;
            reset = 0x0;
        } cyc[31:0];
    } PT_SHUTTER_CYC1 @ 0x1D4;

    reg {
        name = "Shutter timing 2 width register";
        desc = "PT_SHUTTER_CYC2 is a shutter timing 2 width register.

Data sheet 9.1.6 PT_SHUTTER_CYC2 (offset 0x1D8, printed page 9-40, `hi3516av200--Hi3516AV200-Datasheet.txt` line 39596).";

        field {
            name = "cyc";
            desc = "Duration of shutter timing 2 (in VICAP working clock). The configured value is the actual value minus 1.";
            sw = rw;
            hw = r;
            reset = 0x0;
        } cyc[31:0];
    } PT_SHUTTER_CYC2 @ 0x1D8;

    reg {
        name = "Shutter timing 3 width register";
        desc = "PT_SHUTTER_CYC3 is a shutter timing 3 width register.

Data sheet 9.1.6 PT_SHUTTER_CYC3 (offset 0x1DC, printed page 9-41, `hi3516av200--Hi3516AV200-Datasheet.txt` line 39623).";

        field {
            name = "cyc";
            desc = "Duration of shutter timing 3 (in VICAP working clock). The configured value is the actual value minus 1.";
            sw = rw;
            hw = r;
            reset = 0x0;
        } cyc[31:0];
    } PT_SHUTTER_CYC3 @ 0x1DC;

    reg {
        name = "PT_BT656_STATUS";
        desc = "PT_BT656_STATUS is a BT.656 status register.

Data sheet 9.1.6 PT_BT656_STATUS (offset 0x1E4, printed page 9-41, `hi3516av200--Hi3516AV200-Datasheet.txt` line 39644).";

        field {
            name = "seav";
            desc = "Synchronization code";
            sw = r;
            hw = w;
            reset = 0x0;
        } seav[15:8];
    } PT_BT656_STATUS @ 0x1E4;

    reg {
        name = "Input image size register";
        desc = "PT_SIZE is an input image size register. Hi3516A V200 Professional HD IP Camera SoC

Data sheet 9.1.6 PT_SIZE (offset 0x1EC, printed page 9-42, `hi3516av200--Hi3516AV200-Datasheet.txt` line 39674).";

        field {
            name = "height";
            desc = "Input image height";
            sw = r;
            hw = w;
            reset = 0x0;
        } height[31:16];

        field {
            name = "width";
            desc = "Input image width";
            sw = r;
            hw = w;
            reset = 0x0;
        } width[15:0];
    } PT_SIZE @ 0x1EC;

    reg {
        name = "Port interrupt indicator register";
        desc = "PT_INT is a port interrupt indicator register.

Data sheet 9.1.6 PT_INT (offset 0x1F0, printed page 9-42, `hi3516av200--Hi3516AV200-Datasheet.txt` line 39693).";

        enum PT_INT_height_err_enum {
            NO_INTERRUPT_GENERATED = 0 { name = "No Interrupt Generated"; desc = "No interrupt is generated."; };
            INTERRUPT_GENERATED = 1 { name = "Interrupt Generated"; desc = "An interrupt is generated."; };
        };

        field {
            name = "height_err";
            desc = "Status of the image height change interrupt. Writing 1 clears the interrupt.";
            sw = rw;
            hw = w;
            onwrite = woclr;
            encode = PT_INT_height_err_enum;
            reset = 0x0;
        } height_err[2:2];

        enum PT_INT_width_err_enum {
            NO_INTERRUPT_GENERATED = 0 { name = "No Interrupt Generated"; desc = "No interrupt is generated."; };
            INTERRUPT_GENERATED = 1 { name = "Interrupt Generated"; desc = "An interrupt is generated."; };
        };

        field {
            name = "width_err";
            desc = "Status of the image width change interrupt. Writing 1 clears the interrupt.";
            sw = rw;
            hw = w;
            onwrite = woclr;
            encode = PT_INT_width_err_enum;
            reset = 0x0;
        } width_err[1:1];

        enum PT_INT_fstart_enum {
            NO_INTERRUPT_GENERATED = 0 { name = "No Interrupt Generated"; desc = "No interrupt is generated."; };
            INTERRUPT_GENERATED = 1 { name = "Interrupt Generated"; desc = "An interrupt is generated."; };
        };

        field {
            name = "fstart";
            desc = "Status of the frame start interrupt. Writing 1 clears the interrupt.";
            sw = rw;
            hw = w;
            onwrite = woclr;
            encode = PT_INT_fstart_enum;
            reset = 0x0;
        } fstart[0:0];
    } PT_INT @ 0x1F0;

    reg {
        name = "Port interrupt mask register";
        desc = "PT_INT_MASK is a port interrupt mask register. Hi3516A V200 Professional HD IP Camera SoC

Data sheet 9.1.6 PT_INT_MASK (offset 0x1F8, printed page 9-43, `hi3516av200--Hi3516AV200-Datasheet.txt` line 39737).";

        enum PT_INT_MASK_height_err_enum {
            MASKED = 0 { name = "Masked"; desc = "masked"; };
            ENABLED = 1 { name = "Enabled"; desc = "enabled"; };
        };

        field {
            name = "height_err";
            desc = "Image height change interrupt enable";
            sw = rw;
            hw = r;
            encode = PT_INT_MASK_height_err_enum;
            reset = 0x0;
        } height_err[2:2];

        enum PT_INT_MASK_width_err_enum {
            MASKED = 0 { name = "Masked"; desc = "masked"; };
            ENABLED = 1 { name = "Enabled"; desc = "enabled"; };
        };

        field {
            name = "width_err";
            desc = "Image width change interrupt enable";
            sw = rw;
            hw = r;
            encode = PT_INT_MASK_width_err_enum;
            reset = 0x0;
        } width_err[1:1];

        enum PT_INT_MASK_fstart_enum {
            MASKED = 0 { name = "Masked"; desc = "masked"; };
            ENABLED = 1 { name = "Enabled"; desc = "enabled"; };
        };

        field {
            name = "fstart";
            desc = "Frame start interrupt enable";
            sw = rw;
            hw = r;
            encode = PT_INT_MASK_fstart_enum;
            reset = 0x0;
        } fstart[0:0];
    } PT_INT_MASK @ 0x1F8;

    reg {
        name = "DES_CTRL";
        desc = "DES_CTRL is a DES (RAW data write) control register.

Data sheet 9.1.6 DES_CTRL (offset 0x200, printed page 9-43, `hi3516av200--Hi3516AV200-Datasheet.txt` line 39770).";

        enum DES_CTRL_enable_f_enum {
            DISABLED = 0 { name = "Disabled"; desc = "disabled"; };
            ENABLED_0X0200_0X02FF = 1 { name = "Enabled 0X0200 0X02Ff"; desc = "enabled 0x0200-0x02FF: address space of the DES0 register 0x0300-0x03FF: address space of the DES1 register 0x0400-0x04FF: address space of the DES2 register (only vicap0)"; };
        };

        field {
            name = "enable";
            desc = "DES enable";
            sw = rw;
            hw = r;
            encode = DES_CTRL_enable_f_enum;
            reset = 0x0;
        } enable_f[31:31];

        enum DES_CTRL_bit_width_enum {
            V_8_BITS = 0x8 { name = "V 8 Bits"; desc = "8 bits"; };
            V_10_BITS = 0xA { name = "V 10 Bits"; desc = "10 bits"; };
            V_12_BITS = 0xC { name = "V 12 Bits"; desc = "12 bits"; };
            V_14_BITS = 0xE { name = "V 14 Bits"; desc = "14 bits"; };
            V_16_BITS_OTHER = 0x10 { name = "V 16 Bits Other"; desc = "16 bits Other values: reserved"; };
        };

        field {
            name = "bit_width";
            desc = "Width of the data written by the DES";
            sw = rw;
            hw = r;
            encode = DES_CTRL_bit_width_enum;
            reset = 0x0;
        } bit_width[5:0];
    } DES_CTRL @ 0x200;

    reg {
        name = "DES_INT";
        desc = "DES_INT is a DES (RAW data write) raw interrupt register.

Data sheet 9.1.6 DES_INT (offset 0x2F0, printed page 9-44, `hi3516av200--Hi3516AV200-Datasheet.txt` line 39815).";

        enum DES_INT_update_cfg_enum {
            NO_INTERRUPT_GENERATED = 0 { name = "No Interrupt Generated"; desc = "No interrupt is generated."; };
            INTERRUPT_GENERATED = 1 { name = "Interrupt Generated"; desc = "An interrupt is generated."; };
        };

        field {
            name = "update_cfg";
            desc = "Status of the register update interrupt. Writing 1 clears the interrupt.";
            sw = rw;
            hw = w;
            onwrite = woclr;
            encode = DES_INT_update_cfg_enum;
            reset = 0x0;
        } update_cfg[4:4];

        enum DES_INT_field_throw_enum {
            NO_INTERRUPT_GENERATED = 0 { name = "No Interrupt Generated"; desc = "No interrupt is generated."; };
            INTERRUPT_GENERATED = 1 { name = "Interrupt Generated"; desc = "An interrupt is generated."; };
        };

        field {
            name = "field_throw";
            desc = "Status of the frame loss interrupt. Writing 1 clears the interrupt.";
            sw = rw;
            hw = w;
            onwrite = woclr;
            encode = DES_INT_field_throw_enum;
            reset = 0x0;
        } field_throw[3:3];

        enum DES_INT_buf_ovf_enum {
            NO_INTERRUPT_GENERATED = 0 { name = "No Interrupt Generated"; desc = "No interrupt is generated."; };
            INTERRUPT_GENERATED = 1 { name = "Interrupt Generated"; desc = "An interrupt is generated."; };
        };

        field {
            name = "buf_ovf";
            desc = "Status of the internal FIFO overflow error interrupt. Writing 1 clears the interrupt.";
            sw = rw;
            hw = w;
            onwrite = woclr;
            encode = DES_INT_buf_ovf_enum;
            reset = 0x0;
        } buf_ovf[2:2];

        enum DES_INT_cc_int_enum {
            NO_INTERRUPT_GENERATED = 0 { name = "No Interrupt Generated"; desc = "No interrupt is generated."; };
            INTERRUPT_GENERATED = 1 { name = "Interrupt Generated"; desc = "An interrupt is generated."; };
        };

        field {
            name = "cc_int";
            desc = "Status of the capture completion interrupt. Writing 1 clears the interrupt.";
            sw = rw;
            hw = w;
            onwrite = woclr;
            encode = DES_INT_cc_int_enum;
            reset = 0x0;
        } cc_int[1:1];

        enum DES_INT_fstart_enum {
            NO_INTERRUPT_GENERATED = 0 { name = "No Interrupt Generated"; desc = "No interrupt is generated."; };
            INTERRUPT_GENERATED = 1 { name = "Interrupt Generated"; desc = "An interrupt is generated."; };
        };

        field {
            name = "fstart";
            desc = "Status of the frame start interrupt. Writing 1 clears the interrupt.";
            sw = rw;
            hw = w;
            onwrite = woclr;
            encode = DES_INT_fstart_enum;
            reset = 0x0;
        } fstart[0:0];
    } DES_INT @ 0x2F0;

    reg {
        name = "DES_MASK";
        desc = "DES_MASK is a DES (RAW data write) interrupt mask register.

Data sheet 9.1.6 DES_MASK (offset 0x2F8, printed page 9-45, `hi3516av200--Hi3516AV200-Datasheet.txt` line 39871).";

        enum DES_MASK_update_cfg_enum {
            MASKED = 0 { name = "Masked"; desc = "masked"; };
            ENABLED = 1 { name = "Enabled"; desc = "enabled"; };
        };

        field {
            name = "update_cfg";
            desc = "Register update interrupt enable";
            sw = rw;
            hw = r;
            encode = DES_MASK_update_cfg_enum;
            reset = 0x0;
        } update_cfg[4:4];

        enum DES_MASK_field_throw_enum {
            MASKED = 0 { name = "Masked"; desc = "masked"; };
            ENABLED = 1 { name = "Enabled"; desc = "enabled"; };
        };

        field {
            name = "field_throw";
            desc = "Frame loss interrupt enable";
            sw = rw;
            hw = r;
            encode = DES_MASK_field_throw_enum;
            reset = 0x0;
        } field_throw[3:3];

        enum DES_MASK_buf_ovf_enum {
            MASKED = 0 { name = "Masked"; desc = "masked"; };
            ENABLED = 1 { name = "Enabled"; desc = "enabled"; };
        };

        field {
            name = "buf_ovf";
            desc = "Internal FIFO overflow error interrupt enable";
            sw = rw;
            hw = r;
            encode = DES_MASK_buf_ovf_enum;
            reset = 0x0;
        } buf_ovf[2:2];

        enum DES_MASK_cc_int_enum {
            MASKED = 0 { name = "Masked"; desc = "masked"; };
            ENABLED = 1 { name = "Enabled"; desc = "enabled"; };
        };

        field {
            name = "cc_int";
            desc = "Capture completion interrupt enable";
            sw = rw;
            hw = r;
            encode = DES_MASK_cc_int_enum;
            reset = 0x0;
        } cc_int[1:1];

        enum DES_MASK_fstart_enum {
            MASKED = 0 { name = "Masked"; desc = "masked"; };
            ENABLED = 1 { name = "Enabled"; desc = "enabled"; };
        };

        field {
            name = "fstart";
            desc = "Frame start interrupt enable";
            sw = rw;
            hw = r;
            encode = DES_MASK_fstart_enum;
            reset = 0x0;
        } fstart[0:0];
    } DES_MASK @ 0x2F8;

    reg {
        name = "SRC_CTRL";
        desc = "SRC_CTRL is an SRC (RAW data read) control register. Hi3516A V200 Professional HD IP Camera SoC

Data sheet 9.1.6 SRC_CTRL (offset 0x600, printed page 9-46, `hi3516av200--Hi3516AV200-Datasheet.txt` line 39921).";

        enum SRC_CTRL_enable_f_enum {
            DISABLED = 0 { name = "Disabled"; desc = "disabled"; };
            ENABLED_0X600_0X6FF = 1 { name = "Enabled 0X600 0X6Ff"; desc = "enabled 0x600-0x6FF: address space of the SRC0 register 0x700-0x7FF: address space of the SRC1 register (valid only for VICAP0) 0x800-0x8FF: address space of the SRC2 register (valid only for VICAP0) 0x900-0x9FF: address space of the SRC3 register"; };
        };

        field {
            name = "enable";
            desc = "SRC enable";
            sw = rw;
            hw = r;
            encode = SRC_CTRL_enable_f_enum;
            reset = 0x0;
        } enable_f[31:31];

        enum SRC_CTRL_bit_width_enum {
            V_8_BITS = 0x8 { name = "V 8 Bits"; desc = "8 bits"; };
            V_10_BITS = 0xA { name = "V 10 Bits"; desc = "10 bits"; };
            V_12_BITS = 0xC { name = "V 12 Bits"; desc = "12 bits"; };
            V_14_BITS = 0xE { name = "V 14 Bits"; desc = "14 bits"; };
            V_16_BITS_OTHER = 0x10 { name = "V 16 Bits Other"; desc = "16 bits Other values: reserved"; };
        };

        field {
            name = "bit_width";
            desc = "SRC read data bit width";
            sw = rw;
            hw = r;
            encode = SRC_CTRL_bit_width_enum;
            reset = 0x0;
        } bit_width[5:0];
    } SRC_CTRL @ 0x600;

    reg {
        name = "SRC_INT";
        desc = "SRC_INT is an SRC (RAW data read) raw interrupt register. Hi3516A V200 Professional HD IP Camera SoC

Data sheet 9.1.6 SRC_INT (offset 0x6F0, printed page 9-47, `hi3516av200--Hi3516AV200-Datasheet.txt` line 39967).";

        enum SRC_INT_dcmp_wrong_enum {
            NO_INTERRUPT_GENERATED = 0 { name = "No Interrupt Generated"; desc = "No interrupt is generated."; };
            INTERRUPT_GENERATED = 1 { name = "Interrupt Generated"; desc = "An interrupt is generated."; };
        };

        field {
            name = "dcmp_wrong";
            desc = "Status of the decompress error interrupt. Writing 1 clears the interrupt.";
            sw = rw;
            hw = w;
            onwrite = woclr;
            encode = SRC_INT_dcmp_wrong_enum;
            reset = 0x0;
        } dcmp_wrong[5:5];

        enum SRC_INT_update_cfg_enum {
            NO_INTERRUPT_GENERATED = 0 { name = "No Interrupt Generated"; desc = "No interrupt is generated."; };
            INTERRUPT_GENERATED = 1 { name = "Interrupt Generated"; desc = "An interrupt is generated."; };
        };

        field {
            name = "update_cfg";
            desc = "Status of the register update interrupt. Writing 1 clears the interrupt.";
            sw = rw;
            hw = w;
            onwrite = woclr;
            encode = SRC_INT_update_cfg_enum;
            reset = 0x0;
        } update_cfg[4:4];

        enum SRC_INT_field_throw_enum {
            NO_INTERRUPT_GENERATED = 0 { name = "No Interrupt Generated"; desc = "No interrupt is generated."; };
            INTERRUPT_GENERATED = 1 { name = "Interrupt Generated"; desc = "An interrupt is generated."; };
        };

        field {
            name = "field_throw";
            desc = "Status of the frame loss interrupt. Writing 1 clears the interrupt.";
            sw = rw;
            hw = w;
            onwrite = woclr;
            encode = SRC_INT_field_throw_enum;
            reset = 0x0;
        } field_throw[3:3];

        enum SRC_INT_buf_ovf_enum {
            NO_INTERRUPT_GENERATED = 0 { name = "No Interrupt Generated"; desc = "No interrupt is generated."; };
            INTERRUPT_GENERATED = 1 { name = "Interrupt Generated"; desc = "An interrupt is generated."; };
        };

        field {
            name = "buf_ovf";
            desc = "Status of the internal FIFO overflow error interrupt. Writing 1 clears the interrupt.";
            sw = rw;
            hw = w;
            onwrite = woclr;
            encode = SRC_INT_buf_ovf_enum;
            reset = 0x0;
        } buf_ovf[2:2];

        enum SRC_INT_cc_int_enum {
            NO_INTERRUPT_GENERATED = 0 { name = "No Interrupt Generated"; desc = "No interrupt is generated."; };
            INTERRUPT_GENERATED = 1 { name = "Interrupt Generated"; desc = "An interrupt is generated."; };
        };

        field {
            name = "cc_int";
            desc = "Status of the capture completion interrupt. Writing 1 clears the interrupt.";
            sw = rw;
            hw = w;
            onwrite = woclr;
            encode = SRC_INT_cc_int_enum;
            reset = 0x0;
        } cc_int[1:1];

        enum SRC_INT_fstart_enum {
            NO_INTERRUPT_GENERATED = 0 { name = "No Interrupt Generated"; desc = "No interrupt is generated."; };
            INTERRUPT_GENERATED = 1 { name = "Interrupt Generated"; desc = "An interrupt is generated."; };
        };

        field {
            name = "fstart";
            desc = "Status of the frame start interrupt. Writing 1 clears the interrupt.";
            sw = rw;
            hw = w;
            onwrite = woclr;
            encode = SRC_INT_fstart_enum;
            reset = 0x0;
        } fstart[0:0];
    } SRC_INT @ 0x6F0;

    reg {
        name = "SRC_MASK";
        desc = "SRC_MASK is an SRC (RAW data read) interrupt mask register. Hi3516A V200 Professional HD IP Camera SoC

Data sheet 9.1.6 SRC_MASK (offset 0x6F8, printed page 9-48, `hi3516av200--Hi3516AV200-Datasheet.txt` line 40027).";

        enum SRC_MASK_dcmp_wrong_enum {
            MASKED = 0 { name = "Masked"; desc = "masked"; };
            ENABLED = 1 { name = "Enabled"; desc = "enabled"; };
        };

        field {
            name = "dcmp_wrong";
            desc = "Decompress error interrupt enable";
            sw = rw;
            hw = r;
            encode = SRC_MASK_dcmp_wrong_enum;
            reset = 0x0;
        } dcmp_wrong[5:5];

        enum SRC_MASK_update_cfg_enum {
            MASKED = 0 { name = "Masked"; desc = "masked"; };
            ENABLED = 1 { name = "Enabled"; desc = "enabled"; };
        };

        field {
            name = "update_cfg";
            desc = "Register update interrupt enable";
            sw = rw;
            hw = r;
            encode = SRC_MASK_update_cfg_enum;
            reset = 0x0;
        } update_cfg[4:4];

        enum SRC_MASK_field_throw_enum {
            MASKED = 0 { name = "Masked"; desc = "masked"; };
            ENABLED = 1 { name = "Enabled"; desc = "enabled"; };
        };

        field {
            name = "field_throw";
            desc = "Frame loss interrupt enable";
            sw = rw;
            hw = r;
            encode = SRC_MASK_field_throw_enum;
            reset = 0x0;
        } field_throw[3:3];

        enum SRC_MASK_buf_ovf_enum {
            MASKED = 0 { name = "Masked"; desc = "masked"; };
            ENABLED = 1 { name = "Enabled"; desc = "enabled"; };
        };

        field {
            name = "buf_ovf";
            desc = "Internal FIFO overflow error interrupt enable";
            sw = rw;
            hw = r;
            encode = SRC_MASK_buf_ovf_enum;
            reset = 0x0;
        } buf_ovf[2:2];

        enum SRC_MASK_cc_int_enum {
            MASKED = 0 { name = "Masked"; desc = "masked"; };
            ENABLED = 1 { name = "Enabled"; desc = "enabled"; };
        };

        field {
            name = "cc_int";
            desc = "Capture completion interrupt enable";
            sw = rw;
            hw = r;
            encode = SRC_MASK_cc_int_enum;
            reset = 0x0;
        } cc_int[1:1];

        enum SRC_MASK_fstart_enum {
            MASKED = 0 { name = "Masked"; desc = "masked"; };
            ENABLED = 1 { name = "Enabled"; desc = "enabled"; };
        };

        field {
            name = "fstart";
            desc = "Frame start interrupt enable";
            sw = rw;
            hw = r;
            encode = SRC_MASK_fstart_enum;
            reset = 0x0;
        } fstart[0:0];
    } SRC_MASK @ 0x6F8;

    reg {
        name = "Channel control register";
        desc = "CH_CTRL is a channel control register. Hi3516A V200 Professional HD IP Camera SoC

Data sheet 9.1.6 CH_CTRL (offset 0x1000, printed page 9-49, `hi3516av200--Hi3516AV200-Datasheet.txt` line 40079).";

        enum CH_CTRL_enable_f_enum {
            DISABLED = 0 { name = "Disabled"; desc = "disabled"; };
            ENABLED = 1 { name = "Enabled"; desc = "enabled"; };
        };

        field {
            name = "enable";
            desc = "Channel enable";
            sw = rw;
            hw = r;
            encode = CH_CTRL_enable_f_enum;
            reset = 0x0;
        } enable_f[31:31];

        enum CH_CTRL_mode_enum {
            NORMAL_MODE = 0 { name = "Normal Mode"; desc = "normal mode"; };
            SINGLE_COMPONENT_MODE = 1 { name = "Single Component Mode"; desc = "single-component (luminance) mode"; };
            SINGLE_COMPONENT_MODE_2 = 2 { name = "Single Component Mode 2"; desc = "single-component (chrominance) mode Other values: reserved"; };
        };

        field {
            name = "mode";
            desc = "Channel mode";
            sw = rw;
            hw = r;
            encode = CH_CTRL_mode_enum;
            reset = 0x0;
        } mode[1:0];
    } CH_CTRL @ 0x1000;

    reg {
        name = "Capture control register";
        desc = "CH_REG_NEWER is a capture control register.

Data sheet 9.1.6 CH_REG_NEWER (offset 0x1004, printed page 9-49, `hi3516av200--Hi3516AV200-Datasheet.txt` line 40108).";

        field {
            name = "reg_newer";
            desc = "Channel update. This bit is automatically cleared for each frame.";
            sw = rw;
            hw = r;
            reset = 0x0;
        } reg_newer[0:0];
    } CH_REG_NEWER @ 0x1004;

    reg {
        name = "Channel input image start interrupt delay configuration register";
        desc = "CH_DLY_CFG is a channel input image start interrupt delay configuration register. Hi3516A V200 Professional HD IP Camera SoC

Data sheet 9.1.6 CH_DLY_CFG (offset 0x1034, printed page 9-50, `hi3516av200--Hi3516AV200-Datasheet.txt` line 40142).";

        field {
            name = "v_dly_cfg";
            desc = "Number of delayed vertical lines";
            sw = rw;
            hw = r;
            reset = 0x10;
        } v_dly_cfg[31:16];
    } CH_DLY_CFG @ 0x1034;

    reg {
        name = "Y component configuration register for the WCH module";
        desc = "CH_WCH_Y_CFG is a Y component configuration register for the WCH module.

Data sheet 9.1.6 CH_WCH_Y_CFG (offset 0x1080, printed page 9-50, `hi3516av200--Hi3516AV200-Datasheet.txt` line 40161).";

        enum CH_WCH_Y_CFG_enable_f_enum {
            DISABLED = 0 { name = "Disabled"; desc = "disabled"; };
            ENABLED = 1 { name = "Enabled"; desc = "enabled"; };
        };

        field {
            name = "enable";
            desc = "CH write channel enable";
            sw = rw;
            hw = r;
            encode = CH_WCH_Y_CFG_enable_f_enum;
            reset = 0x0;
        } enable_f[31:31];

        enum CH_WCH_Y_CFG_bit_width_enum {
            V_8_BITS = 0 { name = "V 8 Bits"; desc = "8 bits"; };
            V_16_BITS_OTHER = 2 { name = "V 16 Bits Other"; desc = "16 bits Other values: reserved"; };
        };

        field {
            name = "bit_width";
            desc = "Data width";
            sw = rw;
            hw = r;
            encode = CH_WCH_Y_CFG_bit_width_enum;
            reset = 0x0;
        } bit_width[17:16];

        enum CH_WCH_Y_CFG_flip_enum {
            DISABLED = 0 { name = "Disabled"; desc = "disabled"; };
            ENABLED = 1 { name = "Enabled"; desc = "enabled"; };
        };

        field {
            name = "flip";
            desc = "Channel flip enable";
            sw = rw;
            hw = r;
            encode = CH_WCH_Y_CFG_flip_enum;
            reset = 0x0;
        } flip[4:4];

        enum CH_WCH_Y_CFG_mirror_enum {
            DISABLED = 0 { name = "Disabled"; desc = "disabled"; };
            ENABLED = 1 { name = "Enabled"; desc = "enabled"; };
        };

        field {
            name = "mirror";
            desc = "Channel mirror enable";
            sw = rw;
            hw = r;
            encode = CH_WCH_Y_CFG_mirror_enum;
            reset = 0x0;
        } mirror[3:3];

        enum CH_WCH_Y_CFG_head_tword_enum {
            V_128_BITS = 0 { name = "V 128 Bits"; desc = "128 bits (128 bits/line)"; };
            V_256_BITS = 1 { name = "V 256 Bits"; desc = "256 bits (256 bits/line)"; };
        };

        field {
            name = "head_tword";
            desc = "Header information stride";
            sw = rw;
            hw = r;
            encode = CH_WCH_Y_CFG_head_tword_enum;
            reset = 0x0;
        } head_tword[2:2];

        enum CH_WCH_Y_CFG_cmp_mode_enum {
            V_128_PIXELS = 0 { name = "V 128 Pixels"; desc = "128 pixels"; };
            V_256_PIXELS = 1 { name = "V 256 Pixels"; desc = "256 pixels"; };
        };

        field {
            name = "cmp_mode";
            desc = "Compressed segment length";
            sw = rw;
            hw = r;
            encode = CH_WCH_Y_CFG_cmp_mode_enum;
            reset = 0x1;
        } cmp_mode[1:1];

        enum CH_WCH_Y_CFG_cmp_en_enum {
            DISABLED = 0 { name = "Disabled"; desc = "disabled"; };
            ENABLED = 1 { name = "Enabled"; desc = "enabled"; };
        };

        field {
            name = "cmp_en";
            desc = "Compression enable";
            sw = rw;
            hw = r;
            encode = CH_WCH_Y_CFG_cmp_en_enum;
            reset = 0x0;
        } cmp_en[0:0];
    } CH_WCH_Y_CFG @ 0x1080;

    reg {
        name = "Y component storage size register for the WCH module";
        desc = "CH_WCH_Y_SIZE is a Y component storage size register for the WCH module.

Data sheet 9.1.6 CH_WCH_Y_SIZE (offset 0x1084, printed page 9-51, `hi3516av200--Hi3516AV200-Datasheet.txt` line 40219).";

        field {
            name = "height";
            desc = "Height (in line) of the stored image. The configured value is the actual value minus 1.";
            sw = rw;
            hw = r;
            reset = 0x0;
        } height[28:16];

        field {
            name = "width";
            desc = "Width (in pixel) of the stored image. The configured value is the actual value minus 1.";
            sw = rw;
            hw = r;
            reset = 0x0;
        } width[12:0];
    } CH_WCH_Y_SIZE @ 0x1084;

    reg {
        name = "Y component storage base address register for the WCH module";
        desc = "CH_WCH_Y_FADDR is a Y component storage base address register for the WCH module. Hi3516A V200 Professional HD IP Camera SoC

Data sheet 9.1.6 CH_WCH_Y_FADDR (offset 0x1090, printed page 9-52, `hi3516av200--Hi3516AV200-Datasheet.txt` line 40256).";

        field {
            name = "faddr";
            desc = "Base address for storing the Y component";
            sw = rw;
            hw = r;
            reset = 0x0;
        } faddr[31:0];
    } CH_WCH_Y_FADDR @ 0x1090;

    reg {
        name = "Y component header information storage base address register for the WCH module";
        desc = "CH_WCH_Y_HADDR is a Y component header information storage base address register for the WCH module.

Data sheet 9.1.6 CH_WCH_Y_HADDR (offset 0x1094, printed page 9-52, `hi3516av200--Hi3516AV200-Datasheet.txt` line 40275).";

        field {
            name = "haddr";
            desc = "Base address for storing the Y component header information";
            sw = rw;
            hw = r;
            reset = 0x0;
        } haddr[31:0];
    } CH_WCH_Y_HADDR @ 0x1094;

    reg {
        name = "Y component line offset register for the WCH module";
        desc = "CH_WCH_Y_STRIDE is a Y component line offset register for the WCH module.

Data sheet 9.1.6 CH_WCH_Y_STRIDE (offset 0x1098, printed page 9-52, `hi3516av200--Hi3516AV200-Datasheet.txt` line 40293).";

        field {
            name = "stride";
            desc = "Stride (in byte) for storing the Y component";
            sw = rw;
            hw = r;
            reset = 0x0;
        } stride[15:0];
    } CH_WCH_Y_STRIDE @ 0x1098;

    reg {
        name = "C component configuration register for the WCH module";
        desc = "CH_WCH_C_CFG is a C component configuration register for the WCH module.

Data sheet 9.1.6 CH_WCH_C_CFG (offset 0x10A0, printed page 9-53, `hi3516av200--Hi3516AV200-Datasheet.txt` line 40319).";

        enum CH_WCH_C_CFG_enable_f_enum {
            DISABLED = 0 { name = "Disabled"; desc = "disabled"; };
            ENABLED = 1 { name = "Enabled"; desc = "enabled"; };
        };

        field {
            name = "enable";
            desc = "CH write channel enable";
            sw = rw;
            hw = r;
            encode = CH_WCH_C_CFG_enable_f_enum;
            reset = 0x0;
        } enable_f[31:31];

        enum CH_WCH_C_CFG_bit_width_enum {
            V_8_BITS = 0 { name = "V 8 Bits"; desc = "8 bits"; };
            V_16_BITS_OTHER = 2 { name = "V 16 Bits Other"; desc = "16 bits Other values: reserved"; };
        };

        field {
            name = "bit_width";
            desc = "Data width";
            sw = rw;
            hw = r;
            encode = CH_WCH_C_CFG_bit_width_enum;
            reset = 0x0;
        } bit_width[17:16];

        enum CH_WCH_C_CFG_flip_enum {
            DISABLED = 0 { name = "Disabled"; desc = "disabled"; };
            ENABLED = 1 { name = "Enabled"; desc = "enabled"; };
        };

        field {
            name = "flip";
            desc = "Channel flip enable";
            sw = rw;
            hw = r;
            encode = CH_WCH_C_CFG_flip_enum;
            reset = 0x0;
        } flip[4:4];

        enum CH_WCH_C_CFG_mirror_enum {
            DISABLED = 0 { name = "Disabled"; desc = "disabled"; };
            ENABLED = 1 { name = "Enabled"; desc = "enabled"; };
        };

        field {
            name = "mirror";
            desc = "Channel mirror enable";
            sw = rw;
            hw = r;
            encode = CH_WCH_C_CFG_mirror_enum;
            reset = 0x0;
        } mirror[3:3];

        enum CH_WCH_C_CFG_head_tword_enum {
            V_128_BITS = 0 { name = "V 128 Bits"; desc = "128 bits (128 bits/line)"; };
            V_256_BITS = 1 { name = "V 256 Bits"; desc = "256 bits (256 bits/line)"; };
        };

        field {
            name = "head_tword";
            desc = "Header information stride";
            sw = rw;
            hw = r;
            encode = CH_WCH_C_CFG_head_tword_enum;
            reset = 0x0;
        } head_tword[2:2];

        enum CH_WCH_C_CFG_cmp_mode_enum {
            V_128_PIXELS = 0 { name = "V 128 Pixels"; desc = "128 pixels"; };
            V_256_PIXELS = 1 { name = "V 256 Pixels"; desc = "256 pixels"; };
        };

        field {
            name = "cmp_mode";
            desc = "Compressed segment length";
            sw = rw;
            hw = r;
            encode = CH_WCH_C_CFG_cmp_mode_enum;
            reset = 0x1;
        } cmp_mode[1:1];

        enum CH_WCH_C_CFG_cmp_en_enum {
            DISABLED = 0 { name = "Disabled"; desc = "disabled"; };
            ENABLED = 1 { name = "Enabled"; desc = "enabled"; };
        };

        field {
            name = "cmp_en";
            desc = "Compression enable";
            sw = rw;
            hw = r;
            encode = CH_WCH_C_CFG_cmp_en_enum;
            reset = 0x0;
        } cmp_en[0:0];
    } CH_WCH_C_CFG @ 0x10A0;

    reg {
        name = "C component storage size register for the WCH module";
        desc = "CH_WCH_C_SIZE is a C component storage size register for the WCH module.

Data sheet 9.1.6 CH_WCH_C_SIZE (offset 0x10A4, printed page 9-54, `hi3516av200--Hi3516AV200-Datasheet.txt` line 40372).";

        field {
            name = "height";
            desc = "Height (in line) of the stored image. The configured value is the actual value minus 1.";
            sw = rw;
            hw = r;
            reset = 0x0;
        } height[28:16];

        field {
            name = "width";
            desc = "Width (in pixel) of the stored image. The configured value is the actual value minus 1.";
            sw = rw;
            hw = r;
            reset = 0x0;
        } width[12:0];
    } CH_WCH_C_SIZE @ 0x10A4;

    reg {
        name = "C component storage base address register for the WCH module";
        desc = "CH_WCH_C_FADDR is a C component storage base address register for the WCH module.

Data sheet 9.1.6 CH_WCH_C_FADDR (offset 0x10B0, printed page 9-54, `hi3516av200--Hi3516AV200-Datasheet.txt` line 40400).";

        field {
            name = "faddr";
            desc = "Base address for storing the C component";
            sw = rw;
            hw = r;
            reset = 0x0;
        } faddr[31:0];
    } CH_WCH_C_FADDR @ 0x10B0;

    reg {
        name = "C component header information storage base address register for the WCH module";
        desc = "CH_WCH_C_HADDR is a C component header information storage base address register for the WCH module. Hi3516A V200 Professional HD IP Camera SoC

Data sheet 9.1.6 CH_WCH_C_HADDR (offset 0x10B4, printed page 9-55, `hi3516av200--Hi3516AV200-Datasheet.txt` line 40429).";

        field {
            name = "haddr";
            desc = "Base address for storing the C component header information";
            sw = rw;
            hw = r;
            reset = 0x0;
        } haddr[31:0];
    } CH_WCH_C_HADDR @ 0x10B4;

    reg {
        name = "C component line offset register for the WCH module";
        desc = "CH_WCH_C_STRIDE is a C component line offset register for the WCH module.

Data sheet 9.1.6 CH_WCH_C_STRIDE (offset 0x10B8, printed page 9-55, `hi3516av200--Hi3516AV200-Datasheet.txt` line 40447).";

        field {
            name = "stride";
            desc = "Stride (in byte) for storing the C component";
            sw = rw;
            hw = r;
            reset = 0x0;
        } stride[15:0];
    } CH_WCH_C_STRIDE @ 0x10B8;

    reg {
        name = "Channel luminance image output picture size indicator register";
        desc = "CH_Y_OUT_SIZE is a channel luminance image output picture size indicator register.

Data sheet 9.1.6 CH_Y_OUT_SIZE (offset 0x10E8, printed page 9-55, `hi3516av200--Hi3516AV200-Datasheet.txt` line 40467).";

        field {
            name = "height";
            desc = "Image height";
            sw = r;
            hw = w;
            reset = 0x0;
        } height[31:16];

        field {
            name = "width";
            desc = "Image width";
            sw = r;
            hw = w;
            reset = 0x0;
        } width[15:0];
    } CH_Y_OUT_SIZE @ 0x10E8;

    reg {
        name = "Channel chrominance image output picture size indicator register";
        desc = "CH_C_OUT_SIZE is a channel chrominance image output picture size indicator register.

Data sheet 9.1.6 CH_C_OUT_SIZE (offset 0x10EC, printed page 9-56, `hi3516av200--Hi3516AV200-Datasheet.txt` line 40492).";

        field {
            name = "height";
            desc = "Image height";
            sw = r;
            hw = w;
            reset = 0x0;
        } height[31:16];

        field {
            name = "width";
            desc = "Image width";
            sw = r;
            hw = w;
            reset = 0x0;
        } width[15:0];
    } CH_C_OUT_SIZE @ 0x10EC;

    reg {
        name = "Channel raw interrupt register";
        desc = "CH_INT is a channel raw interrupt register.

Data sheet 9.1.6 CH_INT (offset 0x10F0, printed page 9-56, `hi3516av200--Hi3516AV200-Datasheet.txt` line 40512).";

        enum CH_INT_fstart_dly_enum {
            NO_INTERRUPT_GENERATED = 0 { name = "No Interrupt Generated"; desc = "No interrupt is generated."; };
            INTERRUPT_GENERATED = 1 { name = "Interrupt Generated"; desc = "An interrupt is generated."; };
        };

        field {
            name = "fstart_dly";
            desc = "Status of the delayed frame start interrupt. Writing 1 clears the interrupt.";
            sw = rw;
            hw = w;
            onwrite = woclr;
            encode = CH_INT_fstart_dly_enum;
            reset = 0x0;
        } fstart_dly[15:15];

        enum CH_INT_update_cfg_enum {
            NO_INTERRUPT_GENERATED = 0 { name = "No Interrupt Generated"; desc = "No interrupt is generated."; };
            INTERRUPT_GENERATED = 1 { name = "Interrupt Generated"; desc = "An interrupt is generated."; };
        };

        field {
            name = "update_cfg";
            desc = "Status of the register update interrupt. Writing 1 clears the interrupt.";
            sw = rw;
            hw = w;
            onwrite = woclr;
            encode = CH_INT_update_cfg_enum;
            reset = 0x0;
        } update_cfg[4:4];

        enum CH_INT_field_throw_enum {
            NO_INTERRUPT_GENERATED = 0 { name = "No Interrupt Generated"; desc = "No interrupt is generated."; };
            INTERRUPT_GENERATED = 1 { name = "Interrupt Generated"; desc = "An interrupt is generated."; };
        };

        field {
            name = "field_throw";
            desc = "Status of the frame loss interrupt. Writing 1 clears the interrupt.";
            sw = rw;
            hw = w;
            onwrite = woclr;
            encode = CH_INT_field_throw_enum;
            reset = 0x0;
        } field_throw[3:3];

        enum CH_INT_buf_ovf_enum {
            NO_INTERRUPT_GENERATED = 0 { name = "No Interrupt Generated"; desc = "No interrupt is generated."; };
            INTERRUPT_GENERATED = 1 { name = "Interrupt Generated"; desc = "An interrupt is generated."; };
        };

        field {
            name = "buf_ovf";
            desc = "Status of the internal FIFO overflow error interrupt. Writing 1 clears the interrupt.";
            sw = rw;
            hw = w;
            onwrite = woclr;
            encode = CH_INT_buf_ovf_enum;
            reset = 0x0;
        } buf_ovf[2:2];

        enum CH_INT_cc_int_enum {
            NO_INTERRUPT_GENERATED = 0 { name = "No Interrupt Generated"; desc = "No interrupt is generated."; };
            INTERRUPT_GENERATED = 1 { name = "Interrupt Generated"; desc = "An interrupt is generated."; };
        };

        field {
            name = "cc_int";
            desc = "Status of the capture completion interrupt. Writing 1 clears the interrupt.";
            sw = rw;
            hw = w;
            onwrite = woclr;
            encode = CH_INT_cc_int_enum;
            reset = 0x0;
        } cc_int[1:1];

        enum CH_INT_fstart_enum {
            NO_INTERRUPT_GENERATED = 0 { name = "No Interrupt Generated"; desc = "No interrupt is generated."; };
            INTERRUPT_GENERATED = 1 { name = "Interrupt Generated"; desc = "An interrupt is generated."; };
        };

        field {
            name = "fstart";
            desc = "Status of the frame start interrupt. Writing 1 clears the interrupt.";
            sw = rw;
            hw = w;
            onwrite = woclr;
            encode = CH_INT_fstart_enum;
            reset = 0x0;
        } fstart[0:0];
    } CH_INT @ 0x10F0;

    reg {
        name = "Channel interrupt mask register";
        desc = "CH_INT_MASK is a channel interrupt mask register.

Data sheet 9.1.6 CH_INT_MASK (offset 0x10F8, printed page 9-57, `hi3516av200--Hi3516AV200-Datasheet.txt` line 40576).";

        enum CH_INT_MASK_fstart_dly_enum {
            MASKED = 0 { name = "Masked"; desc = "masked"; };
            ENABLED = 1 { name = "Enabled"; desc = "enabled"; };
        };

        field {
            name = "fstart_dly";
            desc = "Delayed frame start interrupt enable";
            sw = rw;
            hw = r;
            encode = CH_INT_MASK_fstart_dly_enum;
            reset = 0x0;
        } fstart_dly[15:15];

        enum CH_INT_MASK_update_cfg_enum {
            MASKED = 0 { name = "Masked"; desc = "masked"; };
            ENABLED = 1 { name = "Enabled"; desc = "enabled"; };
        };

        field {
            name = "update_cfg";
            desc = "Register update interrupt enable";
            sw = rw;
            hw = r;
            encode = CH_INT_MASK_update_cfg_enum;
            reset = 0x0;
        } update_cfg[4:4];

        enum CH_INT_MASK_field_throw_enum {
            MASKED = 0 { name = "Masked"; desc = "masked"; };
            ENABLED = 1 { name = "Enabled"; desc = "enabled"; };
        };

        field {
            name = "field_throw";
            desc = "Frame loss interrupt enable";
            sw = rw;
            hw = r;
            encode = CH_INT_MASK_field_throw_enum;
            reset = 0x0;
        } field_throw[3:3];

        enum CH_INT_MASK_buf_ovf_enum {
            MASKED = 0 { name = "Masked"; desc = "masked"; };
            ENABLED = 1 { name = "Enabled"; desc = "enabled"; };
        };

        field {
            name = "buf_ovf";
            desc = "Internal FIFO overflow error interrupt enable";
            sw = rw;
            hw = r;
            encode = CH_INT_MASK_buf_ovf_enum;
            reset = 0x0;
        } buf_ovf[2:2];

        enum CH_INT_MASK_cc_int_enum {
            MASKED = 0 { name = "Masked"; desc = "masked"; };
            ENABLED = 1 { name = "Enabled"; desc = "enabled"; };
        };

        field {
            name = "cc_int";
            desc = "Capture completion interrupt enable";
            sw = rw;
            hw = r;
            encode = CH_INT_MASK_cc_int_enum;
            reset = 0x0;
        } cc_int[1:1];

        enum CH_INT_MASK_fstart_enum {
            MASKED = 0 { name = "Masked"; desc = "masked"; };
            ENABLED = 1 { name = "Enabled"; desc = "enabled"; };
        };

        field {
            name = "fstart";
            desc = "Frame start interrupt enable";
            sw = rw;
            hw = r;
            encode = CH_INT_MASK_fstart_enum;
            reset = 0x0;
        } fstart[0:0];
    } CH_INT_MASK @ 0x10F8;

    reg {
        name = "Channel luminance crop enable register";
        desc = "CH_Y_CROP_CFG is a channel luminance crop enable register.

Data sheet 9.1.6 CH_Y_CROP_CFG (offset 0x1100, printed page 9-58, `hi3516av200--Hi3516AV200-Datasheet.txt` line 40631).";

        enum CH_Y_CROP_CFG_n0_en_enum {
            DISABLED = 0 { name = "Disabled"; desc = "disabled"; };
            ENABLED = 1 { name = "Enabled"; desc = "enabled"; };
        };

        field {
            name = "n0_en";
            desc = "CROP enable";
            sw = rw;
            hw = r;
            encode = CH_Y_CROP_CFG_n0_en_enum;
            reset = 0x0;
        } n0_en[0:0];
    } CH_Y_CROP_CFG @ 0x1100;

    reg {
        name = "Crop start position register for channel luminance";
        desc = "CH_Y_CROP0_START is a crop start position register for channel luminance. Hi3516A V200 Professional HD IP Camera SoC

Data sheet 9.1.6 CH_Y_CROP0_START (offset 0x1110, printed page 9-59, `hi3516av200--Hi3516AV200-Datasheet.txt` line 40665).";

        field {
            name = "y_start";
            desc = "ID of the line from which the image starts to be captured";
            sw = rw;
            hw = r;
            reset = 0x0;
        } y_start[28:16];

        field {
            name = "x_start";
            desc = "ID of the pixel from which the image starts to be captured";
            sw = rw;
            hw = r;
            reset = 0x0;
        } x_start[12:0];
    } CH_Y_CROP0_START @ 0x1110;

    reg {
        name = "Crop size register for channel luminance";
        desc = "CH_Y_CROP0_SIZE is a crop size register for channel luminance.

Data sheet 9.1.6 CH_Y_CROP0_SIZE (offset 0x1114, printed page 9-59, `hi3516av200--Hi3516AV200-Datasheet.txt` line 40691).";

        field {
            name = "height";
            desc = "Height (in line) of the obtained image. The configured value is the actual value minus 1.";
            sw = rw;
            hw = r;
            reset = 0x0;
        } height[28:16];

        field {
            name = "width";
            desc = "Width (in pixel) of the obtained image. The configured value is the actual value minus 1.";
            sw = rw;
            hw = r;
            reset = 0x0;
        } width[12:0];
    } CH_Y_CROP0_SIZE @ 0x1114;

    reg {
        name = "Channel chrominance crop enable register";
        desc = "CH_C_CROP_CFG is a channel chrominance crop enable register. Hi3516A V200 Professional HD IP Camera SoC

Data sheet 9.1.6 CH_C_CROP_CFG (offset 0x1120, printed page 9-60, `hi3516av200--Hi3516AV200-Datasheet.txt` line 40729).";

        enum CH_C_CROP_CFG_n0_en_enum {
            DISABLED = 0 { name = "Disabled"; desc = "disabled"; };
            ENABLED = 1 { name = "Enabled"; desc = "enabled"; };
        };

        field {
            name = "n0_en";
            desc = "CROP enable";
            sw = rw;
            hw = r;
            encode = CH_C_CROP_CFG_n0_en_enum;
            reset = 0x0;
        } n0_en[0:0];
    } CH_C_CROP_CFG @ 0x1120;

    reg {
        name = "Crop start position register for channel chrominance";
        desc = "CH_C_CROP0_START is a crop start position register for channel chrominance.

Data sheet 9.1.6 CH_C_CROP0_START (offset 0x1130, printed page 9-60, `hi3516av200--Hi3516AV200-Datasheet.txt` line 40752).";

        field {
            name = "y_start";
            desc = "ID of the line from which the image starts to be captured";
            sw = rw;
            hw = r;
            reset = 0x0;
        } y_start[28:16];

        field {
            name = "x_start";
            desc = "ID of the pixel from which the image starts to be captured";
            sw = rw;
            hw = r;
            reset = 0x0;
        } x_start[12:0];
    } CH_C_CROP0_START @ 0x1130;

    reg {
        name = "Crop size register for channel chrominance";
        desc = "CH_C_CROP0_SIZE is a crop size register for channel chrominance. Hi3516A V200 Professional HD IP Camera SoC

Data sheet 9.1.6 CH_C_CROP0_SIZE (offset 0x1134, printed page 9-61, `hi3516av200--Hi3516AV200-Datasheet.txt` line 40788).";

        field {
            name = "height";
            desc = "Height (in line) of the obtained image. The configured value is the actual value minus 1.";
            sw = rw;
            hw = r;
            reset = 0x0;
        } height[28:16];

        field {
            name = "width";
            desc = "Width (in pixel) of the obtained image. The configured value is the actual value minus 1.";
            sw = rw;
            hw = r;
            reset = 0x0;
        } width[12:0];
    } CH_C_CROP0_SIZE @ 0x1134;

    reg {
        name = "BayerSCL control register";
        desc = "ISP_BAS_CFG is a BayerSCL control register. Only VICAP1 supports this register.

Data sheet 9.1.6 ISP_BAS_CFG (offset 0x2A00, printed page 9-61, `hi3516av200--Hi3516AV200-Datasheet.txt` line 40821).";

        enum ISP_BAS_CFG_dsl_6taps_en_enum {
            DISABLED = 0 { name = "Disabled"; desc = "disabled"; };
            ENABLED = 1 { name = "Enabled"; desc = "enabled"; };
        };

        field {
            name = "dsl_6taps_en";
            desc = "Downscale vertical 6-tap enable";
            sw = rw;
            hw = r;
            encode = ISP_BAS_CFG_dsl_6taps_en_enum;
            reset = 0x0;
        } dsl_6taps_en[15:15];

        enum ISP_BAS_CFG_dsl_4taps_en_enum {
            DISABLED = 0 { name = "Disabled"; desc = "disabled"; };
            ENABLED = 1 { name = "Enabled"; desc = "enabled"; };
        };

        field {
            name = "dsl_4taps_en";
            desc = "Downscale vertical 4-tap enable";
            sw = rw;
            hw = r;
            encode = ISP_BAS_CFG_dsl_4taps_en_enum;
            reset = 0x0;
        } dsl_4taps_en[14:14];

        enum ISP_BAS_CFG_dsl_2taps_en_enum {
            DISABLED = 0 { name = "Disabled"; desc = "disabled"; };
            ENABLED = 1 { name = "Enabled"; desc = "enabled"; };
        };

        field {
            name = "dsl_2taps_en";
            desc = "Downscale vertical 2-tap enable";
            sw = rw;
            hw = r;
            encode = ISP_BAS_CFG_dsl_2taps_en_enum;
            reset = 0x0;
        } dsl_2taps_en[13:13];

        enum ISP_BAS_CFG_dsl_reuse_en_enum {
            DISABLED = 0 { name = "Disabled"; desc = "disabled"; };
            ENABLED = 1 { name = "Enabled"; desc = "enabled"; };
        };

        field {
            name = "dsl_reuse_en";
            desc = "Downscale lineniff multiplexing enable";
            sw = rw;
            hw = r;
            encode = ISP_BAS_CFG_dsl_reuse_en_enum;
            reset = 0x0;
        } dsl_reuse_en[12:12];

        enum ISP_BAS_CFG_dsl_en_v_enum {
            DISABLED = 0 { name = "Disabled"; desc = "disabled"; };
            ENABLED = 1 { name = "Enabled"; desc = "enabled"; };
        };

        field {
            name = "dsl_en_v";
            desc = "Downscale vertical sampling enable";
            sw = rw;
            hw = r;
            encode = ISP_BAS_CFG_dsl_en_v_enum;
            reset = 0x0;
        } dsl_en_v[10:10];

        enum ISP_BAS_CFG_dsl_en_h_enum {
            DISABLED = 0 { name = "Disabled"; desc = "disabled"; };
            ENABLED = 1 { name = "Enabled"; desc = "enabled"; };
        };

        field {
            name = "dsl_en_h";
            desc = "Downscale horizontal sampling enable";
            sw = rw;
            hw = r;
            encode = ISP_BAS_CFG_dsl_en_h_enum;
            reset = 0x0;
        } dsl_en_h[9:9];

        enum ISP_BAS_CFG_dsl_en_enum {
            DISABLED = 0 { name = "Disabled"; desc = "disabled"; };
            ENABLED = 1 { name = "Enabled"; desc = "enabled"; };
        };

        field {
            name = "dsl_en";
            desc = "Downscale enable";
            sw = rw;
            hw = r;
            encode = ISP_BAS_CFG_dsl_en_enum;
            reset = 0x0;
        } dsl_en[8:8];

        enum ISP_BAS_CFG_rph_en_v_enum {
            DISABLED = 0 { name = "Disabled"; desc = "disabled"; };
            ENABLED = 1 { name = "Enabled"; desc = "enabled"; };
        };

        field {
            name = "rph_en_v";
            desc = "Rephase vertical sampling enable";
            sw = rw;
            hw = r;
            encode = ISP_BAS_CFG_rph_en_v_enum;
            reset = 0x0;
        } rph_en_v[6:6];

        enum ISP_BAS_CFG_rph_en_h_enum {
            DISABLED = 0 { name = "Disabled"; desc = "disabled"; };
            ENABLED = 1 { name = "Enabled"; desc = "enabled"; };
        };

        field {
            name = "rph_en_h";
            desc = "Rephase horizontal sampling enable";
            sw = rw;
            hw = r;
            encode = ISP_BAS_CFG_rph_en_h_enum;
            reset = 0x0;
        } rph_en_h[5:5];

        enum ISP_BAS_CFG_rph_en_enum {
            DISABLED = 0 { name = "Disabled"; desc = "disabled"; };
            ENABLED = 1 { name = "Enabled"; desc = "enabled"; };
        };

        field {
            name = "rph_en";
            desc = "Rephase enable";
            sw = rw;
            hw = r;
            encode = ISP_BAS_CFG_rph_en_enum;
            reset = 0x0;
        } rph_en[4:4];

        enum ISP_BAS_CFG_bas_en_enum {
            DISABLED = 0 { name = "Disabled"; desc = "disabled"; };
            ENABLED = 1 { name = "Enabled"; desc = "enabled"; };
        };

        field {
            name = "bas_en";
            desc = "BayerSCL enable";
            sw = rw;
            hw = r;
            encode = ISP_BAS_CFG_bas_en_enum;
            reset = 0x0;
        } bas_en[0:0];
    } ISP_BAS_CFG @ 0x2A00;

    reg {
        name = "ISP_BAS_OUTSIZE";
        desc = "ISP_BAS_OUTSIZE.

Data sheet 9.1.6 ISP_BAS_OUTSIZE (offset 0x2A04, printed page 9-63, `hi3516av200--Hi3516AV200-Datasheet.txt` line 40905).";

        field {
            name = "bas_height_out";
            desc = "Output image height. The configured value is the actual value minus 1. The default height is 540.";
            sw = rw;
            hw = r;
            reset = 0x21B;
        } bas_height_out[28:16];

        field {
            name = "bas_width_out";
            desc = "Output image width. The configured value is the actual value minus 1. The default width is 960.";
            sw = rw;
            hw = r;
            reset = 0x3BF;
        } bas_width_out[12:0];
    } ISP_BAS_OUTSIZE @ 0x2A04;

    reg {
        name = "Pixel 0 coordinate register for horizontal down sampling of downscale";
        desc = "ISP_BAS_ACCH is a pixel 0 coordinate register for horizontal down sampling of downscale. Only VICAP1 supports this register.

Data sheet 9.1.6 ISP_BAS_ACCH (offset 0x2A10, printed page 9-63, `hi3516av200--Hi3516AV200-Datasheet.txt` line 40937).";

        field {
            name = "bas_acch";
            desc = "Coordinate of pixel 0 for downscale horizontal sampling";
            sw = rw;
            hw = r;
            reset = 0x0;
        } bas_acch[17:0];
    } ISP_BAS_ACCH @ 0x2A10;

    reg {
        name = "ISP_BAS_ACCV";
        desc = "ISP_BAS_ACCV.

Data sheet 9.1.6 ISP_BAS_ACCV (offset 0x2A14, printed page 9-64, `hi3516av200--Hi3516AV200-Datasheet.txt` line 40969).";

        field {
            name = "bas_accv";
            desc = "Coordinate of pixel 0 for downscale vertical sampling";
            sw = rw;
            hw = r;
            reset = 0x0;
        } bas_accv[17:0];
    } ISP_BAS_ACCV @ 0x2A14;

    reg {
        name = "Downscale horizontal down sampling step register";
        desc = "ISP_BAS_INCH is a downscale horizontal down sampling step register. Only VICAP1 supports this register.

Data sheet 9.1.6 ISP_BAS_INCH (offset 0x2A18, printed page 9-64, `hi3516av200--Hi3516AV200-Datasheet.txt` line 40992).";

        field {
            name = "bas_inch";
            desc = "Step of downscale horizontal sampling";
            sw = rw;
            hw = r;
            reset = 0x00080000;
        } bas_inch[20:0];
    } ISP_BAS_INCH @ 0x2A18;

    reg {
        name = "ISP_BAS_INCV";
        desc = "ISP_BAS_INCV.

Data sheet 9.1.6 ISP_BAS_INCV (offset 0x2A1C, printed page 9-65, `hi3516av200--Hi3516AV200-Datasheet.txt` line 41025).";

        field {
            name = "bas_incv";
            desc = "Step of downscale vertical sampling";
            sw = rw;
            hw = r;
            reset = 0x00080000;
        } bas_incv[20:0];
    } ISP_BAS_INCV @ 0x2A1C;

    reg {
        name = "Rephase horizontal sampling coefficient register";
        desc = "ISP_RPH_WEIH is a rephase horizontal sampling coefficient register. Only VICAP1 supports this register.

Data sheet 9.1.6 ISP_RPH_WEIH (offset 0x2A20, printed page 9-65, `hi3516av200--Hi3516AV200-Datasheet.txt` line 41047).";

        field {
            name = "bas_rph_weih2";
            desc = "Rephase horizontal sampling coefficient 2. It is a signed number. The configured value is a complement.";
            sw = rw;
            hw = r;
            reset = 0x4;
        } bas_rph_weih2[21:16];

        field {
            name = "bas_rph_weih1";
            desc = "Rephase horizontal sampling coefficient 1. It is a signed number. The configured value is a complement.";
            sw = rw;
            hw = r;
            reset = 0x1E;
        } bas_rph_weih1[13:8];

        field {
            name = "bas_rph_weih0";
            desc = "Rephase horizontal sampling coefficient 0. It is a signed number. The configured value is a complement.";
            sw = rw;
            hw = r;
            reset = 0x3E;
        } bas_rph_weih0[5:0];
    } ISP_RPH_WEIH @ 0x2A20;

    reg {
        name = "ISP_RPH_WEIV";
        desc = "ISP_RPH_WEIV.

Data sheet 9.1.6 ISP_RPH_WEIV (offset 0x2A24, printed page 9-66, `hi3516av200--Hi3516AV200-Datasheet.txt` line 41093).";

        field {
            name = "bas_rph_weiv2";
            desc = "Rephase vertical sampling coefficient 2. It is a signed number. The configured value is a complement.";
            sw = rw;
            hw = r;
            reset = 0x4;
        } bas_rph_weiv2[21:16];

        field {
            name = "bas_rph_weiv1";
            desc = "Rephase vertical sampling coefficient 1. It is a signed number. The configured value is a complement.";
            sw = rw;
            hw = r;
            reset = 0x1E;
        } bas_rph_weiv1[13:8];

        field {
            name = "bas_rph_weiv0";
            desc = "Rephase vertical sampling coefficient 0. It is a signed number. The configured value is a complement.";
            sw = rw;
            hw = r;
            reset = 0x3E;
        } bas_rph_weiv0[5:0];
    } ISP_RPH_WEIV @ 0x2A24;

    reg {
        name = "6-tap LUT write address register for downscale horizontal sampling";
        desc = "ISP_BAS_HLUT_HWADDR is a 6-tap LUT write address register for downscale horizontal sampling. Only VICAP1 supports this register.

Data sheet 9.1.6 ISP_BAS_HLUT_HWADDR (offset 0x2A80, printed page 9-66, `hi3516av200--Hi3516AV200-Datasheet.txt` line 41130).";

        field {
            name = "hlut_hwaddr";
            desc = "Write address of the 6-tap LUT for downscale horizontal sampling";
            sw = rw;
            hw = r;
            reset = 0x0;
        } hlut_hwaddr[31:0];
    } ISP_BAS_HLUT_HWADDR @ 0x2A80;

    reg {
        name = "6-tap LUT write data register for downscale horizontal sampling";
        desc = "ISP_BAS_HLUT_HWDATA is a 6-tap LUT write data register for downscale horizontal sampling. Only VICAP1 supports this register.

Data sheet 9.1.6 ISP_BAS_HLUT_HWDATA (offset 0x2A84, printed page 9-67, `hi3516av200--Hi3516AV200-Datasheet.txt` line 41159).";

        field {
            name = "hlut_hwdata";
            desc = "Write data of 6-tap LUT for downscale horizontal sampling";
            sw = r;
            hw = w;
            reset = 0x0;
        } hlut_hwdata[31:0];
    } ISP_BAS_HLUT_HWDATA @ 0x2A84;

    reg {
        name = "6-tap LUT read address register for downscale horizontal sampling";
        desc = "ISP_BAS_HLUT_HRADDR is a 6-tap LUT read address register for downscale horizontal sampling. Only VICAP1 supports this register.

Data sheet 9.1.6 ISP_BAS_HLUT_HRADDR (offset 0x2A88, printed page 9-67, `hi3516av200--Hi3516AV200-Datasheet.txt` line 41181).";

        field {
            name = "hlut_hraddr";
            desc = "Read address of 6-tap LUT for downscale horizontal sampling";
            sw = rw;
            hw = r;
            reset = 0x0;
        } hlut_hraddr[31:0];
    } ISP_BAS_HLUT_HRADDR @ 0x2A88;

    reg {
        name = "ISP_BAS_HLUT_HRDATA";
        desc = "ISP_BAS_HLUT_HRDATA.

Data sheet 9.1.6 ISP_BAS_HLUT_HRDATA (offset 0x2A8C, printed page 9-68, `hi3516av200--Hi3516AV200-Datasheet.txt` line 41213).";

        field {
            name = "hlut_hrdata";
            desc = "Read data of 6-tap LUT for downscale horizontal sampling";
            sw = rw;
            hw = r;
            reset = 0x0;
        } hlut_hrdata[31:0];
    } ISP_BAS_HLUT_HRDATA @ 0x2A8C;

    reg {
        name = "6-tap LUT write address register for downscale horizontal sampling";
        desc = "ISP_BAS_HLUT_LWADDR is a 6-tap LUT write address register for downscale horizontal sampling. Only VICAP1 supports this register.

Data sheet 9.1.6 ISP_BAS_HLUT_LWADDR (offset 0x2A90, printed page 9-68, `hi3516av200--Hi3516AV200-Datasheet.txt` line 41235).";

        field {
            name = "hlut_lwaddr";
            desc = "Write address of the 6-tap LUT for downscale horizontal sampling";
            sw = rw;
            hw = r;
            reset = 0x0;
        } hlut_lwaddr[31:0];
    } ISP_BAS_HLUT_LWADDR @ 0x2A90;

    reg {
        name = "6-tap LUT write data register for downscale horizontal sampling";
        desc = "ISP_BAS_HLUT_LWDATA is a 6-tap LUT write data register for downscale horizontal sampling. Only VICAP1 supports this register.

Data sheet 9.1.6 ISP_BAS_HLUT_LWDATA (offset 0x2A94, printed page 9-68, `hi3516av200--Hi3516AV200-Datasheet.txt` line 41258).";

        field {
            name = "hlut_lwdata";
            desc = "Write data of 6-tap LUT for downscale horizontal sampling";
            sw = r;
            hw = w;
            reset = 0x0;
        } hlut_lwdata[31:0];
    } ISP_BAS_HLUT_LWDATA @ 0x2A94;

    reg {
        name = "6-tap LUT read address register for downscale horizontal sampling";
        desc = "ISP_BAS_HLUT_LRADDR is a 6-tap LUT read address register for downscale horizontal sampling. Only VICAP1 supports this register.

Data sheet 9.1.6 ISP_BAS_HLUT_LRADDR (offset 0x2A98, printed page 9-69, `hi3516av200--Hi3516AV200-Datasheet.txt` line 41289).";

        field {
            name = "hlut_lraddr";
            desc = "Read address of 6-tap LUT for downscale horizontal sampling";
            sw = rw;
            hw = r;
            reset = 0x0;
        } hlut_lraddr[31:0];
    } ISP_BAS_HLUT_LRADDR @ 0x2A98;

    reg {
        name = "6-tap LUT read data register for downscale horizontal sampling";
        desc = "ISP_BAS_HLUT_LRDATA is a 6-tap LUT read data register for downscale horizontal sampling. Only VICAP1 supports this register.

Data sheet 9.1.6 ISP_BAS_HLUT_LRDATA (offset 0x2A9C, printed page 9-69, `hi3516av200--Hi3516AV200-Datasheet.txt` line 41311).";

        field {
            name = "hlut_lrdata";
            desc = "Read data of 6-tap LUT for downscale horizontal sampling";
            sw = rw;
            hw = r;
            reset = 0x0;
        } hlut_lrdata[31:0];
    } ISP_BAS_HLUT_LRDATA @ 0x2A9C;

    reg {
        name = "ISP_BAS_VLUT_HWADDR";
        desc = "ISP_BAS_VLUT_HWADDR.

Data sheet 9.1.6 ISP_BAS_VLUT_HWADDR (offset 0x2AA0, printed page 9-70, `hi3516av200--Hi3516AV200-Datasheet.txt` line 41344).";

        field {
            name = "v6lut_hwaddr";
            desc = "Write address of 6-tap LUT for downscale vertical sampling";
            sw = rw;
            hw = r;
            reset = 0x0;
        } v6lut_hwaddr[31:0];
    } ISP_BAS_VLUT_HWADDR @ 0x2AA0;

    reg {
        name = "6-tap LUT write data register for downscale vertical sampling";
        desc = "ISP_BAS_VLUT_HWDATA is a 6-tap LUT write data register for downscale vertical sampling. Only VICAP1 supports this register.

Data sheet 9.1.6 ISP_BAS_VLUT_HWDATA (offset 0x2AA4, printed page 9-70, `hi3516av200--Hi3516AV200-Datasheet.txt` line 41366).";

        field {
            name = "v6lut_hwdata";
            desc = "Write data of 6-tap LUT for downscale vertical sampling";
            sw = r;
            hw = w;
            reset = 0x0;
        } v6lut_hwdata[31:0];
    } ISP_BAS_VLUT_HWDATA @ 0x2AA4;

    reg {
        name = "6-tap LUT read address register for downscale vertical sampling";
        desc = "ISP_BAS_VLUT_HRADDR is a 6-tap LUT read address register for downscale vertical sampling. Only VICAP1 supports this register.

Data sheet 9.1.6 ISP_BAS_VLUT_HRADDR (offset 0x2AA8, printed page 9-70, `hi3516av200--Hi3516AV200-Datasheet.txt` line 41389).";

        field {
            name = "v6lut_hraddr";
            desc = "Read address of 6-tap LUT for downscale vertical sampling";
            sw = rw;
            hw = r;
            reset = 0x0;
        } v6lut_hraddr[31:0];
    } ISP_BAS_VLUT_HRADDR @ 0x2AA8;

    reg {
        name = "6-tap LUT read data register for downscale vertical sampling";
        desc = "ISP_BAS_VLUT_HRDATA is a 6-tap LUT read data register for downscale vertical sampling. Only VICAP1 supports this register.

Data sheet 9.1.6 ISP_BAS_VLUT_HRDATA (offset 0x2AAC, printed page 9-71, `hi3516av200--Hi3516AV200-Datasheet.txt` line 41419).";

        field {
            name = "v6lut_hrdata";
            desc = "Read data of 6-tap LUT for downscale vertical sampling";
            sw = rw;
            hw = r;
            reset = 0x0;
        } v6lut_hrdata[31:0];
    } ISP_BAS_VLUT_HRDATA @ 0x2AAC;

    reg {
        name = "6-tap LUT write address register for downscale vertical sampling";
        desc = "ISP_BAS_VLUT_LWADDR is a 6-tap LUT write address register for downscale vertical sampling. Only VICAP1 supports this register.

Data sheet 9.1.6 ISP_BAS_VLUT_LWADDR (offset 0x2AB0, printed page 9-71, `hi3516av200--Hi3516AV200-Datasheet.txt` line 41441).";

        field {
            name = "v6lut_lwaddr";
            desc = "Write address of 6-tap LUT for downscale vertical sampling";
            sw = rw;
            hw = r;
            reset = 0x0;
        } v6lut_lwaddr[31:0];
    } ISP_BAS_VLUT_LWADDR @ 0x2AB0;

    reg {
        name = "ISP_BAS_VLUT_LWDATA";
        desc = "ISP_BAS_VLUT_LWDATA.

Data sheet 9.1.6 ISP_BAS_VLUT_LWDATA (offset 0x2AB4, printed page 9-72, `hi3516av200--Hi3516AV200-Datasheet.txt` line 41473).";

        field {
            name = "v6lut_lwdata";
            desc = "Write data of 6-tap LUT for downscale vertical sampling";
            sw = r;
            hw = w;
            reset = 0x0;
        } v6lut_lwdata[31:0];
    } ISP_BAS_VLUT_LWDATA @ 0x2AB4;

    reg {
        name = "6-tap LUT read address register for downscale vertical sampling";
        desc = "ISP_BAS_VLUT_LRADDR is a 6-tap LUT read address register for downscale vertical sampling. Only VICAP1 supports this register.

Data sheet 9.1.6 ISP_BAS_VLUT_LRADDR (offset 0x2AB8, printed page 9-72, `hi3516av200--Hi3516AV200-Datasheet.txt` line 41495).";

        field {
            name = "v6lut_lraddr";
            desc = "Read address of 6-tap LUT for downscale vertical sampling";
            sw = rw;
            hw = r;
            reset = 0x0;
        } v6lut_lraddr[31:0];
    } ISP_BAS_VLUT_LRADDR @ 0x2AB8;

    reg {
        name = "6-tap LUT read data register for downscale vertical sampling";
        desc = "ISP_BAS_VLUT_LRDATA is a 6-tap LUT read data register for downscale vertical sampling. Only VICAP1 supports this register.

Data sheet 9.1.6 ISP_BAS_VLUT_LRDATA (offset 0x2ABC, printed page 9-72, `hi3516av200--Hi3516AV200-Datasheet.txt` line 41517).";

        field {
            name = "v6lut_lrdata";
            desc = "Read data of 6-tap LUT for downscale vertical sampling";
            sw = rw;
            hw = r;
            reset = 0x0;
        } v6lut_lrdata[31:0];
    } ISP_BAS_VLUT_LRDATA @ 0x2ABC;

    reg {
        name = "General control register";
        desc = "ISP_BAS_CTRL_F is a general control register. Only VICAP1 supports this register.

Data sheet 9.1.6 ISP_BAS_CTRL_F (offset 0x2AE0, printed page 9-73, `hi3516av200--Hi3516AV200-Datasheet.txt` line 41548).";

        enum ISP_BAS_CTRL_F_rggb_cfg_enum {
            R_GR_GB = 0 { name = "R Gr Gb"; desc = "R Gr Gb B"; };
            GR_R_B = 1 { name = "Gr R B"; desc = "Gr R B Gb"; };
            GB_B_R = 2 { name = "Gb B R"; desc = "Gb B R Gr"; };
            B_GB_GR = 3 { name = "B Gb Gr"; desc = "B Gb Gr R"; };
        };

        field {
            name = "rggb_cfg";
            desc = "Initial sequence of an RGGB picture";
            sw = rw;
            hw = r;
            encode = ISP_BAS_CTRL_F_rggb_cfg_enum;
            reset = 0x3;
        } rggb_cfg[1:0];
    } ISP_BAS_CTRL_F @ 0x2AE0;

    reg {
        name = "ISP_BAS_CTRL_I";
        desc = "ISP_BAS_CTRL_I.

Data sheet 9.1.6 ISP_BAS_CTRL_I (offset 0x2AE4, printed page 9-74, `hi3516av200--Hi3516AV200-Datasheet.txt` line 41591).";

        enum ISP_BAS_CTRL_I_update_mode_enum {
            UPDATE_MODE_SPECIFIED = 0 { name = "Update Mode Specified"; desc = "update mode specified in ISP_BAS_UPDATE"; };
            FRAME_UPDATE_MODE = 1 { name = "Frame Update Mode"; desc = "frame update mode"; };
        };

        field {
            name = "update_mode";
            desc = "ISP update mode";
            sw = rw;
            hw = r;
            encode = ISP_BAS_CTRL_I_update_mode_enum;
            reset = 0x0;
        } update_mode[0:0];
    } ISP_BAS_CTRL_I @ 0x2AE4;

    reg {
        name = "Output timing configuration register";
        desc = "ISP_BAS_TIMING is an output timing configuration register. Only VICAP1 supports this register.

Data sheet 9.1.6 ISP_BAS_TIMING (offset 0x2AE8, printed page 9-74, `hi3516av200--Hi3516AV200-Datasheet.txt` line 41623).";

        field {
            name = "cpi_fix_timing_stat";
            desc = "Manual timing parameter configuration. The length of the generated line blanking region is configured.";
            sw = rw;
            hw = r;
            reset = 0x40;
        } cpi_fix_timing_stat[13:1];
    } ISP_BAS_TIMING @ 0x2AE8;

    reg {
        name = "Register update register";
        desc = "ISP_BAS_UPDATE is a register update register. Hi3516A V200 Professional HD IP Camera SoC Only VICAP1 supports this register.

Data sheet 9.1.6 ISP_BAS_UPDATE (offset 0x2AEC, printed page 9-75, `hi3516av200--Hi3516AV200-Datasheet.txt` line 41660).";

        field {
            name = "update";
            desc = "ISP update. This bit is automatically cleared for each frame.";
            sw = rw;
            hw = r;
            reset = 0x0;
        } update[0:0];
    } ISP_BAS_UPDATE @ 0x2AEC;

    reg {
        name = "BAS input picture size register";
        desc = "ISP_BAS_SIZE is a BAS input picture size register. Only VICAP1 supports this register.

Data sheet 9.1.6 ISP_BAS_SIZE (offset 0x2AF0, printed page 9-75, `hi3516av200--Hi3516AV200-Datasheet.txt` line 41684).";

        field {
            name = "height";
            desc = "Input picture height. The configured value is the actual value minus 1. For example, if the actual picture height is 1080, this field needs to be set to 1079.";
            sw = rw;
            hw = r;
            reset = 0x437;
        } height[28:16];

        field {
            name = "width";
            desc = "Input picture width. The configured value is the actual value minus 1. For example, if the actual picture width is 1920, this field needs to be set to 1919.";
            sw = rw;
            hw = r;
            reset = 0x77F;
        } width[12:0];
    } ISP_BAS_SIZE @ 0x2AF0;
};

`endif
