`ifndef HISI_VICAP_RDL
`define HISI_VICAP_RDL

regfile eHISI_VICAP_CH {
    name = "HiSilicon VICAP port/channel registers";
    desc = "
    One VICAP port/channel register group (`CH[16]` at 0x10000 + n x 0x2000). Offsets are rebased to the start of the group (the data sheet lists the registers of PORT 0 / CH 0 as 0x10000.. and 0x10300..; Figure 11-17 shows PORTn registers at 0x10000 + n x 0x4000 and CHn registers at 0x10300 + n x 0x2000). The PT_* registers (offsets 0x000..0x044) exist only in channels 0 and 4 (at most two external ports are supported; port 0 serves channels 0-3, port 1 channels 4-7); they are present but not implemented in the other groups. The Hi3520D has 8 channels (Hi3515A: 4), the data sheet space allocation shows 16.

    VENDOR CROSS-CHECK (docs/rdl-campaign/vicap-vendor.md; Source: vendor module hi3520D_viu.ko (Hi3520D_MPP_V2.0.5.1, HiMPP kernel module from the OpenIPC Hi3520D rootfs; static disassembly)): the vendor HAL addresses port p at base + 0x10000 + p x 0x8000 (VIU_HAL_SetPortEn and all PT accessors: index (p + 2) shifted left by 15) and channel c at base + 0x10300 + (c & 3) x 0x2000 + (c >> 2) x 0x8000 (VIU_HAL_GetChnReg: switch on c & 3 selects +0x0/0x2000/0x4000/0x6000, c >> 2 is shifted left by 15). Therefore the PT_* registers of the two Hi3520D ports sit in channel groups 0 and 4 (0x10000 and 0x18000, 0x8000 apart); the 0x4000 port spacing of the data sheet Figure 11-17 does not apply (previously: PORTn at 0x10000 + n x 0x4000 quoted from the figure). Offsets inside a group equal vendor offset + 0x300 for registers the vendor reaches through GetChnReg (vendor +0x100 = CH_CTRL 0x400, +0x110 = CH_CROP_START 0x410, +0x200 = CH_DITHER_CFG 0x500, +0x400 = CH_MSC_CFG 0x700, +0x500 = CH_VCDS_CFG 0x800, +0x640 = CH_LHFIR_SPH 0x940, +0x900 = CH_SUM_Y 0xC00). Confidence HIGH. Not verified on hardware.
    Board facts (2026-11-10, Linux driver test): channel group registers read 0 and drop writes until the port enable bit (PT_INTF_MOD.port_en) is set; the vendor HAL likewise enables the port first (VIU_DRV_EnableDev -> VIU_HAL_SetPortEn, then udelay of g_u32DelayTime = 100 us) and only afterwards programs channels.
    Global per-register source and confidence lines were added 2026-11-10 (user rule): 'Source: data sheet' text is unchanged data-sheet content; every 'Source: vendor module ...' line is derived from the proprietary module by static analysis and is not a data-sheet fact.
    ";

    reg {
        name = "Port mode register";
        desc = "PT_INTF_MOD is a port mode register.

Source: data sheet 11.1.6 PT_INTF_MOD (offset 0x10000, printed page 11-21, `datasheet.txt` line 33933).

Source: vendor module hi3520D_viu.ko (Hi3520D_MPP_V2.0.5.1, HiMPP kernel module from the OpenIPC Hi3520D rootfs; static disassembly), VIU_DRV_SetDevAttrByChip (0x13754), VIU_HAL_SetPortEn/ClkMode/WorkMode/InputMode/CompMode/FixCode, VIU_HAL_SetAdChnId/SetAdChnIdEn, confidence HIGH for the bit positions written: bit0 port_en (SetPortEn), bit1 clk_mode (SetPortClkMode; vendor always writes 0 for BT.656), [4:3] port_mod (SetPortCompMode; written by SetDataLayout only for the 16-bit/digital-camera modes), bit7 fix_code (SetPortFixCode; 0 unless BT.601 or digital camera input), [9:8] written by SetPortWorkMode with the multiplex count (0 = 1Mux, 1 = 2Mux, 2 = 4Mux; forced to 1 for BT1120 interleaved), [11:10] written by SetPortInputMode with the interface type (VI interface enum 0 BT656 -> 0, 1 BT601 -> 1, 2 -> 2, 3 BT1120 standard -> 0, 4 BT1120 interleaved -> 3), [13:12]/[15:14]/[17:16]/[19:18] channel IDs ch0..3 (SetAdChnId) and bits 20..23 id enables (SetAdChnIdEn, only when more than one way is multiplexed). NOTE: the vendor labels of [9:8] (multiplex count) and [11:10] (input interface type) are the reverse of the data-sheet field names port_mux_mode [9:8] / port_cap_mode [11:10] below (the data sheet names [11:10] as the 1/2/4-channel multiplexing field); for the 1-channel BT.656 case both fields are 0 so it does not matter there. Previously the data-sheet naming only. Vendor write order for a BT.656 device: CRG11 sc_sel and divider, channel clock on, 100 us, device reset released, WK_MODE ptN_mode, PT ch IDs, clk_mode 0, [9:8], [11:10], fix_code, then port_en LAST (VIU_DRV_EnableDev), 100 us. Not verified on hardware.";

        enum PT_INTF_MOD_interleave_seq_enum {
            C_COMPONENT_BEFORE = 0 { name = "C Component Before"; desc = "The C component is before the Y component."; };
            Y_COMPONENT_BEFORE = 1 { name = "Y Component Before"; desc = "The Y component is before the C component."; };
        };

        field {
            name = "interleave_seq";
            desc = "Y/C sequence during interleaving.";
            sw = rw;
            hw = r;
            encode = PT_INTF_MOD_interleave_seq_enum;
            reset = 0x0;
        } interleave_seq[24:24];

        enum PT_INTF_MOD_ch3_id_en_enum {
            CHANNEL_ID_NOT = 0 { name = "Channel Id Not"; desc = "The channel ID is not checked."; };
            DATA_CHANNEL_SELECTED = 1 { name = "Data Channel Selected"; desc = "The data channel is selected based on the channel ID."; };
        };

        field {
            name = "ch3_id_en";
            desc = "Channel 3 ID enable.";
            sw = rw;
            hw = r;
            encode = PT_INTF_MOD_ch3_id_en_enum;
            reset = 0x0;
        } ch3_id_en[23:23];

        enum PT_INTF_MOD_ch2_id_en_enum {
            CHANNEL_ID_NOT = 0 { name = "Channel Id Not"; desc = "The channel ID is not checked."; };
            DATA_CHANNEL_SELECTED = 1 { name = "Data Channel Selected"; desc = "The data channel is selected based on the channel ID."; };
        };

        field {
            name = "ch2_id_en";
            desc = "Channel 2 ID enable.";
            sw = rw;
            hw = r;
            encode = PT_INTF_MOD_ch2_id_en_enum;
            reset = 0x0;
        } ch2_id_en[22:22];

        enum PT_INTF_MOD_ch1_id_en_enum {
            CHANNEL_ID_NOT = 0 { name = "Channel Id Not"; desc = "The channel ID is not checked."; };
            DATA_CHANNEL_SELECTED = 1 { name = "Data Channel Selected"; desc = "The data channel is selected based on the channel ID."; };
        };

        field {
            name = "ch1_id_en";
            desc = "Channel 1 ID enable.";
            sw = rw;
            hw = r;
            encode = PT_INTF_MOD_ch1_id_en_enum;
            reset = 0x0;
        } ch1_id_en[21:21];

        enum PT_INTF_MOD_ch0_id_en_enum {
            CHANNEL_ID_NOT = 0 { name = "Channel Id Not"; desc = "The channel ID is not checked."; };
            DATA_CHANNEL_SELECTED = 1 { name = "Data Channel Selected"; desc = "The data channel is selected based on the channel ID."; };
        };

        field {
            name = "ch0_id_en";
            desc = "Channel 0 ID enable.";
            sw = rw;
            hw = r;
            encode = PT_INTF_MOD_ch0_id_en_enum;
            reset = 0x0;
        } ch0_id_en[20:20];

        field {
            name = "ch3_id";
            desc = "The data channel is selected based on the channel ID when the channel 3 ID is enabled.";
            sw = rw;
            hw = r;
            reset = 0x0;
        } ch3_id[19:18];

        field {
            name = "ch2_id";
            desc = "The data channel is selected based on the channel ID when the channel 2 ID is enabled.";
            sw = rw;
            hw = r;
            reset = 0x0;
        } ch2_id[17:16];

        field {
            name = "ch1_id";
            desc = "The data channel is selected based on the channel ID when the channel 1 ID is enabled.";
            sw = rw;
            hw = r;
            reset = 0x0;
        } ch1_id[15:14];

        field {
            name = "ch0_id";
            desc = "The data channel is selected based on the channel ID when the channel 0 ID is enabled.";
            sw = rw;
            hw = r;
            reset = 0x0;
        } ch0_id[13:12];

        enum PT_INTF_MOD_port_cap_mode_enum {
            BT_656_BT = 0 { name = "Bt 656 Bt"; desc = "BT.656/BT.1120 mode"; };
            INTERLEAVE_MODE_OTHER = 3 { name = "Interleave Mode Other"; desc = "interleave mode Other values: reserved"; };
        };

        field {
            name = "port_cap_mode";
            desc = "Port mode. Vendor writes the INPUT INTERFACE type here (0 BT.656/BT.1120 standard, 1 BT.601, 2 and 3 other, 3 = BT.1120 interleaved), not the multiplex count (Source: vendor module hi3520D_viu.ko (Hi3520D_MPP_V2.0.5.1, HiMPP kernel module from the OpenIPC Hi3520D rootfs; static disassembly), VIU_HAL_SetPortInputMode, confidence HIGH for the position, MEDIUM for the value names). Not verified on hardware.";
            sw = rw;
            hw = r;
            encode = PT_INTF_MOD_port_cap_mode_enum;
            reset = 0x0;
        } port_cap_mode[11:10];

        enum PT_INTF_MOD_port_mux_mode_enum {
            V_1_CHANNEL_MULTIPLEXING = 0 { name = "V 1 Channel Multiplexing"; desc = "1-channel multiplexing mode"; };
            V_2_CHANNEL_MULTIPLEXING = 1 { name = "V 2 Channel Multiplexing"; desc = "2-channel multiplexing mode"; };
            V_4_CHANNEL_MULTIPLEXING = 2 { name = "V 4 Channel Multiplexing"; desc = "4-channel multiplexing mode"; };
            RESERVED = 3 { name = "Reserved"; desc = "reserved"; };
        };

        field {
            name = "port_mux_mode";
            desc = "Multiplexing mode. Vendor writes the MULTIPLEX COUNT here (0 = 1 channel, 1 = 2 channel (or BT.1120 interleaved), 2 = 4 channel) (Source: vendor module hi3520D_viu.ko (Hi3520D_MPP_V2.0.5.1, HiMPP kernel module from the OpenIPC Hi3520D rootfs; static disassembly), VIU_HAL_SetPortWorkMode, confidence HIGH for the position). Not verified on hardware.";
            sw = rw;
            hw = r;
            encode = PT_INTF_MOD_port_mux_mode_enum;
            reset = 0x0;
        } port_mux_mode[9:8];

        enum PT_INTF_MOD_fix_code_enum {
            MSB_1 = 0 { name = "Msb 1"; desc = "The MSB is 1."; };
            MSB_0 = 1 { name = "Msb 0"; desc = "The MSB is 0."; };
        };

        field {
            name = "fix_code";
            desc = "MSB of the sync code.";
            sw = rw;
            hw = r;
            encode = PT_INTF_MOD_fix_code_enum;
            reset = 0x0;
        } fix_code[7:7];

        enum PT_INTF_MOD_port_mod_enum {
            SINGLE_COMPONENT_INPUT = 0 { name = "Single Component Input"; desc = "single-component input"; };
            DUAL_COMPONENT_INPUT = 1 { name = "Dual Component Input"; desc = "dual-component input Other values: reserved"; };
        };

        field {
            name = "port_mod";
            desc = "Port mode.";
            sw = rw;
            hw = r;
            encode = PT_INTF_MOD_port_mod_enum;
            reset = 0x0;
        } port_mod[4:3];

        enum PT_INTF_MOD_clk_mode_enum {
            SAMPLING_RISING_EDGE = 0 { name = "Sampling Rising Edge"; desc = "sampling on the rising edge"; };
            SAMPLING_FALLING_EDGE = 1 { name = "Sampling Falling Edge"; desc = "sampling on the falling edge"; };
        };

        field {
            name = "clk_mode";
            desc = "Clock mode.";
            sw = rw;
            hw = r;
            encode = PT_INTF_MOD_clk_mode_enum;
            reset = 0x0;
        } clk_mode[1:1];

        enum PT_INTF_MOD_port_en_enum {
            DISABLED = 0 { name = "Disabled"; desc = "disabled"; };
            ENABLED = 1 { name = "Enabled"; desc = "enabled"; };
        };

        field {
            name = "port_en";
            desc = "Port enable.";
            sw = rw;
            hw = r;
            encode = PT_INTF_MOD_port_en_enum;
            reset = 0x0;
        } port_en[0:0];
    } PT_INTF_MOD @ 0x0;

    reg {
        name = "R component mask register";
        desc = "PT_R_MASK_L is R component mask register.

Source: data sheet 11.1.6 PT_R_MASK_L (offset 0x10004, printed page 11-23, `datasheet.txt` line 34036).";

        field {
            name = "r_mask";
            desc = "R component mask.";
            sw = rw;
            hw = r;
            reset = 0x0;
        } r_mask[31:0];
    } PT_R_MASK_L @ 0x4;

    reg {
        name = "B component mask register";
        desc = "PT_B_MASK_L is B component mask register.

Source: data sheet 11.1.6 PT_B_MASK_L (offset 0x10008, printed page 11-24, `datasheet.txt` line 34065).";

        field {
            name = "b_mask";
            desc = "B component mask.";
            sw = rw;
            hw = r;
            reset = 0x0;
        } b_mask[31:0];
    } PT_B_MASK_L @ 0x8;

    reg {
        name = "G component mask register";
        desc = "PT_G_MASK_L is G component mask register.

Source: data sheet 11.1.6 PT_G_MASK_L (offset 0x1000C, printed page 11-24, `datasheet.txt` line 34084).";

        field {
            name = "g_mask";
            desc = "G component mask.";
            sw = rw;
            hw = r;
            reset = 0x0;
        } g_mask[31:0];
    } PT_G_MASK_L @ 0xC;

    reg {
        name = "R component offset register";
        desc = "PT_R_OFFSET_L is R component offset register.

Source: data sheet 11.1.6 PT_R_OFFSET_L (offset 0x10014, printed page 11-24, `datasheet.txt` line 34102).";

        field {
            name = "r_offset";
            desc = "R component offset.";
            sw = rw;
            hw = r;
            reset = 0x0;
        } r_offset[7:0];
    } PT_R_OFFSET_L @ 0x14;

    reg {
        name = "B component offset register";
        desc = "PT_B_OFFSET_L is B component offset register.

Source: data sheet 11.1.6 PT_B_OFFSET_L (offset 0x10018, printed page 11-25, `datasheet.txt` line 34130).";

        field {
            name = "b_offset";
            desc = "B component offset.";
            sw = rw;
            hw = r;
            reset = 0x0;
        } b_offset[7:0];
    } PT_B_OFFSET_L @ 0x18;

    reg {
        name = "G component offset register";
        desc = "PT_G_OFFSET_L is G component offset register.

Source: data sheet 11.1.6 PT_G_OFFSET_L (offset 0x1001C, printed page 11-25, `datasheet.txt` line 34150).";

        field {
            name = "g_offset";
            desc = "G component offset.";
            sw = rw;
            hw = r;
            reset = 0x0;
        } g_offset[7:0];
    } PT_G_OFFSET_L @ 0x1C;

    reg {
        name = "Port test configuration register";
        desc = "PT_TEST_CFG is a port test configuration register.

Source: data sheet 11.1.6 PT_TEST_CFG (offset 0x10040, printed page 11-25, `datasheet.txt` line 34169).

Source: vendor module hi3520D_viu.ko (Hi3520D_MPP_V2.0.5.1, HiMPP kernel module from the OpenIPC Hi3520D rootfs; static disassembly), VIU_HAL_SetColorBarEn (0x13e38), confidence HIGH that bit 0 is a color bar enable at port base + 0x40: the HAL does read-modify-write of bit 0 only (cbar_en) at base + 0x10040 + port x 0x8000. The function is NOT called anywhere in hi3520D_viu.ko (no caller or exported use; the module has no test-pattern parameter or ioctl), and the vendor never writes hsync_sel [1] or interlace [2]; no timing or clock registers for the generator exist in the vendor code. The only related board script content (crgctrl_*_hi3520D.sh, 0x2003002C values 0x5524ff02 / 0x00241102 / 0xaa240102 / 0x0524f102) never sets PERI_CRG11.vi_selftest. Conclusion: the generator is probably a verification feature (the module also contains an empty RTL_Verify_RegWrite stub); whether it works in silicon is UNKNOWN. Not verified on hardware. Board 2026-11-10: with cbar_en (and hsync_sel/interlace variants) plus vi_selftest set, no frame start interrupt and IPI size 0 were observed.";

        field {
            name = "interlace";
            desc = "interlace Source: data sheet (name only; not referenced by the vendor module, confidence: nothing known about behavior). Not verified on hardware.";
            sw = rw;
            hw = r;
            reset = 0x0;
        } interlace[2:2];

        field {
            name = "hsync_sel";
            desc = "hsync_sel Source: data sheet (name only; not referenced by the vendor module, confidence: nothing known about behavior). Not verified on hardware.";
            sw = rw;
            hw = r;
            reset = 0x0;
        } hsync_sel[1:1];

        field {
            name = "cbar_en";
            desc = "cbar_en Source: vendor module hi3520D_viu.ko, VIU_HAL_SetColorBarEn, confidence HIGH for the bit position; behavior unknown. Not verified on hardware.";
            sw = rw;
            hw = r;
            reset = 0x0;
        } cbar_en[0:0];
    } PT_TEST_CFG @ 0x40;

    reg {
        name = "Port ID status register";
        desc = "PT_ID_STATUS is a port ID status register.

Source: data sheet 11.1.6 PT_ID_STATUS (offset 0x10044, printed page 11-26, `datasheet.txt` line 34226).";

        field {
            name = "id3";
            desc = "Channel 3 ID.";
            sw = r;
            hw = w;
            reset = 0x0;
        } id3[7:6];

        field {
            name = "id2";
            desc = "Channel 2 ID.";
            sw = r;
            hw = w;
            reset = 0x0;
        } id2[5:4];

        field {
            name = "id1";
            desc = "Channel 1 ID.";
            sw = r;
            hw = w;
            reset = 0x0;
        } id1[3:2];

        field {
            name = "id0";
            desc = "Channel 0 ID.";
            sw = r;
            hw = w;
            reset = 0x0;
        } id0[1:0];
    } PT_ID_STATUS @ 0x44;

    reg {
        name = "Port timing register 0";
        desc = "CH_INTF_CFG0 is timing register 0.

Source: data sheet 11.1.6 CH_INTF_CFG0 (offset 0x10300, printed page 11-27, `datasheet.txt` line 34256).

Source: vendor module hi3520D_viu.ko (Hi3520D_MPP_V2.0.5.1, HiMPP kernel module from the OpenIPC Hi3520D rootfs; static disassembly), VIU_HAL_SetChnInputMode ([6:5]), VIU_HAL_SetChnScanMode / SetChnCombineMode ([8:7]), VIU_HAL_SetChnSync, confidence HIGH for positions: [6:5] port_mode: the vendor writes the interface type (0 for BT.656 and BT.1120 standard, 1 and 2 for the sync-based BT.601/digital camera modes, 3 for BT.1120 interleaved; VIU_DRV_SetChnIntfCfg), [8:7] scan mode (bit7 = progressive when set, ScanMode(0 interlaced) clears bit7 and keeps bit8; CombineMode != 0 sets bit8 = Y/C separate). UNDOCUMENTED BITS found: VIU_HAL_SetChnSync writes six single bits of this register from the VI sync configuration (bits 4, 3, 2, 1, 9, 10: arguments in call order; HiMPP VI_SYNC_CFG_S members vsync field/pulse, vsync polarity, vsync valid and its polarity, hsync polarity), used only for BT.601 / digital camera input (not for BT.656; VIU_DRV_SetChnIntfCfg calls it only when the interface type is 1 or 2). Names and polarities are UNKNOWN, confidence LOW for the meaning (HIGH for the positions). Not verified on hardware.";

        field {
            name = "port_scan_mod";
            desc = "Port data input mode. Bit[8]: Scan_mode[1] 0: Y/C composite input mode 1: Y/C separation input mode Bit[7]: Scan_mode[0] 0: interlaced input mode 1: progressive input mode";
            sw = rw;
            hw = r;
            reset = 0x0;
        } port_scan_mod[8:7];

        field {
            name = "port_mode";
            desc = "Port data receive mode. 00: BT.656/BT.1120 mode Other values: reserved";
            sw = rw;
            hw = r;
            reset = 0x0;
        } port_mode[6:5];

        field {
            name = "bit4_unk";
            desc = "Source: vendor module hi3520D_viu.ko (Hi3520D_MPP_V2.0.5.1, static disassembly) Observed only as a written bit: VIU_HAL_SetChnSync (0x15020) writes this bit from its 1st configuration argument (read-modify-write of the whole register; called from VIU_DRV_SetChnIntfCfg only for the BT.601 / digital camera interface types, never for BT.656). Meaning unknown. Unknown purpose, vendor-observed only, confidence LOW, not verified on hardware.";
            sw = rw;
            hw = r;
        } bit4_unk[4:4];

        field {
            name = "bit3_unk";
            desc = "Source: vendor module hi3520D_viu.ko (Hi3520D_MPP_V2.0.5.1, static disassembly) Observed only as a written bit: VIU_HAL_SetChnSync (0x15020) writes this bit from its 2nd configuration argument (read-modify-write of the whole register; called from VIU_DRV_SetChnIntfCfg only for the BT.601 / digital camera interface types, never for BT.656). Meaning unknown. Unknown purpose, vendor-observed only, confidence LOW, not verified on hardware.";
            sw = rw;
            hw = r;
        } bit3_unk[3:3];

        field {
            name = "bit2_unk";
            desc = "Source: vendor module hi3520D_viu.ko (Hi3520D_MPP_V2.0.5.1, static disassembly) Observed only as a written bit: VIU_HAL_SetChnSync (0x15020) writes this bit from its 3rd configuration argument (read-modify-write of the whole register; called from VIU_DRV_SetChnIntfCfg only for the BT.601 / digital camera interface types, never for BT.656). Meaning unknown. Unknown purpose, vendor-observed only, confidence LOW, not verified on hardware.";
            sw = rw;
            hw = r;
        } bit2_unk[2:2];

        field {
            name = "bit1_unk";
            desc = "Source: vendor module hi3520D_viu.ko (Hi3520D_MPP_V2.0.5.1, static disassembly) Observed only as a written bit: VIU_HAL_SetChnSync (0x15020) writes this bit from its 4th configuration argument (read-modify-write of the whole register; called from VIU_DRV_SetChnIntfCfg only for the BT.601 / digital camera interface types, never for BT.656). Meaning unknown. Unknown purpose, vendor-observed only, confidence LOW, not verified on hardware.";
            sw = rw;
            hw = r;
        } bit1_unk[1:1];

        field {
            name = "bit9_unk";
            desc = "Source: vendor module hi3520D_viu.ko (Hi3520D_MPP_V2.0.5.1, static disassembly) Observed only as a written bit: VIU_HAL_SetChnSync (0x15020) writes this bit from its 5th configuration argument (read-modify-write of the whole register; called from VIU_DRV_SetChnIntfCfg only for the BT.601 / digital camera interface types, never for BT.656). Meaning unknown. Unknown purpose, vendor-observed only, confidence LOW, not verified on hardware.";
            sw = rw;
            hw = r;
        } bit9_unk[9:9];

        field {
            name = "bit10_unk";
            desc = "Source: vendor module hi3520D_viu.ko (Hi3520D_MPP_V2.0.5.1, static disassembly) Observed only as a written bit: VIU_HAL_SetChnSync (0x15020) writes this bit from its 6th configuration argument (read-modify-write of the whole register; called from VIU_DRV_SetChnIntfCfg only for the BT.601 / digital camera interface types, never for BT.656). Meaning unknown. Unknown purpose, vendor-observed only, confidence LOW, not verified on hardware.";
            sw = rw;
            hw = r;
        } bit10_unk[10:10];
    } CH_INTF_CFG0 @ 0x300;

    reg {
        name = "Port timing register 1";
        desc = "CH_INTF_CFG1 is timing register 1.

Source: data sheet 11.1.6 CH_INTF_CFG1 (offset 0x10304, printed page 11-28, `datasheet.txt` line 34314).

Source: vendor module hi3520D_viu.ko (Hi3520D_MPP_V2.0.5.1, HiMPP kernel module from the OpenIPC Hi3520D rootfs; static disassembly), VIU_HAL_SetChnYUVInputSeq ([5:4]), SetChnCompMode ([15:14]), SetChnFtcPolar (bit2), SetChnFixcode (bit3), SetChnCorrectEn (bit0), confidence HIGH for the positions. Vendor default path for BT.656 (VIU_DRV_SetChnIntfCfg, interface type 0): sav_ver_en = 0, ftc_cfg = 0, ftc_polar = 0, yuv_seq = 0 (UYVY; 1 for the other interface types), port_mod = 0. The Linux driver writes the whole register as 0, which is identical. Not verified on hardware.";

        enum CH_INTF_CFG1_port_mod_enum {
            SINGLE_COMPONENT_INPUT = 0 { name = "Single Component Input"; desc = "single-component input"; };
            DUAL_COMPONENT_INPUT = 1 { name = "Dual Component Input"; desc = "dual-component input"; };
            TRIPLE_COMPONENT_INPUT = 2 { name = "Triple Component Input"; desc = "triple -component input"; };
            RESERVED = 3 { name = "Reserved"; desc = "reserved"; };
        };

        field {
            name = "port_mod";
            desc = "Port mode.";
            sw = rw;
            hw = r;
            encode = CH_INTF_CFG1_port_mod_enum;
            reset = 0x0;
        } port_mod[15:14];

        field {
            name = "yuv_seq";
            desc = "YUV input sequence. 00: UYVY 01: VYUY 10: YUYV 11: YVYU UV sequence in dual-component mode. 00: VUVU 01: UVUV 10: reserved 11: reserved";
            sw = rw;
            hw = r;
            reset = 0x0;
        } yuv_seq[5:4];

        enum CH_INTF_CFG1_ftc_cfg_enum {
            FIXED_AT_1 = 0 { name = "Fixed At 1"; desc = "fixed at 1"; };
            FIXED_AT_0 = 1 { name = "Fixed At 0"; desc = "fixed at 0"; };
        };

        field {
            name = "ftc_cfg";
            desc = "MSB of the BT.656 timing reference code.";
            sw = rw;
            hw = r;
            encode = CH_INTF_CFG1_ftc_cfg_enum;
            reset = 0x0;
        } ftc_cfg[3:3];

        enum CH_INTF_CFG1_ftc_polar_enum {
            V_1ST_FIELD_F = 0 { name = "V 1St Field F"; desc = "1st field:F = 0 and 2nd field:F = 1 (standard)"; };
            V_1ST_FIELD_F_2 = 1 { name = "V 1St Field F 2"; desc = "1st field:F = 1 and 2nd field:F = 0 (non-standard)"; };
        };

        field {
            name = "ftc_polar";
            desc = "Polarity of the field indication bit (F) of the BT.656 timing reference code.";
            sw = rw;
            hw = r;
            encode = CH_INTF_CFG1_ftc_polar_enum;
            reset = 0x0;
        } ftc_polar[2:2];

        enum CH_INTF_CFG1_sav_ver_en_enum {
            DISABLED = 0 { name = "Disabled"; desc = "disabled"; };
            ENABLED = 1 { name = "Enabled"; desc = "enabled"; };
        };

        field {
            name = "sav_ver_en";
            desc = "SAV and EAV data check enable.";
            sw = rw;
            hw = r;
            encode = CH_INTF_CFG1_sav_ver_en_enum;
            reset = 0x0;
        } sav_ver_en[0:0];
    } CH_INTF_CFG1 @ 0x304;

    reg {
        name = "[inferred] hsync front blank";
        desc = "[inferred] hsync front blank. NOT IN THE DATA SHEET. Source: vendor module hi3520D_viu.ko (Hi3520D_MPP_V2.0.5.1, HiMPP kernel module from the OpenIPC Hi3520D rootfs; static disassembly), VIU_HAL_SetChnHsync_*/SetChnVsync_*/SetChnTimingBlank (channel-group offset 0x310 = vendor GetChnReg offset 0x10): a 16-bit write (strh into a read-modify-write copy, upper half preserved). Used only for BT.601 / digital camera input with explicit sync timing (VIU_DRV_SetChnIntfCfg); the name comes from the vendor function name, the units (pixels or lines) and valid range are UNKNOWN. Confidence MEDIUM for the offset and 16-bit width, LOW for the meaning. Not verified on hardware. The name is VENDOR-DERIVED (from the HAL function name, not documented); access observed: written only (16-bit read-modify-write), value = the VI timing blank configuration given by the application (no constants). Unknown purpose, vendor-observed only, confidence LOW, not verified on hardware.";

        field {
            name = "value";
            desc = "[inferred] 16-bit timing value (vendor-derived, unit unknown).";
            sw = rw;
            hw = r;
            reset = 0x0;
        } value[15:0];
    } CH_HSYNC_HFB @ 0x310;

    reg {
        name = "[inferred] hsync active";
        desc = "[inferred] hsync active. NOT IN THE DATA SHEET. Source: vendor module hi3520D_viu.ko (Hi3520D_MPP_V2.0.5.1, HiMPP kernel module from the OpenIPC Hi3520D rootfs; static disassembly), VIU_HAL_SetChnHsync_*/SetChnVsync_*/SetChnTimingBlank (channel-group offset 0x314 = vendor GetChnReg offset 0x14): a 16-bit write (strh into a read-modify-write copy, upper half preserved). Used only for BT.601 / digital camera input with explicit sync timing (VIU_DRV_SetChnIntfCfg); the name comes from the vendor function name, the units (pixels or lines) and valid range are UNKNOWN. Confidence MEDIUM for the offset and 16-bit width, LOW for the meaning. Not verified on hardware. The name is VENDOR-DERIVED (from the HAL function name, not documented); access observed: written only (16-bit read-modify-write), value = the VI timing blank configuration given by the application (no constants). Unknown purpose, vendor-observed only, confidence LOW, not verified on hardware.";

        field {
            name = "value";
            desc = "[inferred] 16-bit timing value (vendor-derived, unit unknown).";
            sw = rw;
            hw = r;
            reset = 0x0;
        } value[15:0];
    } CH_HSYNC_HACT @ 0x314;

    reg {
        name = "[inferred] hsync back blank";
        desc = "[inferred] hsync back blank. NOT IN THE DATA SHEET. Source: vendor module hi3520D_viu.ko (Hi3520D_MPP_V2.0.5.1, HiMPP kernel module from the OpenIPC Hi3520D rootfs; static disassembly), VIU_HAL_SetChnHsync_*/SetChnVsync_*/SetChnTimingBlank (channel-group offset 0x318 = vendor GetChnReg offset 0x18): a 16-bit write (strh into a read-modify-write copy, upper half preserved). Used only for BT.601 / digital camera input with explicit sync timing (VIU_DRV_SetChnIntfCfg); the name comes from the vendor function name, the units (pixels or lines) and valid range are UNKNOWN. Confidence MEDIUM for the offset and 16-bit width, LOW for the meaning. Not verified on hardware. The name is VENDOR-DERIVED (from the HAL function name, not documented); access observed: written only (16-bit read-modify-write), value = the VI timing blank configuration given by the application (no constants). Unknown purpose, vendor-observed only, confidence LOW, not verified on hardware.";

        field {
            name = "value";
            desc = "[inferred] 16-bit timing value (vendor-derived, unit unknown).";
            sw = rw;
            hw = r;
            reset = 0x0;
        } value[15:0];
    } CH_HSYNC_HBB @ 0x318;

    reg {
        name = "[inferred] vsync field 1 front blank";
        desc = "[inferred] vsync field 1 front blank. NOT IN THE DATA SHEET. Source: vendor module hi3520D_viu.ko (Hi3520D_MPP_V2.0.5.1, HiMPP kernel module from the OpenIPC Hi3520D rootfs; static disassembly), VIU_HAL_SetChnHsync_*/SetChnVsync_*/SetChnTimingBlank (channel-group offset 0x320 = vendor GetChnReg offset 0x20): a 16-bit write (strh into a read-modify-write copy, upper half preserved). Used only for BT.601 / digital camera input with explicit sync timing (VIU_DRV_SetChnIntfCfg); the name comes from the vendor function name, the units (pixels or lines) and valid range are UNKNOWN. Confidence MEDIUM for the offset and 16-bit width, LOW for the meaning. Not verified on hardware. The name is VENDOR-DERIVED (from the HAL function name, not documented); access observed: written only (16-bit read-modify-write), value = the VI timing blank configuration given by the application (no constants). Unknown purpose, vendor-observed only, confidence LOW, not verified on hardware.";

        field {
            name = "value";
            desc = "[inferred] 16-bit timing value (vendor-derived, unit unknown).";
            sw = rw;
            hw = r;
            reset = 0x0;
        } value[15:0];
    } CH_VSYNC_VFB @ 0x320;

    reg {
        name = "[inferred] vsync field 1 active";
        desc = "[inferred] vsync field 1 active. NOT IN THE DATA SHEET. Source: vendor module hi3520D_viu.ko (Hi3520D_MPP_V2.0.5.1, HiMPP kernel module from the OpenIPC Hi3520D rootfs; static disassembly), VIU_HAL_SetChnHsync_*/SetChnVsync_*/SetChnTimingBlank (channel-group offset 0x324 = vendor GetChnReg offset 0x24): a 16-bit write (strh into a read-modify-write copy, upper half preserved). Used only for BT.601 / digital camera input with explicit sync timing (VIU_DRV_SetChnIntfCfg); the name comes from the vendor function name, the units (pixels or lines) and valid range are UNKNOWN. Confidence MEDIUM for the offset and 16-bit width, LOW for the meaning. Not verified on hardware. The name is VENDOR-DERIVED (from the HAL function name, not documented); access observed: written only (16-bit read-modify-write), value = the VI timing blank configuration given by the application (no constants). Unknown purpose, vendor-observed only, confidence LOW, not verified on hardware.";

        field {
            name = "value";
            desc = "[inferred] 16-bit timing value (vendor-derived, unit unknown).";
            sw = rw;
            hw = r;
            reset = 0x0;
        } value[15:0];
    } CH_VSYNC_VACT @ 0x324;

    reg {
        name = "[inferred] vsync field 1 back blank";
        desc = "[inferred] vsync field 1 back blank. NOT IN THE DATA SHEET. Source: vendor module hi3520D_viu.ko (Hi3520D_MPP_V2.0.5.1, HiMPP kernel module from the OpenIPC Hi3520D rootfs; static disassembly), VIU_HAL_SetChnHsync_*/SetChnVsync_*/SetChnTimingBlank (channel-group offset 0x328 = vendor GetChnReg offset 0x28): a 16-bit write (strh into a read-modify-write copy, upper half preserved). Used only for BT.601 / digital camera input with explicit sync timing (VIU_DRV_SetChnIntfCfg); the name comes from the vendor function name, the units (pixels or lines) and valid range are UNKNOWN. Confidence MEDIUM for the offset and 16-bit width, LOW for the meaning. Not verified on hardware. The name is VENDOR-DERIVED (from the HAL function name, not documented); access observed: written only (16-bit read-modify-write), value = the VI timing blank configuration given by the application (no constants). Unknown purpose, vendor-observed only, confidence LOW, not verified on hardware.";

        field {
            name = "value";
            desc = "[inferred] 16-bit timing value (vendor-derived, unit unknown).";
            sw = rw;
            hw = r;
            reset = 0x0;
        } value[15:0];
    } CH_VSYNC_VBB @ 0x328;

    reg {
        name = "[inferred] vsync field 2 front blank";
        desc = "[inferred] vsync field 2 front blank. NOT IN THE DATA SHEET. Source: vendor module hi3520D_viu.ko (Hi3520D_MPP_V2.0.5.1, HiMPP kernel module from the OpenIPC Hi3520D rootfs; static disassembly), VIU_HAL_SetChnHsync_*/SetChnVsync_*/SetChnTimingBlank (channel-group offset 0x330 = vendor GetChnReg offset 0x30): a 16-bit write (strh into a read-modify-write copy, upper half preserved). Used only for BT.601 / digital camera input with explicit sync timing (VIU_DRV_SetChnIntfCfg); the name comes from the vendor function name, the units (pixels or lines) and valid range are UNKNOWN. Confidence MEDIUM for the offset and 16-bit width, LOW for the meaning. Not verified on hardware. The name is VENDOR-DERIVED (from the HAL function name, not documented); access observed: written only (16-bit read-modify-write), value = the VI timing blank configuration given by the application (no constants). Unknown purpose, vendor-observed only, confidence LOW, not verified on hardware.";

        field {
            name = "value";
            desc = "[inferred] 16-bit timing value (vendor-derived, unit unknown).";
            sw = rw;
            hw = r;
            reset = 0x0;
        } value[15:0];
    } CH_VSYNC_VBFB @ 0x330;

    reg {
        name = "[inferred] vsync field 2 active";
        desc = "[inferred] vsync field 2 active. NOT IN THE DATA SHEET. Source: vendor module hi3520D_viu.ko (Hi3520D_MPP_V2.0.5.1, HiMPP kernel module from the OpenIPC Hi3520D rootfs; static disassembly), VIU_HAL_SetChnHsync_*/SetChnVsync_*/SetChnTimingBlank (channel-group offset 0x334 = vendor GetChnReg offset 0x34): a 16-bit write (strh into a read-modify-write copy, upper half preserved). Used only for BT.601 / digital camera input with explicit sync timing (VIU_DRV_SetChnIntfCfg); the name comes from the vendor function name, the units (pixels or lines) and valid range are UNKNOWN. Confidence MEDIUM for the offset and 16-bit width, LOW for the meaning. Not verified on hardware. The name is VENDOR-DERIVED (from the HAL function name, not documented); access observed: written only (16-bit read-modify-write), value = the VI timing blank configuration given by the application (no constants). Unknown purpose, vendor-observed only, confidence LOW, not verified on hardware.";

        field {
            name = "value";
            desc = "[inferred] 16-bit timing value (vendor-derived, unit unknown).";
            sw = rw;
            hw = r;
            reset = 0x0;
        } value[15:0];
    } CH_VSYNC_VBACT @ 0x334;

    reg {
        name = "[inferred] vsync field 2 back blank";
        desc = "[inferred] vsync field 2 back blank. NOT IN THE DATA SHEET. Source: vendor module hi3520D_viu.ko (Hi3520D_MPP_V2.0.5.1, HiMPP kernel module from the OpenIPC Hi3520D rootfs; static disassembly), VIU_HAL_SetChnHsync_*/SetChnVsync_*/SetChnTimingBlank (channel-group offset 0x338 = vendor GetChnReg offset 0x38): a 16-bit write (strh into a read-modify-write copy, upper half preserved). Used only for BT.601 / digital camera input with explicit sync timing (VIU_DRV_SetChnIntfCfg); the name comes from the vendor function name, the units (pixels or lines) and valid range are UNKNOWN. Confidence MEDIUM for the offset and 16-bit width, LOW for the meaning. Not verified on hardware. The name is VENDOR-DERIVED (from the HAL function name, not documented); access observed: written only (16-bit read-modify-write), value = the VI timing blank configuration given by the application (no constants). Unknown purpose, vendor-observed only, confidence LOW, not verified on hardware.";

        field {
            name = "value";
            desc = "[inferred] 16-bit timing value (vendor-derived, unit unknown).";
            sw = rw;
            hw = r;
            reset = 0x0;
        } value[15:0];
    } CH_VSYNC_VBBB @ 0x338;

    reg {
        name = "Frame sync delay register";
        desc = "CH_FSTART_DLY is frame sync delay register. The data sheet lists no bit fields for it.

Source: data sheet 11.1.6 CH_FSTART_DLY (offset 0x10360, printed page 11-29, `datasheet.txt` line 34379).

Source: vendor module hi3520D_viu.ko: no access found (not touched by any HAL function), confidence: nothing known. Not verified on hardware.";

        field {
            name = "value";
            desc = "Register value (the data sheet gives no bit table for this register).";
            sw = rw;
            hw = r;
            reset = 0x0;
        } value[31:0];
    } CH_FSTART_DLY @ 0x360;

    reg {
        name = "Channel control register";
        desc = "CH_CTRL is a channel control register.

Source: data sheet 11.1.6 CH_CTRL (offset 0x10400, printed page 11-29, `datasheet.txt` line 34398).

Source: vendor module hi3520D_viu.ko (Hi3520D_MPP_V2.0.5.1, HiMPP kernel module from the OpenIPC Hi3520D rootfs; static disassembly), VIU_HAL_SetChnEn (0x14718; read-modify-write of bit 0), confidence HIGH. Vendor sequencing (VIU_DRV_EnableChn_ByChip, ViuDrvInterruptRoute, ViuDrvChnProcess): the channel is first cleared (ch_en = 0), the raw interrupts are cleared (all ones written to CH_INT_RAW) and CH_INT_MASK is set to 1 (frame start only, VIU_DRV_GetDefIntMask = 1). ch_en is set to 1 ONLY LATER, from the frame-start interrupt handler, after the next buffer addresses have been written (ViuDrvProcCapFrm -> VIU_DRV_SetChnEn) -- i.e. the vendor takes frame-start interrupts with ch_en = 0, so the frame-start event (CH_INT_RAW bit 0) is generated by the port timing detection independently of ch_en and of buffers. The Linux driver sets ch_en and a buffer before the first frame start; that should be harmless but differs from the vendor. Not verified on hardware.";

        enum CH_CTRL_ch_en_enum {
            DISABLED = 0 { name = "Disabled"; desc = "disabled"; };
            ENABLED = 1 { name = "Enabled"; desc = "enabled"; };
        };

        field {
            name = "ch_en";
            desc = "Channel enable.";
            sw = rw;
            hw = r;
            encode = CH_CTRL_ch_en_enum;
            reset = 0x0;
        } ch_en[0:0];
    } CH_CTRL @ 0x400;

    reg {
        name = "Capture control register";
        desc = "CH_REG_NEWER is a capture control register.

Source: data sheet 11.1.6 CH_REG_NEWER (offset 0x10404, printed page 11-30, `datasheet.txt` line 34431).

Source: vendor module hi3520D_viu.ko (Hi3520D_MPP_V2.0.5.1, HiMPP kernel module from the OpenIPC Hi3520D rootfs; static disassembly), VIU_HAL_SetRegNewer (0x14788: read-modify-write, OR 1), called from the interrupt path after the buffer addresses (CH_YBASE_ADDR..CH_CLINE_OFFSET) were rewritten in the frame-start handler (ViuDrvChnIntProcess), confidence HIGH. Not verified on hardware.";

        field {
            name = "reg_newer";
            desc = "Channel updated. This bit is automatically cleared when a frame is received.";
            sw = rw;
            hw = r;
            reset = 0x0;
        } reg_newer[0:0];
    } CH_REG_NEWER @ 0x404;

    reg {
        name = "Crop start position register";
        desc = "CH_CROP_START is a crop start position register.

Source: data sheet 11.1.6 CH_CROP_START (offset 0x10410, printed page 11-30, `datasheet.txt` line 34458).

Source: vendor module hi3520D_viu.ko (Hi3520D_MPP_V2.0.5.1, HiMPP kernel module from the OpenIPC Hi3520D rootfs; static disassembly), VIU_HAL_SetChnCrop: x start in [11:0], y start in [27:16], written as plain values (not minus one), confidence HIGH. Not verified on hardware.";

        field {
            name = "y_start";
            desc = "Number of the line from which pictures start to be captured.";
            sw = rw;
            hw = r;
            reset = 0x0;
        } y_start[27:16];

        field {
            name = "x_start";
            desc = "Number of the pixel from which pictures start to be captured.";
            sw = rw;
            hw = r;
            reset = 0x0;
        } x_start[11:0];
    } CH_CROP_START @ 0x410;

    reg {
        name = "Crop size configuration register";
        desc = "CH_CROP_SIZE is a crop size configuration register.

Source: data sheet 11.1.6 CH_CROP_SIZE (offset 0x10414, printed page 11-30, `datasheet.txt` line 34480).

VENDOR CONFIRMS the size - 1 encoding (Source: vendor module hi3520D_viu.ko (Hi3520D_MPP_V2.0.5.1, HiMPP kernel module from the OpenIPC Hi3520D rootfs; static disassembly), VIU_HAL_SetChnCrop: the crop size words are written as width - 1 and height - 1, 12 bits each; VIU_HAL_SetChnYCDestSize writes the luma and chroma destination sizes as width - 1 / height - 1), confidence HIGH; the data-sheet description text 'in pixels/lines' is therefore imprecise (previously: size in pixels/lines). Not verified on hardware.";

        field {
            name = "crop_hgt";
            desc = "Height of a captured picture (in lines).";
            sw = rw;
            hw = r;
            reset = 0x23F;
        } crop_hgt[27:16];

        field {
            name = "crop_wth";
            desc = "Width of a line of a captured picture (in pixels).";
            sw = rw;
            hw = r;
            reset = 0x3BF;
        } crop_wth[11:0];
    } CH_CROP_SIZE @ 0x414;

    reg {
        name = "Raw stream luminance storage size register";
        desc = "CH_YDES_SIZE is a luminance storage size register.

Source: data sheet 11.1.6 CH_YDES_SIZE (offset 0x10418, printed page 11-31, `datasheet.txt` line 34511).

VENDOR CONFIRMS the size - 1 encoding (Source: vendor module hi3520D_viu.ko (Hi3520D_MPP_V2.0.5.1, HiMPP kernel module from the OpenIPC Hi3520D rootfs; static disassembly), VIU_HAL_SetChnCrop: the crop size words are written as width - 1 and height - 1, 12 bits each; VIU_HAL_SetChnYCDestSize writes the luma and chroma destination sizes as width - 1 / height - 1), confidence HIGH; the data-sheet description text 'in pixels/lines' is therefore imprecise (previously: size in pixels/lines). Not verified on hardware.";

        field {
            name = "height";
            desc = "Output height of the Y component (in lines).";
            sw = rw;
            hw = r;
            reset = 0x23F;
        } height[27:16];

        field {
            name = "width";
            desc = "Output width of the Y component (in pixels).";
            sw = rw;
            hw = r;
            reset = 0x3BF;
        } width[11:0];
    } CH_YDES_SIZE @ 0x418;

    reg {
        name = "Raw stream chrominance storage size register";
        desc = "CH_CDES_SIZE is a chrominance storage size register.

Source: data sheet 11.1.6 CH_CDES_SIZE (offset 0x1041C, printed page 11-31, `datasheet.txt` line 34533).

VENDOR CONFIRMS the size - 1 encoding (Source: vendor module hi3520D_viu.ko (Hi3520D_MPP_V2.0.5.1, HiMPP kernel module from the OpenIPC Hi3520D rootfs; static disassembly), VIU_HAL_SetChnCrop: the crop size words are written as width - 1 and height - 1, 12 bits each; VIU_HAL_SetChnYCDestSize writes the luma and chroma destination sizes as width - 1 / height - 1), confidence HIGH; the data-sheet description text 'in pixels/lines' is therefore imprecise (previously: size in pixels/lines). Not verified on hardware.";

        field {
            name = "height";
            desc = "Output height of the C component (in lines).";
            sw = rw;
            hw = r;
            reset = 0x23F;
        } height[27:16];

        field {
            name = "width";
            desc = "Output width of the C component (in pixels).";
            sw = rw;
            hw = r;
            reset = 0x3BF;
        } width[11:0];
    } CH_CDES_SIZE @ 0x41C;

    reg {
        name = "Raw stream luminance storage base address register";
        desc = "CH_YBASE_ADDR is a luminance storage base address register.

Source: data sheet 11.1.6 CH_YBASE_ADDR (offset 0x10420, printed page 11-32, `datasheet.txt` line 34564).

Source: vendor module hi3520D_viu.ko (Hi3520D_MPP_V2.0.5.1, HiMPP kernel module from the OpenIPC Hi3520D rootfs; static disassembly), VIU_HAL_SetOutPicMemInfo (word write at group offset +0x120), confidence HIGH. Not verified on hardware.";

        field {
            name = "ybase_addr";
            desc = "Base address for storing the luminance of the raw stream.";
            sw = rw;
            hw = r;
            reset = 0x0;
        } ybase_addr[31:0];
    } CH_YBASE_ADDR @ 0x420;

    reg {
        name = "Raw stream chrominance storage base address register";
        desc = "CH_CBASE_ADDR is a chrominance storage base address register.

Source: data sheet 11.1.6 CH_CBASE_ADDR (offset 0x10424, printed page 11-32, `datasheet.txt` line 34583).

Source: vendor module hi3520D_viu.ko (Hi3520D_MPP_V2.0.5.1, HiMPP kernel module from the OpenIPC Hi3520D rootfs; static disassembly), VIU_HAL_SetOutPicMemInfo (word write at +0x124), confidence HIGH. Not verified on hardware.";

        field {
            name = "cbase_addr";
            desc = "Base address for storing the chrominance of the raw stream.";
            sw = rw;
            hw = r;
            reset = 0x0;
        } cbase_addr[31:0];
    } CH_CBASE_ADDR @ 0x424;

    reg {
        name = "Raw stream luminance line offset register";
        desc = "CH_YLINE_OFFSET is a luminance line offset register.

Source: data sheet 11.1.6 CH_YLINE_OFFSET (offset 0x10428, printed page 11-32, `datasheet.txt` line 34601).

Source: vendor module hi3520D_viu.ko (Hi3520D_MPP_V2.0.5.1, HiMPP kernel module from the OpenIPC Hi3520D rootfs; static disassembly), VIU_HAL_SetOutPicMemInfo (16-bit write into [15:0], upper half preserved; ViuDrvStartCap passes line stride x 2 when a frame is captured as two interleaved fields, and the plain stride otherwise), confidence HIGH. Not verified on hardware.";

        field {
            name = "y_stride";
            desc = "Stride for storing the picture luminance (in bytes).";
            sw = rw;
            hw = r;
            reset = 0x3C0;
        } y_stride[15:0];
    } CH_YLINE_OFFSET @ 0x428;

    reg {
        name = "Raw stream chrominance line offset register";
        desc = "CH_CLINE_OFFSET is a chrominance line offset register.

Source: data sheet 11.1.6 CH_CLINE_OFFSET (offset 0x1042C, printed page 11-33, `datasheet.txt` line 34630).

Source: vendor module hi3520D_viu.ko (Hi3520D_MPP_V2.0.5.1, HiMPP kernel module from the OpenIPC Hi3520D rootfs; static disassembly), VIU_HAL_SetOutPicMemInfo (16-bit write into [15:0]), confidence HIGH. Not verified on hardware.";

        field {
            name = "c_stride";
            desc = "Stride for storing the picture chrominance (in bytes).";
            sw = rw;
            hw = r;
            reset = 0x3C0;
        } c_stride[15:0];
    } CH_CLINE_OFFSET @ 0x42C;

    reg {
        name = "Channel raw interrupt register";
        desc = "CH_INT_RAW is a channel raw interrupt register.

Source: data sheet 11.1.6 CH_INT_RAW (offset 0x10430, printed page 11-33, `datasheet.txt` line 34650).

Source: vendor module hi3520D_viu.ko (Hi3520D_MPP_V2.0.5.1, HiMPP kernel module from the OpenIPC Hi3520D rootfs; static disassembly), VIU_HAL_GetRawIntStatus (+0x130), VIU_HAL_ClrInterruptStatus (write of the read value OR mask back to +0x130; the vendor clears with all ones at channel enable), confidence HIGH. The vendor interrupt handler (ViuDrvInterruptRoute, GIC ID 68 = 0x44 passed to request_threaded_irq) first reads VICAP_INT, then per channel the masked status (CH_INT) and raw status, clears, and tests bits 0 (frame start), 8 (field throw) and 17 (buffer overflow, VIU_HAL_BUFOVF). Default enabled mask = bit 0 only. Not verified on hardware.";

        enum CH_INT_RAW_bus_err_enum {
            NO_RAW_INTERRUPT = 0 { name = "No Raw Interrupt"; desc = "No raw interrupt is generated."; };
            RAW_INTERRUPT_GENERATED = 1 { name = "Raw Interrupt Generated"; desc = "A raw interrupt is generated."; };
        };

        field {
            name = "bus_err";
            desc = "Status of the bus error interrupt. Writing 1 clears this interrupt.";
            sw = rw;
            hw = w;
            onwrite = woclr;
            encode = CH_INT_RAW_bus_err_enum;
            reset = 0x0;
        } bus_err[18:18];

        enum CH_INT_RAW_buf_ovf_enum {
            NO_RAW_INTERRUPT = 0 { name = "No Raw Interrupt"; desc = "No raw interrupt is generated."; };
            RAW_INTERRUPT_GENERATED = 1 { name = "Raw Interrupt Generated"; desc = "A raw interrupt is generated."; };
        };

        field {
            name = "buf_ovf";
            desc = "Status of the internal FIFO overflow error interrupt. Writing 1 clears this interrupt.";
            sw = rw;
            hw = w;
            onwrite = woclr;
            encode = CH_INT_RAW_buf_ovf_enum;
            reset = 0x0;
        } buf_ovf[17:17];

        enum CH_INT_RAW_cc_int_enum {
            NO_RAW_INTERRUPT = 0 { name = "No Raw Interrupt"; desc = "No raw interrupt is generated."; };
            RAW_INTERRUPT_GENERATED = 1 { name = "Raw Interrupt Generated"; desc = "A raw interrupt is generated."; };
        };

        field {
            name = "cc_int";
            desc = "Status o the capture completion interrupt. Writing 1 clears this interrupt.";
            sw = rw;
            hw = w;
            onwrite = woclr;
            encode = CH_INT_RAW_cc_int_enum;
            reset = 0x0;
        } cc_int[16:16];

        enum CH_INT_RAW_timing_err_enum {
            NO_RAW_INTERRUPT = 0 { name = "No Raw Interrupt"; desc = "No raw interrupt is generated."; };
            RAW_INTERRUPT_GENERATED = 1 { name = "Raw Interrupt Generated"; desc = "A raw interrupt is generated."; };
        };

        field {
            name = "timing_err";
            desc = "Status of the timing error interrupt. Writing 1 clears this interrupt.";
            sw = rw;
            hw = w;
            onwrite = woclr;
            encode = CH_INT_RAW_timing_err_enum;
            reset = 0x0;
        } timing_err[9:9];

        enum CH_INT_RAW_field_throw_enum {
            NO_RAW_INTERRUPT = 0 { name = "No Raw Interrupt"; desc = "No raw interrupt is generated."; };
            RAW_INTERRUPT_GENERATED = 1 { name = "Raw Interrupt Generated"; desc = "A raw interrupt is generated."; };
        };

        field {
            name = "field_throw";
            desc = "Status of the field/frame loss interrupt. Writing 1 clears this interrupt.";
            sw = rw;
            hw = w;
            onwrite = woclr;
            encode = CH_INT_RAW_field_throw_enum;
            reset = 0x0;
        } field_throw[8:8];

        enum CH_INT_RAW_reg_update_enum {
            NO_RAW_INTERRUPT = 0 { name = "No Raw Interrupt"; desc = "No raw interrupt is generated."; };
            RAW_INTERRUPT_GENERATED = 1 { name = "Raw Interrupt Generated"; desc = "A raw interrupt is generated."; };
        };

        field {
            name = "reg_update";
            desc = "Status of the register update interrupt. Writing 1 clears this interrupt.";
            sw = rw;
            hw = w;
            onwrite = woclr;
            encode = CH_INT_RAW_reg_update_enum;
            reset = 0x0;
        } reg_update[1:1];

        enum CH_INT_RAW_fstart_enum {
            NO_RAW_INTERRUPT = 0 { name = "No Raw Interrupt"; desc = "No raw interrupt is generated."; };
            RAW_INTERRUPT_GENERATED = 1 { name = "Raw Interrupt Generated"; desc = "A raw interrupt is generated."; };
        };

        field {
            name = "fstart";
            desc = "Status of the field/frame start interrupt. Writing 1 clears this interrupt.";
            sw = rw;
            hw = w;
            onwrite = woclr;
            encode = CH_INT_RAW_fstart_enum;
            reset = 0x0;
        } fstart[0:0];
    } CH_INT_RAW @ 0x430;

    reg {
        name = "Channel interrupt register";
        desc = "CH_INT is a channel interrupt register.

Source: data sheet 11.1.6 CH_INT (offset 0x10434, printed page 11-34, `datasheet.txt` line 34719).";

        enum CH_INT_bus_err_enum {
            NO_RAW_INTERRUPT = 0 { name = "No Raw Interrupt"; desc = "No raw interrupt is generated."; };
            RAW_INTERRUPT_GENERATED = 1 { name = "Raw Interrupt Generated"; desc = "A raw interrupt is generated."; };
        };

        field {
            name = "bus_err";
            desc = "Status of the bus error interrupt.";
            sw = r;
            hw = w;
            encode = CH_INT_bus_err_enum;
            reset = 0x0;
        } bus_err[18:18];

        enum CH_INT_buf_ovf_enum {
            NO_RAW_INTERRUPT = 0 { name = "No Raw Interrupt"; desc = "No raw interrupt is generated."; };
            RAW_INTERRUPT_GENERATED = 1 { name = "Raw Interrupt Generated"; desc = "A raw interrupt is generated."; };
        };

        field {
            name = "buf_ovf";
            desc = "Status of the internal FIFO overflow error interrupt.";
            sw = r;
            hw = w;
            encode = CH_INT_buf_ovf_enum;
            reset = 0x0;
        } buf_ovf[17:17];

        enum CH_INT_cc_int_enum {
            NO_RAW_INTERRUPT = 0 { name = "No Raw Interrupt"; desc = "No raw interrupt is generated."; };
            RAW_INTERRUPT_GENERATED = 1 { name = "Raw Interrupt Generated"; desc = "A raw interrupt is generated."; };
        };

        field {
            name = "cc_int";
            desc = "Status of the capture completion interrupt.";
            sw = r;
            hw = w;
            encode = CH_INT_cc_int_enum;
            reset = 0x0;
        } cc_int[16:16];

        enum CH_INT_timing_err_enum {
            NO_RAW_INTERRUPT = 0 { name = "No Raw Interrupt"; desc = "No raw interrupt is generated."; };
            RAW_INTERRUPT_GENERATED = 1 { name = "Raw Interrupt Generated"; desc = "A raw interrupt is generated."; };
        };

        field {
            name = "timing_err";
            desc = "Status of the timing error interrupt.";
            sw = r;
            hw = w;
            encode = CH_INT_timing_err_enum;
            reset = 0x0;
        } timing_err[9:9];

        enum CH_INT_field_throw_enum {
            NO_RAW_INTERRUPT = 0 { name = "No Raw Interrupt"; desc = "No raw interrupt is generated."; };
            RAW_INTERRUPT_GENERATED = 1 { name = "Raw Interrupt Generated"; desc = "A raw interrupt is generated."; };
        };

        field {
            name = "field_throw";
            desc = "Status of the field/frame loss interrupt.";
            sw = r;
            hw = w;
            encode = CH_INT_field_throw_enum;
            reset = 0x0;
        } field_throw[8:8];

        enum CH_INT_reg_update_enum {
            NO_RAW_INTERRUPT = 0 { name = "No Raw Interrupt"; desc = "No raw interrupt is generated."; };
            RAW_INTERRUPT_GENERATED = 1 { name = "Raw Interrupt Generated"; desc = "A raw interrupt is generated."; };
        };

        field {
            name = "reg_update";
            desc = "Status of the register update interrupt.";
            sw = r;
            hw = w;
            encode = CH_INT_reg_update_enum;
            reset = 0x0;
        } reg_update[1:1];

        enum CH_INT_fstart_enum {
            NO_RAW_INTERRUPT = 0 { name = "No Raw Interrupt"; desc = "No raw interrupt is generated."; };
            RAW_INTERRUPT_GENERATED = 1 { name = "Raw Interrupt Generated"; desc = "A raw interrupt is generated."; };
        };

        field {
            name = "fstart";
            desc = "Status of the frame/field start interrupt.";
            sw = r;
            hw = w;
            encode = CH_INT_fstart_enum;
            reset = 0x0;
        } fstart[0:0];
    } CH_INT @ 0x434;

    reg {
        name = "Channel interrupt mask register";
        desc = "CH_INT_MASK is a channel interrupt mask register.

Source: data sheet 11.1.6 CH_INT_MASK (offset 0x10438, printed page 11-36, `datasheet.txt` line 34784).

Source: vendor module hi3520D_viu.ko (Hi3520D_MPP_V2.0.5.1, HiMPP kernel module from the OpenIPC Hi3520D rootfs; static disassembly), VIU_HAL_SetIntMask / GetIntMask (+0x138), default mask written at channel enable = 1 (VIU_DRV_GetDefIntMask), confidence HIGH. Not verified on hardware.";

        enum CH_INT_MASK_bus_err_en_enum {
            MASKED = 0 { name = "Masked"; desc = "masked"; };
            ENABLED = 1 { name = "Enabled"; desc = "enabled"; };
        };

        field {
            name = "bus_err_en";
            desc = "Raw stream bus error interrupt enable.";
            sw = rw;
            hw = r;
            encode = CH_INT_MASK_bus_err_en_enum;
            reset = 0x0;
        } bus_err_en[18:18];

        enum CH_INT_MASK_buf_ovf_en_enum {
            MASKED = 0 { name = "Masked"; desc = "masked"; };
            ENABLED = 1 { name = "Enabled"; desc = "enabled"; };
        };

        field {
            name = "buf_ovf_en";
            desc = "Raw stream internal FIFO overflow error interrupt enable.";
            sw = rw;
            hw = r;
            encode = CH_INT_MASK_buf_ovf_en_enum;
            reset = 0x0;
        } buf_ovf_en[17:17];

        enum CH_INT_MASK_cc_int_en_enum {
            MASKED = 0 { name = "Masked"; desc = "masked"; };
            ENABLED = 1 { name = "Enabled"; desc = "enabled"; };
        };

        field {
            name = "cc_int_en";
            desc = "Raw stream capture completion interrupt enable.";
            sw = rw;
            hw = r;
            encode = CH_INT_MASK_cc_int_en_enum;
            reset = 0x0;
        } cc_int_en[16:16];

        enum CH_INT_MASK_timing_err_en_enum {
            MASKED = 0 { name = "Masked"; desc = "masked"; };
            ENABLED = 1 { name = "Enabled"; desc = "enabled"; };
        };

        field {
            name = "timing_err_en";
            desc = "Timing error interrupt enable.";
            sw = rw;
            hw = r;
            encode = CH_INT_MASK_timing_err_en_enum;
            reset = 0x0;
        } timing_err_en[9:9];

        enum CH_INT_MASK_field_throw_en_enum {
            MASKED = 0 { name = "Masked"; desc = "masked"; };
            ENABLED = 1 { name = "Enabled"; desc = "enabled"; };
        };

        field {
            name = "field_throw_en";
            desc = "Field/Frame loss interrupt enable.";
            sw = rw;
            hw = r;
            encode = CH_INT_MASK_field_throw_en_enum;
            reset = 0x0;
        } field_throw_en[8:8];

        enum CH_INT_MASK_reg_update_en_enum {
            MASKED = 0 { name = "Masked"; desc = "masked"; };
            ENABLED = 1 { name = "Enabled"; desc = "enabled"; };
        };

        field {
            name = "reg_update_en";
            desc = "Register update interrupt enable.";
            sw = rw;
            hw = r;
            encode = CH_INT_MASK_reg_update_en_enum;
            reset = 0x0;
        } reg_update_en[1:1];

        enum CH_INT_MASK_fstart_en_enum {
            MASKED = 0 { name = "Masked"; desc = "masked"; };
            ENABLED = 1 { name = "Enabled"; desc = "enabled"; };
        };

        field {
            name = "fstart_en";
            desc = "Frame/field start interrupt enable.";
            sw = rw;
            hw = r;
            encode = CH_INT_MASK_fstart_en_enum;
            reset = 0x0;
        } fstart_en[0:0];
    } CH_INT_MASK @ 0x438;

    reg {
        name = "Channel status register";
        desc = "CH_STATUS is a channel status register.

Source: data sheet 11.1.6 CH_STATUS (offset 0x1043C, printed page 11-37, `datasheet.txt` line 34840).

Source: vendor module hi3520D_viu.ko (Hi3520D_MPP_V2.0.5.1, HiMPP kernel module from the OpenIPC Hi3520D rootfs; static disassembly), VIU_HAL_IsInCapTop reads +0x13c bit 0 (returns NOT bit0; used to decide whether the capture is in the top field), confidence MEDIUM for the meaning, HIGH for the position. Not verified on hardware.";

        enum CH_STATUS_busy_enum {
            IDLE = 0 { name = "Idle"; desc = "idle"; };
            BUSY = 1 { name = "Busy"; desc = "busy"; };
        };

        field {
            name = "busy";
            desc = "Working status.";
            sw = r;
            hw = w;
            encode = CH_STATUS_busy_enum;
            reset = 0x0;
        } busy[19:19];

        enum CH_STATUS_bus_err_enum {
            CORRECT = 0 { name = "Correct"; desc = "correct"; };
            INCORRECT = 1 { name = "Incorrect"; desc = "incorrect"; };
        };

        field {
            name = "bus_err";
            desc = "Bus error.";
            sw = r;
            hw = w;
            encode = CH_STATUS_bus_err_enum;
            reset = 0x0;
        } bus_err[18:18];

        enum CH_STATUS_buf_ovf_enum {
            NOT_OVERFLOW = 0 { name = "Not Overflow"; desc = "not overflow"; };
            OVERFLOW_V = 1 { name = "Overflow V"; desc = "overflow"; };
        };

        field {
            name = "buf_ovf";
            desc = "Internal buffer overflow.";
            sw = r;
            hw = w;
            encode = CH_STATUS_buf_ovf_enum;
            reset = 0x0;
        } buf_ovf[17:17];

        enum CH_STATUS_image_done_enum {
            NOT_COMPLETE = 0 { name = "Not Complete"; desc = "not complete"; };
            COMPLETE = 1 { name = "Complete"; desc = "complete"; };
        };

        field {
            name = "image_done";
            desc = "Capture completion.";
            sw = r;
            hw = w;
            encode = CH_STATUS_image_done_enum;
            reset = 0x0;
        } image_done[16:16];

        enum CH_STATUS_timing_err_enum {
            CORRECT = 0 { name = "Correct"; desc = "correct"; };
            INCORRECT = 1 { name = "Incorrect"; desc = "incorrect"; };
        };

        field {
            name = "timing_err";
            desc = "Timing error status.";
            sw = r;
            hw = w;
            encode = CH_STATUS_timing_err_enum;
            reset = 0x0;
        } timing_err[9:9];

        enum CH_STATUS_field_throw_enum {
            NOT_LOST = 0 { name = "Not Lost"; desc = "not lost"; };
            LOST = 1 { name = "Lost"; desc = "lost"; };
        };

        field {
            name = "field_throw";
            desc = "Field/Frame data loss.";
            sw = r;
            hw = w;
            encode = CH_STATUS_field_throw_enum;
            reset = 0x0;
        } field_throw[8:8];

        enum CH_STATUS_field2_enum {
            ODD_FIELD = 0 { name = "Odd Field"; desc = "odd field"; };
            EVEN_FIELD = 1 { name = "Even Field"; desc = "even field"; };
        };

        field {
            name = "field2";
            desc = "Odd/Even field indicator.";
            sw = r;
            hw = w;
            encode = CH_STATUS_field2_enum;
            reset = 0x0;
        } field2[0:0];
    } CH_STATUS @ 0x43C;

    reg {
        name = "Channel size indication register E";
        desc = "CH_IPI_STATUS_SIZE is a channel size indication register.

Source: data sheet 11.1.6 CH_IPI_STATUS_SIZE (offset 0x10440, printed page 11-38, `datasheet.txt` line 34900).

Source: vendor module hi3520D_viu.ko (Hi3520D_MPP_V2.0.5.1, HiMPP kernel module from the OpenIPC Hi3520D rootfs; static disassembly), VIU_HAL_GetStatusSize: a halfword read at +0x142 (= [31:16], height), confidence HIGH for the height; the width in [15:0] is NOT read by the vendor (the width field is still unknown, LOW). Not verified on hardware.";

        field {
            name = "height";
            desc = "Picture height.";
            sw = r;
            hw = w;
            reset = 0x0;
        } height[31:16];
    } CH_IPI_STATUS_SIZE @ 0x440;

    reg {
        name = "Channel SEAV indication register AV";
        desc = "CH_IPI_STATUS_SEAV is a channel SEAV indication register.

Source: data sheet 11.1.6 CH_IPI_STATUS_SEAV (offset 0x10444, printed page 11-38, `datasheet.txt` line 34920).

Source: vendor module hi3520D_viu.ko (Hi3520D_MPP_V2.0.5.1, HiMPP kernel module from the OpenIPC Hi3520D rootfs; static disassembly), VIU_HAL_GetStatusSEAV: byte read at +0x145 (= bits [15:8]), confidence HIGH. Not verified on hardware.";

        field {
            name = "SEAV";
            desc = "SEAV code value.";
            sw = r;
            hw = w;
            reset = 0x0;
        } SEAV[15:8];
    } CH_IPI_STATUS_SEAV @ 0x444;

    reg {
        name = "Dither configuration register";
        desc = "CH_DITHER_CFG is a dither configuration register.

Source: data sheet 11.1.6 CH_DITHER_CFG (offset 0x10500, printed page 11-39, `datasheet.txt` line 34951).

Source: vendor module hi3520D_viu.ko (Hi3520D_MPP_V2.0.5.1, HiMPP kernel module from the OpenIPC Hi3520D rootfs; static disassembly), VIU_HAL_SetDitherMode (bits [31:29] written at +0x200), confidence HIGH for the position. Not verified on hardware.";

        enum CH_DITHER_CFG_dither_md_enum {
            V_12_BIT_INPUTS = 0 { name = "V 12 Bit Inputs"; desc = "12-bit inputs, 10-bit outputs, no dithering, and direct bit truncation"; };
            V_12_BIT_INPUTS_2 = 1 { name = "V 12 Bit Inputs 2"; desc = "12-bit inputs, 10-bit output, and time-domain dithering"; };
            V_12_BIT_INPUTS_3 = 2 { name = "V 12 Bit Inputs 3"; desc = "12-bit inputs, 10-bit output, and spatial-domain dithering"; };
            V_12_BIT_INPUTS_4 = 3 { name = "V 12 Bit Inputs 4"; desc = "12-bit inputs, 8-bit output, and time-domain and spatial- domain dithering"; };
            V_12_BIT_INPUTS_5 = 4 { name = "V 12 Bit Inputs 5"; desc = "12-bit inputs, 10-bit outputs, and round off"; };
            V_12_BIT_INPUTS_6 = 5 { name = "V 12 Bit Inputs 6"; desc = "12-bit inputs, 8-bit outputs, and round off"; };
            DITHERING_BYPASS = 7 { name = "Dithering Bypass"; desc = "dithering bypass"; };
        };

        field {
            name = "dither_md";
            desc = "Dither mode select. The data sheet (issue 02) gives the register a total reset value of 0xE000_0000, i.e. this field resets to 7 (dither bypass).";
            sw = rw;
            hw = r;
            encode = CH_DITHER_CFG_dither_md_enum;
            reset = 0x7;
        } dither_md[31:29];
    } CH_DITHER_CFG @ 0x500;

    reg {
        name = "Dither coefficient register 0";
        desc = "CH_DITHER_COEF0 is dither coefficient register 0.

Source: data sheet 11.1.6 CH_DITHER_COEF0 (offset 0x10504, printed page 11-39, `datasheet.txt` line 34984).";

        field {
            name = "dither_coef3";
            desc = "Coefficient 3 for the dither in time-domain mode.";
            sw = rw;
            hw = r;
            reset = 0xDD;
        } dither_coef3[31:24];

        field {
            name = "dither_coef2";
            desc = "Coefficient 2 for the dither in time-domain mode.";
            sw = rw;
            hw = r;
            reset = 0x66;
        } dither_coef2[23:16];

        field {
            name = "dither_coef1";
            desc = "Coefficient 1 for the dither in time-domain mode.";
            sw = rw;
            hw = r;
            reset = 0x44;
        } dither_coef1[15:8];

        field {
            name = "dither_coef0";
            desc = "Coefficient 0 for the dither in time-domain mode.";
            sw = rw;
            hw = r;
            reset = 0x0;
        } dither_coef0[7:0];
    } CH_DITHER_COEF0 @ 0x504;

    reg {
        name = "Dither coefficient register 1";
        desc = "CH_DITHER_COEF1 is dither coefficient register 1.

Source: data sheet 11.1.6 CH_DITHER_COEF1 (offset 0x10508, printed page 11-40, `datasheet.txt` line 35012).";

        field {
            name = "dither_coef7";
            desc = "Coefficient 7 for the dither in time-domain mode.";
            sw = rw;
            hw = r;
            reset = 0xDD;
        } dither_coef7[31:24];

        field {
            name = "dither_coef6";
            desc = "Coefficient 6 for the dither in time-domain mode.";
            sw = rw;
            hw = r;
            reset = 0x66;
        } dither_coef6[23:16];

        field {
            name = "dither_coef5";
            desc = "Coefficient 5 for the dither in time-domain mode.";
            sw = rw;
            hw = r;
            reset = 0x44;
        } dither_coef5[15:8];

        field {
            name = "dither_coef4";
            desc = "Coefficient 4 for the dither in time-domain mode.";
            sw = rw;
            hw = r;
            reset = 0x0;
        } dither_coef4[7:0];
    } CH_DITHER_COEF1 @ 0x508;

    reg {
        name = "Dither input picture width register";
        desc = "CH_DITHER_SIZE is a dither input picture width register.

Source: data sheet 11.1.6 CH_DITHER_SIZE (offset 0x1050C, printed page 11-40, `datasheet.txt` line 35034).

Source: vendor module hi3520D_viu.ko (Hi3520D_MPP_V2.0.5.1, HiMPP kernel module from the OpenIPC Hi3520D rootfs; static disassembly), VIU_HAL_SetDitherSize ([11:0] at +0x20c), confidence HIGH. Not verified on hardware.";

        field {
            name = "width";
            desc = "Input picture width of the dither.";
            sw = rw;
            hw = r;
            reset = 0x3BF;
        } width[11:0];
    } CH_DITHER_SIZE @ 0x50C;

    reg {
        name = "Raw stream mirror control register";
        desc = "CH_MIR_CTRL is a raw stream mirror control register.

Source: data sheet 11.1.6 CH_MIR_CTRL (offset 0x10510, printed page 11-41, `datasheet.txt` line 35063).

Source: vendor module hi3520D_viu.ko (Hi3520D_MPP_V2.0.5.1, HiMPP kernel module from the OpenIPC Hi3520D rootfs; static disassembly), VIU_HAL_SetChnMirrorEn (bit 0), VIU_HAL_SetChnFlipEn (bit 1) at +0x210, confidence HIGH (matches the data-sheet positions). Not verified on hardware.";

        enum CH_MIR_CTRL_flip_en_enum {
            DISABLED = 0 { name = "Disabled"; desc = "disabled"; };
            ENABLED = 1 { name = "Enabled"; desc = "enabled"; };
        };

        field {
            name = "flip_en";
            desc = "Flip enable.";
            sw = rw;
            hw = r;
            encode = CH_MIR_CTRL_flip_en_enum;
            reset = 0x0;
        } flip_en[1:1];

        enum CH_MIR_CTRL_mir_en_enum {
            DISABLED = 0 { name = "Disabled"; desc = "disabled"; };
            ENABLED = 1 { name = "Enabled"; desc = "enabled"; };
        };

        field {
            name = "mir_en";
            desc = "Mirror enable. Called we_en in the data sheet bit table (issue 02), described there as horizontal inversion enable; the bit diagram calls it mir_in.";
            sw = rw;
            hw = r;
            encode = CH_MIR_CTRL_mir_en_enum;
            reset = 0x0;
        } mir_en[0:0];
    } CH_MIR_CTRL @ 0x510;

    reg {
        name = "Block mask configuration register";
        desc = "CH_MSC_CFG is a block mask configuration register.

Source: data sheet 11.1.6 CH_MSC_CFG (offset 0x10700, printed page 11-41, `datasheet.txt` line 35090).

Source: vendor module hi3520D_viu.ko (Hi3520D_MPP_V2.0.5.1, HiMPP kernel module from the OpenIPC Hi3520D rootfs; static disassembly), Viu_HAL_SetBlockFill: bits 0..3 enable block 0..3 at +0x400 (written from a block count), confidence HIGH. The block start registers (+0x410..) take x [11:0] / y [27:16], the size registers (+0x450..) take width - 1 / height - 1 (12 bits each), the color registers (+0x490..) a 32-bit value. Not verified on hardware.";

        enum CH_MSC_CFG_msc3_en_enum {
            DISABLED = 0 { name = "Disabled"; desc = "disabled"; };
            ENABLED = 1 { name = "Enabled"; desc = "enabled"; };
        };

        field {
            name = "msc3_en";
            desc = "Block 3 mask enable.";
            sw = rw;
            hw = r;
            encode = CH_MSC_CFG_msc3_en_enum;
            reset = 0x0;
        } msc3_en[3:3];

        enum CH_MSC_CFG_msc2_en_enum {
            DISABLED = 0 { name = "Disabled"; desc = "disabled"; };
            ENABLED = 1 { name = "Enabled"; desc = "enabled"; };
        };

        field {
            name = "msc2_en";
            desc = "Block 2 mask enable.";
            sw = rw;
            hw = r;
            encode = CH_MSC_CFG_msc2_en_enum;
            reset = 0x0;
        } msc2_en[2:2];

        field {
            name = "msc1_en";
            desc = "msc1_en";
            sw = rw;
            hw = r;
            reset = 0x0;
        } msc1_en[1:1];

        field {
            name = "msc0_en";
            desc = "msc0_en";
            sw = rw;
            hw = r;
            reset = 0x0;
        } msc0_en[0:0];
    } CH_MSC_CFG @ 0x700;

    reg {
        name = "Mask start position register for block 0";
        desc = "CH_BLOCK0_START is the mask start position register for block 0.

Source: data sheet 11.1.6 CH_BLOCK0_START (offset 0x10710, printed page 11-42, `datasheet.txt` line 35151).";

        field {
            name = "y_start";
            desc = "Vertical start point for masking block 0.";
            sw = rw;
            hw = r;
            reset = 0x0;
        } y_start[27:16];

        field {
            name = "x_start";
            desc = "Horizontal start point for masking block 0.";
            sw = rw;
            hw = r;
            reset = 0x0;
        } x_start[11:0];
    } CH_BLOCK0_START @ 0x710;

    reg {
        name = "Mask start position register for block 1";
        desc = "CH_BLOCK1_START is the mask start position register for block 1.

Source: data sheet 11.1.6 CH_BLOCK1_START (offset 0x10714, printed page 11-43, `datasheet.txt` line 35182).";

        field {
            name = "y_start";
            desc = "Vertical start point for masking block 1.";
            sw = rw;
            hw = r;
            reset = 0x0;
        } y_start[27:16];

        field {
            name = "x_start";
            desc = "Horizontal start point for masking block 1.";
            sw = rw;
            hw = r;
            reset = 0x0;
        } x_start[11:0];
    } CH_BLOCK1_START @ 0x714;

    reg {
        name = "Mask start position register for block 2";
        desc = "CH_BLOCK2_START is the mask start position register for block 2.

Source: data sheet 11.1.6 CH_BLOCK2_START (offset 0x10718, printed page 11-43, `datasheet.txt` line 35204).";

        field {
            name = "y_start";
            desc = "Vertical start point for masking block 2.";
            sw = rw;
            hw = r;
            reset = 0x0;
        } y_start[27:16];

        field {
            name = "x_start";
            desc = "Horizontal start point for masking block 2.";
            sw = rw;
            hw = r;
            reset = 0x0;
        } x_start[11:0];
    } CH_BLOCK2_START @ 0x718;

    reg {
        name = "Mask start position register for block 3";
        desc = "CH_BLOCK3_START is the mask start position register for block 3.

Source: data sheet 11.1.6 CH_BLOCK3_START (offset 0x1071C, printed page 11-43, `datasheet.txt` line 35226).";

        field {
            name = "y_start";
            desc = "Vertical start point for masking block 3.";
            sw = rw;
            hw = r;
            reset = 0x0;
        } y_start[27:16];

        field {
            name = "x_start";
            desc = "Horizontal start point for masking block 3.";
            sw = rw;
            hw = r;
            reset = 0x0;
        } x_start[11:0];
    } CH_BLOCK3_START @ 0x71C;

    reg {
        name = "Mask size register for block 0";
        desc = "CH_BLOCK0_SIZE is the mask size register for block 0.

Source: data sheet 11.1.6 CH_BLOCK0_SIZE (offset 0x10750, printed page 11-44, `datasheet.txt` line 35257).";

        field {
            name = "blk_height";
            desc = "Height for masking block 0 minus 1.";
            sw = rw;
            hw = r;
            reset = 0x0;
        } blk_height[27:16];

        field {
            name = "blk_width";
            desc = "Width for masking block 0 minus 1.";
            sw = rw;
            hw = r;
            reset = 0x0;
        } blk_width[11:0];
    } CH_BLOCK0_SIZE @ 0x750;

    reg {
        name = "Mask size register for block 1";
        desc = "CH_BLOCK1_SIZE is the mask size register for block 1.

Source: data sheet 11.1.6 CH_BLOCK1_SIZE (offset 0x10754, printed page 11-44, `datasheet.txt` line 35279).";

        field {
            name = "blk_height";
            desc = "Height for masking block 1 minus 1.";
            sw = rw;
            hw = r;
            reset = 0x0;
        } blk_height[27:16];

        field {
            name = "blk_width";
            desc = "blk_width";
            sw = rw;
            hw = r;
            reset = 0x0;
        } blk_width[11:0];
    } CH_BLOCK1_SIZE @ 0x754;

    reg {
        name = "Mask size register for block 2";
        desc = "CH_BLOCK2_SIZE is the mask size register for block 2.

Source: data sheet 11.1.6 CH_BLOCK2_SIZE (offset 0x10758, printed page 11-45, `datasheet.txt` line 35321).";

        field {
            name = "blk_height";
            desc = "Height for masking block 2 minus 1.";
            sw = rw;
            hw = r;
            reset = 0x0;
        } blk_height[27:16];

        field {
            name = "blk_width";
            desc = "Width for masking block 2 minus 1.";
            sw = rw;
            hw = r;
            reset = 0x0;
        } blk_width[11:0];
    } CH_BLOCK2_SIZE @ 0x758;

    reg {
        name = "Mask size register for block 3";
        desc = "CH_BLOCK3_SIZE is the mask size register for block 3.

Source: data sheet 11.1.6 CH_BLOCK3_SIZE (offset 0x1075C, printed page 11-45, `datasheet.txt` line 35342).";

        field {
            name = "blk_height";
            desc = "Height for masking block 3 minus 1.";
            sw = rw;
            hw = r;
            reset = 0x0;
        } blk_height[27:16];

        field {
            name = "blk_width";
            desc = "blk_width";
            sw = rw;
            hw = r;
            reset = 0x0;
        } blk_width[11:0];
    } CH_BLOCK3_SIZE @ 0x75C;

    reg {
        name = "Filling color register for block 0";
        desc = "CH_BLOCK0_COLOR is the filling color register for block 0.

Source: data sheet 11.1.6 CH_BLOCK0_COLOR (offset 0x10790, printed page 11-46, `datasheet.txt` line 35385).";

        field {
            name = "blk_cr";
            desc = "Cr component of the filling color of block 0.";
            sw = rw;
            hw = r;
            reset = 0x0;
        } blk_cr[23:16];

        field {
            name = "blk_cb";
            desc = "Cb component of the filling color of block 0.";
            sw = rw;
            hw = r;
            reset = 0x0;
        } blk_cb[15:8];

        field {
            name = "blk_y";
            desc = "Y component of the filling color of block 0.";
            sw = rw;
            hw = r;
            reset = 0x0;
        } blk_y[7:0];
    } CH_BLOCK0_COLOR @ 0x790;

    reg {
        name = "Filling color register for block 1";
        desc = "CH_BLOCK1_COLOR is the filling color register for block 1.

Source: data sheet 11.1.6 CH_BLOCK1_COLOR (offset 0x10794, printed page 11-46, `datasheet.txt` line 35406).";

        field {
            name = "blk_cr";
            desc = "blk_cr";
            sw = rw;
            hw = r;
            reset = 0x0;
        } blk_cr[23:16];

        field {
            name = "blk_cb";
            desc = "blk_cb";
            sw = rw;
            hw = r;
            reset = 0x0;
        } blk_cb[15:8];

        field {
            name = "blk_y";
            desc = "blk_y";
            sw = rw;
            hw = r;
            reset = 0x0;
        } blk_y[7:0];
    } CH_BLOCK1_COLOR @ 0x794;

    reg {
        name = "Filling color register for block 2";
        desc = "CH_BLOCK2_COLOR is the filling color register for block 2.

Source: data sheet 11.1.6 CH_BLOCK2_COLOR (offset 0x10798, printed page 11-47, `datasheet.txt` line 35449).";

        field {
            name = "blk_cr";
            desc = "Cr component of the filling color of block 2.";
            sw = rw;
            hw = r;
            reset = 0x0;
        } blk_cr[23:16];

        field {
            name = "blk_cb";
            desc = "Cb component of the filling color of block 2.";
            sw = rw;
            hw = r;
            reset = 0x0;
        } blk_cb[15:8];

        field {
            name = "blk_y";
            desc = "Y component of the filling color of block 2.";
            sw = rw;
            hw = r;
            reset = 0x0;
        } blk_y[7:0];
    } CH_BLOCK2_COLOR @ 0x798;

    reg {
        name = "Filling color register for block 3";
        desc = "CH_BLOCK3_COLOR is the filling color register for block 3.

Source: data sheet 11.1.6 CH_BLOCK3_COLOR (offset 0x1079C, printed page 11-47, `datasheet.txt` line 35470).";

        field {
            name = "blk_cr";
            desc = "Cr component of the filling color of block 3.";
            sw = rw;
            hw = r;
            reset = 0x0;
        } blk_cr[23:16];

        field {
            name = "blk_cb";
            desc = "Cb component of the filling color of block 3.";
            sw = rw;
            hw = r;
            reset = 0x0;
        } blk_cb[15:8];

        field {
            name = "blk_y";
            desc = "Y component of the filling color of block 3.";
            sw = rw;
            hw = r;
            reset = 0x0;
        } blk_y[7:0];
    } CH_BLOCK3_COLOR @ 0x79C;

    reg {
        name = "Major stream chrominance vertical down sampling configuration register";
        desc = "CH_VCDS_CFG is a major stream chrominance vertical down sampling configuration register.

Source: data sheet 11.1.6 CH_VCDS_CFG (offset 0x10800, printed page 11-48, `datasheet.txt` line 35502).

Source: vendor module hi3520D_viu.ko (Hi3520D_MPP_V2.0.5.1, HiMPP kernel module from the OpenIPC Hi3520D rootfs; static disassembly), VIU_HAL_SetChnCdsEn (bit 0 at +0x500), confidence HIGH. Not verified on hardware.";

        enum CH_VCDS_CFG_cds_en_enum {
            DISABLED = 0 { name = "Disabled"; desc = "disabled"; };
            ENABLED = 1 { name = "Enabled"; desc = "enabled"; };
        };

        field {
            name = "cds_en";
            desc = "Down sampling enable.";
            sw = rw;
            hw = r;
            encode = CH_VCDS_CFG_cds_en_enum;
            reset = 0x0;
        } cds_en[0:0];
    } CH_VCDS_CFG @ 0x800;

    reg {
        name = "Major stream chrominance vertical down sampling coefficient register";
        desc = "CH_VCDS_COEF is a major stream chrominance vertical down sampling coefficient register.

Source: data sheet 11.1.6 CH_VCDS_COEF (offset 0x10808, printed page 11-48, `datasheet.txt` line 35525).

Source: vendor module hi3520D_viu.ko (Hi3520D_MPP_V2.0.5.1, HiMPP kernel module from the OpenIPC Hi3520D rootfs; static disassembly), VIU_HAL_SetChnCdsAttr: [4:0] and [20:16] at +0x508 written from the vendor tables g_stCDSAttr_NORM/_Top/_Bottom (two 5-bit coefficients per register), confidence HIGH for the positions. Not verified on hardware.";

        field {
            name = "coef1";
            desc = "Down sampling coefficient 1.";
            sw = rw;
            hw = r;
            reset = 0x0;
        } coef1[20:16];

        field {
            name = "coef0";
            desc = "Down sampling coefficient 0.";
            sw = rw;
            hw = r;
            reset = 0x1F;
        } coef0[4:0];
    } CH_VCDS_COEF @ 0x808;

    reg {
        name = "Luminance horizontal scaling parameter configuration register";
        desc = "CH_SCL_LHFIR_SPH is a luminance horizontal scaling parameter configuration register.

Source: data sheet 11.1.6 CH_LHFIR_SPH (offset 0x10940, printed page 11-49, `datasheet.txt` line 35558).

Source: vendor module hi3520D_viu.ko (Hi3520D_MPP_V2.0.5.1, HiMPP kernel module from the OpenIPC Hi3520D rootfs; static disassembly), VIU_HAL_SetScaleEn (bit 31 at +0x640), SetScaleStep ([15:12]), SetScaleCoef (+0x680..+0x698 hold three 10-bit coefficients per word: [9:0], [19:10], [29:20] -- NOT in this RDL, group offsets 0x980..0x998), confidence MEDIUM. Not verified on hardware.";

        enum CH_LHFIR_SPH_hlmsc_en_enum {
            DISABLED = 0 { name = "Disabled"; desc = "disabled"; };
            ENABLED = 1 { name = "Enabled"; desc = "enabled"; };
        };

        field {
            name = "hlmsc_en";
            desc = "Luminance horizontal scaling enable.";
            sw = rw;
            hw = r;
            encode = CH_LHFIR_SPH_hlmsc_en_enum;
            reset = 0x0;
        } hlmsc_en[31:31];
    } CH_LHFIR_SPH @ 0x940;

    reg {
        name = "Chrominance horizontal scaling parameter configuration register";
        desc = "CH_CHFIR_SPH is a chrominance horizontal scaling parameter configuration register.

Source: data sheet 11.1.6 CH_CHFIR_SPH (offset 0x10944, printed page 11-49, `datasheet.txt` line 35586).";

        enum CH_CHFIR_SPH_hchmsc_en_enum {
            DISABLED = 0 { name = "Disabled"; desc = "disabled"; };
            ENABLED = 1 { name = "Enabled"; desc = "enabled"; };
        };

        field {
            name = "hchmsc_en";
            desc = "Chrominance horizontal scaling enable.";
            sw = rw;
            hw = r;
            encode = CH_CHFIR_SPH_hchmsc_en_enum;
            reset = 0x0;
        } hchmsc_en[31:31];

        field {
            name = "hchratio";
            desc = "Not in the Hi3520D data sheet issue 02, which lists bits [30:0] of CH_CHFIR_SPH as reserved (read-only); kept from a later data sheet issue. Chrominance horizontal scaling ratio. It is calculated by dividing the output width by the input width. If horizontal pre-processing is enabled, the input width after pre-processing is used. The ratio is in the format of (u, 4). That is, the ratio is an unsigned number and consists of a 4-bit integral part.";
            sw = rw;
            hw = r;
            reset = 0x0;
        } hchratio[15:12];
    } CH_CHFIR_SPH @ 0x944;

    reg {
        name = "Luminance scaling horizontal offset SET register";
        desc = "CH_LHFIR_OFFSET is a luminance scaling horizontal offset register.

Source: data sheet 11.1.6 CH_LHFIR_OFFSET (offset 0x10948, printed page 11-50, `datasheet.txt` line 35627).";

        field {
            name = "hluma_offset";
            desc = "Luminance horizontal start position offset, in the format of (s, 5). That is, the offset value consists of a 1-bit signed bit and 4-bit integral part. The value is expressed as a complementary code and the offset value ranges from -6 to +15.";
            sw = rw;
            hw = r;
            reset = 0x0;
        } hluma_offset[16:12];
    } CH_LHFIR_OFFSET @ 0x948;

    reg {
        name = "Chrominance scaling horizontal offset SET register";
        desc = "CH_CHFIR_OFFSET is a chrominance scaling horizontal offset register.

Source: data sheet 11.1.6 CH_CHFIR_OFFSET (offset 0x1094C, printed page 11-50, `datasheet.txt` line 35651).";

        field {
            name = "hchroma_offset";
            desc = "Chrominance horizontal start position offset, in the format of (s, 5). That is, the offset value consists of a 1-bit signed bit and 4-bit integral part. The value is expressed as a complementary code and the offset value ranges from -6 to +15.";
            sw = rw;
            hw = r;
            reset = 0x0;
        } hchroma_offset[16:12];
    } CH_CHFIR_OFFSET @ 0x94C;

    reg {
        name = "UNK_0x980";
        desc = "UNK_0x980 (name is a placeholder, not a vendor name). NOT IN THE DATA SHEET. Source: vendor module hi3520D_viu.ko (Hi3520D_MPP_V2.0.5.1, static disassembly), VIU_HAL_SetScaleCoef (0x14954): read-modify-write of three 10-bit groups [9:0], [19:10], [29:20] (vendor group offset +0x680 = group offset 0x980); the values come from the vendor coefficient tables (coeff_lanc3_*, coeff_6Phase_*, Blinear_Down*), selected by the scaling ratio; the split of the six words into luma/chroma and horizontal phase sets is not decoded. Written only when horizontal scaling is configured (scaler path, not used for plain capture). Neighbors written together: the other five UNK_0x98x/0x99x words, then CH_LHFIR_SPH / CH_CHFIR_SPH (scale enable bit 31, step [15:12]) and the CH_*FIR_OFFSET registers. Unknown purpose, vendor-observed only, confidence LOW, not verified on hardware.";

        field {
            name = "grp0_unk";
            desc = "Unknown 10-bit group grp0_unk (vendor-observed write only).";
            sw = rw;
            hw = r;
        } grp0_unk[9:0];

        field {
            name = "grp1_unk";
            desc = "Unknown 10-bit group grp1_unk (vendor-observed write only).";
            sw = rw;
            hw = r;
        } grp1_unk[19:10];

        field {
            name = "grp2_unk";
            desc = "Unknown 10-bit group grp2_unk (vendor-observed write only).";
            sw = rw;
            hw = r;
        } grp2_unk[29:20];

    } UNK_0x980 @ 0x980;

    reg {
        name = "UNK_0x984";
        desc = "UNK_0x984 (name is a placeholder, not a vendor name). NOT IN THE DATA SHEET. Source: vendor module hi3520D_viu.ko (Hi3520D_MPP_V2.0.5.1, static disassembly), VIU_HAL_SetScaleCoef (0x14954): read-modify-write of three 10-bit groups [9:0], [19:10], [29:20] (vendor group offset +0x684 = group offset 0x984); the values come from the vendor coefficient tables (coeff_lanc3_*, coeff_6Phase_*, Blinear_Down*), selected by the scaling ratio; the split of the six words into luma/chroma and horizontal phase sets is not decoded. Written only when horizontal scaling is configured (scaler path, not used for plain capture). Neighbors written together: the other five UNK_0x98x/0x99x words, then CH_LHFIR_SPH / CH_CHFIR_SPH (scale enable bit 31, step [15:12]) and the CH_*FIR_OFFSET registers. Unknown purpose, vendor-observed only, confidence LOW, not verified on hardware.";

        field {
            name = "grp0_unk";
            desc = "Unknown 10-bit group grp0_unk (vendor-observed write only).";
            sw = rw;
            hw = r;
        } grp0_unk[9:0];

        field {
            name = "grp1_unk";
            desc = "Unknown 10-bit group grp1_unk (vendor-observed write only).";
            sw = rw;
            hw = r;
        } grp1_unk[19:10];

        field {
            name = "grp2_unk";
            desc = "Unknown 10-bit group grp2_unk (vendor-observed write only).";
            sw = rw;
            hw = r;
        } grp2_unk[29:20];

    } UNK_0x984 @ 0x984;

    reg {
        name = "UNK_0x988";
        desc = "UNK_0x988 (name is a placeholder, not a vendor name). NOT IN THE DATA SHEET. Source: vendor module hi3520D_viu.ko (Hi3520D_MPP_V2.0.5.1, static disassembly), VIU_HAL_SetScaleCoef (0x14954): read-modify-write of three 10-bit groups [9:0], [19:10], [29:20] (vendor group offset +0x688 = group offset 0x988); the values come from the vendor coefficient tables (coeff_lanc3_*, coeff_6Phase_*, Blinear_Down*), selected by the scaling ratio; the split of the six words into luma/chroma and horizontal phase sets is not decoded. Written only when horizontal scaling is configured (scaler path, not used for plain capture). Neighbors written together: the other five UNK_0x98x/0x99x words, then CH_LHFIR_SPH / CH_CHFIR_SPH (scale enable bit 31, step [15:12]) and the CH_*FIR_OFFSET registers. Unknown purpose, vendor-observed only, confidence LOW, not verified on hardware.";

        field {
            name = "grp0_unk";
            desc = "Unknown 10-bit group grp0_unk (vendor-observed write only).";
            sw = rw;
            hw = r;
        } grp0_unk[9:0];

        field {
            name = "grp1_unk";
            desc = "Unknown 10-bit group grp1_unk (vendor-observed write only).";
            sw = rw;
            hw = r;
        } grp1_unk[19:10];

        field {
            name = "grp2_unk";
            desc = "Unknown 10-bit group grp2_unk (vendor-observed write only).";
            sw = rw;
            hw = r;
        } grp2_unk[29:20];

    } UNK_0x988 @ 0x988;

    reg {
        name = "UNK_0x990";
        desc = "UNK_0x990 (name is a placeholder, not a vendor name). NOT IN THE DATA SHEET. Source: vendor module hi3520D_viu.ko (Hi3520D_MPP_V2.0.5.1, static disassembly), VIU_HAL_SetScaleCoef (0x14954): read-modify-write of three 10-bit groups [9:0], [19:10], [29:20] (vendor group offset +0x690 = group offset 0x990); the values come from the vendor coefficient tables (coeff_lanc3_*, coeff_6Phase_*, Blinear_Down*), selected by the scaling ratio; the split of the six words into luma/chroma and horizontal phase sets is not decoded. Written only when horizontal scaling is configured (scaler path, not used for plain capture). Neighbors written together: the other five UNK_0x98x/0x99x words, then CH_LHFIR_SPH / CH_CHFIR_SPH (scale enable bit 31, step [15:12]) and the CH_*FIR_OFFSET registers. Unknown purpose, vendor-observed only, confidence LOW, not verified on hardware.";

        field {
            name = "grp0_unk";
            desc = "Unknown 10-bit group grp0_unk (vendor-observed write only).";
            sw = rw;
            hw = r;
        } grp0_unk[9:0];

        field {
            name = "grp1_unk";
            desc = "Unknown 10-bit group grp1_unk (vendor-observed write only).";
            sw = rw;
            hw = r;
        } grp1_unk[19:10];

        field {
            name = "grp2_unk";
            desc = "Unknown 10-bit group grp2_unk (vendor-observed write only).";
            sw = rw;
            hw = r;
        } grp2_unk[29:20];

    } UNK_0x990 @ 0x990;

    reg {
        name = "UNK_0x994";
        desc = "UNK_0x994 (name is a placeholder, not a vendor name). NOT IN THE DATA SHEET. Source: vendor module hi3520D_viu.ko (Hi3520D_MPP_V2.0.5.1, static disassembly), VIU_HAL_SetScaleCoef (0x14954): read-modify-write of three 10-bit groups [9:0], [19:10], [29:20] (vendor group offset +0x694 = group offset 0x994); the values come from the vendor coefficient tables (coeff_lanc3_*, coeff_6Phase_*, Blinear_Down*), selected by the scaling ratio; the split of the six words into luma/chroma and horizontal phase sets is not decoded. Written only when horizontal scaling is configured (scaler path, not used for plain capture). Neighbors written together: the other five UNK_0x98x/0x99x words, then CH_LHFIR_SPH / CH_CHFIR_SPH (scale enable bit 31, step [15:12]) and the CH_*FIR_OFFSET registers. Unknown purpose, vendor-observed only, confidence LOW, not verified on hardware.";

        field {
            name = "grp0_unk";
            desc = "Unknown 10-bit group grp0_unk (vendor-observed write only).";
            sw = rw;
            hw = r;
        } grp0_unk[9:0];

        field {
            name = "grp1_unk";
            desc = "Unknown 10-bit group grp1_unk (vendor-observed write only).";
            sw = rw;
            hw = r;
        } grp1_unk[19:10];

        field {
            name = "grp2_unk";
            desc = "Unknown 10-bit group grp2_unk (vendor-observed write only).";
            sw = rw;
            hw = r;
        } grp2_unk[29:20];

    } UNK_0x994 @ 0x994;

    reg {
        name = "UNK_0x998";
        desc = "UNK_0x998 (name is a placeholder, not a vendor name). NOT IN THE DATA SHEET. Source: vendor module hi3520D_viu.ko (Hi3520D_MPP_V2.0.5.1, static disassembly), VIU_HAL_SetScaleCoef (0x14954): read-modify-write of three 10-bit groups [9:0], [19:10], [29:20] (vendor group offset +0x698 = group offset 0x998); the values come from the vendor coefficient tables (coeff_lanc3_*, coeff_6Phase_*, Blinear_Down*), selected by the scaling ratio; the split of the six words into luma/chroma and horizontal phase sets is not decoded. Written only when horizontal scaling is configured (scaler path, not used for plain capture). Neighbors written together: the other five UNK_0x98x/0x99x words, then CH_LHFIR_SPH / CH_CHFIR_SPH (scale enable bit 31, step [15:12]) and the CH_*FIR_OFFSET registers. Unknown purpose, vendor-observed only, confidence LOW, not verified on hardware.";

        field {
            name = "grp0_unk";
            desc = "Unknown 10-bit group grp0_unk (vendor-observed write only).";
            sw = rw;
            hw = r;
        } grp0_unk[9:0];

        field {
            name = "grp1_unk";
            desc = "Unknown 10-bit group grp1_unk (vendor-observed write only).";
            sw = rw;
            hw = r;
        } grp1_unk[19:10];

        field {
            name = "grp2_unk";
            desc = "Unknown 10-bit group grp2_unk (vendor-observed write only).";
            sw = rw;
            hw = r;
        } grp2_unk[29:20];

    } UNK_0x998 @ 0x998;

    reg {
        name = "Chrominance clip configuration register";
        desc = "CH_Y_CLIP_CFG is a luminance clip configuration register.

Source: data sheet 11.1.6 CH_Y_CLIP_CFG (offset 0x10B00, printed page 11-51, `datasheet.txt` line 35685).";

        field {
            name = "max";
            desc = "Maximum output value.";
            sw = rw;
            hw = r;
            reset = 0xFF;
        } max[23:16];

        field {
            name = "min";
            desc = "Minimum output value.";
            sw = rw;
            hw = r;
            reset = 0x0;
        } min[7:0];
    } CH_Y_CLIP_CFG @ 0xB00;

    reg {
        name = "Luminance clip configuration register";
        desc = "CH_C_CLIP_CFG is a chrominance clip configuration register.

Source: data sheet 11.1.6 CH_C_CLIP_CFG (offset 0x10B04, printed page 11-51, `datasheet.txt` line 35707).";

        field {
            name = "max";
            desc = "Maximum output value.";
            sw = rw;
            hw = r;
            reset = 0xFF;
        } max[23:16];

        field {
            name = "min";
            desc = "Minimum output value.";
            sw = rw;
            hw = r;
            reset = 0x0;
        } min[7:0];
    } CH_C_CLIP_CFG @ 0xB04;

    reg {
        name = "Input picture total luminance statistics register";
        desc = "CH_SUM_Y is an input picture total luminance statistics register.

Source: data sheet 11.1.6 CH_SUM_Y (offset 0x10C00, printed page 11-52, `datasheet.txt` line 35739).

Source: vendor module hi3520D_viu.ko (Hi3520D_MPP_V2.0.5.1, HiMPP kernel module from the OpenIPC Hi3520D rootfs; static disassembly), VIU_HAL_GetLuma (+0x900), confidence HIGH. Not verified on hardware.";

        field {
            name = "sum_y";
            desc = "Total luminance statistics.";
            sw = r;
            hw = w;
            reset = 0x0;
        } sum_y[31:0];
    } CH_SUM_Y @ 0xC00;

};

regfile eHISI_VICAP {
    name = "HiSilicon video capture";
    desc = "
    HiSilicon video capture (VICAP) at 0x20580000 (256 KB window), GIC interrupt ID 68. Receives BT.656 (mux) or BT.1120 (mux) video on two 8-bit ports or one 16-bit port (Hi3520D; Hi3515A: one BT.656 port), 8 channels (Hi3515A: 4) of up to 1080p/D1/960H, optional horizontal down-scaling (2x integral), crop window, mirror/flip, luminance statistics, SP420/SP422 output into DDR, two bus priority levels per channel. Registers 0x0000-0x0200 are system registers (WK_MODE, AXI_CFG, MIXER0_PRO_CFG0, VICAP_INT); everything from 0x10000 is per-port/per-channel (see `eHISI_VICAP_CH`). Registers and reset values are from Hi3520D/Hi3515A/Hi3515C data sheet issue 07, chapter 11.1 (`datasheet.txt` lines 32831-35753). Not hardware verified. The data sheet also marks 4-channel 720p input as \"Hi3520D V200 only\". Clock and reset: PERI_CRG (VICAP bits).

    **Other chips (data sheet cross-check 2026-11-09):** no other data sheet in the tree carries this multi-channel VICAP layout (WK_MODE / AXI_CFG / MIXER0_PRO_CFG0 at 0x0000 and
    16 x 0x2000 channel blocks from 0x10000). The Hi3511 / Hi3512 / Hi3515 / Hi3520 VIU, the Hi3516 V100 VICAP (226 registers), the Hi3518 V100 / Hi3518E V100 / Hi3516C V100 VICAP (116
    registers) and the single-port Hi3518E V20X / Hi3516A / Hi3516C V300 / Hi3519 VICAP (`eHISI_VICAP_V2`, PT/DES/CH names) are other generations.
    ";

    reg {
        name = "Global working configuration register";
        desc = "WK_MODE is a global working configuration register.

Source: data sheet 11.1.6 WK_MODE (offset 0x0, printed page 11-18, `datasheet.txt` line 33726).

Source: vendor module hi3520D_viu.ko (Hi3520D_MPP_V2.0.5.1, HiMPP kernel module from the OpenIPC Hi3520D rootfs; static disassembly), VIU_HAL_SetPowerWorkMode (bit 0 = power_mode), VIU_HAL_SetPortMode (bit 16 for port 0, bit 17 for port 1), confidence HIGH for the positions. Vendor use: ptN_mode is set to 1 when the device interface type is 2, 3 or 4 (BT.1120 standard/interleaved and the digital camera type; VIU_DRV_SetDevAttrByChip: type - 2 <= 2) and to 0 for BT.656 and BT.601 -- it follows the INTERFACE type, not the line count. The board script sysctl_hi3520D.sh writes WK_MODE = 0 ('vicap lowpower'), i.e. power_mode 0. Previously: our Linux driver sets ptN_mode for inputs above 576 lines (derived from the data sheet text only). Not verified on hardware. Board: reads 0 at idle (confirmed).";

        enum WK_MODE_pt1_mode_enum {
            D1_960H = 0 { name = "D1 960H"; desc = "D1 or 960H"; };
            V_720P = 1 { name = "V 720P"; desc = "720p"; };
        };

        field {
            name = "pt1_mode";
            desc = "Operating mode of port 1.";
            sw = rw;
            hw = r;
            encode = WK_MODE_pt1_mode_enum;
            reset = 0x0;
        } pt1_mode[17:17];

        enum WK_MODE_pt0_mode_enum {
            D1_960H = 0 { name = "D1 960H"; desc = "D1 or 960H"; };
            V_720P_1080P = 1 { name = "V 720P 1080P"; desc = "720p or 1080p"; };
        };

        field {
            name = "pt0_mode";
            desc = "Operating mode of port 0.";
            sw = rw;
            hw = r;
            encode = WK_MODE_pt0_mode_enum;
            reset = 0x0;
        } pt0_mode[16:16];

        enum WK_MODE_power_mode_enum {
            LOW_POWER_MODE = 0 { name = "Low Power Mode"; desc = "The low-power mode is disabled."; };
            LOW_POWER_MODE_2 = 1 { name = "Low Power Mode 2"; desc = "The low-power mode is enabled."; };
        };

        field {
            name = "power_mode";
            desc = "Clock mode.";
            sw = rw;
            hw = r;
            encode = WK_MODE_power_mode_enum;
            reset = 0x0;
        } power_mode[0:0];
    } WK_MODE @ 0x0;

    reg {
        name = "Bus configuration register";
        desc = "AXI_CFG is a bus configuration register.

Source: data sheet 11.1.6 AXI_CFG (offset 0x4, printed page 11-18, `datasheet.txt` line 33762).

Source: vendor module hi3520D_viu.ko (Hi3520D_MPP_V2.0.5.1, HiMPP kernel module from the OpenIPC Hi3520D rootfs; static disassembly), VIU_HAL_BoardInit (0x140cc: read-modify-write of [3:0] = 2 right after ioremap of 0x20580000 size 0x20000) and board script sysctl_hi3520D.sh ('himm 0x20580004 0xf0f00002 # vicap outstanding'), confidence HIGH: the vendor always programs m0_otd = 2 (the Linux driver leaves it at the reset value 0). Whether m0_otd = 0 stalls the write master is UNKNOWN. Not verified on hardware. Board: reads 0xF0F00000 (confirmed).";

        field {
            name = "reserved_nz";
            desc = "Reserved (RO); reads 0xF0F: the data sheet total reset value of AXI_CFG is 0xF0F0_0000 (bits 31:28 and 23:20 set).";
            sw = r;
            hw = w;
            reset = 0xF0F;
        } reserved_nz[31:20];

        field {
            name = "m0_id";
            desc = "ID.";
            sw = rw;
            hw = r;
            reset = 0x0;
        } m0_id[19:16];

        field {
            name = "m0_otd";
            desc = "Number of outstandings. The number must be between 0 and 4.";
            sw = rw;
            hw = r;
            reset = 0x0;
        } m0_otd[3:0];
    } AXI_CFG @ 0x4;

    reg {
        name = "Master priority configuration register";
        desc = "MIXER0_PRO_CFG0 is master priority configuration register.

Source: data sheet 11.1.6 MIXER0_PRO_CFG0 (offset 0x8, printed page 11-19, `datasheet.txt` line 33795).

Source: vendor module hi3520D_viu.ko (Hi3520D_MPP_V2.0.5.1, HiMPP kernel module from the OpenIPC Hi3520D rootfs; static disassembly), VIU_HAL_SetMasterPro (0x13f30): pair n (0..7) writes bit 2n and bit 2n+1 (luma/chroma priority of channel n); VIU_HAL_BoardInit writes all pairs 0 (highest priority, = reset), confidence HIGH. Not verified on hardware.";

        field {
            name = "ch7_c_pro";
            desc = "Chrominance priority of channel 7. The value 0 indicates the highest priority.";
            sw = rw;
            hw = r;
            reset = 0x0;
        } ch7_c_pro[15:15];

        field {
            name = "ch7_y_pro";
            desc = "Luminance priority of channel 7. The value 0 indicates the highest priority.";
            sw = rw;
            hw = r;
            reset = 0x0;
        } ch7_y_pro[14:14];

        field {
            name = "ch6_c_pro";
            desc = "Chrominance priority of channel 6. The value 0 indicates the highest priority.";
            sw = rw;
            hw = r;
            reset = 0x0;
        } ch6_c_pro[13:13];

        field {
            name = "ch6_y_pro";
            desc = "Luminance priority of channel 6. The value 0 indicates the highest priority.";
            sw = rw;
            hw = r;
            reset = 0x0;
        } ch6_y_pro[12:12];

        field {
            name = "ch5_c_pro";
            desc = "Chrominance priority of channel 5. The value 0 indicates the highest priority.";
            sw = rw;
            hw = r;
            reset = 0x0;
        } ch5_c_pro[11:11];

        field {
            name = "ch5_y_pro";
            desc = "Luminance priority of channel 5. The value 0 indicates the highest priority.";
            sw = rw;
            hw = r;
            reset = 0x0;
        } ch5_y_pro[10:10];

        field {
            name = "ch4_c_pro";
            desc = "Chrominance priority of channel 4. The value 0 indicates the highest priority.";
            sw = rw;
            hw = r;
            reset = 0x0;
        } ch4_c_pro[9:9];

        field {
            name = "ch4_y_pro";
            desc = "Luminance priority of channel 4. The value 0 indicates the highest priority.";
            sw = rw;
            hw = r;
            reset = 0x0;
        } ch4_y_pro[8:8];

        field {
            name = "ch3_c_pro";
            desc = "Chrominance priority of channel 3. The value 0 indicates the highest priority.";
            sw = rw;
            hw = r;
            reset = 0x0;
        } ch3_c_pro[7:7];

        field {
            name = "ch3_y_pro";
            desc = "Luminance priority of channel 3. The value 0 indicates the highest priority.";
            sw = rw;
            hw = r;
            reset = 0x0;
        } ch3_y_pro[6:6];

        field {
            name = "ch2_c_pro";
            desc = "Chrominance priority of channel 2. The value 0 indicates the highest priority.";
            sw = rw;
            hw = r;
            reset = 0x0;
        } ch2_c_pro[5:5];

        field {
            name = "ch2_y_pro";
            desc = "Luminance priority of channel 2. The value 0 indicates the highest priority.";
            sw = rw;
            hw = r;
            reset = 0x0;
        } ch2_y_pro[4:4];

        field {
            name = "ch1_c_pro";
            desc = "Chrominance priority of channel 1. The value 0 indicates the highest priority.";
            sw = rw;
            hw = r;
            reset = 0x0;
        } ch1_c_pro[3:3];

        field {
            name = "ch1_y_pro";
            desc = "Luminance priority of channel 1. The value 0 indicates the highest priority.";
            sw = rw;
            hw = r;
            reset = 0x0;
        } ch1_y_pro[2:2];

        field {
            name = "ch0_c_pro";
            desc = "Chrominance priority of channel 0. The value 0 indicates the highest priority.";
            sw = rw;
            hw = r;
            reset = 0x0;
        } ch0_c_pro[1:1];

        field {
            name = "ch0_y_pro";
            desc = "Luminance priority of channel 0. The value 0 indicates the highest priority.";
            sw = rw;
            hw = r;
            reset = 0x0;
        } ch0_y_pro[0:0];
    } MIXER0_PRO_CFG0 @ 0x8;

    reg {
        name = "Interrupt indicator register";
        desc = "VICAP_INT is an interrupt indicator register.

Source: data sheet 11.1.6 VICAP_INT (offset 0x100, printed page 11-20, `datasheet.txt` line 33877).

Source: vendor module hi3520D_viu.ko (Hi3520D_MPP_V2.0.5.1, HiMPP kernel module from the OpenIPC Hi3520D rootfs; static disassembly), VIU_HAL_GetIntIndicator (+0x100, one bit per channel as read by the vendor ISR before the per-channel status registers), confidence MEDIUM for the bit meaning, HIGH for the offset. Not verified on hardware.";

        enum VICAP_INT_int_ch7_enum {
            NO_INTERRUPT_GENERATED = 0 { name = "No Interrupt Generated"; desc = "No interrupt is generated."; };
            INTERRUPT_GENERATED = 1 { name = "Interrupt Generated"; desc = "An interrupt is generated."; };
        };

        field {
            name = "int_ch7";
            desc = "Interrupt indicator of channel 7.";
            sw = r;
            hw = w;
            encode = VICAP_INT_int_ch7_enum;
            reset = 0x0;
        } int_ch7[7:7];

        enum VICAP_INT_int_ch6_enum {
            NO_INTERRUPT_GENERATED = 0 { name = "No Interrupt Generated"; desc = "No interrupt is generated."; };
            INTERRUPT_GENERATED = 1 { name = "Interrupt Generated"; desc = "An interrupt is generated."; };
        };

        field {
            name = "int_ch6";
            desc = "Interrupt indicator of channel 6.";
            sw = r;
            hw = w;
            encode = VICAP_INT_int_ch6_enum;
            reset = 0x0;
        } int_ch6[6:6];

        enum VICAP_INT_int_ch5_enum {
            NO_INTERRUPT_GENERATED = 0 { name = "No Interrupt Generated"; desc = "No interrupt is generated."; };
            INTERRUPT_GENERATED = 1 { name = "Interrupt Generated"; desc = "An interrupt is generated."; };
        };

        field {
            name = "int_ch5";
            desc = "Interrupt indicator of channel 5.";
            sw = r;
            hw = w;
            encode = VICAP_INT_int_ch5_enum;
            reset = 0x0;
        } int_ch5[5:5];

        enum VICAP_INT_int_ch4_enum {
            NO_INTERRUPT_GENERATED = 0 { name = "No Interrupt Generated"; desc = "No interrupt is generated."; };
            INTERRUPT_GENERATED = 1 { name = "Interrupt Generated"; desc = "An interrupt is generated."; };
        };

        field {
            name = "int_ch4";
            desc = "Interrupt indicator of channel 4.";
            sw = r;
            hw = w;
            encode = VICAP_INT_int_ch4_enum;
            reset = 0x0;
        } int_ch4[4:4];

        enum VICAP_INT_int_ch3_enum {
            NO_INTERRUPT_GENERATED = 0 { name = "No Interrupt Generated"; desc = "No interrupt is generated."; };
            INTERRUPT_GENERATED = 1 { name = "Interrupt Generated"; desc = "An interrupt is generated."; };
        };

        field {
            name = "int_ch3";
            desc = "Interrupt indicator of channel 3.";
            sw = r;
            hw = w;
            encode = VICAP_INT_int_ch3_enum;
            reset = 0x0;
        } int_ch3[3:3];

        enum VICAP_INT_int_ch2_enum {
            NO_INTERRUPT_GENERATED = 0 { name = "No Interrupt Generated"; desc = "No interrupt is generated."; };
            INTERRUPT_GENERATED = 1 { name = "Interrupt Generated"; desc = "An interrupt is generated."; };
        };

        field {
            name = "int_ch2";
            desc = "Interrupt indicator of channel 2.";
            sw = r;
            hw = w;
            encode = VICAP_INT_int_ch2_enum;
            reset = 0x0;
        } int_ch2[2:2];

        enum VICAP_INT_int_ch1_enum {
            NO_INTERRUPT_GENERATED = 0 { name = "No Interrupt Generated"; desc = "No interrupt is generated."; };
            INTERRUPT_GENERATED = 1 { name = "Interrupt Generated"; desc = "An interrupt is generated."; };
        };

        field {
            name = "int_ch1";
            desc = "Interrupt indicator of channel 1.";
            sw = r;
            hw = w;
            encode = VICAP_INT_int_ch1_enum;
            reset = 0x0;
        } int_ch1[1:1];

        enum VICAP_INT_int_ch0_enum {
            NO_INTERRUPT_GENERATED = 0 { name = "No Interrupt Generated"; desc = "No interrupt is generated."; };
            INTERRUPT_GENERATED = 1 { name = "Interrupt Generated"; desc = "An interrupt is generated."; };
        };

        field {
            name = "int_ch0";
            desc = "Interrupt indicator of channel 0.";
            sw = r;
            hw = w;
            encode = VICAP_INT_int_ch0_enum;
            reset = 0x0;
        } int_ch0[0:0];
    } VICAP_INT @ 0x100;

    eHISI_VICAP_CH CH[16] @ 0x10000 += 0x2000;

};

`endif
