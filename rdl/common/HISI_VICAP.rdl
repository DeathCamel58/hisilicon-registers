`ifndef HISI_VICAP_RDL
`define HISI_VICAP_RDL

regfile eHISI_VICAP_CH {
    name = "HiSilicon VICAP port/channel registers";
    desc = "
    One VICAP port/channel register group (`CH[16]` at 0x10000 + n x 0x2000). Offsets are rebased to the start of the group (the data sheet lists the registers of PORT 0 / CH 0 as 0x10000.. and 0x10300..; Figure 11-17 shows PORTn registers at 0x10000 + n x 0x4000 and CHn registers at 0x10300 + n x 0x2000). The PT_* registers (offsets 0x000..0x044) exist only in channels 0 and 4 (at most two external ports are supported; port 0 serves channels 0-3, port 1 channels 4-7); they are present but not implemented in the other groups. The Hi3520D has 8 channels (Hi3515A: 4), the data sheet space allocation shows 16.
    ";

    reg {
        name = "Port mode register";
        desc = "PT_INTF_MOD is a port mode register.

Data sheet 11.1.6 PT_INTF_MOD (offset 0x10000, printed page 11-21, `datasheet.txt` line 33933).";

        enum PT_INTF_MOD_interleave_seq_enum {
            C_COMPONENT_BEFORE = 0 { name = "C Component Before"; desc = "The C component is before the Y component."; };
            Y_COMPONENT_BEFORE = 1 { name = "Y Component Before"; desc = "The Y component is before the C component."; };
        };

        field {
            name = "interleave_seq";
            desc = "Y/C sequence during interleaving.";
            sw = rw;
            hw = r;
            encode = PT_INTF_MOD_interleave_seq_enum;
            reset = 0x0;
        } interleave_seq[24:24];

        enum PT_INTF_MOD_ch3_id_en_enum {
            CHANNEL_ID_NOT = 0 { name = "Channel Id Not"; desc = "The channel ID is not checked."; };
            DATA_CHANNEL_SELECTED = 1 { name = "Data Channel Selected"; desc = "The data channel is selected based on the channel ID."; };
        };

        field {
            name = "ch3_id_en";
            desc = "Channel 3 ID enable.";
            sw = rw;
            hw = r;
            encode = PT_INTF_MOD_ch3_id_en_enum;
            reset = 0x0;
        } ch3_id_en[23:23];

        enum PT_INTF_MOD_ch2_id_en_enum {
            CHANNEL_ID_NOT = 0 { name = "Channel Id Not"; desc = "The channel ID is not checked."; };
            DATA_CHANNEL_SELECTED = 1 { name = "Data Channel Selected"; desc = "The data channel is selected based on the channel ID."; };
        };

        field {
            name = "ch2_id_en";
            desc = "Channel 2 ID enable.";
            sw = rw;
            hw = r;
            encode = PT_INTF_MOD_ch2_id_en_enum;
            reset = 0x0;
        } ch2_id_en[22:22];

        enum PT_INTF_MOD_ch1_id_en_enum {
            CHANNEL_ID_NOT = 0 { name = "Channel Id Not"; desc = "The channel ID is not checked."; };
            DATA_CHANNEL_SELECTED = 1 { name = "Data Channel Selected"; desc = "The data channel is selected based on the channel ID."; };
        };

        field {
            name = "ch1_id_en";
            desc = "Channel 1 ID enable.";
            sw = rw;
            hw = r;
            encode = PT_INTF_MOD_ch1_id_en_enum;
            reset = 0x0;
        } ch1_id_en[21:21];

        enum PT_INTF_MOD_ch0_id_en_enum {
            CHANNEL_ID_NOT = 0 { name = "Channel Id Not"; desc = "The channel ID is not checked."; };
            DATA_CHANNEL_SELECTED = 1 { name = "Data Channel Selected"; desc = "The data channel is selected based on the channel ID."; };
        };

        field {
            name = "ch0_id_en";
            desc = "Channel 0 ID enable.";
            sw = rw;
            hw = r;
            encode = PT_INTF_MOD_ch0_id_en_enum;
            reset = 0x0;
        } ch0_id_en[20:20];

        field {
            name = "ch3_id";
            desc = "The data channel is selected based on the channel ID when the channel 3 ID is enabled.";
            sw = rw;
            hw = r;
            reset = 0x0;
        } ch3_id[19:18];

        field {
            name = "ch2_id";
            desc = "The data channel is selected based on the channel ID when the channel 2 ID is enabled.";
            sw = rw;
            hw = r;
            reset = 0x0;
        } ch2_id[17:16];

        field {
            name = "ch1_id";
            desc = "The data channel is selected based on the channel ID when the channel 1 ID is enabled.";
            sw = rw;
            hw = r;
            reset = 0x0;
        } ch1_id[15:14];

        field {
            name = "ch0_id";
            desc = "The data channel is selected based on the channel ID when the channel 0 ID is enabled.";
            sw = rw;
            hw = r;
            reset = 0x0;
        } ch0_id[13:12];

        enum PT_INTF_MOD_port_cap_mode_enum {
            BT_656_BT = 0 { name = "Bt 656 Bt"; desc = "BT.656/BT.1120 mode"; };
            INTERLEAVE_MODE_OTHER = 3 { name = "Interleave Mode Other"; desc = "interleave mode Other values: reserved"; };
        };

        field {
            name = "port_cap_mode";
            desc = "Port mode.";
            sw = rw;
            hw = r;
            encode = PT_INTF_MOD_port_cap_mode_enum;
            reset = 0x0;
        } port_cap_mode[11:10];

        enum PT_INTF_MOD_port_mux_mode_enum {
            V_1_CHANNEL_MULTIPLEXING = 0 { name = "V 1 Channel Multiplexing"; desc = "1-channel multiplexing mode"; };
            V_2_CHANNEL_MULTIPLEXING = 1 { name = "V 2 Channel Multiplexing"; desc = "2-channel multiplexing mode"; };
            V_4_CHANNEL_MULTIPLEXING = 2 { name = "V 4 Channel Multiplexing"; desc = "4-channel multiplexing mode"; };
            RESERVED = 3 { name = "Reserved"; desc = "reserved"; };
        };

        field {
            name = "port_mux_mode";
            desc = "Multiplexing mode.";
            sw = rw;
            hw = r;
            encode = PT_INTF_MOD_port_mux_mode_enum;
            reset = 0x0;
        } port_mux_mode[9:8];

        enum PT_INTF_MOD_fix_code_enum {
            MSB_1 = 0 { name = "Msb 1"; desc = "The MSB is 1."; };
            MSB_0 = 1 { name = "Msb 0"; desc = "The MSB is 0."; };
        };

        field {
            name = "fix_code";
            desc = "MSB of the sync code.";
            sw = rw;
            hw = r;
            encode = PT_INTF_MOD_fix_code_enum;
            reset = 0x0;
        } fix_code[7:7];

        enum PT_INTF_MOD_port_mod_enum {
            SINGLE_COMPONENT_INPUT = 0 { name = "Single Component Input"; desc = "single-component input"; };
            DUAL_COMPONENT_INPUT = 1 { name = "Dual Component Input"; desc = "dual-component input Other values: reserved"; };
        };

        field {
            name = "port_mod";
            desc = "Port mode.";
            sw = rw;
            hw = r;
            encode = PT_INTF_MOD_port_mod_enum;
            reset = 0x0;
        } port_mod[4:3];

        enum PT_INTF_MOD_clk_mode_enum {
            SAMPLING_RISING_EDGE = 0 { name = "Sampling Rising Edge"; desc = "sampling on the rising edge"; };
            SAMPLING_FALLING_EDGE = 1 { name = "Sampling Falling Edge"; desc = "sampling on the falling edge"; };
        };

        field {
            name = "clk_mode";
            desc = "Clock mode.";
            sw = rw;
            hw = r;
            encode = PT_INTF_MOD_clk_mode_enum;
            reset = 0x0;
        } clk_mode[1:1];

        enum PT_INTF_MOD_port_en_enum {
            DISABLED = 0 { name = "Disabled"; desc = "disabled"; };
            ENABLED = 1 { name = "Enabled"; desc = "enabled"; };
        };

        field {
            name = "port_en";
            desc = "Port enable.";
            sw = rw;
            hw = r;
            encode = PT_INTF_MOD_port_en_enum;
            reset = 0x0;
        } port_en[0:0];
    } PT_INTF_MOD @ 0x0;

    reg {
        name = "R component mask register";
        desc = "PT_R_MASK_L is R component mask register.

Data sheet 11.1.6 PT_R_MASK_L (offset 0x10004, printed page 11-23, `datasheet.txt` line 34036).";

        field {
            name = "r_mask";
            desc = "R component mask.";
            sw = rw;
            hw = r;
            reset = 0x0;
        } r_mask[31:0];
    } PT_R_MASK_L @ 0x4;

    reg {
        name = "B component mask register";
        desc = "PT_B_MASK_L is B component mask register.

Data sheet 11.1.6 PT_B_MASK_L (offset 0x10008, printed page 11-24, `datasheet.txt` line 34065).";

        field {
            name = "b_mask";
            desc = "B component mask.";
            sw = rw;
            hw = r;
            reset = 0x0;
        } b_mask[31:0];
    } PT_B_MASK_L @ 0x8;

    reg {
        name = "G component mask register";
        desc = "PT_G_MASK_L is G component mask register.

Data sheet 11.1.6 PT_G_MASK_L (offset 0x1000C, printed page 11-24, `datasheet.txt` line 34084).";

        field {
            name = "g_mask";
            desc = "G component mask.";
            sw = rw;
            hw = r;
            reset = 0x0;
        } g_mask[31:0];
    } PT_G_MASK_L @ 0xC;

    reg {
        name = "R component offset register";
        desc = "PT_R_OFFSET_L is R component offset register.

Data sheet 11.1.6 PT_R_OFFSET_L (offset 0x10014, printed page 11-24, `datasheet.txt` line 34102).";

        field {
            name = "r_offset";
            desc = "R component offset.";
            sw = rw;
            hw = r;
            reset = 0x0;
        } r_offset[7:0];
    } PT_R_OFFSET_L @ 0x14;

    reg {
        name = "B component offset register";
        desc = "PT_B_OFFSET_L is B component offset register.

Data sheet 11.1.6 PT_B_OFFSET_L (offset 0x10018, printed page 11-25, `datasheet.txt` line 34130).";

        field {
            name = "b_offset";
            desc = "B component offset.";
            sw = rw;
            hw = r;
            reset = 0x0;
        } b_offset[7:0];
    } PT_B_OFFSET_L @ 0x18;

    reg {
        name = "G component offset register";
        desc = "PT_G_OFFSET_L is G component offset register.

Data sheet 11.1.6 PT_G_OFFSET_L (offset 0x1001C, printed page 11-25, `datasheet.txt` line 34150).";

        field {
            name = "g_offset";
            desc = "G component offset.";
            sw = rw;
            hw = r;
            reset = 0x0;
        } g_offset[7:0];
    } PT_G_OFFSET_L @ 0x1C;

    reg {
        name = "Port test configuration register";
        desc = "PT_TEST_CFG is a port test configuration register.

Data sheet 11.1.6 PT_TEST_CFG (offset 0x10040, printed page 11-25, `datasheet.txt` line 34169).";

        field {
            name = "interlace";
            desc = "interlace";
            sw = rw;
            hw = r;
            reset = 0x0;
        } interlace[2:2];

        field {
            name = "hsync_sel";
            desc = "hsync_sel";
            sw = rw;
            hw = r;
            reset = 0x0;
        } hsync_sel[1:1];

        field {
            name = "cbar_en";
            desc = "cbar_en";
            sw = rw;
            hw = r;
            reset = 0x0;
        } cbar_en[0:0];
    } PT_TEST_CFG @ 0x40;

    reg {
        name = "Port ID status register";
        desc = "PT_ID_STATUS is a port ID status register.

Data sheet 11.1.6 PT_ID_STATUS (offset 0x10044, printed page 11-26, `datasheet.txt` line 34226).";

        field {
            name = "id3";
            desc = "Channel 3 ID.";
            sw = r;
            hw = w;
            reset = 0x0;
        } id3[7:6];

        field {
            name = "id2";
            desc = "Channel 2 ID.";
            sw = r;
            hw = w;
            reset = 0x0;
        } id2[5:4];

        field {
            name = "id1";
            desc = "Channel 1 ID.";
            sw = r;
            hw = w;
            reset = 0x0;
        } id1[3:2];

        field {
            name = "id0";
            desc = "Channel 0 ID.";
            sw = r;
            hw = w;
            reset = 0x0;
        } id0[1:0];
    } PT_ID_STATUS @ 0x44;

    reg {
        name = "Port timing register 0";
        desc = "CH_INTF_CFG0 is timing register 0.

Data sheet 11.1.6 CH_INTF_CFG0 (offset 0x10300, printed page 11-27, `datasheet.txt` line 34256).";

        field {
            name = "port_scan_mod";
            desc = "Port data input mode. Bit[8]: Scan_mode[1] 0: Y/C composite input mode 1: Y/C separation input mode Bit[7]: Scan_mode[0] 0: interlaced input mode 1: progressive input mode";
            sw = rw;
            hw = r;
            reset = 0x0;
        } port_scan_mod[8:7];

        field {
            name = "port_mode";
            desc = "Port data receive mode. 00: BT.656/BT.1120 mode Other values: reserved";
            sw = rw;
            hw = r;
            reset = 0x0;
        } port_mode[6:5];
    } CH_INTF_CFG0 @ 0x300;

    reg {
        name = "Port timing register 1";
        desc = "CH_INTF_CFG1 is timing register 1.

Data sheet 11.1.6 CH_INTF_CFG1 (offset 0x10304, printed page 11-28, `datasheet.txt` line 34314).";

        enum CH_INTF_CFG1_port_mod_enum {
            SINGLE_COMPONENT_INPUT = 0 { name = "Single Component Input"; desc = "single-component input"; };
            DUAL_COMPONENT_INPUT = 1 { name = "Dual Component Input"; desc = "dual-component input"; };
            TRIPLE_COMPONENT_INPUT = 2 { name = "Triple Component Input"; desc = "triple -component input"; };
            RESERVED = 3 { name = "Reserved"; desc = "reserved"; };
        };

        field {
            name = "port_mod";
            desc = "Port mode.";
            sw = rw;
            hw = r;
            encode = CH_INTF_CFG1_port_mod_enum;
            reset = 0x0;
        } port_mod[15:14];

        field {
            name = "yuv_seq";
            desc = "YUV input sequence. 00: UYVY 01: VYUY 10: YUYV 11: YVYU UV sequence in dual-component mode. 00: VUVU 01: UVUV 10: reserved 11: reserved";
            sw = rw;
            hw = r;
            reset = 0x0;
        } yuv_seq[5:4];

        enum CH_INTF_CFG1_ftc_cfg_enum {
            FIXED_AT_1 = 0 { name = "Fixed At 1"; desc = "fixed at 1"; };
            FIXED_AT_0 = 1 { name = "Fixed At 0"; desc = "fixed at 0"; };
        };

        field {
            name = "ftc_cfg";
            desc = "MSB of the BT.656 timing reference code.";
            sw = rw;
            hw = r;
            encode = CH_INTF_CFG1_ftc_cfg_enum;
            reset = 0x0;
        } ftc_cfg[3:3];

        enum CH_INTF_CFG1_ftc_polar_enum {
            V_1ST_FIELD_F = 0 { name = "V 1St Field F"; desc = "1st field:F = 0 and 2nd field:F = 1 (standard)"; };
            V_1ST_FIELD_F_2 = 1 { name = "V 1St Field F 2"; desc = "1st field:F = 1 and 2nd field:F = 0 (non-standard)"; };
        };

        field {
            name = "ftc_polar";
            desc = "Polarity of the field indication bit (F) of the BT.656 timing reference code.";
            sw = rw;
            hw = r;
            encode = CH_INTF_CFG1_ftc_polar_enum;
            reset = 0x0;
        } ftc_polar[2:2];

        enum CH_INTF_CFG1_sav_ver_en_enum {
            DISABLED = 0 { name = "Disabled"; desc = "disabled"; };
            ENABLED = 1 { name = "Enabled"; desc = "enabled"; };
        };

        field {
            name = "sav_ver_en";
            desc = "SAV and EAV data check enable.";
            sw = rw;
            hw = r;
            encode = CH_INTF_CFG1_sav_ver_en_enum;
            reset = 0x0;
        } sav_ver_en[0:0];
    } CH_INTF_CFG1 @ 0x304;

    reg {
        name = "Frame sync delay register";
        desc = "CH_FSTART_DLY is frame sync delay register. The data sheet lists no bit fields for it.

Data sheet 11.1.6 CH_FSTART_DLY (offset 0x10360, printed page 11-29, `datasheet.txt` line 34379).";

        field {
            name = "value";
            desc = "Register value (the data sheet gives no bit table for this register).";
            sw = rw;
            hw = r;
            reset = 0x0;
        } value[31:0];
    } CH_FSTART_DLY @ 0x360;

    reg {
        name = "Channel control register";
        desc = "CH_CTRL is a channel control register.

Data sheet 11.1.6 CH_CTRL (offset 0x10400, printed page 11-29, `datasheet.txt` line 34398).";

        enum CH_CTRL_ch_en_enum {
            DISABLED = 0 { name = "Disabled"; desc = "disabled"; };
            ENABLED = 1 { name = "Enabled"; desc = "enabled"; };
        };

        field {
            name = "ch_en";
            desc = "Channel enable.";
            sw = rw;
            hw = r;
            encode = CH_CTRL_ch_en_enum;
            reset = 0x0;
        } ch_en[0:0];
    } CH_CTRL @ 0x400;

    reg {
        name = "Capture control register";
        desc = "CH_REG_NEWER is a capture control register.

Data sheet 11.1.6 CH_REG_NEWER (offset 0x10404, printed page 11-30, `datasheet.txt` line 34431).";

        field {
            name = "reg_newer";
            desc = "Channel updated. This bit is automatically cleared when a frame is received.";
            sw = rw;
            hw = r;
            reset = 0x0;
        } reg_newer[0:0];
    } CH_REG_NEWER @ 0x404;

    reg {
        name = "Crop start position register";
        desc = "CH_CROP_START is a crop start position register.

Data sheet 11.1.6 CH_CROP_START (offset 0x10410, printed page 11-30, `datasheet.txt` line 34458).";

        field {
            name = "y_start";
            desc = "Number of the line from which pictures start to be captured.";
            sw = rw;
            hw = r;
            reset = 0x0;
        } y_start[27:16];

        field {
            name = "x_start";
            desc = "Number of the pixel from which pictures start to be captured.";
            sw = rw;
            hw = r;
            reset = 0x0;
        } x_start[11:0];
    } CH_CROP_START @ 0x410;

    reg {
        name = "Crop size configuration register";
        desc = "CH_CROP_SIZE is a crop size configuration register.

Data sheet 11.1.6 CH_CROP_SIZE (offset 0x10414, printed page 11-30, `datasheet.txt` line 34480).";

        field {
            name = "crop_hgt";
            desc = "Height of a captured picture (in lines).";
            sw = rw;
            hw = r;
            reset = 0x23F;
        } crop_hgt[27:16];

        field {
            name = "crop_wth";
            desc = "Width of a line of a captured picture (in pixels).";
            sw = rw;
            hw = r;
            reset = 0x3BF;
        } crop_wth[11:0];
    } CH_CROP_SIZE @ 0x414;

    reg {
        name = "Raw stream luminance storage size register";
        desc = "CH_YDES_SIZE is a luminance storage size register.

Data sheet 11.1.6 CH_YDES_SIZE (offset 0x10418, printed page 11-31, `datasheet.txt` line 34511).";

        field {
            name = "height";
            desc = "Output height of the Y component (in lines).";
            sw = rw;
            hw = r;
            reset = 0x23F;
        } height[27:16];

        field {
            name = "width";
            desc = "Output width of the Y component (in pixels).";
            sw = rw;
            hw = r;
            reset = 0x3BF;
        } width[11:0];
    } CH_YDES_SIZE @ 0x418;

    reg {
        name = "Raw stream chrominance storage size register";
        desc = "CH_CDES_SIZE is a chrominance storage size register.

Data sheet 11.1.6 CH_CDES_SIZE (offset 0x1041C, printed page 11-31, `datasheet.txt` line 34533).";

        field {
            name = "height";
            desc = "Output height of the C component (in lines).";
            sw = rw;
            hw = r;
            reset = 0x23F;
        } height[27:16];

        field {
            name = "width";
            desc = "Output width of the C component (in pixels).";
            sw = rw;
            hw = r;
            reset = 0x3BF;
        } width[11:0];
    } CH_CDES_SIZE @ 0x41C;

    reg {
        name = "Raw stream luminance storage base address register";
        desc = "CH_YBASE_ADDR is a luminance storage base address register.

Data sheet 11.1.6 CH_YBASE_ADDR (offset 0x10420, printed page 11-32, `datasheet.txt` line 34564).";

        field {
            name = "ybase_addr";
            desc = "Base address for storing the luminance of the raw stream.";
            sw = rw;
            hw = r;
            reset = 0x0;
        } ybase_addr[31:0];
    } CH_YBASE_ADDR @ 0x420;

    reg {
        name = "Raw stream chrominance storage base address register";
        desc = "CH_CBASE_ADDR is a chrominance storage base address register.

Data sheet 11.1.6 CH_CBASE_ADDR (offset 0x10424, printed page 11-32, `datasheet.txt` line 34583).";

        field {
            name = "cbase_addr";
            desc = "Base address for storing the chrominance of the raw stream.";
            sw = rw;
            hw = r;
            reset = 0x0;
        } cbase_addr[31:0];
    } CH_CBASE_ADDR @ 0x424;

    reg {
        name = "Raw stream luminance line offset register";
        desc = "CH_YLINE_OFFSET is a luminance line offset register.

Data sheet 11.1.6 CH_YLINE_OFFSET (offset 0x10428, printed page 11-32, `datasheet.txt` line 34601).";

        field {
            name = "y_stride";
            desc = "Stride for storing the picture luminance (in bytes).";
            sw = rw;
            hw = r;
            reset = 0x3C0;
        } y_stride[15:0];
    } CH_YLINE_OFFSET @ 0x428;

    reg {
        name = "Raw stream chrominance line offset register";
        desc = "CH_CLINE_OFFSET is a chrominance line offset register.

Data sheet 11.1.6 CH_CLINE_OFFSET (offset 0x1042C, printed page 11-33, `datasheet.txt` line 34630).";

        field {
            name = "c_stride";
            desc = "Stride for storing the picture chrominance (in bytes).";
            sw = rw;
            hw = r;
            reset = 0x3C0;
        } c_stride[15:0];
    } CH_CLINE_OFFSET @ 0x42C;

    reg {
        name = "Channel raw interrupt register";
        desc = "CH_INT_RAW is a channel raw interrupt register.

Data sheet 11.1.6 CH_INT_RAW (offset 0x10430, printed page 11-33, `datasheet.txt` line 34650).";

        enum CH_INT_RAW_bus_err_enum {
            NO_RAW_INTERRUPT = 0 { name = "No Raw Interrupt"; desc = "No raw interrupt is generated."; };
            RAW_INTERRUPT_GENERATED = 1 { name = "Raw Interrupt Generated"; desc = "A raw interrupt is generated."; };
        };

        field {
            name = "bus_err";
            desc = "Status of the bus error interrupt. Writing 1 clears this interrupt.";
            sw = rw;
            hw = w;
            onwrite = woclr;
            encode = CH_INT_RAW_bus_err_enum;
            reset = 0x0;
        } bus_err[18:18];

        enum CH_INT_RAW_buf_ovf_enum {
            NO_RAW_INTERRUPT = 0 { name = "No Raw Interrupt"; desc = "No raw interrupt is generated."; };
            RAW_INTERRUPT_GENERATED = 1 { name = "Raw Interrupt Generated"; desc = "A raw interrupt is generated."; };
        };

        field {
            name = "buf_ovf";
            desc = "Status of the internal FIFO overflow error interrupt. Writing 1 clears this interrupt.";
            sw = rw;
            hw = w;
            onwrite = woclr;
            encode = CH_INT_RAW_buf_ovf_enum;
            reset = 0x0;
        } buf_ovf[17:17];

        enum CH_INT_RAW_cc_int_enum {
            NO_RAW_INTERRUPT = 0 { name = "No Raw Interrupt"; desc = "No raw interrupt is generated."; };
            RAW_INTERRUPT_GENERATED = 1 { name = "Raw Interrupt Generated"; desc = "A raw interrupt is generated."; };
        };

        field {
            name = "cc_int";
            desc = "Status o the capture completion interrupt. Writing 1 clears this interrupt.";
            sw = rw;
            hw = w;
            onwrite = woclr;
            encode = CH_INT_RAW_cc_int_enum;
            reset = 0x0;
        } cc_int[16:16];

        enum CH_INT_RAW_timing_err_enum {
            NO_RAW_INTERRUPT = 0 { name = "No Raw Interrupt"; desc = "No raw interrupt is generated."; };
            RAW_INTERRUPT_GENERATED = 1 { name = "Raw Interrupt Generated"; desc = "A raw interrupt is generated."; };
        };

        field {
            name = "timing_err";
            desc = "Status of the timing error interrupt. Writing 1 clears this interrupt.";
            sw = rw;
            hw = w;
            onwrite = woclr;
            encode = CH_INT_RAW_timing_err_enum;
            reset = 0x0;
        } timing_err[9:9];

        enum CH_INT_RAW_field_throw_enum {
            NO_RAW_INTERRUPT = 0 { name = "No Raw Interrupt"; desc = "No raw interrupt is generated."; };
            RAW_INTERRUPT_GENERATED = 1 { name = "Raw Interrupt Generated"; desc = "A raw interrupt is generated."; };
        };

        field {
            name = "field_throw";
            desc = "Status of the field/frame loss interrupt. Writing 1 clears this interrupt.";
            sw = rw;
            hw = w;
            onwrite = woclr;
            encode = CH_INT_RAW_field_throw_enum;
            reset = 0x0;
        } field_throw[8:8];

        enum CH_INT_RAW_reg_update_enum {
            NO_RAW_INTERRUPT = 0 { name = "No Raw Interrupt"; desc = "No raw interrupt is generated."; };
            RAW_INTERRUPT_GENERATED = 1 { name = "Raw Interrupt Generated"; desc = "A raw interrupt is generated."; };
        };

        field {
            name = "reg_update";
            desc = "Status of the register update interrupt. Writing 1 clears this interrupt.";
            sw = rw;
            hw = w;
            onwrite = woclr;
            encode = CH_INT_RAW_reg_update_enum;
            reset = 0x0;
        } reg_update[1:1];

        enum CH_INT_RAW_fstart_enum {
            NO_RAW_INTERRUPT = 0 { name = "No Raw Interrupt"; desc = "No raw interrupt is generated."; };
            RAW_INTERRUPT_GENERATED = 1 { name = "Raw Interrupt Generated"; desc = "A raw interrupt is generated."; };
        };

        field {
            name = "fstart";
            desc = "Status of the field/frame start interrupt. Writing 1 clears this interrupt.";
            sw = rw;
            hw = w;
            onwrite = woclr;
            encode = CH_INT_RAW_fstart_enum;
            reset = 0x0;
        } fstart[0:0];
    } CH_INT_RAW @ 0x430;

    reg {
        name = "Channel interrupt register";
        desc = "CH_INT is a channel interrupt register.

Data sheet 11.1.6 CH_INT (offset 0x10434, printed page 11-34, `datasheet.txt` line 34719).";

        enum CH_INT_bus_err_enum {
            NO_RAW_INTERRUPT = 0 { name = "No Raw Interrupt"; desc = "No raw interrupt is generated."; };
            RAW_INTERRUPT_GENERATED = 1 { name = "Raw Interrupt Generated"; desc = "A raw interrupt is generated."; };
        };

        field {
            name = "bus_err";
            desc = "Status of the bus error interrupt.";
            sw = r;
            hw = w;
            encode = CH_INT_bus_err_enum;
            reset = 0x0;
        } bus_err[18:18];

        enum CH_INT_buf_ovf_enum {
            NO_RAW_INTERRUPT = 0 { name = "No Raw Interrupt"; desc = "No raw interrupt is generated."; };
            RAW_INTERRUPT_GENERATED = 1 { name = "Raw Interrupt Generated"; desc = "A raw interrupt is generated."; };
        };

        field {
            name = "buf_ovf";
            desc = "Status of the internal FIFO overflow error interrupt.";
            sw = r;
            hw = w;
            encode = CH_INT_buf_ovf_enum;
            reset = 0x0;
        } buf_ovf[17:17];

        enum CH_INT_cc_int_enum {
            NO_RAW_INTERRUPT = 0 { name = "No Raw Interrupt"; desc = "No raw interrupt is generated."; };
            RAW_INTERRUPT_GENERATED = 1 { name = "Raw Interrupt Generated"; desc = "A raw interrupt is generated."; };
        };

        field {
            name = "cc_int";
            desc = "Status of the capture completion interrupt.";
            sw = r;
            hw = w;
            encode = CH_INT_cc_int_enum;
            reset = 0x0;
        } cc_int[16:16];

        enum CH_INT_timing_err_enum {
            NO_RAW_INTERRUPT = 0 { name = "No Raw Interrupt"; desc = "No raw interrupt is generated."; };
            RAW_INTERRUPT_GENERATED = 1 { name = "Raw Interrupt Generated"; desc = "A raw interrupt is generated."; };
        };

        field {
            name = "timing_err";
            desc = "Status of the timing error interrupt.";
            sw = r;
            hw = w;
            encode = CH_INT_timing_err_enum;
            reset = 0x0;
        } timing_err[9:9];

        enum CH_INT_field_throw_enum {
            NO_RAW_INTERRUPT = 0 { name = "No Raw Interrupt"; desc = "No raw interrupt is generated."; };
            RAW_INTERRUPT_GENERATED = 1 { name = "Raw Interrupt Generated"; desc = "A raw interrupt is generated."; };
        };

        field {
            name = "field_throw";
            desc = "Status of the field/frame loss interrupt.";
            sw = r;
            hw = w;
            encode = CH_INT_field_throw_enum;
            reset = 0x0;
        } field_throw[8:8];

        enum CH_INT_reg_update_enum {
            NO_RAW_INTERRUPT = 0 { name = "No Raw Interrupt"; desc = "No raw interrupt is generated."; };
            RAW_INTERRUPT_GENERATED = 1 { name = "Raw Interrupt Generated"; desc = "A raw interrupt is generated."; };
        };

        field {
            name = "reg_update";
            desc = "Status of the register update interrupt.";
            sw = r;
            hw = w;
            encode = CH_INT_reg_update_enum;
            reset = 0x0;
        } reg_update[1:1];

        enum CH_INT_fstart_enum {
            NO_RAW_INTERRUPT = 0 { name = "No Raw Interrupt"; desc = "No raw interrupt is generated."; };
            RAW_INTERRUPT_GENERATED = 1 { name = "Raw Interrupt Generated"; desc = "A raw interrupt is generated."; };
        };

        field {
            name = "fstart";
            desc = "Status of the frame/field start interrupt.";
            sw = r;
            hw = w;
            encode = CH_INT_fstart_enum;
            reset = 0x0;
        } fstart[0:0];
    } CH_INT @ 0x434;

    reg {
        name = "Channel interrupt mask register";
        desc = "CH_INT_MASK is a channel interrupt mask register.

Data sheet 11.1.6 CH_INT_MASK (offset 0x10438, printed page 11-36, `datasheet.txt` line 34784).";

        enum CH_INT_MASK_bus_err_en_enum {
            MASKED = 0 { name = "Masked"; desc = "masked"; };
            ENABLED = 1 { name = "Enabled"; desc = "enabled"; };
        };

        field {
            name = "bus_err_en";
            desc = "Raw stream bus error interrupt enable.";
            sw = rw;
            hw = r;
            encode = CH_INT_MASK_bus_err_en_enum;
            reset = 0x0;
        } bus_err_en[18:18];

        enum CH_INT_MASK_buf_ovf_en_enum {
            MASKED = 0 { name = "Masked"; desc = "masked"; };
            ENABLED = 1 { name = "Enabled"; desc = "enabled"; };
        };

        field {
            name = "buf_ovf_en";
            desc = "Raw stream internal FIFO overflow error interrupt enable.";
            sw = rw;
            hw = r;
            encode = CH_INT_MASK_buf_ovf_en_enum;
            reset = 0x0;
        } buf_ovf_en[17:17];

        enum CH_INT_MASK_cc_int_en_enum {
            MASKED = 0 { name = "Masked"; desc = "masked"; };
            ENABLED = 1 { name = "Enabled"; desc = "enabled"; };
        };

        field {
            name = "cc_int_en";
            desc = "Raw stream capture completion interrupt enable.";
            sw = rw;
            hw = r;
            encode = CH_INT_MASK_cc_int_en_enum;
            reset = 0x0;
        } cc_int_en[16:16];

        enum CH_INT_MASK_timing_err_en_enum {
            MASKED = 0 { name = "Masked"; desc = "masked"; };
            ENABLED = 1 { name = "Enabled"; desc = "enabled"; };
        };

        field {
            name = "timing_err_en";
            desc = "Timing error interrupt enable.";
            sw = rw;
            hw = r;
            encode = CH_INT_MASK_timing_err_en_enum;
            reset = 0x0;
        } timing_err_en[9:9];

        enum CH_INT_MASK_field_throw_en_enum {
            MASKED = 0 { name = "Masked"; desc = "masked"; };
            ENABLED = 1 { name = "Enabled"; desc = "enabled"; };
        };

        field {
            name = "field_throw_en";
            desc = "Field/Frame loss interrupt enable.";
            sw = rw;
            hw = r;
            encode = CH_INT_MASK_field_throw_en_enum;
            reset = 0x0;
        } field_throw_en[8:8];

        enum CH_INT_MASK_reg_update_en_enum {
            MASKED = 0 { name = "Masked"; desc = "masked"; };
            ENABLED = 1 { name = "Enabled"; desc = "enabled"; };
        };

        field {
            name = "reg_update_en";
            desc = "Register update interrupt enable.";
            sw = rw;
            hw = r;
            encode = CH_INT_MASK_reg_update_en_enum;
            reset = 0x0;
        } reg_update_en[1:1];

        enum CH_INT_MASK_fstart_en_enum {
            MASKED = 0 { name = "Masked"; desc = "masked"; };
            ENABLED = 1 { name = "Enabled"; desc = "enabled"; };
        };

        field {
            name = "fstart_en";
            desc = "Frame/field start interrupt enable.";
            sw = rw;
            hw = r;
            encode = CH_INT_MASK_fstart_en_enum;
            reset = 0x0;
        } fstart_en[0:0];
    } CH_INT_MASK @ 0x438;

    reg {
        name = "Channel status register";
        desc = "CH_STATUS is a channel status register.

Data sheet 11.1.6 CH_STATUS (offset 0x1043C, printed page 11-37, `datasheet.txt` line 34840).";

        enum CH_STATUS_busy_enum {
            IDLE = 0 { name = "Idle"; desc = "idle"; };
            BUSY = 1 { name = "Busy"; desc = "busy"; };
        };

        field {
            name = "busy";
            desc = "Working status.";
            sw = r;
            hw = w;
            encode = CH_STATUS_busy_enum;
            reset = 0x0;
        } busy[19:19];

        enum CH_STATUS_bus_err_enum {
            CORRECT = 0 { name = "Correct"; desc = "correct"; };
            INCORRECT = 1 { name = "Incorrect"; desc = "incorrect"; };
        };

        field {
            name = "bus_err";
            desc = "Bus error.";
            sw = r;
            hw = w;
            encode = CH_STATUS_bus_err_enum;
            reset = 0x0;
        } bus_err[18:18];

        enum CH_STATUS_buf_ovf_enum {
            NOT_OVERFLOW = 0 { name = "Not Overflow"; desc = "not overflow"; };
            OVERFLOW_V = 1 { name = "Overflow V"; desc = "overflow"; };
        };

        field {
            name = "buf_ovf";
            desc = "Internal buffer overflow.";
            sw = r;
            hw = w;
            encode = CH_STATUS_buf_ovf_enum;
            reset = 0x0;
        } buf_ovf[17:17];

        enum CH_STATUS_image_done_enum {
            NOT_COMPLETE = 0 { name = "Not Complete"; desc = "not complete"; };
            COMPLETE = 1 { name = "Complete"; desc = "complete"; };
        };

        field {
            name = "image_done";
            desc = "Capture completion.";
            sw = r;
            hw = w;
            encode = CH_STATUS_image_done_enum;
            reset = 0x0;
        } image_done[16:16];

        enum CH_STATUS_timing_err_enum {
            CORRECT = 0 { name = "Correct"; desc = "correct"; };
            INCORRECT = 1 { name = "Incorrect"; desc = "incorrect"; };
        };

        field {
            name = "timing_err";
            desc = "Timing error status.";
            sw = r;
            hw = w;
            encode = CH_STATUS_timing_err_enum;
            reset = 0x0;
        } timing_err[9:9];

        enum CH_STATUS_field_throw_enum {
            NOT_LOST = 0 { name = "Not Lost"; desc = "not lost"; };
            LOST = 1 { name = "Lost"; desc = "lost"; };
        };

        field {
            name = "field_throw";
            desc = "Field/Frame data loss.";
            sw = r;
            hw = w;
            encode = CH_STATUS_field_throw_enum;
            reset = 0x0;
        } field_throw[8:8];

        enum CH_STATUS_field2_enum {
            ODD_FIELD = 0 { name = "Odd Field"; desc = "odd field"; };
            EVEN_FIELD = 1 { name = "Even Field"; desc = "even field"; };
        };

        field {
            name = "field2";
            desc = "Odd/Even field indicator.";
            sw = r;
            hw = w;
            encode = CH_STATUS_field2_enum;
            reset = 0x0;
        } field2[0:0];
    } CH_STATUS @ 0x43C;

    reg {
        name = "Channel size indication register E";
        desc = "CH_IPI_STATUS_SIZE is a channel size indication register.

Data sheet 11.1.6 CH_IPI_STATUS_SIZE (offset 0x10440, printed page 11-38, `datasheet.txt` line 34900).";

        field {
            name = "height";
            desc = "Picture height.";
            sw = r;
            hw = w;
            reset = 0x0;
        } height[31:16];
    } CH_IPI_STATUS_SIZE @ 0x440;

    reg {
        name = "Channel SEAV indication register AV";
        desc = "CH_IPI_STATUS_SEAV is a channel SEAV indication register.

Data sheet 11.1.6 CH_IPI_STATUS_SEAV (offset 0x10444, printed page 11-38, `datasheet.txt` line 34920).";

        field {
            name = "SEAV";
            desc = "SEAV code value.";
            sw = r;
            hw = w;
            reset = 0x0;
        } SEAV[15:8];
    } CH_IPI_STATUS_SEAV @ 0x444;

    reg {
        name = "Dither configuration register";
        desc = "CH_DITHER_CFG is a dither configuration register.

Data sheet 11.1.6 CH_DITHER_CFG (offset 0x10500, printed page 11-39, `datasheet.txt` line 34951).";

        enum CH_DITHER_CFG_dither_md_enum {
            V_12_BIT_INPUTS = 0 { name = "V 12 Bit Inputs"; desc = "12-bit inputs, 10-bit outputs, no dithering, and direct bit truncation"; };
            V_12_BIT_INPUTS_2 = 1 { name = "V 12 Bit Inputs 2"; desc = "12-bit inputs, 10-bit output, and time-domain dithering"; };
            V_12_BIT_INPUTS_3 = 2 { name = "V 12 Bit Inputs 3"; desc = "12-bit inputs, 10-bit output, and spatial-domain dithering"; };
            V_12_BIT_INPUTS_4 = 3 { name = "V 12 Bit Inputs 4"; desc = "12-bit inputs, 8-bit output, and time-domain and spatial- domain dithering"; };
            V_12_BIT_INPUTS_5 = 4 { name = "V 12 Bit Inputs 5"; desc = "12-bit inputs, 10-bit outputs, and round off"; };
            V_12_BIT_INPUTS_6 = 5 { name = "V 12 Bit Inputs 6"; desc = "12-bit inputs, 8-bit outputs, and round off"; };
            DITHERING_BYPASS = 7 { name = "Dithering Bypass"; desc = "dithering bypass"; };
        };

        field {
            name = "dither_md";
            desc = "Dither mode select. The data sheet (issue 02) gives the register a total reset value of 0xE000_0000, i.e. this field resets to 7 (dither bypass).";
            sw = rw;
            hw = r;
            encode = CH_DITHER_CFG_dither_md_enum;
            reset = 0x7;
        } dither_md[31:29];
    } CH_DITHER_CFG @ 0x500;

    reg {
        name = "Dither coefficient register 0";
        desc = "CH_DITHER_COEF0 is dither coefficient register 0.

Data sheet 11.1.6 CH_DITHER_COEF0 (offset 0x10504, printed page 11-39, `datasheet.txt` line 34984).";

        field {
            name = "dither_coef3";
            desc = "Coefficient 3 for the dither in time-domain mode.";
            sw = rw;
            hw = r;
            reset = 0xDD;
        } dither_coef3[31:24];

        field {
            name = "dither_coef2";
            desc = "Coefficient 2 for the dither in time-domain mode.";
            sw = rw;
            hw = r;
            reset = 0x66;
        } dither_coef2[23:16];

        field {
            name = "dither_coef1";
            desc = "Coefficient 1 for the dither in time-domain mode.";
            sw = rw;
            hw = r;
            reset = 0x44;
        } dither_coef1[15:8];

        field {
            name = "dither_coef0";
            desc = "Coefficient 0 for the dither in time-domain mode.";
            sw = rw;
            hw = r;
            reset = 0x0;
        } dither_coef0[7:0];
    } CH_DITHER_COEF0 @ 0x504;

    reg {
        name = "Dither coefficient register 1";
        desc = "CH_DITHER_COEF1 is dither coefficient register 1.

Data sheet 11.1.6 CH_DITHER_COEF1 (offset 0x10508, printed page 11-40, `datasheet.txt` line 35012).";

        field {
            name = "dither_coef7";
            desc = "Coefficient 7 for the dither in time-domain mode.";
            sw = rw;
            hw = r;
            reset = 0xDD;
        } dither_coef7[31:24];

        field {
            name = "dither_coef6";
            desc = "Coefficient 6 for the dither in time-domain mode.";
            sw = rw;
            hw = r;
            reset = 0x66;
        } dither_coef6[23:16];

        field {
            name = "dither_coef5";
            desc = "Coefficient 5 for the dither in time-domain mode.";
            sw = rw;
            hw = r;
            reset = 0x44;
        } dither_coef5[15:8];

        field {
            name = "dither_coef4";
            desc = "Coefficient 4 for the dither in time-domain mode.";
            sw = rw;
            hw = r;
            reset = 0x0;
        } dither_coef4[7:0];
    } CH_DITHER_COEF1 @ 0x508;

    reg {
        name = "Dither input picture width register";
        desc = "CH_DITHER_SIZE is a dither input picture width register.

Data sheet 11.1.6 CH_DITHER_SIZE (offset 0x1050C, printed page 11-40, `datasheet.txt` line 35034).";

        field {
            name = "width";
            desc = "Input picture width of the dither.";
            sw = rw;
            hw = r;
            reset = 0x3BF;
        } width[11:0];
    } CH_DITHER_SIZE @ 0x50C;

    reg {
        name = "Raw stream mirror control register";
        desc = "CH_MIR_CTRL is a raw stream mirror control register.

Data sheet 11.1.6 CH_MIR_CTRL (offset 0x10510, printed page 11-41, `datasheet.txt` line 35063).";

        enum CH_MIR_CTRL_flip_en_enum {
            DISABLED = 0 { name = "Disabled"; desc = "disabled"; };
            ENABLED = 1 { name = "Enabled"; desc = "enabled"; };
        };

        field {
            name = "flip_en";
            desc = "Flip enable.";
            sw = rw;
            hw = r;
            encode = CH_MIR_CTRL_flip_en_enum;
            reset = 0x0;
        } flip_en[1:1];

        enum CH_MIR_CTRL_mir_en_enum {
            DISABLED = 0 { name = "Disabled"; desc = "disabled"; };
            ENABLED = 1 { name = "Enabled"; desc = "enabled"; };
        };

        field {
            name = "mir_en";
            desc = "Mirror enable. Called we_en in the data sheet bit table (issue 02), described there as horizontal inversion enable; the bit diagram calls it mir_in.";
            sw = rw;
            hw = r;
            encode = CH_MIR_CTRL_mir_en_enum;
            reset = 0x0;
        } mir_en[0:0];
    } CH_MIR_CTRL @ 0x510;

    reg {
        name = "Block mask configuration register";
        desc = "CH_MSC_CFG is a block mask configuration register.

Data sheet 11.1.6 CH_MSC_CFG (offset 0x10700, printed page 11-41, `datasheet.txt` line 35090).";

        enum CH_MSC_CFG_msc3_en_enum {
            DISABLED = 0 { name = "Disabled"; desc = "disabled"; };
            ENABLED = 1 { name = "Enabled"; desc = "enabled"; };
        };

        field {
            name = "msc3_en";
            desc = "Block 3 mask enable.";
            sw = rw;
            hw = r;
            encode = CH_MSC_CFG_msc3_en_enum;
            reset = 0x0;
        } msc3_en[3:3];

        enum CH_MSC_CFG_msc2_en_enum {
            DISABLED = 0 { name = "Disabled"; desc = "disabled"; };
            ENABLED = 1 { name = "Enabled"; desc = "enabled"; };
        };

        field {
            name = "msc2_en";
            desc = "Block 2 mask enable.";
            sw = rw;
            hw = r;
            encode = CH_MSC_CFG_msc2_en_enum;
            reset = 0x0;
        } msc2_en[2:2];

        field {
            name = "msc1_en";
            desc = "msc1_en";
            sw = rw;
            hw = r;
            reset = 0x0;
        } msc1_en[1:1];

        field {
            name = "msc0_en";
            desc = "msc0_en";
            sw = rw;
            hw = r;
            reset = 0x0;
        } msc0_en[0:0];
    } CH_MSC_CFG @ 0x700;

    reg {
        name = "Mask start position register for block 0";
        desc = "CH_BLOCK0_START is the mask start position register for block 0.

Data sheet 11.1.6 CH_BLOCK0_START (offset 0x10710, printed page 11-42, `datasheet.txt` line 35151).";

        field {
            name = "y_start";
            desc = "Vertical start point for masking block 0.";
            sw = rw;
            hw = r;
            reset = 0x0;
        } y_start[27:16];

        field {
            name = "x_start";
            desc = "Horizontal start point for masking block 0.";
            sw = rw;
            hw = r;
            reset = 0x0;
        } x_start[11:0];
    } CH_BLOCK0_START @ 0x710;

    reg {
        name = "Mask start position register for block 1";
        desc = "CH_BLOCK1_START is the mask start position register for block 1.

Data sheet 11.1.6 CH_BLOCK1_START (offset 0x10714, printed page 11-43, `datasheet.txt` line 35182).";

        field {
            name = "y_start";
            desc = "Vertical start point for masking block 1.";
            sw = rw;
            hw = r;
            reset = 0x0;
        } y_start[27:16];

        field {
            name = "x_start";
            desc = "Horizontal start point for masking block 1.";
            sw = rw;
            hw = r;
            reset = 0x0;
        } x_start[11:0];
    } CH_BLOCK1_START @ 0x714;

    reg {
        name = "Mask start position register for block 2";
        desc = "CH_BLOCK2_START is the mask start position register for block 2.

Data sheet 11.1.6 CH_BLOCK2_START (offset 0x10718, printed page 11-43, `datasheet.txt` line 35204).";

        field {
            name = "y_start";
            desc = "Vertical start point for masking block 2.";
            sw = rw;
            hw = r;
            reset = 0x0;
        } y_start[27:16];

        field {
            name = "x_start";
            desc = "Horizontal start point for masking block 2.";
            sw = rw;
            hw = r;
            reset = 0x0;
        } x_start[11:0];
    } CH_BLOCK2_START @ 0x718;

    reg {
        name = "Mask start position register for block 3";
        desc = "CH_BLOCK3_START is the mask start position register for block 3.

Data sheet 11.1.6 CH_BLOCK3_START (offset 0x1071C, printed page 11-43, `datasheet.txt` line 35226).";

        field {
            name = "y_start";
            desc = "Vertical start point for masking block 3.";
            sw = rw;
            hw = r;
            reset = 0x0;
        } y_start[27:16];

        field {
            name = "x_start";
            desc = "Horizontal start point for masking block 3.";
            sw = rw;
            hw = r;
            reset = 0x0;
        } x_start[11:0];
    } CH_BLOCK3_START @ 0x71C;

    reg {
        name = "Mask size register for block 0";
        desc = "CH_BLOCK0_SIZE is the mask size register for block 0.

Data sheet 11.1.6 CH_BLOCK0_SIZE (offset 0x10750, printed page 11-44, `datasheet.txt` line 35257).";

        field {
            name = "blk_height";
            desc = "Height for masking block 0 minus 1.";
            sw = rw;
            hw = r;
            reset = 0x0;
        } blk_height[27:16];

        field {
            name = "blk_width";
            desc = "Width for masking block 0 minus 1.";
            sw = rw;
            hw = r;
            reset = 0x0;
        } blk_width[11:0];
    } CH_BLOCK0_SIZE @ 0x750;

    reg {
        name = "Mask size register for block 1";
        desc = "CH_BLOCK1_SIZE is the mask size register for block 1.

Data sheet 11.1.6 CH_BLOCK1_SIZE (offset 0x10754, printed page 11-44, `datasheet.txt` line 35279).";

        field {
            name = "blk_height";
            desc = "Height for masking block 1 minus 1.";
            sw = rw;
            hw = r;
            reset = 0x0;
        } blk_height[27:16];

        field {
            name = "blk_width";
            desc = "blk_width";
            sw = rw;
            hw = r;
            reset = 0x0;
        } blk_width[11:0];
    } CH_BLOCK1_SIZE @ 0x754;

    reg {
        name = "Mask size register for block 2";
        desc = "CH_BLOCK2_SIZE is the mask size register for block 2.

Data sheet 11.1.6 CH_BLOCK2_SIZE (offset 0x10758, printed page 11-45, `datasheet.txt` line 35321).";

        field {
            name = "blk_height";
            desc = "Height for masking block 2 minus 1.";
            sw = rw;
            hw = r;
            reset = 0x0;
        } blk_height[27:16];

        field {
            name = "blk_width";
            desc = "Width for masking block 2 minus 1.";
            sw = rw;
            hw = r;
            reset = 0x0;
        } blk_width[11:0];
    } CH_BLOCK2_SIZE @ 0x758;

    reg {
        name = "Mask size register for block 3";
        desc = "CH_BLOCK3_SIZE is the mask size register for block 3.

Data sheet 11.1.6 CH_BLOCK3_SIZE (offset 0x1075C, printed page 11-45, `datasheet.txt` line 35342).";

        field {
            name = "blk_height";
            desc = "Height for masking block 3 minus 1.";
            sw = rw;
            hw = r;
            reset = 0x0;
        } blk_height[27:16];

        field {
            name = "blk_width";
            desc = "blk_width";
            sw = rw;
            hw = r;
            reset = 0x0;
        } blk_width[11:0];
    } CH_BLOCK3_SIZE @ 0x75C;

    reg {
        name = "Filling color register for block 0";
        desc = "CH_BLOCK0_COLOR is the filling color register for block 0.

Data sheet 11.1.6 CH_BLOCK0_COLOR (offset 0x10790, printed page 11-46, `datasheet.txt` line 35385).";

        field {
            name = "blk_cr";
            desc = "Cr component of the filling color of block 0.";
            sw = rw;
            hw = r;
            reset = 0x0;
        } blk_cr[23:16];

        field {
            name = "blk_cb";
            desc = "Cb component of the filling color of block 0.";
            sw = rw;
            hw = r;
            reset = 0x0;
        } blk_cb[15:8];

        field {
            name = "blk_y";
            desc = "Y component of the filling color of block 0.";
            sw = rw;
            hw = r;
            reset = 0x0;
        } blk_y[7:0];
    } CH_BLOCK0_COLOR @ 0x790;

    reg {
        name = "Filling color register for block 1";
        desc = "CH_BLOCK1_COLOR is the filling color register for block 1.

Data sheet 11.1.6 CH_BLOCK1_COLOR (offset 0x10794, printed page 11-46, `datasheet.txt` line 35406).";

        field {
            name = "blk_cr";
            desc = "blk_cr";
            sw = rw;
            hw = r;
            reset = 0x0;
        } blk_cr[23:16];

        field {
            name = "blk_cb";
            desc = "blk_cb";
            sw = rw;
            hw = r;
            reset = 0x0;
        } blk_cb[15:8];

        field {
            name = "blk_y";
            desc = "blk_y";
            sw = rw;
            hw = r;
            reset = 0x0;
        } blk_y[7:0];
    } CH_BLOCK1_COLOR @ 0x794;

    reg {
        name = "Filling color register for block 2";
        desc = "CH_BLOCK2_COLOR is the filling color register for block 2.

Data sheet 11.1.6 CH_BLOCK2_COLOR (offset 0x10798, printed page 11-47, `datasheet.txt` line 35449).";

        field {
            name = "blk_cr";
            desc = "Cr component of the filling color of block 2.";
            sw = rw;
            hw = r;
            reset = 0x0;
        } blk_cr[23:16];

        field {
            name = "blk_cb";
            desc = "Cb component of the filling color of block 2.";
            sw = rw;
            hw = r;
            reset = 0x0;
        } blk_cb[15:8];

        field {
            name = "blk_y";
            desc = "Y component of the filling color of block 2.";
            sw = rw;
            hw = r;
            reset = 0x0;
        } blk_y[7:0];
    } CH_BLOCK2_COLOR @ 0x798;

    reg {
        name = "Filling color register for block 3";
        desc = "CH_BLOCK3_COLOR is the filling color register for block 3.

Data sheet 11.1.6 CH_BLOCK3_COLOR (offset 0x1079C, printed page 11-47, `datasheet.txt` line 35470).";

        field {
            name = "blk_cr";
            desc = "Cr component of the filling color of block 3.";
            sw = rw;
            hw = r;
            reset = 0x0;
        } blk_cr[23:16];

        field {
            name = "blk_cb";
            desc = "Cb component of the filling color of block 3.";
            sw = rw;
            hw = r;
            reset = 0x0;
        } blk_cb[15:8];

        field {
            name = "blk_y";
            desc = "Y component of the filling color of block 3.";
            sw = rw;
            hw = r;
            reset = 0x0;
        } blk_y[7:0];
    } CH_BLOCK3_COLOR @ 0x79C;

    reg {
        name = "Major stream chrominance vertical down sampling configuration register";
        desc = "CH_VCDS_CFG is a major stream chrominance vertical down sampling configuration register.

Data sheet 11.1.6 CH_VCDS_CFG (offset 0x10800, printed page 11-48, `datasheet.txt` line 35502).";

        enum CH_VCDS_CFG_cds_en_enum {
            DISABLED = 0 { name = "Disabled"; desc = "disabled"; };
            ENABLED = 1 { name = "Enabled"; desc = "enabled"; };
        };

        field {
            name = "cds_en";
            desc = "Down sampling enable.";
            sw = rw;
            hw = r;
            encode = CH_VCDS_CFG_cds_en_enum;
            reset = 0x0;
        } cds_en[0:0];
    } CH_VCDS_CFG @ 0x800;

    reg {
        name = "Major stream chrominance vertical down sampling coefficient register";
        desc = "CH_VCDS_COEF is a major stream chrominance vertical down sampling coefficient register.

Data sheet 11.1.6 CH_VCDS_COEF (offset 0x10808, printed page 11-48, `datasheet.txt` line 35525).";

        field {
            name = "coef1";
            desc = "Down sampling coefficient 1.";
            sw = rw;
            hw = r;
            reset = 0x0;
        } coef1[20:16];

        field {
            name = "coef0";
            desc = "Down sampling coefficient 0.";
            sw = rw;
            hw = r;
            reset = 0x1F;
        } coef0[4:0];
    } CH_VCDS_COEF @ 0x808;

    reg {
        name = "Luminance horizontal scaling parameter configuration register";
        desc = "CH_SCL_LHFIR_SPH is a luminance horizontal scaling parameter configuration register.

Data sheet 11.1.6 CH_LHFIR_SPH (offset 0x10940, printed page 11-49, `datasheet.txt` line 35558).";

        enum CH_LHFIR_SPH_hlmsc_en_enum {
            DISABLED = 0 { name = "Disabled"; desc = "disabled"; };
            ENABLED = 1 { name = "Enabled"; desc = "enabled"; };
        };

        field {
            name = "hlmsc_en";
            desc = "Luminance horizontal scaling enable.";
            sw = rw;
            hw = r;
            encode = CH_LHFIR_SPH_hlmsc_en_enum;
            reset = 0x0;
        } hlmsc_en[31:31];
    } CH_LHFIR_SPH @ 0x940;

    reg {
        name = "Chrominance horizontal scaling parameter configuration register";
        desc = "CH_CHFIR_SPH is a chrominance horizontal scaling parameter configuration register.

Data sheet 11.1.6 CH_CHFIR_SPH (offset 0x10944, printed page 11-49, `datasheet.txt` line 35586).";

        enum CH_CHFIR_SPH_hchmsc_en_enum {
            DISABLED = 0 { name = "Disabled"; desc = "disabled"; };
            ENABLED = 1 { name = "Enabled"; desc = "enabled"; };
        };

        field {
            name = "hchmsc_en";
            desc = "Chrominance horizontal scaling enable.";
            sw = rw;
            hw = r;
            encode = CH_CHFIR_SPH_hchmsc_en_enum;
            reset = 0x0;
        } hchmsc_en[31:31];

        field {
            name = "hchratio";
            desc = "Not in the Hi3520D data sheet issue 02, which lists bits [30:0] of CH_CHFIR_SPH as reserved (read-only); kept from a later data sheet issue. Chrominance horizontal scaling ratio. It is calculated by dividing the output width by the input width. If horizontal pre-processing is enabled, the input width after pre-processing is used. The ratio is in the format of (u, 4). That is, the ratio is an unsigned number and consists of a 4-bit integral part.";
            sw = rw;
            hw = r;
            reset = 0x0;
        } hchratio[15:12];
    } CH_CHFIR_SPH @ 0x944;

    reg {
        name = "Luminance scaling horizontal offset SET register";
        desc = "CH_LHFIR_OFFSET is a luminance scaling horizontal offset register.

Data sheet 11.1.6 CH_LHFIR_OFFSET (offset 0x10948, printed page 11-50, `datasheet.txt` line 35627).";

        field {
            name = "hluma_offset";
            desc = "Luminance horizontal start position offset, in the format of (s, 5). That is, the offset value consists of a 1-bit signed bit and 4-bit integral part. The value is expressed as a complementary code and the offset value ranges from -6 to +15.";
            sw = rw;
            hw = r;
            reset = 0x0;
        } hluma_offset[16:12];
    } CH_LHFIR_OFFSET @ 0x948;

    reg {
        name = "Chrominance scaling horizontal offset SET register";
        desc = "CH_CHFIR_OFFSET is a chrominance scaling horizontal offset register.

Data sheet 11.1.6 CH_CHFIR_OFFSET (offset 0x1094C, printed page 11-50, `datasheet.txt` line 35651).";

        field {
            name = "hchroma_offset";
            desc = "Chrominance horizontal start position offset, in the format of (s, 5). That is, the offset value consists of a 1-bit signed bit and 4-bit integral part. The value is expressed as a complementary code and the offset value ranges from -6 to +15.";
            sw = rw;
            hw = r;
            reset = 0x0;
        } hchroma_offset[16:12];
    } CH_CHFIR_OFFSET @ 0x94C;

    reg {
        name = "Chrominance clip configuration register";
        desc = "CH_Y_CLIP_CFG is a luminance clip configuration register.

Data sheet 11.1.6 CH_Y_CLIP_CFG (offset 0x10B00, printed page 11-51, `datasheet.txt` line 35685).";

        field {
            name = "max";
            desc = "Maximum output value.";
            sw = rw;
            hw = r;
            reset = 0xFF;
        } max[23:16];

        field {
            name = "min";
            desc = "Minimum output value.";
            sw = rw;
            hw = r;
            reset = 0x0;
        } min[7:0];
    } CH_Y_CLIP_CFG @ 0xB00;

    reg {
        name = "Luminance clip configuration register";
        desc = "CH_C_CLIP_CFG is a chrominance clip configuration register.

Data sheet 11.1.6 CH_C_CLIP_CFG (offset 0x10B04, printed page 11-51, `datasheet.txt` line 35707).";

        field {
            name = "max";
            desc = "Maximum output value.";
            sw = rw;
            hw = r;
            reset = 0xFF;
        } max[23:16];

        field {
            name = "min";
            desc = "Minimum output value.";
            sw = rw;
            hw = r;
            reset = 0x0;
        } min[7:0];
    } CH_C_CLIP_CFG @ 0xB04;

    reg {
        name = "Input picture total luminance statistics register";
        desc = "CH_SUM_Y is an input picture total luminance statistics register.

Data sheet 11.1.6 CH_SUM_Y (offset 0x10C00, printed page 11-52, `datasheet.txt` line 35739).";

        field {
            name = "sum_y";
            desc = "Total luminance statistics.";
            sw = r;
            hw = w;
            reset = 0x0;
        } sum_y[31:0];
    } CH_SUM_Y @ 0xC00;

};

regfile eHISI_VICAP {
    name = "HiSilicon video capture";
    desc = "
    HiSilicon video capture (VICAP) at 0x20580000 (256 KB window), GIC interrupt ID 68. Receives BT.656 (mux) or BT.1120 (mux) video on two 8-bit ports or one 16-bit port (Hi3520D; Hi3515A: one BT.656 port), 8 channels (Hi3515A: 4) of up to 1080p/D1/960H, optional horizontal down-scaling (2x integral), crop window, mirror/flip, luminance statistics, SP420/SP422 output into DDR, two bus priority levels per channel. Registers 0x0000-0x0200 are system registers (WK_MODE, AXI_CFG, MIXER0_PRO_CFG0, VICAP_INT); everything from 0x10000 is per-port/per-channel (see `eHISI_VICAP_CH`). Registers and reset values are from Hi3520D/Hi3515A/Hi3515C data sheet issue 07, chapter 11.1 (`datasheet.txt` lines 32831-35753). Not hardware verified. The data sheet also marks 4-channel 720p input as \"Hi3520D V200 only\". Clock and reset: PERI_CRG (VICAP bits).

    **Other chips (data sheet cross-check 2026-11-09):** no other data sheet in the tree carries this multi-channel VICAP layout (WK_MODE / AXI_CFG / MIXER0_PRO_CFG0 at 0x0000 and
    16 x 0x2000 channel blocks from 0x10000). The Hi3511 / Hi3512 / Hi3515 / Hi3520 VIU, the Hi3516 V100 VICAP (226 registers), the Hi3518 V100 / Hi3518E V100 / Hi3516C V100 VICAP (116
    registers) and the single-port Hi3518E V20X / Hi3516A / Hi3516C V300 / Hi3519 VICAP (`eHISI_VICAP_V2`, PT/DES/CH names) are other generations.
    ";

    reg {
        name = "Global working configuration register";
        desc = "WK_MODE is a global working configuration register.

Data sheet 11.1.6 WK_MODE (offset 0x0, printed page 11-18, `datasheet.txt` line 33726).";

        enum WK_MODE_pt1_mode_enum {
            D1_960H = 0 { name = "D1 960H"; desc = "D1 or 960H"; };
            V_720P = 1 { name = "V 720P"; desc = "720p"; };
        };

        field {
            name = "pt1_mode";
            desc = "Operating mode of port 1.";
            sw = rw;
            hw = r;
            encode = WK_MODE_pt1_mode_enum;
            reset = 0x0;
        } pt1_mode[17:17];

        enum WK_MODE_pt0_mode_enum {
            D1_960H = 0 { name = "D1 960H"; desc = "D1 or 960H"; };
            V_720P_1080P = 1 { name = "V 720P 1080P"; desc = "720p or 1080p"; };
        };

        field {
            name = "pt0_mode";
            desc = "Operating mode of port 0.";
            sw = rw;
            hw = r;
            encode = WK_MODE_pt0_mode_enum;
            reset = 0x0;
        } pt0_mode[16:16];

        enum WK_MODE_power_mode_enum {
            LOW_POWER_MODE = 0 { name = "Low Power Mode"; desc = "The low-power mode is disabled."; };
            LOW_POWER_MODE_2 = 1 { name = "Low Power Mode 2"; desc = "The low-power mode is enabled."; };
        };

        field {
            name = "power_mode";
            desc = "Clock mode.";
            sw = rw;
            hw = r;
            encode = WK_MODE_power_mode_enum;
            reset = 0x0;
        } power_mode[0:0];
    } WK_MODE @ 0x0;

    reg {
        name = "Bus configuration register";
        desc = "AXI_CFG is a bus configuration register.

Data sheet 11.1.6 AXI_CFG (offset 0x4, printed page 11-18, `datasheet.txt` line 33762).";

        field {
            name = "reserved_nz";
            desc = "Reserved (RO); reads 0xF0F: the data sheet total reset value of AXI_CFG is 0xF0F0_0000 (bits 31:28 and 23:20 set).";
            sw = r;
            hw = w;
            reset = 0xF0F;
        } reserved_nz[31:20];

        field {
            name = "m0_id";
            desc = "ID.";
            sw = rw;
            hw = r;
            reset = 0x0;
        } m0_id[19:16];

        field {
            name = "m0_otd";
            desc = "Number of outstandings. The number must be between 0 and 4.";
            sw = rw;
            hw = r;
            reset = 0x0;
        } m0_otd[3:0];
    } AXI_CFG @ 0x4;

    reg {
        name = "Master priority configuration register";
        desc = "MIXER0_PRO_CFG0 is master priority configuration register.

Data sheet 11.1.6 MIXER0_PRO_CFG0 (offset 0x8, printed page 11-19, `datasheet.txt` line 33795).";

        field {
            name = "ch7_c_pro";
            desc = "Chrominance priority of channel 7. The value 0 indicates the highest priority.";
            sw = rw;
            hw = r;
            reset = 0x0;
        } ch7_c_pro[15:15];

        field {
            name = "ch7_y_pro";
            desc = "Luminance priority of channel 7. The value 0 indicates the highest priority.";
            sw = rw;
            hw = r;
            reset = 0x0;
        } ch7_y_pro[14:14];

        field {
            name = "ch6_c_pro";
            desc = "Chrominance priority of channel 6. The value 0 indicates the highest priority.";
            sw = rw;
            hw = r;
            reset = 0x0;
        } ch6_c_pro[13:13];

        field {
            name = "ch6_y_pro";
            desc = "Luminance priority of channel 6. The value 0 indicates the highest priority.";
            sw = rw;
            hw = r;
            reset = 0x0;
        } ch6_y_pro[12:12];

        field {
            name = "ch5_c_pro";
            desc = "Chrominance priority of channel 5. The value 0 indicates the highest priority.";
            sw = rw;
            hw = r;
            reset = 0x0;
        } ch5_c_pro[11:11];

        field {
            name = "ch5_y_pro";
            desc = "Luminance priority of channel 5. The value 0 indicates the highest priority.";
            sw = rw;
            hw = r;
            reset = 0x0;
        } ch5_y_pro[10:10];

        field {
            name = "ch4_c_pro";
            desc = "Chrominance priority of channel 4. The value 0 indicates the highest priority.";
            sw = rw;
            hw = r;
            reset = 0x0;
        } ch4_c_pro[9:9];

        field {
            name = "ch4_y_pro";
            desc = "Luminance priority of channel 4. The value 0 indicates the highest priority.";
            sw = rw;
            hw = r;
            reset = 0x0;
        } ch4_y_pro[8:8];

        field {
            name = "ch3_c_pro";
            desc = "Chrominance priority of channel 3. The value 0 indicates the highest priority.";
            sw = rw;
            hw = r;
            reset = 0x0;
        } ch3_c_pro[7:7];

        field {
            name = "ch3_y_pro";
            desc = "Luminance priority of channel 3. The value 0 indicates the highest priority.";
            sw = rw;
            hw = r;
            reset = 0x0;
        } ch3_y_pro[6:6];

        field {
            name = "ch2_c_pro";
            desc = "Chrominance priority of channel 2. The value 0 indicates the highest priority.";
            sw = rw;
            hw = r;
            reset = 0x0;
        } ch2_c_pro[5:5];

        field {
            name = "ch2_y_pro";
            desc = "Luminance priority of channel 2. The value 0 indicates the highest priority.";
            sw = rw;
            hw = r;
            reset = 0x0;
        } ch2_y_pro[4:4];

        field {
            name = "ch1_c_pro";
            desc = "Chrominance priority of channel 1. The value 0 indicates the highest priority.";
            sw = rw;
            hw = r;
            reset = 0x0;
        } ch1_c_pro[3:3];

        field {
            name = "ch1_y_pro";
            desc = "Luminance priority of channel 1. The value 0 indicates the highest priority.";
            sw = rw;
            hw = r;
            reset = 0x0;
        } ch1_y_pro[2:2];

        field {
            name = "ch0_c_pro";
            desc = "Chrominance priority of channel 0. The value 0 indicates the highest priority.";
            sw = rw;
            hw = r;
            reset = 0x0;
        } ch0_c_pro[1:1];

        field {
            name = "ch0_y_pro";
            desc = "Luminance priority of channel 0. The value 0 indicates the highest priority.";
            sw = rw;
            hw = r;
            reset = 0x0;
        } ch0_y_pro[0:0];
    } MIXER0_PRO_CFG0 @ 0x8;

    reg {
        name = "Interrupt indicator register";
        desc = "VICAP_INT is an interrupt indicator register.

Data sheet 11.1.6 VICAP_INT (offset 0x100, printed page 11-20, `datasheet.txt` line 33877).";

        enum VICAP_INT_int_ch7_enum {
            NO_INTERRUPT_GENERATED = 0 { name = "No Interrupt Generated"; desc = "No interrupt is generated."; };
            INTERRUPT_GENERATED = 1 { name = "Interrupt Generated"; desc = "An interrupt is generated."; };
        };

        field {
            name = "int_ch7";
            desc = "Interrupt indicator of channel 7.";
            sw = r;
            hw = w;
            encode = VICAP_INT_int_ch7_enum;
            reset = 0x0;
        } int_ch7[7:7];

        enum VICAP_INT_int_ch6_enum {
            NO_INTERRUPT_GENERATED = 0 { name = "No Interrupt Generated"; desc = "No interrupt is generated."; };
            INTERRUPT_GENERATED = 1 { name = "Interrupt Generated"; desc = "An interrupt is generated."; };
        };

        field {
            name = "int_ch6";
            desc = "Interrupt indicator of channel 6.";
            sw = r;
            hw = w;
            encode = VICAP_INT_int_ch6_enum;
            reset = 0x0;
        } int_ch6[6:6];

        enum VICAP_INT_int_ch5_enum {
            NO_INTERRUPT_GENERATED = 0 { name = "No Interrupt Generated"; desc = "No interrupt is generated."; };
            INTERRUPT_GENERATED = 1 { name = "Interrupt Generated"; desc = "An interrupt is generated."; };
        };

        field {
            name = "int_ch5";
            desc = "Interrupt indicator of channel 5.";
            sw = r;
            hw = w;
            encode = VICAP_INT_int_ch5_enum;
            reset = 0x0;
        } int_ch5[5:5];

        enum VICAP_INT_int_ch4_enum {
            NO_INTERRUPT_GENERATED = 0 { name = "No Interrupt Generated"; desc = "No interrupt is generated."; };
            INTERRUPT_GENERATED = 1 { name = "Interrupt Generated"; desc = "An interrupt is generated."; };
        };

        field {
            name = "int_ch4";
            desc = "Interrupt indicator of channel 4.";
            sw = r;
            hw = w;
            encode = VICAP_INT_int_ch4_enum;
            reset = 0x0;
        } int_ch4[4:4];

        enum VICAP_INT_int_ch3_enum {
            NO_INTERRUPT_GENERATED = 0 { name = "No Interrupt Generated"; desc = "No interrupt is generated."; };
            INTERRUPT_GENERATED = 1 { name = "Interrupt Generated"; desc = "An interrupt is generated."; };
        };

        field {
            name = "int_ch3";
            desc = "Interrupt indicator of channel 3.";
            sw = r;
            hw = w;
            encode = VICAP_INT_int_ch3_enum;
            reset = 0x0;
        } int_ch3[3:3];

        enum VICAP_INT_int_ch2_enum {
            NO_INTERRUPT_GENERATED = 0 { name = "No Interrupt Generated"; desc = "No interrupt is generated."; };
            INTERRUPT_GENERATED = 1 { name = "Interrupt Generated"; desc = "An interrupt is generated."; };
        };

        field {
            name = "int_ch2";
            desc = "Interrupt indicator of channel 2.";
            sw = r;
            hw = w;
            encode = VICAP_INT_int_ch2_enum;
            reset = 0x0;
        } int_ch2[2:2];

        enum VICAP_INT_int_ch1_enum {
            NO_INTERRUPT_GENERATED = 0 { name = "No Interrupt Generated"; desc = "No interrupt is generated."; };
            INTERRUPT_GENERATED = 1 { name = "Interrupt Generated"; desc = "An interrupt is generated."; };
        };

        field {
            name = "int_ch1";
            desc = "Interrupt indicator of channel 1.";
            sw = r;
            hw = w;
            encode = VICAP_INT_int_ch1_enum;
            reset = 0x0;
        } int_ch1[1:1];

        enum VICAP_INT_int_ch0_enum {
            NO_INTERRUPT_GENERATED = 0 { name = "No Interrupt Generated"; desc = "No interrupt is generated."; };
            INTERRUPT_GENERATED = 1 { name = "Interrupt Generated"; desc = "An interrupt is generated."; };
        };

        field {
            name = "int_ch0";
            desc = "Interrupt indicator of channel 0.";
            sw = r;
            hw = w;
            encode = VICAP_INT_int_ch0_enum;
            reset = 0x0;
        } int_ch0[0:0];
    } VICAP_INT @ 0x100;

    eHISI_VICAP_CH CH[16] @ 0x10000 += 0x2000;

};

`endif
