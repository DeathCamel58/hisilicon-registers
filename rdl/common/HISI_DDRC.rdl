`ifndef DDRC_RDL
`define DDRC_RDL

regfile eDDRC {
    name = "DDRC Registers";
`ifdef DDRC_HI3516V100
    desc = "
        DDRC (DDR2/3 SDRAM Controller) realizes the access control to the dynamic memory DDR2/3 SDRAM. In the following, DDRn SDRAM will be used instead of DDR2/3 SDRAM.

        Hi3516 V100 edition (`DDRC_HI3516V100`, original Chinese data sheet 4.1.5, Table 4-8, base 0x2011_0000, 49 registers): the same controller core as the Hi3518 / Hi3516C V100 and Hi3520D (STATUS, SREFCTRL, INITCTRL, EMRS, CMDCFG/CMDEXE/RNKCFG, TIMING0-4 and the DTR gate-training registers are identical to the Hi3518 tables), with four AXI ports (AXISTATUS bits 3:0, one FIFO level per port in QOSCFG0), a per-rank ODT bitmap in ODTCFG, QoS ID registers at 0x110 with aging / priority adaptation, no BASEADDR / FLUX / TEST registers, and its own DDR PHY control block inside the same window: PHYCFG/PHYNEG/PHYSEL (0x200-0x218), command- and data-lane DLL configuration (CDLLCFG 0x228, QDLLCFG[4] 0x230), DDR3 write leveling (LVL* 0x260-0x2D4), DQS fine tuning (0x2F0/0x2F4) and IO configuration / compensation (0x360-0x388). The data sheet marks many fields 'reserved, not supported in this version' (ECC, exclusive address, extra ranks). The address map (Table 1-1 line 1008) lists the DDRC window as 64 KB at 0x2011_0000; 0x2012_0000 is reserved (no separate PHY window as on the Hi3518).
   ";
`else
`ifdef DDRC_HI3515V100
    desc = "
        DDRC (DDR2 SDRAM controller) of the Hi3515 (data sheet 4.1.5, Table 4-5, base 0x2011_0000, 28 registers): the Hi3520 V100 DDR2 edition (STATUS/CTRL, EMRS01/23, CONFIG, TIMING0-3, ODT_CONFIG 0x94, QOS_CONFIG 0x104, QOS[16] 0x108) plus a self-test / ECC status in STATUS and CTRL, DQS gate training (DTR_CTRL/PRD/GATE/LAT 0x3C-0x48, PHY_STATUS/ADDR/DATA0-3 0x4C-0x60), IF_STATUS 0x90, QOS_CTRL 0x100 and the PHY_CONFIG / DLL_STATUS / DLL_CONFIG / IO_CTRL block at 0x270-0x27C; it has no DLL_CONTROL / DLL_SRST / IO_CONFIG (0x240-0x268). English data sheet only.
   ";
`else
`ifdef DDRC_HI3511V100
    desc = "
        DDRC (DDR2 SDRAM controller) of the Hi3511 / Hi3512 (original Chinese data sheet 4.1.5, Table 4-4, base 0x1015_0000, 13 registers): the oldest edition of the Hi3520 V100 DDR2 controller. STATUS (total reset 0xD), CTRL, raw EMRS01 / EMRS23 (summary name DDRC_DDRCONFIG), CONFIG (reset 0x7022: 32-bit DDR2), TIMING0-3 (TIMING1 has trl instead of trdlat/trtw), ODT_CONFIG at 0x40, DLL_STATUS 0x78, DLL_CONFIG 0x7C and the per-channel DDRC_CHn_QOS[8] at 0x98. No QoS ID map / priority registers, no DLL_CONTROL / DLL_SRST / IO_CONFIG.
   ";
`else
    desc = "
        DDRC (DDR2/3 SDRAM Controller) realizes the access control to the dynamic memory DDR2/3 SDRAM. In the following, DDRn SDRAM will be used instead of DDR2/3 SDRAM.
`ifdef DDRC_16_BIT_ONLY

        !!! NOTE
            This version only supports 16bit DDR bit width.
`endif
   ";
`endif
`endif
`endif

    /* Useful enums to keep from having to keep copying them */
    enum DDRC_zero_enable_enum {
        ENABLE  = 0x0 { desc = "Enable"; };
        DISABLE = 0x1 { desc = "Disable"; };
    };

    enum DDRC_one_enable_enum {
        ENABLE  = 0x0 { desc = "Enable"; };
        DISABLE = 0x1 { desc = "Disable"; };
    };

    // 0 = disabled, 1 = enabled. The two enums above are ENABLE=0/DISABLE=1; fields whose data sheet
    // polarity is 0 = disabled / 1 = enabled (decided per field, see docs/rdl-sweep) encode this one.
    enum DDRC_enabled_enum {
        DISABLE = 0x0 { desc = "Disable"; };
        ENABLE  = 0x1 { desc = "Enable"; };
    };

    // 3-bit DLL / slave-DLL phase delay select used by the PHY_REG6/7/8/9/10/11/15/19/21 fields. PHY_REG6 and
    // PHY_REG7 print the table as 000..111 (000 no delay, 001 22.5, 010 45, 011 67.5, 100 90, 101 112.5, 110 135,
    // 111 157.5 degrees); the other registers print "00..11 = 0..67.5 degrees, 000..011 = 90..157.5 degrees" (the
    // leading bit of the code is dropped), which is the same table.
    enum DDRC_dll_phase_enum {
        DELAY_0     = 0x0 { desc = "No delay"; };
        DELAY_22_5  = 0x1 { desc = "22.5 degree delay"; };
        DELAY_45    = 0x2 { desc = "45 degree delay"; };
        DELAY_67_5  = 0x3 { desc = "67.5 degree delay"; };
        DELAY_90    = 0x4 { desc = "90 degree delay"; };
        DELAY_112_5 = 0x5 { desc = "112.5 degree delay"; };
        DELAY_135   = 0x6 { desc = "135 degree delay"; };
        DELAY_157_5 = 0x7 { desc = "157.5 degree delay"; };
    };

    // 2-bit DLL phase delay select (PHY_REG8 / PHY_REG11 *rxdqsdll_dly).
    enum DDRC_dll_phase2_enum {
        DELAY_0    = 0x0 { desc = "No delay"; };
        DELAY_22_5 = 0x1 { desc = "22.5 degree delay"; };
        DELAY_45   = 0x2 { desc = "45 degree delay"; };
        DELAY_67_5 = 0x3 { desc = "67.5 degree delay"; };
    };

    /* Fields */

    reg {
        name = "DDRC_STATUS";
`ifdef DDRC_HI3520D_NOTES
        desc = "
            Data sheet (Hi3520D/Hi3515A/Hi3515C, 4.1.6): total reset 0x0000_0005 (busy = 1, in_sr = 1). Used by the standby sequence (DS 4.1.4.1 'Clock gating'): after setting DDRC_SREFCTRL[sr_req] = 1 poll `in_sr` until it reads 1, and after clearing `sr_req` poll it until it reads 0 (the DS also says to wait at most 1 us for `in_sr` = 0 in the DDR2/DDR3 bring-up sequences). During the initialization sequence poll `in_init` until it reads 0 after writing DDRC_INITCTRL[init_req].
        ";
`endif

`ifdef DDRC_TEST_PASS_FIELD
        enum DDRC_STATUS_test_pass_enum {
            FAIL = 0x0 { desc = "Did not pass the test."; };
            PASS = 0x1 { desc = "Passed the test."; };
        };

        field {
            name = "test_pass";
            desc = "Self-test status (Hi3515 data sheet DDRC_STATUS, dump line 16516; the total reset value 0x0000_004D gives this bit 1 after reset).";
            encode = DDRC_STATUS_test_pass_enum;
            sw = r;
            hw = w;
`ifdef DDRC_RESET_G3
            reset = 0x1;
`endif
        } test_pass[6:6];
`endif

`ifdef DDRC_ECC_SERR_FIELD
        enum DDRC_STATUS_ecc_serr_enum {
            NO_ERR = 0x0 { desc = "No single bit errors."; };
            ERROR  = 0x1 { desc = "A single bit errors."; };
        };

        field {
            name = "ecc_serr";
            desc = "Single-bit error indicator through ECC (data sheet access RC: cleared by reading).";
            encode = DDRC_STATUS_ecc_serr_enum;
            sw = r;
            hw = w;
            onread = rclr;
            reset = 0x0;
        } ecc_serr[5:5];
`endif

`ifdef DDRC_ECC_DERR_FIELD
        enum DDRC_STATUS_ecc_derr_enum {
            NO_ERR = 0x0 { desc = "No multi bit errors."; };
            ERROR  = 0x1 { desc = "A multi bit errors."; };
        };

        field {
            name = "ecc_derr";
            desc = "Multi-bit error indicator through ECC (data sheet access RC: cleared by reading).";
            encode = DDRC_STATUS_ecc_derr_enum;
            sw = r;
            hw = w;
            onread = rclr;
            reset = 0x0;
        } ecc_derr[4:4];
`endif

`ifdef DDRC_RESET_G3
        // Hi3520 V100 (original Chinese data sheet DDRC_STATUS, 0 = initializing, 1 = normal operating mode): the polarity is the
        // opposite of the Hi3518 / Hi3520D data sheets (0 = normal, 1 = initializing). Reset 1 (DS total 0x4D).
        enum DDRC_STATUS_in_init_enum {
            INITIALIZING = 0x0 { desc = "Initializing."; };
            NORMAL       = 0x1 { desc = "Normal operating mode."; };
        };
`else
        enum DDRC_STATUS_in_init_enum {
            NORMAL         = 0x0 { desc = "Normal."; };
            INITIALIZATION = 0x1 { desc = "Initialization state."; };
        };
`endif

        field {
            name = "in_init";
            desc = "Initialization status of the controller.";
            encode = DDRC_STATUS_in_init_enum;
`ifdef DDRC_RESET_G2
            reset = 0x0;
`endif
`ifdef DDRC_RESET_G3
            reset = 0x1;
`endif
            sw = r;
            hw = w;
        } in_init[3:3];

`ifdef DDRC_RESET_G3
`ifndef DDRC_TEST_PASS_FIELD   // Hi3515: bit 6 is test_pass (reset 1); Hi3511: total reset 0xD, bit 6 reads 0
`ifndef DDRC_HI3511V100
        field {
            name = "reserved_nz";
            desc = "Reserved in the bit table ([31:4] RO reserved), but the Hi3520 V100 data sheet total reset value is 0x0000_004D, so bit 6 reads 1 after reset (original Chinese data sheet 4.1.7 DDRC_STATUS, `hi3520v100--Hi3520-Datasheet.txt` line 20606).";
            sw = r;
            hw = na;
            reset = 0x1;
        } reserved_nz[6:6];
`endif
`endif
`endif

        enum DDRC_STATUS_in_sr_enum {
            NORMAL       = 0x0 { desc = "Normal."; };
            SELF_REFRESH = 0x1 { desc = "Self-refresh state."; };
        };

        field {
            name = "in_sr";
            desc = "Controller self-refresh status.";
            encode = DDRC_STATUS_in_sr_enum;
            reset = 0x1;
            sw = r;
            hw = w;
        } in_sr[2:2];

        enum DDRC_STATUS_busy_enum {
            IDLE       = 0x0 { desc = "Idle."; };
            PROCESSING = 0x1 { desc = "Command processing."; };
        };

        field {
            name = "busy";
            desc = "Controller busy status register.";
            encode = DDRC_STATUS_busy_enum;
            reset = 0x1;
            sw = r;
            hw = w;
        } busy[0:0];

    } DDRC_STATUS @ 0x0000;

    reg {
        name = "DDRC self-refresh control register";
`ifdef DDRC_HI3520D_NOTES
        desc = "
            Data sheet 4.1.6: only `sr_req` (bit 0, reset 1, so the controller comes out of reset in self-refresh) exists in this register; bits [31:1] are reserved. The DS text of 3.9 (Power management) and 4.1.4.5 (Low power configuration) speaks of a field `DDRC_SREFCTRL[sr_seq]`, which does not appear in the register description (probably a leftover from a sibling DDRC with more fields); treat it as nonexistent.

            Standby sequence from the DS 4.1.4.1 (run from on-chip RAM or flash, not from DDR): (1) set `sr_req` = 1; (2) poll DDRC_STATUS[in_sr] until 1; (3) clear DDRC_PHY_REG4[phy_ck_en] as the DS says (note the polarity conflict described there); (4) gate the DDRC clock. Exit: (1) enable the DDRC clock; (2) write DDRC_CONFIG1 = 0x0040_0785 and set DDRC_PHY_REG4[phy_ck_en] = 1; (3) write DDRC_PHYCTRL (0x408) = 0 to start the DDRPHY initialization; (4) wait about 500 ns and poll DDRC_PHYSTATUS[phy_init_done] (0x404) until 1; (5) clear `sr_req`; (6) poll DDRC_STATUS[in_sr] until 0.
        ";
`endif

`ifdef DDRC_SREF_TEST_REQ_FIELD
        enum DDRC_SREFCTRL_sref_test_req_enum {
            NORMAL     = 0x0 { desc = "Normal operating mode."; };
            START_TEST = 0x1 { desc = "The self-test starts; the bit is cleared automatically when the test completes."; };
        };

        field {
            name = "sref_test_req";
            desc = "Read/write data channel test of the controller and PHY (Hi3515 data sheet DDRC_CTRL, dump line 16572; the result is DDRC_STATUS.test_pass).";
            encode = DDRC_SREFCTRL_sref_test_req_enum;
            reset = 0x0;
        } sref_test_req[4:4];
`endif

`ifdef DDRC_ECC_EN_FIELD
        field {
            name = "ecc_en";
            desc = "
            ECC enable (the data sheet prints 'CCC enable').

            !!! NOTE
                Not supported.
            ";
            reset = 0x0;
        } ecc_en[3:3];
`endif

`ifdef DDRC_SREFCTRL_RATIO_FIELD
        enum DDRC_SREFCTRL_clk_ratio_enum {
            RATIO_1_2 = 0x0 { desc = "The controller and PHY work in 1:2 mode."; };
            RATIO_1_1 = 0x1 { desc = "The controller and PHY work in 1:1 mode."; };
        };

        field {
            name = "clk_ratio";
            desc = "
            Operating mode of the controller clock.

            !!! NOTE
                Only the `1:1` mode is supported
            ";
            encode = DDRC_SREFCTRL_clk_ratio_enum;
            reset = 0x0;
        } clk_ratio[2:2];
`endif

`ifdef DDRC_INIT_REQ_FIELD
        enum DDRC_SREFCTRL_init_req_enum {
            NORMAL     = 0x0 { desc = "Normal operating mode."; };
            START_INIT = 0x1 { desc = "Start the hardware initialization. When the initialization is complete, this bit is cleared automatically."; };
        };

        field {
            name = "init_req";
`ifdef DDRC_RESET_G3
            desc = "Hardware initialization control. Only writing 1 to this bit has effect (self-clearing). Hi3520 V100: the data sheet calls this register DDRC_CTRL (0x004, reset 0x0000_0001, `hi3520v100--Hi3520-Datasheet.txt` line 20653) with the same two bits; its bit-name row also prints clk_ratio at bit 2 while the bit table lists [31:2] as reserved, so bit 2 is not modelled.";
`else
            desc = "Hardware initialization control. Only writing 1 to this bit has effect (self-clearing).";
`endif
            encode = DDRC_SREFCTRL_init_req_enum;
            reset = 0x0;
        } init_req[1:1];
`endif

        enum DDRC_SREFCTRL_sr_req_enum {
            EXIT  = 0x0 { desc = "Exit self-refresh state."; };
            ENTER = 0x1 { desc = "Enter self-refresh state."; };
        };

        field {
            name = "sr_req";
            desc = "SDRAM self-refresh request.";
            encode = DDRC_SREFCTRL_sr_req_enum;
            reset = 0x1;
        } sr_req[0:0];

    } DDRC_SREFCTRL @ 0x0004;

`ifdef DDRC_INITCTRL_0x08_REG
    reg {
        name = "DDRC initialization control register";

        enum DDRC_INITCTRL_init_req_enum {
            COMPLETED = 0x0 { desc = "Completed initialization or in normal working state."; };
            START     = 0x1 { desc = "Start SDRAM initialization operation."; };
        };

        field {
            name = "init_req";
            desc = "Initialization starts.";
            encode = DDRC_INITCTRL_init_req_enum;
            reset = 0x0;
        } init_req[0:0];

    } DDRC_INITCTRL @ 0x0008;
`endif

`ifdef DDRC_EMRS01_0X08_REG
`ifdef DDRC_HI3511V100
    reg {
        name = "DDR2 SDRAM mode register 01";
        desc = "Hi3511 DDRC_EMRS01: the low 16 bits of the DDR2 SDRAM MRS and EMRS1 mode registers, written raw (the data sheet does not decode the fields as the Hi3520 V100 one does). Original Chinese data sheet 4.1.5 (`hi3511v100--Hi3511-Datasheet.txt` line 14160, total reset 0x0000_0000).";

        field {
            name = "emrs1";
            desc = "DDR2 SDRAM extended mode register 1 (low 16 bits of EMRS1).";
            reset = 0x0;
        } emrs1[31:16];

        field {
            name = "mrs";
            desc = "DDR2 SDRAM mode register (low 16 bits of MRS).";
            reset = 0x0;
        } mrs[15:0];
    } DDRC_EMRS01 @ 0x0008;
`else
    reg {
        name = "Mode configuration register for DDR";
        desc = "Hi3520 V100 DDR2 mode register 1 (DDRC_EMRS01). Bits [31:23] and [15:12] are reserved and must be written as 0. Original Chinese data sheet 4.1.7 (`hi3520v100--Hi3520-Datasheet.txt` line 20686), total reset 0x0000_0000.";

        field {
            name = "ddr_rtt1";
            desc = "DDR2 SDRAM termination (RTT), high bit. {ddr_rtt1, ddr_rtt0}: 00 termination disabled, 01 75 ohm, 10 150 ohm, 11 50 ohm. Configure according to the DDR2 SDRAM vendor manual (original Chinese data sheet DDRC_EMRS01, `hi3520v100--Hi3520-Datasheet.txt` line 20686).";
            reset = 0x0;
        } ddr_rtt1[22:22];

        field {
            name = "ddr_al";
            desc = "Reserved, must be written as 0 (the data sheet names the field ddr_al, additive latency, but documents it as reserved).";
            reset = 0x0;
        } ddr_al[21:19];

        field {
            name = "ddr_rtt0";
            desc = "DDR2 SDRAM termination (RTT), low bit. {ddr_rtt1, ddr_rtt0}: 00 termination disabled, 01 75 ohm, 10 150 ohm, 11 50 ohm. Configure according to the DDR2 SDRAM vendor manual.";
            reset = 0x0;
        } ddr_rtt0[18:18];

        enum DDRC_EMRS01_ddr_drv_enum {
            STRONG = 0x0 { desc = "Strong drive"; };
            WEAK   = 0x1 { desc = "Weak Drive"; };
        };

        field {
            name = "ddr_drv";
            desc = "DDR2 SDRAM drive capability.";
            encode = DDRC_EMRS01_ddr_drv_enum;
            reset = 0x0;
        } ddr_drv[17:17];

        field {
            name = "ddr_dll_en";
            desc = "DDR2 SDRAM DLL enable.";
            encode = DDRC_enabled_enum;
            reset = 0x0;
        } ddr_dll_en[16:16];

        enum DDRC_EMRS01_ddr_wr_enum {
            CYCLE_2 = 0x2 { desc = "2 clock cycles"; };
            CYCLE_3 = 0x3 { desc = "3 clock cycles"; };
            CYCLE_4 = 0x4 { desc = "4 clock cycles"; };
            CYCLE_5 = 0x5 { desc = "5 clock cycles"; };
            CYCLE_6 = 0x6 { desc = "6 clock cycles"; };
        };

        field {
            name = "ddr_wr";
            desc = "DDR2 SDRAM write recovery time (other values reserved).";
            encode = DDRC_EMRS01_ddr_wr_enum;
            reset = 0x0;
        } ddr_wr[11:9];

        enum DDRC_EMRS01_ddr_rst_enum {
            NO_RESET = 0x0 { desc = "Not Reset"; };
            RESET    = 0x1 { desc = "Reset"; };
        };

        field {
            name = "ddr_rst";
            desc = "DDR2 SDRAM DLL reset control.";
            encode = DDRC_EMRS01_ddr_rst_enum;
            reset = 0x0;
        } ddr_rst[8:8];

        enum DDRC_EMRS01_ddr_tm_enum {
            NORMAL = 0x0 { desc = "Normal Mode"; };
            TEST   = 0x1 { desc = "Test Mode"; };
        };

        field {
            name = "ddr_tm";
            desc = "DDR2 SDRAM test mode.";
            encode = DDRC_EMRS01_ddr_tm_enum;
            reset = 0x0;
        } ddr_tm[7:7];

        enum DDRC_EMRS01_ddr_cas_enum {
            CYCLE_3 = 0x3 { desc = "3 Clock Cycles"; };
            CYCLE_4 = 0x4 { desc = "4 Clock Cycles"; };
            CYCLE_5 = 0x5 { desc = "5 Clock Cycles"; };
            CYCLE_6 = 0x6 { desc = "6 Clock Cycles"; };
        };

        field {
            name = "ddr_cas";
            desc = "DDR2 SDRAM CAS latency (other values reserved).";
            encode = DDRC_EMRS01_ddr_cas_enum;
            reset = 0x0;
        } ddr_cas[6:4];

        enum DDRC_EMRS01_ddr_bt_enum {
            SEQUENTIAL = 0x0 { desc = "Sequential burst"; };
            RESERVED   = 0x1 { desc = "Reserved"; };
        };

        field {
            name = "ddr_bt";
            desc = "DDR2 SDRAM burst type.";
            encode = DDRC_EMRS01_ddr_bt_enum;
            reset = 0x0;
        } ddr_bt[3:3];

        enum DDRC_EMRS01_ddr_bl_enum {
            FOUR  = 0x2 { desc = "4"; };
            EIGHT = 0x3 { desc = "8"; };
        };

        field {
            name = "ddr_bl";
            desc = "DDR2 SDRAM burst length (other values reserved).";
            encode = DDRC_EMRS01_ddr_bl_enum;
            reset = 0x0;
        } ddr_bl[2:0];

    } DDRC_EMRS01 @ 0x0008;
`endif
`endif

`ifdef DDRC_EMRS23_0x0C_REG
    reg {
        name = "Extended Mode Configuration Register for DDR";
`ifdef DDRC_HI3511V100
        desc = "Hi3511: the low 16 bits of the DDR2 SDRAM EMRS2 / EMRS3 mode registers. The data sheet summary table (Table 4-4) calls this register DDRC_DDRCONFIG; the description block calls it DDRC_EMRS23 (original Chinese data sheet 4.1.5, `hi3511v100--Hi3511-Datasheet.txt` line 14193, total reset 0x0000_0000).";
`endif

        field {
            name = "emrs3";
            desc = "Reserved, fixed at 0.";
            reset = 0x0;
        } emrs3[31:16];

        field {
            name = "emrs2";
            desc = "Reserved, fixed at 0.";
            reset = 0x0;
        } emrs2[15:0];

    } DDRC_EMRS23 @ 0x000C;
`endif

`ifdef DDRC_CTRL_REG
    reg {
        name = "DDRC Control Register";

        enum DDRC_CTRL_ddr_rst_n_enum {
            VALID   = 0x0 { desc = "Reset is valid."; };
            INVALID = 0x1 { desc = "reset is invalid."; };
        };

`ifdef DDRC_HI3516V100
        field {
            name = "cmdlane_ctrl";
            desc = "Reserved; not supported in this version (Hi3516 V100 original Chinese data sheet 4.1.5 DDRC_CTRL, `hi3516v100--Hi3516-Datasheet.txt` line 22070). Resets to 3 (total reset value 0x0000_000C).";
            reset = 0x3;
        } cmdlane_ctrl[3:2];

        field {
            name = "eccnt_clr";
            desc = "Reserved; not supported in this version (Hi3516 V100 data sheet).";
            reset = 0x0;
        } eccnt_clr[1:1];
`endif

        field {
            name = "ddr_rst_n";
            desc = "
                DDR3 SDRAM reset.

                !!! NOTE:
                    Only valid for DDR3 SDRAM, the default configuration is 0.
            ";
            encode = DDRC_CTRL_ddr_rst_n_enum;
            reset = 0x0;
        } ddr_rst_n[0:0];

    } DDRC_CTRL @ 0x0010;
`endif

`ifdef DDRC_CONFIG_0x10_REG
    reg {
        name = "DDRC Configuration Register";
        desc = "Hi3520 V100 DDRC_CONFIG (original Chinese data sheet 4.1.7, `hi3520v100--Hi3520-Datasheet.txt` line 20825, total reset 0x0000_6022). Bits 19, 17, [11:10] and 3 are reserved (RW).";

        field {
            name = "init_arefnum";
            desc = "
                Number of auto refreshes issued by the hardware initialization.

                * `0x0`-`0x2`: 2
                * `0x3`-`0xF`: n (decimal value of the field)
            ";
            reset = 0x0;
        } init_arefnum[31:28];

        field {
`ifdef DDRC_HI3511V100
            name = "pd_prd";
`else
            name = "pr_prd";
`endif
            desc = "
                Count of wait CLKs for automatic power down. (Hi3511 data sheet name pd_prd, Hi3520 V100 pr_prd.) When the controller does not receive any request for a period, it disables the CKE of the DDR2 SDRAM.

                * `0x00`: When pd_en is valid and the controller does not receive any request at the next clock cycle, the DDR2 SDRAM enters the low- power mode automatically.
                * `0x01`ΓÇô`0xn`: When pd_en is valid and the controller does not receive any request within n clock cycles, the DDR2 SDRAM enters the low-power mode automatically.

                !!! NOTE
                    For example, 0x03 indicates that the DDR2 SDRAM enters the low-power mode automatically if it does not receive any request within three clock cycles.
            ";
            reset = 0x0;
`ifdef DDRC_HI3511V100
        } pd_prd[27:20];
`else
        } pr_prd[27:20];
`endif

        field {
            name = "sr_cc";
            desc = "Self-refresh clock enable.";
            encode = DDRC_enabled_enum;
            reset = 0x0;
        } sr_cc[18:18];

        enum DDRC_CONFIG_pd_en_enum {
            NO_POWER_DOWN = 0x0 { desc = "Do not enter the power-down mode automatically."; };
            POWER_DOWN    = 0x1 { desc = "Enter the power-down mode automatically."; };
        };

        field {
            name = "pd_en";
            desc = "Auto power-down enable. This signal is used to enable or disable the CKE of the DDR2 SDRAM automatically. When no read or write request is received within PD_PRD clock cycles, the CKE input of the DDR2 SDRAM is disabled automatically.";
            encode = DDRC_CONFIG_pd_en_enum;
            reset = 0x0;
        } pd_en[16:16];

        enum DDRC_CONFIG_mem_type_enum {
            DDR2_16 = 0x6 { desc = "16-bit DDR2"; };
            DDR2_32 = 0x7 { desc = "32-bit DDR2"; };
        };

        field {
            name = "mem_type";
            desc = "External memory type (the data sheet documents only 0x6 and 0x7, other values reserved). Resets to 0x6 (16-bit) on the Hi3520 V100 (total 0x0000_6022) and 0x7 (32-bit) on the Hi3511 (total 0x0000_7022).";
            encode = DDRC_CONFIG_mem_type_enum;
`ifdef DDRC_HI3511V100
            reset = 0x7;
`else
            reset = 0x6;
`endif
        } mem_type[15:12];

        enum DDRC_CONFIG_ap_enum {
            A10 = 0x0 { desc = "A10"; };
            A8  = 0x1 { desc = "A8 (this value is used for early memories and rarely used for current memories)"; };
        };

        field {
            name = "ap";
            desc = "Precharge all indicator.";
            encode = DDRC_CONFIG_ap_enum;
            reset = 0x0;
        } ap[9:9];

        enum DDRC_CONFIG_mem_map_enum {
            RBCD = 0x0 { desc = "Row, Bank, Col, Dw"; };
            BRCD  = 0x1 { desc = "Bank, Row, Col, Dw"; };
        };

        field {
            name = "mem_map";
            desc = "Translation mode of the memory address.";
            encode = DDRC_CONFIG_mem_map_enum;
            reset = 0x0;
        } mem_map[8:8];

        enum DDRC_CONFIG_mem_bank_enum {
            FOUR  = 0x0 { desc = "4"; };
            EIGHT = 0x1 { desc = "8"; };
        };

        field {
            name = "mem_bank";
            desc = "Number of memory banks.";
            encode = DDRC_CONFIG_mem_bank_enum;
            reset = 0x0;
        } mem_bank[7:7];

        enum DDRC_CONFIG_mem_row_enum {
            ELEVEN   = 0x0 { desc = "11"; };
            TWELVE   = 0x1 { desc = "12"; };
            THIRTEEN = 0x2 { desc = "13"; };
            FOURTEEN = 0x3 { desc = "14"; };
            FIFTEEN  = 0x4 { desc = "15"; };
            SIXTEEN  = 0x5 { desc = "16"; };
        };

        field {
            name = "mem_row";
            desc = "Bit width of the row address for a single SDRAM.";
            encode = DDRC_CONFIG_mem_row_enum;
            reset = 0x2;
        } mem_row[6:4];

        enum DDRC_CONFIG_mem_col_enum {
            EIGHT  = 0x0 { desc = "8"; };
            NINE   = 0x1 { desc = "9"; };
            TEN    = 0x2 { desc = "10"; };
            ELEVEN = 0x3 { desc = "11"; };
            TWELVE = 0x4 { desc = "12"; };
        };

        field {
            name = "mem_col";
            desc = "Bit width of the column address for a single SDRAM.";
            encode = DDRC_CONFIG_mem_col_enum;
            reset = 0x2;
        } mem_col[2:0];

    } DDRC_CONFIG @ 0x0010;
`endif

`ifdef DDRC_EMRS01_0X14_REG
    reg {
        name = "Mode configuration register for DDR";

        field {
            name = "emrs1";
            desc = "
                DDRn SDRAM Extended Mode Register 1.
                Corresponds to Mode Register 1 (MR1) [15:0] in DDRn SDRAM manual. Among them, MR1[15:14] of most DDR devices is not used, and [31:30] of DDRC_EMRS01 is reserved and set to 0b00.

                !!! NOTE:
                    For the specific explanation of MR1 , please refer to the manual of the DDRn SDRAM used.
            ";
            reset = 0x0;
        } emrs1[31:16];

        field {
            name = "mrs";
            desc = "
                DDRn SDRAM mode register.
                Corresponds to Mode Register 0 (MR0) [15:0] in DDRn SDRAM manual. Among them, MR0[15:14] of most DDR devices is not used, then DDRC_EMRS01 [15:14] is reserved and set to 0b00.

                !!! NOTE:
                    For the specific explanation of MR0 , please refer to the manual of the DDRn SDRAM used.
            ";
            reset = 0x0;
        } mrs[15:0];

    } DDRC_EMRS01 @ 0x0014;
`endif

`ifdef DDRC_EMRS23_0x18_REG
    reg {
        name = "Extended Mode Configuration Register for DDR";

        field {
            name = "emrs3";
            desc = "
                DDRn SDRAM Extended Mode Register 3.
                Corresponds to Mode Register 3 (MR3) [15:0] in DDRn SDRAM manual. Among them, MR3[15:14] of most DDR devices is not used, and DDRC_EMRS23 [31:30] is reserved and set to 0b00.

                !!! NOTE:
                    For the specific explanation of MR3 , please refer to the manual of the DDRn SDRAM used.
            ";
            reset = 0x0;
        } emrs3[31:16];

        field {
            name = "emrs2";
            desc = "
                DDRn SDRAM Extended Mode Register 2.
                Corresponds to Mode Register 2 (MR2) [15::0] in DDRn SDRAM manual. Among them, MR2[15:14] of most DDR devices is not used, and DDRC_EMRS23 [15:14] is reserved and set to 0b00.

                !!! NOTE:
                    For the specific explanation of MR2 , please refer to the manual of the DDRn SDRAM used.
            ";
            reset = 0x0;
        } emrs2[15:0];

    } DDRC_EMRS23 @ 0x0018;
`endif

`ifdef DDRC_CONFIG0_0x1C_REG
    reg {
        name = "Configure register 0 of DDRC function";

        field {
            name = "init_arefnum";
            desc = "
                Number of auto-refresh operations issued during DDRn SDRAM initialization.

                * `0x0`-`0x2`: 2 times
                * `0x3`-`0xF`: n times
            ";
            reset = 0x2;
        } init_arefnum[31:28];

        field {
            name = "pd_prd";
            desc = "
                SDRAM low power consumption (Power Down) cycle configuration. When DDRC does not receive a command in consecutive pd_prd cycles, it controls SDRAM to enter a low power consumption state, and when a new command arrives, it controls SDRAM to exit a low power consumption state.
                0x00: 1 clock cycle;
                0x01-0xFF: n clock cycles.
                !!! NOTE
                    This parameter is only valid when pd_en is 1 ; the clock cycle is the DDRC bus clock cycle.
            ";
            reset = 0x0;
        } pd_prd[27:20];

`ifndef DDRC_HI3516V100   // Hi3516 V100 data sheet: bit 19 reserved (RW)
        enum DDRC_CONFIG0_rcv_pdr_enum {
            FORBIDDEN = 0x0 { desc = "Forbidden."; };
            ENABLE    = 0x1 { desc = "Enable."; };
        };

        field {
            name = "rcv_pdr";
            desc = "DDR receive IO dynamic Power Down control enable. When enabled, DDRC will turn off the receive buffer of DDR data IO in the non-read state.";
            encode = DDRC_CONFIG0_rcv_pdr_enum;
            reset = 0x0;
        } rcv_pdr[19:19];
`endif

        enum DDRC_CONFIG0_sr_cc_enum {
            CLK_ENABLE  = 0x0 { desc = "Do not turn off the SDRAM clock."; };
            CLK_DISABLE = 0x1 { desc = "Disable SDRAM clock."; };
        };

        field {
            name = "sr_cc";
            desc = "Self-refresh mode, SDRAM clock control.";
            encode = DDRC_CONFIG0_sr_cc_enum;
            reset = 0x0;
        } sr_cc[18:18];

        enum DDRC_CONFIG0_pd_cc_enum {
            CLK_ENABLE  = 0x0 { desc = "Do not turn off the SDRAM clock."; };
            CLK_DISABLE = 0x1 { desc = "Disable SDRAM clock."; };
        };

        field {
            name = "pd_cc";
            desc = "
                Low power mode (PowerDown), SDRAM clock control.

                !!! NOTE
                    This parameter is only valid when the external DDR is LPDDR/LPDDR2 SDRAM.
            ";
            encode = DDRC_CONFIG0_pd_cc_enum;
            reset = 0x0;
        } pd_cc[17:17];

        field {
            name = "pd_en";
            desc = "SDRAM automatic low power enable.";
            encode = DDRC_enabled_enum;
            reset = 0x0;
        } pd_en[16:16];

`ifndef DDRC_CONFIG0_NO_2T   // Hi3518 / Hi3516C data sheets: bits [15:14] reserved (RW); Hi3520D: ddrc_2t_sel / ddrc_2t_en
        enum DDRC_CONFIG0_ddrc_2t_sel_enum {
            VALID_ONE  = 0x0 { desc = "On the DDR interface, the CS_N signal is valid for one cycle, RAS_N, CAS_N and WE_N are valid for two cycles, and the address is valid for two cycles."; };
            ALWAYS_LOW = 0x1 { desc = "On the DDR interface, the CS_N signal is always active low, and RAS_N, CAS_N and WE_N are valid for one cycle , the address is valid for two cycles."; };
        };

        field {
            name = "ddrc_2t_sel";
            desc = "2t timing mode selection.";
            encode = DDRC_CONFIG0_ddrc_2t_sel_enum;
`ifdef DDRC_RESET_G1
            reset = 0x0;
`endif
        } ddrc_2t_sel[15:15];

        field {
            name = "ddrc_2t_en";
            desc = "2t timing enable control.";
            encode = DDRC_enabled_enum;
`ifdef DDRC_RESET_G1
            reset = 0x0;
`endif
        } ddrc_2t_en[14:14];
`endif

        enum DDRC_CONFIG0_rank_enum {
            RANK_1 = 0x0 { desc = "1 Rank"; };  // chips without DDRC_MULTIPLE_RANKS: other values reserved
`ifdef DDRC_MULTIPLE_RANKS
            RANK_2 = 0x1 { desc = "2 Ranks"; };
            RANK_3 = 0x2 { desc = "3 Ranks"; };
            RANK_4 = 0x3 { desc = "4 Ranks"; };
`endif
        };

        field {
            name = "rank";
            desc = "Controller Rank configuration.";
            encode = DDRC_CONFIG0_rank_enum;
            reset = 0x0;
        } rank[13:12];

        enum DDRC_CONFIG0_dram_type_enum {
            DDR2 = 0x5 { desc = "DDR2"; };
            DDR3 = 0x6 { desc = "DDR3"; };
        };

        field {
            name = "dram_type";
            desc = "External memory type.";
            encode = DDRC_CONFIG0_dram_type_enum;
            reset = 0x5;
        } dram_type[10:8];

        enum DDRC_CONFIG0_mem_width_enum {
            BIT_16 = 0x0 { desc = "16 Bit"; };
            BIT_32 = 0x1 { desc = "32 Bit"; };
        };

        field {
            name = "mem_width";
            desc = "Store data bus width.";
            encode = DDRC_CONFIG0_mem_width_enum;
            reset = 0x1;
        } mem_width[5:4];

        field {
            name = "brst_a12";
            desc = "
                DDR3 SDRAM A12 command enable.
                !!! NOTE
                    The recommended configuration is 0.
            ";
            encode = DDRC_enabled_enum;
            reset = 0x0;
        } brst_a12[1:1];

        enum DDRC_CONFIG0_brstlen_enum {
            BL4 = 0x0 { desc = "BL4"; };
            BL8 = 0x1 { desc = "BL8"; };
        };

        field {
            name = "brstlen";
            desc = "
                Controller Burst Length configuration.
                When the frequency ratio of DDRC to PHY is 1:1, DDR2 can be configured as Burst4 and Burst8, and DDR3 can only be configured as Burst8 mode.
                When the frequency ratio of DDRC to PHY is 1:2, both DDR2 and DDR3 can only be configured as Burst4 mode.
            ";
            encode = DDRC_CONFIG0_brstlen_enum;
            reset = 0x0;
        } brstlen[0:0];

    } DDRC_CONFIG0 @ 0x001C;
`endif

`ifdef DDRC_CONFIG1_0x20_REG
    reg {
        name = "Register 1 for configuring the DDRC function";

        enum DDRC_CONFIG1_pin_output_disable_enum {
            NO_DISABLE = 0x0 { desc = "Do not turn off the pin output."; };
            DISABLE    = 0x1 { desc = "Disable pin output."; };
        };

`ifndef DDRC_HI3516V100   // Hi3516 V100 data sheet: bits [31:17] reserved (RO), bit 10 reserved; total reset 0x0000_A380 unchanged
        field {
            name = "sref_arefnum";
            desc = "
                DDRn SDRAM In the DFS process, the number of auto-refresh operations issued after exiting self-refresh.
                0x0-0x1: Send 1 Auto Refresh operation.
                0x2-0xF: Send n Auto Refresh operations.
                !!! NOTE
                    Valid when train_en=1.
                    When train_en=0, self-refresh will be exited directly, and no Auto Refresh operation will be sent.
            ";
            reset = 0x0;
        } sref_arefnum[31:28];

        field {
            name = "sref_zqc_en";
            desc = "
                ZQ Calibration Long is enabled when DDR exits self-refresh.

                !!! NOTE
                    Valid for DDR3 and LPDDR2 modes. If the DDR is in the self-refresh state for a long time, it needs to be configured as 1.
            ";
            encode = DDRC_enabled_enum;
            reset = 0x0;
        } sref_zqc_en[22:22];

        enum DDRC_CONFIG1_clk_switch_enum {
            NO_BACK_PRESSURE = 0x0 { desc = "No back pressure command, directly return ERROR corresponding."; };
            BACK_PRESSURE    = 0x1 { desc = "Back pressure interface command, after the clock switching is completed, continue to execute the original command."; };
        };

        field {
            name = "clk_switch";
            desc = "DDRC Low Power Clock Switching Control. Whether DDRC enters the low power consumption state (DDR Self Refresh) and back pressures the AXI interface command.";
            encode = DDRC_CONFIG1_clk_switch_enum;
            reset = 0x0;
        } clk_switch[20:20];

        field {
            name = "odis_ddrio";
            desc = "
                Output shutdown configuration for DDR command and data IO.

                !!! NOTE
                    This configuration is a static configuration. It is recommended that after configuring DDR to enter self_refresh , it can be configured as 1 to turn off the output of DDR command and data IO . Before configuring DDR to exit self_refresh , configure it as 0 to enable the output of DDR commands and data IO.
            ";
            encode = DDRC_CONFIG1_pin_output_disable_enum;
            reset = 0x0;
        } odis_ddrio[17:17];
`endif

        field {
            name = "pd_ac";
            desc = "
                Low power mode (PowerDown), SDRAM address command dynamic shutdown control.

                !!! NOTE
                    It is valid when pd_en is enabled, and the control pins do not include CKE, ODT, CSN and RESET_N.
            ";
            encode = DDRC_CONFIG1_pin_output_disable_enum;
            reset = 0x0;
        } pd_ac[16:16];

        enum DDRC_CONFIG1_pd_pst_opn_enum {
            CYCLE_0 = 0x0 { desc = "Advance no clock cycles."; };
            CYCLE_1 = 0x1 { desc = "Advance 1 clock cycle."; };
            CYCLE_2 = 0x2 { desc = "Advance 2 clock cycles."; };
            CYCLE_3 = 0x3 { desc = "Advance 3 clock cycles."; };
        };

        field {
            name = "pd_pst_opn";
            desc = "
                Before exiting the low power consumption mode (PowerDown), the SDRAM address command pin is turned on in advance.

                !!! NOTE
                    It is valid when pd_en is enabled, and the control pins do not include CKE and RESET_N; this clock cycle is the DDR SDRAMn working clock cycle.
            ";
            encode = DDRC_CONFIG1_pd_pst_opn_enum;
            reset = 0x2;
        } pd_pst_opn[15:14];

        enum DDRC_CONFIG1_pd_pre_cls_enum {
            CYCLE_0 = 0x0 { desc = "Delay no clock cycles."; };
            CYCLE_1 = 0x1 { desc = "Delay 1 clock cycle."; };
            CYCLE_2 = 0x2 { desc = "Delay 2 clock cycles."; };
            CYCLE_3 = 0x3 { desc = "Delay 3 clock cycles."; };
        };

        field {
            name = "pd_pre_cls";
            desc = "
                SDRAM address command shutdown delay after entering low power consumption mode (PowerDown).

                !!! NOTE
                    It is valid when pd_en is enabled, and the control pins do not include CKE and RESET_N; this clock cycle is the DDR SDRAMn working clock cycle.
            ";
            encode = DDRC_CONFIG1_pd_pre_cls_enum;
            reset = 0x2;
        } pd_pre_cls[13:12];

`ifndef DDRC_HI3516V100
        field {
            name = "auto_pre_en";
            desc = "The Auto Precharge function is enabled.";
            encode = DDRC_enabled_enum;
            reset = 0x0;
        } auto_pre_en[10:10];
`endif

`ifdef DDRC_HI3516V100
        field {
            name = "dual_ch";
            desc = "Reserved; not supported in this version (Hi3516 V100 original Chinese data sheet 4.1.5 DDRC_CONFIG1, `hi3516v100--Hi3516-Datasheet.txt` line 22260).";
            reset = 0x0;
        } dual_ch[4:4];
`endif

        enum DDRC_CONFIG1_wr_rcv_mode_enum {
            DIRECT = 0x0 { desc = "Write command direct receiving mode."; };
            WAIT   = 0x1 { desc = "Write command needs to wait for the corresponding write data to arrive before being received."; };
        };

        field {
            name = "wr_rcv_mode";
            desc = "DDRC AXI port write command receive mode selection.";
            encode = DDRC_CONFIG1_wr_rcv_mode_enum;
            reset = 0x1;
        } wr_rcv_mode[9:9];

        field {
            name = "exclu_en";
            desc = "Exclusive commands are enabled.";
            encode = DDRC_enabled_enum;
            reset = 0x1;
        } exclu_en[8:8];

        field {
            name = "lock_en";
            desc = "WRAP command lock enable.";
            encode = DDRC_enabled_enum;
            reset = 0x1;
        } lock_en[7:7];

        enum DDRC_CONFIG1_aref_mode_enum {
            EVERY_CYCLE = 0x0 { desc = "Perform 1 auto-refresh operation every 1 tREFI cycle."; };
            CYCLES_9    = 0x1 { desc = "Perform 8 auto-refresh operations every 9 tREFI cycles."; };
        };

        field {
            name = "aref_mode";
            desc = "Auto refresh mode selection.";
            encode = DDRC_CONFIG1_aref_mode_enum;
            reset = 0x0;
        } aref_mode[6:6];

        field {
            name = "wrlvl_en";
            desc = "DDR3 WriteLVL hardware automatic control enable.";
            encode = DDRC_enabled_enum;
            reset = 0x0;
        } wrlvl_en[5:5];

        enum DDRC_CONFIG1_read_mode_enum {
            ALONG_ROAD = 0x0 { desc = "Read along with the road mode."; };
            DELAYED    = 0x1 { desc = "Delayed read mode. The read-associated mode means that the controller completes data sampling according to the data valid signal sent by the PHY. Delayed read mode refers to the internal delay of the controller to wait for the completion of sampling the data sent by the PHY."; };
        };

        field {
            name = "read_mode";
            desc = "
                Controller read mode selection.

                !!! NOTE
                    This value must be configured as 0 when DDRC_DTRCTRL[train_mode] is configured as 0.
            ";
            encode = DDRC_CONFIG1_read_mode_enum;
            reset = 0x0;
        } read_mode[3:3];

        enum DDRC_CONFIG1_clkratio_enum {
            ONE_TO_ONE = 0x0 { desc = "The frequency ratio of DDRC and PHY is 1:1."; };
            ONE_TO_TWO = 0x1 { desc = "The frequency ratio of DDRC and PHY is 1:2."; };
        };

        field {
            name = "clkratio";
            desc = "Controller working mode.";
            encode = DDRC_CONFIG1_clkratio_enum;
            reset = 0x0;
        } clkratio[2:2];

        field {
            name = "ecc_en";
            desc = "Controller ECC enabled.";
            encode = DDRC_enabled_enum;
            reset = 0x0;
        } ecc_en[1:1];

        field {
            name = "zqc_en";
            desc = "
                DDR3 SDRAM ZQ enable.

                !!! NOTE
                    Valid for DDR3 SDRAM only. The data sheet text says it is set to 1 by default, but its total reset value (0xA380) has this bit at 0; the reset follows the bit table.
            ";
            encode = DDRC_enabled_enum;
            reset = 0x0;
        } zqc_en[0:0];

    } DDRC_CONFIG1 @ 0x0020;
`endif

`ifdef DDRC_TIMING0_0x20_REG
    reg {
        name = "DDR Timing Parameter Register 0";

        enum DDRC_TIMING0_clk_cycles_1_enum {
            CYCLE_1_0 = 0x0 { desc = "1 Clock Cycle"; };
            CYCLE_1_1 = 0x1 { desc = "1 Clock Cycle"; };
            CYCLE_2   = 0x2 { desc = "2 Clock Cycles"; };
            CYCLE_3   = 0x3 { desc = "3 Clock Cycles"; };
            CYCLE_4   = 0x4 { desc = "4 Clock Cycles"; };
            CYCLE_5   = 0x5 { desc = "5 Clock Cycles"; };
            CYCLE_6   = 0x6 { desc = "6 Clock Cycles"; };
            CYCLE_7   = 0x7 { desc = "7 Clock Cycles"; };
            CYCLE_8   = 0x8 { desc = "8 Clock Cycles"; };
            CYCLE_9   = 0x9 { desc = "9 Clock Cycles"; };
            CYCLE_10  = 0xA { desc = "10 Clock Cycles"; };
            CYCLE_11  = 0xB { desc = "11 Clock Cycles"; };
            CYCLE_12  = 0xC { desc = "12 Clock Cycles"; };
            CYCLE_13  = 0xD { desc = "13 Clock Cycles"; };
            CYCLE_14  = 0xE { desc = "14 Clock Cycles"; };
            CYCLE_15  = 0xF { desc = "15 Clock Cycles"; };
        };

        enum DDRC_TIMING0_clk_cycles_2_enum {
            CYCLE_3_0 = 0x0 { desc = "3 Clock Cycles"; };
            CYCLE_3_1 = 0x1 { desc = "3 Clock Cycles"; };
            CYCLE_3_2 = 0x2 { desc = "3 Clock Cycles"; };
            CYCLE_3_3 = 0x3 { desc = "3 Clock Cycles"; };
            CYCLE_4   = 0x4 { desc = "4 Clock Cycles"; };
            CYCLE_5   = 0x5 { desc = "5 Clock Cycles"; };
            CYCLE_6   = 0x6 { desc = "6 Clock Cycles"; };
            CYCLE_7   = 0x7 { desc = "7 Clock Cycles"; };
            CYCLE_8   = 0x8 { desc = "8 Clock Cycles"; };
            CYCLE_9   = 0x9 { desc = "9 Clock Cycles"; };
            CYCLE_10  = 0xA { desc = "10 Clock Cycles"; };
            CYCLE_11  = 0xB { desc = "11 Clock Cycles"; };
            CYCLE_12  = 0xC { desc = "12 Clock Cycles"; };
            CYCLE_13  = 0xD { desc = "13 Clock Cycles"; };
            CYCLE_14  = 0xE { desc = "14 Clock Cycles"; };
            CYCLE_15  = 0xF { desc = "15 Clock Cycles"; };
        };

        enum DDRC_TIMING0_tmrd_enum {
            CYCLE_1_0 = 0x0 { desc = "1 clock cycle"; };
            CYCLE_1_1 = 0x1 { desc = "1 clock cycle"; };
            CYCLE_2   = 0x2 { desc = "2 clock cycles"; };
            CYCLE_3   = 0x3 { desc = "3 clock cycles"; };
            CYCLE_4   = 0x4 { desc = "4 clock cycles"; };
            CYCLE_5   = 0x5 { desc = "5 clock cycles"; };
            CYCLE_6   = 0x6 { desc = "6 clock cycles"; };
            CYCLE_7   = 0x7 { desc = "7 clock cycles"; };
        };

        field {
            name = "tmrd";
            desc = "Wait period for the Load Mode Register (LMR) command. Bit 31 is reserved (original Chinese data sheet DDRC_TIMING0, `hi3520v100--Hi3520-Datasheet.txt` line 20937, total reset 0x7FFF_3F1F).";
            encode = DDRC_TIMING0_tmrd_enum;
            reset = 0x7;
        } tmrd[30:28];

        field {
            name = "trrd";
            desc = "Waiting period from opening BANK A to opening BANK B (ACT bank a to ACT bank b)";
            encode = DDRC_TIMING0_clk_cycles_1_enum;
            reset = 0xF;
        } trrd[27:24];

        field {
            name = "trp";
            desc = "The wait period for the shutdown (PRE period) command.";
            encode = DDRC_TIMING0_clk_cycles_1_enum;
            reset = 0xF;
        } trp[23:20];

        field {
            name = "trcd";
            desc = "Same as BANK activation to read or write (ACT to READ or WRITE) command wait period.";
            encode = DDRC_TIMING0_clk_cycles_2_enum;
            reset = 0xF;
        } trcd[19:16];

        field {
            name = "trc";
            desc = "It is the same as the wait period from active command to active command (active a bank to active a bank) of BANK.";
            encode = DDRC_TIMING0_clk_cycles_1_enum;
            reset = 0x3F;
        } trc[13:8];

        field {
            name = "tras";
            desc = "It is the same as the wait period from BANK activation command to close command (ACT to PRE).";
            encode = DDRC_TIMING0_clk_cycles_1_enum;
            reset = 0x1F;
        } tras[4:0];

    } DDRC_TIMING0 @ 0x0020;
`endif

`ifdef DDRC_CMDCFG_0x24_REG
    reg {
        name = "DDRC Command Configuration Register";

        field {
            name = "cmd_mrs";
            desc = "Value of the DDR mode register when the load mode register (LMR) command is configured.";
            reset = 0x0;
        } cmd_mrs[31:16];

        field {
            name = "cmd_ba";
            desc = "Value of the DDR BA when the LMR command is configured.";
            reset = 0x0;
        } cmd_ba[15:8];

        field {
            name = "cmd_rank";
            desc = "
                Rank for running commands. Each bit controls one rank: 0 = the configuration command is executed on that rank, 1 = it is not executed.

                !!! NOTE
                    The Hi3520D has only rank0, so cmd_rank must be set to 0x0 or 0x1.
            ";
            reset = 0x0;
        } cmd_rank[7:4];

        enum DDRC_cmd_type_enum {
            ENTER_POWER_DOWN = 0x0 { desc = "Enter the deep power-down mode."; };
            EXIT_POWER_DOWN  = 0x1 { desc = "Exit the deep power-down mode."; };
            LMR              = 0x2 { desc = "LMR command."; };
            ZQCL             = 0x3 { desc = "ZQCL"; };
        };

        field {
            name = "cmd_type";
            desc = "DDR command configuration.";
            encode = DDRC_cmd_type_enum;
            reset = 0x0;
        } cmd_type[1:0];
    } DDRC_CMDCFG @ 0x0024;
`endif

`ifdef DDRC_TIMING1_0x24_REG
    reg {
        name = "DDR Timing Parameter Register 1";

        field {
            name = "tsre";
            desc = "
                Wait period from exiting self-refresh to a read command.

                * `0x00`-`0xFF`: n clock cycles (devices usually require 200 clock cycles).

                Original Chinese data sheet DDRC_TIMING1 (`hi3520v100--Hi3520-Datasheet.txt` line 21011, total reset 0xFF01_23FF). Bits 19 and 11 are reserved.
            ";
            reset = 0xFF;
        } tsre[31:24];

`ifdef DDRC_HI3511V100
        enum DDRC_TIMING1_trl_enum {
            CYCLE_3 = 0x2 { desc = "3 clock cycles (default)."; };
            CYCLE_4 = 0x3 { desc = "4 clock cycles."; };
            CYCLE_5 = 0x5 { desc = "5 clock cycles."; };
        };

        field {
            name = "trl";
            desc = "Read data latency, configured for the delay caused by the board and other external factors: 0b010 when the board delay is below one cycle, otherwise according to the delay. Other values reserved. Hi3511 data sheet DDRC_TIMING1 (`hi3511v100--Hi3511-Datasheet.txt` line 14511, total reset 0xFF02_23FF; bits [23:19] reserved, no trdlat).";
            encode = DDRC_TIMING1_trl_enum;
            reset = 0x2;
        } trl[18:16];
`else
        field {
            name = "trdlat";
            desc = "
                Read data latency, determined by the length of the DQS traces on the board.

                * `0x0`-`0xF`: n+1 cycles.
            ";
            reset = 0x0;
        } trdlat[23:20];

        field {
            name = "trtw";
            desc = "
                Latency from the last read data to the first write data.

                * `0b000`-`0b110`: n+1 clock cycles.
            ";
            reset = 0x1;
        } trtw[18:16];
`endif

        field {
            name = "twl";
            desc = "
                Wait period from the write command to the write data.

                * `0x0`-`0xF`: n clock cycles.

                !!! NOTE
                    In DDR2 mode twl is configured as tcl-1, and twl-taond >= 1 must hold.
            ";
            reset = 0x2;
        } twl[15:12];

        enum DDRC_TIMING1_tcl_enum {
            CL_3 = 0x3 { desc = "CL = 3"; };
            CL_4 = 0x4 { desc = "CL = 4"; };
            CL_5 = 0x5 { desc = "CL = 5"; };
            CL_6 = 0x6 { desc = "CL = 6"; };
        };

        field {
            name = "tcl";
            desc = "DDR read command to read data delay (CAS latency); other values reserved.";
            encode = DDRC_TIMING1_tcl_enum;
            reset = 0x3;
        } tcl[10:8];

        field {
            name = "trfc";
            desc = "
                Auto refresh command period and auto refresh to active (AREF period or AREF to ACT) command wait period.

                * `0x00`-`0x01`: 1 clock cycle;
                * `0x02`-`0xFF`: n clock cycles.
            ";
            reset = 0xFF;
        } trfc[7:0];

    } DDRC_TIMING1 @ 0x0024;
`endif

`ifdef DDRC_CMDEXE_0x28_REG
    reg {
        name = "DDRC Software Configuration Command Start Register";

        enum DDRC_cmd_req_enum {
            NOT_EXECUTED = 0x0 { desc = "The command is not executed or the parameter is cleared automatically after the command is executed."; };
            EXECUTED     = 0x1 { desc = "The command is requested to be executed."; };
        };

        field {
            name = "cmd_req";
            encode = DDRC_cmd_req_enum;
            reset = 0x0;
        } cmd_req[0:0];
    } DDRC_CMDEXE @ 0x0028;
`endif

`ifdef DDRC_TIMING2_0x28_REG
    reg {
        name = "DDR Timing Parameter Register 2";

        enum DDRC_TIMING2_clk_cycles_enum {
            CYCLE_0  = 0x0 { desc = "1 Clock Cycle"; };
            CYCLE_1  = 0x1 { desc = "1 Clock Cycle"; };
            CYCLE_2  = 0x2 { desc = "2 Clock Cycles"; };
            CYCLE_3  = 0x3 { desc = "3 Clock Cycles"; };
            CYCLE_4  = 0x4 { desc = "4 Clock Cycles"; };
            CYCLE_5  = 0x5 { desc = "5 Clock Cycles"; };
            CYCLE_6  = 0x6 { desc = "6 Clock Cycles"; };
            CYCLE_7  = 0x7 { desc = "7 Clock Cycles"; };
            CYCLE_8  = 0x8 { desc = "8 Clock Cycles"; };
            CYCLE_9  = 0x9 { desc = "9 Clock Cycles"; };
            CYCLE_10 = 0xA { desc = "10 Clock Cycles"; };
            CYCLE_11 = 0xB { desc = "11 Clock Cycles"; };
            CYCLE_12 = 0xC { desc = "12 Clock Cycles"; };
            CYCLE_13 = 0xD { desc = "13 Clock Cycles"; };
            CYCLE_14 = 0xE { desc = "14 Clock Cycles"; };
            CYCLE_15 = 0xF { desc = "15 Clock Cycles"; };
        };

        enum DDRC_TIMING2_cycles2_enum {
            CYCLE_1_0 = 0x0 { desc = "1 clock cycle"; };
            CYCLE_1_1 = 0x1 { desc = "1 clock cycle"; };
            CYCLE_2   = 0x2 { desc = "2 clock cycles"; };
            CYCLE_3   = 0x3 { desc = "3 clock cycles"; };
        };

        field {
            name = "tcke";
            desc = "Minimum time the DDR stays in the low-power state. Bits [31:30], [27:26], [19:18] and 11 are reserved (original Chinese data sheet DDRC_TIMING2, `hi3520v100--Hi3520-Datasheet.txt` line 21081, total reset 0x33F3_F7FF).";
            encode = DDRC_TIMING2_cycles2_enum;
            reset = 0x3;
        } tcke[29:28];

        field {
            name = "twtr";
            desc = "Wait period from the last write data to a read command (write to read).";
            encode = DDRC_TIMING2_cycles2_enum;
            reset = 0x3;
        } twtr[25:24];

        field {
            name = "twr";
            desc = "Write recovery wait period.";
            encode = DDRC_TIMING2_clk_cycles_enum;
            reset = 0xF;
        } twr[23:20];

        field {
            name = "tfaw";
            desc = "
                Four consecutive activate commands window.

                * `0x00`-`0x3F`: n clock cycles
            ";
            reset = 0x3F;
        } tfaw[17:12];

        field {
            name = "taref";
            desc = "
                Auto refresh period.

                `0x000`: auto refresh disabled.
                `0x001`-`0x7FF`: SDRAM refresh period of 16 x n clock cycles (e.g. 0x008 = 128 clock cycles; depends on the SDRAM operating frequency).
            ";
            reset = 0x7FF;
        } taref[10:0];

    } DDRC_TIMING2 @ 0x0028;
`endif

`ifdef DDRC_RNKCFG_0x2C_REG
    reg {
        name = "Registers to configure DDR features";

        enum DDRC_RNKCFG_mem_map_enum {
            RANK_ROW_BANK_COL = 0x0 { desc = "{Rank, Row, Ba, Col, DW} = AXI address."; };
            RANK_BANK_ROW_COL = 0x1 { desc = "{Rank, Ba, Row, Col, DW} = AXI address."; };
        };

        field {
            name = "mem_map";
            desc = "SDRAM address decoding mode.";
            encode = DDRC_RNKCFG_mem_map_enum;
            reset = 0x0;
        } mem_map[13:12];

        enum DDRC_RNKCFG_mem_bank_enum {
            BANK_4 = 0x0 { desc = "4 Bank."; };
            BANK_8 = 0x1 { desc = "8 Bank."; };
        };

        field {
            name = "mem_bank";
            desc = "
                Single chip SDRAM Bank number.

                !!! NOTE
                    When there are multiple ranks, different configurations are supported for each rank in the same channel. But in dual-channel mode, both channels must use the same configuration.
            ";
            encode = DDRC_RNKCFG_mem_bank_enum;
            reset = 0x0;
        } mem_bank[8:8];

        enum DDRC_RNKCFG_mem_row_enum {
            BIT_11 = 0x0 { desc = "11 Bit."; };
            BIT_12 = 0x1 { desc = "12 Bit."; };
            BIT_13 = 0x2 { desc = "13 Bit."; };
            BIT_14 = 0x3 { desc = "14 Bit."; };
            BIT_15 = 0x4 { desc = "15 Bit."; };
            BIT_16 = 0x5 { desc = "16 Bit."; };
        };

        field {
            name = "mem_row";
            desc = "Single-chip SDRAM row address bit width configuration.";
            encode = DDRC_RNKCFG_mem_row_enum;
            reset = 0x0;
        } mem_row[6:4];

        enum DDRC_RNKCFG_mem_col_enum {
            BIT_8  = 0x0 { desc = "8 Bit."; };
            BIT_9  = 0x1 { desc = "9 Bit."; };
            BIT_10 = 0x2 { desc = "10 Bit."; };
            BIT_11 = 0x3 { desc = "11 Bit."; };
            BIT_12 = 0x4 { desc = "12 Bit."; };
        };

        field {
            name = "mem_col";
            desc = "Single-chip SDRAM column address bit width configuration.";
            encode = DDRC_RNKCFG_mem_col_enum;
            reset = 0x0;
        } mem_col[2:0];

    } DDRC_RNKCFG @ 0x002C;
`endif

`ifdef DDRC_TIMING3_0x2C_REG
    reg {
        name = "DDR Timing Parameter Register 3";
        desc = "Hi3520 V100 DDRC_TIMING3 (original Chinese data sheet 4.1.7, `hi3520v100--Hi3520-Datasheet.txt` line 21149, total reset 0x0000_0F02). Bits [31:22] (RO), [19:12] and [7:3] are reserved.";

        enum DDRC_TIMING3_taond_enum {
            CYCLE_2  = 0x0 { desc = "2/2.5"; };
            CYCLE_3  = 0x1 { desc = "3/3.5"; };
            CYCLE_4  = 0x2 { desc = "4/4.5"; };
            CYCLE_5  = 0x3 { desc = "5/5.5"; };
        };

        field {
`ifdef DDRC_HI3511V100
            name = "tanod_taofd";
`else
            name = "taond";
`endif
            desc = "ODT (on-die termination) turn-on / turn-off period (tAOND / tAOFD) in clock cycles. (Hi3511 data sheet name tanod_taofd, Hi3520 V100 taond.)";
            encode = DDRC_TIMING3_taond_enum;
            reset = 0x0;
`ifdef DDRC_HI3511V100
        } tanod_taofd[21:20];
`else
        } taond[21:20];
`endif

        field {
            name = "txard";
            desc = "
                Wait period for exiting the DDR2 SDRAM low-power state.

                * `0x0`-`0xF`: n clock cycles (use the maximum of tXP, tXARD and tXARDS).
            ";
            reset = 0xF;
        } txard[11:8];

        enum DDRC_TIMING3_trtp_enum {
            CYCLE_2_0 = 0x0 { desc = "2 clock cycles"; };
            CYCLE_2_1 = 0x1 { desc = "2 clock cycles"; };
            CYCLE_2_2 = 0x2 { desc = "2 clock cycles"; };
            CYCLE_3   = 0x3 { desc = "3 clock cycles"; };
            CYCLE_4   = 0x4 { desc = "4 clock cycles"; };
            CYCLE_5   = 0x5 { desc = "5 clock cycles"; };
            CYCLE_6   = 0x6 { desc = "6 clock cycles"; };
            CYCLE_7   = 0x7 { desc = "7 clock cycles"; };
        };

        field {
            name = "trtp";
            desc = "Read command to precharge command wait period. The delay is AL + BL/2 + max(trtp, 2) - 2.";
            encode = DDRC_TIMING3_trtp_enum;
            reset = 0x2;
        } trtp[2:0];

    } DDRC_TIMING3 @ 0x002C;
`endif

`ifdef DDRC_DTRCTRL_0x3C_REG
    reg {
        name = "DDRC Gating Training Control Register";

        enum dt_byte_enum {
            DISABLED = 0x0 { desc = "Disabled"; };
            ENABLED  = 0x1 { desc = "Enabled"; };
        };

        field {
            name = "dt_byte_7";
            desc = "Byte 7 training enable. The data sheets print one 8-bit field dt_byte[31:24] (bit n = byte n training enable); it is modelled as one bit per byte lane here.";
            encode = dt_byte_enum;
        } dt_byte_7[31:31];

        field {
            name = "dt_byte_6";
            desc = "Byte 6 training enable.";
            encode = dt_byte_enum;
        } dt_byte_6[30:30];

        field {
            name = "dt_byte_5";
            desc = "Byte 5 training enable.";
            encode = dt_byte_enum;
        } dt_byte_5[29:29];

        field {
            name = "dt_byte_4";
            desc = "Byte 4 training enable.";
            encode = dt_byte_enum;
        } dt_byte_4[28:28];

        field {
            name = "dt_byte_3";
            desc = "Byte 3 training enable.";
            encode = dt_byte_enum;
        } dt_byte_3[27:27];

        field {
            name = "dt_byte_2";
            desc = "Byte 2 training enable.";
            encode = dt_byte_enum;
        } dt_byte_2[26:26];

        field {
            name = "dt_byte_1";
            desc = "Byte 1 training enable.";
            encode = dt_byte_enum;
        } dt_byte_1[25:25];

        field {
            name = "dt_byte_0";
            desc = "Byte 0 training enable.";
            encode = dt_byte_enum;
        } dt_byte_0[24:24];

`ifdef DDRC_TRAIN_START_POS_FIELD
        field {
            name = "train_start_pos";
            desc = "
                Start position of the gating training.

                * `0x0`-`0x5`: n clock cycles
                * Other values: reserved
            ";
            reset = 0x0;
        } train_start_pos[19:16];
`endif

`ifdef DDRC_TRAIN_RANK_FIELD
        field {
            name = "train_rank";
            desc = "
                Number of ranks in the gating training.

                * `0x0`-`0x3`: n + 1 ranks
            ";
            reset = 0x0;
        } train_rank[13:12];
`endif

`ifdef DDRC_RENSEL_FIELD
        field {
            name = "rensel";
            desc = "
                Read enable delay cycle.

                * `0b000`-`0b011`: n + 1 clock cycles
                * Other values: reserved
            ";
        } rensel[11:9];
`endif

`ifdef DDRC_TRAIN_MODE_FIELD
        enum DDRC_DTRCTRL_train_mode_enum {
            DOLPHIN_TRAINING = 0x0 { desc = "Dolphin training mode."; };
            NORMAL_TRAINING  = 0x1 { desc = "Normal training mode."; };
        };

        field {
            name = "train_mode";
            desc = "Gating training mode.";
            encode = DDRC_DTRCTRL_train_mode_enum;
        } train_mode[8:8];
`endif

`ifdef DDRC_DT_LIMIT_FIELD
        enum DDRC_dt_limit_enum {
            SHIFT_0   = 0x0 { desc = "Shift 0┬░."; };
            SHIFT_90  = 0x1 { desc = "Shift 90┬░."; };
            SHIFT_180 = 0x2 { desc = "Shift 180┬░."; };
            SHIFT_270 = 0x3 { desc = "Shift 270┬░."; };
        };

        field {
            name = "dt_limit";
            desc = "DQS gating shift control.";
            encode = DDRC_dt_limit_enum;
        } dt_limit[5:4];
`endif

        enum DDRC_DTRCTRL_track_en_enum {
            FORBIDDEN = 0x0 { desc = "Forbidden."; };
            ENABLE    = 0x1 { desc = "Enable."; };
        };

        field {
            name = "track_en";
            desc = "
                Gated position auto-update enabled.

                !!! NOTE
                    There must be a set of read operations between two train operations, and the continuous access length is greater than DDRBURST8.
            ";
            encode = DDRC_DTRCTRL_track_en_enum;
        } track_en[2:2];

        field {
            name = "train_en";
            desc = "Gated position training enabled.";
            encode = DDRC_one_enable_enum;
        } train_en[1:1];

`ifdef DDRC_ITM_RST_FIELD
        enum DDRC_DTRCTRL_itm_rst_enum {
            VALID   = 0x0 { desc = "Valid"; };
            INVALID = 0x1 { desc = "Invalid"; };
        };

        field {
            name = "itm_rst";
            desc = "ITM reset signal of the PHY: 0: reset asserted (valid); 1: reset released. Resets to 1 (Hi3515 data sheet DDRC_DTR_CTRL total reset 0x0000_0001, dump line 17139).";
            encode = DDRC_DTRCTRL_itm_rst_enum;
            reset = 0x1;
        } itm_rst[0:0];
`endif

    } DDRC_DTRCTRL @ 0x003C;
`endif

`ifdef DDRC_BASEADDR_0x40_REG
    reg {
        name = "DDR space base address configuration register";

        field {
            name = "mem_base_addr";
            desc = "The starting base address configuration of DDR memory space in the whole chip system.";
            reset = 0x0;
        } mem_base_addr[31:0];

    } DDRC_BASEADDR @ 0x0040;
`endif

`ifdef DDRC_DTR_PRD_0x40_REG
    reg {
        name = "DDRC Data Training Period Register";

        field {
            name = "track_prd";
            desc = "
            Auto refresh cycle of the DQS gating. If there is no read operation during the configured clock cycles, the controller automatically initiates a read operation to refresh the DQS gating.

            * 0x0: The controller initiates a dummy read if there is no read operation in one auto-refresh clock cycle.
            * 0x1: The controller initiates a dummy read if there is no read operation in two auto-refresh clock cycles.
            * 0x2-0x7FF: The controller initiates a dummy read if there is no read operation in n+1 auto-refresh clock cycles.
            ";
            reset = 0x0;
        } track_prd[19:0];

    } DDRC_DTR_PRD @ 0x0040;
`endif

`ifdef DDRC_DTR_GATE_0x44_REG
    reg {
        name = "DDRC Data Training Gating Register";

        enum DDRC_DTR_GATE_gate_sel_enum {
            NONE        = 0x0 { desc = "0┬░"; };
            NINETY      = 0x1 { desc = "90┬░"; };
            ONE_EIGHTY  = 0x2 { desc = "180┬░"; };
            TWO_SEVENTY = 0x3 { desc = "270┬░"; };
        };

        field {
            name = "gate_sel7";
            desc = "Gating delay phase of DDR SDRAM byte 7.";
            encode = DDRC_DTR_GATE_gate_sel_enum;
        } gate_sel7[15:14];

        field {
            name = "gate_sel6";
            desc = "Gating delay phase of DDR SDRAM byte 6.";
            encode = DDRC_DTR_GATE_gate_sel_enum;
        } gate_sel6[13:12];

        field {
            name = "gate_sel5";
            desc = "Gating delay phase of DDR SDRAM byte 5.";
            encode = DDRC_DTR_GATE_gate_sel_enum;
        } gate_sel5[11:10];

        field {
            name = "gate_sel4";
            desc = "Gating delay phase of DDR SDRAM byte 4.";
            encode = DDRC_DTR_GATE_gate_sel_enum;
        } gate_sel4[9:8];

        field {
            name = "gate_sel3";
            desc = "Gating delay phase of DDR SDRAM byte 3.";
            encode = DDRC_DTR_GATE_gate_sel_enum;
        } gate_sel3[7:6];

        field {
            name = "gate_sel2";
            desc = "Gating delay phase of DDR SDRAM byte 2.";
            encode = DDRC_DTR_GATE_gate_sel_enum;
        } gate_sel2[5:4];

        field {
            name = "gate_sel1";
            desc = "Gating delay phase of DDR SDRAM byte 1.";
            encode = DDRC_DTR_GATE_gate_sel_enum;
        } gate_sel1[3:2];

        field {
            name = "gate_sel0";
            desc = "Gating delay phase of DDR SDRAM byte 0.";
            encode = DDRC_DTR_GATE_gate_sel_enum;
        } gate_sel0[1:0];

    } DDRC_DTR_GATE @ 0x0044;
`endif

`ifdef DDRC_DTR_LAT_0x48_REG
    reg {
        name = "DDRC data training gating latency register";
        desc = "Gating delay in clock cycles per DDR SDRAM byte (the earlier RDL copied the DTR_GATE phase layout here; corrected against the Hi3515 data sheet 4.1.5 DDRC_DTR_LAT, offset 0x48, printed page 4-26, dump line 17307, total reset 0x0000_0000). Bits 31, 27, 23, 19, 15, 11, 7 and 3 are reserved. The data sheet misspells byte 1 'thpy_rden1'.";

        enum DDRC_DTR_LAT_tphy_rden_enum {
            CYCLE_0 = 0x0 { desc = "0 clock cycles"; };
            CYCLE_1 = 0x1 { desc = "1 clock cycle"; };
            CYCLE_2 = 0x2 { desc = "2 clock cycles"; };
            CYCLE_3 = 0x3 { desc = "3 clock cycles"; };
            CYCLE_4 = 0x4 { desc = "4 clock cycles"; };
            CYCLE_5 = 0x5 { desc = "5 clock cycles"; };
        };

        field {
            name = "tphy_rden7";
            desc = "Gating delay cycle of DDR SDRAM byte 7 (values 6-7 reserved).";
            encode = DDRC_DTR_LAT_tphy_rden_enum;
            reset = 0x0;
        } tphy_rden7[30:28];

        field {
            name = "tphy_rden6";
            desc = "Gating delay cycle of DDR SDRAM byte 6 (values 6-7 reserved).";
            encode = DDRC_DTR_LAT_tphy_rden_enum;
            reset = 0x0;
        } tphy_rden6[26:24];

        field {
            name = "tphy_rden5";
            desc = "Gating delay cycle of DDR SDRAM byte 5 (values 6-7 reserved).";
            encode = DDRC_DTR_LAT_tphy_rden_enum;
            reset = 0x0;
        } tphy_rden5[22:20];

        field {
            name = "tphy_rden4";
            desc = "Gating delay cycle of DDR SDRAM byte 4 (values 6-7 reserved).";
            encode = DDRC_DTR_LAT_tphy_rden_enum;
            reset = 0x0;
        } tphy_rden4[18:16];

        field {
            name = "tphy_rden3";
            desc = "Gating delay cycle of DDR SDRAM byte 3 (values 6-7 reserved).";
            encode = DDRC_DTR_LAT_tphy_rden_enum;
            reset = 0x0;
        } tphy_rden3[14:12];

        field {
            name = "tphy_rden2";
            desc = "Gating delay cycle of DDR SDRAM byte 2 (values 6-7 reserved).";
            encode = DDRC_DTR_LAT_tphy_rden_enum;
            reset = 0x0;
        } tphy_rden2[10:8];

        field {
            name = "tphy_rden1";
            desc = "Gating delay cycle of DDR SDRAM byte 1 (values 6-7 reserved).";
            encode = DDRC_DTR_LAT_tphy_rden_enum;
            reset = 0x0;
        } tphy_rden1[6:4];

        field {
            name = "tphy_rden0";
            desc = "Gating delay cycle of DDR SDRAM byte 0 (values 6-7 reserved).";
            encode = DDRC_DTR_LAT_tphy_rden_enum;
            reset = 0x0;
        } tphy_rden0[2:0];

    } DDRC_DTR_LAT @ 0x0048;
`endif

`ifdef DDRC_TIMING0_0x50_REG
    reg {
        name = "DDR Timing Parameter Register 0";

        enum DDRC_TIMING0_clk_cycles_1_enum {
            CYCLE_1_0 = 0x0 { desc = "1 Clock Cycle"; };
            CYCLE_1_1 = 0x1 { desc = "1 Clock Cycle"; };
            CYCLE_2   = 0x2 { desc = "2 Clock Cycles"; };
            CYCLE_3   = 0x3 { desc = "3 Clock Cycles"; };
            CYCLE_4   = 0x4 { desc = "4 Clock Cycles"; };
            CYCLE_5   = 0x5 { desc = "5 Clock Cycles"; };
            CYCLE_6   = 0x6 { desc = "6 Clock Cycles"; };
            CYCLE_7   = 0x7 { desc = "7 Clock Cycles"; };
            CYCLE_8   = 0x8 { desc = "8 Clock Cycles"; };
            CYCLE_9   = 0x9 { desc = "9 Clock Cycles"; };
            CYCLE_10  = 0xA { desc = "10 Clock Cycles"; };
            CYCLE_11  = 0xB { desc = "11 Clock Cycles"; };
            CYCLE_12  = 0xC { desc = "12 Clock Cycles"; };
            CYCLE_13  = 0xD { desc = "13 Clock Cycles"; };
            CYCLE_14  = 0xE { desc = "14 Clock Cycles"; };
            CYCLE_15  = 0xF { desc = "15 Clock Cycles"; };
        };

        enum DDRC_TIMING0_clk_cycles_2_enum {
            CYCLE_3_0 = 0x0 { desc = "3 Clock Cycles"; };
            CYCLE_3_1 = 0x1 { desc = "3 Clock Cycles"; };
            CYCLE_3_2 = 0x2 { desc = "3 Clock Cycles"; };
            CYCLE_3_3 = 0x3 { desc = "3 Clock Cycles"; };
            CYCLE_4   = 0x4 { desc = "4 Clock Cycles"; };
            CYCLE_5   = 0x5 { desc = "5 Clock Cycles"; };
            CYCLE_6   = 0x6 { desc = "6 Clock Cycles"; };
            CYCLE_7   = 0x7 { desc = "7 Clock Cycles"; };
            CYCLE_8   = 0x8 { desc = "8 Clock Cycles"; };
            CYCLE_9   = 0x9 { desc = "9 Clock Cycles"; };
            CYCLE_10  = 0xA { desc = "10 Clock Cycles"; };
            CYCLE_11  = 0xB { desc = "11 Clock Cycles"; };
            CYCLE_12  = 0xC { desc = "12 Clock Cycles"; };
            CYCLE_13  = 0xD { desc = "13 Clock Cycles"; };
            CYCLE_14  = 0xE { desc = "14 Clock Cycles"; };
            CYCLE_15  = 0xF { desc = "15 Clock Cycles"; };
        };

        field {
            name = "tmrd";
            desc = "Wait period for the Load Mode Register (LMR) command";
            encode = DDRC_TIMING0_clk_cycles_1_enum;
            reset = 0xF;
        } tmrd[31:28];

        field {
            name = "trrd";
            desc = "Waiting period from opening BANK A to opening BANK B (ACT bank a to ACT bank b)";
            encode = DDRC_TIMING0_clk_cycles_1_enum;
            reset = 0xF;
        } trrd[27:24];

        field {
            name = "trp";
            desc = "The wait period for the shutdown (PRE period) command.";
            encode = DDRC_TIMING0_clk_cycles_1_enum;
            reset = 0xF;
        } trp[23:20];

        field {
            name = "trcd";
            desc = "Same as BANK activation to read or write (ACT to READ or WRITE) command wait period.";
            encode = DDRC_TIMING0_clk_cycles_2_enum;
            reset = 0xF;
        } trcd[19:16];

        field {
            name = "trc";
            desc = "It is the same as the wait period from active command to active command (active a bank to active a bank) of BANK.";
            encode = DDRC_TIMING0_clk_cycles_1_enum;
            reset = 0x3F;
        } trc[13:8];

        field {
            name = "tras";
            desc = "It is the same as the wait period from BANK activation command to close command (ACT to PRE).";
            encode = DDRC_TIMING0_clk_cycles_1_enum;
            reset = 0x1F;
        } tras[4:0];

    } DDRC_TIMING0 @ 0x0050;
`endif

`ifdef DDRC_TIMING1_0x54_REG
    reg {
        name = "DDR Timing Parameter Register 1";

        enum DDRC_TIMING1_clk_cycles_1_enum {
            CYCLE_1_0 = 0x0 { desc = "1 Clock Cycle"; };
            CYCLE_1_1 = 0x1 { desc = "1 Clock Cycle"; };
            CYCLE_2   = 0x2 { desc = "2 Clock Cycles"; };
            CYCLE_3   = 0x3 { desc = "3 Clock Cycles"; };
            CYCLE_4   = 0x4 { desc = "4 Clock Cycles"; };
            CYCLE_5   = 0x5 { desc = "5 Clock Cycles"; };
            CYCLE_6   = 0x6 { desc = "6 Clock Cycles"; };
            CYCLE_7   = 0x7 { desc = "7 Clock Cycles"; };
            CYCLE_8   = 0x8 { desc = "8 Clock Cycles"; };
            CYCLE_9   = 0x9 { desc = "9 Clock Cycles"; };
            CYCLE_10  = 0xA { desc = "10 Clock Cycles"; };
            CYCLE_11  = 0xB { desc = "11 Clock Cycles"; };
            CYCLE_12  = 0xC { desc = "12 Clock Cycles"; };
            CYCLE_13  = 0xD { desc = "13 Clock Cycles"; };
            CYCLE_14  = 0xE { desc = "14 Clock Cycles"; };
            CYCLE_15  = 0xF { desc = "15 Clock Cycles"; };
        };

        field {
            name = "tsre";
            desc = "
                Exit the wait cycle from Self-Refresh to Read Command.
                0x0: 1 clock cycle
                0x01-0xFF: nx2 clock cycles.
                For DDR3 SDRAM, this value configures the tXSDLL value.
            ";
            reset = 0xFF;
        } tsre[31:24];

        field {
            name = "trdlat";
            desc = "
                DDRPHY inherent latency.
                
                * `0x0`-`0xF`: n+1 cycles.
                
                When using Dolphin PHY, it is configured as 0x5.
                Valid when read_mode=1 (delayed read mode).
            ";
            reset = 0x0;
        } trdlat[23:20];

        field {
            name = "trtw";
            desc = "
                Latency from last read data to first write data.
                
                * `0x0`-`0x1`: 1 clock cycle;
                * `0x2`-`0xF`: n+1 clock cycle.
            ";
            reset = 0x1;
        } trtw[19:16];

        field {
            name = "twl";
            desc = "
                Wait period from write command to write data.

                !!! NOTE
                    In DDR2 mode, twl is configured as tcl-1, and twl –taond ≥1 should be satisfied when twl is configured.
                    The time parameter is calculated according to the ddr sram clock cycle.
            ";
            encode = DDRC_TIMING1_clk_cycles_1_enum;
            reset = 0x4;
        } twl[15:12];

        field {
            name = "tcl";
            desc = "DDR read command to read data delay (CAS Latency).";
            encode = DDRC_TIMING1_clk_cycles_1_enum;
            reset = 0x5;
        } tcl[11:8];

        field {
            name = "trfc";
            desc = "
                Auto refresh command period and auto refresh to active (AREF period or AREF to ACT) command wait period. This register selects a large value for configuration max{trfc,tzqcs}.
                
                * `0x00`-`0x01`: 1 clock cycle;
                * `0x02`-`0xFF`: n clock cycles.
            ";
            reset = 0xFF;
        } trfc[7:0];

    } DDRC_TIMING1 @ 0x0054;
`endif

`ifdef DDRC_TIMING2_0x58_REG
    reg {
        name = "DDR Timing Parameter Register 2";

        enum DDRC_TIMING2_clk_cycles_enum {
            CYCLE_0  = 0x0 { desc = "1 Clock Cycle"; };
            CYCLE_1  = 0x1 { desc = "1 Clock Cycle"; };
            CYCLE_2  = 0x2 { desc = "2 Clock Cycles"; };
            CYCLE_3  = 0x3 { desc = "3 Clock Cycles"; };
            CYCLE_4  = 0x4 { desc = "4 Clock Cycles"; };
            CYCLE_5  = 0x5 { desc = "5 Clock Cycles"; };
            CYCLE_6  = 0x6 { desc = "6 Clock Cycles"; };
            CYCLE_7  = 0x7 { desc = "7 Clock Cycles"; };
            CYCLE_8  = 0x8 { desc = "8 Clock Cycles"; };
            CYCLE_9  = 0x9 { desc = "9 Clock Cycles"; };
            CYCLE_10 = 0xA { desc = "10 Clock Cycles"; };
            CYCLE_11 = 0xB { desc = "11 Clock Cycles"; };
            CYCLE_12 = 0xC { desc = "12 Clock Cycles"; };
            CYCLE_13 = 0xD { desc = "13 Clock Cycles"; };
            CYCLE_14 = 0xE { desc = "14 Clock Cycles"; };
            CYCLE_15 = 0xF { desc = "15 Clock Cycles"; };
        };

        field {
            name = "tcke";
            desc = "
                The minimum time to maintain a low power state
                This value needs to configure the maximum value among tCKESR, tCKSRE, tCKSRX, and tCKE. When using Dophin's DDRPHY, the value of this register is configured as max{tCKSRx,tCKE}+3.
            ";
            encode = DDRC_TIMING2_clk_cycles_enum;
            reset = 0xF;
        } tcke[31:28];

        field {
            name = "twtr";
            desc = "The wait cycle for the last write data to read command (write to read) of the write operation.";
            encode = DDRC_TIMING2_clk_cycles_enum;
            reset = 0x3;
        } twtr[27:24];

        field {
            name = "twr";
            desc = "
                Write recovery wait period.

                !!! NOTE
                    When DFS is required, the tWR parameter needs to be configured according to the highest possible frequency of the chip in DFS . And the configuration of tWR cannot be modified with the frequency change of DDR .
            ";
            encode = DDRC_TIMING2_clk_cycles_enum;
            reset = 0xF;
        } twr[23:20];

        field {
            name = "tfaw";
            desc = "
                4 consecutive active command cycles.
                
                * `0x00`-`0x3F`: n clock cycles
            ";
            reset = 0x3F;
        } tfaw[17:12];

        field {
            name = "taref";
            desc = "
                Automatic refresh cycle.
                
                `0x000`: Automatic refresh disabled.
                `0x001`-`0x7FF`: SDRAM refresh cycle time is 16xn clock cycles.

                The configuration interval time is (tREFI = 7800ns)/16/tclk. Tclk is twice the operating cycle when SDRAM is used.
                When DDRC_CONFIG1[aref_mode]=1, this register needs to be configured with an interval time of 8 x tREFI.
            ";
            reset = 0x0;
        } taref[10:0];

    } DDRC_TIMING2 @ 0x0058;
`endif

`ifdef DDRC_TIMING3_0x5C_REG
    reg {
        name = "DDR Timing Parameter Register 3";

        field {
            name = "tzq_prd";
            desc = "
                ZQCS command cycle.

                * `0x000`: ZQCS command disabled
                * `0x001`-`0x3FF`: nx128 AREF cycles.

                ZQCS command cycle time is nx128 taref clock cycles.
            ";
            reset = 0x3FF;
        } tzq_prd[31:22];

        field {
            name = "tzqinit";
            desc = "
                ZQ initialization delay period.
                
                * `0x0`-`0x1ff`: n+1 clock cycles.
                
                This value configures the maximum value of tZQINIT, tDLLK.
            ";
            reset = 0x1FF;
        } tzqinit[21:12];

        enum DDRC_TIMING3_taond_enum {
            CYCLE_0  = 0x0 { desc = "2/2.5"; };
            CYCLE_1  = 0x1 { desc = "3/3.5"; };
            CYCLE_2  = 0x2 { desc = "4/4.5"; };
            CYCLE_3  = 0x3 { desc = "5/5.5"; };
        };

        field {
            name = "taond";
            desc = "
                ODT (On-die termination) open and close cycle.
                In DDR2 mode (taond/taofd), enum applies.
                In DDR3 mode, this value is configured as tWL-1.
                !!! NOTE
                    This time parameter is calculated according to ddr sram clock cycle.
            ";
            encode = DDRC_TIMING3_taond_enum;
            reset = 0x0;
        } taond[11:8];

        field {
            name = "txard";
            desc = "
                Exit DDR low-power state wait cycle.

                * `0x0`-`0xF`: n clock cycles, n represents a decimal number
                
                Take the maximum value among {tXP,tXARD,tXARDS,tXS}. In DDR3 mode, when this register is configured as tXS, txard only needs to be configured as an equivalent clock cycle of 10ns.
            ";
            reset = 0xF;
        } txard[7:4];

        enum DDRC_TIMING3_trtp_enum {
            CYCLE_2_0 = 0x0 { desc = "2 Clock Cycles"; };
            CYCLE_2_1 = 0x1 { desc = "2 Clock Cycles"; };
            CYCLE_2_2 = 0x2 { desc = "2 Clock Cycles"; };
            CYCLE_3   = 0x3 { desc = "3 Clock Cycles"; };
            CYCLE_4   = 0x4 { desc = "4 Clock Cycles"; };
            CYCLE_5   = 0x5 { desc = "5 Clock Cycles"; };
            CYCLE_6   = 0x6 { desc = "6 Clock Cycles"; };
            CYCLE_7   = 0x7 { desc = "7 Clock Cycles"; };
        };

        field {
            name = "trtp";
            desc = "
                Wait delay from the read command to the precharge (disable) command.

                * `0x0`-`0x2`: 2 clock cycles
                * `0x3`-`0x7`: n clock cycles

                Trtp is calculated as AL + BL/2 + Max(trtp, 2) - 2.
            ";
            encode = DDRC_TIMING3_trtp_enum;
            reset = 0x2;
        } trtp[3:0];

    } DDRC_TIMING3 @ 0x005C;
`endif

`ifdef DDRC_TIMING4_0x60_REG
    reg {
        name = "DDR Timing Parameter Register 4";

        field {
            name = "twlo";
            desc = "
                DDR3 write level status delay.

                * `0x0`–`0x1`: 1 clock cycle
                * `0x2`–`0xF`: n clock cycles

                The parameter is equal to `twlo`+`twloe` defined in the DDR3 protocol.
                Hi3518 data sheet total reset 0x000F_2028 (`hi3518v100--Hi3518-Datasheet.txt` line 28362).
                ";
            reset = 0xF;
        } twlo[19:16];

        field {
            name = "twldqsen";
            desc = "
                DDR3 write level start delay.

                * `0x0`–`0x1`: 1 clock cycle
                * `0x02`-`0x3F`: n clock cycles
            ";
            reset = 0x20;
        } twldqsen[13:8];

        field {
            name = "twlmrd";
            desc = "
                Valid delay of the initial DQS of DDR3 write level.

                * `0x0`–`0x1`: 1 clock cycle
                * `0x02`-`0x3F`: n clock cycles
            ";
            reset = 0x28;
        } twlmrd[5:0];

    } DDRC_TIMING4 @ 0x0060;
`endif

`ifdef DDRC_ODT_CONFIG_0x40_REG
    reg {
        name = "DDR ODT Feature Configuration Register";
        desc = "Hi3511 DDRC_ODT_CONFIG at 0x40 (original Chinese data sheet 4.1.5, `hi3511v100--Hi3511-Datasheet.txt` line 14712, total reset 0x0000_0001): read ODT enable (0: close the DDR2 SDRAM ODT during reads; 1: open it) and write ODT enable. Same layout as the Hi3520 V100 / Hi3515 register at 0x94. Bits [31:2] are reserved.";

        field {
            name = "rodt";
            desc = "Read ODT enable.";
            encode = DDRC_enabled_enum;
            reset = 0x0;
        } rodt[1:1];

        field {
            name = "wodt";
            desc = "Write ODT enable.";
            encode = DDRC_enabled_enum;
            reset = 0x1;
        } wodt[0:0];

    } DDRC_ODT_CONFIG @ 0x0040;
`endif

`ifdef DDRC_ODT_CONFIG_0x94_REG
    reg {
        name = "DDR ODT Feature Configuration Register";
        desc = "Hi3520 V100 DDRC_ODT_CONFIG (original Chinese data sheet 4.1.7, `hi3520v100--Hi3520-Datasheet.txt` line 21204, total reset 0x0000_0001). Bits [31:2] are reserved (RO).";

        field {
            name = "rodt";
            desc = "Read ODT enable.";
            encode = DDRC_enabled_enum;
            reset = 0x0;
        } rodt[1:1];

        field {
            name = "wodt";
            desc = "Write ODT enable.";
            encode = DDRC_enabled_enum;
            reset = 0x1;
        } wodt[0:0];

    } DDRC_ODT_CONFIG @ 0x0094;
`endif

`ifdef DDRC_DTRADDR_REG
    reg {
        name = "DDR Gating Training Address Configuration Register";

        field {
            name = "train_row";
            desc = "Row address of the DDRn SDRAM used in the gating position training. When the row address is less than 16 bits, the upper bits are stuffed with 0s.";
            reset = 0x0;
        } train_row[31:16];

        field {
            name = "train_bank";
            desc = "Bank address of the DDRn SDRAM used in the gating position training. When the bank address is less than three bits, the upper bits are stuffed with 0s.";
            reset = 0x0;
        } train_bank[15:13];

        field {
            name = "train_col";
            desc = "Column address of the DDRn SDRAM used in the gating position training. When the column address is less than 13 bits, the upper bits are stuffed with 0s.";
            reset = 0x0;
        } train_col[12:0];

    } DDRC_DTRADDR @ 0x00A0;
`endif

`ifdef DDRC_DTRDATA0_REG
    reg {
        name = "DDR Gating Training Data Configuration Register 0";

        field {
            name = "dtr_byte3";
            desc = "
            Gating training data configuration 0 of the DDRC.

            When the DDRC performs training, data must be transferred in DDR BL8 mode in each read or write operation.

            !!! NOTE
                The data configured for each byte (data for the upper four bits and lower four bits) must be different.
            ";
            reset = 0xE1;
        } dtr_byte3[31:24];

        field {
            name = "dtr_byte2";
            desc = "Gating training data configuration of the DDRC.";
            reset = 0x1E;
        } dtr_byte2[23:16];

        field {
            name = "dtr_byte1";
            desc = "Gating training data configuration of the DDRC.";
            reset = 0xD2;
        } dtr_byte1[15:8];

        field {
            name = "dtr_byte0";
            desc = "Gating training data configuration of the DDRC.";
            reset = 0x2D;
        } dtr_byte0[7:0];

    } DDRC_DTRDATA0 @ 0x00A4;
`endif

`ifdef DDRC_DTRDATA1_REG
    reg {
        name = "DDR Gating Training Data Configuration Register 1";

        field {
            name = "dtr_byte7";
            desc = "
            Gating training data configuration 1 of the DDRC.

            When the DDRC performs training, data must be transferred in DDR BL8 mode in each read or write operation.

            !!! NOTE
                The data configured for each byte (data for the upper four bits and lower four bits) must be different.
            ";
            reset = 0xC3;
        } dtr_byte7[31:24];

        field {
            name = "dtr_byte6";
            desc = "Gating training data configuration of the DDRC.";
            reset = 0x3C;
        } dtr_byte6[23:16];

        field {
            name = "dtr_byte5";
            desc = "Gating training data configuration of the DDRC.";
            reset = 0xB4;
        } dtr_byte5[15:8];

        field {
            name = "dtr_byte4";
            desc = "Gating training data configuration of the DDRC.";
            reset = 0x4B;
        } dtr_byte4[7:0];

    } DDRC_DTRDATA1 @ 0x00A8;
`endif

`ifdef DDRC_DTRCTRL_0xAC_REG
    reg {
        name = "DDRC Gating Training Control Register";

        enum dt_byte_enum {
            DISABLED = 0x0 { desc = "Disabled"; };
            ENABLED  = 0x1 { desc = "Enabled"; };
        };

        field {
            name = "dt_byte_7";
            desc = "Byte 7 training enable. The data sheets print one 8-bit field dt_byte[31:24] (bit n = byte n training enable); it is modelled as one bit per byte lane here.";
            encode = dt_byte_enum;
            reset = 0x0;
        } dt_byte_7[31:31];

        field {
            name = "dt_byte_6";
            desc = "Byte 6 training enable.";
            encode = dt_byte_enum;
            reset = 0x0;
        } dt_byte_6[30:30];

        field {
            name = "dt_byte_5";
            desc = "Byte 5 training enable.";
            encode = dt_byte_enum;
            reset = 0x0;
        } dt_byte_5[29:29];

        field {
            name = "dt_byte_4";
            desc = "Byte 4 training enable.";
            encode = dt_byte_enum;
            reset = 0x0;
        } dt_byte_4[28:28];

        field {
            name = "dt_byte_3";
            desc = "Byte 3 training enable.";
            encode = dt_byte_enum;
            reset = 0x0;
        } dt_byte_3[27:27];

        field {
            name = "dt_byte_2";
            desc = "Byte 2 training enable.";
            encode = dt_byte_enum;
            reset = 0x0;
        } dt_byte_2[26:26];

        field {
            name = "dt_byte_1";
            desc = "Byte 1 training enable.";
            encode = dt_byte_enum;
            reset = 0x0;
        } dt_byte_1[25:25];

        field {
            name = "dt_byte_0";
            desc = "Byte 0 training enable.";
            encode = dt_byte_enum;
            reset = 0x0;
        } dt_byte_0[24:24];

`ifdef DDRC_HI3516V100
        field {
            name = "ecc_byte";
            desc = "Reserved; not supported in this version (Hi3516 V100 original Chinese data sheet 4.1.5 DDRC_DTRCTRL, `hi3516v100--Hi3516-Datasheet.txt` line 22964; the Hi3516 V100 prints dt_byte as one 8-bit field, modelled per byte as on the Hi3518).";
            reset = 0x0;
        } ecc_byte[21:20];
`endif

`ifdef DDRC_TRAIN_START_POS_FIELD
        field {
            name = "train_start_pos";
            desc = "
                Start position of the gating training.

                * `0x0`-`0x5`: n clock cycles
                * Other values: reserved
            ";
            reset = 0x0;
        } train_start_pos[19:16];
`endif

`ifdef DDRC_TRAIN_RANK_FIELD
        field {
            name = "train_rank";
            desc = "
                Number of ranks in the gating training.

                * `0x0`–`0x3`: n + 1 ranks
            ";
        } train_rank[13:12];
`endif

`ifdef DDRC_RENSEL_FIELD
        field {
            name = "rensel";
            desc = "
                Read enable delay cycle.

                * `0b000`-`0b011`: n + 1 clock cycles
                * Other values: reserved
            ";
            reset = 0x2;
        } rensel[11:9];
`endif

`ifdef DDRC_TRAIN_MODE_FIELD
        enum DDRC_DTRCTRL_train_mode_enum {
            DOLPHIN_TRAINING = 0x0 { desc = "Dolphin training mode."; };
            NORMAL_TRAINING  = 0x1 { desc = "Normal training mode."; };
        };

        field {
            name = "train_mode";
            desc = "Gating training mode.";
            encode = DDRC_DTRCTRL_train_mode_enum;
            reset = 0x0;
        } train_mode[8:8];
`endif

`ifdef DDRC_DT_LIMIT_FIELD
        enum DDRC_dt_limit_enum {
            SHIFT_0   = 0x0 { desc = "Shift 0°."; };
            SHIFT_90  = 0x1 { desc = "Shift 90°."; };
            SHIFT_180 = 0x2 { desc = "Shift 180°."; };
            SHIFT_270 = 0x3 { desc = "Shift 270°."; };
        };

        field {
            name = "dt_limit";
            desc = "DQS gating shift control.";
            encode = DDRC_dt_limit_enum;
            reset = 0x0;
        } dt_limit[5:4];
`endif

        enum DDRC_DTRCTRL_track_en_enum {
            FORBIDDEN = 0x0 { desc = "Forbidden."; };
            ENABLE    = 0x1 { desc = "Enable."; };
        };

        field {
            name = "track_en";
            desc = "
                Gated position auto-update enabled.

                !!! NOTE
                    There must be a set of read operations between two train operations, and the continuous access length is greater than DDRBURST8.
            ";
            encode = DDRC_DTRCTRL_track_en_enum;
            reset = 0x0;
        } track_en[2:2];

        field {
            name = "train_en";
            desc = "Gated position training enabled.";
            encode = DDRC_enabled_enum;
            reset = 0x0;
        } train_en[1:1];

`ifdef DDRC_ITM_RST_FIELD
        enum DDRC_DTRCTRL_itm_rst_enum {
            VALID   = 0x0 { desc = "Valid"; };
            INVALID = 0x1 { desc = "Invalid"; };
        };

        field {
            name = "itm_rst";
            desc = "ITM reset signal of the PHY. 0: reset asserted; 1: reset released. Hi3516 V100: resets to 1 (original Chinese data sheet DDRC_DTRCTRL total reset 0x0000_0001).";
            encode = DDRC_DTRCTRL_itm_rst_enum;
`ifdef DDRC_HI3516V100
            reset = 0x1;
`endif
        } itm_rst[0:0];
`endif

`ifdef DDRC_DTRCTRL_BIT0_RESERVED_NZ
        field {
            name = "reserved_nz";
            desc = "Reserved in the data sheet (the bit table lists bit 0 as reserved, RO), but the data sheet total reset is 0x0000_0401, so the bit reads 1 after reset. Keep the reset value when writing the register.";
            reset = 0x1;
        } reserved_nz[0:0];
`endif

    } DDRC_DTRCTRL @ 0x00AC;
`endif

`ifdef DDRC_DTRPRD_0xB0_REG
    reg {
        name = "DDRC Gating Track Period Configuration Register";

        field {
            name = "track_prd";
            desc = "
                Auto-update period configuration of the DQS gating. The DDRC tracks the gating position in the configured period.

                * `0x0`: 1 AREF period
                * `0x1`-`0x7FF`: n + 1 AREF periods
            ";
            reset = 0x0;
        } track_prd[19:0];

    } DDRC_DTRPRD @ 0x00B0;
`endif

`ifdef DDRC_DTRGATE_0xB4_REG
    reg {
        name = "DDR Gating Phase Position Register";

        field {
            name = "gate_sel";
            desc = "
            Gating phase position of the DDRC.
            * `0x00`: 0°
            * `0x01`: 90°
            * `0x10`: 180°
            * `0x11`: 270°
            * `[2 x (N + 1) – 1:2 x N]`: gating phase of DDRC byteN. N = 0–7
            ";
        } gate_sel[15:0];

    } DDRC_DTRGATE @ 0x00B4;
`endif

`ifdef DDRC_DTRLAT_0xC4_REG
    reg {
        name = "DDR Gating Period Position Register";

        field {
            name = "sys_lat";
            desc = "
            Number of gating delay cycles of the DDRC.

            * `0x0`–`0x5`: n clock cycles
            * Other values: reserved
            * [4 x (N + 1) – 1:4 x N]: gating phase of DDRC ByteN. N = 0–7

            !!! NOTE
                This register cannot be read or written continuously.
            ";
        } sys_lat[31:0];

    } DDRC_DTRLAT @ 0x00C4;
`endif

`ifdef DDRC_DTRSTATUS_0xD4_REG
    reg {
        name = "DDR Gating Period Position Register";

        enum DDRC_DTRSTATUS_dtr_st_enum {
            SHIFT_0   = 0x0 { desc = "shift 0°."; };
            SHIFT_90  = 0x1 { desc = "shift 90°."; };
            SHIFT_180 = 0x2 { desc = "shift 180°."; };
            SHIFT_270 = 0x3 { desc = "shift 270°."; };
        };

        field {
            name = "dtr_st_byte_7";
            desc = "Phase shift status of the byte gating position for byte 7.";
            encode = DDRC_DTRSTATUS_dtr_st_enum;
            sw = r;
            hw = w;
            reset = 0x0;
        } dtr_st_byte_7[31:30];

        field {
            name = "dtr_st_byte_6";
            desc = "Phase shift status of the byte gating position for byte 6.";
            encode = DDRC_DTRSTATUS_dtr_st_enum;
            sw = r;
            hw = w;
            reset = 0x0;
        } dtr_st_byte_6[29:28];

        field {
            name = "dtr_st_byte_5";
            desc = "Phase shift status of the byte gating position for byte 5.";
            encode = DDRC_DTRSTATUS_dtr_st_enum;
            sw = r;
            hw = w;
            reset = 0x0;
        } dtr_st_byte_5[27:26];

        field {
            name = "dtr_st_byte_4";
            desc = "Phase shift status of the byte gating position for byte 4.";
            encode = DDRC_DTRSTATUS_dtr_st_enum;
            sw = r;
            hw = w;
            reset = 0x0;
        } dtr_st_byte_4[25:24];

        field {
            name = "dtr_st_byte_3";
            desc = "Phase shift status of the byte gating position for byte 3.";
            encode = DDRC_DTRSTATUS_dtr_st_enum;
            sw = r;
            hw = w;
            reset = 0x0;
        } dtr_st_byte_3[23:22];

        field {
            name = "dtr_st_byte_2";
            desc = "Phase shift status of the byte gating position for byte 2.";
            encode = DDRC_DTRSTATUS_dtr_st_enum;
            sw = r;
            hw = w;
            reset = 0x0;
        } dtr_st_byte_2[21:20];

        field {
            name = "dtr_st_byte_1";
            desc = "Phase shift status of the byte gating position for byte 1.";
            encode = DDRC_DTRSTATUS_dtr_st_enum;
            sw = r;
            hw = w;
            reset = 0x0;
        } dtr_st_byte_1[19:18];

        field {
            name = "dtr_st_byte_0";
            desc = "Phase shift status of the byte gating position for byte 0.";
            encode = DDRC_DTRSTATUS_dtr_st_enum;
            sw = r;
            hw = w;
            reset = 0x0;
        } dtr_st_byte_0[17:16];

        enum DDRC_DTRSTATUS_dtr_ok_enum {
            ERROR    = 0x0 { desc = "Training Error."; };
            NO_ERROR = 0x1 { desc = "No Training Error."; };
        };

        field {
            name = "dtr_ok_byte_7";
            desc = "Gating training status for byte 7.";
            encode = DDRC_DTRSTATUS_dtr_ok_enum;
            sw = r;
            hw = w;
            reset = 0x0;
        } dtr_ok_byte_7[15:15];

        field {
            name = "dtr_ok_byte_6";
            desc = "Gating training status for byte 6.";
            encode = DDRC_DTRSTATUS_dtr_ok_enum;
            sw = r;
            hw = w;
            reset = 0x0;
        } dtr_ok_byte_6[14:14];

        field {
            name = "dtr_ok_byte_5";
            desc = "Gating training status for byte 5.";
            encode = DDRC_DTRSTATUS_dtr_ok_enum;
            sw = r;
            hw = w;
            reset = 0x0;
        } dtr_ok_byte_5[13:13];

        field {
            name = "dtr_ok_byte_4";
            desc = "Gating training status for byte 4.";
            encode = DDRC_DTRSTATUS_dtr_ok_enum;
            sw = r;
            hw = w;
            reset = 0x0;
        } dtr_ok_byte_4[12:12];

        field {
            name = "dtr_ok_byte_3";
            desc = "Gating training status for byte 3.";
            encode = DDRC_DTRSTATUS_dtr_ok_enum;
            sw = r;
            hw = w;
            reset = 0x0;
        } dtr_ok_byte_3[11:11];

        field {
            name = "dtr_ok_byte_2";
            desc = "Gating training status for byte 2.";
            encode = DDRC_DTRSTATUS_dtr_ok_enum;
            sw = r;
            hw = w;
            reset = 0x0;
        } dtr_ok_byte_2[10:10];

        field {
            name = "dtr_ok_byte_1";
            desc = "Gating training status for byte 1.";
            encode = DDRC_DTRSTATUS_dtr_ok_enum;
            sw = r;
            hw = w;
            reset = 0x0;
        } dtr_ok_byte_1[9:9];

        field {
            name = "dtr_ok_byte_0";
            desc = "Gating training status for byte 0.";
            encode = DDRC_DTRSTATUS_dtr_ok_enum;
            sw = r;
            hw = w;
            reset = 0x0;
        } dtr_ok_byte_0[8:8];

        enum DDRC_DTRSTATUS_dtr_err_enum {
            ERROR    = 0x0 { desc = "Training Error."; };
            NO_ERROR = 0x1 { desc = "No Training Error."; };
        };

        field {
            name = "dtr_err_byte_7";
            desc = "Auto tracking error status of the gating position for byte 7.";
            encode = DDRC_DTRSTATUS_dtr_err_enum;
            sw = r;
            hw = w;
            reset = 0x0;
        } dtr_err_byte_7[7:7];

        field {
            name = "dtr_err_byte_6";
            desc = "Auto tracking error status of the gating position for byte 6.";
            encode = DDRC_DTRSTATUS_dtr_err_enum;
            sw = r;
            hw = w;
            reset = 0x0;
        } dtr_err_byte_6[6:6];

        field {
            name = "dtr_err_byte_5";
            desc = "Auto tracking error status of the gating position for byte 5.";
            encode = DDRC_DTRSTATUS_dtr_err_enum;
            sw = r;
            hw = w;
            reset = 0x0;
        } dtr_err_byte_5[5:5];

        field {
            name = "dtr_err_byte_4";
            desc = "Auto tracking error status of the gating position for byte 4.";
            encode = DDRC_DTRSTATUS_dtr_err_enum;
            sw = r;
            hw = w;
            reset = 0x0;
        } dtr_err_byte_4[4:4];

        field {
            name = "dtr_err_byte_3";
            desc = "Auto tracking error status of the gating position for byte 3.";
            encode = DDRC_DTRSTATUS_dtr_err_enum;
            sw = r;
            hw = w;
            reset = 0x0;
        } dtr_err_byte_3[3:3];

        field {
            name = "dtr_err_byte_2";
            desc = "Auto tracking error status of the gating position for byte 2.";
            encode = DDRC_DTRSTATUS_dtr_err_enum;
            sw = r;
            hw = w;
            reset = 0x0;
        } dtr_err_byte_2[2:2];

        field {
            name = "dtr_err_byte_1";
            desc = "Auto tracking error status of the gating position for byte 1.";
            encode = DDRC_DTRSTATUS_dtr_err_enum;
            sw = r;
            hw = w;
            reset = 0x0;
        } dtr_err_byte_1[1:1];

        field {
            name = "dtr_err_byte_0";
            desc = "Auto tracking error status of the gating position for byte 0.";
            encode = DDRC_DTRSTATUS_dtr_err_enum;
            sw = r;
            hw = w;
            reset = 0x0;
        } dtr_err_byte_0[0:0];

    } DDRC_DTRSTATUS @ 0x00D4;
`endif

`ifdef DDRT_AXISTATUS_0xF0_REG
    reg {
        name = "DDRC interface status register";

        enum DDRC_AXISTATUS_idle_enum {
            IDLE     = 0x0 { desc = "Idle."; };
            EXECUTED = 0x1 { desc = "A command is being executed."; };
        };

`ifndef DDRC_HI3516V100   // Hi3516 V100: four AXI ports, bits [31:4] reserved
        field {
            name = "axi_st7";
            desc = "Status of DDRC bus interface 7.";
            encode = DDRC_AXISTATUS_idle_enum;
            reset = 0x0;
            sw = r;
            hw = w;
        } axi_st7[7:7];

        field {
            name = "axi_st6";
            desc = "Status of DDRC bus interface 6.";
            encode = DDRC_AXISTATUS_idle_enum;
            reset = 0x0;
            sw = r;
            hw = w;
        } axi_st6[6:6];

        field {
            name = "axi_st5";
            desc = "Status of DDRC bus interface 5.";
            encode = DDRC_AXISTATUS_idle_enum;
            reset = 0x0;
            sw = r;
            hw = w;
        } axi_st5[5:5];

        field {
            name = "axi_st4";
            desc = "Status of DDRC bus interface 4.";
            encode = DDRC_AXISTATUS_idle_enum;
            reset = 0x0;
            sw = r;
            hw = w;
        } axi_st4[4:4];
`endif

        field {
            name = "axi_st3";
            desc = "Status of DDRC bus interface 3.";
            encode = DDRC_AXISTATUS_idle_enum;
            reset = 0x0;
            sw = r;
            hw = w;
        } axi_st3[3:3];

        field {
            name = "axi_st2";
            desc = "Status of DDRC bus interface 2.";
            encode = DDRC_AXISTATUS_idle_enum;
            reset = 0x0;
            sw = r;
            hw = w;
        } axi_st2[2:2];

        field {
            name = "axi_st1";
            desc = "Status of DDRC bus interface 1.";
            encode = DDRC_AXISTATUS_idle_enum;
            reset = 0x0;
            sw = r;
            hw = w;
        } axi_st1[1:1];

        field {
            name = "axi_st0";
            desc = "Status of DDRC bus interface 0.";
            encode = DDRC_AXISTATUS_idle_enum;
            reset = 0x0;
            sw = r;
            hw = w;
        } axi_st0[0:0];

    } DDRC_AXISTATUS @ 0x00F0;
`endif

`ifdef DDRT_ODTCFG_0xF4_REG
`ifdef DDRC_HI3516V100
    reg {
        name = "DDR ODT feature configuration register";
        desc = "Hi3516 V100 edition: one 4-bit ODT bitmap per rank for reads and for writes; only the rank 0 bitmaps are implemented (rodt1..3 / wodt1..3 are reserved, 'not supported in this version'). Original Chinese data sheet 4.1.5 DDRC_ODTCFG (`hi3516v100--Hi3516-Datasheet.txt` line 23273, total reset 0x0000_0000).";

        field {
            name = "rodt3";
            desc = "Reserved; not supported in this version.";
            reset = 0x0;
        } rodt3[31:28];

        field {
            name = "rodt2";
            desc = "Reserved; not supported in this version.";
            reset = 0x0;
        } rodt2[27:24];

        field {
            name = "rodt1";
            desc = "Reserved; not supported in this version.";
            reset = 0x0;
        } rodt1[23:20];

        field {
            name = "rodt0";
            desc = "Rank 0 read ODT configuration: which ranks drive ODT while rank 0 is read, one bit per rank (bit 16 = rank 0 ODT ... bit 19 = rank 3 ODT); 0: read ODT disabled; 1: read ODT enabled.";
            reset = 0x0;
        } rodt0[19:16];

        field {
            name = "wodt3";
            desc = "Reserved; not supported in this version.";
            reset = 0x0;
        } wodt3[15:12];

        field {
            name = "wodt2";
            desc = "Reserved; not supported in this version.";
            reset = 0x0;
        } wodt2[11:8];

        field {
            name = "wodt1";
            desc = "Reserved; not supported in this version.";
            reset = 0x0;
        } wodt1[7:4];

        field {
            name = "wodt0";
            desc = "Rank 0 write ODT configuration: which ranks drive ODT while rank 0 is written, one bit per rank (bit 0 = rank 0 ODT ... bit 3 = rank 3 ODT); 0: write ODT disabled; 1: write ODT enabled.";
            reset = 0x0;
        } wodt0[3:0];
    } DDRC_ODTCFG @ 0x00F4;
`else
    reg {
        name = "DDR ODT Feature Configuration Register";
        desc = "Hardware (Hi3520D V100 board, read on hardware 2026-11-08, stock U-Boot prompt after a cold boot): reads 0x00000001 (wodt0 = 1), reset here 0. Boot value: the vendor boot table writes 0x1 here, so it is not taken as the reset value.";

        enum DDRC_ODTCFG_rodt0_enum {
            DISABLE_READING = 0x0 { desc = "Disable reading ODT."; };
            ENABLE_READING  = 0x1 { desc = "Enable read ODT."; };
        };

        field {
            name = "rodt0";
            desc = "Rank0 reads ODT configuration.";
            encode = DDRC_ODTCFG_rodt0_enum;
            reset = 0x0;
        } rodt0[16:16];

        enum DDRC_ODTCFG_wodt0_enum {
            ENABLE_WRITING  = 0x1 { desc = "Enable writing ODT."; };
            DISABLE_WRITING = 0x0 { desc = "Disable writing ODT."; };
        };

        field {
            name = "wodt0";
            desc = "Rank0 write ODT configuration.";
            encode = DDRC_ODTCFG_wodt0_enum;
            reset = 0x0;
        } wodt0[0:0];

    } DDRC_ODTCFG @ 0x00F4;
`endif
`endif

`ifdef DDRC_QOSCFG0_0x100_REG
`ifdef DDRC_HI3516V100
    reg {
        name = "DDRC QoS algorithm configuration register 0";
        desc = "Hi3516 V100 edition (one FIFO level per AXI port). Original Chinese data sheet 4.1.5 DDRC_QOSCFG0 (`hi3516v100--Hi3516-Datasheet.txt` line 23331, total reset 0x0007_7777). Bits [31:30] and [27:20] are reserved (RW).";

        field {
            name = "id_order_ctl";
            desc = "Out-of-order execution enable of the specified ID. 1: the controller does not guarantee the order between the read/write commands of the specified ID and the commands of other IDs when a DDR row-address conflict occurs; the master must ensure data consistency.";
            encode = DDRC_enabled_enum;
            reset = 0x0;
        } id_order_ctl[29:29];

        field {
            name = "order_en";
            desc = "In-order execution enable for commands of the same priority.";
            encode = DDRC_enabled_enum;
            reset = 0x0;
        } order_en[28:28];

        field {
            name = "dmc_fifo_lvl";
            desc = "Depth of the command register FIFO in the DMC: 0x0-0x7 = n + 1 command depths; other values reserved.";
            reset = 0x7;
        } dmc_fifo_lvl[19:16];

        field {
            name = "axi3_fifo_lvl";
            desc = "Command-full watermark of AXI interface 3 (flow control of the interface commands): 0x0-0x7 = n + 1 command depths; other values reserved.";
            reset = 0x7;
        } axi3_fifo_lvl[15:12];

        field {
            name = "axi2_fifo_lvl";
            desc = "Command-full watermark of AXI interface 2: 0x0-0x7 = n + 1 command depths; other values reserved.";
            reset = 0x7;
        } axi2_fifo_lvl[11:8];

        field {
            name = "axi1_fifo_lvl";
            desc = "Command-full watermark of AXI interface 1: 0x0-0x7 = n + 1 command depths; other values reserved.";
            reset = 0x7;
        } axi1_fifo_lvl[7:4];

        field {
            name = "axi0_fifo_lvl";
            desc = "Command-full watermark of AXI interface 0: 0x0-0x7 = n + 1 command depths; other values reserved.";
            reset = 0x7;
        } axi0_fifo_lvl[3:0];
    } DDRC_QOSCFG0 @ 0x0100;
`else
    reg {
        name = "DDRC QoS algorithm configuration register 0";

        enum DDRC_QOSCFG0_idmap_mode_enum {
            ID_MAP_REGISTER = 0x0 { desc = "Use the id_map mapping mode configured by DDRC_QOSCFG1 (default)."; };
            QOS_MAPPING     = 0x1 { desc = "Use the QoS mapping mode. The AXI port configures this mode in associated mode by running read/write commands. Valid only when the corresponding macro is enabled in the RTL code."; };
        };

        field {
            name = "idmap_mode";
            desc = "
                ID mapping mode.

                !!! NOTE
                    The data sheet says this field must be 1, although its reset value is 0.
            ";
            encode = DDRC_QOSCFG0_idmap_mode_enum;
            reset = 0x0;
        } idmap_mode[6:6];

        field {
            name = "id_order_ctl";
            desc = "Out-of-order execution enable of the specified ID. When enabled, the DDRC does not guarantee the order when a DDR row address conflict occurs between the read/write commands of the specified ID and other IDs; the master must ensure data consistency.";
            encode = DDRC_enabled_enum;
            reset = 0x0;
        } id_order_ctl[5:5];

        field {
            name = "order_en";
            desc = "Execution order enable for commands with the same priority.";
            encode = DDRC_enabled_enum;
            reset = 0x0;
        } order_en[4:4];

        field {
            name = "dmc_fifo_lvl";
            desc = "
                Depth of the command register FIFO in the DMC.

                * `0x0`-`0xF`: n + 1 command depths

                !!! NOTE
                    The maximum depth of the command register FIFO in the Hi3520D is 0xB, but it is recommended to set 0x7.
            ";
            reset = 0xF;
        } dmc_fifo_lvl[3:0];
    } DDRC_QOSCFG0 @ 0x0100;
`endif
`endif

`ifdef DDRC_QOSCFG1_0x104_REG
    reg {
        name = "DDRC QoS algorithm configuration register 1";

`ifdef DDRC_HI3516V100
        enum DDRC_QOSCFG1_idmap_mode_enum {
            ID_MAP_REGISTER = 0x0 { desc = "Use the id_map mapping configured in this register (default)."; };
            QOS_MAPPING     = 0x1 { desc = "Use the QoS mapping configured in-band with the read/write commands on the AXI interface (valid only when the corresponding macro is enabled in the RTL code)."; };
        };

        field {
            name = "idmap_mode";
            desc = "ID mapping mode. Hi3516 V100 original Chinese data sheet 4.1.5 DDRC_QOSCFG1 (`hi3516v100--Hi3516-Datasheet.txt` line 23399, total reset 0x0000_3210; bits [31:17] reserved).";
            encode = DDRC_QOSCFG1_idmap_mode_enum;
            reset = 0x0;
        } idmap_mode[16:16];

        field {
            name = "id_map";
            desc = "
                Selects four bits of the bus ID for the QoS configuration lookup:

                * bit[15:12]: bus ID bit mapped to bit[3] of the QoS ID
                * bit[11:8]: bus ID bit mapped to bit[2]
                * bit[7:4]: bus ID bit mapped to bit[1]
                * bit[3:0]: bus ID bit mapped to bit[0]

                For example, 0x5320 uses ID[5], ID[3], ID[2] and ID[0] of the bus ID for the ID mapping and priority configuration. The DDRC inserts a 2-bit AXI port number into bits 9 and 8 of the original 13-bit ID (00: AXI port 1, 01: AXI port 2, 10: AXI port 3, 11: AXI port 4), so the mapped ID is 15 bits wide.
            ";
            reset = 0x3210;
        } id_map[15:0];
`endif
`ifdef DDRC_QOSCFG1_VAR1
        field {
            name = "id_map";
            desc = "
                Selects four bits of the bus ID for the QoS configuration lookup:

                * bit[15:12]: bus ID bit mapped to bit[3] of the QoS ID
                * bit[11:8]: bus ID bit mapped to bit[2]
                * bit[7:4]: bus ID bit mapped to bit[1]
                * bit[3:0]: bus ID bit mapped to bit[0]

                For example, 0x5320 uses ID[5], ID[3], ID[2] and ID[0] of the bus ID for the ID mapping and priority configuration. Bits [31:16] are reserved (RO).
                Hi3520 V100: the data sheet calls this register DDRC_QOS_CONFIG (original Chinese data sheet 4.1.7, `hi3520v100--Hi3520-Datasheet.txt` line 21242, total reset 0x0000_3210).
            ";
            reset = 0x3210;
        } id_map[15:0];
`endif
`ifdef DDRC_QOSCFG1_VAR2
        field {
            name = "id_map_rd";
            desc = "For the read command.
                QoS configured by selecting four bits of the bus read ID.

                * bit[15:12]: bus ID bit mapped to bit[3] of the QoS ID
                * bit[11:8]: bus ID bit mapped to bit[2]
                * bit[7:4]: bus ID bit mapped to bit[1]
                * bit[3:0]: bus ID bit mapped to bit[0]

                For example, 0x5320 uses ID[5], ID[3], ID[2] and ID[0] of the bus ID for ID mapping and priority configuration.
                The DDRC inserts three AXI port number bits (0b000 = port 0 ... 0b111 = port 7) between bits 9, 8 and 7 of the existing 13-bit ID, so the ID mapped by the DDRC is 16 bits wide.
            ";
            reset = 0x3210;
        } id_map_rd[31:16];

        field {
            name = "id_map_wr";
            desc = "For the write command.
                QoS configured by selecting four bits of the bus write ID.

                * bit[15:12]: bus ID bit mapped to bit[3] of the QoS ID
                * bit[11:8]: bus ID bit mapped to bit[2]
                * bit[7:4]: bus ID bit mapped to bit[1]
                * bit[3:0]: bus ID bit mapped to bit[0]

                For example, 0x5320 uses ID[5], ID[3], ID[2] and ID[0] of the bus ID for ID mapping and priority configuration.
                The DDRC inserts three AXI port number bits (0b000 = port 0 ... 0b111 = port 7) between bits 9, 8 and 7 of the existing 13-bit ID, so the ID mapped by the DDRC is 16 bits wide.

                !!! NOTE
                    The data sheet text of this field repeats the id_map_rd wording (\"read command\"); the write command is meant.
            ";
            reset = 0x3210;
        } id_map_wr[15:0];
`endif
    } DDRC_QOSCFG1 @ 0x0104;
`endif

`ifdef DDRC_RESET_G3
`ifndef DDRC_HI3511V100
    reg {
        name = "DDRC command priority configuration register";
        desc = "One register per QoS ID, n = 0..15 (0x108 + 0x4 x n). Original Chinese data sheet 4.1.7 DDRC_QOS (`hi3520v100--Hi3520-Datasheet.txt` line 21269, total reset 0x0000_0000; the register is missing from the summary table 4-6). Bits [31:17] (RO), [15:14] and 3 are reserved.";

        field {
            name = "qos_en";
            desc = "QoS signal enable.";
            encode = DDRC_enabled_enum;
            reset = 0x0;
        } qos_en[16:16];

        field {
            name = "qos";
            desc = "Channel aging time; the recommended range is 0x002-0x3FF.";
            reset = 0x0;
        } qos[13:4];

        enum DDRC_QOS_pri_enum {
            HIGHEST = 0x0 { desc = "Highest priority."; };
            HIGHER  = 0x1 { desc = "Higher priority."; };
            P2      = 0x2 { desc = "Priority 2."; };
            P3      = 0x3 { desc = "Priority 3."; };
            P4      = 0x4 { desc = "Priority 4."; };
            P5      = 0x5 { desc = "Priority 5."; };
            P6      = 0x6 { desc = "Priority 6."; };
            LOWEST  = 0x7 { desc = "Lowest priority."; };
        };

        field {
            name = "pri";
            desc = "Channel priority (000 highest ... 111 lowest).";
            encode = DDRC_QOS_pri_enum;
            reset = 0x0;
        } pri[2:0];

    } DDRC_QOS[16] @ 0x0108 += 0x4;
`endif
`endif

`ifdef DDRC_QOS_0x150_REG
    reg {
        name = "DDRC command priority configuration register";
        desc = "One register per AXI command ID group, id0s = 0..15 (0x150 + 0x4 x id0s). The DS bit diagram prints the fields with an rd_ prefix (rd_pri_apt ...); the bit table names are used here.";

        field {
            name = "pri_apt";
            desc = "
                Command priority adaptation configuration.

                * `0x0`: disabled
                * `0x1`-`0xF`: n x 16 clock cycles
            ";
            reset = 0x0;
        } pri_apt[27:24];

        field {
            name = "age_prd";
            desc = "
                Command aging cycle configuration.

                * `0x0`: disabled
                * `0x1`-`0xF`: n x 16 clock cycles
            ";
            reset = 0x0;
        } age_prd[23:20];

        field {
            name = "qos_en";
            desc = "Command QoS (timeout) enable.";
            encode = DDRC_enabled_enum;
            reset = 0x0;
        } qos_en[16:16];

        field {
            name = "qos";
            desc = "
                Command QoS (timeout) configuration.

                * `0x1`-`0x3FF`: n clock cycles
                * Other values: reserved

                The timeout actually used is an integral multiple of 16: the low four bits are ignored.
            ";
            reset = 0x0;
        } qos[13:4];

        enum DDRC_QOS_pri_enum {
            HIGHEST = 0x0 { desc = "Highest priority."; };
            HIGHER  = 0x1 { desc = "Higher priority."; };
            P2      = 0x2 { desc = "Priority 2."; };
            P3      = 0x3 { desc = "Priority 3."; };
            P4      = 0x4 { desc = "Priority 4."; };
            P5      = 0x5 { desc = "Priority 5."; };
            P6      = 0x6 { desc = "Priority 6."; };
            LOWEST  = 0x7 { desc = "Lowest priority."; };
        };

        field {
            name = "pri";
            desc = "Command priority configuration.";
            encode = DDRC_QOS_pri_enum;
            reset = 0x4;
        } pri[2:0];

    } DDRC_QOS[16] @ 0x0150 += 0x4;
`endif

`ifdef DDRC_HI3516V100
    // Hi3516 V100 edition: registers that exist only in this chip's DDRC (original Chinese data sheet
    // 4.1.5, Table 4-8, base 0x2011_0000, `hi3516v100--Hi3516-Datasheet.txt` lines 21770-24330).
    // The per-rank / per-channel / per-command-lane registers (rnks, chnls, cmdls = 0..0) are single
    // registers; the per-byte-lane (blanes = 0..3) and per-compensation-block (cmps = 0..1) ones are arrays.

    reg {
        name = "DDRC exclusive-operation data-consistency address configuration register";
        desc = "Reserved: used only when both ECC and exclusive access are present, which this version does not support (original Chinese data sheet 4.1.5 DDRC_EXADDRCFG, `hi3516v100--Hi3516-Datasheet.txt` line 22830, total reset 0x0000_0000).";

        field {
            name = "ex_addr_mask";
            desc = "Reserved; not supported in this version.";
            reset = 0x0;
        } ex_addr_mask[31:16];

        field {
            name = "ex_addr_base";
            desc = "Reserved; not supported in this version.";
            reset = 0x0;
        } ex_addr_base[15:0];
    } DDRC_EXADDRCFG @ 0x0090;

    reg {
        name = "DDRC ECC gate-training status register";
        desc = "All fields are reserved ('not supported in this version'). Original Chinese data sheet 4.1.5 DDRC_ECCDTST (`hi3516v100--Hi3516-Datasheet.txt` line 23200, total reset 0x0000_0000); bits [31:16] reserved.";

        field {
            name = "ecc_st";
            desc = "Reserved; not supported in this version.";
            sw = r;
            hw = w;
            reset = 0x0;
        } ecc_st[15:8];

        field {
            name = "ecc_err";
            desc = "Reserved; not supported in this version.";
            sw = r;
            hw = w;
            reset = 0x0;
        } ecc_err[7:4];

        field {
            name = "ecc_ok";
            desc = "Reserved; not supported in this version.";
            sw = r;
            hw = w;
            reset = 0x0;
        } ecc_ok[3:0];
    } DDRC_ECCDTST @ 0x00E8;

    enum DDRC_QOS_pri_enum_hi3516 {
        HIGHEST = 0x0 { desc = "Highest priority."; };
        LOWEST  = 0x7 { desc = "Lowest priority."; };
    };

    reg {
        name = "DDRC command priority configuration register";
        desc = "One register per QoS ID, n = 0..15 (0x110 + 0x4 x n). Original Chinese data sheet 4.1.5 DDRC_QOS (`hi3516v100--Hi3516-Datasheet.txt` line 23459, total reset 0x0000_0004); bits [31:28], [19:17], [15:14] and 3 are reserved.";

        field {
            name = "pri_apt";
            desc = "Command priority adaptation: 0x0: priority adaptation disabled; 0x1-0xF: N x 16 clock cycles.";
            reset = 0x0;
        } pri_apt[27:24];

        field {
            name = "age_prd";
            desc = "Command aging time: 0x0: aging disabled; 0x1-0xF: N x 16 clock cycles.";
            reset = 0x0;
        } age_prd[23:20];

        field {
            name = "qos_en";
            desc = "QoS enable.";
            encode = DDRC_enabled_enum;
            reset = 0x0;
        } qos_en[16:16];

        field {
            name = "qos";
            desc = "Command QoS: 0x1-0x3FF: n clock cycles; other values reserved.";
            reset = 0x0;
        } qos[13:4];

        field {
            name = "pri";
            desc = "Channel priority: 000 highest, 001 second highest ... 111 lowest. Resets to 100.";
            encode = DDRC_QOS_pri_enum_hi3516;
            reset = 0x4;
        } pri[2:0];
    } DDRC_QOS[16] @ 0x0110 += 0x4;

    reg {
        name = "DDR PHY configuration register";
        desc = "Original Chinese data sheet 4.1.5 DDRC_PHYCFG (0x200 + 0x4 x chnls, chnls = 0 only; `hi3516v100--Hi3516-Datasheet.txt` line 23525, total reset 0x0000_0000); bits [31:8] reserved.";

        field {
            name = "ref_e";
            desc = "DDR PHY IO reference configuration: 0: external input control; 1: internal resistor control.";
            reset = 0x0;
        } ref_e[7:7];

        field {
            name = "rensel";
            desc = "Read-enable delay: 000-011: n + 1 clock cycles; other values reserved.";
            reset = 0x0;
        } rensel[6:4];

        field {
            name = "comp";
            desc = "DDR PHY gate select: 0: gate value output by the DDRC; 1: the DDR PHY's own gate value.";
            reset = 0x0;
        } comp[3:3];

        field {
            name = "comp_en";
            desc = "DDR PHY gate training enable.";
            encode = DDRC_enabled_enum;
            reset = 0x0;
        } comp_en[2:2];

        field {
            name = "bl";
            desc = "DDR PHY burst configuration: 0: BL4; 1: BL8.";
            reset = 0x0;
        } bl[1:1];

        field {
            name = "bl_en";
            desc = "DDR PHY burst configuration enable: 0: disabled, a variable burst length is used; 1: enabled.";
            reset = 0x0;
        } bl_en[0:0];
    } DDRC_PHYCFG @ 0x0200;

    reg {
        name = "DDR PHY gate phase position register";
        desc = "Original Chinese data sheet 4.1.5 DDRC_PHYNEG (0x208 + 0x4 x rnks, rnks = 0 only; `hi3516v100--Hi3516-Datasheet.txt` line 23586, total reset 0x0000_0000); bits [31:18] reserved.";

        field {
            name = "ecc_negmod";
            desc = "Reserved; not supported in this version.";
            reset = 0x0;
        } ecc_negmod[17:16];

        field {
            name = "neg_mod";
            desc = "DDR PHY gate phase select (Dolphin mode), two bits per data lane N in bits [2N+1:2N], N = 0..3 (the data sheet prints the field as 16 bits wide): 00: 0 degree phase shift; 01: 90 degrees; 10: 180 degrees; 11: 270 degrees.";
            reset = 0x0;
        } neg_mod[15:0];
    } DDRC_PHYNEG @ 0x0208;

    reg {
        name = "DDR PHY gate cycle position register";
        desc = "Original Chinese data sheet 4.1.5 DDRC_PHYSEL (0x218 + 0x4 x rnks, rnks = 0 only; `hi3516v100--Hi3516-Datasheet.txt` line 23635, total reset 0x0000_0000); bits [31:18] reserved.";

        field {
            name = "ecc_selmod";
            desc = "Reserved; not supported in this version.";
            reset = 0x0;
        } ecc_selmod[17:16];

        field {
            name = "sel_mod";
            desc = "DDR PHY gate delay select (Dolphin mode), two bits per data lane N in bits [2N+1:2N], N = 0..3: 00-11: n clock cycles.";
            reset = 0x0;
        } sel_mod[15:0];
    } DDRC_PHYSEL @ 0x0218;

    reg {
        name = "DDR PHY command-lane DLL configuration register";
        desc = "Original Chinese data sheet 4.1.5 DDRC_CDLLCFG (0x228 + 0x4 x cmdls, cmdls = 0 only; `hi3516v100--Hi3516-Datasheet.txt` line 23681, total reset 0x0000_0057); bits [31:30], [27:25], 19 and [15:11] reserved.";

        field {
            name = "unfl";
            desc = "DLL underflow status: 0: no underflow; 1: underflow.";
            sw = r;
            hw = w;
            reset = 0x0;
        } unfl[29:29];

        field {
            name = "ovfl";
            desc = "DLL overflow status: 0: no overflow; 1: overflow.";
            sw = r;
            hw = w;
            reset = 0x0;
        } ovfl[28:28];

        field {
            name = "bypctl";
            desc = "DLL ctlout value while the DLL is bypassed.";
            reset = 0x0;
        } bypctl[24:20];

        field {
            name = "bypfc";
            desc = "DLL fcout value while the DLL is bypassed.";
            reset = 0x0;
        } bypfc[18:16];

        field {
            name = "limit";
            desc = "DLL lock bandwidth.";
            reset = 0x5;
        } limit[10:4];

        field {
            name = "byp";
            desc = "DLL bypass enable.";
            encode = DDRC_enabled_enum;
            reset = 0x0;
        } byp[3:3];

        field {
            name = "dll_updt_en";
            desc = "DLL update enable.";
            encode = DDRC_enabled_enum;
            reset = 0x1;
        } dll_updt_en[2:2];

        field {
            name = "dll_en";
            desc = "DLL enable.";
            encode = DDRC_enabled_enum;
            reset = 0x1;
        } dll_en[1:1];

        field {
            name = "dll_reset";
            desc = "DLL reset: 0: reset asserted; 1: reset released.";
            reset = 0x1;
        } dll_reset[0:0];
    } DDRC_CDLLCFG @ 0x0228;

    reg {
        name = "DDR PHY data-lane DLL configuration register";
        desc = "One register per byte lane, n = 0..3 (0x230 + 0x4 x n). Same layout as DDRC_CDLLCFG. Original Chinese data sheet 4.1.5 DDRC_QDLLCFG (`hi3516v100--Hi3516-Datasheet.txt` line 23756, total reset 0x0000_0057); bits [31:30], [27:25], 19 and [15:11] reserved.";

        field {
            name = "unfl_mod";
            desc = "DLL underflow status: 0: no underflow; 1: underflow.";
            sw = r;
            hw = w;
            reset = 0x0;
        } unfl_mod[29:29];

        field {
            name = "ovfl_mod";
            desc = "DLL overflow status: 0: no overflow; 1: overflow.";
            sw = r;
            hw = w;
            reset = 0x0;
        } ovfl_mod[28:28];

        field {
            name = "bypctl_mod";
            desc = "DLL ctlout value while the DLL is bypassed.";
            reset = 0x0;
        } bypctl_mod[24:20];

        field {
            name = "bypfc_mod";
            desc = "DLL fcout value while the DLL is bypassed.";
            reset = 0x0;
        } bypfc_mod[18:16];

        field {
            name = "limit_mod";
            desc = "DLL lock bandwidth.";
            reset = 0x5;
        } limit_mod[10:4];

        field {
            name = "byp_mod";
            desc = "DLL bypass enable.";
            encode = DDRC_enabled_enum;
            reset = 0x0;
        } byp_mod[3:3];

        field {
            name = "dll_updt_en_mod";
            desc = "DLL update enable.";
            encode = DDRC_enabled_enum;
            reset = 0x1;
        } dll_updt_en_mod[2:2];

        field {
            name = "dll_en_mod";
            desc = "DLL enable.";
            encode = DDRC_enabled_enum;
            reset = 0x1;
        } dll_en_mod[1:1];

        field {
            name = "dll_reset_mod";
            desc = "DLL reset: 0: reset asserted; 1: reset released.";
            reset = 0x1;
        } dll_reset_mod[0:0];
    } DDRC_QDLLCFG[4] @ 0x0230 += 0x4;

    reg {
        name = "DDR PHY data-line phase fine-tune control register";
        desc = "Original Chinese data sheet 4.1.5 DDRC_LVLSKEW (`hi3516v100--Hi3516-Datasheet.txt` line 23830, total reset 0x0000_0000); bits [31:10] reserved.";

        field {
            name = "dqs_skew";
            desc = "Data-line fine-tune enable, one bit per byte: bit N = byte N (N = 0..9). 0: disabled; 1: enabled.";
            reset = 0x0;
        } dqs_skew[9:0];
    } DDRC_LVLSKEW @ 0x0260;

    reg {
        name = "DDR PHY write-leveling control register";
        desc = "Original Chinese data sheet 4.1.5 DDRC_LVLCTRL (`hi3516v100--Hi3516-Datasheet.txt` line 23864, total reset 0x0000_0000); bits [31:10] reserved.";

        field {
            name = "wrlvl_allow";
            desc = "Write-leveling operation start, one bit per byte: bit N = byte N (N = 0..9). 0: disabled; 1: enabled.";
            reset = 0x0;
        } wrlvl_allow[9:0];
    } DDRC_LVLCTRL @ 0x0264;

    reg {
        name = "DDR PHY write-leveling DQS control register";
        desc = "Original Chinese data sheet 4.1.5 DDRC_LVLSTR (`hi3516v100--Hi3516-Datasheet.txt` line 23889, total reset 0x0000_0000); bits [31:10] reserved.";

        field {
            name = "wrlvl_strobe";
            desc = "Write-leveling single-cycle strobe, one bit per byte: bit N = byte N (N = 0..9). 0: idle; writing 1 issues one strobe.";
            reset = 0x0;
        } wrlvl_strobe[9:0];
    } DDRC_LVLSTR @ 0x0268;

    reg {
        name = "DDR PHY write-leveling ODT control register";
        desc = "Original Chinese data sheet 4.1.5 DDRC_LVLODT (`hi3516v100--Hi3516-Datasheet.txt` line 23923, total reset 0x0000_0000); bits [31:4] reserved.";

        field {
            name = "wrlvl_odt";
            desc = "ODT control in write-leveling mode, one bit per rank: bit N = rank N (N = 0..3). 0: disabled; 1: enabled.";
            reset = 0x0;
        } wrlvl_odt[3:0];
    } DDRC_LVLODT @ 0x026C;

    reg {
        name = "DDR PHY write-leveling configuration register";
        desc = "One register per byte lane, n = 0..3 (0x270 + 0x4 x n). Accessible only while DDRC_CONFIG1[wrlvl_en] is 0. Original Chinese data sheet 4.1.5 DDRC_LVLCTL (`hi3516v100--Hi3516-Datasheet.txt` line 23950, total reset 0x0000_0000).";

        field {
            name = "clkinv";
            desc = "Leveling phase select: 0: phase 0; 1: 180 degree phase.";
            reset = 0x0;
        } clkinv[31:31];

        field {
            name = "lvlctl_mod";
            desc = "DQS coarse delay in write-leveling mode, thermometer coded: 0x0000_0000: 0 delay units; 0x0000_0001: 1; 0x0000_0003: 2; 0x0000_0007: 3; ... 0x7FFF_FFFF: 31 delay units.";
            reset = 0x0;
        } lvlctl_mod[30:0];
    } DDRC_LVLCTL[4] @ 0x0270 += 0x4;

    reg {
        name = "DDR PHY write-leveling response register";
        desc = "Original Chinese data sheet 4.1.5 DDRC_LVLRSP (`hi3516v100--Hi3516-Datasheet.txt` line 23994, total reset 0x0000_0000); bits [31:10] reserved.";

        field {
            name = "lvlrsp_mod";
            desc = "Write-leveling response, one bit per byte: bit N = byte N (N = 0..9). 0: error; 1: OK.";
            sw = r;
            hw = w;
            reset = 0x0;
        } lvlrsp_mod[9:0];
    } DDRC_LVLRSP @ 0x02D0;

    reg {
        name = "DDR PHY write-leveling status register";
        desc = "Original Chinese data sheet 4.1.5 DDRC_LVLST (`hi3516v100--Hi3516-Datasheet.txt` line 24028, total reset 0x0000_0000); bits [31:10] reserved.";

        field {
            name = "lvl_ok";
            desc = "Write-leveling status after initialisation, one bit per byte: bit N = byte N (N = 0..9). 0: failed; 1: succeeded.";
            sw = r;
            hw = w;
            reset = 0x0;
        } lvl_ok[9:0];
    } DDRC_LVLST @ 0x02D4;

    reg {
        name = "DDR PHY write DQS fine-tune register";
        desc = "Original Chinese data sheet 4.1.5 DDRC_WRDQS_SKEW (`hi3516v100--Hi3516-Datasheet.txt` line 24053, total reset 0x0000_0000; the summary table truncates the name to DDRC_WRDQS_SKE); bits [31:30] reserved.";

        field {
            name = "wrdqs_skew";
            desc = "Write DQS delay fine-tune, three bits per byte lane N in bits [3N+2:3N], N = 0..9: 0x0-0x7 delay units.";
            reset = 0x0;
        } wrdqs_skew[29:0];
    } DDRC_WRDQS_SKEW @ 0x02F0;

    reg {
        name = "DDR PHY read DQS fine-tune register";
        desc = "Original Chinese data sheet 4.1.5 DDRC_RDDQS_SKEW (`hi3516v100--Hi3516-Datasheet.txt` line 24093, total reset 0x0000_0000; the summary table truncates the name to DDRC_RDDQS_SKE); bits [31:30] reserved.";

        field {
            name = "rddqs_skew";
            desc = "Read DQS delay fine-tune, three bits per byte lane N in bits [3N+2:3N], N = 0..9: 0x0-0x7 delay units.";
            reset = 0x0;
        } rddqs_skew[29:0];
    } DDRC_RDDQS_SKEW @ 0x02F4;

    reg {
        name = "DDR PHY IO configuration register";
        desc = "Original Chinese data sheet 4.1.5 DDRC_IOCFG (0x360 + 0x4 x cmdls, cmdls = 0 only; `hi3516v100--Hi3516-Datasheet.txt` line 24126, total reset 0x0000_0007); bits [31:12] and 3 reserved.";

        field {
            name = "lpddr_en";
            desc = "Single-ended read DQS receive mode: 0: disabled, differential DQS; 1: enabled, single-ended DQS.";
            reset = 0x0;
        } lpddr_en[11:11];

        field {
            name = "odis_clk";
            desc = "Output clock disable, one bit per clock pair: bit n = DDR_CLKP/N[n], n = 0..2. 0: the output clock is enabled; 1: disabled. DDR_CLKP2 / DDR_CLKN2 are unused in this version: set odis_clk[2] = 1.";
            reset = 0x0;
        } odis_clk[10:8];

        field {
            name = "fena_rcv";
            desc = "Force receive enable.";
            encode = DDRC_enabled_enum;
            reset = 0x0;
        } fena_rcv[7:7];

        field {
            name = "ddr3";
            desc = "Mode select: 0: DDR2 mode; 1: DDR3 mode.";
            reset = 0x0;
        } ddr3[6:6];

        field {
            name = "rtt";
            desc = "Termination resistance (ren75, ren150): 00: disabled; 01: external resistor value / 2; 1x: external resistor value / 4.";
            reset = 0x0;
        } rtt[5:4];

        field {
            name = "sl";
            desc = "Signal slew-rate control: 111: fastest ... 000: slowest.";
            reset = 0x7;
        } sl[2:0];
    } DDRC_IOCFG @ 0x0360;

    reg {
        name = "DDR PHY IO compensation configuration register";
        desc = "One register per compensation block, n = 0..1 (0x370 + 0x4 x n). Original Chinese data sheet 4.1.5 DDRC_IOCMP (`hi3516v100--Hi3516-Datasheet.txt` line 24207, total reset 0x0000_0005); bits [31:17] reserved.";

        field {
            name = "rtt_byp_en";
            desc = "Termination-resistor compensation circuit bypass enable.";
            encode = DDRC_enabled_enum;
            reset = 0x0;
        } rtt_byp_en[16:16];

        field {
            name = "rtt_byp";
            desc = "Termination resistance value in bypass mode.";
            reset = 0x0;
        } rtt_byp[15:12];

        field {
            name = "drv_byp_n";
            desc = "Pull-down drive resistance value in bypass mode.";
            reset = 0x0;
        } drv_byp_n[11:8];

        field {
            name = "drv_byp_p";
            desc = "Pull-up drive resistance value in bypass mode.";
            reset = 0x0;
        } drv_byp_p[7:4];

        field {
            name = "drv_byp_en";
            desc = "Drive compensation bypass enable.";
            encode = DDRC_enabled_enum;
            reset = 0x0;
        } drv_byp_en[3:3];

        field {
            name = "update_en";
            desc = "Compensation update enable.";
            encode = DDRC_enabled_enum;
            reset = 0x1;
        } update_en[2:2];

        field {
            name = "mvg_en";
            desc = "Averaging enable.";
            encode = DDRC_enabled_enum;
            reset = 0x0;
        } mvg_en[1:1];

        field {
            name = "comp_e";
            desc = "Driver and receiver compensation enable.";
            encode = DDRC_enabled_enum;
            reset = 0x1;
        } comp_e[0:0];
    } DDRC_IOCMP[2] @ 0x0370 += 0x4;

    reg {
        name = "DDR PHY IO compensation status register 0";
        desc = "One register per compensation block, n = 0..1 (0x380 + 0x4 x n). Original Chinese data sheet 4.1.5 DDRC_CMPSTATUS0 (`hi3516v100--Hi3516-Datasheet.txt` line 24271, total reset 0x0001_0001). The data sheet labels pctl_core 'pull-down' and nctl_core 'pull-up' (as printed).";

        field {
            name = "pctl_core";
            desc = "Pull-down compensation resistance status.";
            sw = r;
            hw = w;
            reset = 0x1;
        } pctl_core[31:16];

        field {
            name = "nctl_core";
            desc = "Pull-up compensation resistance status.";
            sw = r;
            hw = w;
            reset = 0x1;
        } nctl_core[15:0];
    } DDRC_CMPSTATUS0[2] @ 0x0380 += 0x4;

    reg {
        name = "DDR PHY IO compensation status register 1";
        desc = "Original Chinese data sheet 4.1.5 DDRC_CMPSTATUS1 (`hi3516v100--Hi3516-Datasheet.txt` line 24293, total reset 0x0000_0000); bits [31:14] reserved.";

        field {
            name = "ctl_core";
            desc = "RTT (termination) compensation resistance status.";
            sw = r;
            hw = w;
            reset = 0x0;
        } ctl_core[13:0];
    } DDRC_CMPSTATUS1 @ 0x0388;
`endif

`ifdef DDRC_HI3515V100
    // Hi3515 edition: registers that exist only in this chip's DDRC (data sheet 4.1.5, Table 4-5, base
    // 0x2011_0000, `hi3515v100--Hi3515-Datasheet.txt` lines 16421-18010): DQS gate-training status and
    // training address/data (0x4C-0x60), interface status (0x90), QoS control (0x100) and the PHY/DLL/IO
    // control registers (0x270-0x27C). The rest of the Hi3515 set is the Hi3520 V100 edition.

    enum DDRC_PHY_STATUS_phase_enum {
        SHIFT_0   = 0x0 { desc = "Shift 0 degrees."; };
        SHIFT_90  = 0x1 { desc = "Shift 90 degrees."; };
        SHIFT_180 = 0x2 { desc = "Shift 180 degrees."; };
        SHIFT_270 = 0x3 { desc = "Shift 270 degrees."; };
    };

    reg {
        name = "DDRC PHY status register";
        desc = "DQS gate-training status per byte. Data sheet 4.1.5 DDRC_PHY_STATUS (offset 0x4C, printed page 4-28, dump line 17435, total reset 0x0000_0000).";

        field {
            name = "dtr_status";
            desc = "Phase-shift status of the byte gating position, two bits per byte (bits [2n+17:2n+16] = byte n): 00: shift 0 degrees; 01: 90; 10: 180; 11: 270.";
            sw = r;
            hw = w;
            reset = 0x0;
        } dtr_status[31:16];

        field {
            name = "dtr_err";
            desc = "Auto-tracking error status of the gating position, one bit per byte: 0: no error occurred during tracking; 1: an error occurred during tracking.";
            sw = r;
            hw = w;
            reset = 0x0;
        } dtr_err[15:8];

        field {
            name = "dtr_ok";
            desc = "Gating training status, one bit per byte: 0: an error occurred during training; 1: no error occurred during training.";
            sw = r;
            hw = w;
            reset = 0x0;
        } dtr_ok[7:0];
    } DDRC_PHY_STATUS @ 0x004C;

    reg {
        name = "DDRC PHY training address register";
        desc = "DDR2 SDRAM address used for gate training. Data sheet 4.1.5 DDRC_PHY_ADDR (offset 0x50, printed page 4-29, dump line 17476, total reset 0x0000_0000).";

        field {
            name = "train_row";
            desc = "Gating training position: row address of the DDR2 SDRAM. When the row address is narrower than 16 bits the upper bits are stuffed with 0s.";
            reset = 0x0;
        } train_row[31:16];

        field {
            name = "train_bank";
            desc = "Gating training position: bank address of the DDR2 SDRAM. When the bank address is narrower than three bits the upper bits are stuffed with 0s.";
            reset = 0x0;
        } train_bank[15:13];

        field {
            name = "train_col";
            desc = "Gating training position: column address of the DDR2 SDRAM. When the column address is narrower than 13 bits the upper bits are stuffed with 0s.";
            reset = 0x0;
        } train_col[12:0];
    } DDRC_PHY_ADDR @ 0x0050;

    reg {
        name = "DDRC PHY training data register 0";
        desc = "Data sheet 4.1.5 DDRC_PHY_DATA0 (offset 0x54, printed page 4-29, dump line 17508, total reset 0xEE11_DD22).";

        field {
            name = "dt_data0";
            desc = "DQS gating training data 0.";
            reset = 0xEE11DD22;
        } dt_data0[31:0];
    } DDRC_PHY_DATA0 @ 0x0054;

    reg {
        name = "DDRC PHY training data register 1";
        desc = "Data sheet 4.1.5 DDRC_PHY_DATA1 (offset 0x58, printed page 4-30, dump line 17539, total reset 0xCC33_BB44).";

        field {
            name = "dt_data1";
            desc = "DQS gating training data 1.";
            reset = 0xCC33BB44;
        } dt_data1[31:0];
    } DDRC_PHY_DATA1 @ 0x0058;

    reg {
        name = "DDRC PHY training data register 2";
        desc = "Data sheet 4.1.5 DDRC_PHY_DATA2 (offset 0x5C, printed page 4-30, dump line 17558, total reset 0x44BB_33CC).";

        field {
            name = "dt_data2";
            desc = "DQS gating training data 2.";
            reset = 0x44BB33CC;
        } dt_data2[31:0];
    } DDRC_PHY_DATA2 @ 0x005C;

    reg {
        name = "DDRC PHY training data register 3";
        desc = "Data sheet 4.1.5 DDRC_PHY_DATA3 (offset 0x60, printed page 4-30, dump line 17577, total reset 0x22DD_11EE).";

        field {
            name = "dt_data3";
            desc = "DQS gating training data 3.";
            reset = 0x22DD11EE;
        } dt_data3[31:0];
    } DDRC_PHY_DATA3 @ 0x0060;

    reg {
        name = "DDRC interface status register";
        desc = "Data sheet 4.1.5 DDRC_IF_STATUS (offset 0x90, printed page 4-31, dump line 17604, total reset 0x0000_0000); bits [31:2] reserved.";

        field {
            name = "axistatus";
            desc = "Status of the DDRC bus interfaces, one bit per interface: 0: idle; 1: a command is being executed. For example 0x01 means there is data in the buffer of the ahb0 interface (data sheet wording).";
            sw = r;
            hw = w;
            reset = 0x0;
        } axistatus[1:0];
    } DDRC_IF_STATUS @ 0x0090;

    reg {
        name = "DDRC QoS control register";
        desc = "Data sheet 4.1.5 DDRC_QOS_CTRL (offset 0x100, printed page 4-32, dump line 17674, total reset 0x0000_0888); bits [31:27] and [16:12] reserved.";

        field {
            name = "adp_cnt";
            desc = "Priority adaptation cycle. Every adp_cnt cycles after a command in the DMC times out, the absolute priority of that command is raised by one level until it reaches the highest priority. 0x0: disabled; 0x1-0x3FF: enabled.";
            reset = 0x0;
        } adp_cnt[26:17];

        field {
            name = "dmc_fifo_lvl";
            desc = "Depth of the command register FIFO in the DMC: 0x0-0x1: depth of one command; 0x2-0x8: depth of n commands; other values reserved.";
            reset = 0x8;
        } dmc_fifo_lvl[11:8];

        field {
            name = "axi1_fifo_lvl";
            desc = "Command-full threshold of AXI interface 1 (flow control of the interface commands): 0x0-0x1: depth of one command; 0x2-0x8: depth of n commands; other values reserved.";
            reset = 0x8;
        } axi1_fifo_lvl[7:4];

        field {
            name = "axi0_fifo_lvl";
            desc = "Command-full threshold of AXI interface 0 (flow control of the interface commands): 0x0-0x1: depth of one command; 0x2-0x8: depth of n commands; other values reserved.";
            reset = 0x8;
        } axi0_fifo_lvl[3:0];
    } DDRC_QOS_CTRL @ 0x0100;

    enum DDRC_PHY_CONFIG_ioodt_enum {
        DISABLED = 0x0 { desc = "IO ODT disabled."; };
        OHM_75   = 0x1 { desc = "75 ohm."; };
        OHM_150  = 0x2 { desc = "150 ohm."; };
        RESERVED = 0x3 { desc = "Reserved."; };
    };

    reg {
        name = "DDRC PHY configuration register";
        desc = "Data sheet 4.1.5 DDRC_PHY_CONFIG (offset 0x270, printed page 4-34, dump line 17805, total reset 0x0000_0000); bits [31:4] reserved (RW).";

        field {
            name = "ioodt";
            desc = "ODT configuration of the DDR2 IO.";
            encode = DDRC_PHY_CONFIG_ioodt_enum;
            reset = 0x0;
        } ioodt[3:2];

        field {
            name = "ck1_dis";
            desc = "DDR CK1 low-power control: 0: do not disable the CK1 clock output; 1: disable the CK1 clock output.";
            reset = 0x0;
        } ck1_dis[1:1];

        field {
            name = "ck0_dis";
            desc = "DDR CK0 low-power control: 0: do not disable the CK0 clock output; 1: disable the CK0 clock output.";
            reset = 0x0;
        } ck0_dis[0:0];
    } DDRC_PHY_CONFIG @ 0x0270;

    reg {
        name = "DDRC DLL status register";
        desc = "Data sheet 4.1.5 DDRC_DLL_STATUS (offset 0x274, printed page 4-35, dump line 17850, total reset 0x0000_00F0); bits [31:12] and [3:2] reserved.";

        field {
            name = "dll_mdly_tap";
            desc = "Valid delay-unit level of the master DLL: the number of DLL delay units needed to delay one clock cycle.";
            sw = r;
            hw = w;
            reset = 0xF;
        } dll_mdly_tap[11:4];

        field {
            name = "overflow";
            desc = "DLL overflow indicator: the total delay of all delay units is less than one clock cycle. 0: no DLL overflow; 1: DLL overflow.";
            sw = r;
            hw = w;
            reset = 0x0;
        } overflow[1:1];

        field {
            name = "locked";
            desc = "DLL lock indicator: 0: unlocked; 1: locked.";
            sw = r;
            hw = w;
            reset = 0x0;
        } locked[0:0];
    } DDRC_DLL_STATUS @ 0x0274;

    reg {
        name = "DDRC DLL configuration register";
        desc = "Data sheet 4.1.5 DDRC_DLL_CONFIG (offset 0x278, printed page 4-35, dump line 17884, total reset 0x0000_0009); bits [31:16] and 7 reserved.";

        field {
            name = "dll_slave_sel";
            desc = "Delay level of the slave DLL (maximum 0x2D); valid when dll_mode is 1.";
            reset = 0x0;
        } dll_slave_sel[15:8];

        field {
            name = "dll_mode";
            desc = "Operating mode of the slave DLL: 0: the delay level of the slave DLL is controlled by the master DLL automatically; 1: the delay level of the slave DLL equals dll_slave_sel (the data sheet calls it DLL_SDLY_SEL).";
            reset = 0x0;
        } dll_mode[6:6];

        field {
            name = "cali_en";
            desc = "DLL re-calibration enable (for frequency switching).";
            encode = DDRC_enabled_enum;
            reset = 0x0;
        } cali_en[5:5];

        field {
            name = "stop";
            desc = "DLL stop-tracking control: 0: the DLL tracks dynamically; 1: the DLL stops tracking.";
            reset = 0x0;
        } stop[4:4];

        field {
            name = "tune";
            desc = "DLL delay tune: bit 3: 0: increase the DLL delay; 1: decrease the DLL delay; bits [2:0]: number of delay units (000: 0 ... 111: 7). Resets to 0x9 (decrease by one unit).";
            reset = 0x9;
        } tune[3:0];
    } DDRC_DLL_CONFIG @ 0x0278;

    enum DDRC_IO_CTRL_drv_enum {
        SSTL18_FULL = 0x0 { desc = "SSTL18 full strength."; };
        SSTL18_HALF = 0x1 { desc = "SSTL18 half strength."; };
    };

    reg {
        name = "DDRC IO control register";
        desc = "Data sheet 4.1.5 DDRC_IO_CTRL (offset 0x27C, printed page 4-36, dump line 17947, total reset 0x0001_0001); bits [31:18], [15:13], [11:10], [7:6] and [3:2] reserved.";

        field {
            name = "pwd_inout";
            desc = "Power-down control of the DDR IOs (DQ and DQS): 0: power down invalid; 1: power down valid.";
            reset = 0x0;
        } pwd_inout[17:17];

        field {
            name = "pwd_out";
            desc = "Power-down control of the DDR outputs (CK, CMD, ADDR and DM): 0: power down invalid; 1: power down valid.";
            reset = 0x1;
        } pwd_out[16:16];

        field {
            name = "lvcmos";
            desc = "IO level: 0: SSTL18, DDR2 mode; 1: 1.8 V mobile DDR mode. Must be 0 on the Hi3515 (mobile DDR is not supported).";
            reset = 0x0;
        } lvcmos[12:12];

        field {
            name = "drv_ck";
            desc = "Drive capability of the CK pins (S0, S1), DDR2 mode; values 2-3 reserved.";
            encode = DDRC_IO_CTRL_drv_enum;
            reset = 0x0;
        } drv_ck[9:8];

        field {
            name = "drv_cmd";
            desc = "Drive capability of the CMD and ADDR pins (S0, S1), DDR2 mode (lvcmos = 0); values 2-3 reserved.";
            encode = DDRC_IO_CTRL_drv_enum;
            reset = 0x0;
        } drv_cmd[5:4];

        field {
            name = "drv_data";
            desc = "Drive capability of the DQ, DM and DQS pins (S0, S1), DDR2 mode (lvcmos = 0); values 2-3 reserved.";
            encode = DDRC_IO_CTRL_drv_enum;
            reset = 0x1;
        } drv_data[1:0];
    } DDRC_IO_CTRL @ 0x027C;
`endif

`ifdef DDRC_HI3511V100
    // Hi3511 / Hi3512 edition: registers that exist only in this chip's DDRC (original Chinese data sheet
    // 4.1.5, Table 4-4, base 0x1015_0000, `hi3511v100--Hi3511-Datasheet.txt` lines 13984-14887).

    reg {
        name = "DDRC DLL status register";
        desc = "Original Chinese data sheet 4.1.5 DDRC_DLL_STATUS (offset 0x78, dump line 14740, total reset 0x0000_0000; the bit table prints both flags as RW, modelled read-only); bits [31:2] reserved.";

        field {
            name = "overflow";
            desc = "DLL overflow flag: 0: the DLL has not overflowed; 1: the DLL overflowed.";
            sw = r;
            hw = w;
            reset = 0x0;
        } overflow[1:1];

        field {
            name = "dll_locked";
            desc = "DLL lock flag: 0: not locked; 1: locked.";
            sw = r;
            hw = w;
            reset = 0x0;
        } dll_locked[0:0];
    } DDRC_DLL_STATUS @ 0x0078;

    reg {
        name = "DDRC DLL configuration register";
        desc = "Original Chinese data sheet 4.1.5 DDRC_DLL_CONFIG (offset 0x7C, dump line 14778, total reset 0x0000_0009); bits [31:6] reserved. The DDR frequency-switching sequence (DS 4.1.4) sets dll_cali_en = 1, waits, then clears it; the data sheet recommends the default tune value.";

        field {
            name = "dll_cali_en";
            desc = "Frequency-switching enable: re-calibrates the DLL after a frequency switch. 0: disabled; 1: enabled.";
            reset = 0x0;
        } dll_cali_en[5:5];

        field {
            name = "stop";
            desc = "DLL stop: 0: the DLL works; 1: the DLL is stopped.";
            reset = 0x0;
        } stop[4:4];

        field {
            name = "tune";
            desc = "DLL delay fine tune: bit 3: 0: add delay units; 1: remove delay units; bits [2:0]: number of delay units added or removed. The data sheet recommends the default (0x9).";
            reset = 0x9;
        } tune[3:0];
    } DDRC_DLL_CONFIG @ 0x007C;

    enum DDRC_CHN_QOS_pri_enum {
        HIGHEST = 0x0 { desc = "Highest priority."; };
        LOWEST  = 0x7 { desc = "Lowest priority."; };
    };

    reg {
        name = "DDRC channel QoS configuration register";
        desc = "One register per bus channel, n = 0..7 (0x98 + 0x4 x n, DS name DDRC_CHn_QOS, summary row 0x098-0x0B4). Original Chinese data sheet 4.1.5 (dump line 14846, total reset 0x0000_0000); bits [31:17], [15:14] and 3 reserved.";

        field {
            name = "qos_en";
            desc = "QoS enable: 0: QoS disabled; 1: QoS enabled.";
            encode = DDRC_enabled_enum;
            reset = 0x0;
        } qos_en[16:16];

        field {
            name = "qos";
            desc = "Channel aging time; the recommended range is 0x002-0x3FF.";
            reset = 0x0;
        } qos[13:4];

        field {
            name = "pri";
            desc = "Channel priority (the smaller the value the higher the priority): 000 highest, 001 second highest ... 111 lowest.";
            encode = DDRC_CHN_QOS_pri_enum;
            reset = 0x0;
        } pri[2:0];
    } DDRC_CHN_QOS[8] @ 0x0098 += 0x4;
`endif

`ifdef DDRC_FLUX_0x200_REG
    reg {
        name = "DDRC AXI port bandwidth flux control configuration register";
`ifdef DDRC_FLUX_6_PORTS
        desc = "One register per AXI port, ports = 0..5 (0x200 + 0x4 x ports; Hi3518 data sheet `ports(0-5)`).";
`else
        desc = "One register per AXI port, ports = 0..4 (0x200 + 0x4 x ports).";
`endif

        field {
            name = "flux_port_en";
            desc = "AXI port DDRC traffic count enable.";
            encode = DDRC_enabled_enum;
            reset = 0x0;
        } flux_port_en[21:21];

        field {
            name = "flux_ovfl";
            desc = "
                AXI port traffic overflow allow enable.

                When set, traffic of the AXI port may exceed its configured bandwidth limit when no request is raised by the other AXI ports; the bandwidth of the AXI port can then exceed the configured value.
            ";
            encode = DDRC_enabled_enum;
            reset = 0x0;
        } flux_ovfl[20:20];

        field {
            name = "flux_lvl";
            desc = "
                AXI port traffic overflow allow threshold.

                * `0x0`-`0xC`: DMC command-count threshold for allowing traffic overflow
                * Other values: reserved

                With flux_ovfl = 1, overflow of the AXI port is allowed when its traffic is above the configured flux and the number of commands pending in the DMC is below this threshold.
            ";
            reset = 0x0;
        } flux_lvl[16:12];

        field {
            name = "flux";
            desc = "
                Bandwidth configuration of the AXI port, `0x0`-`0x3FF`: ratio of the maximum DDR bandwidth available to this AXI port to the total bandwidth, with the total bandwidth being 1024.

                Value = (required bandwidth / total bandwidth) x 1024, e.g. 20 % -> 0xCD.
            ";
            reset = 0x0;
        } flux[9:0];

`ifdef DDRC_FLUX_6_PORTS
    } DDRC_FLUX[6] @ 0x0200 += 0x4;
`else
    } DDRC_FLUX[5] @ 0x0200 += 0x4;
`endif
`endif

`ifdef DDRC_DLL_CONTROL_0x240_REG
    reg {
        name = "DLL Control Register";
        desc = "Hi3520 V100 DDRC_DLL_CONTROL: DLL bypass enable, one bit per DLL (original Chinese data sheet 4.1.7, `hi3520v100--Hi3520-Datasheet.txt` line 21321, total reset 0x0000_0000; the summary table 4-6 at line 20582 lists the register at 0x200 while the register description header says 0x240: the description is followed here). Bits [31:6] are reserved (RO).";

        field {
            name = "dll_bypass_command";
            desc = "Command Channel DLL Bypass Enable";
            encode = DDRC_enabled_enum;
            reset = 0x0;
        } dll_bypass_command[5:5];

        field {
            name = "dll_bypass_ecc";
            desc = "ECC Data Channel DLL Bypass Enable";
            encode = DDRC_enabled_enum;
            reset = 0x0;
        } dll_bypass_ecc[4:4];

        field {
            name = "dll_bypass_data_byte_3";
            desc = "Data Byte 3 Channel DLL Bypass Enable";
            encode = DDRC_enabled_enum;
            reset = 0x0;
        } dll_bypass_data_byte_3[3:3];

        field {
            name = "dll_bypass_data_byte_2";
            desc = "Data Byte 2 Channel DLL Bypass Enable";
            encode = DDRC_enabled_enum;
            reset = 0x0;
        } dll_bypass_data_byte_2[2:2];

        field {
            name = "dll_bypass_data_byte_1";
            desc = "Data Byte 1 Channel DLL Bypass Enable";
            encode = DDRC_enabled_enum;
            reset = 0x0;
        } dll_bypass_data_byte_1[1:1];

        field {
            name = "dll_bypass_data_byte_0";
            desc = "Data Byte 0 Channel DLL Bypass Enable";
            encode = DDRC_enabled_enum;
            reset = 0x0;
        } dll_bypass_data_byte_0[0:0];

    } DDRC_DLL_CONTROL @ 0x0240;
`endif

`ifdef DDRC_TEST0_0x240_REG
    reg {
        name = "DDRC Test Status Register 0";

        field {
            name = "dmc_ct";
            desc = "DDRC Command Type.";
            sw = r;
            reset = 0x0;
            hw = w;
        } dmc_ct[31:16];

        field {
            name = "dmc_cv";
            desc = "Commands that are being process by the DDRC.";
            sw = r;
            reset = 0x0;
            hw = w;
        } dmc_cv[15:0];

    } DDRC_TEST0 @ 0x0240;
`endif

`ifdef DDRC_TEST1_0x244_REG
    reg {
        name = "DDRC Test Status Register 1";

        field {
            name = "dt_num";
            desc = "Cycle n select, data read from the training module (n = 0–23).";
            reset = 0x0;
        } dt_num[8:4];

        field {
            name = "byte_sel";
            desc = "
            Channel select of the returned data.

            * `0x0`-`0x7`: channel n select
            ";
            reset = 0x0;
        } byte_sel[2:0];

    } DDRC_TEST1 @ 0x0244;
`endif

`ifdef DDRC_DLL_SRST_0x244_REG
    reg {
        name = "DLL Soft Reset Register";

        enum DDRC_DLL_SRST_dll_srst_n_enum {
            RESET    = 0x0 { desc = "Reset"; };
            NO_RESET = 0x1 { desc = "No Reset"; };
        };

        field {
            name = "dll_srst_n";
            desc = "DLL Soft Reset";
            encode = DDRC_DLL_SRST_dll_srst_n_enum;
            reset = 0x1;
        } dll_srst_n[0:0];

    } DDRC_DLL_SRST @ 0x0244;
`endif

`ifdef DDRC_TEST2_0x248_REG
    reg {
        name = "DDRC Test Status Register 2";

        field {
            name = "data_h";
            desc = "Upper 32 bits of the training data.";
            sw = r;
            hw = w;
            reset = 0x0;
        } data_h[31:0];

    } DDRC_TEST2 @ 0x0248;
`endif

`ifdef DDRC_TEST3_0x24C_REG
    reg {
        name = "DDRC Test Status Register 3";

        field {
            name = "data_l";
            desc = "Lower 32 bits of the training data.";
            sw = r;
            hw = w;
            reset = 0x0;
        } data_l[31:0];

    } DDRC_TEST3 @ 0x024C;
`endif

`ifdef DDRC_TEST4_0x250_REG
    reg {
        name = "DDRC Test Status Register 4";

        field {
            name = "dt_ok_cnt";
            desc = "
            Number of times of correct training data.

            * `0x0`–`0xF`: n + 1
            * [3 x (N + 1) - 1:3 x N]: number of times of correct byteN
            ";
            sw = r;
            hw = w;
            reset = 0x0;
        } dt_ok_cnt[31:0];

    } DDRC_TEST4 @ 0x0250;
`endif

`ifdef DDRC_TEST7_0x260_REG
    reg {
        name = "DDRC Test Status Register 7";
        enum DDRC_TEST7_perf_mode_enum {
            CONTINUOUS = 0x0 { desc = "Continuous trigger mode: the performance counter counts continuously (no overflow within 1 s at 533 MHz); on overflow the count wraps."; };
            SINGLE     = 0x1 { desc = "Single trigger mode: when the counter reaches its maximum the count is retained and counting stops."; };
        };

        field {
            name = "perf_mode";
            desc = "Performance measurement mode.";
            encode = DDRC_TEST7_perf_mode_enum;
            reset = 0x0;
        } perf_mode[31:31];

        field {
            name = "perf_en";
            desc = "
                Performance measurement enable.

                !!! NOTE
                    With perf_mode = 0 and this bit set, the performance measurement registers count cyclically. With perf_mode = 1 this bit is cleared after one counting pass is complete.
            ";
            encode = DDRC_enabled_enum;
            reset = 0x0;
        } perf_en[30:30];

        enum DDRC_TEST7_perf_ch_enum {
            DISABLED  = 0x0 { desc = "Disabled."; };
            CHANNEL_0 = 0x1 { desc = "Channel 0."; };
            CHANNEL_1 = 0x2 { desc = "Channel 1."; };
            BOTH      = 0x3 { desc = "Channel 0 and channel 1."; };
        };

        field {
            name = "perf_ch";
            desc = "
                Read/write count channel. Limits the read/write command count channels of DDRC_TEST8 and DDRC_TEST9.
            ";
            encode = DDRC_TEST7_perf_ch_enum;
            reset = 0x0;
        } perf_ch[29:28];

        field {
            name = "perf_prd";
            desc = "
                Performance measurement cycle, `0x0`-`0xFFFFFFF`. The actual count period is perf_prd x 4 x tclk, where tclk is the DDRC bus clock cycle.

                !!! NOTE
                    Valid only when perf_mode is 1; with perf_mode 0 (continuous) the counters keep counting.
            ";
            reset = 0x0;
        } perf_prd[27:0];
    } DDRC_TEST7 @ 0x0260;
`endif

`ifdef DDRC_TEST8_0x264_REG
    reg {
        name = "DDRC Test Status Register 8";
        field {
            name = "wr_num";
            desc = "Count of write commands in the count period. Written to clear; supports wrap-around counting.";
            sw = rw;
            onwrite = wclr;
            hw = w;
            reset = 0x0;
        } wr_num[31:0];
    } DDRC_TEST8 @ 0x0264;
`endif

`ifdef DDRC_TEST9_0x268_REG
    reg {
        name = "DDRC Test Status Register 9";
        field {
            name = "rd_num";
            desc = "Count of read commands in the count period. Written to clear; supports wrap-around counting.";
            sw = rw;
            onwrite = wclr;
            hw = w;
            reset = 0x0;
        } rd_num[31:0];
    } DDRC_TEST9 @ 0x0268;
`endif

`ifdef DDRC_IO_CONFIG_0x268_REG
    reg {
        name = "IO Configuration Register";

        field {
            name = "ae";
            desc = "
            Analog IO Output Enable

            !!! NOTE
                Output for testing the DLL
            ";
            encode = DDRC_enabled_enum;
            reset = 0x0;
        } ae[13:13];

        enum DDRC_IO_CONFIG_ddr_mode_enum {
            DDR2 = 0x0 { desc = "DDR2 mode"; };
            DDR1 = 0x1 { desc = "DDR (DDR1) mode"; };
        };

        field {
            name = "ddr_mode";
            desc = "Controls the output driving mode of the IO (original Chinese data sheet DDRC_IO_CONFIG, `hi3520v100--Hi3520-Datasheet.txt` line 21388, total reset 0x0000_0000; bits [31:14] reserved).";
            encode = DDRC_IO_CONFIG_ddr_mode_enum;
            reset = 0x0;
        } ddr_mode[12:12];

        field {
            name = "ck_ds";
            desc = "
            Controls the driving mode of the clock IO

            In DDR2 Mode:

            * `0x0`: `SSTL_18` Half Driver
            * `0x1`: `SSTL_18` Full Driver

            In DDR SDRAM Mode:

            * `0x0`: `SSTL_2` class1
            * `0x1`: `SSTL_2` class2
            ";
            reset = 0x0;
        } ck_ds[11:11];

        field {
            name = "cmd_ds";
            desc = "
            Controls the driving mode of the command and address IO

            In DDR2 Mode:

            * `0x0`: `SSTL_18` Half Driver
            * `0x1`: `SSTL_18` Full Driver

            In DDR SDRAM Mode:

            * `0x0`: `SSTL_2` class1
            * `0x1`: `SSTL_2` class2
            ";
            reset = 0x0;
        } cmd_ds[10:10];

        field {
            name = "dqs_ds";
            desc = "
            Controls the driving mode of the DQ/DM IO (so named in the data sheet; the field names dqs_ds / dq_ds appear swapped against their descriptions)

            In DDR2 Mode:

            * `0x0`: `SSTL_18` Half Driver
            * `0x1`: `SSTL_18` Full Driver

            In DDR SDRAM Mode:

            * `0x0`: `SSTL_2` class1
            * `0x1`: `SSTL_2` class2
            ";
            reset = 0x0;
        } dqs_ds[9:9];

        field {
            name = "dq_ds";
            desc = "
            Controls the driving mode of the DQS IO

            In DDR2 Mode:

            * `0x0`: `SSTL_18` Half Driver
            * `0x1`: `SSTL_18` Full Driver

            In DDR SDRAM Mode:

            * `0x0`: `SSTL_2` class1
            * `0x1`: `SSTL_2` class2
            ";
            reset = 0x0;
        } dq_ds[8:8];

        enum DDRC_IO_CONFIG_rtt_enum {
            DISABLED = 0x0 { desc = "ODT disabled"; };
            OHM_150  = 0x1 { desc = "150 ohm"; };
            OHM_75   = 0x2 { desc = "75 ohm"; };
            OHM_50   = 0x3 { desc = "50 ohm"; };
        };

        field {
            name = "rtt";
            desc = "IO ODT resistance control";
            encode = DDRC_IO_CONFIG_rtt_enum;
            reset = 0x0;
        } rtt[7:6];

        enum DDRC_IO_CONFIG_circuit_en_enum {
            ENABLE  = 0x0 { desc = "SSTL Input Circuit Enable"; };
            DISABLE = 0x1 { desc = "SSTL Input Circuit Disable; LVCMOS input mode is enabled; ODT is automatically disabled"; };
        };

        field {
            name = "sstl_cmd_en";
            desc = "IDDQ control of command IO";
            encode = DDRC_IO_CONFIG_circuit_en_enum;
            reset = 0x0;
        } sstl_cmd_en[5:5];

        field {
            name = "sstl_ecc_en";
            desc = "IDDQ control of data IO";
            encode = DDRC_IO_CONFIG_circuit_en_enum;
            reset = 0x0;
        } sstl_ecc_en[4:4];

        field {
            name = "sstl_byte3_en";
            desc = "IDDQ control of data IO";
            encode = DDRC_IO_CONFIG_circuit_en_enum;
            reset = 0x0;
        } sstl_byte3_en[3:3];

        field {
            name = "sstl_byte2_en";
            desc = "IDDQ control of data IO";
            encode = DDRC_IO_CONFIG_circuit_en_enum;
            reset = 0x0;
        } sstl_byte2_en[2:2];

        field {
            name = "sstl_byte1_en";
            desc = "IDDQ control of data IO";
            encode = DDRC_IO_CONFIG_circuit_en_enum;
            reset = 0x0;
        } sstl_byte1_en[1:1];

        field {
            name = "sstl_byte0_en";
            desc = "IDDQ control of data IO";
            encode = DDRC_IO_CONFIG_circuit_en_enum;
            reset = 0x0;
        } sstl_byte0_en[0:0];

    } DDRC_IO_CONFIG @ 0x0268;
`endif

`ifdef DDRC_TEST10_0x26C_REG
    reg {
        name = "DDRC Test Status Register 10";
        field {
            name = "dmc_cmd_num";
            desc = "Count of DMC wait commands of the DDRC in the count period. Written to clear; supports wrap-around counting. The displayed value is half the actual count (the register width is limited and overflow within 1 s at 660 MHz must be avoided).";
            sw = rw;
            onwrite = wclr;
            hw = w;
            reset = 0x0;
        } dmc_cmd_num[31:0];
    } DDRC_TEST10 @ 0x026C;
`endif

`ifdef DDRC_TEST12_0x280_REG
    reg {
        name = "DDRC Test Status Register 12";
        field {
            name = "wfifo_f";
            desc = "Write FIFO full status.";
            sw = r;
            hw = w;
            reset = 0x0;
        } wfifo_f[31:16];

        field {
            name = "wfifo_e";
            desc = "
                Write FIFO empty status.

                !!! NOTE
                    Only the low 12 bits have reset value 1 on the Hi3520D (reset 0xFFF).
            ";
            sw = r;
            hw = w;
            reset = 0xFFF;
        } wfifo_e[15:0];
    } DDRC_TEST12 @ 0x0280;
`endif

`ifdef DDRC_TEST13_0x284_REG
    reg {
        name = "DDRC Test Status Register 13";
        field {
            name = "ddrexec_reorder";
            sw = r;
            hw = w;
            reset = 0x0;
        } ddrexec_reorder[15:0];
    } DDRC_TEST13 @ 0x0284;
`endif

`ifdef DDRC_TEST14_0x288_REG
    reg {
        name = "DDRC Test Status Register 14";
        field {
            name = "ddrexec_reorder_req";
            sw = r;
            hw = w;
            reset = 0x0;
        } ddrexec_reorder_req[15:0];
    } DDRC_TEST14 @ 0x0288;
`endif

`ifdef DDRC_TEST15_0x28C_REG
    reg {
        name = "DDRC Test Status Register 15";
        field {
            name = "ddrexec_reorder_gnt";
            sw = r;
            hw = w;
            reset = 0x0;
        } ddrexec_reorder_gnt[15:0];
    } DDRC_TEST15 @ 0x028C;
`endif

`ifdef DDRC_PHYSRST_0x400_REG
    reg {
        name = "DDRPHY soft reset control signal";

        enum DDRC_PHYSRST_ddrphy_srst_enum {
            RESET_VALID   = 0x0 { desc = "The reset is valid (DDRPHY held in reset)."; };
            RESET_INVALID = 0x1 { desc = "The reset is invalid (DDRPHY running)."; };
        };

        field {
            name = "ddrphy_srst";
            desc = "DDRPHY reset control.";
            encode = DDRC_PHYSRST_ddrphy_srst_enum;
            reset = 0x1;
        } ddrphy_srst[0:0];
    } DDRC_PHYSRST @ 0x0400;
`endif

`ifdef DDRC_PHYSTATUS_0x404_REG
    reg {
        name = "DDRPHY status register";

        enum DDRC_PHYSTATUS_phy_init_done_enum {
            INCOMPLETE = 0x0 { desc = "DDRPHY initialization is not completed."; };
            COMPLETE   = 0x1 { desc = "DDRPHY initialization is complete."; };
        };

        field {
            name = "phy_init_done";
            desc = "DDRPHY initialization done flag.";
            encode = DDRC_PHYSTATUS_phy_init_done_enum;
            sw = r;
            hw = w;
            reset = 0x0;
        } phy_init_done[0:0];

    } DDRC_PHYSTATUS @ 0x0404;
`endif

`ifdef DDRC_PHYCTRL_REG
    reg {
        name = "DDRPHY Control Register";

        enum DDRC_PHYCTRL_phy_init_start_enum {
            VALID   = 0x0 { desc = "The request is valid."; };
            INVALID = 0x1 { desc = "Invalid request."; };
        };

        field {
            name = "phy_init_start";
            desc = "DDRPHY initialization request.";
            encode = DDRC_PHYCTRL_phy_init_start_enum;
            reset = 0x1;
        } phy_init_start[0:0];

    } DDRC_PHYCTRL @ 0x0408;
`endif

`ifdef DDRC_PHY_REG1_REG
    reg {
        name = "DDRPHY register 1";

        enum DDRC_PHY_REG1_phy_rfifo_en_enum {
            BITS_8  = 0x1 { desc = "8 bits read DQ signal;"; };
            BITS_16 = 0x3 { desc = "16 bits read DQ signal."; };
        };

        field {
            name = "phy_rfifo_en";
            desc = "RX FIFO enable.";
            encode = DDRC_PHY_REG1_phy_rfifo_en_enum;
            reset = 0x3;
        } phy_rfifo_en[5:4];

        field {
            name = "reserved_nz";
            desc = "Reserved in the data sheet; the initial value is not zero (reset 0xF). Keep the reset value when writing the register.";
            reset = 0xF;
        } reserved_nz[3:0];

    } DDRC_PHY_REG1 @ 0x0800;
`endif

`ifdef DDRC_PHY_REG2_REG
    reg {
        name = "DDRPHY register 2";

        enum DDRC_PHY_REG2_phy_mem_type_enum {
            DDR3 = 0x0 { desc = "DDR3"; };
            DDR2 = 0x1 { desc = "DDR2"; };
        };

        field {
            name = "phy_mem_type";
            desc = "Memory selection.";
            encode = DDRC_PHY_REG2_phy_mem_type_enum;
            reset = 0x0;
        } phy_mem_type[6:6];

        enum DDRC_PHY_REG2_cal_mode_enum {
            NON_BYPASS = 0x0 { desc = "Non-Bypass Mode"; };
            BYPASS     = 0x1 { desc = "Bypass Mode"; };
        };

        field {
            name = "cal_mode";
            desc = "
                DQS squelch correction mode selection.

                !!! NOTE
                    DQS squelch correction, that is, the internal logic of the chip automatically repeatedly increases or decreases the delay training for the external asynchronous signal reading DQS gating signal, and finally the gating signal can be properly gated to read DQS.
            ";
            encode = DDRC_PHY_REG2_cal_mode_enum;
            reset = 0x0;
        } cal_mode[1:1];

        field {
            name = "cal_start";
            desc = "DQS squelch auto-calibration enable, valid in non-bypass mode.";
            encode = DDRC_enabled_enum;
            reset = 0x0;
        } cal_start[0:0];

    } DDRC_PHY_REG2 @ 0x0808;
`endif

`ifdef DDRC_PHY_REG3_REG
    reg {
        name = "DDRPHY register 3";

        enum DDRC_PHY_REG3_phy_bl_enum {
            BURST_4 = 0x0 { desc = "Burst 4"; };
            BURST_8 = 0x1 { desc = "Burst 8"; };
        };

        field {
            name = "phy_bl";
            desc = "Correct burst length selection.";
            encode = DDRC_PHY_REG3_phy_bl_enum;
            reset = 0x1;
        } phy_bl[0:0];

        field {
            name = "reserved_nz";
            desc = "Reserved in the data sheet; the initial value is not zero (reset 0x12). Keep the reset value when writing the register.";
            reset = 0x12;
        } reserved_nz[7:1];

    } DDRC_PHY_REG3 @ 0x0804;
`endif

`ifdef DDRC_PHY_REG4_REG
    reg {
        name = "DDRPHY register 4";

        field {
            name = "phy_ck_en";
            desc = "
                CK/CKB I/O Enable.
`ifdef DDRC_HI3520D_NOTES

                !!! NOTE
                    Data sheet conflict: the bit table (4.1.6) says 0 = enable, 1 = disable (matching the encoding and the reset value 0 = clock enabled), but the DS standby sequence (4.1.4.1) says to write `phy_ck_en` = 0 to turn the DDR clock off on entry and 1 to turn it on again on exit. One of the two is inverted; the bit table agrees with the reset state (clock running), the sequence is probably the error. Verify on hardware before relying on either.
`endif
            ";
            encode = DDRC_zero_enable_enum;
            reset = 0x0;
        } phy_ck_en[6:6];

        field {
            name = "phy_odt_en";
            desc = "ODT I/O enable.";
            encode = DDRC_zero_enable_enum;
            reset = 0x0;
        } phy_odt_en[3:3];

        field {
            name = "phy_cs_en";
            desc = "CS I/O enable.";
            encode = DDRC_zero_enable_enum;
            reset = 0x0;
        } phy_cs_en[2:2];

        enum DDRC_PHY_REG4_phy_cmd_en_enum {
            ALWAYS       = 0x0 { desc = "Always Enable"; };
            WHEN_COMMAND = 0x1 { desc = "Enabled when a command is received."; };
        };

        field {
            name = "phy_cmd_en";
            desc = "CMD I/O enable.";
            encode = DDRC_PHY_REG4_phy_cmd_en_enum;
            reset = 0x0;
        } phy_cmd_en[1:1];

        field {
            name = "phy_cke_en";
            desc = "CKE I/O Enable.";
            encode = DDRC_zero_enable_enum;
            reset = 0x0;
        } phy_cke_en[0:0];

        field {
            name = "reserved_nz";
            desc = "Reserved in the data sheet; the initial value is not zero (reset 0x2). Keep the reset value when writing the register.";
            reset = 0x2;
        } reserved_nz[5:4];

    } DDRC_PHY_REG4 @ 0x0824;
`endif

`ifdef DDRC_PHY_REG4A_REG
    reg {
        name = "DDRPHY Register 4A";

        field {
            name = "phy_cl";
            desc = "
                CL (CAS latency) delay value.
                DDR2/DDR3 CL latency.
            ";
            reset = 0x7;
        } phy_cl[7:4];

        field {
            name = "phy_al";
            desc = "
                AL (additive latency) value.
                DDR2/DDR3 AL latency.
            ";
            reset = 0x0;
        } phy_al[3:0];

    } DDRC_PHY_REG4A @ 0x0838;
`endif

`ifdef DDRC_PHY_REG4B_REG
    reg {
        name = "DDRPHY Register 4B";

        field {
            name = "phy_dqssq_dly_h";
            desc = "In bypass mode, DQS gate delay selection for upper eight data bits DQ[15:8].";
            reset = 0x1;
        } phy_dqssq_dly_h[5:3];

        field {
            name = "phy_dqssq_dly_l";
            desc = "In bypass mode, the DQS gate delay selection of the lower eight bits of data DQ[15:8].";
            reset = 0x1;
        } phy_dqssq_dly_l[2:0];

    } DDRC_PHY_REG4B @ 0x083C;
`endif

`ifdef DDRC_PHY_REG6_0x8D4_REG
    reg {
        name = "DDRPHY Register 6";

        enum DDRC_PHY_REG6_phy_ltxdqdll_byph_enum {
            NO_DELAY = 0x0 { desc = "No Delay"; };
            DELAY_90 = 0x1 { desc = "90° Delay"; };
        };

        field {
            name = "phy_ltxdqdll_byph";
            desc = "In bypass mode, left channel transmit DQ DLL phase selection.";
            encode = DDRC_PHY_REG6_phy_ltxdqdll_byph_enum;
            reset = 0x0;
        } phy_ltxdqdll_byph[4:4];

        field {
            name = "phy_ltxdqdll_en";
            desc = "Left channel transmit DQ DLL enable.";
            encode = DDRC_enabled_enum;
            reset = 0x1;
        } phy_ltxdqdll_en[3:3];

        field {
            name = "phy_ltxdqdll_dly";
            desc = "Left channel transmit DQ DLL phase delay selection.";
            encode = DDRC_dll_phase_enum;
            reset = 0x4;
        } phy_ltxdqdll_dly[2:0];

    } DDRC_PHY_REG6 @ 0x08D4;
`endif

`ifdef DDRC_PHY_REG7_0x8D8_REG
    reg {
        name = "DDRPHY Register 7";

        enum DDRC_PHY_REG7_phy_ltxdqsdll_byph_enum {
            NO_DELAY = 0x0 { desc = "No Delay"; };
            DELAY_90 = 0x1 { desc = "90° Delay"; };
        };

        field {
            name = "phy_ltxdqsdll_byph";
            desc = "In bypass mode, left channel transmit DQS DLL phase delay selection.";
            encode = DDRC_PHY_REG7_phy_ltxdqsdll_byph_enum;
            reset = 0x0;
        } phy_ltxdqsdll_byph[4:4];

        field {
            name = "phy_ltxdqsdll_en";
            desc = "Left channel transmit DQS DLL enable.";
            encode = DDRC_enabled_enum;
            reset = 0x1;
        } phy_ltxdqsdll_en[3:3];

        field {
            name = "phy_ltxdqsdll_dly";
            desc = "Left channel transmit DQS DLL phase delay selection.";
            encode = DDRC_dll_phase_enum;
            reset = 0x0;
        } phy_ltxdqsdll_dly[2:0];
    } DDRC_PHY_REG7 @ 0x08D8;
`endif

`ifdef DDRC_PHY_REG8_0x8E0_REG
    reg {
        name = "DDRPHY Register 8";

        field {
            name = "phy_ldqssqdll_en";
            desc = "Left channel receive DQS squelch DLL enable.";
            encode = DDRC_zero_enable_enum;
            reset = 0x0;
        } phy_ldqssqdll_en[6:6];

        field {
            name = "phy_ldqssqdll_dly";
            desc = "Left channel receive DQS squelch DLL phase delay selection.";
            encode = DDRC_dll_phase_enum;
            reset = 0x0;
        } phy_ldqssqdll_dly[5:3];

        field {
            name = "phy_lrxdqsdll_en";
            desc = "Left channel receive DQS latching DLL enable.";
            encode = DDRC_zero_enable_enum;
            reset = 0x0;
        } phy_lrxdqsdll_en[2:2];

        enum DDRC_PHY_REG8_phy_lrxdqsdll_dly_enum {
            NO_DELAY   = 0x0 { desc = "No Delay"; };
            DELAY_22_5 = 0x1 { desc = "22.5° Delay"; };
            DELAY_45   = 0x2 { desc = "45° Delay"; };
            DELAY_67_5 = 0x3 { desc = "67.5° Delay"; };
        };

        field {
            name = "phy_lrxdqsdll_dly";
            desc = "The left channel receives DQS latching DLL phase delay selection.";
            encode = DDRC_PHY_REG8_phy_lrxdqsdll_dly_enum;
            reset = 0x1;
        } phy_lrxdqsdll_dly[1:0];

    } DDRC_PHY_REG8 @ 0x08E0;
`endif

`ifdef DDRC_PHY_REG9_0x914_REG
    reg {
        name = "DDRPHY Register 9";

        enum DDRC_PHY_REG9_phy_rtxdqdll_byph_enum {
            NO_DELAY = 0x0 { desc = "No Delay"; };
            DELAY_90 = 0x1 { desc = "90° Delay"; };
        };

        field {
            name = "phy_rtxdqdll_byph";
            desc = "In bypass mode, right channel transmit DQ DLL phase delay selection.";
            encode = DDRC_PHY_REG9_phy_rtxdqdll_byph_enum;
            reset = 0x0;
        } phy_rtxdqdll_byph[4:4];

        field {
            name = "phy_rtxdqdll_en";
            desc = "Right channel transmit DQ DLL enable.";
            encode = DDRC_enabled_enum;
            reset = 0x1;
        } phy_rtxdqdll_en[3:3];

        field {
            name = "phy_rtxdqdll_dly";
            desc = "Right channel transmit DQ DLL phase delay selection.";
            encode = DDRC_dll_phase_enum;
            reset = 0x4;
        } phy_rtxdqdll_dly[2:0];

    } DDRC_PHY_REG9 @ 0x0914;
`endif

`ifdef DDRC_PHY_REG10_0x918_REG
    reg {
        name = "DDRPHY Register 10";

        enum DDRC_PHY_REG10_phy_rtxdqsdll_byph_enum {
            NO_DELAY = 0x0 { desc = "No Delay"; };
            DELAY_90 = 0x1 { desc = "90° Delay"; };
        };

        field {
            name = "phy_rtxdqsdll_byph";
            desc = "In bypass mode, the right channel transmits DQS DLL phase delay selection.";
            encode = DDRC_PHY_REG10_phy_rtxdqsdll_byph_enum;
            reset = 0x0;
        } phy_rtxdqsdll_byph[4:4];

        field {
            name = "phy_rtxdqsdll_en";
            desc = "Right channel transmit DQS DLL";
            encode = DDRC_enabled_enum;
            reset = 0x1;
        } phy_rtxdqsdll_en[3:3];

        field {
            name = "phy_rtxdqsdll_dly";
            desc = "Right channel transmit DQS DLL phase delay select.";
            encode = DDRC_dll_phase_enum;
            reset = 0x0;
        } phy_rtxdqsdll_dly[2:0];

    } DDRC_PHY_REG10 @ 0x0918;
`endif

`ifdef DDRC_PHY_REG11_0x920_REG
    reg {
        name = "DDRPHY Register 11";

        field {
            name = "phy_rdqssqdll_en";
            desc = "Right channel receive DQS squelch DLL";
            encode = DDRC_zero_enable_enum;
            reset = 0x0;
        } phy_rdqssqdll_en[6:6];

        field {
            name = "phy_rdqssqdll_dly";
            desc = "Right channel receive DQS squelch DLL phase delay selection.";
            encode = DDRC_dll_phase_enum;
            reset = 0x0;
        } phy_rdqssqdll_dly[5:3];

        field {
            name = "phy_rrxdqsdll_en";
            desc = "Right channel receive DQS latching DLL";
            encode = DDRC_zero_enable_enum;
            reset = 0x0;
        } phy_rrxdqsdll_en[2:2];

        field {
            name = "phy_rrxdqsdll_dly";
            desc = "Right channel receive DQS latching DLL phase delay selection.";
            encode = DDRC_dll_phase2_enum;
            reset = 0x1;
        } phy_rrxdqsdll_dly[1:0];

    } DDRC_PHY_REG11 @ 0x0920;
`endif

`ifdef DDRC_PHY_REG12_REG
    reg {
        name = "DDRPHY Register 12";

        field {
            name = "phy_cmd0pu_str";
            desc = "CMD0 I/O pull-up driver strength control.";
            reset = 0x8;
        } phy_cmd0pu_str[7:4];

        field {
            name = "phy_cmd0pd_str";
            desc = "CMD0 I/O pull-down driver strength control.";
            reset = 0x8;
        } phy_cmd0pd_str[3:0];

    } DDRC_PHY_REG12 @ 0x0840;
`endif

`ifdef DDRC_PHY_REG13_REG
    reg {
        name = "DDRPHY Register 13";

        field {
            name = "phy_cmd0_rsl";
            desc = "CMD0 I/O rising slope control.";
            reset = 0x8;
        } phy_cmd0_rsl[7:4];

        field {
            name = "phy_cmd0_fsl";
            desc = "CMD0 I/O falling slope control.";
            reset = 0x8;
        } phy_cmd0_fsl[3:0];

    } DDRC_PHY_REG13 @ 0x0844;
`endif

`ifdef DDRC_PHY_REG14_REG
    reg {
        name = "DDRPHY Register 14";

        field {
            name = "phy_cmd0sdll_lpen";
            desc = "CMD0 Slave DLL low power";
            encode = DDRC_zero_enable_enum;
            reset = 0x0;
        } phy_cmd0sdll_lpen[7:7];

        enum DDRC_PHY_REG14_phy_cmd0dly_en_enum {
            NO_DELAY = 0x0 { desc = "No delay"; };
            CYCLE_1  = 0x1 { desc = "1 Cycle"; };
        };

        field {
            name = "phy_cmd0dly_en";
            desc = "CMD0 One clock (2xclk) cycle delay selection.";
            encode = DDRC_PHY_REG14_phy_cmd0dly_en_enum;
            reset = 0x1;
        } phy_cmd0dly_en[6:6];

        field {
            name = "phy_rstn_pu";
            desc = "RESETN Weak pull-up enable.";
            encode = DDRC_zero_enable_enum;
            reset = 0x1;
        } phy_rstn_pu[5:5];

        field {
            name = "phy_rstn_pd";
            desc = "RESETN Weak pull-down.";
            encode = DDRC_enabled_enum;
            reset = 0x1;
        } phy_rstn_pd[4:4];

        field {
            name = "phy_cmd0_pu";
            desc = "CMD0 weak pull-up";
            encode = DDRC_zero_enable_enum;
            reset = 0x0;
        } phy_cmd0_pu[3:3];

        field {
            name = "phy_cmd0_pd";
            desc = "CMD0 weak pull-down enable.";
            encode = DDRC_enabled_enum;
            reset = 0x0;
        } phy_cmd0_pd[2:2];

        field {
            name = "phy_cmd0pu_msb";
            desc = "CMD0 pull-up drive strength control, the highest bit.";
            reset = 0x1;
        } phy_cmd0pu_msb[1:1];

        field {
            name = "phy_cmd0pd_msb";
            desc = "CMD0 pull-down drive strength control, the highest bit.";
            reset = 0x1;
        } phy_cmd0pd_msb[0:0];

    } DDRC_PHY_REG14 @ 0x0848;
`endif

`ifdef DDRC_PHY_REG15_REG
    reg {
        name = "DDRPHY Register 15";

        field {
            name = "phy_cmd0fb_en";
            desc = "CMD0 feedback enable.";
            encode = DDRC_enabled_enum;
            reset = 0x0;
        } phy_cmd0fb_en[5:5];

        enum DDRC_PHY_REG15_phy_cmd0sdll_inv_enum {
            NO_REVERSE = 0x0 { desc = "No Reverse"; };
            REVERSE    = 0x1 { desc = "Reverse"; };
        };

        field {
            name = "phy_cmd0sdll_inv";
            desc = "CMD0 is selected from DLL reverse";
            encode = DDRC_PHY_REG15_phy_cmd0sdll_inv_enum;
            reset = 0x0;
        } phy_cmd0sdll_inv[4:4];

        field {
            name = "phy_cmd0sdll_en";
            desc = "CMD0 is enabled from DLL.";
            encode = DDRC_enabled_enum;
            reset = 0x1;
        } phy_cmd0sdll_en[3:3];

        field {
            name = "phy_cmd0txsdll_dly";
            desc = "CMD0 TX slave DLL phase delay select.";
            encode = DDRC_dll_phase_enum;
            reset = 0x0;
        } phy_cmd0txsdll_dly[2:0];

    } DDRC_PHY_REG15 @ 0x084C;
`endif

`ifdef DDRC_PHY_REG16_REG
    reg {
        name = "DDRPHY Register 16";

        field {
            name = "phy_cmd1pu_str";
            desc = "CMD1 pull-up drive strength control.";
            reset = 0x8;
        } phy_cmd1pu_str[7:4];

        field {
            name = "phy_cmd1pd_str";
            desc = "CMD1 pull-down drive strength control.";
            reset = 0x8;
        } phy_cmd1pd_str[3:0];

    } DDRC_PHY_REG16 @ 0x0854;
`endif

`ifdef DDRC_PHY_REG17_REG
    reg {
        name = "DDRPHY Register 17";

        field {
            name = "phy_cmd1_rsl";
            desc = "CMD1 rising slope control.";
            reset = 0x8;
        } phy_cmd1_rsl[7:4];

        field {
            name = "phy_cmd1_fsl";
            desc = "CMD1 falling slope control.";
            reset = 0x8;
        } phy_cmd1_fsl[3:0];

    } DDRC_PHY_REG17 @ 0x0858;
`endif

`ifdef DDRC_PHY_REG18_REG
    reg {
        name = "DDRPHY Register 18";

        field {
            name = "phy_cmd1sdll_lpen";
            desc = "CMD1 Slave DLL low power";
            encode = DDRC_zero_enable_enum;
            reset = 0x0;
        } phy_cmd1sdll_lpen[7:7];

        enum DDRC_PHY_REG18_phy_cmd1dly_en_enum {
            NO_DELAY = 0x0 { desc = "No Delay"; };
            CYCLE_1  = 0x1 { desc = "1 Cycle"; };
        };

        field {
            name = "phy_cmd1dly_en";
            desc = "CMD1 One clock (2xclk) cycle delay selection.";
            encode = DDRC_PHY_REG18_phy_cmd1dly_en_enum;
            reset = 0x1;
        } phy_cmd1dly_en[6:6];

        field {
            name = "phy_rstn_pu";
            desc = "CKE Weak pull-up control.";
            encode = DDRC_zero_enable_enum;
            reset = 0x0;
        } phy_rstn_pu[5:5];

        field {
            name = "phy_rstn_pd";
            desc = "CKE weak pull-down enable.";
            encode = DDRC_enabled_enum;
            reset = 0x1;
        } phy_rstn_pd[4:4];

        field {
            name = "phy_cmd1_pu";
            desc = "CMD1 weak pull-up";
            encode = DDRC_zero_enable_enum;
            reset = 0x0;
        } phy_cmd1_pu[3:3];

        field {
            name = "phy_cmd1_pd";
            desc = "CMD1 weak pull-down enable.";
            encode = DDRC_enabled_enum;
            reset = 0x0;
        } phy_cmd1_pd[2:2];

        field {
            name = "phy_cmd1pu_msb";
            desc = "CMD1 pull-up drive strength control, the highest bit.";
            reset = 0x1;
        } phy_cmd1pu_msb[1:1];

        field {
            name = "phy_cmd1pd_msb";
            desc = "CMD1 pull-down drive strength control, highest bit.";
            reset = 0x1;
        } phy_cmd1pd_msb[0:0];

    } DDRC_PHY_REG18 @ 0x085C;
`endif

`ifdef DDRC_PHY_REG19_REG
    reg {
        name = "DDRPHY Register 19";

        field {
            name = "phy_cmd1fb_en";
            desc = "CMD1 feedback enable.";
            encode = DDRC_enabled_enum;
            reset = 0x0;
        } phy_cmd1fb_en[5:5];

        enum DDRC_PHY_REG19_phy_cmd1sdll_inv_enum {
            NO_REVERSE = 0x0 { desc = "No Reverse"; };
            REVERSE    = 0x1 { desc = "Reverse"; };
        };

        field {
            name = "phy_cmd1sdll_inv";
            desc = "CMD1 Select from DLL reverse mode.";
            encode = DDRC_PHY_REG19_phy_cmd1sdll_inv_enum;
            reset = 0x0;
        } phy_cmd1sdll_inv[4:4];

        field {
            name = "phy_cmd1sdll_en";
            desc = "CMD1 Enable from DLL.";
            encode = DDRC_enabled_enum;
            reset = 0x1;
        } phy_cmd1sdll_en[3:3];

        field {
            name = "phy_cmd1txsdll_dly";
            desc = "CMD1 TX slave DLL phase delay select.";
            encode = DDRC_dll_phase_enum;
            reset = 0x0;
        } phy_cmd1txsdll_dly[2:0];

    } DDRC_PHY_REG19 @ 0x0860;
`endif

`ifdef DDRC_PHY_REG20_REG
    reg {
        name = "DDRPHY Register 20";

        field {
            name = "phy_cmd1obv_en";
            desc = "CMD1 observation enable.";
            encode = DDRC_enabled_enum;
            reset = 0x0;
        } phy_cmd1obv_en[3:3];

        enum DDRC_PHY_REG20_phy_ckdly_en_enum {
            NO_DELAY = 0x0 { desc = "No Delay"; };
            CYCLE_1  = 0x1 { desc = "1 Cycle"; };
        };

        field {
            name = "phy_ckdly_en";
            desc = "CK One clock (2xclk) cycle delay selection.";
            encode = DDRC_PHY_REG20_phy_ckdly_en_enum;
            reset = 0x1;
        } phy_ckdly_en[0:0];

        field {
            name = "reserved_nz";
            desc = "Reserved in the data sheet; the initial value is not zero (reset 0x2). Keep the reset value when writing the register.";
            reset = 0x2;
        } reserved_nz[2:1];

    } DDRC_PHY_REG20 @ 0x0864;
`endif

`ifdef DDRC_PHY_REG21_REG
    reg {
        name = "DDRPHY Register 21";

        enum DDRC_PHY_REG21_phy_cksdll_inv_enum {
            NO_REVERSE = 0x0 { desc = "No Reverse"; };
            REVERSE    = 0x1 { desc = "Reverse"; };
        };

        field {
            name = "phy_cksdll_inv";
            desc = "CK is selected from DLL reverse";
            encode = DDRC_PHY_REG21_phy_cksdll_inv_enum;
            reset = 0x0;
        } phy_cksdll_inv[3:3];

        field {
            name = "phy_cktxsdll_dly";
            desc = "CK transmit from DLL phase delay select.";
            encode = DDRC_dll_phase_enum;
            reset = 0x0;
        } phy_cktxsdll_dly[2:0];

    } DDRC_PHY_REG21 @ 0x0868;
`endif

`ifdef DDRC_PHY_REG22_REG
    reg {
        name = "DDRPHY Register 22";

        field {
            name = "phy_ckpu_str";
            desc = "CK pull-up drive strength control.";
            reset = 0x8;
        } phy_ckpu_str[7:4];

        field {
            name = "phy_ckpd_str";
            desc = "CK pull-down drive strength control.";
            reset = 0x8;
        } phy_ckpd_str[3:0];

    } DDRC_PHY_REG22 @ 0x0870;
`endif

`ifdef DDRC_PHY_REG23_REG
    reg {
        name = "DDRPHY Register 23";

        field {
            name = "phy_ck_rsl";
            desc = "CK rising slope control.";
            reset = 0x8;
        } phy_ck_rsl[7:4];

        field {
            name = "phy_ck_fsl";
            desc = "CK falling slope control.";
            reset = 0x8;
        } phy_ck_fsl[3:0];

    } DDRC_PHY_REG23 @ 0x0874;
`endif

`ifdef DDRC_PHY_REG24_REG
    reg {
        name = "DDRPHY Register 24";

        field {
            name = "phy_ckpu_msb";
            desc = "CK pull-up drive strength control, highest bit.";
            reset = 0x1;
        } phy_ckpu_msb[1:1];

        field {
            name = "phy_ckpd_msb";
            desc = "CK pull-down drive strength control, MSB.";
            reset = 0x1;
        } phy_ckpd_msb[0:0];

    } DDRC_PHY_REG24 @ 0x0878;
`endif

`ifdef DDRC_PHY_REG25_REG
    reg {
        name = "DDRPHY Register 25";

        field {
            name = "phy_dqpu_str";
            desc = "DQ pull-up drive strength control.";
            reset = 0x8;
        } phy_dqpu_str[7:4];

        field {
            name = "phy_dqpd_str";
            desc = "DQ pull-down drive strength control.";
            reset = 0x8;
        } phy_dqpd_str[3:0];

    } DDRC_PHY_REG25 @ 0x0880;
`endif

`ifdef DDRC_PHY_REG26_REG
    reg {
        name = "DDRPHY Register 26";

        field {
            name = "phy_dq_rsl";
            desc = "DQ rising slope control.";
            reset = 0x8;
        } phy_dq_rsl[7:4];

        field {
            name = "phy_dq_fsl";
            desc = "DQ falling slope control.";
            reset = 0x8;
        } phy_dq_fsl[3:0];

    } DDRC_PHY_REG26 @ 0x0884;
`endif

`ifdef DDRC_PHY_REG27_REG
    reg {
        name = "DDRPHY Register 27";

        field {
            name = "phy_dqpu_odt";
            desc = "DQ pull-up ODT control.";
            reset = 0x4;
        } phy_dqpu_odt[5:3];

        field {
            name = "phy_dqpd_odt";
            desc = "DQ pull-down ODT control.";
            reset = 0x4;
        } phy_dqpd_odt[2:0];

    } DDRC_PHY_REG27 @ 0x0888;
`endif

`ifdef DDRC_PHY_REG28_REG
    reg {
        name = "DDRPHY Register 28";

        field {
            name = "phy_dqpd_msb";
            desc = "DQ pull-down drive strength control, highest bit.";
            reset = 0x1;
        } phy_dqpd_msb[5:5];

        field {
            name = "phy_dqpu_msb";
            desc = "DQ pull-up drive strength control, the highest bit.";
            reset = 0x1;
        } phy_dqpu_msb[4:4];

        field {
            name = "phy_dqpu_en";
            desc = "DQ weak pull-up";
            encode = DDRC_zero_enable_enum;
            reset = 0x0;
        } phy_dqpu_en[3:3];

        field {
            name = "phy_dqpd_en";
            desc = "DQ weak pull-down";
            encode = DDRC_enabled_enum;
            reset = 0x1;
        } phy_dqpd_en[2:2];

        field {
            name = "phy_dqpu_odtmsb";
            desc = "DQ pull-up ODT control, the highest bit.";
            reset = 0x1;
        } phy_dqpu_odtmsb[1:1];

        field {
            name = "phy_dqpd_odtmsb";
            desc = "DQ pull-down ODT control, highest bit.";
            reset = 0x1;
        } phy_dqpd_odtmsb[0:0];

    } DDRC_PHY_REG28 @ 0x088C;
`endif

`ifdef DDRC_PHY_REG29_REG
    reg {
        name = "DDRPHY Register 29";
        desc = "Hardware (Hi3520D V100 board, read on hardware 2026-11-08, stock U-Boot prompt after a cold boot): reads 0x00000024 (phy_dqssq_2xdly_h = 0, phy_dqssq_2xdly_l = 0, reserved_nz bits 5 and 2 = 1); the data sheet reset is 0x2D (both delay fields 1). Hardware wins: the reset is 0x24. It may have been changed by the boot table (the vendor boot table does not list 0x9C0).";

        enum DDRC_PHY_REG29_delay_cycles_enum {
            NO_DELAY = 0x0 { desc = "No Delay"; };
            CYCLE_1  = 0x1 { desc = "One Cycle"; };
            CYCLE_2  = 0x2 { desc = "Two Cycles"; };
            CYCLE_3  = 0x3 { desc = "Three Cycles"; };
        };

        field {
            name = "phy_dqssq_2xdly_h";
            desc = "The upper eight bits receive the clock (2xclk) cycle delay selection for the DQS squelch.";
            encode = DDRC_PHY_REG29_delay_cycles_enum;
            reset = 0x0;
        } phy_dqssq_2xdly_h[4:3];

        field {
            name = "phy_dqssq_2xdly_l";
            desc = "The lower eight bits receive the clock (2xclk) cycle delay selection for the DQS squelch";
            encode = DDRC_PHY_REG29_delay_cycles_enum;
            reset = 0x0;
        } phy_dqssq_2xdly_l[1:0];

        field {
            name = "reserved_nz1";
            desc = "Reserved in the data sheet; the initial value is not zero (reset 0x1). Keep the reset value when writing the register.";
            reset = 0x1;
        } reserved_nz1[5:5];

        field {
            name = "reserved_nz0";
            desc = "Reserved in the data sheet; the initial value is not zero (reset 0x1). Keep the reset value when writing the register.";
            reset = 0x1;
        } reserved_nz0[2:2];

    } DDRC_PHY_REG29 @ 0x09C0;
`endif

`ifdef DDRC_PHY_REG30_REG
    reg {
        name = "DDRPHY Register 30";
        desc = "Read on hardware 2026-11-08 (Hi3520D V100, stock U-Boot prompt after a cold boot): 0x00000000. The vendor boot table zeroes 0xAC4..0xB4C and then writes 0x9 to a few of them, so this is the boot-table value, not taken as the reset value (the reset here is the data sheet value).";

        field {
            name = "phy_skew_a1";
            desc = "A1 delay.";
            reset = 0x4;
        } phy_skew_a1[5:3];

        field {
            name = "phy_skew_a0";
            desc = "A0 delay.";
            reset = 0x4;
        } phy_skew_a0[2:0];

    } DDRC_PHY_REG30 @ 0x0AC4;
`endif

`ifdef DDRC_PHY_REG31_REG
    reg {
        name = "DDRPHY Register 31";
        desc = "Read on hardware 2026-11-08 (Hi3520D V100, stock U-Boot prompt after a cold boot): 0x00000000. The vendor boot table zeroes 0xAC4..0xB4C and then writes 0x9 to a few of them, so this is the boot-table value, not taken as the reset value (the reset here is the data sheet value).";

        field {
            name = "phy_skew_a3";
            desc = "A3 delay.";
            reset = 0x4;
        } phy_skew_a3[5:3];

        field {
            name = "phy_skew_a2";
            desc = "A2 delay.";
            reset = 0x4;
        } phy_skew_a2[2:0];

    } DDRC_PHY_REG31 @ 0x0AC8;
`endif

`ifdef DDRC_PHY_REG32_REG
    reg {
        name = "DDRPHY Register 32";
        desc = "Read on hardware 2026-11-08 (Hi3520D V100, stock U-Boot prompt after a cold boot): 0x00000000. The vendor boot table zeroes 0xAC4..0xB4C and then writes 0x9 to a few of them, so this is the boot-table value, not taken as the reset value (the reset here is the data sheet value).";

        field {
            name = "phy_skew_a5";
            desc = "A5 delay.";
            reset = 0x4;
        } phy_skew_a5[5:3];

        field {
            name = "phy_skew_a4";
            desc = "A4 delay.";
            reset = 0x4;
        } phy_skew_a4[2:0];

    } DDRC_PHY_REG32 @ 0x0ACC;
`endif

`ifdef DDRC_PHY_REG33_REG
    reg {
        name = "DDRPHY Register 33";
        desc = "Read on hardware 2026-11-08 (Hi3520D V100, stock U-Boot prompt after a cold boot): 0x00000000. The vendor boot table zeroes 0xAC4..0xB4C and then writes 0x9 to a few of them, so this is the boot-table value, not taken as the reset value (the reset here is the data sheet value).";

        field {
            name = "phy_skew_a7";
            desc = "A7 delay.";
            reset = 0x4;
        } phy_skew_a7[5:3];

        field {
            name = "phy_skew_a6";
            desc = "A6 delay.";
            reset = 0x4;
        } phy_skew_a6[2:0];

    } DDRC_PHY_REG33 @ 0x0AD0;
`endif

`ifdef DDRC_PHY_REG34_REG
    reg {
        name = "DDRPHY Register 34";
        desc = "Read on hardware 2026-11-08 (Hi3520D V100, stock U-Boot prompt after a cold boot): 0x00000000. The vendor boot table zeroes 0xAC4..0xB4C and then writes 0x9 to a few of them, so this is the boot-table value, not taken as the reset value (the reset here is the data sheet value).";

        field {
            name = "phy_skew_a9";
            desc = "A9 delay.";
            reset = 0x4;
        } phy_skew_a9[5:3];

        field {
            name = "phy_skew_a8";
            desc = "A8 delay.";
            reset = 0x4;
        } phy_skew_a8[2:0];

    } DDRC_PHY_REG34 @ 0x0AD4;
`endif

`ifdef DDRC_PHY_REG35_REG
    reg {
        name = "DDRPHY Register 35";
        desc = "Read on hardware 2026-11-08 (Hi3520D V100, stock U-Boot prompt after a cold boot): 0x00000000. The vendor boot table zeroes 0xAC4..0xB4C and then writes 0x9 to a few of them, so this is the boot-table value, not taken as the reset value (the reset here is the data sheet value).";

        field {
            name = "phy_skew_a11";
            desc = "A11 delay.";
            reset = 0x4;
        } phy_skew_a11[5:3];

        field {
            name = "phy_skew_a10";
            desc = "A10 delay.";
            reset = 0x4;
        } phy_skew_a10[2:0];

    } DDRC_PHY_REG35 @ 0x0AD8;
`endif

`ifdef DDRC_PHY_REG36_REG
    reg {
        name = "DDRPHY Register 36";
        desc = "Read on hardware 2026-11-08 (Hi3520D V100, stock U-Boot prompt after a cold boot): 0x00000000. The vendor boot table zeroes 0xAC4..0xB4C and then writes 0x9 to a few of them, so this is the boot-table value, not taken as the reset value (the reset here is the data sheet value).";

        field {
            name = "phy_skew_a13";
            desc = "A13 delay.";
            reset = 0x4;
        } phy_skew_a13[5:3];

        field {
            name = "phy_skew_a12";
            desc = "A12 delay.";
            reset = 0x4;
        } phy_skew_a12[2:0];

    } DDRC_PHY_REG36 @ 0x0ADC;
`endif

`ifdef DDRC_PHY_REG37_REG
    reg {
        name = "DDRPHY Register 37";
        desc = "Read on hardware 2026-11-08 (Hi3520D V100, stock U-Boot prompt after a cold boot): 0x00000000. The vendor boot table zeroes 0xAC4..0xB4C and then writes 0x9 to a few of them, so this is the boot-table value, not taken as the reset value (the reset here is the data sheet value).";

        field {
            name = "phy_skew_b1";
            desc = "B1 delay.";
            reset = 0x4;
        } phy_skew_b1[5:3];

        field {
            name = "phy_skew_b0";
            desc = "B0 delay.";
            reset = 0x4;
        } phy_skew_b0[2:0];

    } DDRC_PHY_REG37 @ 0x0AE0;
`endif

`ifdef DDRC_PHY_REG38_REG
    reg {
        name = "DDRPHY Register 38";
        desc = "Read on hardware 2026-11-08 (Hi3520D V100, stock U-Boot prompt after a cold boot): 0x00000000. The vendor boot table zeroes 0xAC4..0xB4C and then writes 0x9 to a few of them, so this is the boot-table value, not taken as the reset value (the reset here is the data sheet value).";

        field {
            name = "phy_skew_rasb";
            desc = "RASB delay.";
            reset = 0x4;
        } phy_skew_rasb[5:3];

        field {
            name = "phy_skew_b2";
            desc = "B2 delay.";
            reset = 0x4;
        } phy_skew_b2[2:0];

    } DDRC_PHY_REG38 @ 0x0AE4;
`endif

`ifdef DDRC_PHY_REG39_REG
    reg {
        name = "DDRPHY Register 39";
        desc = "Read on hardware 2026-11-08 (Hi3520D V100, stock U-Boot prompt after a cold boot): 0x00000000. The vendor boot table zeroes 0xAC4..0xB4C and then writes 0x9 to a few of them, so this is the boot-table value, not taken as the reset value (the reset here is the data sheet value).";

        field {
            name = "phy_skew_web";
            desc = "WEB delay.";
            reset = 0x4;
        } phy_skew_web[5:3];

        field {
            name = "phy_skew_casb";
            desc = "CASB delay.";
            reset = 0x4;
        } phy_skew_casb[2:0];

    } DDRC_PHY_REG39 @ 0x0AE8;
`endif

`ifdef DDRC_PHY_REG40_REG
    reg {
        name = "DDRPHY Register 40";
        desc = "Read on hardware 2026-11-08 (Hi3520D V100, stock U-Boot prompt after a cold boot): 0x00000009. The vendor boot table zeroes 0xAC4..0xB4C and then writes 0x9 to a few of them, so this is the boot-table value, not taken as the reset value (the reset here is the data sheet value).";

        field {
            name = "phy_skew_ckb1";
            desc = "CKB1 delay.";
            reset = 0x4;
        } phy_skew_ckb1[5:3];

        field {
            name = "phy_skew_ck1";
            desc = "CK1 delay.";
            reset = 0x4;
        } phy_skew_ck1[2:0];

    } DDRC_PHY_REG40 @ 0x0AEC;
`endif

`ifdef DDRC_PHY_REG41_REG
    reg {
        name = "DDRPHY Register 41";
        desc = "Read on hardware 2026-11-08 (Hi3520D V100, stock U-Boot prompt after a cold boot): 0x00000000. The vendor boot table zeroes 0xAC4..0xB4C and then writes 0x9 to a few of them, so this is the boot-table value, not taken as the reset value (the reset here is the data sheet value).";

        field {
            name = "phy_skew_cke";
            desc = "CKE delay.";
            reset = 0x4;
        } phy_skew_cke[5:3];

        field {
            name = "phy_skew_odt";
            desc = "ODT delay.";
            reset = 0x4;
        } phy_skew_odt[2:0];

    } DDRC_PHY_REG41 @ 0x0AF0;
`endif

`ifdef DDRC_PHY_REG42_REG
    reg {
        name = "DDRPHY Register 42";
        desc = "Read on hardware 2026-11-08 (Hi3520D V100, stock U-Boot prompt after a cold boot): 0x00000000. The vendor boot table zeroes 0xAC4..0xB4C and then writes 0x9 to a few of them, so this is the boot-table value, not taken as the reset value (the reset here is the data sheet value).";

        field {
            name = "phy_skew_rstn";
            desc = "RESETN delay.";
            reset = 0x4;
        } phy_skew_rstn[2:0];

    } DDRC_PHY_REG42 @ 0x0AF4;
`endif

`ifdef DDRC_PHY_REG43_REG
    reg {
        name = "DDRPHY Register 43";
        desc = "Read on hardware 2026-11-08 (Hi3520D V100, stock U-Boot prompt after a cold boot): 0x00000000. The vendor boot table zeroes 0xAC4..0xB4C and then writes 0x9 to a few of them, so this is the boot-table value, not taken as the reset value (the reset here is the data sheet value).";

        field {
            name = "phy_txskew_dm1";
            desc = "TX DM1 delay.";
            reset = 0x4;
        } phy_txskew_dm1[5:3];

        field {
            name = "phy_txskew_dm0";
            desc = "TX DM0 delay.";
            reset = 0x4;
        } phy_txskew_dm0[2:0];

    } DDRC_PHY_REG43 @ 0x0AF8;
`endif

`ifdef DDRC_PHY_TXDQSKEW_REG
    reg {
        name = "DDRPHY TX DQ skew register";
        desc = "One register per DQ pair, dq_hf = 0..7 (0xAFC + 0x4 x dq_hf). Read on hardware 2026-11-08 (Hi3520D V100, stock U-Boot prompt after a cold boot): [0] 0x0, [1] 0x0, [2] 0x0, [3] 0x0, [4] 0x0, [5] 0x0, [6] 0x0, [7] 0x0. The vendor boot table zeroes 0xAC4..0xB4C and then writes 0x9 to a few of them, so this is the boot-table value, not taken as the reset value (the reset here is the data sheet value).";

        field {
            name = "phy_txskew_dq_o";
            desc = "TX DQ[2 x dq_hf + 1] bit delay.";
            reset = 0x4;
        } phy_txskew_dq_o[5:3];

        field {
            name = "phy_txskew_dq_e";
            desc = "TX DQ[2 x dq_hf] bit delay (the data sheet misprints the index as `dq_hal`).";
            reset = 0x4;
        } phy_txskew_dq_e[2:0];

    } DDRC_PHY_TXDQSKEW[8] @ 0x0AFC += 0x4;
`endif

`ifdef DDRC_PHY_REG52_REG
    reg {
        name = "DDRPHY Register 52";
        desc = "Read on hardware 2026-11-08 (Hi3520D V100, stock U-Boot prompt after a cold boot): 0x00000000. The vendor boot table zeroes 0xAC4..0xB4C and then writes 0x9 to a few of them, so this is the boot-table value, not taken as the reset value (the reset here is the data sheet value).";

        field {
            name = "phy_txskew_dqs1";
            desc = "TX DQS1 delay.";
            reset = 0x4;
        } phy_txskew_dqs1[5:3];

        field {
            name = "phy_txskew_dqs0";
            desc = "TX DQS0 delay.";
            reset = 0x4;
        } phy_txskew_dqs0[2:0];

    } DDRC_PHY_REG52 @ 0x0B1C;
`endif

`ifdef DDRC_PHY_REG53_REG
    reg {
        name = "DDRPHY Register 53";
        desc = "Read on hardware 2026-11-08 (Hi3520D V100, stock U-Boot prompt after a cold boot): 0x00000000. The vendor boot table zeroes 0xAC4..0xB4C and then writes 0x9 to a few of them, so this is the boot-table value, not taken as the reset value (the reset here is the data sheet value).";

        field {
            name = "phy_skew_a14";
            desc = "A14 bit delay.";
            reset = 0x4;
        } phy_skew_a14[2:0];

    } DDRC_PHY_REG53 @ 0x0B20;
`endif

`ifdef DDRC_PHY_REG54_REG
    reg {
        name = "DDRPHY Register 54";
        desc = "Read on hardware 2026-11-08 (Hi3520D V100, stock U-Boot prompt after a cold boot): 0x00000009. The vendor boot table zeroes 0xAC4..0xB4C and then writes 0x9 to a few of them, so this is the boot-table value, not taken as the reset value (the reset here is the data sheet value).";

        field {
            name = "phy_skew_ckb0";
            desc = "CKB0 delay.";
            reset = 0x4;
        } phy_skew_ckb0[5:3];

        field {
            name = "phy_skew_ck0";
            desc = "CK0 delay.";
            reset = 0x4;
        } phy_skew_ck0[2:0];

    } DDRC_PHY_REG54 @ 0x0B24;
`endif

`ifdef DDRC_PHY_REG55_REG
    reg {
        name = "DDRPHY Register 55";
        desc = "Read on hardware 2026-11-08 (Hi3520D V100, stock U-Boot prompt after a cold boot): 0x00000000. The vendor boot table zeroes 0xAC4..0xB4C and then writes 0x9 to a few of them, so this is the boot-table value, not taken as the reset value (the reset here is the data sheet value).";

        field {
            name = "phy_rxskew_dm1";
            desc = "RX DM1 delay.";
            reset = 0x4;
        } phy_rxskew_dm1[5:3];

        field {
            name = "phy_rxskew_dm0";
            desc = "RX DM0 delay.";
            reset = 0x4;
        } phy_rxskew_dm0[2:0];

    } DDRC_PHY_REG55 @ 0x0B28;
`endif

`ifdef DDRC_PHY_RXDQSKEW_REG
    reg {
        name = "DDRPHY RX DQ skew register";
        desc = "One register per DQ pair, dq_hf = 0..7 (0xB2C + 0x4 x dq_hf). Read on hardware 2026-11-08 (Hi3520D V100, stock U-Boot prompt after a cold boot): [0] 0x9, [1] 0x1, [2] 0xB, [3] 0x1, [4] 0x8, [5] 0x1, [6] 0x1, [7] 0x8. The vendor boot table zeroes 0xAC4..0xB4C and then writes 0x9 to a few of them, so this is the boot-table value, not taken as the reset value (the reset here is the data sheet value).";

        field {
            name = "phy_rxskew_dq_o";
            desc = "RX DQ[2 x dq_hf + 1] bit delay.";
            reset = 0x4;
        } phy_rxskew_dq_o[5:3];

        field {
            name = "phy_rxskew_dq_e";
            desc = "RX DQ[2 x dq_hf] bit delay (the data sheet misprints the index as `dq_hal`).";
            reset = 0x4;
        } phy_rxskew_dq_e[2:0];

    } DDRC_PHY_RXDQSKEW[8] @ 0x0B2C += 0x4;
`endif

`ifdef DDRC_PHY_REG5E_REG
    reg {
        name = "DDRPHY register 5E";
        desc = "Read on hardware 2026-11-08 (Hi3520D V100, stock U-Boot prompt after a cold boot): 0x00000009. The vendor boot table zeroes 0xAC4..0xB4C and then writes 0x9 to a few of them, so this is the boot-table value, not taken as the reset value (the reset here is the data sheet value).";

        field {
            name = "phy_rxskew_dqs1";
            desc = "RX DQS1 latency.";
            reset = 0x4;
        } phy_rxskew_dqs1[5:3];

        field {
            name = "phy_rxskew_dqs0";
            desc = "RX DQS0 delay.";
            reset = 0x4;
        } phy_rxskew_dqs0[2:0];

    } DDRC_PHY_REG5E @ 0x0B4C;
`endif

`ifdef DDRC_PHY_REG60_REG
    reg {
        name = "DDRPHY Register 60";
        desc = "One register per byte lane, blanes = 0..1 (0xBE0 + 0x4 x blanes). Read-only gating calibration result. Read on hardware 2026-11-08 (stock U-Boot prompt after a cold boot): 0x00000082 (lane 0) and 0x00000062 (lane 1), the result of the boot gate training; status, not a reset value.";

        field {
            name = "phy_cal_dllsel";
            desc = "Calibration configuration: DLL phase delay select.";
            sw = r;
            hw = w;
            reset = 0x0;
        } phy_cal_dllsel[7:5];

        field {
            name = "phy_cal_ophsel";
            desc = "Calibration configuration: gating delay clock cycle select.";
            sw = r;
            hw = w;
            reset = 0x0;
        } phy_cal_ophsel[4:3];

        field {
            name = "phy_cal_cycsel";
            desc = "Calibration configuration: read enable delay clock cycle select.";
            sw = r;
            hw = w;
            reset = 0x0;
        } phy_cal_cycsel[2:0];

    } DDRC_PHY_REG60[2] @ 0x0BE0 += 0x4;
`endif

`ifdef DDRC_PHY_REG61_REG
    reg {
        name = "DDRPHY Register 61";
`ifdef DDRC_HI3520D_NOTES
        desc = "
            The data sheet DDR2/DDR3 bring-up sequences (4.1.4) say to poll `DDRC_PHYREG62[phy_cal_done_h]` and `[phy_cal_done_l]` 'at address 0xB48' after starting the automatic read DQS training with DDRC_PHY_REG2 = 1. The register tables put `phy_cal_done_h/l` in this register (DDRC_PHY_REG61, 0xBE8), while DDRC_PHY_REG62 (0xBC4) holds phy_idqe_h/phy_idqs_l and 0xB48 is DDRC_PHY_RXDQSKEW[7]. The sequence text names the wrong register and address.
        ";
`endif

        field {
            name = "phy_cal_done_h";
            desc = "DQS gating signal correction completion signal of high eight-bit data DQ[15:8].";
            reset = 0x0;
            sw = r;
            hw = w;
        } phy_cal_done_h[1:1];

        field {
            name = "phy_cal_done_l";
            desc = "DQS gate control signal of the lower eight bits of data DQ[15:8] Calibration complete signal.";
            reset = 0x0;
            sw = r;
            hw = w;
        } phy_cal_done_l[0:0];

    } DDRC_PHY_REG61 @ 0x0BE8;
`endif

`ifdef DDRC_PHY_REG62_REG
    reg {
        name = "DDRPHY Register 62";

        field {
            name = "phy_idqe_h";
            desc = "DQS gate signal sampling DQS value of high eight-bit data DQ[15:8].";
            reset = 0x0;
            sw = r;
            hw = w;
        } phy_idqe_h[1:1];

        field {
            name = "phy_idqs_l";
            desc = "DQS gate signal sampling DQS value of the lower eight bits of data DQ[7:0].";
            reset = 0x0;
            sw = r;
            hw = w;
        } phy_idqs_l[0:0];

    } DDRC_PHY_REG62 @ 0x0BC4;
`endif

`ifdef DDRC_PHY_UNDOC_0xA04_REG
    reg {
        name = "DDR PHY register 0xA04 (undocumented)";
        desc = "Undocumented: not in the data sheet. Seen in the vendor boot register table (decoded from the OEM boot image, reg_info Hi3520D-bvt_No1_660_330_660_ddr_innerFEPHY and the Hi3515A table): the boot writes 0x0000001f here before the other DDR PHY registers (DDR PHY analogue and delay settings step, right after the SC_PERIPHCTRL27 bit 0 clear). Nothing else is known; 0x1f is the value the vendor boot writes, not a reset value. Field layout unknown (modelled as one 32-bit field). Read on hardware 2026-11-08 (Hi3520D V100, stock U-Boot prompt after a cold boot): 0x0000001F, i.e. the value the vendor boot table writes, so this is the boot-table value at the prompt, not a proven reset value (the register exists and is readable).";
        field {
            name = "value";
            desc = "Undocumented: whole register; the vendor boot writes 0x1f.";
            sw = rw;
        } value[31:0];
    } DDRC_PHY_UNDOC_0A04 @ 0x0A04;
`endif

`ifdef DDRC_PHY_UNDOC_0xAC0_REG
    reg {
        name = "DDR PHY register 0xAC0 (undocumented)";
        desc = "Undocumented: not in the data sheet. Seen in the vendor boot register table (decoded from the OEM boot image): the boot writes 0x00000055 here (Hi3520D and Hi3515A tables), then zeroes 0xAC4-0xB4C (see DDRC_PHY_REG30..DDRC_PHY_REG5E, per-lane delay registers). 0x55 is the value the vendor boot writes, not a reset value. The suspicion that the data sheet address 0x9C0 of DDRC_PHY_REG29 is a typo for 0xAC0 is refuted by the hardware read of 2026-11-08: 0x9C0 reads 0x24 and 0xAC0 reads 0x55, so both exist and are different registers. Field layout unknown (modelled as one 32-bit field). Read on hardware 2026-11-08 (Hi3520D V100, stock U-Boot prompt after a cold boot): 0x00000055, i.e. the value the vendor boot table writes, so this is the boot-table value at the prompt, not a proven reset value (the register exists and is readable).";
        field {
            name = "value";
            desc = "Undocumented: whole register; the vendor boot writes 0x55.";
            sw = rw;
        } value[31:0];
    } DDRC_PHY_UNDOC_0AC0 @ 0x0AC0;
`endif

`ifdef DDRC_PHY_UNDOC_0x818_REG
    reg {
        name = "DDR PHY register 0x818 (undocumented)";
        desc = "Undocumented: not in the data sheet. Seen in the vendor boot register table (decoded from the OEM boot image, listed there only as 'DDRC +0x818'): the boot writes 0x00000040 here (Hi3520D and Hi3515A tables) between DDRC_PHY_REG3 (0x804) and DDRC_PHY_REG12 (0x840). 0x40 is the value the vendor boot writes, not a reset value. Field layout unknown (modelled as one 32-bit field). Read on hardware 2026-11-08 (Hi3520D V100, stock U-Boot prompt after a cold boot): 0x00000040, i.e. the value the vendor boot table writes, so this is the boot-table value at the prompt, not a proven reset value (the register exists and is readable).";
        field {
            name = "value";
            desc = "Undocumented: whole register; the vendor boot writes 0x40.";
            sw = rw;
        } value[31:0];
    } DDRC_PHY_UNDOC_0818 @ 0x0818;
`endif

`ifdef DDRC_PHY_UNDOC_0x830_REG
    reg {
        name = "DDR PHY register 0x830 (undocumented)";
        desc = "Undocumented: not in the data sheet. Seen in the vendor boot register table (decoded from the OEM boot image, listed there only as 'DDRC +0x830'): the boot writes 0x00000091 here (Hi3520D and Hi3515A tables) between DDRC_PHY_REG3 (0x804) and DDRC_PHY_REG12 (0x840). 0x91 is the value the vendor boot writes, not a reset value. Field layout unknown (modelled as one 32-bit field). Read on hardware 2026-11-08 (Hi3520D V100, stock U-Boot prompt after a cold boot): 0x00000091, i.e. the value the vendor boot table writes, so this is the boot-table value at the prompt, not a proven reset value (the register exists and is readable).";
        field {
            name = "value";
            desc = "Undocumented: whole register; the vendor boot writes 0x91.";
            sw = rw;
        } value[31:0];
    } DDRC_PHY_UNDOC_0830 @ 0x0830;
`endif

};

`ifdef DDRC_PUB_PIR_REG
regfile eDDRC_PUB_PHY {
    name = "DDR PHY (Synopsys DWC DDR PHY PUB) registers";
    desc = "
        DDR PHY register block of the Hi3518 / Hi3516C generation: the DesignWare DDR PHY utility block (PUB, `DDRC_PUB_*`). The data sheet lists it as a separate block, Table 4-7 'Summary of the DDR PHY registers (base address: 0x2012_0000)' with offsets 0x404.. (`hi3518v100--Hi3518-Datasheet.txt` line 27415; Hi3516C data sheet Table 4-7, `hi3516cv100--Hi3516C-Datasheet.txt` line 21445, identical). The vendor U-Boot agrees: `arch/arm/include/asm/arch-hi3518/platform.h` DDR_PHY_BASE 0x20120000 and `arch/arm/cpu/hi3518/start.S` writes PGCR / PIR / reads PGSR at DDR_PHY_BASE + 0x408 / 0x404 / 0x40C. Instantiate it at 0x20120000, not inside the DDRC window (the registers were wrongly placed at DDRC + 0x404 before).
        The DATX8 registers DXnGCR .. DXnDQSTR (0x5C0 + 0x40 x n, n = 0..1) are described in the data sheet but missing from its summary table. English data sheet only (no Chinese original of the Hi3518 data sheet in the tree); no reset values verified on hardware.
    ";

`ifdef DDRC_PUB_PIR_REG
    reg {
        name = "PHY Initialization Register";
        field {
            name = "initbyp";
            reset = 0x0;
        } initbyp[31:31];

        field {
            name = "zcalbyp";
            reset = 0x0;
        } zcalbyp[30:30];

        field {
            name = "lockbyp";
            reset = 0x0;
        } lockbyp[29:29];

        field {
            name = "clrsr";
            reset = 0x0;
        } clrsr[28:28];

        field {
            name = "ctldinit";
            reset = 0x0;
        } ctldinit[18:18];

        field {
            name = "dllbyp";
            reset = 0x0;
        } dllbyp[17:17];

        field {
            name = "icpc";
            reset = 0x0;
        } icpc[16:16];

        field {
            name = "eyetrn";
            reset = 0x0;
        } eyetrn[8:8];

        field {
            name = "qstrn";
            reset = 0x0;
        } qstrn[7:7];

        field {
            name = "draminit";
            reset = 0x0;
        } draminit[6:6];

        field {
            name = "dramrst";
            reset = 0x0;
        } dramrst[5:5];

        field {
            name = "itmsrst";
            reset = 0x0;
        } itmsrst[4:4];

        field {
            name = "zcal";
            reset = 0x0;
        } zcal[3:3];

        field {
            name = "dlllock";
            reset = 0x0;
        } dlllock[2:2];

        field {
            name = "dllsrst";
            reset = 0x0;
        } dllsrst[1:1];

        field {
            name = "init";
            reset = 0x0;
        } init[0:0];
    } DDRC_PUB_PIR @ 0x0404;
`endif

`ifdef DDRC_PUB_PGCR_REG
    reg {
        name = "PHY General Configuration Register";
        field {
            name = "lbmode";
            reset = 0x0;
        } lbmode[31:31];

        field {
            name = "lbgdqs";
            reset = 0x0;
        } lbgdqs[30:30];

        field {
            name = "lbdqss";
            reset = 0x0;
        } lbdqss[29:29];

        field {
            name = "rfshdt";
            reset = 0x0;
        } rfshdt[28:25];

        field {
            name = "pddisdx";
            reset = 0x1;
        } pddisdx[24:24];

        field {
            name = "zcksel";
            reset = 0x2;
        } zcksel[23:22];

        field {
            name = "ranken";
            reset = 0x1;
        } ranken[21:18];

        field {
            name = "ioddrm";
            reset = 0x0;
        } ioddrm[17:16];

        field {
            name = "iolb";
            reset = 0x0;
        } iolb[15:15];

        field {
            name = "ckinv";
            reset = 0x0;
        } ckinv[14:14];

        field {
            name = "ckdv";
            reset = 0x2;
        } ckdv[13:12];

        field {
            name = "cken";
            reset = 0x7;
        } cken[11:9];

        field {
            name = "dtosel";
            reset = 0x0;
        } dtosel[8:5];

        field {
            name = "dftlmt";
            reset = 0x0;
        } dftlmt[4:3];

        field {
            name = "dftcmp";
            reset = 0x1;
        } dftcmp[2:2];

        field {
            name = "dqscfg";
            reset = 0x0;
        } dqscfg[1:1];

        field {
            name = "itmdmd";
            reset = 0x0;
        } itmdmd[0:0];
    } DDRC_PUB_PGCR @ 0x0408;
`endif

`ifdef DDRC_PUB_PGSR_REG
    reg {
        name = "PHY General Status Register";
        field {
            name = "tq";
            sw = r;
            hw = w;
            reset = 0x0;
        } tq[31:31];

        field {
            name = "dfterr";
            sw = r;
            hw = w;
            reset = 0x0;
        } dfterr[7:7];

        field {
            name = "dtierr";
            sw = r;
            hw = w;
            reset = 0x0;
        } dtierr[6:6];

        field {
            name = "dterr";
            sw = r;
            hw = w;
            reset = 0x0;
        } dterr[5:5];

        field {
            name = "dtdone";
            sw = r;
            hw = w;
            reset = 0x0;
        } dtdone[4:4];

        field {
            name = "didone";
            sw = r;
            hw = w;
            reset = 0x0;
        } didone[3:3];

        field {
            name = "zcdone";
            sw = r;
            hw = w;
            reset = 0x0;
        } zcdone[2:2];

        field {
            name = "dldone";
            sw = r;
            hw = w;
            reset = 0x0;
        } dldone[1:1];

        field {
            name = "idone";
            sw = r;
            hw = w;
            reset = 0x0;
        } idone[0:0];
    } DDRC_PUB_PGSR @ 0x040C;
`endif

`ifdef DDRC_PUB_DLLGCR_REG
    reg {
        name = "DLL General Control Register";
        field {
            name = "dllrsvd2";
            reset = 0x0;
        } dllrsvd2[31:30];

        field {
            name = "lockdet";
            reset = 0x0;
        } lockdet[29:29];

        field {
            name = "dllrsvd1";
            reset = 0x0;
        } dllrsvd1[28:28];

        field {
            name = "sbias";
            reset = 0x37;
        } sbias[27:20];

        field {
            name = "mbias";
            reset = 0x37;
        } mbias[19:12];

        field {
            name = "testsw";
            reset = 0x0;
        } testsw[11:11];

        field {
            name = "atc";
            reset = 0x0;
        } atc[10:9];

        field {
            name = "dtc";
            reset = 0x0;
        } dtc[8:6];

        field {
            name = "testen";
            reset = 0x0;
        } testen[5:5];

        field {
            name = "ipump";
            reset = 0x0;
        } ipump[4:2];

        field {
            name = "dres";
            reset = 0x0;
        } dres[1:0];
    } DDRC_PUB_DLLGCR @ 0x0410;
`endif

`ifdef DDRC_PUB_ACDLLCR_REG
    reg {
        name = "DLL General Control Register";
        field {
            name = "dlldis";
            reset = 0x0;
        } dlldis[31:31];

        field {
            name = "dllsrst";
            reset = 0x1;
        } dllsrst[30:30];

        field {
            name = "sdlbmode";
            reset = 0x0;
        } sdlbmode[19:19];

        field {
            name = "atesten";
            reset = 0x0;
        } atesten[18:18];

        field {
            name = "sdphase";
            reset = 0x0;
        } sdphase[17:14];

        field {
            name = "sstart";
            reset = 0x0;
        } sstart[13:12];

        field {
            name = "mfwdly";
            reset = 0x0;
        } mfwdly[11:9];

        field {
            name = "mfbdly";
            reset = 0x0;
        } mfbdly[8:6];

        field {
            name = "sfwdly";
            reset = 0x0;
        } sfwdly[5:3];

        field {
            name = "sfbdly";
            reset = 0x0;
        } sfbdly[2:0];
    } DDRC_PUB_ACDLLCR @ 0x0414;
`endif

`ifdef DDRC_PUB_PTR0_REG
    reg {
        name = "PHY Timing Register 0";
        field {
            name = "titmsrst";
            reset = 0x8;
        } titmsrst[21:18];

        field {
            name = "tdlllock";
            reset = 0xABE;
        } tdlllock[17:6];

        field {
            name = "tdllsrst";
            reset = 0x1B;
        } tdllsrst[5:0];
    } DDRC_PUB_PTR0 @ 0x0418;
`endif

`ifdef DDRC_PUB_PTR1_REG
    reg {
        name = "PHY Timing Register 1";
        field {
            name = "tdinit1";
            reset = 0xC0;
        } tdinit1[26:19];

        field {
            name = "tdinit0";
            reset = 0x4111D;
        } tdinit0[18:0];
    } DDRC_PUB_PTR1 @ 0x041C;
`endif

`ifdef DDRC_PUB_PTR2_REG
    reg {
        name = "PHY Timing Register 2";
        field {
            name = "tdinit3";
            reset = 0x216;
        } tdinit3[26:17];

        field {
            name = "tdinit2";
            reset = 0x1A072;
        } tdinit2[16:0];
    } DDRC_PUB_PTR2 @ 0x0420;
`endif

`ifdef DDRC_PUB_ACIOCR_REG
    reg {
        name = "AC I/O Configuration Register";
        field {
            name = "acsr";
            sw = r;
            hw = w;
            reset = 0x0;
        } acsr[31:30];

        field {
            name = "rstiom";
            reset = 0x1;
        } rstiom[29:29];

        field {
            name = "rstpdr";
            reset = 0x1;
        } rstpdr[28:28];

        field {
            name = "rstpdd";
            reset = 0x0;
        } rstpdd[27:27];

        field {
            name = "rstodt";
            reset = 0x0;
        } rstodt[26:26];

        field {
            name = "rankpdr";
            reset = 0x1;
        } rankpdr[25:22];

        field {
            name = "cspdd";
            reset = 0x0;
        } cspdd[21:18];

        field {
            name = "rankodt";
            reset = 0x0;
        } rankodt[17:14];

        field {
            name = "ckpdr";
            reset = 0x1;
        } ckpdr[13:11];

        field {
            name = "ckpdd";
            reset = 0x0;
        } ckpdd[10:8];

        field {
            name = "ckodt";
            reset = 0x0;
        } ckodt[7:5];

        field {
            name = "acpdr";
            reset = 0x1;
        } acpdr[4:4];

        field {
            name = "acpdd";
            reset = 0x0;
        } acpdd[3:3];

        field {
            name = "acodt";
            reset = 0x0;
        } acodt[2:2];

        field {
            name = "acoe";
            reset = 0x1;
        } acoe[1:1];

        field {
            name = "aciom";
            reset = 0x0;
        } aciom[0:0];
    } DDRC_PUB_ACIOCR @ 0x0424;
`endif

`ifdef DDRC_PUB_DXCCR_REG
    reg {
        name = "DATX8 Common Configuration Register";
        field {
            name = "dxsr";
            reset = 0x0;
        } dxsr[13:12];

        field {
            name = "dqsnres";
            reset = 0x8;
        } dqsnres[11:8];

        field {
            name = "dqsres";
            reset = 0x0;
        } dqsres[7:4];

        field {
            name = "dxpdr";
            reset = 0x0;
        } dxpdr[3:3];

        field {
            name = "dxpdd";
            reset = 0x0;
        } dxpdd[2:2];

        field {
            name = "dxiom";
            reset = 0x0;
        } dxiom[1:1];

        field {
            name = "dxodt";
            reset = 0x0;
        } dxodt[0:0];
    } DDRC_PUB_DXCCR @ 0x0428;
`endif

`ifdef DDRC_PUB_DSGCR_REG
    reg {
        name = "DDR System General Configuration Register";
        field {
            name = "ckeoe";
            reset = 0x1;
        } ckeoe[31:31];

        field {
            name = "rstoe";
            reset = 0x1;
        } rstoe[30:30];

        field {
            name = "odtoe";
            reset = 0x1;
        } odtoe[29:29];

        field {
            name = "ckoe";
            reset = 0x1;
        } ckoe[28:28];

        field {
            name = "tpdoe";
            reset = 0x1;
        } tpdoe[27:27];

        field {
            name = "tpdpd";
            reset = 0x0;
        } tpdpd[26:26];

        field {
            name = "nl2oe";
            reset = 0x1;
        } nl2oe[25:25];

        field {
            name = "nl2pd";
            reset = 0x0;
        } nl2pd[24:24];

        field {
            name = "odtpdd";
            reset = 0x0;
        } odtpdd[23:20];

        field {
            name = "ckepdd";
            reset = 0x0;
        } ckepdd[19:16];

        field {
            name = "dqsge";
            reset = 0x0;
        } dqsge[10:8];

        field {
            name = "dqsgx";
            reset = 0x0;
        } dqsgx[7:5];

        field {
            name = "lpdllpd";
            reset = 0x1;
        } lpdllpd[4:4];

        field {
            name = "lpiopd";
            reset = 0x1;
        } lpiopd[3:3];

        field {
            name = "zuen";
            reset = 0x1;
        } zuen[2:2];

        field {
            name = "bdisen";
            reset = 0x1;
        } bdisen[1:1];

        field {
            name = "puren";
            reset = 0x1;
        } puren[0:0];
    } DDRC_PUB_DSGCR @ 0x042C;
`endif

`ifdef DDRC_PUB_DCR_REG
    reg {
        name = "DRAM Configuration Register";
        field {
            name = "tpd";
            reset = 0x0;
        } tpd[31:31];

        field {
            name = "rdimm";
            reset = 0x0;
        } rdimm[30:30];

        field {
            name = "udimm";
            reset = 0x0;
        } udimm[29:29];

        field {
            name = "ddr2t";
            reset = 0x0;
        } ddr2t[28:28];

        field {
            name = "nosra";
            reset = 0x0;
        } nosra[27:27];

        field {
            name = "ddrtype";
            reset = 0x0;
        } ddrtype[9:8];

        field {
            name = "mprdq";
            reset = 0x0;
        } mprdq[7:7];

        field {
            name = "pdq";
            reset = 0x0;
        } pdq[6:4];

        field {
            name = "ddr8bnk";
            reset = 0x1;
        } ddr8bnk[3:3];

        field {
            name = "ddrmd";
            reset = 0x3;
        } ddrmd[2:0];
    } DDRC_PUB_DCR @ 0x0430;
`endif

`ifdef DDRC_PUB_DTPR0_REG
    reg {
        name = "DRAM Timing Parameters Register 0";
        field {
            name = "tccd";
            reset = 0x0;
        } tccd[31:31];

        field {
            name = "trc";
            reset = 0x18;
        } trc[30:25];

        field {
            name = "trrd";
            reset = 0x4;
        } trrd[24:21];

        field {
            name = "tras";
            reset = 0x12;
        } tras[20:16];

        field {
            name = "trcd";
            reset = 0x6;
        } trcd[15:12];

        field {
            name = "trp";
            reset = 0x6;
        } trp[11:8];

        field {
            name = "twtr";
            reset = 0x3;
        } twtr[7:5];

        field {
            name = "trtp";
            reset = 0x3;
        } trtp[4:2];

        field {
            name = "tmrd";
            reset = 0x2;
        } tmrd[1:0];
    } DDRC_PUB_DTPR0 @ 0x0434;
`endif

`ifdef DDRC_PUB_DTPR1_REG
    reg {
        name = "DRAM Timing Parameters Register 1";
        field {
            name = "tdqsckmax";
            reset = 0x1;
        } tdqsckmax[29:27];

        field {
            name = "tdqsck";
            reset = 0x1;
        } tdqsck[26:24];

        field {
            name = "trfc";
            reset = 0x83;
        } trfc[23:16];

        field {
            name = "trtodt";
            reset = 0x0;
        } trtodt[11:11];

        field {
            name = "tmod";
            reset = 0x0;
        } tmod[10:9];

        field {
            name = "tfaw";
            reset = 0x12;
        } tfaw[8:3];

        field {
            name = "trtw";
            reset = 0x0;
        } trtw[2:2];

        field {
            name = "taondtaofd";
            reset = 0x0;
        } taondtaofd[1:0];
    } DDRC_PUB_DTPR1 @ 0x0438;
`endif

`ifdef DDRC_PUB_DTPR2_REG
    reg {
        name = "DRAM Timing Parameters Register 2";
        field {
            name = "tdllk";
            reset = 0x200;
        } tdllk[28:19];

        field {
            name = "tcke";
            reset = 0x3;
        } tcke[18:15];

        field {
            name = "txp";
            reset = 0x8;
        } txp[14:10];

        field {
            name = "txs";
            reset = 0xC8;
        } txs[9:0];
    } DDRC_PUB_DTPR2 @ 0x043C;
`endif

`ifdef DDRC_PUB_MR0_REG
    reg {
        name = "Mode Register 0";
        field {
            name = "mr0";
            reset = 0xA52;
        } mr0[15:0];
    } DDRC_PUB_MR0 @ 0x0440;
`endif

`ifdef DDRC_PUB_MR1_REG
    reg {
        name = "Mode Register 1";
        field {
            name = "mr1";
            reset = 0x0;
        } mr1[15:0];
    } DDRC_PUB_MR1 @ 0x0444;
`endif

`ifdef DDRC_PUB_MR2_REG
    reg {
        name = "Mode Register 2";
        field {
            name = "mr2";
            reset = 0x0;
        } mr2[15:0];
    } DDRC_PUB_MR2 @ 0x0448;
`endif

`ifdef DDRC_PUB_MR3_REG
    reg {
        name = "Mode Register 3";
        field {
            name = "mr3";
            reset = 0x0;
        } mr3[15:0];
    } DDRC_PUB_MR3 @ 0x044C;
`endif

`ifdef DDRC_PUB_ODTCR_REG
    reg {
        name = "ODT Configuration Register";
        field {
            name = "wrodt3";
            reset = 0x0;
        } wrodt3[31:28];

        field {
            name = "wrodt2";
            reset = 0x0;
        } wrodt2[27:24];

        field {
            name = "wrodt1";
            reset = 0x0;
        } wrodt1[23:20];

        field {
            name = "wrodt0";
            reset = 0x1;
        } wrodt0[19:16];

        field {
            name = "rdodt3";
            reset = 0x0;
        } rdodt3[15:12];

        field {
            name = "rdodt2";
            reset = 0x0;
        } rdodt2[11:8];

        field {
            name = "rdodt1";
            reset = 0x0;
        } rdodt1[7:4];

        field {
            name = "rdodt0";
            reset = 0x0;
        } rdodt0[3:0];
    } DDRC_PUB_ODTCR @ 0x0450;
`endif

`ifdef DDRC_PUB_DTAR_REG
    reg {
        name = "Data Training Address Register";
        field {
            name = "dtmpr";
            reset = 0x0;
        } dtmpr[31:31];

        field {
            name = "dtbank";
            reset = 0x0;
        } dtbank[30:28];

        field {
            name = "dtrow";
            reset = 0x0;
        } dtrow[27:12];

        field {
            name = "dtcol";
            reset = 0x0;
        } dtcol[11:0];
    } DDRC_PUB_DTAR @ 0x0454;
`endif

`ifdef DDRC_PUB_DTDR0_REG
    reg {
        name = "Data Training Register 0";
        field {
            name = "dtbyte3";
            reset = 0xDD;
        } dtbyte3[31:24];

        field {
            name = "dtbyte2";
            reset = 0x22;
        } dtbyte2[23:16];

        field {
            name = "dtbyte1";
            reset = 0xEE;
        } dtbyte1[15:8];

        field {
            name = "dtbyte0";
            reset = 0x11;
        } dtbyte0[7:0];
    } DDRC_PUB_DTDR0 @ 0x0458;
`endif

`ifdef DDRC_PUB_DTDR1_REG
    reg {
        name = "Data Training Register 1";
        field {
            name = "dtbyte7";
            reset = 0x77;
        } dtbyte7[31:24];

        field {
            name = "dtbyte6";
            reset = 0x88;
        } dtbyte6[23:16];

        field {
            name = "dtbyte5";
            reset = 0xBB;
        } dtbyte5[15:8];

        field {
            name = "dtbyte4";
            reset = 0x44;
        } dtbyte4[7:0];
    } DDRC_PUB_DTDR1 @ 0x045C;
`endif

`ifdef DDRC_PUB_ZQ_CTRL0_REG
    reg {
        name = "PUB DDR PHY I/O Compensation Configuration Register 0";
        field {
            name = "zqpd";
            reset = 0x0;
        } zqpd[31:31];

        field {
            name = "zcal";
            reset = 0x0;
        } zcal[30:30];

        field {
            name = "zcalbyp";
            reset = 0x0;
        } zcalbyp[29:29];

        field {
            name = "zden";
            reset = 0x0;
        } zden[28:28];

        field {
            name = "zdata";
            reset = 0x14A;
        } zdata[27:0];
    } DDRC_PUB_ZQ_CTRL0 @ 0x0580;
`endif

`ifdef DDRC_PUB_ZQ_CTRL1_REG
    reg {
        name = "PUB DDR PHY I/O Compensation Configuration Register 1";
        field {
            name = "zprog_odt";
            reset = 0x7;
        } zprog_odt[7:4];

        field {
            name = "zprog_drv";
            reset = 0xB;
        } zprog_drv[3:0];
    } DDRC_PUB_ZQ_CTRL1 @ 0x0584;
`endif

`ifdef DDRC_PUB_ZQ_STATUS0_REG
    reg {
        name = "PUB DDR PHY I/O Compensation Status Register 0";
        field {
            name = "zdone";
            sw = r;
            hw = w;
            reset = 0x0;
        } zdone[31:31];

        field {
            name = "zerr";
            sw = r;
            hw = w;
            reset = 0x0;
        } zerr[30:30];

        field {
            name = "zctrl";
            sw = r;
            hw = w;
            reset = 0x0;
        } zctrl[27:0];
    } DDRC_PUB_ZQ_STATUS0 @ 0x0588;
`endif

`ifdef DDRC_PUB_ZQ_STATUS1_REG
    reg {
        name = "PUB DDR PHY I/O Compensation Status Register 1";
        field {
            name = "opu";
            sw = r;
            hw = w;
            reset = 0x0;
        } opu[7:6];

        field {
            name = "opd";
            sw = r;
            hw = w;
            reset = 0x0;
        } opd[5:4];

        field {
            name = "zpu";
            sw = r;
            hw = w;
            reset = 0x0;
        } zpu[3:2];

        field {
            name = "zpd";
            sw = r;
            hw = w;
            reset = 0x0;
        } zpd[1:0];
    } DDRC_PUB_ZQ_STATUS1 @ 0x058C;
`endif

`ifdef DDRC_PUB_DXNGCR_REG
    regfile {
        name = "DATX8 (data byte lane) registers";
        desc = "One register set per data byte lane, blanes = 0..1, at 0x5C0 + 0x40 x blanes (data sheet offsets 0x5C0 + 0x40 x blanes .. 0x5D4 + 0x40 x blanes).";

`ifdef DDRC_PUB_DXNGCR_REG
        reg {
            name = "DATX8 general configuration register";
            desc = "One register per data byte lane, blanes = 0..1 (0x5C0 + 0x40 x blanes). Hi3518 data sheet 4.1.6 DDRC_PUB_DXNGCR (`hi3518v100--Hi3518-Datasheet.txt` line 31136, total reset 0x0000_0E81; not in the summary table 4-7). Bits [31:14] reserved (RW).";

            enum DDRC_PUB_DXNGCR_rttoal_enum {
                TWO_CYCLES = 0x0 { desc = "ODT control is set to DQSODT/DQODT almost two cycles before the read data preamble."; };
                ONE_CYCLE  = 0x1 { desc = "ODT control is set to DQSODT/DQODT almost one cycle before the read data preamble."; };
            };

            field {
                name = "rttoal";
                desc = "RTT on additive latency: when the ODT control of the DQ/DQS SSTL I/Os is set to the value in DQODT/DQSODT during read cycles.";
                encode = DDRC_PUB_DXNGCR_rttoal_enum;
                reset = 0x0;
            } rttoal[13:13];

            field {
                name = "rttoh";
                desc = "RTT output hold: number of clock cycles (0-3) after the read data postamble during which the ODT control retains DQSODT for DQS or DQODT for DQ/DM before it is disabled, when dynamic ODT control is used.";
                reset = 0x1;
            } rttoh[12:11];

            field {
                name = "dqrtt";
                desc = "DQ dynamic RTT control. 1: the ODT control of the DQ/DM SSTL I/Os is set to DQODT during reads and 0 in any other cycle; 0: always DQODT.";
                reset = 0x1;
            } dqrtt[10:10];

            field {
                name = "dqsrtt";
                desc = "DQS dynamic RTT control. 1: the ODT control of the DQS SSTL I/Os is set to DQSODT during reads and 0 in any other cycle; 0: always DQSODT.";
                reset = 0x1;
            } dqsrtt[9:9];

            enum DDRC_PUB_DXNGCR_dsen_enum {
                DISABLED_LOW  = 0x0 { desc = "DQS disabled (driven to constant 0)"; };
                INVERTED      = 0x1 { desc = "DQS toggling with inverted polarity"; };
                NORMAL        = 0x2 { desc = "DQS toggling with normal polarity (default)"; };
                DISABLED_HIGH = 0x3 { desc = "DQS disabled (driven to constant 1)"; };
            };

            field {
                name = "dsen";
                desc = "Write DQS enable: whether the write DQS going to the SDRAM toggles or is static, and whether it is inverted (DQS# is always the inversion of DQS). Valid only when the DQS/DQS# output enable is on, otherwise DQS/DQS# is tristated.";
                encode = DDRC_PUB_DXNGCR_dsen_enum;
                reset = 0x1;
            } dsen[8:7];

            field {
                name = "dqsrpd";
                desc = "DQSR power down: when set, the PDQSR cell is powered down.";
                reset = 0x0;
            } dqsrpd[6:6];

            field {
                name = "dxpdr";
                desc = "Data power down receiver: when set, the input receiver on the DQ, DM and DQS/DQS# pins of the byte is powered down.";
                reset = 0x0;
            } dxpdr[5:5];

            field {
                name = "dxpdd";
                desc = "Data power down driver: when set, the output driver on the DQ, DM and DQS/DQS# pins of the byte is powered down.";
                reset = 0x0;
            } dxpdd[4:4];

            enum DDRC_PUB_DXNGCR_dxiom_enum {
                SSTL = 0x0 { desc = "SSTL mode"; };
                CMOS = 0x1 { desc = "CMOS mode"; };
            };

            field {
                name = "dxiom";
                desc = "Data I/O mode of the DQ, DM and DQS/DQS# pins of the byte.";
                encode = DDRC_PUB_DXNGCR_dxiom_enum;
                reset = 0x0;
            } dxiom[3:3];

            field {
                name = "dqodt";
                desc = "Data on-die termination: when set, the on-die termination is enabled on the DQ and DM pins of the byte.";
                reset = 0x0;
            } dqodt[2:2];

            field {
                name = "dqsodt";
                desc = "DQS on-die termination: when set, the on-die termination is enabled on the DQS/DQS# pins of the byte.";
                reset = 0x0;
            } dqsodt[1:1];

            field {
                name = "dxen";
                desc = "Data byte enable: when set, the DATX8 and the SSTL I/Os of the data byte are enabled. 0 disables the byte (its SSTL I/Os enter power-down and the DATX8 DLL enters bypass mode).";
                reset = 0x1;
            } dxen[0:0];

        } DDRC_PUB_DXNGCR @ 0x0;
`endif

`ifdef DDRC_PUB_DXNGSR0_REG
        reg {
            name = "DATX8 general status register 0";
            desc = "One register per data byte lane, blanes = 0..1 (0x5C4 + 0x40 x blanes). Hi3518 data sheet 4.1.6 DDRC_PUB_DXNGSR0 (`hi3518v100--Hi3518-Datasheet.txt` line 31243, total reset 0x0000_0000). Bits [31:25] and 12 reserved.";

            field {
                name = "dtpass";
                desc = "Data training pass count: number of passing configurations during DQS gate training. Bits [2:0] are rank 0, [5:3] rank 1, and so on.";
                sw = r;
                hw = w;
                reset = 0x0;
            } dtpass[24:13];

            field {
                name = "dtierr";
                desc = "Data training intermittent error (a pass followed by a failure and another pass) during data training of the byte; bit n is rank n.";
                sw = r;
                hw = w;
                reset = 0x0;
            } dtierr[11:8];

            field {
                name = "dterr";
                desc = "Data training error: no valid DQS gating window could be found during data training of the byte; bit n is rank n.";
                sw = r;
                hw = w;
                reset = 0x0;
            } dterr[7:4];

            field {
                name = "dtdone";
                desc = "Data training done for the byte; bit n is rank n.";
                sw = r;
                hw = w;
                reset = 0x0;
            } dtdone[3:0];

        } DDRC_PUB_DXNGSR0 @ 0x4;
`endif

`ifdef DDRC_PUB_DXNGSR1_REG
        reg {
            name = "DATX8 general status register 1";
            desc = "One register per data byte lane, blanes = 0..1 (0x5C8 + 0x40 x blanes). Hi3518 data sheet 4.1.6 DDRC_PUB_DXNGSR1 (`hi3518v100--Hi3518-Datasheet.txt` line 31286, total reset 0x0000_0000). Bits [31:12] reserved.";

            field {
                name = "dqsdft";
                desc = "DQS drift of the read data strobe of the byte, two bits per rank ([1:0] rank 0, [3:2] rank 1, ...): 00 no drift, 01 90 degree drift, 10 180 degree drift, 11 270 degree drift or more.";
                sw = r;
                hw = w;
                reset = 0x0;
            } dqsdft[11:4];

            field {
                name = "dfterr";
                desc = "DQS drift error: the read data strobe of the byte has drifted by at least the drift limit configured in PGCR; bit n is rank n.";
                sw = r;
                hw = w;
                reset = 0x0;
            } dfterr[3:0];

        } DDRC_PUB_DXNGSR1 @ 0x8;
`endif

`ifdef DDRC_PUB_DXNDLLCR_REG
        reg {
            name = "DATX8 DLL control register";
            desc = "One register per data byte lane, blanes = 0..1 (0x5CC + 0x40 x blanes). Hi3518 data sheet 4.1.6 DDRC_PUB_DXNDLLCR (`hi3518v100--Hi3518-Datasheet.txt` line 31331, total reset 0x4000_0000). Bits [29:20] reserved.";

            field {
                name = "dlldis";
                desc = "DLL disable: a disabled DLL is bypassed (0 = DLL enabled).";
                reset = 0x0;
            } dlldis[31:31];

            field {
                name = "dllsrst";
                desc = "DLL soft reset: soft-resets the byte DLL by driving its soft reset pin.";
                reset = 0x1;
            } dllsrst[30:30];

            field {
                name = "sdlbmode";
                desc = "Slave DLL loopback mode: no 90 degree phase shift on the read DQS/DQS#; must be set when the byte PHYs operate in loopback mode (e.g. BIST loopback). Only for PHYs with this feature.";
                reset = 0x0;
            } sdlbmode[19:19];

            field {
                name = "atesten";
                desc = "Analog test enable: outputs the analog test signal on the DLL analog test output (test_out_a), tristated when 0.";
                reset = 0x0;
            } atesten[18:18];

            enum DDRC_PUB_DXNDLLCR_sdphase_enum {
                DEG_90_0  = 0x0 { desc = "90"; };
                DEG_72_0  = 0x1 { desc = "72"; };
                DEG_54_0  = 0x2 { desc = "54"; };
                DEG_36    = 0x3 { desc = "36"; };
                DEG_108_0 = 0x4 { desc = "108"; };
                DEG_90_1  = 0x5 { desc = "90"; };
                DEG_72_1  = 0x6 { desc = "72"; };
                DEG_54_1  = 0x7 { desc = "54"; };
                DEG_126_0 = 0x8 { desc = "126"; };
                DEG_108_1 = 0x9 { desc = "108"; };
                DEG_90_2  = 0xA { desc = "90"; };
                DEG_72_2  = 0xB { desc = "72"; };
                DEG_144   = 0xC { desc = "144"; };
                DEG_126_1 = 0xD { desc = "126"; };
                DEG_108_2 = 0xE { desc = "108"; };
                DEG_90_3  = 0xF { desc = "90"; };
            };

            field {
                name = "sdphase";
                desc = "Slave DLL phase trim: phase difference (degrees) between the input clock and the corresponding output clock of the slave DLL.";
                encode = DDRC_PUB_DXNDLLCR_sdphase_enum;
                reset = 0x0;
            } sdphase[17:14];

            field {
                name = "sstart";
                desc = "Slave auto startup: 0x: the slave DLL starts automatically once the master DLL is locked; 10: automatic startup disabled, phase detector disabled; 11: automatic startup disabled, phase detector enabled.";
                reset = 0x0;
            } sstart[13:12];

            field {
                name = "mfwdly";
                desc = "Master feed-forward delay trim (000 minimum ... 111 maximum delay).";
                reset = 0x0;
            } mfwdly[11:9];

            field {
                name = "mfbdly";
                desc = "Master feedback delay trim (000 minimum ... 111 maximum delay).";
                reset = 0x0;
            } mfbdly[8:6];

            field {
                name = "sfwdly";
                desc = "Slave feed-forward delay trim (000 minimum ... 111 maximum delay).";
                reset = 0x0;
            } sfwdly[5:3];

            field {
                name = "sfbdly";
                desc = "Slave feedback delay trim (000 minimum ... 111 maximum delay).";
                reset = 0x0;
            } sfbdly[2:0];

        } DDRC_PUB_DXNDLLCR @ 0xC;
`endif

`ifdef DDRC_PUB_DXNDQTR_REG
        reg {
            name = "DATX8 DQ timing register";
            desc = "One register per data byte lane, blanes = 0..1 (0x5D0 + 0x40 x blanes). Hi3518 data sheet 4.1.6 DDRC_PUB_DXNDQTR (`hi3518v100--Hi3518-Datasheet.txt` line 31441, total reset 0xFFFF_FFFF). Each 4-bit dqdlyN field delays data bit N of the byte relative to the nominal delay that matches the data strobes through the slave DLL and clock tree: the low two bits delay the data clocked by DQS, the high two bits the data clocked by DQS#, each 00 nominal, 01 +1 step, 10 +2 steps, 11 +3 steps (step size per the DWC DDR PHY data book).";

            field {
                name = "dqdly7";
                desc = "DQ7 delay.";
                reset = 0xF;
            } dqdly7[31:28];

            field {
                name = "dqdly6";
                desc = "DQ6 delay.";
                reset = 0xF;
            } dqdly6[27:24];

            field {
                name = "dqdly5";
                desc = "DQ5 delay.";
                reset = 0xF;
            } dqdly5[23:20];

            field {
                name = "dqdly4";
                desc = "DQ4 delay.";
                reset = 0xF;
            } dqdly4[19:16];

            field {
                name = "dqdly3";
                desc = "DQ3 delay.";
                reset = 0xF;
            } dqdly3[15:12];

            field {
                name = "dqdly2";
                desc = "DQ2 delay.";
                reset = 0xF;
            } dqdly2[11:8];

            field {
                name = "dqdly1";
                desc = "DQ1 delay.";
                reset = 0xF;
            } dqdly1[7:4];

            field {
                name = "dqdly0";
                desc = "DQ0 delay.";
                reset = 0xF;
            } dqdly0[3:0];

        } DDRC_PUB_DXNDQTR @ 0x10;
`endif

`ifdef DDRC_PUB_DXNDQSTR_REG
        reg {
            name = "DATX8 DQS timing register";
            desc = "One register per data byte lane, blanes = 0..1 (0x5D4 + 0x40 x blanes). Hi3518 data sheet 4.1.6 DDRC_PUB_DXNDQSTR (`hi3518v100--Hi3518-Datasheet.txt` line 31508, total reset 0x3DB0_1000). Bits [31:30] reserved. The rank 1-3 fields are present but the Hi3518 supports one rank only (data sheet note).";

            field {
                name = "dmdly";
                desc = "DM delay relative to the nominal delay matching the data strobes: low two bits for data clocked by DQS, high two bits for data clocked by DQS#, each 00 nominal, 01 +1 step, 10 +2 steps, 11 +3 steps.";
                reset = 0xF;
            } dmdly[29:26];

            enum DDRC_PUB_DXNDQSTR_dqsdly_enum {
                MINUS_3 = 0x0 { desc = "nominal delay - 3 steps"; };
                MINUS_2 = 0x1 { desc = "nominal delay - 2 steps"; };
                MINUS_1 = 0x2 { desc = "nominal delay - 1 step"; };
                NOMINAL = 0x3 { desc = "nominal delay"; };
                PLUS_1  = 0x4 { desc = "nominal delay + 1 step"; };
                PLUS_2  = 0x5 { desc = "nominal delay + 2 steps"; };
                PLUS_3  = 0x6 { desc = "nominal delay + 3 steps"; };
                PLUS_4  = 0x7 { desc = "nominal delay + 4 steps"; };
            };

            field {
                name = "dqsndly";
                desc = "DQS# delay relative to the nominal delay matching the data bits through the slave DLL and clock tree.";
                encode = DDRC_PUB_DXNDQSTR_dqsdly_enum;
                reset = 0x3;
            } dqsndly[25:23];

            field {
                name = "dqsdly";
                desc = "DQS delay relative to the nominal delay matching the data bits through the slave DLL and clock tree.";
                encode = DDRC_PUB_DXNDQSTR_dqsdly_enum;
                reset = 0x3;
            } dqsdly[22:20];

            enum DDRC_PUB_DXNDQSTR_dgps_enum {
                CLK90  = 0x0 { desc = "90 degree clock (clk90)"; };
                CLK180 = 0x1 { desc = "180 degree clock (clk180)"; };
                CLK270 = 0x2 { desc = "270 degree clock (clk270)"; };
                CLK0   = 0x3 { desc = "360 degree clock (clk0)"; };
            };

            field {
                name = "r3dgps";
                desc = "Rank 3 DQS gating phase select: the clock used to enable the data strobes during reads so that the strobe values around the preamble/postamble are filtered out. Set by the PUBL during automatic DQS data training and updated by the drift compensation (unless disabled in PGCR); can be overwritten by software. The actual reset value depends on the configured number of ranks; the Hi3518 does not support this rank.";
                encode = DDRC_PUB_DXNDQSTR_dgps_enum;
                reset = 0x0;
            } r3dgps[19:18];

            field {
                name = "r2dgps";
                desc = "Rank 2 DQS gating phase select: the clock used to enable the data strobes during reads so that the strobe values around the preamble/postamble are filtered out. Set by the PUBL during automatic DQS data training and updated by the drift compensation (unless disabled in PGCR); can be overwritten by software. The actual reset value depends on the configured number of ranks; the Hi3518 does not support this rank.";
                encode = DDRC_PUB_DXNDQSTR_dgps_enum;
                reset = 0x0;
            } r2dgps[17:16];

            field {
                name = "r1dgps";
                desc = "Rank 1 DQS gating phase select: the clock used to enable the data strobes during reads so that the strobe values around the preamble/postamble are filtered out. Set by the PUBL during automatic DQS data training and updated by the drift compensation (unless disabled in PGCR); can be overwritten by software. The actual reset value depends on the configured number of ranks; the Hi3518 does not support this rank.";
                encode = DDRC_PUB_DXNDQSTR_dgps_enum;
                reset = 0x0;
            } r1dgps[15:14];

            field {
                name = "r0dgps";
                desc = "Rank 0 DQS gating phase select: the clock used to enable the data strobes during reads so that the strobe values around the preamble/postamble are filtered out. Set by the PUBL during automatic DQS data training and updated by the drift compensation (unless disabled in PGCR); can be overwritten by software.";
                encode = DDRC_PUB_DXNDQSTR_dgps_enum;
                reset = 0x1;
            } r0dgps[13:12];

            enum DDRC_PUB_DXNDQSTR_dgsl_enum {
                EXTRA_0 = 0x0 { desc = "no extra clock cycles"; };
                EXTRA_1 = 0x1 { desc = "1 extra clock cycle"; };
                EXTRA_2 = 0x2 { desc = "2 extra clock cycles"; };
                EXTRA_3 = 0x3 { desc = "3 extra clock cycles"; };
                EXTRA_4 = 0x4 { desc = "4 extra clock cycles"; };
                EXTRA_5 = 0x5 { desc = "5 extra clock cycles"; };
            };

            field {
                name = "r3dgsl";
                desc = "Rank 3 DQS gating system latency: extra clock cycles (at most five) before valid DDR read data, compensating board and system delays. Set by the PUBL during automatic DQS data training; can be overwritten by software. Values 6 and 7 are reserved. The actual reset value depends on the configured number of ranks; the Hi3518 does not support this rank.";
                encode = DDRC_PUB_DXNDQSTR_dgsl_enum;
                reset = 0x0;
            } r3dgsl[11:9];

            field {
                name = "r2dgsl";
                desc = "Rank 2 DQS gating system latency: extra clock cycles (at most five) before valid DDR read data, compensating board and system delays. Set by the PUBL during automatic DQS data training; can be overwritten by software. Values 6 and 7 are reserved. The actual reset value depends on the configured number of ranks; the Hi3518 does not support this rank.";
                encode = DDRC_PUB_DXNDQSTR_dgsl_enum;
                reset = 0x0;
            } r2dgsl[8:6];

            field {
                name = "r1dgsl";
                desc = "Rank 1 DQS gating system latency: extra clock cycles (at most five) before valid DDR read data, compensating board and system delays. Set by the PUBL during automatic DQS data training; can be overwritten by software. Values 6 and 7 are reserved. The actual reset value depends on the configured number of ranks; the Hi3518 does not support this rank.";
                encode = DDRC_PUB_DXNDQSTR_dgsl_enum;
                reset = 0x0;
            } r1dgsl[5:3];

            field {
                name = "r0dgsl";
                desc = "Rank 0 DQS gating system latency: extra clock cycles (at most five) before valid DDR read data, compensating board and system delays. Set by the PUBL during automatic DQS data training; can be overwritten by software. Values 6 and 7 are reserved.";
                encode = DDRC_PUB_DXNDQSTR_dgsl_enum;
                reset = 0x0;
            } r0dgsl[2:0];

        } DDRC_PUB_DXNDQSTR @ 0x14;
`endif

    } DDRC_PUB_DX[2] @ 0x05C0 += 0x40;
`endif

};
`endif

`endif
