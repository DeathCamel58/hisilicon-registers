`ifndef HISI_VDP_3516V100_RDL
`define HISI_VDP_3516V100_RDL


regfile eHISI_VDP_3516V100 {
    name = "VDP (video display processor, Hi3516 V100)";
    desc = "Video display processor (VDP) of the Hi3516 V100 at 0x20640000 (64 KB, data sheet chapter 8.2; VOU interrupt 52 in the data sheet interrupt table). Registers are named VDP*, VHD* (HD video layer), VSD*, G0..G* (graphics layers), DHD0 and DAC/interface registers; same vocabulary as the Hi3520D `eHISI_VDP` but every layer base is moved (see docs/rdl-campaign/m-cells-2026-11-15.md). The data sheet of this chip is Chinese-only: this block transcribes register offsets, names, bit ranges, access types and reset values from the data sheet register tables; the Chinese description text and value encodings were NOT translated, so every description here is generated from the register or field name. Generated 2026-11-15 by scripts/rdl-extract/gen_m_cells.py from the data sheet register tables (ds_extract2 + description extraction from the PDF); PROVENANCE: PROVEN = offsets, names, bit fields, access and reset values from the data sheet tables; nothing here is hardware verified.

    Register sources: 201 registers from the data sheet (hi3516v100--Hi3516-Datasheet.txt, section 8.2.5). ";

    reg {
        name = "VDPCTRL";
        desc = "Data sheet 8.2.5 VDPCTRL (offset 0x0, printed page 8-211, `hi3516v100--Hi3516-Datasheet.txt` line 47591).";

        field {
            name = "vdp_ck_gt_en";
            desc = "Vdp ck gt enable. Chinese-only data sheet: description and value encoding not translated.";
            sw = rw;
            hw = r;
            reset = 0x0;
        } vdp_ck_gt_en[31:31];

        field {
            name = "bus_dbg_en";
            desc = "Bus dbg enable. Chinese-only data sheet: description and value encoding not translated.";
            sw = rw;
            hw = r;
            reset = 0x0;
        } bus_dbg_en[21:20];

        field {
            name = "outstd_wid0";
            desc = "Outstd wid0. Chinese-only data sheet: description and value encoding not translated.";
            sw = rw;
            hw = r;
            reset = 0x0;
        } outstd_wid0[19:16];

        field {
            name = "vdp_id_sel";
            desc = "Vdp id select. Chinese-only data sheet: description and value encoding not translated.";
            sw = rw;
            hw = r;
            reset = 0x0;
        } vdp_id_sel[12:12];

        field {
            name = "outstd_rid0";
            desc = "Outstd rid0. Chinese-only data sheet: description and value encoding not translated.";
            sw = rw;
            hw = r;
            reset = 0x0;
        } outstd_rid0[11:8];

        field {
            name = "arb_mode";
            desc = "Arb mode. Chinese-only data sheet: description and value encoding not translated.";
            sw = rw;
            hw = r;
            reset = 0x0;
        } arb_mode[3:0];
    } VDPCTRL @ 0x0;

    reg {
        name = "VDPINTSTA";
        desc = "Data sheet 8.2.5 VDPINTSTA (offset 0x4, printed page 8-212, `hi3516v100--Hi3516-Datasheet.txt` line 47660).";

        field {
            name = "g1rr_int";
            desc = "G1rr interrupt. Chinese-only data sheet: description and value encoding not translated.";
            sw = r;
            hw = w;
            reset = 0x0;
        } g1rr_int[24:24];

        field {
            name = "g0rr_int";
            desc = "G0rr interrupt. Chinese-only data sheet: description and value encoding not translated.";
            sw = r;
            hw = w;
            reset = 0x0;
        } g0rr_int[23:23];

        field {
            name = "vhdrr_int";
            desc = "Vhdrr interrupt. Chinese-only data sheet: description and value encoding not translated.";
            sw = r;
            hw = w;
            reset = 0x0;
        } vhdrr_int[22:22];

        field {
            name = "vsdrr_int";
            desc = "Vsdrr interrupt. Chinese-only data sheet: description and value encoding not translated.";
            sw = r;
            hw = w;
            reset = 0x0;
        } vsdrr_int[20:20];

        field {
            name = "dhduf_int";
            desc = "Dhduf interrupt. Chinese-only data sheet: description and value encoding not translated.";
            sw = r;
            hw = w;
            reset = 0x0;
        } dhduf_int[7:7];

        field {
            name = "dhdvtthd1_int";
            desc = "Dhdvtthd1 interrupt. Chinese-only data sheet: description and value encoding not translated.";
            sw = r;
            hw = w;
            reset = 0x0;
        } dhdvtthd1_int[4:4];

        field {
            name = "dsduf_int";
            desc = "Dsduf interrupt. Chinese-only data sheet: description and value encoding not translated.";
            sw = r;
            hw = w;
            reset = 0x0;
        } dsduf_int[3:3];

        field {
            name = "dsdvtthd1_int";
            desc = "Dsdvtthd1 interrupt. Chinese-only data sheet: description and value encoding not translated.";
            sw = r;
            hw = w;
            reset = 0x0;
        } dsdvtthd1_int[0:0];
    } VDPINTSTA @ 0x4;

    reg {
        name = "VDPMSKINTSTA";
        desc = "Data sheet 8.2.5 VDPMSKINTSTA (offset 0x8, printed page 8-213, `hi3516v100--Hi3516-Datasheet.txt` line 47722).";

        field {
            name = "be_int";
            desc = "Be interrupt. Chinese-only data sheet: description and value encoding not translated.";
            sw = rw;
            hw = w;
            onread = rclr;
            reset = 0x0;
        } be_int[31:31];

        field {
            name = "ut_end_int";
            desc = "Ut end interrupt. Chinese-only data sheet: description and value encoding not translated.";
            sw = rw;
            hw = w;
            onread = rclr;
            reset = 0x0;
        } ut_end_int[30:30];

        field {
            name = "vhd_regup_err_int";
            desc = "Vhd regup error interrupt. Chinese-only data sheet: description and value encoding not translated.";
            sw = rw;
            hw = w;
            onread = rclr;
            reset = 0x0;
        } vhd_regup_err_int[28:28];

        field {
            name = "g1rr_int";
            desc = "G1rr interrupt. Chinese-only data sheet: description and value encoding not translated.";
            sw = rw;
            hw = w;
            onread = rclr;
            reset = 0x0;
        } g1rr_int[24:24];

        field {
            name = "g0rr_int";
            desc = "G0rr interrupt. Chinese-only data sheet: description and value encoding not translated.";
            sw = rw;
            hw = w;
            onread = rclr;
            reset = 0x0;
        } g0rr_int[23:23];

        field {
            name = "vhdrr_int";
            desc = "Vhdrr interrupt. Chinese-only data sheet: description and value encoding not translated.";
            sw = rw;
            hw = w;
            onread = rclr;
            reset = 0x0;
        } vhdrr_int[22:22];

        field {
            name = "vte_int";
            desc = "Vertical timing end interrupt. Chinese-only data sheet: description and value encoding not translated.";
            sw = rw;
            hw = w;
            onread = rclr;
            reset = 0x0;
        } vte_int[9:9];

        field {
            name = "dhduf_int";
            desc = "Dhduf interrupt. Chinese-only data sheet: description and value encoding not translated.";
            sw = rw;
            hw = w;
            onread = rclr;
            reset = 0x0;
        } dhduf_int[7:7];

        field {
            name = "dhdvtthd1_int";
            desc = "Dhdvtthd1 interrupt. Chinese-only data sheet: description and value encoding not translated.";
            sw = rw;
            hw = w;
            onread = rclr;
            reset = 0x0;
        } dhdvtthd1_int[4:4];

        field {
            name = "dsduf_int";
            desc = "Dsduf interrupt. Chinese-only data sheet: description and value encoding not translated.";
            sw = rw;
            hw = w;
            onread = rclr;
            reset = 0x0;
        } dsduf_int[3:3];

        field {
            name = "dsdvtthd1_int";
            desc = "Dsdvtthd1 interrupt. Chinese-only data sheet: description and value encoding not translated.";
            sw = rw;
            hw = w;
            onread = rclr;
            reset = 0x0;
        } dsdvtthd1_int[0:0];
    } VDPMSKINTSTA @ 0x8;

    reg {
        name = "VDPINTMSK";
        desc = "Data sheet 8.2.5 VDPINTMSK (offset 0xC, printed page 8-214, `hi3516v100--Hi3516-Datasheet.txt` line 47792).";

        field {
            name = "be_intmsk";
            desc = "Be interrupt mask. Chinese-only data sheet: description and value encoding not translated.";
            sw = rw;
            hw = r;
            reset = 0x0;
        } be_intmsk[31:31];

        field {
            name = "ut_end_intmsk";
            desc = "Ut end interrupt mask. Chinese-only data sheet: description and value encoding not translated.";
            sw = rw;
            hw = r;
            reset = 0x0;
        } ut_end_intmsk[30:30];

        field {
            name = "vhd_regup_err_intmsk";
            desc = "Vhd regup error interrupt mask. Chinese-only data sheet: description and value encoding not translated.";
            sw = rw;
            hw = w;
            onread = rclr;
            reset = 0x0;
        } vhd_regup_err_intmsk[28:28];

        field {
            name = "g1rr_intmsk";
            desc = "G1rr interrupt mask. Chinese-only data sheet: description and value encoding not translated.";
            sw = rw;
            hw = r;
            reset = 0x0;
        } g1rr_intmsk[24:24];

        field {
            name = "g0rr_intmsk";
            desc = "G0rr interrupt mask. Chinese-only data sheet: description and value encoding not translated.";
            sw = rw;
            hw = r;
            reset = 0x0;
        } g0rr_intmsk[23:23];

        field {
            name = "vhdrr_intmsk";
            desc = "Vhdrr interrupt mask. Chinese-only data sheet: description and value encoding not translated.";
            sw = rw;
            hw = r;
            reset = 0x0;
        } vhdrr_intmsk[22:22];

        field {
            name = "vsdrr_intmsk";
            desc = "Vsdrr interrupt mask. Chinese-only data sheet: description and value encoding not translated.";
            sw = rw;
            hw = r;
            reset = 0x0;
        } vsdrr_intmsk[20:20];

        field {
            name = "vte_intmsk";
            desc = "Vertical timing end interrupt mask. Chinese-only data sheet: description and value encoding not translated.";
            sw = rw;
            hw = r;
            reset = 0x0;
        } vte_intmsk[9:9];

        field {
            name = "dhduf_intmsk";
            desc = "Dhduf interrupt mask. Chinese-only data sheet: description and value encoding not translated.";
            sw = rw;
            hw = r;
            reset = 0x0;
        } dhduf_intmsk[7:7];

        field {
            name = "dhdvtthd1_intmsk";
            desc = "Dhdvtthd1 interrupt mask. Chinese-only data sheet: description and value encoding not translated.";
            sw = rw;
            hw = r;
            reset = 0x0;
        } dhdvtthd1_intmsk[4:4];

        field {
            name = "dsduf_intmsk";
            desc = "Dsduf interrupt mask. Chinese-only data sheet: description and value encoding not translated.";
            sw = rw;
            hw = r;
            reset = 0x0;
        } dsduf_intmsk[3:3];

        field {
            name = "dsdvtthd1_intmsk";
            desc = "Dsdvtthd1 interrupt mask. Chinese-only data sheet: description and value encoding not translated.";
            sw = rw;
            hw = r;
            reset = 0x0;
        } dsdvtthd1_intmsk[0:0];
    } VDPINTMSK @ 0xC;

    reg {
        name = "VDPVERSION1";
        desc = "Data sheet 8.2.5 VDPVERSION1 (offset 0x10, printed page 8-216, `hi3516v100--Hi3516-Datasheet.txt` line 47883).";

        field {
            name = "vdpversion0";
            desc = "Vdpversion0. Chinese-only data sheet: description and value encoding not translated.";
            sw = r;
            hw = w;
            reset = 0x76756F76;
        } vdpversion0[31:0];
    } VDPVERSION1 @ 0x10;

    reg {
        name = "VDPVERSION2";
        desc = "Data sheet 8.2.5 VDPVERSION2 (offset 0x14, printed page 8-216, `hi3516v100--Hi3516-Datasheet.txt` line 47902).";

        field {
            name = "vdpversion1";
            desc = "Vdpversion1. Chinese-only data sheet: description and value encoding not translated.";
            sw = r;
            hw = w;
            reset = 0x30303134;
        } vdpversion1[31:0];
    } VDPVERSION2 @ 0x14;

    reg {
        name = "VDPPARAUP";
        desc = "Data sheet 8.2.5 VDPPARAUP (offset 0x40, printed page 8-217, `hi3516v100--Hi3516-Datasheet.txt` line 47937).";

        field {
            name = "video_acc_upd";
            desc = "Video ACC update. Chinese-only data sheet: description and value encoding not translated.";
            sw = rw;
            hw = r;
            reset = 0x0;
        } video_acc_upd[4:4];
    } VDPPARAUP @ 0x40;

    reg {
        name = "ACCAD";
        desc = "Data sheet 8.2.5 ACCAD (offset 0x54, printed page 8-217, `hi3516v100--Hi3516-Datasheet.txt` line 47971).";

        field {
            name = "coef_addr";
            desc = "Coefficient address. Chinese-only data sheet: description and value encoding not translated.";
            sw = rw;
            hw = r;
            reset = 0x0;
        } coef_addr[31:0];
    } ACCAD @ 0x54;

    reg {
        name = "VHDCTRL";
        desc = "Data sheet 8.2.5 VHDCTRL (offset 0x100, printed page 8-218, `hi3516v100--Hi3516-Datasheet.txt` line 47999).";

        field {
            name = "surface_en";
            desc = "Surface enable. Chinese-only data sheet: description and value encoding not translated.";
            sw = rw;
            hw = r;
            reset = 0x0;
        } surface_en[31:31];

        field {
            name = "ifir_mode";
            desc = "Input FIR filter mode. Chinese-only data sheet: description and value encoding not translated.";
            sw = rw;
            hw = r;
            reset = 0x0;
        } ifir_mode[19:18];

        field {
            name = "vup_mode";
            desc = "Vup mode. Chinese-only data sheet: description and value encoding not translated. [check] The data sheet prints '-' in the access column of this named field; modelled RW.";
            sw = rw;
            hw = r;
            reset = 0x0;
        } vup_mode[17:17];

        field {
            name = "ifmt";
            desc = "Input format. Chinese-only data sheet: description and value encoding not translated.";
            sw = rw;
            hw = r;
            reset = 0x0;
        } ifmt[3:0];
    } VHDCTRL @ 0x100;

    reg {
        name = "VHDUPD";
        desc = "Data sheet 8.2.5 VHDUPD (offset 0x104, printed page 8-219, `hi3516v100--Hi3516-Datasheet.txt` line 48061).";

        field {
            name = "regup";
            desc = "Regup. Chinese-only data sheet: description and value encoding not translated.";
            sw = rw;
            hw = r;
            reset = 0x0;
        } regup[0:0];
    } VHDUPD @ 0x104;

    reg {
        name = "VHDCADDR";
        desc = "Data sheet 8.2.5 VHDCADDR (offset 0x110, printed page 8-219, `hi3516v100--Hi3516-Datasheet.txt` line 48087).";

        field {
            name = "surface_caddr";
            desc = "Surface caddr. Chinese-only data sheet: description and value encoding not translated.";
            sw = rw;
            hw = r;
            reset = 0x0;
        } surface_caddr[31:0];
    } VHDCADDR @ 0x110;

    reg {
        name = "VHDCCADDR";
        desc = "Data sheet 8.2.5 VHDCCADDR (offset 0x114, printed page 8-220, `hi3516v100--Hi3516-Datasheet.txt` line 48119).";

        field {
            name = "surface_ccaddr";
            desc = "Surface ccaddr. Chinese-only data sheet: description and value encoding not translated.";
            sw = rw;
            hw = r;
            reset = 0x0;
        } surface_ccaddr[31:0];
    } VHDCCADDR @ 0x114;

    reg {
        name = "VHDSTRIDE";
        desc = "Data sheet 8.2.5 VHDSTRIDE (offset 0x124, printed page 8-220, `hi3516v100--Hi3516-Datasheet.txt` line 48138).";

        field {
            name = "surface_cstride";
            desc = "Surface cstride. Chinese-only data sheet: description and value encoding not translated.";
            sw = rw;
            hw = r;
            reset = 0x0;
        } surface_cstride[31:16];

        field {
            name = "surface_stride";
            desc = "Surface stride. Chinese-only data sheet: description and value encoding not translated.";
            sw = rw;
            hw = r;
            reset = 0x0;
        } surface_stride[15:0];
    } VHDSTRIDE @ 0x124;

    reg {
        name = "VHDIRESO";
        desc = "Data sheet 8.2.5 VHDIRESO (offset 0x128, printed page 8-221, `hi3516v100--Hi3516-Datasheet.txt` line 48178).";

        field {
            name = "ih";
            desc = "Ih. Chinese-only data sheet: description and value encoding not translated.";
            sw = rw;
            hw = r;
            reset = 0x0;
        } ih[23:12];

        field {
            name = "iw";
            desc = "Iw. Chinese-only data sheet: description and value encoding not translated.";
            sw = rw;
            hw = r;
            reset = 0x0;
        } iw[11:0];
    } VHDIRESO @ 0x128;

    reg {
        name = "VHDCBMPARA";
        desc = "Data sheet 8.2.5 VHDCBMPARA (offset 0x134, printed page 8-221, `hi3516v100--Hi3516-Datasheet.txt` line 48203).";

        field {
            name = "galpha";
            desc = "Galpha. Chinese-only data sheet: description and value encoding not translated.";
            sw = rw;
            hw = r;
            reset = 0x0;
        } galpha[7:0];
    } VHDCBMPARA @ 0x134;

    reg {
        name = "VHDDFPOS";
        desc = "Data sheet 8.2.5 VHDDFPOS (offset 0x160, printed page 8-222, `hi3516v100--Hi3516-Datasheet.txt` line 48239).";

        field {
            name = "disp_yfpos";
            desc = "Disp yfpos. Chinese-only data sheet: description and value encoding not translated.";
            sw = rw;
            hw = r;
            reset = 0x0;
        } disp_yfpos[23:12];

        field {
            name = "disp_xfpos";
            desc = "Disp xfpos. Chinese-only data sheet: description and value encoding not translated.";
            sw = rw;
            hw = r;
            reset = 0x0;
        } disp_xfpos[11:0];
    } VHDDFPOS @ 0x160;

    reg {
        name = "VHDDLPOS";
        desc = "Data sheet 8.2.5 VHDDLPOS (offset 0x164, printed page 8-222, `hi3516v100--Hi3516-Datasheet.txt` line 48266).";

        field {
            name = "disp_ylpos";
            desc = "Disp ylpos. Chinese-only data sheet: description and value encoding not translated.";
            sw = rw;
            hw = r;
            reset = 0x0;
        } disp_ylpos[23:12];

        field {
            name = "disp_xlpos";
            desc = "Disp xlpos. Chinese-only data sheet: description and value encoding not translated.";
            sw = rw;
            hw = r;
            reset = 0x0;
        } disp_xlpos[11:0];
    } VHDDLPOS @ 0x164;

    reg {
        name = "VHDVFPOS";
        desc = "Data sheet 8.2.5 VHDVFPOS (offset 0x168, printed page 8-223, `hi3516v100--Hi3516-Datasheet.txt` line 48307).";

        field {
            name = "video_yfpos";
            desc = "Video yfpos. Chinese-only data sheet: description and value encoding not translated.";
            sw = rw;
            hw = r;
            reset = 0x0;
        } video_yfpos[23:12];

        field {
            name = "video_xfpos";
            desc = "Video xfpos. Chinese-only data sheet: description and value encoding not translated.";
            sw = rw;
            hw = r;
            reset = 0x0;
        } video_xfpos[11:0];
    } VHDVFPOS @ 0x168;

    reg {
        name = "VHDVLPOS";
        desc = "Data sheet 8.2.5 VHDVLPOS (offset 0x16C, printed page 8-223, `hi3516v100--Hi3516-Datasheet.txt` line 48333).";

        field {
            name = "video_ylpos";
            desc = "Video ylpos. Chinese-only data sheet: description and value encoding not translated.";
            sw = rw;
            hw = r;
            reset = 0x0;
        } video_ylpos[23:12];

        field {
            name = "video_xlpos";
            desc = "Video xlpos. Chinese-only data sheet: description and value encoding not translated.";
            sw = rw;
            hw = r;
            reset = 0x0;
        } video_xlpos[11:0];
    } VHDVLPOS @ 0x16C;

    reg {
        name = "VHDCSCIDC";
        desc = "Data sheet 8.2.5 VHDCSCIDC (offset 0x180, printed page 8-224, `hi3516v100--Hi3516-Datasheet.txt` line 48369).";

        field {
            name = "csc_en";
            desc = "Colour-space conversion enable. Chinese-only data sheet: description and value encoding not translated.";
            sw = rw;
            hw = r;
            reset = 0x0;
        } csc_en[27:27];

        field {
            name = "cscidc2";
            desc = "Cscidc2. Chinese-only data sheet: description and value encoding not translated.";
            sw = rw;
            hw = r;
            reset = 0x0;
        } cscidc2[26:18];

        field {
            name = "cscidc1";
            desc = "Cscidc1. Chinese-only data sheet: description and value encoding not translated.";
            sw = rw;
            hw = r;
            reset = 0x0;
        } cscidc1[17:9];

        field {
            name = "cscidc0";
            desc = "Cscidc0. Chinese-only data sheet: description and value encoding not translated.";
            sw = rw;
            hw = r;
            reset = 0x0;
        } cscidc0[8:0];
    } VHDCSCIDC @ 0x180;

    reg {
        name = "VHDCSCODC";
        desc = "Data sheet 8.2.5 VHDCSCODC (offset 0x184, printed page 8-224, `hi3516v100--Hi3516-Datasheet.txt` line 48400).";

        field {
            name = "cscodc2";
            desc = "Cscodc2. Chinese-only data sheet: description and value encoding not translated.";
            sw = rw;
            hw = r;
            reset = 0x0;
        } cscodc2[26:18];

        field {
            name = "cscodc1";
            desc = "Cscodc1. Chinese-only data sheet: description and value encoding not translated.";
            sw = rw;
            hw = r;
            reset = 0x0;
        } cscodc1[17:9];

        field {
            name = "cscodc0";
            desc = "Cscodc0. Chinese-only data sheet: description and value encoding not translated.";
            sw = rw;
            hw = r;
            reset = 0x0;
        } cscodc0[8:0];
    } VHDCSCODC @ 0x184;

    reg {
        name = "VHDCSCP0";
        desc = "Data sheet 8.2.5 VHDCSCP0 (offset 0x188, printed page 8-225, `hi3516v100--Hi3516-Datasheet.txt` line 48437).";

        field {
            name = "cscp01";
            desc = "Cscp01. Chinese-only data sheet: description and value encoding not translated.";
            sw = rw;
            hw = r;
            reset = 0x0;
        } cscp01[28:16];

        field {
            name = "cscp00";
            desc = "Cscp00. Chinese-only data sheet: description and value encoding not translated.";
            sw = rw;
            hw = r;
            reset = 0x0;
        } cscp00[12:0];
    } VHDCSCP0 @ 0x188;

    reg {
        name = "VHDCSCP1";
        desc = "Data sheet 8.2.5 VHDCSCP1 (offset 0x18C, printed page 8-225, `hi3516v100--Hi3516-Datasheet.txt` line 48471).";

        field {
            name = "cscp10";
            desc = "Cscp10. Chinese-only data sheet: description and value encoding not translated.";
            sw = rw;
            hw = r;
            reset = 0x0;
        } cscp10[28:16];

        field {
            name = "cscp02";
            desc = "Cscp02. Chinese-only data sheet: description and value encoding not translated.";
            sw = rw;
            hw = r;
            reset = 0x0;
        } cscp02[12:0];
    } VHDCSCP1 @ 0x18C;

    reg {
        name = "VHDCSCP2";
        desc = "Data sheet 8.2.5 VHDCSCP2 (offset 0x190, printed page 8-226, `hi3516v100--Hi3516-Datasheet.txt` line 48513).";

        field {
            name = "cscp12";
            desc = "Cscp12. Chinese-only data sheet: description and value encoding not translated.";
            sw = rw;
            hw = r;
            reset = 0x0;
        } cscp12[28:16];

        field {
            name = "cscp11";
            desc = "Cscp11. Chinese-only data sheet: description and value encoding not translated.";
            sw = rw;
            hw = r;
            reset = 0x0;
        } cscp11[12:0];
    } VHDCSCP2 @ 0x190;

    reg {
        name = "VHDCSCP3";
        desc = "Data sheet 8.2.5 VHDCSCP3 (offset 0x194, printed page 8-227, `hi3516v100--Hi3516-Datasheet.txt` line 48562).";

        field {
            name = "cscp21";
            desc = "Cscp21. Chinese-only data sheet: description and value encoding not translated.";
            sw = rw;
            hw = r;
            reset = 0x0;
        } cscp21[28:16];

        field {
            name = "cscp20";
            desc = "Cscp20. Chinese-only data sheet: description and value encoding not translated.";
            sw = rw;
            hw = r;
            reset = 0x0;
        } cscp20[12:0];
    } VHDCSCP3 @ 0x194;

    reg {
        name = "VHDCSCP4";
        desc = "Data sheet 8.2.5 VHDCSCP4 (offset 0x198, printed page 8-227, `hi3516v100--Hi3516-Datasheet.txt` line 48596).";

        field {
            name = "cscp22";
            desc = "Cscp22. Chinese-only data sheet: description and value encoding not translated.";
            sw = rw;
            hw = r;
            reset = 0x0;
        } cscp22[12:0];
    } VHDCSCP4 @ 0x198;

    reg {
        name = "VHDVSP";
        desc = "Data sheet 8.2.5 VHDVSP (offset 0x1D8, printed page 8-228, `hi3516v100--Hi3516-Datasheet.txt` line 48628).";

        field {
            name = "vchmsc_en";
            desc = "Vchmsc enable. Chinese-only data sheet: description and value encoding not translated.";
            sw = rw;
            hw = r;
            reset = 0x0;
        } vchmsc_en[30:30];

        field {
            name = "vsc_chroma_tap";
            desc = "Vsc chroma tap. Chinese-only data sheet: description and value encoding not translated.";
            sw = rw;
            hw = r;
            reset = 0x0;
        } vsc_chroma_tap[26:26];

        field {
            name = "chroma_type";
            desc = "Chroma type. Chinese-only data sheet: description and value encoding not translated.";
            sw = rw;
            hw = r;
            reset = 0x0;
        } chroma_type[25:25];

        field {
            name = "vchfir_en";
            desc = "Vchfir enable. Chinese-only data sheet: description and value encoding not translated.";
            sw = rw;
            hw = r;
            reset = 0x0;
        } vchfir_en[23:23];
    } VHDVSP @ 0x1D8;

    reg {
        name = "VHDZMEORESO";
        desc = "Data sheet 8.2.5 VHDZMEORESO (offset 0x1E4, printed page 8-229, `hi3516v100--Hi3516-Datasheet.txt` line 48692).";

        field {
            name = "oh";
            desc = "Oh. Chinese-only data sheet: description and value encoding not translated.";
            sw = rw;
            hw = r;
            reset = 0x0;
        } oh[23:12];

        field {
            name = "ow";
            desc = "Ow. Chinese-only data sheet: description and value encoding not translated.";
            sw = rw;
            hw = r;
            reset = 0x0;
        } ow[11:0];
    } VHDZMEORESO @ 0x1E4;

    reg {
        name = "VHDZMEIRESO";
        desc = "Data sheet 8.2.5 VHDZMEIRESO (offset 0x1E8, printed page 8-229, `hi3516v100--Hi3516-Datasheet.txt` line 48719).";

        field {
            name = "ih";
            desc = "Ih. Chinese-only data sheet: description and value encoding not translated.";
            sw = rw;
            hw = r;
            reset = 0x0;
        } ih[23:12];

        field {
            name = "iw";
            desc = "Iw. Chinese-only data sheet: description and value encoding not translated.";
            sw = rw;
            hw = r;
            reset = 0x0;
        } iw[11:0];
    } VHDZMEIRESO @ 0x1E8;

    reg {
        name = "VHDCOEF00";
        desc = "Data sheet 8.2.5 VHDCOEF00 (offset 0x1F0, printed page 8-230, `hi3516v100--Hi3516-Datasheet.txt` line 48755).";

        field {
            name = "coef01";
            desc = "Coef01. Chinese-only data sheet: description and value encoding not translated.";
            sw = rw;
            hw = r;
            reset = 0x0;
        } coef01[19:10];

        field {
            name = "coef00";
            desc = "Coef00. Chinese-only data sheet: description and value encoding not translated.";
            sw = rw;
            hw = r;
            reset = 0x0;
        } coef00[9:0];
    } VHDCOEF00 @ 0x1F0;

    reg {
        name = "VHDCOEF01";
        desc = "Data sheet 8.2.5 VHDCOEF01 (offset 0x1F4, printed page 8-230, `hi3516v100--Hi3516-Datasheet.txt` line 48778).";

        field {
            name = "coef01";
            desc = "Coef01. Chinese-only data sheet: description and value encoding not translated.";
            sw = rw;
            hw = r;
            reset = 0x0;
        } coef01[19:10];

        field {
            name = "coef00";
            desc = "Coef00. Chinese-only data sheet: description and value encoding not translated.";
            sw = rw;
            hw = r;
            reset = 0x0;
        } coef00[9:0];
    } VHDCOEF01 @ 0x1F4;

    reg {
        name = "VHDCOEF10";
        desc = "Data sheet 8.2.5 VHDCOEF10 (offset 0x1F8, printed page 8-231, `hi3516v100--Hi3516-Datasheet.txt` line 48816).";

        field {
            name = "coef01";
            desc = "Coef01. Chinese-only data sheet: description and value encoding not translated.";
            sw = rw;
            hw = r;
            reset = 0x0;
        } coef01[19:10];

        field {
            name = "coef00";
            desc = "Coef00. Chinese-only data sheet: description and value encoding not translated.";
            sw = rw;
            hw = r;
            reset = 0x0;
        } coef00[9:0];
    } VHDCOEF10 @ 0x1F8;

    reg {
        name = "VHDCOEF11";
        desc = "Data sheet 8.2.5 VHDCOEF11 (offset 0x1FC, printed page 8-231, `hi3516v100--Hi3516-Datasheet.txt` line 48839).";

        field {
            name = "coef01";
            desc = "Coef01. Chinese-only data sheet: description and value encoding not translated.";
            sw = rw;
            hw = r;
            reset = 0x0;
        } coef01[19:10];

        field {
            name = "coef00";
            desc = "Coef00. Chinese-only data sheet: description and value encoding not translated.";
            sw = rw;
            hw = r;
            reset = 0x0;
        } coef00[9:0];
    } VHDCOEF11 @ 0x1FC;

    reg {
        name = "VHDACCTHD1";
        desc = "Data sheet 8.2.5 VHDACCTHD1 (offset 0x200, printed page 8-232, `hi3516v100--Hi3516-Datasheet.txt` line 48874).";

        field {
            name = "acc_en";
            desc = "ACC enable. Chinese-only data sheet: description and value encoding not translated.";
            sw = rw;
            hw = r;
            reset = 0x0;
        } acc_en[31:31];

        field {
            name = "acc_mode";
            desc = "ACC mode. Chinese-only data sheet: description and value encoding not translated.";
            sw = rw;
            hw = r;
            reset = 0x0;
        } acc_mode[30:30];

        field {
            name = "thd_med_low";
            desc = "Threshold med low. Chinese-only data sheet: description and value encoding not translated.";
            sw = rw;
            hw = r;
            reset = 0x0;
        } thd_med_low[29:20];

        field {
            name = "thd_high";
            desc = "Threshold high. Chinese-only data sheet: description and value encoding not translated.";
            sw = rw;
            hw = r;
            reset = 0x0;
        } thd_high[19:10];

        field {
            name = "thd_low";
            desc = "Threshold low. Chinese-only data sheet: description and value encoding not translated.";
            sw = rw;
            hw = r;
            reset = 0x0;
        } thd_low[9:0];
    } VHDACCTHD1 @ 0x200;

    reg {
        name = "VHDACCTHD2";
        desc = "Data sheet 8.2.5 VHDACCTHD2 (offset 0x204, printed page 8-232, `hi3516v100--Hi3516-Datasheet.txt` line 48910).";

        field {
            name = "acc_rst";
            desc = "ACC rst. Chinese-only data sheet: description and value encoding not translated.";
            sw = rw;
            hw = r;
            reset = 0x0;
        } acc_rst[18:18];

        field {
            name = "acc_multiple";
            desc = "ACC multiple. Chinese-only data sheet: description and value encoding not translated.";
            sw = rw;
            hw = r;
            reset = 0x0;
        } acc_multiple[17:10];

        field {
            name = "thd_med_high";
            desc = "Threshold med high. Chinese-only data sheet: description and value encoding not translated.";
            sw = rw;
            hw = r;
            reset = 0x0;
        } thd_med_high[9:0];
    } VHDACCTHD2 @ 0x204;

    reg {
        name = "VHDACCLOWN";
        desc = "Data sheet 8.2.5 VHDACCLOWN (offset 0x210, printed page 8-233, `hi3516v100--Hi3516-Datasheet.txt` line 48949).";

        field {
            name = "table_data3n";
            desc = "Table data3n. Chinese-only data sheet: description and value encoding not translated.";
            sw = rw;
            hw = r;
            reset = 0x0;
        } table_data3n[29:20];

        field {
            name = "table_data2n";
            desc = "Table data2n. Chinese-only data sheet: description and value encoding not translated.";
            sw = rw;
            hw = r;
            reset = 0x0;
        } table_data2n[19:10];

        field {
            name = "table_data1n";
            desc = "Table data1n. Chinese-only data sheet: description and value encoding not translated.";
            sw = rw;
            hw = r;
            reset = 0x0;
        } table_data1n[9:0];
    } VHDACCLOWN[3] @ 0x210 += 0x4;

    reg {
        name = "VHDACCMEDN";
        desc = "Data sheet 8.2.5 VHDACCMEDN (offset 0x220, printed page 8-233, `hi3516v100--Hi3516-Datasheet.txt` line 48979).";

        field {
            name = "table_data3n";
            desc = "Table data3n. Chinese-only data sheet: description and value encoding not translated.";
            sw = rw;
            hw = r;
            reset = 0x0;
        } table_data3n[29:20];

        field {
            name = "table_data2n";
            desc = "Table data2n. Chinese-only data sheet: description and value encoding not translated.";
            sw = rw;
            hw = r;
            reset = 0x0;
        } table_data2n[19:10];

        field {
            name = "table_data1n";
            desc = "Table data1n. Chinese-only data sheet: description and value encoding not translated.";
            sw = rw;
            hw = r;
            reset = 0x0;
        } table_data1n[9:0];
    } VHDACCMEDN[3] @ 0x220 += 0x4;

    reg {
        name = "VHDACCHIGHN";
        desc = "Data sheet 8.2.5 VHDACCHIGHN (offset 0x230, printed page 8-234, `hi3516v100--Hi3516-Datasheet.txt` line 49018).";

        field {
            name = "table_data3n";
            desc = "Table data3n. Chinese-only data sheet: description and value encoding not translated.";
            sw = rw;
            hw = r;
            reset = 0x0;
        } table_data3n[29:20];

        field {
            name = "table_data2n";
            desc = "Table data2n. Chinese-only data sheet: description and value encoding not translated.";
            sw = rw;
            hw = r;
            reset = 0x0;
        } table_data2n[19:10];

        field {
            name = "table_data1n";
            desc = "Table data1n. Chinese-only data sheet: description and value encoding not translated.";
            sw = rw;
            hw = r;
            reset = 0x0;
        } table_data1n[9:0];
    } VHDACCHIGHN[3] @ 0x230 += 0x4;

    reg {
        name = "VHDACCMLN";
        desc = "Data sheet 8.2.5 VHDACCMLN (offset 0x240, printed page 8-235, `hi3516v100--Hi3516-Datasheet.txt` line 49063).";

        field {
            name = "table_data3n";
            desc = "Table data3n. Chinese-only data sheet: description and value encoding not translated.";
            sw = rw;
            hw = r;
            reset = 0x0;
        } table_data3n[29:20];

        field {
            name = "table_data2n";
            desc = "Table data2n. Chinese-only data sheet: description and value encoding not translated.";
            sw = rw;
            hw = r;
            reset = 0x0;
        } table_data2n[19:10];

        field {
            name = "table_data1n";
            desc = "Table data1n. Chinese-only data sheet: description and value encoding not translated.";
            sw = rw;
            hw = r;
            reset = 0x0;
        } table_data1n[9:0];
    } VHDACCMLN[3] @ 0x240 += 0x4;

    reg {
        name = "VHDACCMHN";
        desc = "Data sheet 8.2.5 VHDACCMHN (offset 0x250, printed page 8-235, `hi3516v100--Hi3516-Datasheet.txt` line 49093).";

        field {
            name = "table_data3n";
            desc = "Table data3n. Chinese-only data sheet: description and value encoding not translated.";
            sw = rw;
            hw = r;
            reset = 0x0;
        } table_data3n[29:20];

        field {
            name = "table_data2n";
            desc = "Table data2n. Chinese-only data sheet: description and value encoding not translated.";
            sw = rw;
            hw = r;
            reset = 0x0;
        } table_data2n[19:10];

        field {
            name = "table_data1n";
            desc = "Table data1n. Chinese-only data sheet: description and value encoding not translated.";
            sw = rw;
            hw = r;
            reset = 0x0;
        } table_data1n[9:0];
    } VHDACCMHN[3] @ 0x250 += 0x4;

    reg {
        name = "VHDACC3LOW";
        desc = "Data sheet 8.2.5 VHDACC3LOW (offset 0x260, printed page 8-236, `hi3516v100--Hi3516-Datasheet.txt` line 49132).";

        field {
            name = "cnt3_low";
            desc = "Cnt3 low. Chinese-only data sheet: description and value encoding not translated.";
            sw = r;
            hw = w;
            reset = 0x0;
        } cnt3_low[20:0];
    } VHDACC3LOW @ 0x260;

    reg {
        name = "VHDACC3MED";
        desc = "Data sheet 8.2.5 VHDACC3MED (offset 0x264, printed page 8-236, `hi3516v100--Hi3516-Datasheet.txt` line 49153).";

        field {
            name = "cnt3_med";
            desc = "Cnt3 med. Chinese-only data sheet: description and value encoding not translated.";
            sw = r;
            hw = w;
            reset = 0x0;
        } cnt3_med[20:0];
    } VHDACC3MED @ 0x264;

    reg {
        name = "VHDACC3HIGH";
        desc = "Data sheet 8.2.5 VHDACC3HIGH (offset 0x268, printed page 8-237, `hi3516v100--Hi3516-Datasheet.txt` line 49189).";

        field {
            name = "cnt3_high";
            desc = "Cnt3 high. Chinese-only data sheet: description and value encoding not translated.";
            sw = r;
            hw = w;
            reset = 0x0;
        } cnt3_high[20:0];
    } VHDACC3HIGH @ 0x268;

    reg {
        name = "VHDACC8MLOW";
        desc = "Data sheet 8.2.5 VHDACC8MLOW (offset 0x26C, printed page 8-237, `hi3516v100--Hi3516-Datasheet.txt` line 49210).";

        field {
            name = "cnt8_med_low";
            desc = "Cnt8 med low. Chinese-only data sheet: description and value encoding not translated.";
            sw = r;
            hw = w;
            reset = 0x0;
        } cnt8_med_low[20:0];
    } VHDACC8MLOW @ 0x26C;

    reg {
        name = "VHDACC8MHIGH";
        desc = "Data sheet 8.2.5 VHDACC8MHIGH (offset 0x270, printed page 8-238, `hi3516v100--Hi3516-Datasheet.txt` line 49244).";

        field {
            name = "cnt8_med_high";
            desc = "Cnt8 med high. Chinese-only data sheet: description and value encoding not translated.";
            sw = r;
            hw = w;
            reset = 0x0;
        } cnt8_med_high[20:0];
    } VHDACC8MHIGH @ 0x270;

    reg {
        name = "VHDACCTOTAL";
        desc = "Data sheet 8.2.5 VHDACCTOTAL (offset 0x274, printed page 8-238, `hi3516v100--Hi3516-Datasheet.txt` line 49265).";

        field {
            name = "acc_pix_total";
            desc = "ACC pix total. Chinese-only data sheet: description and value encoding not translated.";
            sw = r;
            hw = w;
            reset = 0x0;
        } acc_pix_total[20:0];
    } VHDACCTOTAL @ 0x274;

    reg {
        name = "VHDIFIRCOEF01";
        desc = "Data sheet 8.2.5 VHDIFIRCOEF01 (offset 0x280, printed page 8-238, `hi3516v100--Hi3516-Datasheet.txt` line 49286).";

        field {
            name = "coef1";
            desc = "Coef1. Chinese-only data sheet: description and value encoding not translated.";
            sw = rw;
            hw = r;
            reset = 0xD;
        } coef1[25:16];

        field {
            name = "coef0";
            desc = "Coef0. Chinese-only data sheet: description and value encoding not translated.";
            sw = rw;
            hw = r;
            reset = 0x0;
        } coef0[9:0];
    } VHDIFIRCOEF01 @ 0x280;

    reg {
        name = "VHDIFIRCOEF23";
        desc = "Data sheet 8.2.5 VHDIFIRCOEF23 (offset 0x284, printed page 8-239, `hi3516v100--Hi3516-Datasheet.txt` line 49322).";

        field {
            name = "coef3";
            desc = "Coef3. Chinese-only data sheet: description and value encoding not translated.";
            sw = rw;
            hw = r;
            reset = 0x132;
        } coef3[25:16];

        field {
            name = "coef2";
            desc = "Coef2. Chinese-only data sheet: description and value encoding not translated.";
            sw = rw;
            hw = r;
            reset = 0x3C1;
        } coef2[9:0];
    } VHDIFIRCOEF23 @ 0x284;

    reg {
        name = "VHDIFIRCOEF45";
        desc = "Data sheet 8.2.5 VHDIFIRCOEF45 (offset 0x288, printed page 8-239, `hi3516v100--Hi3516-Datasheet.txt` line 49347).";

        field {
            name = "coef5";
            desc = "Coef5. Chinese-only data sheet: description and value encoding not translated.";
            sw = rw;
            hw = r;
            reset = 0x3C1;
        } coef5[25:16];

        field {
            name = "coef4";
            desc = "Coef4. Chinese-only data sheet: description and value encoding not translated.";
            sw = rw;
            hw = r;
            reset = 0x132;
        } coef4[9:0];
    } VHDIFIRCOEF45 @ 0x288;

    reg {
        name = "VHDIFIRCOEF67";
        desc = "Data sheet 8.2.5 VHDIFIRCOEF67 (offset 0x28C, printed page 8-240, `hi3516v100--Hi3516-Datasheet.txt` line 49381).";

        field {
            name = "coef7";
            desc = "Coef7. Chinese-only data sheet: description and value encoding not translated.";
            sw = rw;
            hw = r;
            reset = 0x0;
        } coef7[25:16];

        field {
            name = "coef6";
            desc = "Coef6. Chinese-only data sheet: description and value encoding not translated.";
            sw = rw;
            hw = r;
            reset = 0xD;
        } coef6[9:0];
    } VHDIFIRCOEF67 @ 0x28C;

    reg {
        name = "VSDCTRL";
        desc = "Data sheet 8.2.5 VSDCTRL (offset 0x700, printed page 8-240, `hi3516v100--Hi3516-Datasheet.txt` line 49406).";

        field {
            name = "surface_en";
            desc = "Surface enable. Chinese-only data sheet: description and value encoding not translated.";
            sw = rw;
            hw = r;
            reset = 0x0;
        } surface_en[31:31];

        field {
            name = "ifir_mode";
            desc = "Input FIR filter mode. Chinese-only data sheet: description and value encoding not translated.";
            sw = rw;
            hw = r;
            reset = 0x0;
        } ifir_mode[19:18];

        field {
            name = "vup_mode";
            desc = "Vup mode. Chinese-only data sheet: description and value encoding not translated.";
            sw = rw;
            hw = r;
            reset = 0x0;
        } vup_mode[17:17];

        field {
            name = "ifmt";
            desc = "Input format. Chinese-only data sheet: description and value encoding not translated.";
            sw = rw;
            hw = r;
            reset = 0x0;
        } ifmt[3:0];
    } VSDCTRL @ 0x700;

    reg {
        name = "VSDUPD";
        desc = "Data sheet 8.2.5 VSDUPD (offset 0x704, printed page 8-241, `hi3516v100--Hi3516-Datasheet.txt` line 49465).";

        field {
            name = "regup";
            desc = "Regup. Chinese-only data sheet: description and value encoding not translated.";
            sw = rw;
            hw = r;
            reset = 0x0;
        } regup[0:0];
    } VSDUPD @ 0x704;

    reg {
        name = "VSDCADDR";
        desc = "Data sheet 8.2.5 VSDCADDR (offset 0x710, printed page 8-242, `hi3516v100--Hi3516-Datasheet.txt` line 49500).";

        field {
            name = "surface_caddr";
            desc = "Surface caddr. Chinese-only data sheet: description and value encoding not translated.";
            sw = rw;
            hw = r;
            reset = 0x0;
        } surface_caddr[31:0];
    } VSDCADDR @ 0x710;

    reg {
        name = "VSDCCADDR";
        desc = "Data sheet 8.2.5 VSDCCADDR (offset 0x714, printed page 8-242, `hi3516v100--Hi3516-Datasheet.txt` line 49520).";

        field {
            name = "surface_ccaddr";
            desc = "Surface ccaddr. Chinese-only data sheet: description and value encoding not translated.";
            sw = rw;
            hw = r;
            reset = 0x0;
        } surface_ccaddr[31:0];
    } VSDCCADDR @ 0x714;

    reg {
        name = "VSDSTRIDE";
        desc = "Data sheet 8.2.5 VSDSTRIDE (offset 0x724, printed page 8-243, `hi3516v100--Hi3516-Datasheet.txt` line 49554).";

        field {
            name = "surface_cstride";
            desc = "Surface cstride. Chinese-only data sheet: description and value encoding not translated.";
            sw = rw;
            hw = r;
            reset = 0x0;
        } surface_cstride[31:16];

        field {
            name = "surface_stride";
            desc = "Surface stride. Chinese-only data sheet: description and value encoding not translated.";
            sw = rw;
            hw = r;
            reset = 0x0;
        } surface_stride[15:0];
    } VSDSTRIDE @ 0x724;

    reg {
        name = "VSDIRESO";
        desc = "Data sheet 8.2.5 VSDIRESO (offset 0x728, printed page 8-243, `hi3516v100--Hi3516-Datasheet.txt` line 49579).";

        field {
            name = "ih";
            desc = "Ih. Chinese-only data sheet: description and value encoding not translated.";
            sw = rw;
            hw = r;
            reset = 0x0;
        } ih[23:12];

        field {
            name = "iw";
            desc = "Iw. Chinese-only data sheet: description and value encoding not translated.";
            sw = rw;
            hw = r;
            reset = 0x0;
        } iw[11:0];
    } VSDIRESO @ 0x728;

    reg {
        name = "VSDCBMPARA";
        desc = "Data sheet 8.2.5 VSDCBMPARA (offset 0x734, printed page 8-244, `hi3516v100--Hi3516-Datasheet.txt` line 49616).";

        field {
            name = "galpha";
            desc = "Galpha. Chinese-only data sheet: description and value encoding not translated.";
            sw = rw;
            hw = r;
            reset = 0x0;
        } galpha[7:0];
    } VSDCBMPARA @ 0x734;

    reg {
        name = "VSDDFPOS";
        desc = "Data sheet 8.2.5 VSDDFPOS (offset 0x760, printed page 8-244, `hi3516v100--Hi3516-Datasheet.txt` line 49640).";

        field {
            name = "disp_yfpos";
            desc = "Disp yfpos. Chinese-only data sheet: description and value encoding not translated.";
            sw = rw;
            hw = r;
            reset = 0x0;
        } disp_yfpos[23:12];

        field {
            name = "disp_xfpos";
            desc = "Disp xfpos. Chinese-only data sheet: description and value encoding not translated.";
            sw = rw;
            hw = r;
            reset = 0x0;
        } disp_xfpos[11:0];
    } VSDDFPOS @ 0x760;

    reg {
        name = "VSDDLPOS";
        desc = "Data sheet 8.2.5 VSDDLPOS (offset 0x764, printed page 8-245, `hi3516v100--Hi3516-Datasheet.txt` line 49681).";

        field {
            name = "disp_ylpos";
            desc = "Disp ylpos. Chinese-only data sheet: description and value encoding not translated.";
            sw = rw;
            hw = r;
            reset = 0x0;
        } disp_ylpos[23:12];

        field {
            name = "disp_xlpos";
            desc = "Disp xlpos. Chinese-only data sheet: description and value encoding not translated.";
            sw = rw;
            hw = r;
            reset = 0x0;
        } disp_xlpos[11:0];
    } VSDDLPOS @ 0x764;

    reg {
        name = "VSDVFPOS";
        desc = "Data sheet 8.2.5 VSDVFPOS (offset 0x768, printed page 8-245, `hi3516v100--Hi3516-Datasheet.txt` line 49707).";

        field {
            name = "video_yfpos";
            desc = "Video yfpos. Chinese-only data sheet: description and value encoding not translated.";
            sw = rw;
            hw = r;
            reset = 0x0;
        } video_yfpos[23:12];

        field {
            name = "video_xfpos";
            desc = "Video xfpos. Chinese-only data sheet: description and value encoding not translated.";
            sw = rw;
            hw = r;
            reset = 0x0;
        } video_xfpos[11:0];
    } VSDVFPOS @ 0x768;

    reg {
        name = "VSDVLPOS";
        desc = "Data sheet 8.2.5 VSDVLPOS (offset 0x76C, printed page 8-246, `hi3516v100--Hi3516-Datasheet.txt` line 49743).";

        field {
            name = "video_ylpos";
            desc = "Video ylpos. Chinese-only data sheet: description and value encoding not translated.";
            sw = rw;
            hw = r;
            reset = 0x0;
        } video_ylpos[23:12];

        field {
            name = "video_xlpos";
            desc = "Video xlpos. Chinese-only data sheet: description and value encoding not translated.";
            sw = rw;
            hw = r;
            reset = 0x0;
        } video_xlpos[11:0];
    } VSDVLPOS @ 0x76C;

    reg {
        name = "VSDCSCIDC";
        desc = "Data sheet 8.2.5 VSDCSCIDC (offset 0x780, printed page 8-246, `hi3516v100--Hi3516-Datasheet.txt` line 49768).";

        field {
            name = "csc_en";
            desc = "Colour-space conversion enable. Chinese-only data sheet: description and value encoding not translated.";
            sw = rw;
            hw = r;
            reset = 0x0;
        } csc_en[27:27];

        field {
            name = "cscidc2";
            desc = "Cscidc2. Chinese-only data sheet: description and value encoding not translated.";
            sw = rw;
            hw = r;
            reset = 0x0;
        } cscidc2[26:18];

        field {
            name = "cscidc1";
            desc = "Cscidc1. Chinese-only data sheet: description and value encoding not translated.";
            sw = rw;
            hw = r;
            reset = 0x0;
        } cscidc1[17:9];

        field {
            name = "cscidc0";
            desc = "Cscidc0. Chinese-only data sheet: description and value encoding not translated.";
            sw = rw;
            hw = r;
            reset = 0x0;
        } cscidc0[8:0];
    } VSDCSCIDC @ 0x780;

    reg {
        name = "VSDCSCODC";
        desc = "Data sheet 8.2.5 VSDCSCODC (offset 0x784, printed page 8-247, `hi3516v100--Hi3516-Datasheet.txt` line 49811).";

        field {
            name = "cscodc2";
            desc = "Cscodc2. Chinese-only data sheet: description and value encoding not translated.";
            sw = rw;
            hw = r;
            reset = 0x0;
        } cscodc2[26:18];

        field {
            name = "cscodc1";
            desc = "Cscodc1. Chinese-only data sheet: description and value encoding not translated.";
            sw = rw;
            hw = r;
            reset = 0x0;
        } cscodc1[17:9];

        field {
            name = "cscodc0";
            desc = "Cscodc0. Chinese-only data sheet: description and value encoding not translated.";
            sw = rw;
            hw = r;
            reset = 0x0;
        } cscodc0[8:0];
    } VSDCSCODC @ 0x784;

    reg {
        name = "VSDCSCP0";
        desc = "Data sheet 8.2.5 VSDCSCP0 (offset 0x788, printed page 8-247, `hi3516v100--Hi3516-Datasheet.txt` line 49836).";

        field {
            name = "cscp01";
            desc = "Cscp01. Chinese-only data sheet: description and value encoding not translated.";
            sw = rw;
            hw = r;
            reset = 0x0;
        } cscp01[28:16];

        field {
            name = "cscp00";
            desc = "Cscp00. Chinese-only data sheet: description and value encoding not translated.";
            sw = rw;
            hw = r;
            reset = 0x0;
        } cscp00[12:0];
    } VSDCSCP0 @ 0x788;

    reg {
        name = "VSDCSCP1";
        desc = "Data sheet 8.2.5 VSDCSCP1 (offset 0x78C, printed page 8-248, `hi3516v100--Hi3516-Datasheet.txt` line 49876).";

        field {
            name = "cscp10";
            desc = "Cscp10. Chinese-only data sheet: description and value encoding not translated.";
            sw = rw;
            hw = r;
            reset = 0x0;
        } cscp10[28:16];

        field {
            name = "cscp02";
            desc = "Cscp02. Chinese-only data sheet: description and value encoding not translated.";
            sw = rw;
            hw = r;
            reset = 0x0;
        } cscp02[12:0];
    } VSDCSCP1 @ 0x78C;

    reg {
        name = "VSDCSCP2";
        desc = "Data sheet 8.2.5 VSDCSCP2 (offset 0x790, printed page 8-248, `hi3516v100--Hi3516-Datasheet.txt` line 49910).";

        field {
            name = "cscp12";
            desc = "Cscp12. Chinese-only data sheet: description and value encoding not translated.";
            sw = rw;
            hw = r;
            reset = 0x0;
        } cscp12[28:16];

        field {
            name = "cscp11";
            desc = "Cscp11. Chinese-only data sheet: description and value encoding not translated.";
            sw = rw;
            hw = r;
            reset = 0x0;
        } cscp11[12:0];
    } VSDCSCP2 @ 0x790;

    reg {
        name = "VSDCSCP3";
        desc = "Data sheet 8.2.5 VSDCSCP3 (offset 0x794, printed page 8-249, `hi3516v100--Hi3516-Datasheet.txt` line 49955).";

        field {
            name = "cscp21";
            desc = "Cscp21. Chinese-only data sheet: description and value encoding not translated.";
            sw = rw;
            hw = r;
            reset = 0x0;
        } cscp21[28:16];

        field {
            name = "cscp20";
            desc = "Cscp20. Chinese-only data sheet: description and value encoding not translated.";
            sw = rw;
            hw = r;
            reset = 0x0;
        } cscp20[12:0];
    } VSDCSCP3 @ 0x794;

    reg {
        name = "VSDCSCP4";
        desc = "Data sheet 8.2.5 VSDCSCP4 (offset 0x798, printed page 8-250, `hi3516v100--Hi3516-Datasheet.txt` line 50001).";

        field {
            name = "cscp22";
            desc = "Cscp22. Chinese-only data sheet: description and value encoding not translated.";
            sw = rw;
            hw = r;
            reset = 0x0;
        } cscp22[12:0];
    } VSDCSCP4 @ 0x798;

    reg {
        name = "VSDMOSAIC register";
        desc = "VSDMOSAIC register. The data sheet lists no bit fields for it.

Data sheet 8.2.5 VSDMOSAIC (offset 0x7F0, printed page 8-250, `hi3516v100--Hi3516-Datasheet.txt` line 50024).";

        field {
            name = "value";
            desc = "Register value (the data sheet gives no bit table for this register).";
            sw = rw;
            hw = r;
            reset = 0x0;
        } value[31:0];
    } VSDMOSAIC[4] @ 0x7F0 += 0x4;

    reg {
        name = "VSDACCTHD1";
        desc = "Data sheet 8.2.5 VSDACCTHD1 (offset 0x800, printed page 8-251, `hi3516v100--Hi3516-Datasheet.txt` line 50058).";

        field {
            name = "acc_en";
            desc = "ACC enable. Chinese-only data sheet: description and value encoding not translated.";
            sw = rw;
            hw = r;
            reset = 0x0;
        } acc_en[31:31];

        field {
            name = "acc_mode";
            desc = "ACC mode. Chinese-only data sheet: description and value encoding not translated.";
            sw = rw;
            hw = r;
            reset = 0x0;
        } acc_mode[30:30];

        field {
            name = "thd_med_low";
            desc = "Threshold med low. Chinese-only data sheet: description and value encoding not translated.";
            sw = rw;
            hw = r;
            reset = 0x0;
        } thd_med_low[29:20];

        field {
            name = "thd_high";
            desc = "Threshold high. Chinese-only data sheet: description and value encoding not translated.";
            sw = rw;
            hw = r;
            reset = 0x0;
        } thd_high[19:10];

        field {
            name = "thd_low";
            desc = "Threshold low. Chinese-only data sheet: description and value encoding not translated.";
            sw = rw;
            hw = r;
            reset = 0x0;
        } thd_low[9:0];
    } VSDACCTHD1 @ 0x800;

    reg {
        name = "VSDACCTHD2";
        desc = "Data sheet 8.2.5 VSDACCTHD2 (offset 0x804, printed page 8-251, `hi3516v100--Hi3516-Datasheet.txt` line 50094).";

        field {
            name = "acc_rst";
            desc = "ACC rst. Chinese-only data sheet: description and value encoding not translated.";
            sw = rw;
            hw = r;
            reset = 0x0;
        } acc_rst[18:18];

        field {
            name = "acc_multiple";
            desc = "ACC multiple. Chinese-only data sheet: description and value encoding not translated.";
            sw = rw;
            hw = r;
            reset = 0x0;
        } acc_multiple[17:10];

        field {
            name = "thd_med_high";
            desc = "Threshold med high. Chinese-only data sheet: description and value encoding not translated.";
            sw = rw;
            hw = r;
            reset = 0x0;
        } thd_med_high[9:0];
    } VSDACCTHD2 @ 0x804;

    reg {
        name = "VSDACCLOWN";
        desc = "Data sheet 8.2.5 VSDACCLOWN (offset 0x810, printed page 8-252, `hi3516v100--Hi3516-Datasheet.txt` line 50130).";

        field {
            name = "table_data3n";
            desc = "Table data3n. Chinese-only data sheet: description and value encoding not translated.";
            sw = rw;
            hw = r;
            reset = 0x0;
        } table_data3n[29:20];

        field {
            name = "table_data2n";
            desc = "Table data2n. Chinese-only data sheet: description and value encoding not translated.";
            sw = rw;
            hw = r;
            reset = 0x0;
        } table_data2n[19:10];

        field {
            name = "table_data1n";
            desc = "Table data1n. Chinese-only data sheet: description and value encoding not translated.";
            sw = rw;
            hw = r;
            reset = 0x0;
        } table_data1n[9:0];
    } VSDACCLOWN[3] @ 0x810 += 0x4;

    reg {
        name = "VSDACCMEDN";
        desc = "Data sheet 8.2.5 VSDACCMEDN (offset 0x820, printed page 8-252, `hi3516v100--Hi3516-Datasheet.txt` line 50160).";

        field {
            name = "table_data3n";
            desc = "Table data3n. Chinese-only data sheet: description and value encoding not translated.";
            sw = rw;
            hw = r;
            reset = 0x0;
        } table_data3n[29:20];

        field {
            name = "table_data2n";
            desc = "Table data2n. Chinese-only data sheet: description and value encoding not translated.";
            sw = rw;
            hw = r;
            reset = 0x0;
        } table_data2n[19:10];

        field {
            name = "table_data1n";
            desc = "Table data1n. Chinese-only data sheet: description and value encoding not translated.";
            sw = rw;
            hw = r;
            reset = 0x0;
        } table_data1n[9:0];
    } VSDACCMEDN[3] @ 0x820 += 0x4;

    reg {
        name = "VSDACCHIGHN";
        desc = "Data sheet 8.2.5 VSDACCHIGHN (offset 0x830, printed page 8-253, `hi3516v100--Hi3516-Datasheet.txt` line 50202).";

        field {
            name = "table_data3n";
            desc = "Table data3n. Chinese-only data sheet: description and value encoding not translated.";
            sw = rw;
            hw = r;
            reset = 0x0;
        } table_data3n[29:20];

        field {
            name = "table_data2n";
            desc = "Table data2n. Chinese-only data sheet: description and value encoding not translated.";
            sw = rw;
            hw = r;
            reset = 0x0;
        } table_data2n[19:10];

        field {
            name = "table_data1n";
            desc = "Table data1n. Chinese-only data sheet: description and value encoding not translated.";
            sw = rw;
            hw = r;
            reset = 0x0;
        } table_data1n[9:0];
    } VSDACCHIGHN[3] @ 0x830 += 0x4;

    reg {
        name = "VSDACCMLN";
        desc = "Data sheet 8.2.5 VSDACCMLN (offset 0x840, printed page 8-254, `hi3516v100--Hi3516-Datasheet.txt` line 50244).";

        field {
            name = "table_data3n";
            desc = "Table data3n. Chinese-only data sheet: description and value encoding not translated.";
            sw = rw;
            hw = r;
            reset = 0x0;
        } table_data3n[29:20];

        field {
            name = "table_data2n";
            desc = "Table data2n. Chinese-only data sheet: description and value encoding not translated.";
            sw = rw;
            hw = r;
            reset = 0x0;
        } table_data2n[19:10];

        field {
            name = "table_data1n";
            desc = "Table data1n. Chinese-only data sheet: description and value encoding not translated.";
            sw = rw;
            hw = r;
            reset = 0x0;
        } table_data1n[9:0];
    } VSDACCMLN[3] @ 0x840 += 0x4;

    reg {
        name = "VSDACCMHN";
        desc = "Data sheet 8.2.5 VSDACCMHN (offset 0x850, printed page 8-254, `hi3516v100--Hi3516-Datasheet.txt` line 50274).";

        field {
            name = "table_data3n";
            desc = "Table data3n. Chinese-only data sheet: description and value encoding not translated.";
            sw = rw;
            hw = r;
            reset = 0x0;
        } table_data3n[29:20];

        field {
            name = "table_data2n";
            desc = "Table data2n. Chinese-only data sheet: description and value encoding not translated.";
            sw = rw;
            hw = r;
            reset = 0x0;
        } table_data2n[19:10];

        field {
            name = "table_data1n";
            desc = "Table data1n. Chinese-only data sheet: description and value encoding not translated.";
            sw = rw;
            hw = r;
            reset = 0x0;
        } table_data1n[9:0];
    } VSDACCMHN[3] @ 0x850 += 0x4;

    reg {
        name = "VSDACC3LOW";
        desc = "Data sheet 8.2.5 VSDACC3LOW (offset 0x860, printed page 8-255, `hi3516v100--Hi3516-Datasheet.txt` line 50316).";

        field {
            name = "cnt3_low";
            desc = "Cnt3 low. Chinese-only data sheet: description and value encoding not translated.";
            sw = r;
            hw = w;
            reset = 0x0;
        } cnt3_low[20:0];
    } VSDACC3LOW @ 0x860;

    reg {
        name = "VSDACC3MED";
        desc = "Data sheet 8.2.5 VSDACC3MED (offset 0x864, printed page 8-255, `hi3516v100--Hi3516-Datasheet.txt` line 50337).";

        field {
            name = "cnt3_med";
            desc = "Cnt3 med. Chinese-only data sheet: description and value encoding not translated.";
            sw = r;
            hw = w;
            reset = 0x0;
        } cnt3_med[20:0];
    } VSDACC3MED @ 0x864;

    reg {
        name = "VSDACC3HIGH";
        desc = "Data sheet 8.2.5 VSDACC3HIGH (offset 0x868, printed page 8-256, `hi3516v100--Hi3516-Datasheet.txt` line 50370).";

        field {
            name = "cnt3_high";
            desc = "Cnt3 high. Chinese-only data sheet: description and value encoding not translated.";
            sw = r;
            hw = w;
            reset = 0x0;
        } cnt3_high[20:0];
    } VSDACC3HIGH @ 0x868;

    reg {
        name = "VSDACC8MLOW";
        desc = "Data sheet 8.2.5 VSDACC8MLOW (offset 0x86C, printed page 8-256, `hi3516v100--Hi3516-Datasheet.txt` line 50391).";

        field {
            name = "cnt8_med_low";
            desc = "Cnt8 med low. Chinese-only data sheet: description and value encoding not translated.";
            sw = r;
            hw = w;
            reset = 0x0;
        } cnt8_med_low[20:0];
    } VSDACC8MLOW @ 0x86C;

    reg {
        name = "VSDACC8MHIGH";
        desc = "Data sheet 8.2.5 VSDACC8MHIGH (offset 0x870, printed page 8-256, `hi3516v100--Hi3516-Datasheet.txt` line 50412).";

        field {
            name = "cnt8_med_high";
            desc = "Cnt8 med high. Chinese-only data sheet: description and value encoding not translated.";
            sw = r;
            hw = w;
            reset = 0x0;
        } cnt8_med_high[20:0];
    } VSDACC8MHIGH @ 0x870;

    reg {
        name = "VSDACCTOTAL";
        desc = "Data sheet 8.2.5 VSDACCTOTAL (offset 0x874, printed page 8-257, `hi3516v100--Hi3516-Datasheet.txt` line 50444).";

        field {
            name = "acc_pix_total";
            desc = "ACC pix total. Chinese-only data sheet: description and value encoding not translated.";
            sw = r;
            hw = w;
            reset = 0x0;
        } acc_pix_total[20:0];
    } VSDACCTOTAL @ 0x874;

    reg {
        name = "VSDIFIRCOEF01";
        desc = "Data sheet 8.2.5 VSDIFIRCOEF01 (offset 0x880, printed page 8-257, `hi3516v100--Hi3516-Datasheet.txt` line 50465).";

        field {
            name = "coef1";
            desc = "Coef1. Chinese-only data sheet: description and value encoding not translated.";
            sw = rw;
            hw = r;
            reset = 0xD;
        } coef1[25:16];

        field {
            name = "coef0";
            desc = "Coef0. Chinese-only data sheet: description and value encoding not translated.";
            sw = rw;
            hw = r;
            reset = 0x0;
        } coef0[9:0];
    } VSDIFIRCOEF01 @ 0x880;

    reg {
        name = "VSDIFIRCOEF23";
        desc = "Data sheet 8.2.5 VSDIFIRCOEF23 (offset 0x884, printed page 8-258, `hi3516v100--Hi3516-Datasheet.txt` line 50499).";

        field {
            name = "coef3";
            desc = "Coef3. Chinese-only data sheet: description and value encoding not translated.";
            sw = rw;
            hw = r;
            reset = 0x132;
        } coef3[25:16];

        field {
            name = "coef2";
            desc = "Coef2. Chinese-only data sheet: description and value encoding not translated.";
            sw = rw;
            hw = r;
            reset = 0x3C1;
        } coef2[9:0];
    } VSDIFIRCOEF23 @ 0x884;

    reg {
        name = "VSDIFIRCOEF45";
        desc = "Data sheet 8.2.5 VSDIFIRCOEF45 (offset 0x888, printed page 8-258, `hi3516v100--Hi3516-Datasheet.txt` line 50524).";

        field {
            name = "coef5";
            desc = "Coef5. Chinese-only data sheet: description and value encoding not translated.";
            sw = rw;
            hw = r;
            reset = 0x3C;
        } coef5[25:16];

        field {
            name = "coef4";
            desc = "Coef4. Chinese-only data sheet: description and value encoding not translated.";
            sw = rw;
            hw = r;
            reset = 0x132;
        } coef4[9:0];
    } VSDIFIRCOEF45 @ 0x888;

    reg {
        name = "VSDIFIRCOEF67";
        desc = "Data sheet 8.2.5 VSDIFIRCOEF67 (offset 0x88C, printed page 8-259, `hi3516v100--Hi3516-Datasheet.txt` line 50561).";

        field {
            name = "coef7";
            desc = "Coef7. Chinese-only data sheet: description and value encoding not translated.";
            sw = rw;
            hw = r;
            reset = 0x0;
        } coef7[25:16];

        field {
            name = "coef6";
            desc = "Coef6. Chinese-only data sheet: description and value encoding not translated.";
            sw = rw;
            hw = r;
            reset = 0xD;
        } coef6[9:0];
    } VSDIFIRCOEF67 @ 0x88C;

    reg {
        name = "G0CTRL";
        desc = "Data sheet 8.2.5 G0CTRL (offset 0x900, printed page 8-259, `hi3516v100--Hi3516-Datasheet.txt` line 50586).";

        field {
            name = "upd_mode";
            desc = "Update mode. Chinese-only data sheet: description and value encoding not translated.";
            sw = rw;
            hw = r;
            reset = 0x0;
        } upd_mode[27:27];

        field {
            name = "read_mode";
            desc = "Read mode. Chinese-only data sheet: description and value encoding not translated.";
            sw = rw;
            hw = r;
            reset = 0x0;
        } read_mode[26:26];

        field {
            name = "bitext";
            desc = "Bitext. Chinese-only data sheet: description and value encoding not translated.";
            sw = rw;
            hw = r;
            reset = 0x0;
        } bitext[9:8];

        field {
            name = "ifmt";
            desc = "Input format. Chinese-only data sheet: description and value encoding not translated.";
            sw = rw;
            hw = r;
            reset = 0x0;
        } ifmt[7:0];
    } G0CTRL @ 0x900;

    reg {
        name = "G0UPD";
        desc = "Data sheet 8.2.5 G0UPD (offset 0x904, printed page 8-260, `hi3516v100--Hi3516-Datasheet.txt` line 50644).";

        field {
            name = "regup";
            desc = "Regup. Chinese-only data sheet: description and value encoding not translated.";
            sw = rw;
            hw = r;
            reset = 0x0;
        } regup[0:0];
    } G0UPD @ 0x904;

    reg {
        name = "G0CBMPARA";
        desc = "Data sheet 8.2.5 G0CBMPARA (offset 0x910, printed page 8-261, `hi3516v100--Hi3516-Datasheet.txt` line 50684).";

        field {
            name = "palpha_en";
            desc = "Palpha enable. Chinese-only data sheet: description and value encoding not translated.";
            sw = rw;
            hw = r;
            reset = 0x0;
        } palpha_en[12:12];

        field {
            name = "palpha_range";
            desc = "Palpha range. Chinese-only data sheet: description and value encoding not translated.";
            sw = rw;
            hw = r;
            reset = 0x0;
        } palpha_range[8:8];

        field {
            name = "galpha";
            desc = "Galpha. Chinese-only data sheet: description and value encoding not translated.";
            sw = rw;
            hw = r;
            reset = 0x0;
        } galpha[7:0];
    } G0CBMPARA @ 0x910;

    reg {
        name = "G0CKMAX";
        desc = "Data sheet 8.2.5 G0CKMAX (offset 0x914, printed page 8-262, `hi3516v100--Hi3516-Datasheet.txt` line 50737).";

        field {
            name = "va0";
            desc = "Va0. Chinese-only data sheet: description and value encoding not translated.";
            sw = rw;
            hw = r;
            reset = 0x0;
        } va0[31:24];
    } G0CKMAX @ 0x914;

    reg {
        name = "G0CKMIN";
        desc = "Data sheet 8.2.5 G0CKMIN (offset 0x918, printed page 8-262, `hi3516v100--Hi3516-Datasheet.txt` line 50760).";

        field {
            name = "va1";
            desc = "Va1. Chinese-only data sheet: description and value encoding not translated.";
            sw = rw;
            hw = r;
            reset = 0x0;
        } va1[31:24];
    } G0CKMIN @ 0x918;

    reg {
        name = "G0IRESO";
        desc = "Data sheet 8.2.5 G0IRESO (offset 0x920, printed page 8-263, `hi3516v100--Hi3516-Datasheet.txt` line 50798).";

        field {
            name = "ih";
            desc = "Ih. Chinese-only data sheet: description and value encoding not translated.";
            sw = rw;
            hw = r;
            reset = 0x0;
        } ih[23:12];

        field {
            name = "iw";
            desc = "Iw. Chinese-only data sheet: description and value encoding not translated.";
            sw = rw;
            hw = r;
            reset = 0x0;
        } iw[11:0];
    } G0IRESO @ 0x920;

    reg {
        name = "G0ORESO";
        desc = "Data sheet 8.2.5 G0ORESO (offset 0x924, printed page 8-263, `hi3516v100--Hi3516-Datasheet.txt` line 50825).";

        field {
            name = "oh";
            desc = "Oh. Chinese-only data sheet: description and value encoding not translated.";
            sw = rw;
            hw = r;
            reset = 0x0;
        } oh[23:12];

        field {
            name = "ow";
            desc = "Ow. Chinese-only data sheet: description and value encoding not translated.";
            sw = rw;
            hw = r;
            reset = 0x0;
        } ow[11:7];

        field {
            name = "src_xfpos";
            desc = "Source xfpos. Chinese-only data sheet: description and value encoding not translated.";
            sw = rw;
            hw = r;
            reset = 0x0;
        } src_xfpos[6:0];
    } G0ORESO @ 0x924;

    reg {
        name = "G0DFPOS";
        desc = "Data sheet 8.2.5 G0DFPOS (offset 0x92C, printed page 8-264, `hi3516v100--Hi3516-Datasheet.txt` line 50864).";

        field {
            name = "disp_yfpos";
            desc = "Disp yfpos. Chinese-only data sheet: description and value encoding not translated.";
            sw = rw;
            hw = r;
            reset = 0x0;
        } disp_yfpos[23:12];

        field {
            name = "disp_xfpos";
            desc = "Disp xfpos. Chinese-only data sheet: description and value encoding not translated.";
            sw = rw;
            hw = r;
            reset = 0x0;
        } disp_xfpos[11:0];
    } G0DFPOS @ 0x92C;

    reg {
        name = "G0DLPOS";
        desc = "Data sheet 8.2.5 G0DLPOS (offset 0x930, printed page 8-264, `hi3516v100--Hi3516-Datasheet.txt` line 50889).";

        field {
            name = "disp_ylpos";
            desc = "Disp ylpos. Chinese-only data sheet: description and value encoding not translated.";
            sw = rw;
            hw = r;
            reset = 0x0;
        } disp_ylpos[23:12];

        field {
            name = "disp_xlpos";
            desc = "Disp xlpos. Chinese-only data sheet: description and value encoding not translated.";
            sw = rw;
            hw = r;
            reset = 0x0;
        } disp_xlpos[11:0];
    } G0DLPOS @ 0x930;

    reg {
        name = "G0CSCIDC";
        desc = "Data sheet 8.2.5 G0CSCIDC (offset 0x9A0, printed page 8-265, `hi3516v100--Hi3516-Datasheet.txt` line 50926).";

        field {
            name = "csc_en";
            desc = "Colour-space conversion enable. Chinese-only data sheet: description and value encoding not translated.";
            sw = rw;
            hw = r;
            reset = 0x0;
        } csc_en[27:27];

        field {
            name = "cscidc2";
            desc = "Cscidc2. Chinese-only data sheet: description and value encoding not translated.";
            sw = rw;
            hw = r;
            reset = 0x0;
        } cscidc2[26:18];

        field {
            name = "cscidc1";
            desc = "Cscidc1. Chinese-only data sheet: description and value encoding not translated.";
            sw = rw;
            hw = r;
            reset = 0x0;
        } cscidc1[17:9];

        field {
            name = "cscidc0";
            desc = "Cscidc0. Chinese-only data sheet: description and value encoding not translated.";
            sw = rw;
            hw = r;
            reset = 0x0;
        } cscidc0[8:0];
    } G0CSCIDC @ 0x9A0;

    reg {
        name = "G0CSCODC";
        desc = "Data sheet 8.2.5 G0CSCODC (offset 0x9A4, printed page 8-265, `hi3516v100--Hi3516-Datasheet.txt` line 50957).";

        field {
            name = "cscodc2";
            desc = "Cscodc2. Chinese-only data sheet: description and value encoding not translated.";
            sw = rw;
            hw = r;
            reset = 0x0;
        } cscodc2[26:18];

        field {
            name = "cscodc1";
            desc = "Cscodc1. Chinese-only data sheet: description and value encoding not translated.";
            sw = rw;
            hw = r;
            reset = 0x0;
        } cscodc1[17:9];

        field {
            name = "cscodc0";
            desc = "Cscodc0. Chinese-only data sheet: description and value encoding not translated.";
            sw = rw;
            hw = r;
            reset = 0x0;
        } cscodc0[8:0];
    } G0CSCODC @ 0x9A4;

    reg {
        name = "G0CSCP0";
        desc = "Data sheet 8.2.5 G0CSCP0 (offset 0x9A8, printed page 8-266, `hi3516v100--Hi3516-Datasheet.txt` line 50990).";

        field {
            name = "cscp01";
            desc = "Cscp01. Chinese-only data sheet: description and value encoding not translated.";
            sw = rw;
            hw = r;
            reset = 0x0;
        } cscp01[28:16];

        field {
            name = "cscp00";
            desc = "Cscp00. Chinese-only data sheet: description and value encoding not translated.";
            sw = rw;
            hw = r;
            reset = 0x0;
        } cscp00[12:0];
    } G0CSCP0 @ 0x9A8;

    reg {
        name = "G0CSCP1";
        desc = "Data sheet 8.2.5 G0CSCP1 (offset 0x9AC, printed page 8-266, `hi3516v100--Hi3516-Datasheet.txt` line 51024).";

        field {
            name = "cscp10";
            desc = "Cscp10. Chinese-only data sheet: description and value encoding not translated.";
            sw = rw;
            hw = r;
            reset = 0x0;
        } cscp10[28:16];

        field {
            name = "cscp02";
            desc = "Cscp02. Chinese-only data sheet: description and value encoding not translated.";
            sw = rw;
            hw = r;
            reset = 0x0;
        } cscp02[12:0];
    } G0CSCP1 @ 0x9AC;

    reg {
        name = "G0CSCP2";
        desc = "Data sheet 8.2.5 G0CSCP2 (offset 0x9B0, printed page 8-267, `hi3516v100--Hi3516-Datasheet.txt` line 51070).";

        field {
            name = "cscp12";
            desc = "Cscp12. Chinese-only data sheet: description and value encoding not translated.";
            sw = rw;
            hw = r;
            reset = 0x0;
        } cscp12[28:16];

        field {
            name = "cscp11";
            desc = "Cscp11. Chinese-only data sheet: description and value encoding not translated.";
            sw = rw;
            hw = r;
            reset = 0x0;
        } cscp11[12:0];
    } G0CSCP2 @ 0x9B0;

    reg {
        name = "G0CSCP3";
        desc = "Data sheet 8.2.5 G0CSCP3 (offset 0x9B4, printed page 8-268, `hi3516v100--Hi3516-Datasheet.txt` line 51116).";

        field {
            name = "cscp21";
            desc = "Cscp21. Chinese-only data sheet: description and value encoding not translated.";
            sw = rw;
            hw = r;
            reset = 0x0;
        } cscp21[28:16];

        field {
            name = "cscp20";
            desc = "Cscp20. Chinese-only data sheet: description and value encoding not translated.";
            sw = rw;
            hw = r;
            reset = 0x0;
        } cscp20[12:0];
    } G0CSCP3 @ 0x9B4;

    reg {
        name = "G0CSCP4";
        desc = "Data sheet 8.2.5 G0CSCP4 (offset 0x9B8, printed page 8-268, `hi3516v100--Hi3516-Datasheet.txt` line 51150).";

        field {
            name = "cscp22";
            desc = "Cscp22. Chinese-only data sheet: description and value encoding not translated.";
            sw = rw;
            hw = r;
            reset = 0x0;
        } cscp22[12:0];
    } G0CSCP4 @ 0x9B8;

    reg {
        name = "G0P0ADDR";
        desc = "Data sheet 8.2.5 G0P0ADDR (offset 0xA00, printed page 8-269, `hi3516v100--Hi3516-Datasheet.txt` line 51187).";

        field {
            name = "surface_addr";
            desc = "Surface address. Chinese-only data sheet: description and value encoding not translated.";
            sw = rw;
            hw = r;
            reset = 0x0;
        } surface_addr[31:0];
    } G0P0ADDR @ 0xA00;

    reg {
        name = "G0P0STRIDE";
        desc = "Data sheet 8.2.5 G0P0STRIDE (offset 0xA04, printed page 8-269, `hi3516v100--Hi3516-Datasheet.txt` line 51206).";

        field {
            name = "surface_stride";
            desc = "Surface stride. Chinese-only data sheet: description and value encoding not translated.";
            sw = rw;
            hw = r;
            reset = 0x0;
        } surface_stride[15:0];
    } G0P0STRIDE @ 0xA04;

    reg {
        name = "G0P0DFPOS";
        desc = "Data sheet 8.2.5 G0P0DFPOS (offset 0xA08, printed page 8-270, `hi3516v100--Hi3516-Datasheet.txt` line 51240).";

        field {
            name = "yfpos";
            desc = "Yfpos. Chinese-only data sheet: description and value encoding not translated.";
            sw = rw;
            hw = r;
            reset = 0x0;
        } yfpos[23:12];

        field {
            name = "xfpos";
            desc = "Xfpos. Chinese-only data sheet: description and value encoding not translated.";
            sw = rw;
            hw = r;
            reset = 0x0;
        } xfpos[11:0];
    } G0P0DFPOS @ 0xA08;

    reg {
        name = "G0P0DLPOS";
        desc = "Data sheet 8.2.5 G0P0DLPOS (offset 0xA0C, printed page 8-270, `hi3516v100--Hi3516-Datasheet.txt` line 51266).";

        field {
            name = "ylpos";
            desc = "Ylpos. Chinese-only data sheet: description and value encoding not translated.";
            sw = rw;
            hw = r;
            reset = 0x0;
        } ylpos[23:12];

        field {
            name = "xlpos";
            desc = "Xlpos. Chinese-only data sheet: description and value encoding not translated.";
            sw = rw;
            hw = r;
            reset = 0x0;
        } xlpos[11:0];
    } G0P0DLPOS @ 0xA0C;

    reg {
        name = "G0P0RESO";
        desc = "Data sheet 8.2.5 G0P0RESO (offset 0xA10, printed page 8-271, `hi3516v100--Hi3516-Datasheet.txt` line 51304).";

        field {
            name = "h";
            desc = "H. Chinese-only data sheet: description and value encoding not translated.";
            sw = rw;
            hw = r;
            reset = 0x0;
        } h[23:12];

        field {
            name = "w";
            desc = "W. Chinese-only data sheet: description and value encoding not translated.";
            sw = rw;
            hw = r;
            reset = 0x0;
        } w_f[11:0];
    } G0P0RESO @ 0xA10;

    reg {
        name = "G0P1ADDR";
        desc = "Data sheet 8.2.5 G0P1ADDR (offset 0xA14, printed page 8-271, `hi3516v100--Hi3516-Datasheet.txt` line 51331).";

        field {
            name = "surface_addr";
            desc = "Surface address. Chinese-only data sheet: description and value encoding not translated.";
            sw = rw;
            hw = r;
            reset = 0x0;
        } surface_addr[31:0];
    } G0P1ADDR @ 0xA14;

    reg {
        name = "G0P1STRIDE";
        desc = "Data sheet 8.2.5 G0P1STRIDE (offset 0xA18, printed page 8-272, `hi3516v100--Hi3516-Datasheet.txt` line 51362).";

        field {
            name = "surface_stride";
            desc = "Surface stride. Chinese-only data sheet: description and value encoding not translated.";
            sw = rw;
            hw = r;
            reset = 0x0;
        } surface_stride[15:0];
    } G0P1STRIDE @ 0xA18;

    reg {
        name = "G0P1DFPOS";
        desc = "Data sheet 8.2.5 G0P1DFPOS (offset 0xA1C, printed page 8-272, `hi3516v100--Hi3516-Datasheet.txt` line 51384).";

        field {
            name = "yfpos";
            desc = "Yfpos. Chinese-only data sheet: description and value encoding not translated.";
            sw = rw;
            hw = r;
            reset = 0x0;
        } yfpos[23:12];

        field {
            name = "xfpos";
            desc = "Xfpos. Chinese-only data sheet: description and value encoding not translated.";
            sw = rw;
            hw = r;
            reset = 0x0;
        } xfpos[11:0];
    } G0P1DFPOS @ 0xA1C;

    reg {
        name = "G0P1DLPOS";
        desc = "Data sheet 8.2.5 G0P1DLPOS (offset 0xA20, printed page 8-273, `hi3516v100--Hi3516-Datasheet.txt` line 51425).";

        field {
            name = "ylpos";
            desc = "Ylpos. Chinese-only data sheet: description and value encoding not translated.";
            sw = rw;
            hw = r;
            reset = 0x0;
        } ylpos[23:12];

        field {
            name = "xlpos";
            desc = "Xlpos. Chinese-only data sheet: description and value encoding not translated.";
            sw = rw;
            hw = r;
            reset = 0x0;
        } xlpos[11:0];
    } G0P1DLPOS @ 0xA20;

    reg {
        name = "G0P1RESO";
        desc = "Data sheet 8.2.5 G0P1RESO (offset 0xA24, printed page 8-273, `hi3516v100--Hi3516-Datasheet.txt` line 51448).";

        field {
            name = "h";
            desc = "H. Chinese-only data sheet: description and value encoding not translated.";
            sw = rw;
            hw = r;
            reset = 0x0;
        } h[23:12];

        field {
            name = "w";
            desc = "W. Chinese-only data sheet: description and value encoding not translated.";
            sw = rw;
            hw = r;
            reset = 0x0;
        } w_f[11:0];
    } G0P1RESO @ 0xA24;

    reg {
        name = "G0P2ADDR";
        desc = "Data sheet 8.2.5 G0P2ADDR (offset 0xA28, printed page 8-274, `hi3516v100--Hi3516-Datasheet.txt` line 51487).";

        field {
            name = "surface_addr";
            desc = "Surface address. Chinese-only data sheet: description and value encoding not translated.";
            sw = rw;
            hw = r;
            reset = 0x0;
        } surface_addr[31:0];
    } G0P2ADDR @ 0xA28;

    reg {
        name = "G0P2STRIDE";
        desc = "Data sheet 8.2.5 G0P2STRIDE (offset 0xA2C, printed page 8-274, `hi3516v100--Hi3516-Datasheet.txt` line 51506).";

        field {
            name = "surface_stride";
            desc = "Surface stride. Chinese-only data sheet: description and value encoding not translated.";
            sw = rw;
            hw = r;
            reset = 0x0;
        } surface_stride[15:0];
    } G0P2STRIDE @ 0xA2C;

    reg {
        name = "G0P2DFPOS";
        desc = "Data sheet 8.2.5 G0P2DFPOS (offset 0xA30, printed page 8-274, `hi3516v100--Hi3516-Datasheet.txt` line 51528).";

        field {
            name = "yfpos";
            desc = "Yfpos. Chinese-only data sheet: description and value encoding not translated.";
            sw = rw;
            hw = r;
            reset = 0x0;
        } yfpos[23:12];

        field {
            name = "xfpos";
            desc = "Xfpos. Chinese-only data sheet: description and value encoding not translated.";
            sw = rw;
            hw = r;
            reset = 0x0;
        } xfpos[11:0];
    } G0P2DFPOS @ 0xA30;

    reg {
        name = "G0P2DLPOS";
        desc = "Data sheet 8.2.5 G0P2DLPOS (offset 0xA34, printed page 8-275, `hi3516v100--Hi3516-Datasheet.txt` line 51566).";

        field {
            name = "ylpos";
            desc = "Ylpos. Chinese-only data sheet: description and value encoding not translated.";
            sw = rw;
            hw = r;
            reset = 0x0;
        } ylpos[23:12];

        field {
            name = "xlpos";
            desc = "Xlpos. Chinese-only data sheet: description and value encoding not translated.";
            sw = rw;
            hw = r;
            reset = 0x0;
        } xlpos[11:0];
    } G0P2DLPOS @ 0xA34;

    reg {
        name = "G0P2RESO";
        desc = "Data sheet 8.2.5 G0P2RESO (offset 0xA38, printed page 8-275, `hi3516v100--Hi3516-Datasheet.txt` line 51589).";

        field {
            name = "h";
            desc = "H. Chinese-only data sheet: description and value encoding not translated.";
            sw = rw;
            hw = r;
            reset = 0x0;
        } h[23:12];

        field {
            name = "w";
            desc = "W. Chinese-only data sheet: description and value encoding not translated.";
            sw = rw;
            hw = r;
            reset = 0x0;
        } w_f[11:0];
    } G0P2RESO @ 0xA38;

    reg {
        name = "G0P3ADDR";
        desc = "Data sheet 8.2.5 G0P3ADDR (offset 0xA3C, printed page 8-276, `hi3516v100--Hi3516-Datasheet.txt` line 51627).";

        field {
            name = "surface_addr";
            desc = "Surface address. Chinese-only data sheet: description and value encoding not translated.";
            sw = rw;
            hw = r;
            reset = 0x0;
        } surface_addr[31:0];
    } G0P3ADDR @ 0xA3C;

    reg {
        name = "G0P3STRIDE";
        desc = "Data sheet 8.2.5 G0P3STRIDE (offset 0xA40, printed page 8-276, `hi3516v100--Hi3516-Datasheet.txt` line 51646).";

        field {
            name = "surface_stride";
            desc = "Surface stride. Chinese-only data sheet: description and value encoding not translated.";
            sw = rw;
            hw = r;
            reset = 0x0;
        } surface_stride[15:0];
    } G0P3STRIDE @ 0xA40;

    reg {
        name = "G0P3DFPOS";
        desc = "Data sheet 8.2.5 G0P3DFPOS (offset 0xA44, printed page 8-277, `hi3516v100--Hi3516-Datasheet.txt` line 51680).";

        field {
            name = "yfpos";
            desc = "Yfpos. Chinese-only data sheet: description and value encoding not translated.";
            sw = rw;
            hw = r;
            reset = 0x0;
        } yfpos[23:12];

        field {
            name = "xfpos";
            desc = "Xfpos. Chinese-only data sheet: description and value encoding not translated.";
            sw = rw;
            hw = r;
            reset = 0x0;
        } xfpos[11:0];
    } G0P3DFPOS @ 0xA44;

    reg {
        name = "G0P3DLPOS";
        desc = "Data sheet 8.2.5 G0P3DLPOS (offset 0xA48, printed page 8-277, `hi3516v100--Hi3516-Datasheet.txt` line 51706).";

        field {
            name = "ylpos";
            desc = "Ylpos. Chinese-only data sheet: description and value encoding not translated.";
            sw = rw;
            hw = r;
            reset = 0x0;
        } ylpos[23:12];

        field {
            name = "xlpos";
            desc = "Xlpos. Chinese-only data sheet: description and value encoding not translated.";
            sw = rw;
            hw = r;
            reset = 0x0;
        } xlpos[11:0];
    } G0P3DLPOS @ 0xA48;

    reg {
        name = "G0P3RESO";
        desc = "Data sheet 8.2.5 G0P3RESO (offset 0xA4C, printed page 8-278, `hi3516v100--Hi3516-Datasheet.txt` line 51738).";

        field {
            name = "h";
            desc = "H. Chinese-only data sheet: description and value encoding not translated.";
            sw = rw;
            hw = r;
            reset = 0x0;
        } h[23:12];

        field {
            name = "w";
            desc = "W. Chinese-only data sheet: description and value encoding not translated.";
            sw = rw;
            hw = r;
            reset = 0x0;
        } w_f[11:0];
    } G0P3RESO @ 0xA4C;

    reg {
        name = "G0P4ADDR";
        desc = "Data sheet 8.2.5 G0P4ADDR (offset 0xA50, printed page 8-278, `hi3516v100--Hi3516-Datasheet.txt` line 51765).";

        field {
            name = "surface_addr";
            desc = "Surface address. Chinese-only data sheet: description and value encoding not translated.";
            sw = rw;
            hw = r;
            reset = 0x0;
        } surface_addr[31:0];
    } G0P4ADDR @ 0xA50;

    reg {
        name = "G0P4STRIDE";
        desc = "Data sheet 8.2.5 G0P4STRIDE (offset 0xA54, printed page 8-279, `hi3516v100--Hi3516-Datasheet.txt` line 51799).";

        field {
            name = "surface_stride";
            desc = "Surface stride. Chinese-only data sheet: description and value encoding not translated.";
            sw = rw;
            hw = r;
            reset = 0x0;
        } surface_stride[15:0];
    } G0P4STRIDE @ 0xA54;

    reg {
        name = "G0P4DFPOS";
        desc = "Data sheet 8.2.5 G0P4DFPOS (offset 0xA58, printed page 8-279, `hi3516v100--Hi3516-Datasheet.txt` line 51821).";

        field {
            name = "yfpos";
            desc = "Yfpos. Chinese-only data sheet: description and value encoding not translated.";
            sw = rw;
            hw = r;
            reset = 0x0;
        } yfpos[23:12];

        field {
            name = "xfpos";
            desc = "Xfpos. Chinese-only data sheet: description and value encoding not translated.";
            sw = rw;
            hw = r;
            reset = 0x0;
        } xfpos[11:0];
    } G0P4DFPOS @ 0xA58;

    reg {
        name = "G0P4DLPOS";
        desc = "Data sheet 8.2.5 G0P4DLPOS (offset 0xA5C, printed page 8-280, `hi3516v100--Hi3516-Datasheet.txt` line 51859).";

        field {
            name = "ylpos";
            desc = "Ylpos. Chinese-only data sheet: description and value encoding not translated.";
            sw = rw;
            hw = r;
            reset = 0x0;
        } ylpos[23:12];

        field {
            name = "xlpos";
            desc = "Xlpos. Chinese-only data sheet: description and value encoding not translated.";
            sw = rw;
            hw = r;
            reset = 0x0;
        } xlpos[11:0];
    } G0P4DLPOS @ 0xA5C;

    reg {
        name = "G0P4RESO";
        desc = "Data sheet 8.2.5 G0P4RESO (offset 0xA60, printed page 8-280, `hi3516v100--Hi3516-Datasheet.txt` line 51882).";

        field {
            name = "h";
            desc = "H. Chinese-only data sheet: description and value encoding not translated.";
            sw = rw;
            hw = r;
            reset = 0x0;
        } h[23:12];

        field {
            name = "w";
            desc = "W. Chinese-only data sheet: description and value encoding not translated.";
            sw = rw;
            hw = r;
            reset = 0x0;
        } w_f[11:0];
    } G0P4RESO @ 0xA60;

    reg {
        name = "G0P5ADDR";
        desc = "Data sheet 8.2.5 G0P5ADDR (offset 0xA64, printed page 8-281, `hi3516v100--Hi3516-Datasheet.txt` line 51924).";

        field {
            name = "surface_addr";
            desc = "Surface address. Chinese-only data sheet: description and value encoding not translated.";
            sw = rw;
            hw = r;
            reset = 0x0;
        } surface_addr[31:0];
    } G0P5ADDR @ 0xA64;

    reg {
        name = "G0P5STRIDE";
        desc = "Data sheet 8.2.5 G0P5STRIDE (offset 0xA68, printed page 8-281, `hi3516v100--Hi3516-Datasheet.txt` line 51943).";

        field {
            name = "surface_stride";
            desc = "Surface stride. Chinese-only data sheet: description and value encoding not translated.";
            sw = rw;
            hw = r;
            reset = 0x0;
        } surface_stride[15:0];
    } G0P5STRIDE @ 0xA68;

    reg {
        name = "G0P5DFPOS";
        desc = "Data sheet 8.2.5 G0P5DFPOS (offset 0xA6C, printed page 8-282, `hi3516v100--Hi3516-Datasheet.txt` line 51977).";

        field {
            name = "yfpos";
            desc = "Yfpos. Chinese-only data sheet: description and value encoding not translated.";
            sw = rw;
            hw = r;
            reset = 0x0;
        } yfpos[23:12];

        field {
            name = "xfpos";
            desc = "Xfpos. Chinese-only data sheet: description and value encoding not translated.";
            sw = rw;
            hw = r;
            reset = 0x0;
        } xfpos[11:0];
    } G0P5DFPOS @ 0xA6C;

    reg {
        name = "G0P5DLPOS";
        desc = "Data sheet 8.2.5 G0P5DLPOS (offset 0xA70, printed page 8-282, `hi3516v100--Hi3516-Datasheet.txt` line 52003).";

        field {
            name = "ylpos";
            desc = "Ylpos. Chinese-only data sheet: description and value encoding not translated.";
            sw = rw;
            hw = r;
            reset = 0x0;
        } ylpos[23:12];

        field {
            name = "xlpos";
            desc = "Xlpos. Chinese-only data sheet: description and value encoding not translated.";
            sw = rw;
            hw = r;
            reset = 0x0;
        } xlpos[11:0];
    } G0P5DLPOS @ 0xA70;

    reg {
        name = "G0P5RESO";
        desc = "Data sheet 8.2.5 G0P5RESO (offset 0xA74, printed page 8-283, `hi3516v100--Hi3516-Datasheet.txt` line 52041).";

        field {
            name = "h";
            desc = "H. Chinese-only data sheet: description and value encoding not translated.";
            sw = rw;
            hw = r;
            reset = 0x0;
        } h[23:12];

        field {
            name = "w";
            desc = "W. Chinese-only data sheet: description and value encoding not translated.";
            sw = rw;
            hw = r;
            reset = 0x0;
        } w_f[11:0];
    } G0P5RESO @ 0xA74;

    reg {
        name = "G0P6ADDR";
        desc = "Data sheet 8.2.5 G0P6ADDR (offset 0xA78, printed page 8-283, `hi3516v100--Hi3516-Datasheet.txt` line 52068).";

        field {
            name = "surface_addr";
            desc = "Surface address. Chinese-only data sheet: description and value encoding not translated.";
            sw = rw;
            hw = r;
            reset = 0x0;
        } surface_addr[31:0];
    } G0P6ADDR @ 0xA78;

    reg {
        name = "G0P6STRIDE";
        desc = "Data sheet 8.2.5 G0P6STRIDE (offset 0xA7C, printed page 8-284, `hi3516v100--Hi3516-Datasheet.txt` line 52099).";

        field {
            name = "surface_stride";
            desc = "Surface stride. Chinese-only data sheet: description and value encoding not translated.";
            sw = rw;
            hw = r;
            reset = 0x0;
        } surface_stride[15:0];
    } G0P6STRIDE @ 0xA7C;

    reg {
        name = "G0P6DFPOS";
        desc = "Data sheet 8.2.5 G0P6DFPOS (offset 0xA80, printed page 8-284, `hi3516v100--Hi3516-Datasheet.txt` line 52121).";

        field {
            name = "yfpos";
            desc = "Yfpos. Chinese-only data sheet: description and value encoding not translated.";
            sw = rw;
            hw = r;
            reset = 0x0;
        } yfpos[23:12];

        field {
            name = "xfpos";
            desc = "Xfpos. Chinese-only data sheet: description and value encoding not translated.";
            sw = rw;
            hw = r;
            reset = 0x0;
        } xfpos[11:0];
    } G0P6DFPOS @ 0xA80;

    reg {
        name = "G0P6DLPOS";
        desc = "Data sheet 8.2.5 G0P6DLPOS (offset 0xA84, printed page 8-285, `hi3516v100--Hi3516-Datasheet.txt` line 52162).";

        field {
            name = "ylpos";
            desc = "Ylpos. Chinese-only data sheet: description and value encoding not translated.";
            sw = rw;
            hw = r;
            reset = 0x0;
        } ylpos[23:12];

        field {
            name = "xlpos";
            desc = "Xlpos. Chinese-only data sheet: description and value encoding not translated.";
            sw = rw;
            hw = r;
            reset = 0x0;
        } xlpos[11:0];
    } G0P6DLPOS @ 0xA84;

    reg {
        name = "G0P6RESO";
        desc = "Data sheet 8.2.5 G0P6RESO (offset 0xA88, printed page 8-285, `hi3516v100--Hi3516-Datasheet.txt` line 52185).";

        field {
            name = "h";
            desc = "H. Chinese-only data sheet: description and value encoding not translated.";
            sw = rw;
            hw = r;
            reset = 0x0;
        } h[23:12];

        field {
            name = "w";
            desc = "W. Chinese-only data sheet: description and value encoding not translated.";
            sw = rw;
            hw = r;
            reset = 0x0;
        } w_f[11:0];
    } G0P6RESO @ 0xA88;

    reg {
        name = "G0P7ADDR";
        desc = "Data sheet 8.2.5 G0P7ADDR (offset 0xA8C, printed page 8-286, `hi3516v100--Hi3516-Datasheet.txt` line 52224).";

        field {
            name = "surface_addr";
            desc = "Surface address. Chinese-only data sheet: description and value encoding not translated.";
            sw = rw;
            hw = r;
            reset = 0x0;
        } surface_addr[31:0];
    } G0P7ADDR @ 0xA8C;

    reg {
        name = "G0P7STRIDE";
        desc = "Data sheet 8.2.5 G0P7STRIDE (offset 0xA90, printed page 8-286, `hi3516v100--Hi3516-Datasheet.txt` line 52243).";

        field {
            name = "surface_stride";
            desc = "Surface stride. Chinese-only data sheet: description and value encoding not translated.";
            sw = rw;
            hw = r;
            reset = 0x0;
        } surface_stride[15:0];
    } G0P7STRIDE @ 0xA90;

    reg {
        name = "G0P7DFPOS";
        desc = "Data sheet 8.2.5 G0P7DFPOS (offset 0xA94, printed page 8-286, `hi3516v100--Hi3516-Datasheet.txt` line 52265).";

        field {
            name = "yfpos";
            desc = "Yfpos. Chinese-only data sheet: description and value encoding not translated.";
            sw = rw;
            hw = r;
            reset = 0x0;
        } yfpos[23:12];

        field {
            name = "xfpos";
            desc = "Xfpos. Chinese-only data sheet: description and value encoding not translated.";
            sw = rw;
            hw = r;
            reset = 0x0;
        } xfpos[11:0];
    } G0P7DFPOS @ 0xA94;

    reg {
        name = "G0P7DLPOS";
        desc = "Data sheet 8.2.5 G0P7DLPOS (offset 0xA98, printed page 8-287, `hi3516v100--Hi3516-Datasheet.txt` line 52303).";

        field {
            name = "ylpos";
            desc = "Ylpos. Chinese-only data sheet: description and value encoding not translated.";
            sw = rw;
            hw = r;
            reset = 0x0;
        } ylpos[23:12];

        field {
            name = "xlpos";
            desc = "Xlpos. Chinese-only data sheet: description and value encoding not translated.";
            sw = rw;
            hw = r;
            reset = 0x0;
        } xlpos[11:0];
    } G0P7DLPOS @ 0xA98;

    reg {
        name = "G0P7RESO";
        desc = "Data sheet 8.2.5 G0P7RESO (offset 0xA9C, printed page 8-287, `hi3516v100--Hi3516-Datasheet.txt` line 52326).";

        field {
            name = "h";
            desc = "H. Chinese-only data sheet: description and value encoding not translated.";
            sw = rw;
            hw = r;
            reset = 0x0;
        } h[23:12];

        field {
            name = "w";
            desc = "W. Chinese-only data sheet: description and value encoding not translated.";
            sw = rw;
            hw = r;
            reset = 0x0;
        } w_f[11:0];
    } G0P7RESO @ 0xA9C;

    reg {
        name = "G08SLICEEN";
        desc = "Data sheet 8.2.5 G08SLICEEN (offset 0xAA0, printed page 8-288, `hi3516v100--Hi3516-Datasheet.txt` line 52364).";

        field {
            name = "p7_en";
            desc = "P7 enable. Chinese-only data sheet: description and value encoding not translated.";
            sw = rw;
            hw = r;
            reset = 0x0;
        } p7_en[7:7];

        field {
            name = "p6_en";
            desc = "P6 enable. Chinese-only data sheet: description and value encoding not translated.";
            sw = rw;
            hw = r;
            reset = 0x0;
        } p6_en[6:6];

        field {
            name = "p5_en";
            desc = "P5 enable. Chinese-only data sheet: description and value encoding not translated.";
            sw = rw;
            hw = r;
            reset = 0x0;
        } p5_en[5:5];

        field {
            name = "p4_en";
            desc = "P4 enable. Chinese-only data sheet: description and value encoding not translated.";
            sw = rw;
            hw = r;
            reset = 0x0;
        } p4_en[4:4];

        field {
            name = "p3_en";
            desc = "P3 enable. Chinese-only data sheet: description and value encoding not translated.";
            sw = rw;
            hw = r;
            reset = 0x0;
        } p3_en[3:3];

        field {
            name = "p2_en";
            desc = "P2 enable. Chinese-only data sheet: description and value encoding not translated.";
            sw = rw;
            hw = r;
            reset = 0x0;
        } p2_en[2:2];

        field {
            name = "p1_en";
            desc = "P1 enable. Chinese-only data sheet: description and value encoding not translated.";
            sw = rw;
            hw = r;
            reset = 0x0;
        } p1_en[1:1];

        field {
            name = "p0_en";
            desc = "P0 enable. Chinese-only data sheet: description and value encoding not translated.";
            sw = rw;
            hw = r;
            reset = 0x0;
        } p0_en[0:0];
    } G08SLICEEN @ 0xAA0;

    reg {
        name = "G1CTRL";
        desc = "Data sheet 8.2.5 G1CTRL (offset 0xB00, printed page 8-289, `hi3516v100--Hi3516-Datasheet.txt` line 52430).";

        field {
            name = "surface_en";
            desc = "Surface enable. Chinese-only data sheet: description and value encoding not translated.";
            sw = rw;
            hw = r;
            reset = 0x0;
        } surface_en[31:31];

        field {
            name = "upd_mode";
            desc = "Update mode. Chinese-only data sheet: description and value encoding not translated.";
            sw = rw;
            hw = r;
            reset = 0x0;
        } upd_mode[27:27];

        field {
            name = "read_mode";
            desc = "Read mode. Chinese-only data sheet: description and value encoding not translated.";
            sw = rw;
            hw = r;
            reset = 0x0;
        } read_mode[26:26];

        field {
            name = "bitext";
            desc = "Bitext. Chinese-only data sheet: description and value encoding not translated.";
            sw = rw;
            hw = r;
            reset = 0x0;
        } bitext[9:8];

        field {
            name = "ifmt";
            desc = "Input format. Chinese-only data sheet: description and value encoding not translated.";
            sw = rw;
            hw = r;
            reset = 0x0;
        } ifmt[7:0];
    } G1CTRL @ 0xB00;

    reg {
        name = "G1UPD";
        desc = "Data sheet 8.2.5 G1UPD (offset 0xB04, printed page 8-290, `hi3516v100--Hi3516-Datasheet.txt` line 52495).";

        field {
            name = "regup";
            desc = "Regup. Chinese-only data sheet: description and value encoding not translated.";
            sw = rw;
            hw = r;
            reset = 0x0;
        } regup[0:0];
    } G1UPD @ 0xB04;

    reg {
        name = "G1ADDR";
        desc = "Data sheet 8.2.5 G1ADDR (offset 0xB08, printed page 8-291, `hi3516v100--Hi3516-Datasheet.txt` line 52533).";

        field {
            name = "surface_addr";
            desc = "Surface address. Chinese-only data sheet: description and value encoding not translated.";
            sw = rw;
            hw = r;
            reset = 0x0;
        } surface_addr[31:0];
    } G1ADDR @ 0xB08;

    reg {
        name = "G1STRIDE";
        desc = "Data sheet 8.2.5 G1STRIDE (offset 0xB0C, printed page 8-291, `hi3516v100--Hi3516-Datasheet.txt` line 52552).";

        field {
            name = "surface_stride";
            desc = "Surface stride. Chinese-only data sheet: description and value encoding not translated.";
            sw = rw;
            hw = r;
            reset = 0x0;
        } surface_stride[15:0];
    } G1STRIDE @ 0xB0C;

    reg {
        name = "G1CBMPARA";
        desc = "Data sheet 8.2.5 G1CBMPARA (offset 0xB10, printed page 8-292, `hi3516v100--Hi3516-Datasheet.txt` line 52585).";

        field {
            name = "palpha_en";
            desc = "Palpha enable. Chinese-only data sheet: description and value encoding not translated.";
            sw = rw;
            hw = r;
            reset = 0x0;
        } palpha_en[12:12];

        field {
            name = "palpha_range";
            desc = "Palpha range. Chinese-only data sheet: description and value encoding not translated.";
            sw = rw;
            hw = r;
            reset = 0x0;
        } palpha_range[8:8];

        field {
            name = "galpha";
            desc = "Galpha. Chinese-only data sheet: description and value encoding not translated.";
            sw = rw;
            hw = r;
            reset = 0x0;
        } galpha[7:0];
    } G1CBMPARA @ 0xB10;

    reg {
        name = "G1IRESO";
        desc = "Data sheet 8.2.5 G1IRESO (offset 0xB20, printed page 8-292, `hi3516v100--Hi3516-Datasheet.txt` line 52626).";

        field {
            name = "ih";
            desc = "Ih. Chinese-only data sheet: description and value encoding not translated.";
            sw = rw;
            hw = r;
            reset = 0x0;
        } ih[23:12];

        field {
            name = "iw";
            desc = "Iw. Chinese-only data sheet: description and value encoding not translated.";
            sw = rw;
            hw = r;
            reset = 0x0;
        } iw[11:0];
    } G1IRESO @ 0xB20;

    reg {
        name = "G1ORESO";
        desc = "Data sheet 8.2.5 G1ORESO (offset 0xB24, printed page 8-293, `hi3516v100--Hi3516-Datasheet.txt` line 52668).";

        field {
            name = "oh";
            desc = "Oh. Chinese-only data sheet: description and value encoding not translated.";
            sw = rw;
            hw = r;
            reset = 0x0;
        } oh[23:12];

        field {
            name = "ow";
            desc = "Ow. Chinese-only data sheet: description and value encoding not translated.";
            sw = rw;
            hw = r;
            reset = 0x0;
        } ow[11:7];

        field {
            name = "src_xfpos";
            desc = "Source xfpos. Chinese-only data sheet: description and value encoding not translated.";
            sw = rw;
            hw = r;
            reset = 0x0;
        } src_xfpos[6:0];
    } G1ORESO @ 0xB24;

    reg {
        name = "G1DFPOS";
        desc = "Data sheet 8.2.5 G1DFPOS (offset 0xB2C, printed page 8-294, `hi3516v100--Hi3516-Datasheet.txt` line 52710).";

        field {
            name = "disp_yfpos";
            desc = "Disp yfpos. Chinese-only data sheet: description and value encoding not translated.";
            sw = rw;
            hw = r;
            reset = 0x0;
        } disp_yfpos[23:12];

        field {
            name = "disp_xfpos";
            desc = "Disp xfpos. Chinese-only data sheet: description and value encoding not translated.";
            sw = rw;
            hw = r;
            reset = 0x0;
        } disp_xfpos[11:0];
    } G1DFPOS @ 0xB2C;

    reg {
        name = "G1DLPOS";
        desc = "Data sheet 8.2.5 G1DLPOS (offset 0xB30, printed page 8-294, `hi3516v100--Hi3516-Datasheet.txt` line 52735).";

        field {
            name = "disp_ylpos";
            desc = "Disp ylpos. Chinese-only data sheet: description and value encoding not translated.";
            sw = rw;
            hw = r;
            reset = 0x0;
        } disp_ylpos[23:12];

        field {
            name = "disp_xlpos";
            desc = "Disp xlpos. Chinese-only data sheet: description and value encoding not translated.";
            sw = rw;
            hw = r;
            reset = 0x0;
        } disp_xlpos[11:0];
    } G1DLPOS @ 0xB30;

    reg {
        name = "G1CSCIDC";
        desc = "Data sheet 8.2.5 G1CSCIDC (offset 0xBA0, printed page 8-295, `hi3516v100--Hi3516-Datasheet.txt` line 52773).";

        field {
            name = "csc_en";
            desc = "Colour-space conversion enable. Chinese-only data sheet: description and value encoding not translated.";
            sw = rw;
            hw = r;
            reset = 0x0;
        } csc_en[27:27];

        field {
            name = "cscidc2";
            desc = "Cscidc2. Chinese-only data sheet: description and value encoding not translated.";
            sw = rw;
            hw = r;
            reset = 0x0;
        } cscidc2[26:18];

        field {
            name = "cscidc1";
            desc = "Cscidc1. Chinese-only data sheet: description and value encoding not translated.";
            sw = rw;
            hw = r;
            reset = 0x0;
        } cscidc1[17:9];

        field {
            name = "cscidc0";
            desc = "Cscidc0. Chinese-only data sheet: description and value encoding not translated.";
            sw = rw;
            hw = r;
            reset = 0x0;
        } cscidc0[8:0];
    } G1CSCIDC @ 0xBA0;

    reg {
        name = "G1CSCODC";
        desc = "Data sheet 8.2.5 G1CSCODC (offset 0xBA4, printed page 8-295, `hi3516v100--Hi3516-Datasheet.txt` line 52804).";

        field {
            name = "cscodc2";
            desc = "Cscodc2. Chinese-only data sheet: description and value encoding not translated.";
            sw = rw;
            hw = r;
            reset = 0x0;
        } cscodc2[26:18];

        field {
            name = "cscodc1";
            desc = "Cscodc1. Chinese-only data sheet: description and value encoding not translated.";
            sw = rw;
            hw = r;
            reset = 0x0;
        } cscodc1[17:9];

        field {
            name = "cscodc0";
            desc = "Cscodc0. Chinese-only data sheet: description and value encoding not translated.";
            sw = rw;
            hw = r;
            reset = 0x0;
        } cscodc0[8:0];
    } G1CSCODC @ 0xBA4;

    reg {
        name = "G1CSCP0";
        desc = "Data sheet 8.2.5 G1CSCP0 (offset 0xBA8, printed page 8-296, `hi3516v100--Hi3516-Datasheet.txt` line 52837).";

        field {
            name = "cscp01";
            desc = "Cscp01. Chinese-only data sheet: description and value encoding not translated.";
            sw = rw;
            hw = r;
            reset = 0x0;
        } cscp01[28:16];

        field {
            name = "cscp00";
            desc = "Cscp00. Chinese-only data sheet: description and value encoding not translated.";
            sw = rw;
            hw = r;
            reset = 0x0;
        } cscp00[12:0];
    } G1CSCP0 @ 0xBA8;

    reg {
        name = "G1CSCP1";
        desc = "Data sheet 8.2.5 G1CSCP1 (offset 0xBAC, printed page 8-296, `hi3516v100--Hi3516-Datasheet.txt` line 52871).";

        field {
            name = "cscp10";
            desc = "Cscp10. Chinese-only data sheet: description and value encoding not translated.";
            sw = rw;
            hw = r;
            reset = 0x0;
        } cscp10[28:16];

        field {
            name = "cscp02";
            desc = "Cscp02. Chinese-only data sheet: description and value encoding not translated.";
            sw = rw;
            hw = r;
            reset = 0x0;
        } cscp02[12:0];
    } G1CSCP1 @ 0xBAC;

    reg {
        name = "G1CSCP2";
        desc = "Data sheet 8.2.5 G1CSCP2 (offset 0xBB0, printed page 8-297, `hi3516v100--Hi3516-Datasheet.txt` line 52917).";

        field {
            name = "cscp12";
            desc = "Cscp12. Chinese-only data sheet: description and value encoding not translated.";
            sw = rw;
            hw = r;
            reset = 0x0;
        } cscp12[28:16];

        field {
            name = "cscp11";
            desc = "Cscp11. Chinese-only data sheet: description and value encoding not translated.";
            sw = rw;
            hw = r;
            reset = 0x0;
        } cscp11[12:0];
    } G1CSCP2 @ 0xBB0;

    reg {
        name = "G1CSCP3";
        desc = "Data sheet 8.2.5 G1CSCP3 (offset 0xBB4, printed page 8-298, `hi3516v100--Hi3516-Datasheet.txt` line 52963).";

        field {
            name = "cscp21";
            desc = "Cscp21. Chinese-only data sheet: description and value encoding not translated.";
            sw = rw;
            hw = r;
            reset = 0x0;
        } cscp21[28:16];

        field {
            name = "cscp20";
            desc = "Cscp20. Chinese-only data sheet: description and value encoding not translated.";
            sw = rw;
            hw = r;
            reset = 0x0;
        } cscp20[12:0];
    } G1CSCP3 @ 0xBB4;

    reg {
        name = "G1CSCP4";
        desc = "Data sheet 8.2.5 G1CSCP4 (offset 0xBB8, printed page 8-298, `hi3516v100--Hi3516-Datasheet.txt` line 52997).";

        field {
            name = "cscp22";
            desc = "Cscp22. Chinese-only data sheet: description and value encoding not translated.";
            sw = rw;
            hw = r;
            reset = 0x0;
        } cscp22[12:0];
    } G1CSCP4 @ 0xBB8;

    reg {
        name = "CBMBKG1";
        desc = "Data sheet 8.2.5 CBMBKG1 (offset 0x1000, printed page 8-299, `hi3516v100--Hi3516-Datasheet.txt` line 53034).";

        field {
            name = "cbm_bkgy1";
            desc = "Cbm bkgy1. Chinese-only data sheet: description and value encoding not translated.";
            sw = rw;
            hw = r;
            reset = 0x0;
        } cbm_bkgy1[23:16];

        field {
            name = "cbm_bkgcb1";
            desc = "Cbm bkgcb1. Chinese-only data sheet: description and value encoding not translated.";
            sw = rw;
            hw = r;
            reset = 0x0;
        } cbm_bkgcb1[15:8];

        field {
            name = "cbm_bkgcr1";
            desc = "Cbm bkgcr1. Chinese-only data sheet: description and value encoding not translated.";
            sw = rw;
            hw = r;
            reset = 0x0;
        } cbm_bkgcr1[7:0];
    } CBMBKG1 @ 0x1000;

    reg {
        name = "CBMBKG2";
        desc = "Data sheet 8.2.5 CBMBKG2 (offset 0x1004, printed page 8-299, `hi3516v100--Hi3516-Datasheet.txt` line 53059).";

        field {
            name = "cbm_bkgy2";
            desc = "Cbm bkgy2. Chinese-only data sheet: description and value encoding not translated.";
            sw = rw;
            hw = r;
            reset = 0x0;
        } cbm_bkgy2[23:16];

        field {
            name = "cbm_bkgcb2";
            desc = "Cbm bkgcb2. Chinese-only data sheet: description and value encoding not translated.";
            sw = rw;
            hw = r;
            reset = 0x0;
        } cbm_bkgcb2[15:8];

        field {
            name = "cbm_bkgcr2";
            desc = "Cbm bkgcr2. Chinese-only data sheet: description and value encoding not translated.";
            sw = rw;
            hw = r;
            reset = 0x0;
        } cbm_bkgcr2[7:0];
    } CBMBKG2 @ 0x1004;

    reg {
        name = "CBMMIX1";
        desc = "Data sheet 8.2.5 CBMMIX1 (offset 0x1010, printed page 8-300, `hi3516v100--Hi3516-Datasheet.txt` line 53095).";

        field {
            name = "mixer_prio1";
            desc = "Mixer prio1. Chinese-only data sheet: description and value encoding not translated.";
            sw = rw;
            hw = r;
            reset = 0x3;
        } mixer_prio1[5:3];

        field {
            name = "mixer_prio0";
            desc = "Mixer prio0. Chinese-only data sheet: description and value encoding not translated.";
            sw = rw;
            hw = r;
            reset = 0x1;
        } mixer_prio0[2:0];
    } CBMMIX1 @ 0x1010;

    reg {
        name = "CBMMIX2";
        desc = "Data sheet 8.2.5 CBMMIX2 (offset 0x1014, printed page 8-301, `hi3516v100--Hi3516-Datasheet.txt` line 53148).";

        field {
            name = "mixer_prio1";
            desc = "Mixer prio1. Chinese-only data sheet: description and value encoding not translated.";
            sw = rw;
            hw = r;
            reset = 0x0;
        } mixer_prio1[5:3];

        field {
            name = "mixer_prio0";
            desc = "Mixer prio0. Chinese-only data sheet: description and value encoding not translated.";
            sw = rw;
            hw = r;
            reset = 0x0;
        } mixer_prio0[2:0];
    } CBMMIX2 @ 0x1014;

    reg {
        name = "DHDCTRL";
        desc = "Data sheet 8.2.5 DHDCTRL (offset 0x1100, printed page 8-302, `hi3516v100--Hi3516-Datasheet.txt` line 53203).";

        field {
            name = "intf_en";
            desc = "Intf enable. Chinese-only data sheet: description and value encoding not translated.";
            sw = rw;
            hw = r;
            reset = 0x0;
        } intf_en[31:31];

        field {
            name = "fpga_lmt_en";
            desc = "Fpga lmt enable. Chinese-only data sheet: description and value encoding not translated.";
            sw = rw;
            hw = r;
            reset = 0x0;
        } fpga_lmt_en[27:27];

        field {
            name = "fpga_lmt_width";
            desc = "Fpga lmt width. Chinese-only data sheet: description and value encoding not translated.";
            sw = rw;
            hw = r;
            reset = 0x0;
        } fpga_lmt_width[26:20];

        field {
            name = "idv";
            desc = "Idv. Chinese-only data sheet: description and value encoding not translated.";
            sw = rw;
            hw = r;
            reset = 0x0;
        } idv[10:10];

        field {
            name = "ihs";
            desc = "Ihs. Chinese-only data sheet: description and value encoding not translated.";
            sw = rw;
            hw = r;
            reset = 0x0;
        } ihs[9:9];

        field {
            name = "ivs";
            desc = "Ivs. Chinese-only data sheet: description and value encoding not translated.";
            sw = rw;
            hw = r;
            reset = 0x0;
        } ivs[8:8];

        field {
            name = "iop";
            desc = "Iop. Chinese-only data sheet: description and value encoding not translated.";
            sw = rw;
            hw = r;
            reset = 0x0;
        } iop[7:7];

        field {
            name = "synm";
            desc = "Synm. Chinese-only data sheet: description and value encoding not translated.";
            sw = rw;
            hw = r;
            reset = 0x0;
        } synm[6:6];

        field {
            name = "intfb";
            desc = "Intfb. Chinese-only data sheet: description and value encoding not translated.";
            sw = rw;
            hw = r;
            reset = 0x1;
        } intfb[5:4];

        field {
            name = "intfdm";
            desc = "Intfdm. Chinese-only data sheet: description and value encoding not translated.";
            sw = rw;
            hw = r;
            reset = 0x0;
        } intfdm[3:0];
    } DHDCTRL @ 0x1100;

    reg {
        name = "DHDVSYNC";
        desc = "Data sheet 8.2.5 DHDVSYNC (offset 0x1104, printed page 8-303, `hi3516v100--Hi3516-Datasheet.txt` line 53292).";

        field {
            name = "vfb";
            desc = "Vfb. Chinese-only data sheet: description and value encoding not translated.";
            sw = rw;
            hw = r;
            reset = 0x1;
        } vfb[27:20];

        field {
            name = "vbb";
            desc = "Vbb. Chinese-only data sheet: description and value encoding not translated.";
            sw = rw;
            hw = r;
            reset = 0x13;
        } vbb[19:12];

        field {
            name = "vact";
            desc = "Vact. Chinese-only data sheet: description and value encoding not translated.";
            sw = rw;
            hw = r;
            reset = 0x21B;
        } vact[11:0];
    } DHDVSYNC @ 0x1104;

    reg {
        name = "DHDHSYNC1";
        desc = "Data sheet 8.2.5 DHDHSYNC1 (offset 0x1108, printed page 8-304, `hi3516v100--Hi3516-Datasheet.txt` line 53337).";

        field {
            name = "hbb";
            desc = "Hbb. Chinese-only data sheet: description and value encoding not translated.";
            sw = rw;
            hw = r;
            reset = 0xBF;
        } hbb[31:16];

        field {
            name = "hact";
            desc = "Hact. Chinese-only data sheet: description and value encoding not translated.";
            sw = rw;
            hw = r;
            reset = 0x77F;
        } hact[15:0];
    } DHDHSYNC1 @ 0x1108;

    reg {
        name = "DHDHSYNC2";
        desc = "Data sheet 8.2.5 DHDHSYNC2 (offset 0x110C, printed page 8-304, `hi3516v100--Hi3516-Datasheet.txt` line 53360).";

        field {
            name = "hmid";
            desc = "Hmid. Chinese-only data sheet: description and value encoding not translated.";
            sw = rw;
            hw = r;
            reset = 0x0;
        } hmid[31:16];

        field {
            name = "hfb";
            desc = "Hfb. Chinese-only data sheet: description and value encoding not translated.";
            sw = rw;
            hw = r;
            reset = 0x20F;
        } hfb[15:0];
    } DHDHSYNC2 @ 0x110C;

    reg {
        name = "DHDVPLUS";
        desc = "Data sheet 8.2.5 DHDVPLUS (offset 0x1110, printed page 8-305, `hi3516v100--Hi3516-Datasheet.txt` line 53393).";

        field {
            name = "bvfb";
            desc = "Bvfb. Chinese-only data sheet: description and value encoding not translated.";
            sw = rw;
            hw = r;
            reset = 0x2;
        } bvfb[27:20];

        field {
            name = "bvbb";
            desc = "Bvbb. Chinese-only data sheet: description and value encoding not translated.";
            sw = rw;
            hw = r;
            reset = 0x13;
        } bvbb[19:12];

        field {
            name = "bvact";
            desc = "Bvact. Chinese-only data sheet: description and value encoding not translated.";
            sw = rw;
            hw = r;
            reset = 0x21B;
        } bvact[11:0];
    } DHDVPLUS @ 0x1110;

    reg {
        name = "DHDPWR";
        desc = "Data sheet 8.2.5 DHDPWR (offset 0x1114, printed page 8-305, `hi3516v100--Hi3516-Datasheet.txt` line 53421).";

        field {
            name = "vpw";
            desc = "Vpw. Chinese-only data sheet: description and value encoding not translated.";
            sw = rw;
            hw = r;
            reset = 0x0;
        } vpw[23:16];

        field {
            name = "hpw";
            desc = "Hpw. Chinese-only data sheet: description and value encoding not translated.";
            sw = rw;
            hw = r;
            reset = 0x0;
        } hpw[15:0];
    } DHDPWR @ 0x1114;

    reg {
        name = "DHDVTTHD";
        desc = "Data sheet 8.2.5 DHDVTTHD (offset 0x111C, printed page 8-306, `hi3516v100--Hi3516-Datasheet.txt` line 53454).";

        field {
            name = "thd2_mode";
            desc = "Thd2 mode. Chinese-only data sheet: description and value encoding not translated.";
            sw = rw;
            hw = r;
            reset = 0x0;
        } thd2_mode[31:31];

        field {
            name = "thd1_mode";
            desc = "Thd1 mode. Chinese-only data sheet: description and value encoding not translated.";
            sw = rw;
            hw = r;
            reset = 0x0;
        } thd1_mode[15:15];

        field {
            name = "vtmgthd1";
            desc = "Vtmgthd1. Chinese-only data sheet: description and value encoding not translated.";
            sw = rw;
            hw = r;
            reset = 0x1;
        } vtmgthd1[12:0];
    } DHDVTTHD @ 0x111C;

    reg {
        name = "DHDCSCIDC";
        desc = "Data sheet 8.2.5 DHDCSCIDC (offset 0x1120, printed page 8-307, `hi3516v100--Hi3516-Datasheet.txt` line 53508).";

        field {
            name = "csc_en";
            desc = "Colour-space conversion enable. Chinese-only data sheet: description and value encoding not translated.";
            sw = rw;
            hw = r;
            reset = 0x0;
        } csc_en[27:27];

        field {
            name = "cscidc2";
            desc = "Cscidc2. Chinese-only data sheet: description and value encoding not translated.";
            sw = rw;
            hw = r;
            reset = 0x0;
        } cscidc2[26:18];

        field {
            name = "cscidc1";
            desc = "Cscidc1. Chinese-only data sheet: description and value encoding not translated.";
            sw = rw;
            hw = r;
            reset = 0x0;
        } cscidc1[17:9];

        field {
            name = "cscidc0";
            desc = "Cscidc0. Chinese-only data sheet: description and value encoding not translated.";
            sw = rw;
            hw = r;
            reset = 0x0;
        } cscidc0[8:0];
    } DHDCSCIDC @ 0x1120;

    reg {
        name = "DHDCSCODC";
        desc = "Data sheet 8.2.5 DHDCSCODC (offset 0x1124, printed page 8-307, `hi3516v100--Hi3516-Datasheet.txt` line 53539).";

        field {
            name = "cscodc2";
            desc = "Cscodc2. Chinese-only data sheet: description and value encoding not translated.";
            sw = rw;
            hw = r;
            reset = 0x0;
        } cscodc2[26:18];

        field {
            name = "cscodc1";
            desc = "Cscodc1. Chinese-only data sheet: description and value encoding not translated.";
            sw = rw;
            hw = r;
            reset = 0x0;
        } cscodc1[17:9];

        field {
            name = "cscodc0";
            desc = "Cscodc0. Chinese-only data sheet: description and value encoding not translated.";
            sw = rw;
            hw = r;
            reset = 0x0;
        } cscodc0[8:0];
    } DHDCSCODC @ 0x1124;

    reg {
        name = "DHDCSCP0";
        desc = "Data sheet 8.2.5 DHDCSCP0 (offset 0x1128, printed page 8-308, `hi3516v100--Hi3516-Datasheet.txt` line 53572).";

        field {
            name = "cscp01";
            desc = "Cscp01. Chinese-only data sheet: description and value encoding not translated.";
            sw = rw;
            hw = r;
            reset = 0x0;
        } cscp01[28:16];

        field {
            name = "cscp00";
            desc = "Cscp00. Chinese-only data sheet: description and value encoding not translated.";
            sw = rw;
            hw = r;
            reset = 0x0;
        } cscp00[12:0];
    } DHDCSCP0 @ 0x1128;

    reg {
        name = "DHDCSCP1";
        desc = "Data sheet 8.2.5 DHDCSCP1 (offset 0x112C, printed page 8-308, `hi3516v100--Hi3516-Datasheet.txt` line 53606).";

        field {
            name = "cscp10";
            desc = "Cscp10. Chinese-only data sheet: description and value encoding not translated.";
            sw = rw;
            hw = r;
            reset = 0x0;
        } cscp10[28:16];

        field {
            name = "cscp02";
            desc = "Cscp02. Chinese-only data sheet: description and value encoding not translated.";
            sw = rw;
            hw = r;
            reset = 0x0;
        } cscp02[12:0];
    } DHDCSCP1 @ 0x112C;

    reg {
        name = "DHDCSCP2";
        desc = "Data sheet 8.2.5 DHDCSCP2 (offset 0x1130, printed page 8-309, `hi3516v100--Hi3516-Datasheet.txt` line 53652).";

        field {
            name = "cscp12";
            desc = "Cscp12. Chinese-only data sheet: description and value encoding not translated.";
            sw = rw;
            hw = r;
            reset = 0x0;
        } cscp12[28:16];

        field {
            name = "cscp11";
            desc = "Cscp11. Chinese-only data sheet: description and value encoding not translated.";
            sw = rw;
            hw = r;
            reset = 0x0;
        } cscp11[12:0];
    } DHDCSCP2 @ 0x1130;

    reg {
        name = "DHDCSCP3";
        desc = "Data sheet 8.2.5 DHDCSCP3 (offset 0x1134, printed page 8-310, `hi3516v100--Hi3516-Datasheet.txt` line 53698).";

        field {
            name = "cscp21";
            desc = "Cscp21. Chinese-only data sheet: description and value encoding not translated.";
            sw = rw;
            hw = r;
            reset = 0x0;
        } cscp21[28:16];

        field {
            name = "cscp20";
            desc = "Cscp20. Chinese-only data sheet: description and value encoding not translated.";
            sw = rw;
            hw = r;
            reset = 0x0;
        } cscp20[12:0];
    } DHDCSCP3 @ 0x1134;

    reg {
        name = "DHDCSCP4";
        desc = "Data sheet 8.2.5 DHDCSCP4 (offset 0x1138, printed page 8-310, `hi3516v100--Hi3516-Datasheet.txt` line 53732).";

        field {
            name = "cscp22";
            desc = "Cscp22. Chinese-only data sheet: description and value encoding not translated.";
            sw = rw;
            hw = r;
            reset = 0x0;
        } cscp22[12:0];
    } DHDCSCP4 @ 0x1138;

    reg {
        name = "DHDCLIPL";
        desc = "Data sheet 8.2.5 DHDCLIPL (offset 0x1140, printed page 8-311, `hi3516v100--Hi3516-Datasheet.txt` line 53769).";

        field {
            name = "clip_en";
            desc = "Clip enable. Chinese-only data sheet: description and value encoding not translated.";
            sw = rw;
            hw = r;
            reset = 0x0;
        } clip_en[31:31];

        field {
            name = "dfir_en";
            desc = "Dfir enable. Chinese-only data sheet: description and value encoding not translated.";
            sw = rw;
            hw = r;
            reset = 0x1;
        } dfir_en[30:30];

        field {
            name = "clipcl2";
            desc = "Clipcl2. Chinese-only data sheet: description and value encoding not translated.";
            sw = rw;
            hw = r;
            reset = 0x10;
        } clipcl2[29:20];

        field {
            name = "clipcl1";
            desc = "Clipcl1. Chinese-only data sheet: description and value encoding not translated.";
            sw = rw;
            hw = r;
            reset = 0x10;
        } clipcl1[19:10];

        field {
            name = "clipcl0";
            desc = "Clipcl0. Chinese-only data sheet: description and value encoding not translated.";
            sw = rw;
            hw = r;
            reset = 0x10;
        } clipcl0[9:0];
    } DHDCLIPL @ 0x1140;

    reg {
        name = "DHDCLIPH";
        desc = "Data sheet 8.2.5 DHDCLIPH (offset 0x1144, printed page 8-311, `hi3516v100--Hi3516-Datasheet.txt` line 53801).";

        field {
            name = "clipch2";
            desc = "Clipch2. Chinese-only data sheet: description and value encoding not translated.";
            sw = rw;
            hw = r;
            reset = 0xEB;
        } clipch2[29:20];

        field {
            name = "clipch1";
            desc = "Clipch1. Chinese-only data sheet: description and value encoding not translated.";
            sw = rw;
            hw = r;
            reset = 0x0;
        } clipch1[19:10];

        field {
            name = "clipch0";
            desc = "Clipch0. Chinese-only data sheet: description and value encoding not translated.";
            sw = rw;
            hw = r;
            reset = 0xF0;
        } clipch0[9:0];
    } DHDCLIPH @ 0x1144;

    reg {
        name = "DHDSTATE";
        desc = "Data sheet 8.2.5 DHDSTATE (offset 0x11F0, printed page 8-312, `hi3516v100--Hi3516-Datasheet.txt` line 53839).";

        field {
            name = "bottom_field";
            desc = "Bottom field. Chinese-only data sheet: description and value encoding not translated.";
            sw = rw;
            hw = r;
            reset = 0x0;
        } bottom_field[2:2];

        field {
            name = "vblank";
            desc = "Vblank. Chinese-only data sheet: description and value encoding not translated.";
            sw = rw;
            hw = r;
            reset = 0x0;
        } vblank[1:1];

        field {
            name = "vback_blank";
            desc = "Vback blank. Chinese-only data sheet: description and value encoding not translated.";
            sw = rw;
            hw = r;
            reset = 0x0;
        } vback_blank[0:0];
    } DHDSTATE @ 0x11F0;

    reg {
        name = "DSDCTRL";
        desc = "Data sheet 8.2.5 DSDCTRL (offset 0x1300, printed page 8-313, `hi3516v100--Hi3516-Datasheet.txt` line 53892).";

        field {
            name = "intf_en";
            desc = "Intf enable. Chinese-only data sheet: description and value encoding not translated.";
            sw = rw;
            hw = r;
            reset = 0x0;
        } intf_en[31:31];

        field {
            name = "idv";
            desc = "Idv. Chinese-only data sheet: description and value encoding not translated.";
            sw = rw;
            hw = r;
            reset = 0x0;
        } idv[10:10];

        field {
            name = "ihs";
            desc = "Ihs. Chinese-only data sheet: description and value encoding not translated.";
            sw = rw;
            hw = r;
            reset = 0x0;
        } ihs[9:9];

        field {
            name = "ivs";
            desc = "Ivs. Chinese-only data sheet: description and value encoding not translated.";
            sw = rw;
            hw = r;
            reset = 0x0;
        } ivs[8:8];

        field {
            name = "iop";
            desc = "Iop. Chinese-only data sheet: description and value encoding not translated.";
            sw = rw;
            hw = r;
            reset = 0x0;
        } iop[7:7];

        field {
            name = "synm";
            desc = "Synm. Chinese-only data sheet: description and value encoding not translated.";
            sw = rw;
            hw = r;
            reset = 0x0;
        } synm[6:6];

        field {
            name = "intfb";
            desc = "Intfb. Chinese-only data sheet: description and value encoding not translated.";
            sw = rw;
            hw = r;
            reset = 0x0;
        } intfb[5:4];

        field {
            name = "intfdm";
            desc = "Intfdm. Chinese-only data sheet: description and value encoding not translated.";
            sw = rw;
            hw = r;
            reset = 0x0;
        } intfdm[3:0];
    } DSDCTRL @ 0x1300;

    reg {
        name = "DSDVSYNC";
        desc = "Data sheet 8.2.5 DSDVSYNC (offset 0x1304, printed page 8-314, `hi3516v100--Hi3516-Datasheet.txt` line 53963).";

        field {
            name = "vfb";
            desc = "Vfb. Chinese-only data sheet: description and value encoding not translated.";
            sw = rw;
            hw = r;
            reset = 0x1;
        } vfb[27:20];

        field {
            name = "vbb";
            desc = "Vbb. Chinese-only data sheet: description and value encoding not translated.";
            sw = rw;
            hw = r;
            reset = 0x15;
        } vbb[19:12];

        field {
            name = "vact";
            desc = "Vact. Chinese-only data sheet: description and value encoding not translated.";
            sw = rw;
            hw = r;
            reset = 0x11F;
        } vact[11:0];
    } DSDVSYNC @ 0x1304;

    reg {
        name = "DSDHSYNC1";
        desc = "Data sheet 8.2.5 DSDHSYNC1 (offset 0x1308, printed page 8-315, `hi3516v100--Hi3516-Datasheet.txt` line 54011).";

        field {
            name = "hbb";
            desc = "Hbb. Chinese-only data sheet: description and value encoding not translated.";
            sw = rw;
            hw = r;
            reset = 0x107;
        } hbb[31:16];

        field {
            name = "hact";
            desc = "Hact. Chinese-only data sheet: description and value encoding not translated.";
            sw = rw;
            hw = r;
            reset = 0x2CF;
        } hact[15:0];
    } DSDHSYNC1 @ 0x1308;

    reg {
        name = "DSDHSYNC2";
        desc = "Data sheet 8.2.5 DSDHSYNC2 (offset 0x130C, printed page 8-315, `hi3516v100--Hi3516-Datasheet.txt` line 54034).";

        field {
            name = "hfb";
            desc = "Hfb. Chinese-only data sheet: description and value encoding not translated.";
            sw = rw;
            hw = r;
            reset = 0x17;
        } hfb[15:0];
    } DSDHSYNC2 @ 0x130C;

    reg {
        name = "DSDVPLUS";
        desc = "Data sheet 8.2.5 DSDVPLUS (offset 0x1310, printed page 8-316, `hi3516v100--Hi3516-Datasheet.txt` line 54068).";

        field {
            name = "bvfb";
            desc = "Bvfb. Chinese-only data sheet: description and value encoding not translated.";
            sw = rw;
            hw = r;
            reset = 0x1;
        } bvfb[27:20];

        field {
            name = "bvbb";
            desc = "Bvbb. Chinese-only data sheet: description and value encoding not translated.";
            sw = rw;
            hw = r;
            reset = 0x16;
        } bvbb[19:12];

        field {
            name = "bvact";
            desc = "Bvact. Chinese-only data sheet: description and value encoding not translated.";
            sw = rw;
            hw = r;
            reset = 0x11F;
        } bvact[11:0];
    } DSDVPLUS @ 0x1310;

    reg {
        name = "DSDPWR";
        desc = "Data sheet 8.2.5 DSDPWR (offset 0x1314, printed page 8-316, `hi3516v100--Hi3516-Datasheet.txt` line 54096).";

        field {
            name = "vpw";
            desc = "Vpw. Chinese-only data sheet: description and value encoding not translated.";
            sw = rw;
            hw = r;
            reset = 0x0;
        } vpw[23:16];

        field {
            name = "hpw";
            desc = "Hpw. Chinese-only data sheet: description and value encoding not translated.";
            sw = rw;
            hw = r;
            reset = 0x0;
        } hpw[15:0];
    } DSDPWR @ 0x1314;

    reg {
        name = "DSDVTTHD";
        desc = "Data sheet 8.2.5 DSDVTTHD (offset 0x131C, printed page 8-317, `hi3516v100--Hi3516-Datasheet.txt` line 54135).";

        field {
            name = "thd2_mode";
            desc = "Thd2 mode. Chinese-only data sheet: description and value encoding not translated.";
            sw = rw;
            hw = r;
            reset = 0x0;
        } thd2_mode[31:31];

        field {
            name = "thd1_mode";
            desc = "Thd1 mode. Chinese-only data sheet: description and value encoding not translated.";
            sw = rw;
            hw = r;
            reset = 0x0;
        } thd1_mode[15:15];

        field {
            name = "vtmgthd1";
            desc = "Vtmgthd1. Chinese-only data sheet: description and value encoding not translated.";
            sw = rw;
            hw = r;
            reset = 0x1;
        } vtmgthd1[12:0];
    } DSDVTTHD @ 0x131C;

    reg {
        name = "DSDCSCIDC";
        desc = "Data sheet 8.2.5 DSDCSCIDC (offset 0x1320, printed page 8-317, `hi3516v100--Hi3516-Datasheet.txt` line 54174).";

        field {
            name = "csc_en";
            desc = "Colour-space conversion enable. Chinese-only data sheet: description and value encoding not translated.";
            sw = rw;
            hw = r;
            reset = 0x0;
        } csc_en[27:27];

        field {
            name = "cscidc2";
            desc = "Cscidc2. Chinese-only data sheet: description and value encoding not translated.";
            sw = rw;
            hw = r;
            reset = 0x0;
        } cscidc2[26:18];

        field {
            name = "cscidc1";
            desc = "Cscidc1. Chinese-only data sheet: description and value encoding not translated.";
            sw = rw;
            hw = r;
            reset = 0x0;
        } cscidc1[17:9];

        field {
            name = "cscidc0";
            desc = "Cscidc0. Chinese-only data sheet: description and value encoding not translated.";
            sw = rw;
            hw = r;
            reset = 0x0;
        } cscidc0[8:0];
    } DSDCSCIDC @ 0x1320;

    reg {
        name = "DSDCSCODC";
        desc = "Data sheet 8.2.5 DSDCSCODC (offset 0x1324, printed page 8-318, `hi3516v100--Hi3516-Datasheet.txt` line 54215).";

        field {
            name = "cscodc2";
            desc = "Cscodc2. Chinese-only data sheet: description and value encoding not translated.";
            sw = rw;
            hw = r;
            reset = 0x0;
        } cscodc2[26:18];

        field {
            name = "cscodc1";
            desc = "Cscodc1. Chinese-only data sheet: description and value encoding not translated.";
            sw = rw;
            hw = r;
            reset = 0x0;
        } cscodc1[17:9];

        field {
            name = "cscodc0";
            desc = "Cscodc0. Chinese-only data sheet: description and value encoding not translated.";
            sw = rw;
            hw = r;
            reset = 0x0;
        } cscodc0[8:0];
    } DSDCSCODC @ 0x1324;

    reg {
        name = "DSDCSCP0";
        desc = "Data sheet 8.2.5 DSDCSCP0 (offset 0x1328, printed page 8-319, `hi3516v100--Hi3516-Datasheet.txt` line 54255).";

        field {
            name = "cscp01";
            desc = "Cscp01. Chinese-only data sheet: description and value encoding not translated.";
            sw = rw;
            hw = r;
            reset = 0x0;
        } cscp01[28:16];

        field {
            name = "cscp00";
            desc = "Cscp00. Chinese-only data sheet: description and value encoding not translated.";
            sw = rw;
            hw = r;
            reset = 0x0;
        } cscp00[12:0];
    } DSDCSCP0 @ 0x1328;

    reg {
        name = "DSDCSCP1";
        desc = "Data sheet 8.2.5 DSDCSCP1 (offset 0x132C, printed page 8-319, `hi3516v100--Hi3516-Datasheet.txt` line 54289).";

        field {
            name = "cscp10";
            desc = "Cscp10. Chinese-only data sheet: description and value encoding not translated.";
            sw = rw;
            hw = r;
            reset = 0x0;
        } cscp10[28:16];

        field {
            name = "cscp02";
            desc = "Cscp02. Chinese-only data sheet: description and value encoding not translated.";
            sw = rw;
            hw = r;
            reset = 0x0;
        } cscp02[12:0];
    } DSDCSCP1 @ 0x132C;

    reg {
        name = "DSDCSCP2";
        desc = "Data sheet 8.2.5 DSDCSCP2 (offset 0x1330, printed page 8-320, `hi3516v100--Hi3516-Datasheet.txt` line 54334).";

        field {
            name = "cscp12";
            desc = "Cscp12. Chinese-only data sheet: description and value encoding not translated.";
            sw = rw;
            hw = r;
            reset = 0x0;
        } cscp12[28:16];

        field {
            name = "cscp11";
            desc = "Cscp11. Chinese-only data sheet: description and value encoding not translated.";
            sw = rw;
            hw = r;
            reset = 0x0;
        } cscp11[12:0];
    } DSDCSCP2 @ 0x1330;

    reg {
        name = "DSDCSCP3";
        desc = "Data sheet 8.2.5 DSDCSCP3 (offset 0x1334, printed page 8-321, `hi3516v100--Hi3516-Datasheet.txt` line 54383).";

        field {
            name = "cscp21";
            desc = "Cscp21. Chinese-only data sheet: description and value encoding not translated.";
            sw = rw;
            hw = r;
            reset = 0x0;
        } cscp21[28:16];

        field {
            name = "cscp20";
            desc = "Cscp20. Chinese-only data sheet: description and value encoding not translated.";
            sw = rw;
            hw = r;
            reset = 0x0;
        } cscp20[12:0];
    } DSDCSCP3 @ 0x1334;

    reg {
        name = "DSDCSCP4";
        desc = "Data sheet 8.2.5 DSDCSCP4 (offset 0x1338, printed page 8-321, `hi3516v100--Hi3516-Datasheet.txt` line 54417).";

        field {
            name = "cscp22";
            desc = "Cscp22. Chinese-only data sheet: description and value encoding not translated.";
            sw = rw;
            hw = r;
            reset = 0x0;
        } cscp22[12:0];
    } DSDCSCP4 @ 0x1338;

    reg {
        name = "DSDCLIPL";
        desc = "Data sheet 8.2.5 DSDCLIPL (offset 0x1340, printed page 8-322, `hi3516v100--Hi3516-Datasheet.txt` line 54449).";

        field {
            name = "clip_en";
            desc = "Clip enable. Chinese-only data sheet: description and value encoding not translated.";
            sw = rw;
            hw = r;
            reset = 0x0;
        } clip_en[31:31];

        field {
            name = "dfir_en";
            desc = "Dfir enable. Chinese-only data sheet: description and value encoding not translated.";
            sw = rw;
            hw = r;
            reset = 0x1;
        } dfir_en[30:30];

        field {
            name = "clipcl2";
            desc = "Clipcl2. Chinese-only data sheet: description and value encoding not translated.";
            sw = rw;
            hw = r;
            reset = 0x1;
        } clipcl2[29:20];

        field {
            name = "clipcl1";
            desc = "Clipcl1. Chinese-only data sheet: description and value encoding not translated.";
            sw = rw;
            hw = r;
            reset = 0x4;
        } clipcl1[19:10];

        field {
            name = "clipcl0";
            desc = "Clipcl0. Chinese-only data sheet: description and value encoding not translated.";
            sw = rw;
            hw = r;
            reset = 0x10;
        } clipcl0[9:0];
    } DSDCLIPL @ 0x1340;

    reg {
        name = "DSDCLIPH";
        desc = "Data sheet 8.2.5 DSDCLIPH (offset 0x1344, printed page 8-322, `hi3516v100--Hi3516-Datasheet.txt` line 54483).";

        field {
            name = "clipch2";
            desc = "Clipch2. Chinese-only data sheet: description and value encoding not translated.";
            sw = rw;
            hw = r;
            reset = 0xE;
        } clipch2[29:20];

        field {
            name = "clipch1";
            desc = "Clipch1. Chinese-only data sheet: description and value encoding not translated.";
            sw = rw;
            hw = r;
            reset = 0x2FC;
        } clipch1[19:10];

        field {
            name = "clipch0";
            desc = "Clipch0. Chinese-only data sheet: description and value encoding not translated.";
            sw = rw;
            hw = r;
            reset = 0xF0;
        } clipch0[9:0];
    } DSDCLIPH @ 0x1344;

    reg {
        name = "DSDSTATE";
        desc = "Data sheet 8.2.5 DSDSTATE (offset 0x13F0, printed page 8-323, `hi3516v100--Hi3516-Datasheet.txt` line 54526).";

        field {
            name = "bottom_field";
            desc = "Bottom field. Chinese-only data sheet: description and value encoding not translated.";
            sw = rw;
            hw = r;
            reset = 0x0;
        } bottom_field[2:2];

        field {
            name = "vblank";
            desc = "Vblank. Chinese-only data sheet: description and value encoding not translated.";
            sw = rw;
            hw = r;
            reset = 0x0;
        } vblank[1:1];

        field {
            name = "vback_blank";
            desc = "Vback blank. Chinese-only data sheet: description and value encoding not translated.";
            sw = rw;
            hw = r;
            reset = 0x0;
        } vback_blank[0:0];
    } DSDSTATE @ 0x13F0;

    reg {
        name = "DATE_COEFF0";
        desc = "Data sheet 8.2.5 DATE_COEFF0 (offset 0x1600, printed page 8-324, `hi3516v100--Hi3516-Datasheet.txt` line 54575).";

        field {
            name = "clpf_sel";
            desc = "Clpf select. Chinese-only data sheet: description and value encoding not translated.";
            sw = rw;
            hw = r;
            reset = 0x1;
        } clpf_sel[31:30];

        field {
            name = "dis_ire";
            desc = "Dis ire. Chinese-only data sheet: description and value encoding not translated.";
            sw = rw;
            hw = r;
            reset = 0x0;
        } dis_ire[29:29];

        field {
            name = "scanline";
            desc = "Scanline. Chinese-only data sheet: description and value encoding not translated.";
            sw = rw;
            hw = r;
            reset = 0x1;
        } scanline[25:25];

        field {
            name = "rgb_en";
            desc = "Rgb enable. Chinese-only data sheet: description and value encoding not translated.";
            sw = rw;
            hw = r;
            reset = 0x0;
        } rgb_en[24:24];

        field {
            name = "vbi_lpf_en";
            desc = "Vbi lpf enable. Chinese-only data sheet: description and value encoding not translated.";
            sw = rw;
            hw = r;
            reset = 0x1;
        } vbi_lpf_en[23:23];

        field {
            name = "fm_sel";
            desc = "Fm select. Chinese-only data sheet: description and value encoding not translated.";
            sw = rw;
            hw = r;
            reset = 0x0;
        } fm_sel[22:22];

        field {
            name = "style_sel";
            desc = "Style select. Chinese-only data sheet: description and value encoding not translated.";
            sw = rw;
            hw = r;
            reset = 0x1;
        } style_sel[21:18];

        field {
            name = "sync_mode_sel";
            desc = "Sync mode select. Chinese-only data sheet: description and value encoding not translated.";
            sw = rw;
            hw = r;
            reset = 0x0;
        } sync_mode_sel[17:16];

        field {
            name = "sync_mode_scart";
            desc = "Sync mode scart. Chinese-only data sheet: description and value encoding not translated.";
            sw = rw;
            hw = r;
            reset = 0x0;
        } sync_mode_scart[15:15];

        field {
            name = "length_sel";
            desc = "Length select. Chinese-only data sheet: description and value encoding not translated.";
            sw = rw;
            hw = r;
            reset = 0x0;
        } length_sel[14:14];

        field {
            name = "agc_amp_sel";
            desc = "Agc amp select. Chinese-only data sheet: description and value encoding not translated.";
            sw = rw;
            hw = r;
            reset = 0x0;
        } agc_amp_sel[13:13];

        field {
            name = "luma_dl";
            desc = "Luma dl. Chinese-only data sheet: description and value encoding not translated.";
            sw = rw;
            hw = r;
            reset = 0xA;
        } luma_dl[12:9];

        field {
            name = "oversam_en";
            desc = "Oversam enable. Chinese-only data sheet: description and value encoding not translated.";
            sw = rw;
            hw = r;
            reset = 0x3;
        } oversam_en[7:6];

        field {
            name = "lunt_en";
            desc = "Lunt enable. Chinese-only data sheet: description and value encoding not translated.";
            sw = rw;
            hw = r;
            reset = 0x1;
        } lunt_en[5:5];

        field {
            name = "oversam2_en";
            desc = "Oversam2 enable. Chinese-only data sheet: description and value encoding not translated.";
            sw = rw;
            hw = r;
            reset = 0x1;
        } oversam2_en[4:4];

        field {
            name = "chlp_en";
            desc = "Chlp enable. Chinese-only data sheet: description and value encoding not translated.";
            sw = rw;
            hw = r;
            reset = 0x1;
        } chlp_en[3:3];

        field {
            name = "sylp_en";
            desc = "Sylp enable. Chinese-only data sheet: description and value encoding not translated.";
            sw = rw;
            hw = r;
            reset = 0x1;
        } sylp_en[2:2];

        field {
            name = "chgain_en";
            desc = "Chgain enable. Chinese-only data sheet: description and value encoding not translated.";
            sw = rw;
            hw = r;
            reset = 0x0;
        } chgain_en[1:1];

        field {
            name = "tt_seq";
            desc = "Tt seq. Chinese-only data sheet: description and value encoding not translated.";
            sw = rw;
            hw = r;
            reset = 0x0;
        } tt_seq[0:0];
    } DATE_COEFF0 @ 0x1600;

    reg {
        name = "DATE_COEFF1";
        desc = "Data sheet 8.2.5 DATE_COEFF1 (offset 0x1604, printed page 8-327, `hi3516v100--Hi3516-Datasheet.txt` line 54769).";

        field {
            name = "c_gain";
            desc = "C gain. Chinese-only data sheet: description and value encoding not translated.";
            sw = rw;
            hw = r;
            reset = 0x0;
        } c_gain[31:29];

        field {
            name = "cvbs_limit_en";
            desc = "Cvbs limit enable. Chinese-only data sheet: description and value encoding not translated.";
            sw = rw;
            hw = r;
            reset = 0x0;
        } cvbs_limit_en[28:28];

        field {
            name = "wss_seq";
            desc = "Wss seq. Chinese-only data sheet: description and value encoding not translated.";
            sw = rw;
            hw = r;
            reset = 0x0;
        } wss_seq[27:27];

        field {
            name = "vps_seq";
            desc = "Vps seq. Chinese-only data sheet: description and value encoding not translated.";
            sw = rw;
            hw = r;
            reset = 0x0;
        } vps_seq[26:26];

        field {
            name = "cgms_seq";
            desc = "Cgms seq. Chinese-only data sheet: description and value encoding not translated.";
            sw = rw;
            hw = r;
            reset = 0x0;
        } cgms_seq[25:25];

        field {
            name = "cc_seq";
            desc = "Cc seq. Chinese-only data sheet: description and value encoding not translated.";
            sw = rw;
            hw = r;
            reset = 0x0;
        } cc_seq[24:24];

        field {
            name = "c_limit_en";
            desc = "C limit enable. Chinese-only data sheet: description and value encoding not translated.";
            sw = rw;
            hw = r;
            reset = 0x0;
        } c_limit_en[23:23];

        field {
            name = "amp_outside";
            desc = "Amp outside. Chinese-only data sheet: description and value encoding not translated.";
            sw = rw;
            hw = r;
            reset = 0x0;
        } amp_outside[22:13];

        field {
            name = "date_test_en";
            desc = "Date test enable. Chinese-only data sheet: description and value encoding not translated.";
            sw = rw;
            hw = r;
            reset = 0x0;
        } date_test_en[12:12];

        field {
            name = "date_test_mode";
            desc = "Date test mode. Chinese-only data sheet: description and value encoding not translated.";
            sw = rw;
            hw = r;
            reset = 0x0;
        } date_test_mode[11:10];

        field {
            name = "dac_test";
            desc = "DAC test. Chinese-only data sheet: description and value encoding not translated.";
            sw = rw;
            hw = r;
            reset = 0x0;
        } dac_test[9:3];

        field {
            name = "tt06_enf1";
            desc = "Tt06 enf1. Chinese-only data sheet: description and value encoding not translated.";
            sw = rw;
            hw = r;
            reset = 0x0;
        } tt06_enf1[2:2];

        field {
            name = "tt06_enf2";
            desc = "Tt06 enf2. Chinese-only data sheet: description and value encoding not translated.";
            sw = rw;
            hw = r;
            reset = 0x0;
        } tt06_enf2[1:1];

        field {
            name = "tt05_enf2";
            desc = "Tt05 enf2. Chinese-only data sheet: description and value encoding not translated.";
            sw = rw;
            hw = r;
            reset = 0x0;
        } tt05_enf2[0:0];
    } DATE_COEFF1 @ 0x1604;

    reg {
        name = "DATE_COEFF21";
        desc = "Data sheet 8.2.5 DATE_COEFF21 (offset 0x1654, printed page 8-329, `hi3516v100--Hi3516-Datasheet.txt` line 54863).";

        field {
            name = "dac0_in_sel";
            desc = "Dac0 in select. Chinese-only data sheet: description and value encoding not translated.";
            sw = rw;
            hw = r;
            reset = 0x1;
        } dac0_in_sel[2:0];
    } DATE_COEFF21 @ 0x1654;

    reg {
        name = "DATE_VERSION register";
        desc = "DATE_VERSION register. The data sheet lists no bit fields for it.

Data sheet 8.2.5 DATE_VERSION (offset 0x1690, printed page 8-329, `hi3516v100--Hi3516-Datasheet.txt` line 54895).";

        field {
            name = "value";
            desc = "Register value (the data sheet gives no bit table for this register).";
            sw = rw;
            hw = r;
            reset = 0x24;
        } value[31:0];
    } DATE_VERSION @ 0x1690;
};

`endif
