`ifndef HISI_HIETH_SF_RDL
`define HISI_HIETH_SF_RDL

// Hi3520D/Hi3515A/Hi3515C "hieth" switch-fabric Fast Ethernet MAC (vendor name HISFV300).
// Generated from the data sheet by build/rdl-audit/author/gen_eth.py (kept in scratch), checked against the hardware-verified U-Boot driver; see docs/rdl-sweep/PORT-BLOCKS.md.

regfile eHISI_HIETH_SF_PORT {
    name = "ETH port registers";
    desc = "
    Per-port registers of the ETH switch fabric. The block has two identical ports: the up port (vendor prefix U_, offsets +0x0000..+0x0FFF) and the down port (vendor prefix D_, the same layout at +0x2000..+0x2FFF). The data sheet documents the layout once with the prefix UD_ (`UD_MAC_PORTSEL` is U_MAC_PORTSEL at +0x0200 and D_MAC_PORTSEL at +0x2200); this regfile is instantiated twice by `eHISI_HIETH_SF` as `UP` and `DOWN`, and the `UD_` prefix of the data sheet names is dropped.

    On the Hi3520D/Hi3515A/Hi3515C the MII/RMII pins are wired to the up port only (the embedded FE PHY or an external RMII PHY); the down port is present in the logic and registers but nothing is documented about it beyond the shared `UD_` descriptions.
    ";

        reg {
            name = "PHY physical address register";
            desc = "
                UD_MDIO_PHYADDR is a PHY physical address register. The register does not support soft reset.

                DS name UD_MDIO_PHYADDR; the same register exists in the up port (vendor U_MDIO_PHYADDR) and in the down port at +0x2000 (vendor D_MDIO_PHYADDR).

                Data sheet (Hi3520D/Hi3515A/Hi3515C data sheet issue 07 (2015-02-09)): section 5.1.6.1, Table 5-5, page 5-20, register description at text dump line 25150 (build/sdk-survey/datasheet.txt).
            ";

            field {
                name = "phy_addr";
                desc = "Physical address of the external PHY chip.";
                reset = 0x01;
            } phy_addr[4:0];

        } MDIO_PHYADDR @ 0x108;

        reg {
            name = "PHY status register";
            desc = "
                UD_MDIO_RO_STAT is a PHY status register. The register does not support soft reset.

                DS name UD_MDIO_RO_STAT; the same register exists in the up port (vendor U_MDIO_RO_STAT) and in the down port at +0x2000 (vendor D_MDIO_RO_STAT).

                Data sheet (Hi3520D/Hi3515A/Hi3515C data sheet issue 07 (2015-02-09)): section 5.1.6.1, Table 5-5, page 5-20, register description at text dump line 25169 (build/sdk-survey/datasheet.txt).
            ";

            enum speed_mdio2mac_enum {
                VAL_10_MBIT_S = 0x0 { desc = "10 Mbit/s mode"; };
                VAL_100_MBIT_S = 0x1 { desc = "100 Mbit/s mode"; };
            };

            field {
                name = "speed_mdio2mac";
                desc = "Port speed working status obtained from the MDIO interface, which is in either 10 Mbit/s or 100 Mbit/s working mode.";
                encode = speed_mdio2mac_enum;
                sw = r;
                hw = w;
                reset = 0x0;
            } speed_mdio2mac[2:2];

            enum link_mdio2mac_enum {
                NO_LINK_EXISTS = 0x0 { desc = "No link exists."; };
                LINK_EXISTS = 0x1 { desc = "A link exists."; };
            };

            field {
                name = "link_mdio2mac";
                desc = "Port link status obtained from the MDIO interface.";
                encode = link_mdio2mac_enum;
                sw = r;
                hw = w;
                reset = 0x0;
            } link_mdio2mac[1:1];

            field {
                name = "duplex_mdio2mac";
                desc = "Port duplex working status obtained from the MDIO interface. 1: full-duplex";
                sw = r;
                hw = w;
                reset = 0x0;
            } duplex_mdio2mac[0:0];

        } MDIO_RO_STAT @ 0x10C;

        reg {
            name = "Offset address configuration register for the PHY status";
            desc = "
                UD_MDIO_ANEG_CTRLPHY is an offset address configuration register for the PHY status. The register does not support soft reset. The PHY speed status is indicated by bit[14] of the register with the address of 17, internal_addr_speed is set to 0x11 and speed_index is set to 0xE. In this case, the ETH module reads the bit value as the current working speed mode of the PHY through the MDIO interface.

                DS name UD_MDIO_ANEG_CTRL; the same register exists in the up port (vendor U_MDIO_ANEG_CTRL) and in the down port at +0x2000 (vendor D_MDIO_ANEG_CTRL).

                Data sheet (Hi3520D/Hi3515A/Hi3515C data sheet issue 07 (2015-02-09)): section 5.1.6.1, Table 5-5, page 5-21, register description at text dump line 25223 (build/sdk-survey/datasheet.txt).
            ";

            field {
                name = "internal_addr_speed";
                desc = "Address of the register in the PHY chip that stores the status information (speed). The default value is set according to Intel 9785.";
                reset = 0x11;
            } internal_addr_speed[26:22];

            field {
                name = "internal_addr_link";
                desc = "Address of the register in the PHY chip to store the status";
                reset = 0x11;
            } internal_addr_link[21:17];

            field {
                name = "internal_addr_duplex";
                desc = "Address of the register in the PHY chip that stores the status information (duplex). The default value is set according to Intel 9785.";
                reset = 0x11;
            } internal_addr_duplex[16:12];

            field {
                name = "speed_index";
                desc = "Offset address in the PHY status register that is used to store the speed information. The default value is set according to Intel 9785.";
                reset = 0xE;
            } speed_index[11:8];

            field {
                name = "link_index";
                desc = "Offset address in the PHY status register that is used to store the link information. The default value is set according to Intel 9785.";
                reset = 0xA;
            } link_index[7:4];

            field {
                name = "duplex_index";
                desc = "Offset address in the PHY status register that is used to store the duplex information. The default value is set according to Intel 9785.";
                reset = 0x9;
            } duplex_index[3:0];

        } MDIO_ANEG_CTRL @ 0x110;

        reg {
            name = "Scan mask register for MDIO status changes";
            desc = "
                UD_MDIO_IRQENA is a scan mask register for MDIO status changes. The register does not support soft reset. z If the status information about the PHY chip connecting to the port cannot be scanned and obtained by configuring UD_MDIO_ANEG_CTRL, you can scan the PHY status register by using MDIO_RWCTRL to check whether the port status changes and generate an interrupt to notify software of processing the interrupt. z link_partner status change refers to the change of any bit of link, speed, and duplex for the PHY status.

                DS name UD_MDIO_IRQENA; the same register exists in the up port (vendor U_MDIO_IRQENA) and in the down port at +0x2000 (vendor D_MDIO_IRQENA).

                Data sheet (Hi3520D/Hi3515A/Hi3515C data sheet issue 07 (2015-02-09)): section 5.1.6.1, Table 5-5, page 5-22, register description at text dump line 25291 (build/sdk-survey/datasheet.txt).
            ";

            enum link_partner_ch_mask_enum {
                MASKED = 0x0 { desc = "Mask"; };
                UNMASKED = 0x1 { desc = "Unmask"; };
            };

            field {
                name = "link_partner_ch_mask";
                desc = "Port link partner status scan change interrupt mask.";
                encode = link_partner_ch_mask_enum;
                reset = 0x0;
            } link_partner_ch_mask[3:3];

            enum speed_ch_mask_enum {
                MASKED = 0x0 { desc = "Mask"; };
                UNMASKED = 0x1 { desc = "Unmask"; };
            };

            field {
                name = "speed_ch_mask";
                desc = "Port speed mode scan change interrupt mask.";
                encode = speed_ch_mask_enum;
                reset = 0x0;
            } speed_ch_mask[2:2];

            enum link_ch_mask_enum {
                MASKED = 0x0 { desc = "Mask"; };
                UNMASKED = 0x1 { desc = "Unmask"; };
            };

            field {
                name = "link_ch_mask";
                desc = "Port link mode scan change interrupt mask.";
                encode = link_ch_mask_enum;
                reset = 0x0;
            } link_ch_mask[1:1];

            enum duplex_ch_mask_enum {
                MASKED = 0x0 { desc = "Mask"; };
                UNMASKED = 0x1 { desc = "Unmask"; };
            };

            field {
                name = "duplex_ch_mask";
                desc = "Port duplex mode scan change interrupt mask.";
                encode = duplex_ch_mask_enum;
                reset = 0x0;
            } duplex_ch_mask[0:0];

        } MDIO_IRQENA @ 0x114;

        reg {
            name = "Port working status control register";
            desc = "
                UD_MAC_PORTSEL is a port working status control register. The register does not support soft reset.

                DS name UD_MAC_PORTSEL; the same register exists in the up port (vendor U_MAC_PORTSEL) and in the down port at +0x2000 (vendor D_MAC_PORTSEL).

                Data sheet (Hi3520D/Hi3515A/Hi3515C data sheet issue 07 (2015-02-09)): section 5.1.6.2, Table 5-6, page 5-23, register description at text dump line 25343 (build/sdk-survey/datasheet.txt).
            ";

            enum mii_rmii_enum {
                MII = 0x0 { desc = "MII interface"; };
                RMII = 0x1 { desc = "RMII interface"; };
            };

            field {
                name = "mii_rmii";
                desc = "Port interface mode selection.";
                encode = mii_rmii_enum;
                reset = 0x0;
            } mii_rmii[1:1];

            enum stat_ctrl_enum {
                MDIO = 0x0 { desc = "Use the status information obtained from the MDIO interface."; };
                CPU = 0x1 { desc = "Use the status information set by the CPU."; };
            };

            field {
                name = "stat_ctrl";
                desc = "Port working status information select control register. Hardware-verified: U-Boot hieth_sf.c sets this bit (CPU-set status) and then drives UD_MAC_PORTSET from the PHY state.";
                encode = stat_ctrl_enum;
                reset = 0x1;
            } stat_ctrl[0:0];

        } MAC_PORTSEL @ 0x200;

        reg {
            name = "Port status register";
            desc = "
                UD_MAC_RO_STAT is a port status register. The register does not support soft reset.

                DS name UD_MAC_RO_STAT; the same register exists in the up port (vendor U_MAC_RO_STAT) and in the down port at +0x2000 (vendor D_MAC_RO_STAT).

                Data sheet (Hi3520D/Hi3515A/Hi3515C data sheet issue 07 (2015-02-09)): section 5.1.6.2, Table 5-6, page 5-23, register description at text dump line 25373 (build/sdk-survey/datasheet.txt).
            ";

            enum speed_stat_enum {
                VAL_10_MBIT_S = 0x0 { desc = "10 Mbit/s mode"; };
                VAL_100_MBIT_S = 0x1 { desc = "100 Mbit/s mode"; };
            };

            field {
                name = "speed_stat";
                desc = "Port current speed mode.";
                encode = speed_stat_enum;
                sw = r;
                hw = w;
                reset = 0x0;
            } speed_stat[2:2];

            enum link_stat_enum {
                NO_LINK_EXISTS = 0x0 { desc = "No link exists."; };
                LINK_EXISTS = 0x1 { desc = "A link exists."; };
            };

            field {
                name = "link_stat";
                desc = "Port current link status.";
                encode = link_stat_enum;
                sw = r;
                hw = w;
                reset = 0x0;
            } link_stat[1:1];

            enum duplex_stat_enum {
                HALF_DUPLEX = 0x0 { desc = "half-duplex"; };
                FULL_DUPLEX = 0x1 { desc = "full-duplex"; };
            };

            field {
                name = "duplex_stat";
                desc = "Port current duplex status.";
                encode = duplex_stat_enum;
                sw = r;
                hw = w;
                reset = 0x0;
            } duplex_stat[0:0];

        } MAC_RO_STAT @ 0x204;

        reg {
            name = "Port working status configuration register";
            desc = "
                UD_MAC_PORTSET is a port working status configuration register. The register does not support soft reset.

                DS name UD_MAC_PORTSET; the same register exists in the up port (vendor U_MAC_PORTSET) and in the down port at +0x2000 (vendor D_MAC_PORTSET).

                Data sheet (Hi3520D/Hi3515A/Hi3515C data sheet issue 07 (2015-02-09)): section 5.1.6.2, Table 5-6, page 5-24, register description at text dump line 25418 (build/sdk-survey/datasheet.txt).
            ";

            enum speed_stat_dio_enum {
                VAL_10_MBIT_S = 0x0 { desc = "10 Mbit/s mode"; };
                VAL_100_MBIT_S = 0x1 { desc = "100 Mbit/s mode"; };
            };

            field {
                name = "speed_stat_dio";
                desc = "Port speed mode set by the CPU.";
                encode = speed_stat_dio_enum;
                reset = 0x0;
            } speed_stat_dio[2:2];

            enum link_stat_dio_enum {
                NO_LINK_EXISTS = 0x0 { desc = "No link exists."; };
                LINK_EXISTS = 0x1 { desc = "A link exists."; };
            };

            field {
                name = "link_stat_dio";
                desc = "Port link status set by the CPU.";
                encode = link_stat_dio_enum;
                reset = 0x0;
            } link_stat_dio[1:1];

            enum duplex_stat_dio_enum {
                HALF_DUPLEX = 0x0 { desc = "half-duplex"; };
                FULL_DUPLEX = 0x1 { desc = "full-duplex"; };
            };

            field {
                name = "duplex_stat_dio";
                desc = "Port duplex mode set by the CPU.";
                encode = duplex_stat_dio_enum;
                reset = 0x0;
            } duplex_stat_dio[0:0];

        } MAC_PORTSET @ 0x208;

        reg {
            name = "Port status change indicator register";
            desc = "
                UD_MAC_STAT_CHANGE is a port status change indicator register. The register does not support soft reset.

                DS name UD_MAC_STAT_CHANGE; the same register exists in the up port (vendor U_MAC_STAT_CHANGE) and in the down port at +0x2000 (vendor D_MAC_STAT_CHANGE).

                Data sheet (Hi3520D/Hi3515A/Hi3515C data sheet issue 07 (2015-02-09)): section 5.1.6.2, Table 5-6, page 5-25, register description at text dump line 25460 (build/sdk-survey/datasheet.txt).
            ";

            enum speed_stat_ch_enum {
                NO_CHANGE_OCCURS = 0x0 { desc = "No change occurs."; };
                CHANGE_OCCURS = 0x1 { desc = "A change occurs."; };
            };

            field {
                name = "speed_stat_ch";
                desc = "Port speed mode change indicator. Writing 1 clears this register.";
                encode = speed_stat_ch_enum;
                sw = rw;
                onwrite = woclr;
                hw = w;
                reset = 0x0;
            } speed_stat_ch[2:2];

            enum link_stat_ch_enum {
                NO_CHANGE_OCCURS = 0x0 { desc = "No change occurs."; };
                CHANGE_OCCURS = 0x1 { desc = "A change occurs."; };
            };

            field {
                name = "link_stat_ch";
                desc = "Port link status change indicator. Writing 1 clears this register.";
                encode = link_stat_ch_enum;
                sw = rw;
                onwrite = woclr;
                hw = w;
                reset = 0x0;
            } link_stat_ch[1:1];

            enum duplex_stat_ch_enum {
                NO_CHANGE_OCCURS = 0x0 { desc = "No change occurs."; };
                CHANGE_OCCURS = 0x1 { desc = "A change occurs."; };
            };

            field {
                name = "duplex_stat_ch";
                desc = "Port duplex mode change indicator. Writing 1 clears this register.";
                encode = duplex_stat_ch_enum;
                sw = rw;
                onwrite = woclr;
                hw = w;
                reset = 0x0;
            } duplex_stat_ch[0:0];

        } MAC_STAT_CHANGE @ 0x20C;

        reg {
            name = "MAC function configuration register";
            desc = "
                UD_MAC_SET is a MAC function configuration register. The register does not support soft reset.

                DS name UD_MAC_SET; the same register exists in the up port (vendor U_MAC_SET) and in the down port at +0x2000 (vendor D_MAC_SET).

                Data sheet (Hi3520D/Hi3515A/Hi3515C data sheet issue 07 (2015-02-09)): section 5.1.6.2, Table 5-6, page 5-25, register description at text dump line 25501 (build/sdk-survey/datasheet.txt).
            ";

            enum add_pad_en_enum {
                DISABLED = 0x0 { desc = "Disabled"; };
                ENABLED = 0x1 { desc = "Enabled"; };
            };

            field {
                name = "add_pad_en";
                desc = "Port auto add PAD enable during transmission.";
                encode = add_pad_en_enum;
                reset = 0x1;
            } add_pad_en[29:29];

            enum crcgen_dis_enum {
                TX_FRAME_RECALCULATE = 0x0 { desc = "TX frame recalculate CRC."; };
                TX_FRAME_NOT = 0x1 { desc = "TX frame not recalculate CRC."; };
            };

            field {
                name = "crcgen_dis";
                desc = "Port CRC generation disable control.";
                encode = crcgen_dis_enum;
                reset = 0x0;
            } crcgen_dis[28:28];

            enum cntr_rdclr_en_enum {
                DISABLED = 0x0 { desc = "Disabled"; };
                ENABLED = 0x1 { desc = "Enabled"; };
            };

            field {
                name = "cntr_rdclr_en";
                desc = "Port statistics counter read clear enable.";
                encode = cntr_rdclr_en_enum;
                reset = 0x0;
            } cntr_rdclr_en[27:27];

            enum cntr_clr_all_enum {
                NOT_CLEAR = 0x0 { desc = "not clear"; };
                CLEAR = 0x1 { desc = "clear"; };
            };

            field {
                name = "cntr_clr_all";
                desc = "Port statistics counter clear control. Note: If cntr_clr_all is set to 1, the next clear all operation can be performed only after this bit is set to 0 and then to 1. Note: If cntr_clr_all is set to 1, the next clear all operation can be performed only after this bit is set to 0 and then to 1.";
                encode = cntr_clr_all_enum;
                reset = 0x0;
            } cntr_clr_all[26:26];

            enum cntr_roll_dis_enum {
                DISABLED = 0x0 { desc = "Disabled"; };
                ENABLED = 0x1 { desc = "Enabled"; };
            };

            field {
                name = "cntr_roll_dis";
                desc = "Port statistics acyclic counter enable.";
                encode = cntr_roll_dis_enum;
                reset = 0x0;
            } cntr_roll_dis[25:25];

            field {
                name = "colthreshold";
                desc = "Port collision count statistics threshold. The default value is 0x1, which indicates the count of frames with one collision.";
                reset = 0x1;
            } colthreshold[24:21];

            enum in_loop_en_enum {
                DISABLED = 0x0 { desc = "Disabled"; };
                ENABLED = 0x1 { desc = "Enabled"; };
            };

            field {
                name = "in_loop_en";
                desc = "Port loopback to internal enable. Note: Loopback to internal enable and loopback to external enable cannot be configured at the same time. When the network interface is in normal state, you need to perform soft reset on the module after loopback to internal enable is configured instead of loopback to external enable and vice versa.";
                encode = in_loop_en_enum;
                reset = 0x0;
            } in_loop_en[20:20];

            enum ex_loop_en_enum {
                DISABLED = 0x0 { desc = "Disabled"; };
                ENABLED = 0x1 { desc = "Enabled"; };
            };

            field {
                name = "ex_loop_en";
                desc = "Port loopback to external enable. Note: Loopback to internal enable and loopback to external enable cannot be configured at the same time. When the network interface is in normal state, you need to perform soft reset on the module after loopback to internal enable is configured instead of loopback to external enable and vice versa.";
                encode = ex_loop_en_enum;
                reset = 0x0;
            } ex_loop_en[19:19];

            enum pause_en_enum {
                DISABLED = 0x0 { desc = "Disabled"; };
                ENABLED = 0x1 { desc = "Enabled"; };
            };

            field {
                name = "pause_en";
                desc = "Port pause frame TX enable.";
                encode = pause_en_enum;
                reset = 0x1;
            } pause_en[18:18];

            enum rx_shframe_en_enum {
                DISABLED = 0x0 { desc = "Disabled"; };
                ENABLED = 0x1 { desc = "Enabled"; };
            };

            field {
                name = "rx_shframe_en";
                desc = "Port short frame RX enable. Note: If rx_shframe_en is set to 1, the minimum RX frame length allowed by the port is that set by rx_min_thr. If rx_shframe_en is set to 0, the minimum RX frame length allowed by the port is 64 bytes (including CRC) by default.";
                encode = rx_shframe_en_enum;
                reset = 0x1;
            } rx_shframe_en[17:17];

            field {
                name = "rx_min_thr";
                desc = "Minimum RX frame length allowed by the port. The value range is from 42 bytes to 63 bytes. The default value is 42 bytes. Note: If rx_min_thr is set to a value smaller than 42, 42 is used instead of the value.";
                reset = 0x2A;
            } rx_min_thr[16:11];

            field {
                name = "len_max";
                desc = "Maximum RX frame length allowed by the port. The default value is 1518 bytes. The value is in a range of 1518 bytes to 1535 bytes. Note: If len_max is set to a value greater than 2000, 2000 is used instead of the value. If len_max is set to a value smaller than 256, 256 is used instead of the value.";
                reset = 0x5EE;
            } len_max[10:0];

        } MAC_SET @ 0x210;

        reg {
            name = "Multi-packet interrupt configuration register";
            desc = "
                UD_GLB_IRQN_SET is a multi-packet interrupt configuration register. The register does not support soft reset.

                DS name UD_GLB_IRQN_SET; the same register exists in the up port (vendor U_GLB_IRQN_SET) and in the down port at +0x2000 (vendor D_GLB_IRQN_SET).

                Data sheet (Hi3520D/Hi3515A/Hi3515C data sheet issue 07 (2015-02-09)): section 5.1.6.3, Table 5-7, page 5-48, register description at text dump line 26896 (build/sdk-survey/datasheet.txt).
            ";

            field {
                name = "int_frm_cnt";
                desc = "These bits are used to set the multi-packet interrupt function. That is, how many packets must be received before a multi-packet interrupt can be reported. Note: The minimum value of int_frm_cnt can be set to 1. In this case, multi-packet interrupt is equivalent to single-packet interrupt.";
                reset = 0x08;
            } int_frm_cnt[28:24];

            field {
                name = "age_timer";
                desc = "After the multi-packet interrupt function is enabled, if the number of received packets cannot reach the specified number of packets required for reporting the multi-packet interrupt after a period, this period is defined as the aging time for generating the multi-packet interrupt. Note: age_timer is counted in the unit of the main clock cycle divided by 256.";
                reset = 0x003A;
            } age_timer[15:0];

        } GLB_IRQN_SET @ 0x340;

        reg {
            name = "Queue length configuration register";
            desc = "
                UD_GLB_QLEN_SET is a queue length configuration register. The register does not support soft reset.

                DS name UD_GLB_QLEN_SET; the same register exists in the up port (vendor U_GLB_QLEN_SET) and in the down port at +0x2000 (vendor D_GLB_QLEN_SET).

                Data sheet (Hi3520D/Hi3515A/Hi3515C data sheet issue 07 (2015-02-09)): section 5.1.6.3, Table 5-7, page 5-49, register description at text dump line 26938 (build/sdk-survey/datasheet.txt).
            ";

            field {
                name = "iq_len";
                desc = "RX (packet RX) queue length configuration. Note: iq_len cannot be set to 0. Otherwise, it is forcibly set to 1. The sum of the set values of iq_len and eq_len cannot be greater than 64 (DS text cut off at this point in the dump; 64 frame management queues are shared by RX and TX).";
                reset = 0x20;
            } iq_len[13:8];

            field {
                name = "eq_len";
                desc = "TX (packet TX) queue length configuration. Note: eq_len cannot be set to 0. Otherwise, it is forcibly set to 1.";
                reset = 0x20;
            } eq_len[5:0];

        } GLB_QLEN_SET @ 0x344;

        reg {
            name = "Traffic control register";
            desc = "
                UD_GLB_FC_LEVEL is a traffic control register. The register does not support soft reset. The Hi3520D data sheet (version 02) gives the total reset value 0x3018_0508: its reset bit table also sets bits 29, 28, 20 and 19, which lie in the range the data sheet lists as reserved (bits 31:15); modelled as the read-only field reserved_nz (reset 0x6030) so that the register reset equals the data sheet total.

                DS name UD_GLB_FC_LEVEL; the same register exists in the up port (vendor U_GLB_FC_LEVEL) and in the down port at +0x2000 (vendor D_GLB_FC_LEVEL).

                Data sheet (Hi3520D/Hi3515A/Hi3515C data sheet issue 07 (2015-02-09)): section 5.1.6.3, Table 5-7, page 5-50, register description at text dump line 26978 (build/sdk-survey/datasheet.txt).
            ";

            enum qlimit_ena_enum {
                DISABLED = 0x0 { desc = "Disabled (do not transmit the traffic control message according to the status of RX queue)."; };
                ENABLED = 0x1 { desc = "Enabled (transmit the traffic control message according to the status of RX queue)."; };
            };

            field {
                name = "reserved_nz";
                desc = "Reserved (RO); bits 29, 28, 20 and 19 read 1: the data sheet total reset value is 0x3018_0508 (not read on hardware).";
                sw = r;
                hw = w;
                reset = 0x6030;
            } reserved_nz[31:15];

            field {
                name = "qlimit_ena";
                desc = "Traffic control enable for RX queue.";
                encode = qlimit_ena_enum;
                reset = 0x0;
            } qlimit_ena[14:14];

            field {
                name = "qlimit_up";
                desc = "Upper limit of traffic control for RX queue. When the free space of the RX queue is less than the upper limit, if traffic control for RX queue is enabled, the traffic control message is transmitted to the peer end. Note: If the upper limit qlimit_up is set to 0, the RX queue fails to enter the traffic control status. The upper limit qlimit_up must be greater than the lower limit qlimit_down.";
                reset = 0x05;
            } qlimit_up[13:8];

            field {
                name = "qlimit_down";
                desc = "Lower limit of traffic control for RX queue. When the free space of the RX queue is equal to or greater than the upper limit, if the RX queue is in traffic control state, the current traffic control is stopped.";
                reset = 0x08;
            } qlimit_down[5:0];

        } GLB_FC_LEVEL @ 0x348;

        reg {
            name = "Cause register for the CPU to which the packet is transmitted";
            desc = "
                UD_GLB_CAUSE is a cause register for the CPU to which the packet is transmitted. The register does not support soft reset.

                DS name UD_GLB_CAUSE; the same register exists in the up port (vendor U_GLB_CAUSE) and in the down port at +0x2000 (vendor D_GLB_CAUSE).

                Data sheet (Hi3520D/Hi3515A/Hi3515C data sheet issue 07 (2015-02-09)): section 5.1.6.3, Table 5-7, page 5-51, register description at text dump line 27034 (build/sdk-survey/datasheet.txt).
            ";

            enum mact_cause_enum {
                FORCED_FORWARDING = 0x0 { desc = "Forced forwarding."; };
                PACKET_WHOSE_DESTINATION = 0x1 { desc = "Packet whose destination MAC address is the local MAC address."; };
                BROADCAST_PACKET = 0x2 { desc = "Broadcast packet."; };
                PACKET_MATCHING_MAC = 0x3 { desc = "Packet matching the MAC table."; };
                MULTICAST_PACKET_NOT = 0x4 { desc = "Multicast packet not matching the MAC table."; };
                UNICAST_PACKET_NOT = 0x5 { desc = "Unicast packet not matching the MAC table."; };
            };

            field {
                name = "mact_cause";
                desc = "Packet matching result types by querying the MAC table. Others: Reserved.";
                encode = mact_cause_enum;
                sw = r;
                hw = w;
                reset = 0x0;
            } mact_cause[2:0];

        } GLB_CAUSE @ 0x34C;

        reg {
            name = "RX frame start address register";
            desc = "
                UD_GLB_RXFRM_SADDR is an RX frame start address register. The register does not support soft reset.

                DS name UD_GLB_RXFRM_SADDR; the same register exists in the up port (vendor U_GLB_RXFRM_SADDR) and in the down port at +0x2000 (vendor D_GLB_RXFRM_SADDR).

                Data sheet (Hi3520D/Hi3515A/Hi3515C data sheet issue 07 (2015-02-09)): section 5.1.6.3, Table 5-7, page 5-51, register description at text dump line 27066 (build/sdk-survey/datasheet.txt).
            ";

            field {
                name = "rxfrm_saddr";
                desc = "Start address of the RX frame.";
                sw = r;
                hw = w;
                reset = 0x00000000;
            } rxfrm_saddr[31:0];

        } GLB_RXFRM_SADDR @ 0x350;

        reg {
            name = "RX frame descriptor register";
            desc = "
                UD_GLB_IQFRM_DES is an RX frame descriptor register. The register does not support soft reset.

                DS name UD_GLB_IQFRM_DES; the same register exists in the up port (vendor U_GLB_IQFRM_DES) and in the down port at +0x2000 (vendor D_GLB_IQFRM_DES).

                Data sheet (Hi3520D/Hi3515A/Hi3515C data sheet issue 07 (2015-02-09)): section 5.1.6.3, Table 5-7, page 5-52, register description at text dump line 27097 (build/sdk-survey/datasheet.txt).
            ";

            field {
                name = "fd_in_addr";
                desc = "Relative address of the first frame to be received in the input queue (IQ). It serves as the index (0 to iq_len-1) of the absolute address";
                sw = r;
                hw = w;
                reset = 0x00;
            } fd_in_addr[17:12];

            field {
                name = "fd_in_len";
                desc = "Length of the frame to be received in the RX queue. DS: bits [11:0] (12 bits). Vendor driver (ctrl.h BITS_RXPKG_LEN) and the hardware-verified U-Boot driver (IQFRM_DES_LEN_MASK) use bits [10:0]; the frame length never exceeds 2000 bytes so bit 11 is not exercised.";
                sw = r;
                hw = w;
                reset = 0x000;
            } fd_in_len[11:0];

        } GLB_IQFRM_DES @ 0x354;

        reg {
            name = "RX frame header address register";
            desc = "
                UD_GLB_IQ_ADDR is an RX frame header address register. The register does not support soft reset. If the address assigned by software is not word aligned, the logic writes data according to the word aligned address. In this case, the previously written data is invalid. For example, if the configured header address of a frame is 0xF000_8002 (non-word-aligned address), the logic writes 0x00 or other data to both the 0xF000_8000 and 0xF000_8001 addresses. Then, the logic writes the first byte (valid data) of the RX frame to the 0xF000_8002 address, writes the second byte (valid data) of the RX frame to the 0xF000_8003 address. Subsequent data is written to the buffer in sequence. If the configured header address of the RX frame is other non-word-aligned address, the logic writes data in a similar way.

                DS name UD_GLB_IQ_ADDR; the same register exists in the up port (vendor U_GLB_IQ_ADDR) and in the down port at +0x2000 (vendor D_GLB_IQ_ADDR).

                Data sheet (Hi3520D/Hi3515A/Hi3515C data sheet issue 07 (2015-02-09)): section 5.1.6.3, Table 5-7, page 5-52, register description at text dump line 27135 (build/sdk-survey/datasheet.txt).
            ";

            field {
                name = "startaddr_iq";
                desc = "Header address (configured by the CPU) of the storage space corresponding to the RX frame. The RX frame requests the bus according to this address.";
                reset = 0x00000000;
            } startaddr_iq[31:0];

        } GLB_IQ_ADDR @ 0x358;

        reg {
            name = "Counter for traffic control status of forward buffer and aging time of multi-packet interrupt";
            desc = "
                UD_GLB_BFC_STAT is a counter for traffic control status of forward buffer and aging time of multi-packet interrupt. The register does not support soft reset.

                DS name UD_GLB_BFC_STAT; the same register exists in the up port (vendor U_GLB_BFC_STAT) and in the down port at +0x2000 (vendor D_GLB_BFC_STAT).

                Data sheet (Hi3520D/Hi3515A/Hi3515C data sheet issue 07 (2015-02-09)): section 5.1.6.3, Table 5-7, page 5-53, register description at text dump line 27164 (build/sdk-survey/datasheet.txt).
            ";

            field {
                name = "timerover_cnt";
                desc = "Register for the count of multi-packet interrupt aging time counter overflow events (the count reaches the configured value). Note: If the value of timerover_cnt is too large in a unit of time, it indicates that UD_GLB_IRQN_SET[int_frm_cnt] is set improperly. Multi-packet interrupt is triggered by the aging time. Therefore, the configured value must be reduced.";
                sw = r;
                hw = w;
                reset = 0x0000;
            } timerover_cnt[31:16];

            field {
                name = "flowctrl_cnt";
                desc = "Register for the count of the forward buffer of the uplink or downlink port entering the traffic control status. Note: If the value of flowctrl_cnt is too large in a unit of time, it indicates that UD_GLB_FC_LEVEL[blimit_up] (sic, the field is qlimit_up) or UD_GLB_FC_LEVEL[blimit_down] (qlimit_down) is set to a too small value, or the external network condition is worsened. In this case, the configured value may be reduced.";
                sw = r;
                hw = w;
                reset = 0x0000;
            } flowctrl_cnt[15:0];

        } GLB_BFC_STAT @ 0x35C;

        reg {
            name = "TX queue header address register";
            desc = "
                UD_GLB_EQ_ADDR is a TX queue header address register. The register does not support soft reset. If the header address of the TX frame is not word aligned, the logic reads data according to the word aligned address. In this case, the previously read data is invalid and discarded. For example, if the configured header address of the TX frame is 0xF000_8102 (non-word-aligned address), the logic directly discards the byte data read from the 0xF000_8100 and 0xF000_8101 addresses. Then, the logic considers the data read from the 0xF000_8102 address as the first byte (valid data) of the TX frame and considers the data read from the 0xF000_8103 address as the second byte (valid data) of the TX frame. All subsequent data is valid (until the data of the specified frame length is read). If the configured header address of the TX frame is other non-word-aligned address, the logic reads data in a similar way.

                DS name UD_GLB_EQ_ADDR; the same register exists in the up port (vendor U_GLB_EQ_ADDR) and in the down port at +0x2000 (vendor D_GLB_EQ_ADDR).

                Data sheet (Hi3520D/Hi3515A/Hi3515C data sheet issue 07 (2015-02-09)): section 5.1.6.3, Table 5-7, page 5-53, register description at text dump line 27205 (build/sdk-survey/datasheet.txt).
            ";

            field {
                name = "add_fd_addr_out";
                desc = "Header address of the TX frame added by the CPU to the TX queue.";
                reset = 0x00000000;
            } add_fd_addr_out[31:0];

        } GLB_EQ_ADDR @ 0x360;

        reg {
            name = "TX queue frame length configuration register";
            desc = "
                UD_GLB_EQFRM_LEN is a TX queue frame length configuration register. The register does not support soft reset.

                DS name UD_GLB_EQFRM_LEN; the same register exists in the up port (vendor U_GLB_EQFRM_LEN) and in the down port at +0x2000 (vendor D_GLB_EQFRM_LEN).

                Data sheet (Hi3520D/Hi3515A/Hi3515C data sheet issue 07 (2015-02-09)): section 5.1.6.3, Table 5-7, page 5-54, register description at text dump line 27237 (build/sdk-survey/datasheet.txt).
            ";

            field {
                name = "add_fd_len_out";
                desc = "Length of the TX frame added by the CPU to the TX queue. Configure this register to trigger hardware so that software can write the header address and length of the TX frame to the TX queue for transmission. When transmitting a frame, software must write the header address of the frame before the length of the frame. Note: The frames whose add_fd_len_out is less than 20 bytes or greater than 1600 bytes are discarded. In other words, the allowed range is from 20 bytes to 1600 bytes.";
                reset = 0x000;
            } add_fd_len_out[10:0];

        } GLB_EQFRM_LEN @ 0x364;

        reg {
            name = "Queue status register";
            desc = "
                UD_GLB_QSTAT is a queue status register. The register does not support soft reset.

                DS name UD_GLB_QSTAT; the same register exists in the up port (vendor U_GLB_QSTAT) and in the down port at +0x2000 (vendor D_GLB_QSTAT).

                Data sheet (Hi3520D/Hi3515A/Hi3515C data sheet issue 07 (2015-02-09)): section 5.1.6.3, Table 5-7, page 5-54, register description at text dump line 27265 (build/sdk-survey/datasheet.txt).
            ";

            field {
                name = "iq_in_index";
                desc = "RX index of the RX (packet RX) queue.";
                sw = r;
                hw = w;
                reset = 0x00;
            } iq_in_index[29:24];

            field {
                name = "cpuw_index";
                desc = "RX index of frame header address of the RX (packet RX) queue.";
                sw = r;
                hw = w;
                reset = 0x00;
            } cpuw_index[21:16];

            field {
                name = "eq_in_index";
                desc = "RX index of frame descriptor of the TX (packet TX) queue.";
                sw = r;
                hw = w;
                reset = 0x00;
            } eq_in_index[13:8];

            field {
                name = "eq_out_index";
                desc = "TX index of frame descriptor of the TX (packet TX) queue.";
                sw = r;
                hw = w;
                reset = 0x00;
            } eq_out_index[5:0];

        } GLB_QSTAT @ 0x368;

        reg {
            name = "Address queue status register";
            desc = "
                UD_GLB_ADDRQ_STAT is an address queue status register. The register does not support soft reset.

                DS name UD_GLB_ADDRQ_STAT; the same register exists in the up port (vendor U_GLB_ADDRQ_STAT) and in the down port at +0x2000 (vendor D_GLB_ADDRQ_STAT).

                Data sheet (Hi3520D/Hi3515A/Hi3515C data sheet issue 07 (2015-02-09)): section 5.1.6.3, Table 5-7, page 5-55, register description at text dump line 27305 (build/sdk-survey/datasheet.txt).
            ";

            enum cpuaddr_in_rdy_enum {
                CPU_CANNOT_CONFIGURE = 0x0 { desc = "The CPU cannot configure the frame header address of the RX queue."; };
                CPU_CAN_CONFIGURE = 0x1 { desc = "The CPU can configure the frame header address of the RX queue."; };
            };

            field {
                name = "cpuaddr_in_rdy";
                desc = "Indicates whether the CPU can configure the frame header address of the RX queue. Note: The values of cpuaddr_in_rdy and eq_in_rdy are set to 0 during reset. The values, however, are set to 1 by the circuit immediately after reset. In other words, after reset, the iq address queue and eq descriptor queue are configurable. Hardware-verified: reset value reads 0x03000000 (both ready bits set) and the U-Boot driver polls these bits as RECVQ_RDY/XMITQ_RDY.";
                encode = cpuaddr_in_rdy_enum;
                sw = r;
                hw = w;
                reset = 0x1;
            } cpuaddr_in_rdy[25:25];

            field {
                name = "eq_in_rdy";
                desc = "Note: The values of cpuaddr_in_rdy and eq_in_rdy are set to 0 during reset. The values, however, are set to 1 by the circuit immediately after reset. In other words, after reset, the iq address queue and eq descriptor queue are configurable. can configure the frame descriptor of the TX queue. the frame descriptor (header address";
                sw = r;
                hw = w;
                reset = 0x1;
            } eq_in_rdy[24:24];

            field {
                name = "cpu_cnt";
                desc = "Header address count for available frames assigned by the CPU to the RX queue.";
                sw = r;
                hw = w;
                reset = 0x00;
            } cpu_cnt[21:16];

            field {
                name = "iq_cnt";
                desc = "(0 to iq_len).";
                sw = r;
                hw = w;
                reset = 0x00;
            } iq_cnt[13:8];

            field {
                name = "eq_cnt";
                desc = "(0 to eq_len).";
                sw = r;
                hw = w;
                reset = 0x00;
            } eq_cnt[5:0];

        } GLB_ADDRQ_STAT @ 0x36C;

        reg {
            name = "Traffic control time configuration register";
            desc = "
                UD_GLB_FC_TIMECTRL is a traffic control time configuration register. The register does not support soft reset.

                DS name UD_GLB_FC_TIMECTRL; the same register exists in the up port (vendor U_GLB_FC_TIMECTRL) and in the down port at +0x2000 (vendor D_GLB_FC_TIMECTRL).

                Data sheet (Hi3520D/Hi3515A/Hi3515C data sheet issue 07 (2015-02-09)): section 5.1.6.3, Table 5-7, page 5-56, register description at text dump line 27369 (build/sdk-survey/datasheet.txt).
            ";

            field {
                name = "flux_timer_cfg";
                desc = "Traffic limit time interval counter, which is used to count the frequency division clock generated by flux_timer_inter. If this counter is set to 0, traffic limit is not performed.";
                reset = 0x3FF;
            } flux_timer_cfg[26:17];

            field {
                name = "flux_timer_inter";
                desc = "Traffic limit time slot counter, which is used to count the main clock. The default count is 100,000. For a 100-MHz main clock, the time slot is 1 ms.";
                reset = 0x186A0;
            } flux_timer_inter[16:0];

        } GLB_FC_TIMECTRL @ 0x370;

        reg {
            name = "Traffic control limit configuration register";
            desc = "
                UD_GLB_FC_RXLIMIT is a traffic control limit configuration register. The register does not support soft reset.

                DS name UD_GLB_FC_RXLIMIT; the same register exists in the up port (vendor U_GLB_FC_RXLIMIT) and in the down port at +0x2000 (vendor D_GLB_FC_RXLIMIT).

                Data sheet (Hi3520D/Hi3515A/Hi3515C data sheet issue 07 (2015-02-09)): section 5.1.6.3, Table 5-7, page 5-57, register description at text dump line 27405 (build/sdk-survey/datasheet.txt).
            ";

            field {
                name = "flux_cfg";
                desc = "Traffic limit upper threshold register. This group of bits is used to limit the number of frames received by software in the traffic limit time interval. The frames received after the configured upper threshold is exceeded are selectively discarded or received according to the configuration. When this group of bits is all set to 0, it indicates that traffic limit is not performed.";
                reset = 0x00000;
            } flux_cfg[19:0];

        } GLB_FC_RXLIMIT @ 0x374;

        reg {
            name = "Packet drop control register for traffic limit";
            desc = "
                UD_GLB_FC_DROPCTRL is a packet drop control register for traffic limit. The register does not support soft reset.

                DS name UD_GLB_FC_DROPCTRL; the same register exists in the up port (vendor U_GLB_FC_DROPCTRL) and in the down port at +0x2000 (vendor D_GLB_FC_DROPCTRL).

                Data sheet (Hi3520D/Hi3515A/Hi3515C data sheet issue 07 (2015-02-09)): section 5.1.6.3, Table 5-7, page 5-57, register description at text dump line 27431 (build/sdk-survey/datasheet.txt).
            ";

            enum flux_uni_enum {
                DO_NOT_DISCARD = 0x0 { desc = "Do not discard unicast packets."; };
                DISCARD_UNICAST_PACKETS = 0x1 { desc = "Discard unicast packets."; };
            };

            field {
                name = "flux_uni";
                desc = "Indicates whether unicast packets are discarded when the upper threshold of traffic limit is exceeded.";
                encode = flux_uni_enum;
                reset = 0x0;
            } flux_uni[2:2];

            enum flux_multi_enum {
                DO_NOT_DISCARD = 0x0 { desc = "Do not discard multicast packets."; };
                DISCARD_MULTICAST_PACKETS = 0x1 { desc = "Discard multicast packets."; };
            };

            field {
                name = "flux_multi";
                desc = "Indicates whether multicast packets are discarded when the upper threshold of traffic limit is exceeded.";
                encode = flux_multi_enum;
                reset = 0x0;
            } flux_multi[1:1];

            enum flux_broad_enum {
                DO_NOT_DISCARD = 0x0 { desc = "Do not discard broadcast packets."; };
                DISCARD_BROADCAST_PACKETS = 0x1 { desc = "Discard broadcast packets."; };
            };

            field {
                name = "flux_broad";
                desc = "Indicates whether broadcast packets are discarded when the upper threshold of traffic limit is exceeded.";
                encode = flux_broad_enum;
                reset = 0x0;
            } flux_broad[0:0];

        } GLB_FC_DROPCTRL @ 0x378;

`ifndef HISI_HIETH_SF_NO_EEE
        reg {
            name = "EEE raw interrupt register";
            desc = "
                UD_MAC_EEE_INT is an EEE raw interrupt register.

                DS name UD_MAC_EEE_INT; the same register exists in the up port (vendor U_MAC_EEE_INT) and in the down port at +0x2000 (vendor D_MAC_EEE_INT).

                Data sheet (Hi3520D/Hi3515A/Hi3515C data sheet issue 07 (2015-02-09)): section 5.1.6.2, Table 5-6, page 5-28, register description at text dump line 25619 (build/sdk-survey/datasheet.txt).
            ";

            field {
                name = "tx_entry_start";
                desc = "Raw interrupt that allows the PHY to enter the low-power idle (LPI) state in the ETH TX direction.";
                sw = r;
                hw = w;
                reset = 0x0;
            } tx_entry_start[4:4];

            field {
                name = "rx_leave_lpi";
                desc = "Raw interrupt that allows the PHY to exit the LPI state in the RX direction.";
                sw = r;
                hw = w;
                reset = 0x0;
            } rx_leave_lpi[3:3];

            field {
                name = "rx_entry_lpi";
                desc = "Raw interrupt that allows the PHY to enter the LPI state in the RX direction.";
                sw = r;
                hw = w;
                reset = 0x0;
            } rx_entry_lpi[2:2];

            field {
                name = "tx_leave_lpi";
                desc = "Raw interrupt that allows the PHY to exit the LPI state in the TX direction.";
                sw = r;
                hw = w;
                reset = 0x0;
            } tx_leave_lpi[1:1];

            field {
                name = "tx_entry_lpi";
                desc = "Raw interrupt that allows the PHY to enter the LPI state in the TX direction.";
                sw = r;
                hw = w;
                reset = 0x0;
            } tx_entry_lpi[0:0];

        } MAC_EEE_INT @ 0x480;

        reg {
            name = "EEE interrupt enable register";
            desc = "
                UD_MAC_EEE_INTEN is an EEE interrupt enable register.

                DS name UD_MAC_EEE_INTEN; the same register exists in the up port (vendor U_MAC_EEE_INTEN) and in the down port at +0x2000 (vendor D_MAC_EEE_INTEN).

                Data sheet (Hi3520D/Hi3515A/Hi3515C data sheet issue 07 (2015-02-09)): section 5.1.6.2, Table 5-6, page 5-29, register description at text dump line 25671 (build/sdk-survey/datasheet.txt).
            ";

            field {
                name = "tx_entry_start_msk";
                desc = "Mask of the raw interrupt that allows the PHY to enter the LPI state in the ETH TX direction.";
                reset = 0x0;
            } tx_entry_start_msk[9:9];

            field {
                name = "rx_leave_lpi_msk";
                desc = "Mask of the raw interrupt that allows the PHY to exit the LPI state in the RX direction.";
                reset = 0x0;
            } rx_leave_lpi_msk[8:8];

            field {
                name = "rx_entry_lpi_msk";
                desc = "Mask of the raw interrupt that allows the PHY to enter the LPI state in the RX direction.";
                reset = 0x0;
            } rx_entry_lpi_msk[7:7];

            field {
                name = "tx_leave_lpi_msk";
                desc = "Mask of the raw interrupt that allows the PHY to exit the LPI state in the TX direction.";
                reset = 0x0;
            } tx_leave_lpi_msk[6:6];

            field {
                name = "tx_entry_lpi_msk";
                desc = "Mask of the raw interrupt that allows the PHY to enter the LPI state in the TX direction.";
                reset = 0x0;
            } tx_entry_lpi_msk[5:5];

            field {
                name = "tx_entry_start_en";
                desc = "Enable for the raw interrupt that allows the PHY to enter the LPI state in the ETH TX direction.";
                sw = r;
                hw = w;
                reset = 0x0;
            } tx_entry_start_en[4:4];

            field {
                name = "rx_leave_lpi_en";
                desc = "Enable for the raw interrupt that allows the PHY to exit the LPI state in the RX direction.";
                sw = r;
                hw = w;
                reset = 0x0;
            } rx_leave_lpi_en[3:3];

            field {
                name = "rx_entry_lpi_en";
                desc = "Enable for the raw interrupt that allows the PHY to enter the LPI state in the RX direction.";
                sw = r;
                hw = w;
                reset = 0x0;
            } rx_entry_lpi_en[2:2];

            field {
                name = "tx_leave_lpi_en";
                desc = "Enable for the raw interrupt that allows the PHY to exit the LPI state in the TX direction.";
                sw = r;
                hw = w;
                reset = 0x0;
            } tx_leave_lpi_en[1:1];

            field {
                name = "tx_entry_lpi_en";
                desc = "Enable for the raw interrupt that allows the PHY to enter the LPI state in the TX direction.";
                sw = r;
                hw = w;
                reset = 0x0;
            } tx_entry_lpi_en[0:0];

        } MAC_EEE_INTEN @ 0x484;

        reg {
            name = "EEE enable register";
            desc = "
                UD_MAC_EEE_ENA is an EEE enable register.

                DS name UD_MAC_EEE_ENA; the same register exists in the up port (vendor U_MAC_EEE_ENA) and in the down port at +0x2000 (vendor D_MAC_EEE_ENA).

                Data sheet (Hi3520D/Hi3515A/Hi3515C data sheet issue 07 (2015-02-09)): section 5.1.6.2, Table 5-6, page 5-30, register description at text dump line 25738 (build/sdk-survey/datasheet.txt).
            ";

            field {
                name = "eee_ls_timer";
                desc = "LS timer.";
                reset = 0x00F4240;
            } eee_ls_timer[31:4];

            field {
                name = "eee_assert";
                desc = "EEE LPI state enable.";
                reset = 0x0;
            } eee_assert[1:1];

            field {
                name = "eee_enable";
                desc = "EEE enable.";
                reset = 0x0;
            } eee_enable[0:0];

        } MAC_EEE_ENA @ 0x488;

        reg {
            name = "Timer register required for the EEE function";
            desc = "
                UD_MAC_EEE_TIMER is a timer register required for the EEE function.

                DS name UD_MAC_EEE_TIMER; the same register exists in the up port (vendor U_MAC_EEE_TIMER) and in the down port at +0x2000 (vendor D_MAC_EEE_TIMER).

                Data sheet (Hi3520D/Hi3515A/Hi3515C data sheet issue 07 (2015-02-09)): section 5.1.6.2, Table 5-6, page 5-30, register description at text dump line 25767 (build/sdk-survey/datasheet.txt).
            ";

            field {
                name = "tx_wk_timer";
                desc = "TX_WK_TIMER.";
                reset = 0x001E;
            } tx_wk_timer[31:16];

            field {
                name = "lpi_cond_timer";
                desc = "LPI_COND_TIMER.";
                reset = 0x2710;
            } lpi_cond_timer[15:0];

        } MAC_EEE_TIMER @ 0x48C;

        reg {
            name = "UD_MAC_EEE_LINK_STATUS";
            desc = "
                UD_MAC_EEE_LINK_STATUS an ETH port link status register dedicated for the EEE function.

                DS name UD_MAC_EEE_LINK_STATUS; the same register exists in the up port (vendor U_MAC_EEE_LINK_STATUS) and in the down port at +0x2000 (vendor D_MAC_EEE_LINK_STATUS).

                Data sheet (Hi3520D/Hi3515A/Hi3515C data sheet issue 07 (2015-02-09)): section 5.1.6.2, Table 5-6, page 5-31, register description at text dump line 25804 (build/sdk-survey/datasheet.txt).
            ";

            field {
                name = "auto_eee";
                desc = "The logic controls the EEE process automatically without software interference.";
                reset = 0x0;
            } auto_eee[2:2];

            field {
                name = "eee_tx_press";
                desc = "TX back press data flow, allowing the EEE exit process to comply with the time requirement of wk_timer based on 802.3az.";
                reset = 0x0;
            } eee_tx_press[1:1];

            field {
                name = "phy_link_status";
                desc = "PHY link status.";
                reset = 0x0;
            } phy_link_status[0:0];

        } MAC_EEE_LINK_STATUS @ 0x490;

        reg {
            name = "EEE clock unit counter register";
            desc = "
                UD_MAC_EEE_CLK_CNT is an EEE clock unit counter register.

                DS name UD_MAC_EEE_CLK_CNT; the same register exists in the up port (vendor U_MAC_EEE_CLK_CNT) and in the down port at +0x2000 (vendor D_MAC_EEE_CLK_CNT).

                Data sheet (Hi3520D/Hi3515A/Hi3515C data sheet issue 07 (2015-02-09)): section 5.1.6.2, Table 5-6, page 5-31, register description at text dump line 25837 (build/sdk-survey/datasheet.txt).
            ";

            field {
                name = "eee_clk_cnt";
                desc = "EEE clock unit counter.";
                reset = 0x00000063;
            } eee_clk_cnt[31:0];

        } MAC_EEE_CLK_CNT @ 0x494;
`endif

        reg {
            name = "Port status counter";
            desc = "
                UD_STS_PORTCNT is a port status counter. The register does not support soft reset.

                DS name UD_STS_PORTCNT; the same register exists in the up port (vendor U_STS_PORTCNT) and in the down port at +0x2000 (vendor D_STS_PORTCNT).

                Data sheet (Hi3520D/Hi3515A/Hi3515C data sheet issue 07 (2015-02-09)): section 5.1.6.4, Table 5-8, page 5-58, register description at text dump line 27479 (build/sdk-survey/datasheet.txt).
            ";

            field {
                name = "rxsof_cnt";
                desc = "Count of the frame headers received by the port.";
                sw = r;
                hw = w;
                reset = 0x0;
            } rxsof_cnt[31:28];

            field {
                name = "rxeof_cnt";
                desc = "Count of the frame trailers received by the port.";
                sw = r;
                hw = w;
                reset = 0x0;
            } rxeof_cnt[27:24];

            field {
                name = "rxcrcok_cnt";
                desc = "Count of the frames without CRC errors received by the port.";
                sw = r;
                hw = w;
                reset = 0x0;
            } rxcrcok_cnt[23:20];

            field {
                name = "rxcrcbad_cnt";
                desc = "Count of the frames with CRC errors received by the port.";
                sw = r;
                hw = w;
                reset = 0x0;
            } rxcrcbad_cnt[19:16];

            field {
                name = "txsof_cnt";
                desc = "Count of the frame headers transmitted by the port.";
                sw = r;
                hw = w;
                reset = 0x0;
            } txsof_cnt[15:12];

            field {
                name = "txeof_cnt";
                desc = "Count of the frame trailers transmitted by the port.";
                sw = r;
                hw = w;
                reset = 0x0;
            } txeof_cnt[11:8];

            field {
                name = "txcrcok_cnt";
                desc = "Count of the frames without CRC errors transmitted by the port.";
                sw = r;
                hw = w;
                reset = 0x0;
            } txcrcok_cnt[7:4];

            field {
                name = "txcrcbad_cnt";
                desc = "Count of the frames with CRC errors transmitted by the port.";
                sw = r;
                hw = w;
                reset = 0x0;
            } txcrcbad_cnt[3:0];

        } STS_PORTCNT @ 0x584;

        reg {
            name = "Register for the total number of packets received by the CPU from the uplink or downlink port";
            desc = "
                UD_PORT2CPU_PKTS is a register for the total number of packets received by the CPU from the uplink or downlink port. The register does not support soft reset.

                DS name UD_PORT2CPU_PKTS; the same register exists in the up port (vendor U_PORT2CPU_PKTS) and in the down port at +0x2000 (vendor D_PORT2CPU_PKTS).

                Data sheet (Hi3520D/Hi3515A/Hi3515C data sheet issue 07 (2015-02-09)): section 5.1.6.4, Table 5-8, page 5-58, register description at text dump line 27506 (build/sdk-survey/datasheet.txt).
            ";

            field {
                name = "pkts_cpu";
                desc = "Total number of the packets received by the CPU port from the uplink or downlink port. Writing 0 clears this register. Writing 1 has no effect.";
                sw = rw;
                hw = w;
                reset = 0x0000;
            } pkts_cpu[15:0];

        } PORT2CPU_PKTS @ 0x5A0;

        reg {
            name = "Register for the count of configuring packet receiving address queue by the CPU";
            desc = "
                UD_CPU2IQ_ADDRCNT is a register for the count of configuring packet receiving address queue by the CPU. The register does not support soft reset.

                DS name UD_CPU2IQ_ADDRCNT; the same register exists in the up port (vendor U_CPU2IQ_ADDRCNT) and in the down port at +0x2000 (vendor D_CPU2IQ_ADDRCNT).

                Data sheet (Hi3520D/Hi3515A/Hi3515C data sheet issue 07 (2015-02-09)): section 5.1.6.4, Table 5-8, page 5-59, register description at text dump line 27541 (build/sdk-survey/datasheet.txt).
            ";

            field {
                name = "addr_cpu";
                desc = "Count of configuring packet receiving address queue by the CPU successfully. Writing 0 clears this register. Writing 1 has no effect.";
                sw = rw;
                hw = w;
                reset = 0x0000;
            } addr_cpu[15:0];

        } CPU2IQ_ADDRCNT @ 0x5A4;

        reg {
            name = "Register for the count of reporting single-packet interrupt by the uplink or downlink port";
            desc = "
                UD_RX_IRQCNT is a register for the count of reporting single-packet interrupt by the uplink or downlink port. The register does not support soft reset.

                DS name UD_RX_IRQCNT; the same register exists in the up port (vendor U_RX_IRQCNT) and in the down port at +0x2000 (vendor D_RX_IRQCNT).

                Data sheet (Hi3520D/Hi3515A/Hi3515C data sheet issue 07 (2015-02-09)): section 5.1.6.4, Table 5-8, page 5-59, register description at text dump line 27564 (build/sdk-survey/datasheet.txt).
            ";

            field {
                name = "pkts_port";
                desc = "Count of the frame RX interrupts reported by the uplink or downlink port. Writing 0 clears this register. Writing 1 has no effect.";
                sw = rw;
                hw = w;
                reset = 0x0000;
            } pkts_port[15:0];

        } RX_IRQCNT @ 0x5A8;

        reg {
            name = "Register for the total number of packets transmitted by the CPU to the uplink or downlink port";
            desc = "
                UD_CPU2EQ_PKTS is a register for the total number of packets transmitted by the CPU to the uplink or downlink port. The register does not support soft reset.

                DS name UD_CPU2EQ_PKTS; the same register exists in the up port (vendor U_CPU2EQ_PKTS) and in the down port at +0x2000 (vendor D_CPU2EQ_PKTS).

                Data sheet (Hi3520D/Hi3515A/Hi3515C data sheet issue 07 (2015-02-09)): section 5.1.6.4, Table 5-8, page 5-60, register description at text dump line 27595 (build/sdk-survey/datasheet.txt).
            ";

            field {
                name = "pkts_cpu2tx";
                desc = "Total number of packets transmitted by the CPU to the uplink or downlink port. Writing 0 clears this register. Writing 1 has no effect.";
                sw = rw;
                hw = w;
                reset = 0x0000;
            } pkts_cpu2tx[15:0];

        } CPU2EQ_PKTS @ 0x5AC;

        reg {
            name = "RXDV rising edge count register";
            desc = "
                UD_RX_DVCNT is an RXDV rising edge count register. The register does not support soft reset.

                DS name UD_rx_DVCNT; the same register exists in the up port (vendor U_RX_DVCNT) and in the down port at +0x2000 (vendor D_RX_DVCNT).

                Data sheet (Hi3520D/Hi3515A/Hi3515C data sheet issue 07 (2015-02-09)): section 5.1.6.5, Table 5-9, page 5-60, register description at text dump line 27622 (build/sdk-survey/datasheet.txt).
            ";

            field {
                name = "rxdvrise";
                desc = "Count of all RXDV rising edges.";
                sw = r;
                hw = w;
                reset = 0x00000000;
            } rxdvrise[31:0];

        } RX_DVCNT @ 0x600;

        reg {
            name = "Register for the total number of bytes received";
            desc = "
                UD_RX_OCTS is a register for the total number of bytes received. The register does not support soft reset.

                DS name UD_RX_OCTS; the same register exists in the up port (vendor U_RX_OCTS) and in the down port at +0x2000 (vendor D_RX_OCTS).

                Data sheet (Hi3520D/Hi3515A/Hi3515C data sheet issue 07 (2015-02-09)): section 5.1.6.5, Table 5-9, page 5-61, register description at text dump line 27651 (build/sdk-survey/datasheet.txt).
            ";

            field {
                name = "ifinoctets";
                desc = "Count of all received bytes, including the bytes in correct frames, error frames, and preambles. The frames without valid start of frame delimiters (SFDs) are not counted.";
                sw = r;
                hw = w;
                reset = 0x00000000;
            } ifinoctets[31:0];

        } RX_OCTS @ 0x604;

        reg {
            name = "Register for the total number of bytes of received correct packets";
            desc = "
                UD_RX_RIGHTOCTS is a register for the total number of bytes of received correct packets. The register does not support soft reset.

                DS name UD_RX_RIGHTOCTS; the same register exists in the up port (vendor U_RX_RIGHTOCTS) and in the down port at +0x2000 (vendor D_RX_RIGHTOCTS).

                Data sheet (Hi3520D/Hi3515A/Hi3515C data sheet issue 07 (2015-02-09)): section 5.1.6.5, Table 5-9, page 5-61, register description at text dump line 27672 (build/sdk-survey/datasheet.txt).
            ";

            field {
                name = "octets_rx";
                desc = "Count of the received bytes, including the bytes in correct frames and error frames but excluding the bytes in preambles. The frames without valid SFDs are not counted.";
                sw = r;
                hw = w;
                reset = 0x00000000;
            } octets_rx[31:0];

        } RX_RIGHTOCTS @ 0x608;

        reg {
            name = "Register for the number of packets matching the local MAC address";
            desc = "
                UD_HOSTMAC_PKTS is a register for the number of packets matching the local MAC address. The register does not support soft reset.

                DS name UD_HOSTMAC_PKTS; the same register exists in the up port (vendor U_HOSTMAC_PKTS) and in the down port at +0x2000 (vendor D_HOSTMAC_PKTS).

                Data sheet (Hi3520D/Hi3515A/Hi3515C data sheet issue 07 (2015-02-09)): section 5.1.6.5, Table 5-9, page 5-61, register description at text dump line 27695 (build/sdk-survey/datasheet.txt).
            ";

            field {
                name = "local_mac_match";
                desc = "Count of correct RX frames whose destination MAC address is the same as the local MAC address, excluding short frames, long frames, frames with CRC errors, pause frames, and error TX frames.";
                sw = r;
                hw = w;
                reset = 0x00000000;
            } local_mac_match[31:0];

        } HOSTMAC_PKTS @ 0x60C;

        reg {
            name = "Register for the total number of packets received by the port";
            desc = "
                UD_RX_RIGHTPKTS is a register for the total number of packets received by the port. The register does not support soft reset.

                DS name UD_RX_RIGHTPKTS; the same register exists in the up port (vendor U_RX_RIGHTPKTS) and in the down port at +0x2000 (vendor D_RX_RIGHTPKTS).

                Data sheet (Hi3520D/Hi3515A/Hi3515C data sheet issue 07 (2015-02-09)): section 5.1.6.5, Table 5-9, page 5-62, register description at text dump line 27730 (build/sdk-survey/datasheet.txt).
            ";

            field {
                name = "pkts";
                desc = "Count of all frames.";
                sw = r;
                hw = w;
                reset = 0x00000000;
            } pkts[31:0];

        } RX_RIGHTPKTS @ 0x610;

        reg {
            name = "Register for the number of correct broadcast packets";
            desc = "
                UD_RX_BROADPKTS is a register for the number of correct broadcast packets. The register does not support soft reset.

                DS name UD_RX_broadpkts; the same register exists in the up port (vendor U_RX_BROADPKTS) and in the down port at +0x2000 (vendor D_RX_BROADPKTS).

                Data sheet (Hi3520D/Hi3515A/Hi3515C data sheet issue 07 (2015-02-09)): section 5.1.6.5, Table 5-9, page 5-62, register description at text dump line 27749 (build/sdk-survey/datasheet.txt).
            ";

            field {
                name = "broadcastpkts";
                desc = "Count of broadcast frames with valid length and without CRC errors, excluding pause frames and error TX frames.";
                sw = r;
                hw = w;
                reset = 0x00000000;
            } broadcastpkts[31:0];

        } RX_BROADPKTS @ 0x614;

        reg {
            name = "Register for the number of correct multicast packets";
            desc = "
                UD_RX_MULTPKTS is a register for the number of correct multicast packets. The register does not support soft reset.

                DS name UD_RX_multpkts; the same register exists in the up port (vendor U_RX_MULTPKTS) and in the down port at +0x2000 (vendor D_RX_MULTPKTS).

                Data sheet (Hi3520D/Hi3515A/Hi3515C data sheet issue 07 (2015-02-09)): section 5.1.6.5, Table 5-9, page 5-63, register description at text dump line 27782 (build/sdk-survey/datasheet.txt).
            ";

            field {
                name = "multicastpkts";
                desc = "Count of multicast frames with valid length and without CRC errors, excluding pause frames and error TX frames.";
                sw = r;
                hw = w;
                reset = 0x00000000;
            } multicastpkts[31:0];

        } RX_MULTPKTS @ 0x618;

        reg {
            name = "Register for the number of correct unicast packets";
            desc = "
                UD_RX_UNIPKTS is a register for the number of correct unicast packets. The register does not support soft reset.

                DS name UD_RX_UNIpkts; the same register exists in the up port (vendor U_RX_UNIPKTS) and in the down port at +0x2000 (vendor D_RX_UNIPKTS).

                Data sheet (Hi3520D/Hi3515A/Hi3515C data sheet issue 07 (2015-02-09)): section 5.1.6.5, Table 5-9, page 5-63, register description at text dump line 27803 (build/sdk-survey/datasheet.txt).
            ";

            field {
                name = "ifinucastpkts";
                desc = "Count of unicast frames with valid length and without CRC errors, excluding pause frames and error TX frames.";
                sw = r;
                hw = w;
                reset = 0x00000000;
            } ifinucastpkts[31:0];

        } RX_UNIPKTS @ 0x61C;

        reg {
            name = "Register for the total number of incorrect packets";
            desc = "
                UD_RX_ERRPKTS is a register for the total number of incorrect packets. The register does not support soft reset.

                DS name UD_RX_ERRPKTS; the same register exists in the up port (vendor U_RX_ERRPKTS) and in the down port at +0x2000 (vendor D_RX_ERRPKTS).

                Data sheet (Hi3520D/Hi3515A/Hi3515C data sheet issue 07 (2015-02-09)): section 5.1.6.5, Table 5-9, page 5-63, register description at text dump line 27825 (build/sdk-survey/datasheet.txt).
            ";

            field {
                name = "ifinerrors";
                desc = "Count of all error frames, including frames with CRC errors, short frames, long frames, and error TX frames.";
                sw = r;
                hw = w;
                reset = 0x00000000;
            } ifinerrors[31:0];

        } RX_ERRPKTS @ 0x620;

        reg {
            name = "Register for the count of CRC errors";
            desc = "
                UD_RX_CRCERR_PKTS is a register for the count of CRC errors. The register does not support soft reset.

                DS name UD_RX_crcerr_PKTS; the same register exists in the up port (vendor U_RX_CRCERR_PKTS) and in the down port at +0x2000 (vendor D_RX_CRCERR_PKTS).

                Data sheet (Hi3520D/Hi3515A/Hi3515C data sheet issue 07 (2015-02-09)): section 5.1.6.5, Table 5-9, page 5-64, register description at text dump line 27856 (build/sdk-survey/datasheet.txt).
            ";

            field {
                name = "crcerr";
                desc = "Count of RX frames with valid length (non short and long frames) but with CRC or alignment errors.";
                sw = r;
                hw = w;
                reset = 0x00000000;
            } crcerr[31:0];

        } RX_CRCERR_PKTS @ 0x624;

        reg {
            name = "Register for the number of packets with invalid length";
            desc = "
                UD_RX_LENERR_PKTS is a register for the number of packets with invalid length. The register does not support soft reset.

                DS name UD_RX_LENERR_pkts; the same register exists in the up port (vendor U_RX_LENERR_PKTS) and in the down port at +0x2000 (vendor D_RX_LENERR_PKTS).

                Data sheet (Hi3520D/Hi3515A/Hi3515C data sheet issue 07 (2015-02-09)): section 5.1.6.5, Table 5-9, page 5-64, register description at text dump line 27877 (build/sdk-survey/datasheet.txt).
            ";

            field {
                name = "abnormalsizepkts";
                desc = "Count of frames (short frames and long frames) with invalid length (less than the set minimum valid length or greater than the set maximum valid length).";
                sw = r;
                hw = w;
                reset = 0x00000000;
            } abnormalsizepkts[31:0];

        } RX_LENERR_PKTS @ 0x628;

        reg {
            name = "Register for the number of packets with odd nibbles and CRC errors";
            desc = "
                UD_RX_OCRCERR_PKTS is a register for the number of packets with odd nibbles and CRC errors. The register does not support soft reset.

                DS name UD_RX_OCRCERR_PKTS; the same register exists in the up port (vendor U_RX_OCRCERR_PKTS) and in the down port at +0x2000 (vendor D_RX_OCRCERR_PKTS).

                Data sheet (Hi3520D/Hi3515A/Hi3515C data sheet issue 07 (2015-02-09)): section 5.1.6.5, Table 5-9, page 5-64, register description at text dump line 27900 (build/sdk-survey/datasheet.txt).
            ";

            field {
                name = "dot3alignmenterr";
                desc = "Received frames with odd nibbles and CRC errors.";
                sw = r;
                hw = w;
                reset = 0x00000000;
            } dot3alignmenterr[31:0];

        } RX_OCRCERR_PKTS @ 0x62C;

        reg {
            name = "Register for the number of received pause packets";
            desc = "
                UD_RX_PAUSE_PKTS is a register for the number of received pause packets. The register does not support soft reset.

                DS name UD_RX_PAUSE_PKTS; the same register exists in the up port (vendor U_RX_PAUSE_PKTS) and in the down port at +0x2000 (vendor D_RX_PAUSE_PKTS).

                Data sheet (Hi3520D/Hi3515A/Hi3515C data sheet issue 07 (2015-02-09)): section 5.1.6.5, Table 5-9, page 5-65, register description at text dump line 27930 (build/sdk-survey/datasheet.txt).
            ";

            field {
                name = "dot3pause";
                desc = "Count of received pause frames.";
                sw = r;
                hw = w;
                reset = 0x00000000;
            } dot3pause[31:0];

        } RX_PAUSE_PKTS @ 0x630;

        reg {
            name = "Register for the count of RXFIFO overflow events";
            desc = "
                UD_RF_OVERCNT is a register for the count of RXFIFO overflow events. The register does not support soft reset.

                DS name UD_RF_OVERCNT; the same register exists in the up port (vendor U_RF_OVERCNT) and in the down port at +0x2000 (vendor D_RF_OVERCNT).

                Data sheet (Hi3520D/Hi3515A/Hi3515C data sheet issue 07 (2015-02-09)): section 5.1.6.5, Table 5-9, page 5-65, register description at text dump line 27950 (build/sdk-survey/datasheet.txt).
            ";

            field {
                name = "dropevents";
                desc = "Accumulative count of RXFIFO overflow events during the reception of frames.";
                sw = r;
                hw = w;
                reset = 0x00000000;
            } dropevents[31:0];

        } RF_OVERCNT @ 0x634;

        reg {
            name = "Register for the total number of received packets allowed by the traffic limit";
            desc = "
                UD_FLUX_TOL_IPKTS is a register for the total number of received packets allowed by the traffic limit. The register does not support soft reset.

                DS name UD_flux_TOL_IPKTS; the same register exists in the up port (vendor U_FLUX_TOL_IPKTS) and in the down port at +0x2000 (vendor D_FLUX_TOL_IPKTS).

                Data sheet (Hi3520D/Hi3515A/Hi3515C data sheet issue 07 (2015-02-09)): section 5.1.6.5, Table 5-9, page 5-66, register description at text dump line 27980 (build/sdk-survey/datasheet.txt).
            ";

            field {
                name = "flux_frame_cnt";
                desc = "Total count of correct RX frames allowed by the traffic limit, excluding short frames, long frames, frames with CRC errors, pause frames, and error TX frames.";
                sw = r;
                hw = w;
                reset = 0x00000000;
            } flux_frame_cnt[31:0];

        } FLUX_TOL_IPKTS @ 0x638;

        reg {
            name = "Register for the total number of packets discarded due to traffic limit";
            desc = "
                UD_FLUX_TOL_DPKTS is a register for the total number of packets discarded due to traffic limit. The register does not support soft reset.

                DS name UD_flux_TOL_DPKTS; the same register exists in the up port (vendor U_FLUX_TOL_DPKTS) and in the down port at +0x2000 (vendor D_FLUX_TOL_DPKTS).

                Data sheet (Hi3520D/Hi3515A/Hi3515C data sheet issue 07 (2015-02-09)): section 5.1.6.5, Table 5-9, page 5-66, register description at text dump line 28001 (build/sdk-survey/datasheet.txt).
            ";

            field {
                name = "flux_drop_cnt";
                desc = "Count of correct frames discarded due to traffic limit, excluding short frames, long frames, frames with CRC errors, pause frames, and error TX frames.";
                sw = r;
                hw = w;
                reset = 0x00000000;
            } flux_drop_cnt[31:0];

        } FLUX_TOL_DPKTS @ 0x63C;

`ifdef HISI_HIETH_SF_VLAN_CNT
        reg {
            name = "Register for the number of packets not forwarded to another port due to VLAN limit";
            desc = "
                UD_VN2OTH_PKTS is a register for the number of packets not forwarded to another port due to VLAN limit. The register does not support soft reset.

                DS name UD_VN2OTH_PKTS; the same register exists in the up port and in the down port at +0x2000. Only in the Hi3515 data sheet (the Hi3520D/Hi3515A/Hi3515C data sheet does not list 0x640-0x648); enabled by `define HISI_HIETH_SF_VLAN_CNT.

                Hi3515 data sheet (issue 02, 2010-04-20) 5.6 UD_VN2OTH_PKTS (offset 0X640, printed page 5-67, `Hi3515-Datasheet.txt` line 25392).
            ";

            field {
                name = "vlan_not2oth_pkts";
                desc = "A register for the number of packets not forwarded to another port due to VLAN limit.";
                sw = r;
                hw = w;
                reset = 0x00000000;
            } vlan_not2oth_pkts[31:0];

        } VN2OTH_PKTS @ 0X640;

        reg {
            name = "Register for the number of packets not forwarded to the CPU port due to VLAN limit";
            desc = "
                UD_VN2CPU_PKTS is a register for the number of packets not forwarded to the CPU port due to VLAN limit. The register does not support soft reset.

                DS name UD_VN2CPU_PKTS; the same register exists in the up port and in the down port at +0x2000. Only in the Hi3515 data sheet (the Hi3520D/Hi3515A/Hi3515C data sheet does not list 0x640-0x648); enabled by `define HISI_HIETH_SF_VLAN_CNT.

                Hi3515 data sheet (issue 02, 2010-04-20) 5.6 UD_VN2CPU_PKTS (offset 0X644, printed page 5-67, `Hi3515-Datasheet.txt` line 25414).
            ";

            field {
                name = "vlan_not2cpu_pkts";
                desc = "A register for the number of packets not forwarded to the CPU port due to VLAN limit.";
                sw = r;
                hw = w;
                reset = 0x00000000;
            } vlan_not2cpu_pkts[31:0];

        } VN2CPU_PKTS @ 0X644;

        reg {
            name = "Register for the number of packets not forwarded to another port due to MAC limit";
            desc = "
                UD_MN2OTH_PKTS is a register for the number of packets not forwarded to another port due to MAC limit. The register does not support soft reset.

                DS name UD_MN2OTH_PKTS; the same register exists in the up port and in the down port at +0x2000. Only in the Hi3515 data sheet (the Hi3520D/Hi3515A/Hi3515C data sheet does not list 0x640-0x648); enabled by `define HISI_HIETH_SF_VLAN_CNT.

                Hi3515 data sheet (issue 02, 2010-04-20) 5.6 UD_MN2OTH_PKTS (offset 0X648, printed page 5-67, `Hi3515-Datasheet.txt` line 25436).
            ";

            field {
                name = "mac_not2oth_pkts";
                desc = "A register for the number of packets not forwarded to another port due to MAC limit.";
                sw = r;
                hw = w;
                reset = 0x00000000;
            } mac_not2oth_pkts[31:0];

        } MN2OTH_PKTS @ 0X648;

`endif

        reg {
            name = "Register for the number of packets not forwarded to the CPU port due to MAC limit";
            desc = "
                UD_MN2CPU_PKTS is a register for the number of packets not forwarded to the CPU port due to MAC limit. The register does not support soft reset.

                DS name UD_MN2CPU_PKTS; the same register exists in the up port (vendor U_MN2CPU_PKTS) and in the down port at +0x2000 (vendor D_MN2CPU_PKTS).

                Data sheet (Hi3520D/Hi3515A/Hi3515C data sheet issue 07 (2015-02-09)): section 5.1.6.5, Table 5-9, page 5-66, register description at text dump line 28023 (build/sdk-survey/datasheet.txt).
            ";

            field {
                name = "mac_not2cpu_pkts";
                desc = "Number of packets not forwarded to the CPU port due to MAC limit.";
                sw = r;
                hw = w;
                reset = 0x00000000;
            } mac_not2cpu_pkts[31:0];

        } MN2CPU_PKTS @ 0x64C;

        reg {
            name = "Register for the total number of packets transmitted successfully";
            desc = "
                UD_TX_PKTS is a register for the total number of packets transmitted successfully. The register does not support soft reset.

                DS name UD_TX_PKTS; the same register exists in the up port (vendor U_TX_PKTS) and in the down port at +0x2000 (vendor D_TX_PKTS).

                Data sheet (Hi3520D/Hi3515A/Hi3515C data sheet issue 07 (2015-02-09)): section 5.1.6.5, Table 5-9, page 5-67, register description at text dump line 28055 (build/sdk-survey/datasheet.txt).
            ";

            field {
                name = "pkts_tx";
                desc = "Count of all configured TX frames, excluding the frames discarded due to timeout and the TX frames whose length of UD_GLB_EQFRM_LEN is not within valid range.";
                sw = r;
                hw = w;
                reset = 0x00000000;
            } pkts_tx[31:0];

        } TX_PKTS @ 0x780;

        reg {
            name = "Register for the number of broadcast packets transmitted successfully";
            desc = "
                UD_TX_BROADPKTS is a register for the number of broadcast packets transmitted successfully. The register does not support soft reset.

                DS name UD_TX_BROADPKTS; the same register exists in the up port (vendor U_TX_BROADPKTS) and in the down port at +0x2000 (vendor D_TX_BROADPKTS).

                Data sheet (Hi3520D/Hi3515A/Hi3515C data sheet issue 07 (2015-02-09)): section 5.1.6.5, Table 5-9, page 5-67, register description at text dump line 28076 (build/sdk-survey/datasheet.txt).
            ";

            field {
                name = "broadcastpkts_tx";
                desc = "Count of broadcast frames transmitted successfully (excluding retransmission).";
                sw = r;
                hw = w;
                reset = 0x00000000;
            } broadcastpkts_tx[31:0];

        } TX_BROADPKTS @ 0x784;

        reg {
            name = "Register for the number of multicast packets transmitted successfully";
            desc = "
                UD_TX_MULTPKTS is a register for the number of multicast packets transmitted successfully. The register does not support soft reset.

                DS name UD_TX_MULTPKTS; the same register exists in the up port (vendor U_TX_MULTPKTS) and in the down port at +0x2000 (vendor D_TX_MULTPKTS).

                Data sheet (Hi3520D/Hi3515A/Hi3515C data sheet issue 07 (2015-02-09)): section 5.1.6.5, Table 5-9, page 5-68, register description at text dump line 28107 (build/sdk-survey/datasheet.txt).
            ";

            field {
                name = "multicastpkts_tx";
                desc = "Count of multicast frames transmitted successfully (excluding retransmission).";
                sw = r;
                hw = w;
                reset = 0x00000000;
            } multicastpkts_tx[31:0];

        } TX_MULTPKTS @ 0x788;

        reg {
            name = "Register for the number of unicast packets transmitted successfully";
            desc = "
                UD_TX_UNIPKTS is a register for the number of unicast packets transmitted successfully. The register does not support soft reset.

                DS name UD_TX_UNIPKTS; the same register exists in the up port (vendor U_TX_UNIPKTS) and in the down port at +0x2000 (vendor D_TX_UNIPKTS).

                Data sheet (Hi3520D/Hi3515A/Hi3515C data sheet issue 07 (2015-02-09)): section 5.1.6.5, Table 5-9, page 5-68, register description at text dump line 28128 (build/sdk-survey/datasheet.txt).
            ";

            field {
                name = "ifoutucastpkts_tx";
                desc = "Count of unicast frames transmitted successfully (excluding retransmission).";
                sw = r;
                hw = w;
                reset = 0x00000000;
            } ifoutucastpkts_tx[31:0];

        } TX_UNIPKTS @ 0x78C;

        reg {
            name = "Register for the total number of transmitted bytes";
            desc = "
                UD_TX_OCTS is a register for the total number of transmitted bytes. The register does not support soft reset.

                DS name UD_TX_OCTS; the same register exists in the up port (vendor U_TX_OCTS) and in the down port at +0x2000 (vendor D_TX_OCTS).

                Data sheet (Hi3520D/Hi3515A/Hi3515C data sheet issue 07 (2015-02-09)): section 5.1.6.5, Table 5-9, page 5-68, register description at text dump line 28149 (build/sdk-survey/datasheet.txt).
            ";

            field {
                name = "octets_tx";
                desc = "Total count of transmitted bytes, including the bytes of retransmit frames, correct frames, and error frames, but excluding the preamble bytes.";
                sw = r;
                hw = w;
                reset = 0x00000000;
            } octets_tx[31:0];

        } TX_OCTS @ 0x790;

        reg {
            name = "Register for the number of transmitted pause frames";
            desc = "
                UD_TX_PAUSE_PKTS is a register for the number of transmitted pause frames. The register does not support soft reset.

                DS name UD_TX_PAUSE_PKTS; the same register exists in the up port (vendor U_TX_PAUSE_PKTS) and in the down port at +0x2000 (vendor D_TX_PAUSE_PKTS).

                Data sheet (Hi3520D/Hi3515A/Hi3515C data sheet issue 07 (2015-02-09)): section 5.1.6.5, Table 5-9, page 5-69, register description at text dump line 28177 (build/sdk-survey/datasheet.txt).
            ";

            field {
                name = "dot3outpause";
                desc = "Count of transmitted pause frames.";
                sw = r;
                hw = w;
                reset = 0x00000000;
            } dot3outpause[31:0];

        } TX_PAUSE_PKTS @ 0x794;

        reg {
            name = "Register for the total count of retransmission";
            desc = "
                UD_TX_RETRYCNT is a register for the total count of retransmission. The register does not support soft reset.

                DS name UD_TX_RETRYCNT; the same register exists in the up port (vendor U_TX_RETRYCNT) and in the down port at +0x2000 (vendor D_TX_RETRYCNT).

                Data sheet (Hi3520D/Hi3515A/Hi3515C data sheet issue 07 (2015-02-09)): section 5.1.6.5, Table 5-9, page 5-69, register description at text dump line 28197 (build/sdk-survey/datasheet.txt).
            ";

            field {
                name = "retry_times_tx";
                desc = "Total count of retransmissions of TX frames.";
                sw = r;
                hw = w;
                reset = 0x00000000;
            } retry_times_tx[31:0];

        } TX_RETRYCNT @ 0x798;

        reg {
            name = "Register for the total count of collisions";
            desc = "
                UD_TX_COLCNT is a register for the total count of collisions. The register does not support soft reset.

                DS name UD_TX_COLCNT; the same register exists in the up port (vendor U_TX_COLCNT) and in the down port at +0x2000 (vendor D_TX_COLCNT).

                Data sheet (Hi3520D/Hi3515A/Hi3515C data sheet issue 07 (2015-02-09)): section 5.1.6.5, Table 5-9, page 5-69, register description at text dump line 28217 (build/sdk-survey/datasheet.txt).
            ";

            field {
                name = "collisions";
                desc = "Count of collisions.";
                sw = r;
                hw = w;
                reset = 0x00000000;
            } collisions[31:0];

        } TX_COLCNT @ 0x79C;

        reg {
            name = "Register for the number of packets with late collision";
            desc = "
                UD_TX_LC_PKTS is a register for the number of packets with late collision. The register does not support soft reset.

                DS name UD_TX_LC_PKTS; the same register exists in the up port (vendor U_TX_LC_PKTS) and in the down port at +0x2000 (vendor D_TX_LC_PKTS).

                Data sheet (Hi3520D/Hi3515A/Hi3515C data sheet issue 07 (2015-02-09)): section 5.1.6.5, Table 5-9, page 5-70, register description at text dump line 28245 (build/sdk-survey/datasheet.txt).
            ";

            field {
                name = "dot3latecol";
                desc = "Count of packets with late collision.";
                sw = r;
                hw = w;
                reset = 0x00000000;
            } dot3latecol[31:0];

        } TX_LC_PKTS @ 0x7A0;

        reg {
            name = "Register for the number of packets transmitted successfully with collisions";
            desc = "
                UD_TX_COLOK_PKTS is a register for the number of packets transmitted successfully with collisions. The register does not support soft reset.

                DS name UD_TX_COLOK_PKTS; the same register exists in the up port (vendor U_TX_COLOK_PKTS) and in the down port at +0x2000 (vendor D_TX_COLOK_PKTS).

                Data sheet (Hi3520D/Hi3515A/Hi3515C data sheet issue 07 (2015-02-09)): section 5.1.6.5, Table 5-9, page 5-70, register description at text dump line 28265 (build/sdk-survey/datasheet.txt).
            ";

            field {
                name = "dot3col_ok";
                desc = "Count of packets transmitted successfully with collisions.";
                sw = r;
                hw = w;
                reset = 0x00000000;
            } dot3col_ok[31:0];

        } TX_COLOK_PKTS @ 0x7A4;

        reg {
            name = "Register for the number of packets discarded due to more than 15 times of retransmission";
            desc = "
                UD_TX_RETRY15_PKTS is a register for the number of packets discarded due to more than 15 times of retransmission. The register does not support soft reset.

                DS name UD_TX_RETRY15_PKTS; the same register exists in the up port (vendor U_TX_RETRY15_PKTS) and in the down port at +0x2000 (vendor D_TX_RETRY15_PKTS).

                Data sheet (Hi3520D/Hi3515A/Hi3515C data sheet issue 07 (2015-02-09)): section 5.1.6.5, Table 5-9, page 5-70, register description at text dump line 28285 (build/sdk-survey/datasheet.txt).
            ";

            field {
                name = "dot3excessivecol";
                desc = "Count of the packets discarded due to more than 15 times of retransmission.";
                sw = r;
                hw = w;
                reset = 0x00000000;
            } dot3excessivecol[31:0];

        } TX_RETRY15_PKTS @ 0x7A8;

        reg {
            name = "Register for the number of packets with the count of collisions being equal to the threshold";
            desc = "
                UD_TX_RETRYN_PKTS is a register for the number of packets with the count of collisions being equal to the threshold. The register does not support soft reset.

                DS name UD_TX_RETRYN_PKTS; the same register exists in the up port (vendor U_TX_RETRYN_PKTS) and in the down port at +0x2000 (vendor D_TX_RETRYN_PKTS).

                Data sheet (Hi3520D/Hi3515A/Hi3515C data sheet issue 07 (2015-02-09)): section 5.1.6.5, Table 5-9, page 5-71, register description at text dump line 28317 (build/sdk-survey/datasheet.txt).
            ";

            field {
                name = "dot3colcnt";
                desc = "Count of packets with the count of collisions being equal to the threshold. This register is set by UD_MAC_SET[colthreshold].";
                sw = r;
                hw = w;
                reset = 0x00000000;
            } dot3colcnt[31:0];

        } TX_RETRYN_PKTS @ 0x7AC;

        reg {
            name = "RX inter-packet-gap control register (vendor only)";
            desc = "
                NOT IN THE DATA SHEET. Taken from the vendor driver (u-boot-2010.06 drivers/net/hisfv300/mac.h and mac.c); the data sheet does not list this register and gives no reset value. Vendor name U_MAC_RX_IPGCTRL / D_MAC_RX_IPGCTRL at 0x0214 / 0x2214; no field layout is defined in the vendor sources (only the offset).
            ";

            field {
                name = "ipgctrl";
                desc = "RX IPG control. Bit layout unknown: the vendor sources only define the offset.";
                sw = rw;
            } ipgctrl[31:0];

        } MAC_RX_IPGCTRL @ 0x214;

        reg {
            name = "TX inter-packet-gap control register (vendor only)";
            desc = "
                NOT IN THE DATA SHEET. Taken from the vendor driver (u-boot-2010.06 drivers/net/hisfv300/mac.h and mac.c); the data sheet does not list this register and gives no reset value. Vendor name U_MAC_TX_IPGCTRL / D_MAC_TX_IPGCTRL at 0x0218 / 0x2218. Field layout from mac.h (BITS_PRE_CNT_LIMIT, BITS_IPG, BITS_FC_INTER). The hardware-verified U-Boot driver clears pre_cnt_limit (bits 25:23) during init.
            ";

            field {
                name = "pre_cnt_limit";
                desc = "Lead-code (preamble) count limit (vendor hieth_set_mac_leadcode_cnt_limit). Vendor mac.h BITS_PRE_CNT_LIMIT = bits [25:23].";
                sw = rw;
            } pre_cnt_limit[25:23];

            field {
                name = "ipg";
                desc = "Transmit inter-packet gap in bits (vendor hieth_set_mac_trans_interval_bits). Vendor mac.h BITS_IPG = bits [22:16].";
                sw = rw;
            } ipg[22:16];

            field {
                name = "fc_inter";
                desc = "Flow control (pause frame) interval (vendor hieth_set_mac_fc_interval). Vendor mac.h BITS_FC_INTER = bits [15:0].";
                sw = rw;
            } fc_inter[15:0];

        } MAC_TX_IPGCTRL @ 0x218;
};

regfile eHISI_HIETH_SF_MDIO {
    name = "ETH MDIO command registers";
    desc = "
    Shared MDIO master command and read-data registers (block base +0x1100; the register offsets below are relative to it, e.g. MDIO_RWCTRL is at ETH+0x1100). The per-port PHY address, status-scan and mask registers (`MDIO_PHYADDR`, `MDIO_RO_STAT`, `MDIO_ANEG_CTRL`, `MDIO_IRQENA`) live in the port register files. These registers do not support soft reset (GLB_SOFT_RESET).
    ";

        reg {
            name = "MDIO command word register";
            desc = "
                MDIO_RWCTRL is an MDIO command word register. The register does not support soft reset.

                Data sheet (Hi3520D/Hi3515A/Hi3515C data sheet issue 07 (2015-02-09)): section 5.1.6.1, Table 5-5, page 5-18, register description at text dump line 25039 (build/sdk-survey/datasheet.txt).
            ";

            field {
                name = "cpu_data_in";
                desc = "Data used by the MDIO module to perform write operation on the PHY chip. During write operation, the CPU first writes the 16-bit data to be written to the MDIO to this register.";
                reset = 0x0000;
            } cpu_data_in[31:16];

            enum finish_enum {
                NOT_COMPLETE = 0x0 { desc = "Not complete."; };
                COMPLETE = 0x1 { desc = "Complete."; };
            };

            field {
                name = "finish";
                desc = "PHY read/write operation complete. When the read/write operation is required for the second time, the CPU must clear this bit first. Hardware sets this bit when the command completes. Hardware-verified (U-Boot hieth_sf.c): finish keeps reading back as still set for a short while after a new command is written, so a poll issued straight after the write sees the previous operation state (and stale read data); wait ~10 us before polling. The reset value 0x8000 (finish = 1) is also what the vendor driver writes to re-initialise the register.";
                encode = finish_enum;
                hw = rw;
                reset = 0x1;
            } finish[15:15];

            enum rw_op_enum {
                READ_OPERATION = 0x0 { desc = "Read operation."; };
                WRITE_OPERATION = 0x1 { desc = "Write operation."; };
            };

            field {
                name = "rw";
                desc = "PHY read or write access control.";
                encode = rw_op_enum;
                reset = 0x0;
            } rw_op[13:13];

            field {
                name = "phy_exaddr";
                desc = "Physical address of the external PHY chip. One MDIO can perform read/write operation on multiple external PHY chips. Each PHY chip has one corresponding address. When the MDIO connects to only one external PHY chip, this bit is equivalent to UD_MDIO_PHYADDR[phy0_addr] or UD_MDIO_PHYADDR[phy1_addr].";
                reset = 0x00;
            } phy_exaddr[12:8];

            enum frq_dv_enum {
                FREQUENCY_WORKING_MAIN = 0x0 { desc = "The frequency of the working main clock is divided by 50 and the obtained frequency is 1.1 MHz."; };
                FREQUENCY_WORKING_MAIN_1 = 0x1 { desc = "The frequency of the working main clock is divided by 100 and the obtained frequency is 552 KHz."; };
                FREQUENCY_WORKING_MAIN_2 = 0x2 { desc = "The frequency of the working main clock is divided by 150 and the obtained frequency is 368 KHz."; };
                FREQUENCY_WORKING_MAIN_3 = 0x3 { desc = "The frequency of the working main clock is divided by 200 and the obtained frequency is 276 KHz."; };
                FREQUENCY_WORKING_MAIN_4 = 0x4 { desc = "The frequency of the working main clock is divided by 250 and the obtained frequency is 221 KHz."; };
                FREQUENCY_WORKING_MAIN_5 = 0x5 { desc = "The frequency of the working main clock is divided by 300 and the obtained frequency is 184 KHz."; };
                FREQUENCY_WORKING_MAIN_6 = 0x6 { desc = "The frequency of the working main clock is divided by 350 and the obtained frequency is 158 KHz."; };
                FREQUENCY_WORKING_MAIN_7 = 0x7 { desc = "The frequency of the working main clock is divided by 400 and the obtained frequency is 138 KHz."; };
            };

            field {
                name = "frq_dv";
                desc = "Frequency division factor for the MDCK (the MDIO interface clock) when the MDIO performs the read/write operation on external PHY chips. Take the frequency 54 MHz of the main clock as an example to describe the matching relationship between frq_dv and MDC frequency.";
                encode = frq_dv_enum;
                reset = 0x0;
            } frq_dv[7:5];

            field {
                name = "phy_inaddr";
                desc = "Internal register address of the external PHY chip. This address is presented by a 5-bit binary number.";
                reset = 0x00;
            } phy_inaddr[4:0];

        } MDIO_RWCTRL @ 0x0000;

        reg {
            name = "Read data register";
            desc = "
                MDIO_RO_DATAMDIO is a read data register. The register does not support soft reset.

                Data sheet (Hi3520D/Hi3515A/Hi3515C data sheet issue 07 (2015-02-09)): section 5.1.6.1, Table 5-5, page 5-19, register description at text dump line 25116 (build/sdk-survey/datasheet.txt).
            ";

            field {
                name = "cpu_data_out";
                desc = "Read data register of the MDIO module: the 16-bit data read from the PHY chip by the last read operation (valid when MDIO_RWCTRL[finish] is 1).";
                sw = r;
                hw = w;
                reset = 0x0000;
            } cpu_data_out[15:0];

        } MDIO_RO_DATA @ 0x0004;
};

regfile eHISI_HIETH_SF_GLB {
    name = "ETH global control registers";
    desc = "
    Global registers of the ETH switch fabric (block base +0x1300; the register offsets below are relative to it, e.g. GLB_SOFT_RESET is at ETH+0x1308): local MAC address, soft reset, forwarding and MAC filter control, endianness, interrupt registers and the eight-entry destination MAC address filter table (GLB_MAC0_L32 .. GLB_MAC7_H16 at +0x1400). The data sheet documents only the up-port bits of the forwarding and interrupt registers; the down-port bits listed here come from the vendor driver headers (marked 'NOT IN THE DATA SHEET' in their descriptions).

    The registers do not support soft reset.
    ";

        reg {
            name = "Lower 32-bit register for the local MAC address";
            desc = "
                GLB_HOSTMAC_L32 is a lower 32-bit register for the local MAC address. The register does not support soft reset.

                Data sheet (Hi3520D/Hi3515A/Hi3515C data sheet issue 07 (2015-02-09)): section 5.1.6.3, Table 5-7, page 5-32, register description at text dump line 25874 (build/sdk-survey/datasheet.txt).
            ";

            field {
                name = "local_mac";
                desc = "Lower 32 bits of the local MAC address.";
                reset = 0x00000000;
            } local_mac[31:0];

        } GLB_HOSTMAC_L32 @ 0x0000;

        reg {
            name = "Upper 16-bit register for the local MAC address";
            desc = "
                GLB_HOSTMAC_H16 is an upper 16-bit register for the local MAC address. The register does not support soft reset.

                Data sheet (Hi3520D/Hi3515A/Hi3515C data sheet issue 07 (2015-02-09)): section 5.1.6.3, Table 5-7, page 5-32, register description at text dump line 25894 (build/sdk-survey/datasheet.txt).
            ";

            field {
                name = "local_mac";
                desc = "Upper 16 bits of the local MAC address.";
                reset = 0x0000;
            } local_mac[15:0];

        } GLB_HOSTMAC_H16 @ 0x0004;

        reg {
            name = "Internal soft reset register";
            desc = "
                GLB_SOFT_RESET is an internal soft reset register. The register does not support soft reset. The time for each soft reset must remain for more than 2 ms.

                Data sheet (Hi3520D/Hi3515A/Hi3515C data sheet issue 07 (2015-02-09)): section 5.1.6.3, Table 5-7, page 5-32, register description at text dump line 25917 (build/sdk-survey/datasheet.txt).
            ";

            enum soft_reset_enum {
                NOT_RESET = 0x0 { desc = "Not reset."; };
                RESET = 0x1 { desc = "Reset."; };
            };

            field {
                name = "soft_reset";
                desc = "Internal soft reset. In soft reset state, this bit must be set to 0to clear soft reset.";
                encode = soft_reset_enum;
                reset = 0x0;
            } soft_reset[0:0];

        } GLB_SOFT_RESET @ 0x0008;

        reg {
            name = "Forward control register";
            desc = "
                GLB_FWCTRL is a forward control register. The register does not support soft reset.

                Data sheet (Hi3520D/Hi3515A/Hi3515C data sheet issue 07 (2015-02-09)): section 5.1.6.3, Table 5-7, page 5-33, register description at text dump line 25956 (build/sdk-survey/datasheet.txt).
            ";

            field {
                name = "fwall2cpu_down";
                desc = "Forcibly forward all valid input frames of the down port to the CPU port (down-port counterpart of fwall2cpu_up). NOT IN THE DATA SHEET (vendor driver hisfv300 glb.h BITS_FWALL2CPU_DOWN).";
                reset = 0x0;
            } fwall2cpu_down[11:11];

            field {
                name = "fw2cpu_ena_down";
                desc = "Function enable of forwarding the input frames of the down port to the CPU port (down-port counterpart of fw2cpu_ena_up). NOT IN THE DATA SHEET (vendor driver hisfv300 glb.h BITS_FW2CPU_ENA_DOWN).";
                reset = 0x0;
            } fw2cpu_ena_down[9:9];

            enum fwall2cpu_up_enum {
                NO = 0x0 { desc = "no"; };
                YES = 0x1 { desc = "yes"; };
            };

            field {
                name = "fwall2cpu_up";
                desc = "Indicates whether to forcibly forward all valid input frames to the CPU port.";
                encode = fwall2cpu_up_enum;
                reset = 0x0;
            } fwall2cpu_up[7:7];

            enum fw2cpu_ena_up_enum {
                DISABLED = 0x0 { desc = "Disabled"; };
                ENABLED = 0x1 { desc = "Enabled"; };
            };

            field {
                name = "fw2cpu_ena_up";
                desc = "Function enable of forwarding the input frames to the CPU port.";
                encode = fw2cpu_ena_up_enum;
                reset = 0x1;
            } fw2cpu_ena_up[5:5];

            field {
                name = "vlan_enable";
                desc = "VLAN enable. NOT IN THE DATA SHEET (vendor driver hisfv300 glb.h BITS_VLAN_ENABLE).";
                reset = 0x0;
            } vlan_enable[0:0];

        } GLB_FWCTRL @ 0x0010;

        reg {
            name = "MAC filter table control register";
            desc = "
                GLB_MACTCTRL is a MAC filter table control register. The register does not support soft reset. z If the highest byte of the destination MAC address is even, the frame is a unicast frame. z If the highest byte of the destination MAC address is odd, the frame is a multicast frame. z If all bytes of the destination MAC address are 0xFF, the frame is a broadcast frame.

                Data sheet (Hi3520D/Hi3515A/Hi3515C data sheet issue 07 (2015-02-09)): section 5.1.6.3, Table 5-7, page 5-34, register description at text dump line 26008 (build/sdk-survey/datasheet.txt).
            ";

            field {
                name = "mact_ena_down";
                desc = "Enable bit of all MAC filters of the down port (down-port counterpart of mact_ena_up). NOT IN THE DATA SHEET (vendor driver hisfv300 glb.h BITS_MACT_ENA_DOWN).";
                reset = 0x0;
            } mact_ena_down[15:15];

            field {
                name = "broad2cpu_down";
                desc = "Forward the input broadcast frames of the down port to the CPU port (down-port counterpart of broad2cpu_up). NOT IN THE DATA SHEET (vendor driver hisfv300 glb.h BITS_BROAD2CPU_DOWN).";
                reset = 0x0;
            } broad2cpu_down[13:13];

            enum mact_ena_up_enum {
                DISABLED = 0x0 { desc = "disabled (no MAC filter is used)"; };
                ENABLED = 0x1 { desc = "enabled"; };
            };

            field {
                name = "mact_ena_up";
                desc = "Enable bit of all MAC filters of the port.";
                encode = mact_ena_up_enum;
                reset = 0x0;
            } mact_ena_up[7:7];

            enum broad2cpu_up_enum {
                NO = 0x0 { desc = "no"; };
                YES = 0x1 { desc = "yes"; };
            };

            field {
                name = "broad2cpu_up";
                desc = "Indicates whether to forward the input broadcast frames to the CPU port.";
                encode = broad2cpu_up_enum;
                reset = 0x1;
            } broad2cpu_up[5:5];

            enum multi2cpu_up_enum {
                NO = 0x0 { desc = "no"; };
                YES = 0x1 { desc = "yes"; };
            };

            field {
                name = "multi2cpu_up";
                desc = "Indicates whether to forward the input multicast frames that are not listed in the filter table to the CPU port.";
                encode = multi2cpu_up_enum;
                reset = 0x0;
            } multi2cpu_up[3:3];

            enum uni2cpu_up_enum {
                NO = 0x0 { desc = "no"; };
                YES = 0x1 { desc = "yes"; };
            };

            field {
                name = "uni2cpu_up";
                desc = "Indicates whether to forward the input unicast frames that are not listed in the filter table to the CPU port.";
                encode = uni2cpu_up_enum;
                reset = 0x0;
            } uni2cpu_up[1:1];

        } GLB_MACTCTRL @ 0x0014;

        reg {
            name = "Endian control register";
            desc = "
                GLB_ENDIAN_MOD is an endian control register. The register does not support soft reset.

                Data sheet (Hi3520D/Hi3515A/Hi3515C data sheet issue 07 (2015-02-09)): section 5.1.6.3, Table 5-7, page 5-35, register description at text dump line 26064 (build/sdk-survey/datasheet.txt).
            ";

            enum in_edian_enum {
                BIG_ENDIAN_MODE = 0x0 { desc = "big-endian mode"; };
                LITTLE_ENDIAN_MODE = 0x1 { desc = "little-endian mode"; };
            };

            field {
                name = "in_edian";
                desc = "RX packet write SDRAM endian configuration.";
                encode = in_edian_enum;
                reset = 0x1;
            } in_edian[1:1];

            enum out_edian_enum {
                BIG_ENDIAN_MODE = 0x0 { desc = "big-endian mode"; };
                LITTLE_ENDIAN_MODE = 0x1 { desc = "little-endian mode"; };
            };

            field {
                name = "out_edian";
                desc = "Data consists of bytes. TX packet read SDRAM endian configuration.";
                encode = out_edian_enum;
                reset = 0x1;
            } out_edian[0:0];

        } GLB_ENDIAN_MOD @ 0x0018;

        reg {
            name = "Interrupt status register";
            desc = "
                GLB_IRQ_STAT is an interrupt status register. The register does not support soft reset.

                Data sheet (Hi3520D/Hi3515A/Hi3515C data sheet issue 07 (2015-02-09)): section 5.1.6.3, Table 5-7, page 5-35, register description at text dump line 26096 (build/sdk-survey/datasheet.txt).
            ";

            field {
                name = "int_rxd_down";
                desc = "Interrupt status (multi-packet interrupt) of frames on the down port to be received by the CPU. NOT IN THE DATA SHEET (the DS documents only the up-port bits). Vendor driver hisfv300 ctrl.h HIETH_INT_*_D bit 27.";
                sw = r;
                hw = w;
                reset = 0x0;
            } int_rxd_down[27:27];

            field {
                name = "int_freeeq_down";
                desc = "Interrupt status of the TX queue of the down port changing from nonempty to empty. NOT IN THE DATA SHEET (the DS documents only the up-port bits). Vendor driver hisfv300 ctrl.h HIETH_INT_*_D bit 26.";
                sw = r;
                hw = w;
                reset = 0x0;
            } int_freeeq_down[26:26];

            field {
                name = "int_stat_down";
                desc = "Interrupt status of down port status changes. NOT IN THE DATA SHEET (the DS documents only the up-port bits). Vendor driver hisfv300 ctrl.h HIETH_INT_*_D bit 25.";
                sw = r;
                hw = w;
                reset = 0x0;
            } int_stat_down[25:25];

            field {
                name = "int_duplex_down";
                desc = "Interrupt status of down port duplex mode changes. NOT IN THE DATA SHEET (the DS documents only the up-port bits). Vendor driver hisfv300 ctrl.h HIETH_INT_*_D bit 24.";
                sw = r;
                hw = w;
                reset = 0x0;
            } int_duplex_down[24:24];

            field {
                name = "int_speed_down";
                desc = "Interrupt status of down port speed mode changes. NOT IN THE DATA SHEET (the DS documents only the up-port bits). Vendor driver hisfv300 ctrl.h HIETH_INT_*_D bit 23.";
                sw = r;
                hw = w;
                reset = 0x0;
            } int_speed_down[23:23];

            field {
                name = "int_link_down";
                desc = "Interrupt status of down port link status changes. NOT IN THE DATA SHEET (the DS documents only the up-port bits). Vendor driver hisfv300 ctrl.h HIETH_INT_*_D bit 22.";
                sw = r;
                hw = w;
                reset = 0x0;
            } int_link_down[22:22];

            field {
                name = "int_tx_down";
                desc = "Interrupt status of the completion of transmitting a frame from the CPU by the down port. NOT IN THE DATA SHEET (the DS documents only the up-port bits). Vendor driver hisfv300 ctrl.h HIETH_INT_*_D bit 21.";
                sw = r;
                hw = w;
                reset = 0x0;
            } int_tx_down[21:21];

            field {
                name = "int_rx_down";
                desc = "Interrupt status of frames on the down port to be received by the CPU. NOT IN THE DATA SHEET (the DS documents only the up-port bits). Vendor driver hisfv300 ctrl.h HIETH_INT_*_D bit 20.";
                sw = r;
                hw = w;
                reset = 0x0;
            } int_rx_down[20:20];

            field {
                name = "int_unknown_vlanm";
                desc = "Unknown VLAN member interrupt. NOT IN THE DATA SHEET (the DS documents only the up-port bits). Vendor driver hisfv300 ctrl.h HIETH_INT_UNKNOW_VLANM bit 14.";
                sw = r;
                hw = w;
                reset = 0x0;
            } int_unknown_vlanm[14:14];

            field {
                name = "int_unknown_vlanid";
                desc = "Unknown VLAN ID interrupt. NOT IN THE DATA SHEET (the DS documents only the up-port bits). Vendor driver hisfv300 ctrl.h HIETH_INT_UNKNOW_VLANID bit 13.";
                sw = r;
                hw = w;
                reset = 0x0;
            } int_unknown_vlanid[13:13];

            enum int_mdio_finish_enum {
                NOT_COMPLETED = 0x0 { desc = "Not completed."; };
                COMPLETED = 0x1 { desc = "Completed and an interrupt is generated."; };
            };

            field {
                name = "int_mdio_finish";
                desc = "Interrupt status indicates whether the MDIO interface completes the operation required by the CPU. After this interrupt is generated, software determines whether the MDIO completes the operation by querying MDIO_RWCTRL[finish].";
                encode = int_mdio_finish_enum;
                sw = r;
                hw = w;
                reset = 0x0;
            } int_mdio_finish[12:12];

            enum int_rxd_up_enum {
                INVALID = 0x0 { desc = "The interrupt is invalid."; };
                VALID = 0x1 { desc = "The interrupt is valid. There are frames to be received by the CPU in the RX queue."; };
            };

            field {
                name = "int_rxd_up";
                desc = "Interrupt status (multi-packet interrupt) for a frame (frames) on the port to be received by the CPU. After this interrupt is generated, software determines whether there are frames to be received by querying GLB_IRQ_RAW[iraw_rxd_up].";
                encode = int_rxd_up_enum;
                sw = r;
                hw = w;
                reset = 0x0;
            } int_rxd_up[7:7];

            enum int_freeeq_up_enum {
                NO_INTERRUPT = 0x0 { desc = "No interrupt is generated."; };
                INTERRUPT = 0x1 { desc = "An interrupt is generated."; };
            };

            field {
                name = "int_freeeq_up";
                desc = "Interrupt status indicates that the status of the port output queue is changed from nonempty to empty, that is, the status of the TX queue buffer is changed from nonempty to empty. In this case, the CPU can write a group of new frames to be transmitted. After this interrupt is generated, software determines whether the current TX queue is empty by querying UD_GLB_ADDRQ_STAT[eq_cnt]. If the current TX queue is not empty, it indicates that the interrupt is invalid.";
                encode = int_freeeq_up_enum;
                sw = r;
                hw = w;
                reset = 0x0;
            } int_freeeq_up[6:6];

            enum int_stat_up_enum {
                INVALID = 0x0 { desc = "The interrupt is invalid."; };
                VALID = 0x1 { desc = "The interrupt is valid. The port status changes."; };
            };

            field {
                name = "int_stat_up";
                desc = "Interrupt status for port status changes, indicating that an interrupt is generated when the MDIO obtains the speed change, duplex mode change, and link status change of the PHY chip in auto-adaption mode. After this interrupt is generated, software determines which status changes according to the configuration of UD_MDIO_IRQENA.";
                encode = int_stat_up_enum;
                sw = r;
                hw = w;
                reset = 0x0;
            } int_stat_up[5:5];

            enum int_duplex_up_enum {
                INVALID = 0x0 { desc = "The interrupt is invalid."; };
                VALID = 0x1 { desc = "The interrupt is valid. The duplex mode changes."; };
            };

            field {
                name = "int_duplex_up";
                desc = "Interrupt status for port duplex mode changes. After this interrupt is generated, software determines whether the duplex mode changes by querying UD_MAC_STAT_CHANGE[duplex_stat_ch].";
                encode = int_duplex_up_enum;
                sw = r;
                hw = w;
                reset = 0x0;
            } int_duplex_up[4:4];

            enum int_speed_up_enum {
                INVALID = 0x0 { desc = "The interrupt is invalid."; };
                VALID = 0x1 { desc = "The interrupt is valid. The speed mode changes."; };
            };

            field {
                name = "int_speed_up";
                desc = "Interrupt status for port speed mode changes. After this interrupt is generated, software determines whether the speed mode changes by querying UD_MAC_STAT_CHANGE[speed_stat_ch].";
                encode = int_speed_up_enum;
                sw = r;
                hw = w;
                reset = 0x0;
            } int_speed_up[3:3];

            enum int_link_up_enum {
                INVALID = 0x0 { desc = "The interrupt is invalid."; };
                VALID = 0x1 { desc = "The interrupt is valid. The link status changes."; };
            };

            field {
                name = "int_link_up";
                desc = "Interrupt status for port link status changes. After this interrupt is generated, software determines whether the link status changes by querying UD_MAC_STAT_CHANGE[link_stat_ch].";
                encode = int_link_up_enum;
                sw = r;
                hw = w;
                reset = 0x0;
            } int_link_up[2:2];

            enum int_tx_up_enum {
                NOT_COMPLETED = 0x0 { desc = "Not completed."; };
                COMPLETED = 0x1 { desc = "Completed and an interrupt is generated."; };
            };

            field {
                name = "int_tx_up";
                desc = "Interrupt status for the completion of transmitting a frame from the CPU by the port. After this interrupt is generated, software determines whether to release the buffer of the TX frames by querying the current TX queue address eq_out_index in UD_GLB_QSTAT.";
                encode = int_tx_up_enum;
                sw = r;
                hw = w;
                reset = 0x0;
            } int_tx_up[1:1];

            enum int_rx_up_enum {
                INVALID = 0x0 { desc = "The interrupt is invalid."; };
                VALID = 0x1 { desc = "The interrupt is valid. There are frames to be received by the CPU in the RX queue."; };
            };

            field {
                name = "int_rx_up";
                desc = "Interrupt status for frames on the port to be received by the CPU. After this interrupt is generated, software determines whether frames are received by querying the GLB_IRQ_RAW[iraw_rxd_up] signal.";
                encode = int_rx_up_enum;
                sw = r;
                hw = w;
                reset = 0x0;
            } int_rx_up[0:0];

        } GLB_IRQ_STAT @ 0x0030;

        reg {
            name = "Interrupt enable register";
            desc = "
                GLB_IRQ_ENA is an interrupt enable register. The register does not support soft reset.

                Data sheet (Hi3520D/Hi3515A/Hi3515C data sheet issue 07 (2015-02-09)): section 5.1.6.3, Table 5-7, page 5-37, register description at text dump line 26211 (build/sdk-survey/datasheet.txt).
            ";

            field {
                name = "ien_rxd_down";
                desc = "Interrupt enable (multi-packet interrupt) of frames on the down port to be received by the CPU. NOT IN THE DATA SHEET (the DS documents only the up-port bits). Vendor driver hisfv300 ctrl.h HIETH_INT_*_D bit 27.";
                reset = 0x0;
            } ien_rxd_down[27:27];

            field {
                name = "ien_freeeq_down";
                desc = "Interrupt enable of the TX queue of the down port changing from nonempty to empty. NOT IN THE DATA SHEET (the DS documents only the up-port bits). Vendor driver hisfv300 ctrl.h HIETH_INT_*_D bit 26.";
                reset = 0x0;
            } ien_freeeq_down[26:26];

            field {
                name = "ien_stat_down";
                desc = "Interrupt enable of down port status changes. NOT IN THE DATA SHEET (the DS documents only the up-port bits). Vendor driver hisfv300 ctrl.h HIETH_INT_*_D bit 25.";
                reset = 0x0;
            } ien_stat_down[25:25];

            field {
                name = "ien_duplex_down";
                desc = "Interrupt enable of down port duplex mode changes. NOT IN THE DATA SHEET (the DS documents only the up-port bits). Vendor driver hisfv300 ctrl.h HIETH_INT_*_D bit 24.";
                reset = 0x0;
            } ien_duplex_down[24:24];

            field {
                name = "ien_speed_down";
                desc = "Interrupt enable of down port speed mode changes. NOT IN THE DATA SHEET (the DS documents only the up-port bits). Vendor driver hisfv300 ctrl.h HIETH_INT_*_D bit 23.";
                reset = 0x0;
            } ien_speed_down[23:23];

            field {
                name = "ien_link_down";
                desc = "Interrupt enable of down port link status changes. NOT IN THE DATA SHEET (the DS documents only the up-port bits). Vendor driver hisfv300 ctrl.h HIETH_INT_*_D bit 22.";
                reset = 0x0;
            } ien_link_down[22:22];

            field {
                name = "ien_tx_down";
                desc = "Interrupt enable of the completion of transmitting a frame from the CPU by the down port. NOT IN THE DATA SHEET (the DS documents only the up-port bits). Vendor driver hisfv300 ctrl.h HIETH_INT_*_D bit 21.";
                reset = 0x0;
            } ien_tx_down[21:21];

            field {
                name = "ien_rx_down";
                desc = "Interrupt enable of frames on the down port to be received by the CPU. NOT IN THE DATA SHEET (the DS documents only the up-port bits). Vendor driver hisfv300 ctrl.h HIETH_INT_*_D bit 20.";
                reset = 0x0;
            } ien_rx_down[20:20];

            enum ien_all_enum {
                DISABLED = 0x0 { desc = "disabled (none of the interrupt can be reported)"; };
                ENABLED = 0x1 { desc = "enabled (all interrupts are reported according to the configuration)"; };
            };

            field {
                name = "ien_all";
                desc = "All interrupts enable.";
                encode = ien_all_enum;
                reset = 0x0;
            } ien_all[19:19];

            enum ien_up_enum {
                DISABLED = 0x0 { desc = "disabled (none of the uplink port interrupt can be reported)"; };
                ENABLED = 0x1 { desc = "enabled (all uplink port interrupts are reported according to the configuration)"; };
            };

            field {
                name = "ien_up";
                desc = "All uplink port interrupts enable.";
                encode = ien_up_enum;
                reset = 0x0;
            } ien_up[18:18];

            field {
                name = "ien_down";
                desc = "All down port interrupts enable (down-port counterpart of ien_up). NOT IN THE DATA SHEET (the DS documents only the up-port bits). Vendor driver hisfv300 ctrl.h BITS_IRQS_ENA_D bit 17.";
                reset = 0x0;
            } ien_down[17:17];

            field {
                name = "ien_unknown_vlanm";
                desc = "Unknown VLAN member interrupt enable. NOT IN THE DATA SHEET (the DS documents only the up-port bits). Vendor driver hisfv300 ctrl.h HIETH_INT_UNKNOW_VLANM bit 14.";
                reset = 0x0;
            } ien_unknown_vlanm[14:14];

            field {
                name = "ien_unknown_vlanid";
                desc = "Unknown VLAN ID interrupt enable. NOT IN THE DATA SHEET (the DS documents only the up-port bits). Vendor driver hisfv300 ctrl.h HIETH_INT_UNKNOW_VLANID bit 13.";
                reset = 0x0;
            } ien_unknown_vlanid[13:13];

            enum ien_mdio_finish_enum {
                DISABLED = 0x0 { desc = "Disabled"; };
                ENABLED = 0x1 { desc = "Enabled"; };
            };

            field {
                name = "ien_mdio_finish";
                desc = "Indicator enable for the MDIO to complete the operation required by the CPU.";
                encode = ien_mdio_finish_enum;
                reset = 0x0;
            } ien_mdio_finish[12:12];

            enum ien_rxd_up_enum {
                DISABLED = 0x0 { desc = "Disabled"; };
                ENABLED = 0x1 { desc = "Enabled"; };
            };

            field {
                name = "ien_rxd_up";
                desc = "Interrupt enable (multi-packet interrupt) for a frame (frames) on the uplink port to be received by the CPU.";
                encode = ien_rxd_up_enum;
                reset = 0x0;
            } ien_rxd_up[7:7];

            enum ien_freeeq_up_enum {
                DISABLED = 0x0 { desc = "Disabled"; };
                ENABLED = 0x1 { desc = "Enabled"; };
            };

            field {
                name = "ien_freeeq_up";
                desc = "Interrupt signal enable for the TX queue of the uplink port to change from nonempty to empty.";
                encode = ien_freeeq_up_enum;
                reset = 0x0;
            } ien_freeeq_up[6:6];

            enum ien_stat_up_enum {
                DISABLED = 0x0 { desc = "Disabled"; };
                ENABLED = 0x1 { desc = "Enabled"; };
            };

            field {
                name = "ien_stat_up";
                desc = "Interrupt signal enable for uplink port status changes.";
                encode = ien_stat_up_enum;
                reset = 0x0;
            } ien_stat_up[5:5];

            enum ien_duplex_up_enum {
                DISABLED = 0x0 { desc = "Disabled"; };
                ENABLED = 0x1 { desc = "Enabled"; };
            };

            field {
                name = "ien_duplex_up";
                desc = "Interrupt enable for uplink port duplex mode changes.";
                encode = ien_duplex_up_enum;
                reset = 0x0;
            } ien_duplex_up[4:4];

            enum ien_speed_up_enum {
                DISABLED = 0x0 { desc = "Disabled"; };
                ENABLED = 0x1 { desc = "Enabled"; };
            };

            field {
                name = "ien_speed_up";
                desc = "Interrupt enable for uplink port speed mode changes.";
                encode = ien_speed_up_enum;
                reset = 0x0;
            } ien_speed_up[3:3];

            enum ien_link_up_enum {
                DISABLED = 0x0 { desc = "Disabled"; };
                ENABLED = 0x1 { desc = "Enabled"; };
            };

            field {
                name = "ien_link_up";
                desc = "Interrupt enable for uplink port link status changes.";
                encode = ien_link_up_enum;
                reset = 0x0;
            } ien_link_up[2:2];

            enum ien_tx_up_enum {
                DISABLED = 0x0 { desc = "Disabled"; };
                ENABLED = 0x1 { desc = "Enabled"; };
            };

            field {
                name = "ien_tx_up";
                desc = "Indicator enable for the completion of transmitting a frame from the CPU by the uplink port.";
                encode = ien_tx_up_enum;
                reset = 0x0;
            } ien_tx_up[1:1];

            enum ien_rx_up_enum {
                DISABLED = 0x0 { desc = "Disabled"; };
                ENABLED = 0x1 { desc = "Enabled"; };
            };

            field {
                name = "ien_rx_up";
                desc = "Interrupt enable for frames on the uplink port to be received by the CPU.";
                encode = ien_rx_up_enum;
                reset = 0x0;
            } ien_rx_up[0:0];

        } GLB_IRQ_ENA @ 0x0034;

        reg {
            name = "Raw interrupt register";
            desc = "
                GLB_IRQ_RAW is a raw interrupt register. The register does not support soft reset. Writing 1 clears this register.

                Data sheet (Hi3520D/Hi3515A/Hi3515C data sheet issue 07 (2015-02-09)): section 5.1.6.3, Table 5-7, page 5-39, register description at text dump line 26312 (build/sdk-survey/datasheet.txt).
            ";

            field {
                name = "iraw_rxd_down";
                desc = "Raw interrupt status (multi-packet interrupt) of frames on the down port to be received by the CPU. Writing 1 clears. NOT IN THE DATA SHEET (the DS documents only the up-port bits). Vendor driver hisfv300 ctrl.h HIETH_INT_*_D bit 27.";
                sw = rw;
                onwrite = woclr;
                hw = w;
                reset = 0x0;
            } iraw_rxd_down[27:27];

            field {
                name = "iraw_freeeq_down";
                desc = "Raw interrupt status of the TX queue of the down port changing from nonempty to empty. Writing 1 clears. NOT IN THE DATA SHEET (the DS documents only the up-port bits). Vendor driver hisfv300 ctrl.h HIETH_INT_*_D bit 26.";
                sw = rw;
                onwrite = woclr;
                hw = w;
                reset = 0x0;
            } iraw_freeeq_down[26:26];

            field {
                name = "iraw_stat_down";
                desc = "Raw interrupt status of down port status changes. Writing 1 clears. NOT IN THE DATA SHEET (the DS documents only the up-port bits). Vendor driver hisfv300 ctrl.h HIETH_INT_*_D bit 25.";
                sw = rw;
                onwrite = woclr;
                hw = w;
                reset = 0x0;
            } iraw_stat_down[25:25];

            field {
                name = "iraw_duplex_down";
                desc = "Raw interrupt status of down port duplex mode changes. Writing 1 clears. NOT IN THE DATA SHEET (the DS documents only the up-port bits). Vendor driver hisfv300 ctrl.h HIETH_INT_*_D bit 24.";
                sw = rw;
                onwrite = woclr;
                hw = w;
                reset = 0x0;
            } iraw_duplex_down[24:24];

            field {
                name = "iraw_speed_down";
                desc = "Raw interrupt status of down port speed mode changes. Writing 1 clears. NOT IN THE DATA SHEET (the DS documents only the up-port bits). Vendor driver hisfv300 ctrl.h HIETH_INT_*_D bit 23.";
                sw = rw;
                onwrite = woclr;
                hw = w;
                reset = 0x0;
            } iraw_speed_down[23:23];

            field {
                name = "iraw_link_down";
                desc = "Raw interrupt status of down port link status changes. Writing 1 clears. NOT IN THE DATA SHEET (the DS documents only the up-port bits). Vendor driver hisfv300 ctrl.h HIETH_INT_*_D bit 22.";
                sw = rw;
                onwrite = woclr;
                hw = w;
                reset = 0x0;
            } iraw_link_down[22:22];

            field {
                name = "iraw_tx_down";
                desc = "Raw interrupt status of the completion of transmitting a frame from the CPU by the down port. Writing 1 clears. NOT IN THE DATA SHEET (the DS documents only the up-port bits). Vendor driver hisfv300 ctrl.h HIETH_INT_*_D bit 21.";
                sw = rw;
                onwrite = woclr;
                hw = w;
                reset = 0x0;
            } iraw_tx_down[21:21];

            field {
                name = "iraw_rx_down";
                desc = "Raw interrupt status of frames on the down port to be received by the CPU. Writing 1 clears. NOT IN THE DATA SHEET (the DS documents only the up-port bits). Vendor driver hisfv300 ctrl.h HIETH_INT_*_D bit 20.";
                sw = rw;
                onwrite = woclr;
                hw = w;
                reset = 0x0;
            } iraw_rx_down[20:20];

            field {
                name = "iraw_unknown_vlanm";
                desc = "Raw unknown VLAN member interrupt. Writing 1 clears. NOT IN THE DATA SHEET (the DS documents only the up-port bits). Vendor driver hisfv300 ctrl.h HIETH_INT_UNKNOW_VLANM bit 14.";
                sw = rw;
                onwrite = woclr;
                hw = w;
                reset = 0x0;
            } iraw_unknown_vlanm[14:14];

            field {
                name = "iraw_unknown_vlanid";
                desc = "Raw unknown VLAN ID interrupt. Writing 1 clears. NOT IN THE DATA SHEET (the DS documents only the up-port bits). Vendor driver hisfv300 ctrl.h HIETH_INT_UNKNOW_VLANID bit 13.";
                sw = rw;
                onwrite = woclr;
                hw = w;
                reset = 0x0;
            } iraw_unknown_vlanid[13:13];

            enum iraw_mdio_finish_enum {
                NO_INTERRUPT = 0x0 { desc = "No interrupt is generated."; };
                INTERRUPT = 0x1 { desc = "An interrupt is generated."; };
            };

            field {
                name = "iraw_mdio_finish";
                desc = "Raw interrupt status for the MDIO to complete the operation required by the CPU.";
                encode = iraw_mdio_finish_enum;
                sw = rw;
                onwrite = woclr;
                hw = w;
                reset = 0x0;
            } iraw_mdio_finish[12:12];

            enum iraw_rxd_up_enum {
                NO_INTERRUPT = 0x0 { desc = "No interrupt is generated."; };
                INTERRUPT = 0x1 { desc = "An interrupt is generated."; };
            };

            field {
                name = "iraw_rxd_up";
                desc = "Raw interrupt status (multi-packet interrupt) for a frame (frames) on the uplink port to be received by the CPU.";
                encode = iraw_rxd_up_enum;
                sw = rw;
                onwrite = woclr;
                hw = w;
                reset = 0x0;
            } iraw_rxd_up[7:7];

            enum iraw_freeeq_up_enum {
                NO_INTERRUPT = 0x0 { desc = "No interrupt is generated."; };
                INTERRUPT = 0x1 { desc = "An interrupt is generated."; };
            };

            field {
                name = "iraw_freeeq_up";
                desc = "Raw interrupt status for the TX queue of the uplink port to change from nonempty to empty, indicating that the TX queue buffer changes from nonempty to empty and the CPU can write a group of new frames to be transmitted.";
                encode = iraw_freeeq_up_enum;
                sw = rw;
                onwrite = woclr;
                hw = w;
                reset = 0x0;
            } iraw_freeeq_up[6:6];

            enum iraw_stat_up_enum {
                NO_INTERRUPT = 0x0 { desc = "No interrupt is generated."; };
                INTERRUPT = 0x1 { desc = "An interrupt is generated."; };
            };

            field {
                name = "iraw_stat_up";
                desc = "Raw interrupt status for uplink port status changes, indicating that an interrupt is generated when the MDIO obtains the speed change, duplex mode change, and link status change of the PHY chip in auto-adaption mode.";
                encode = iraw_stat_up_enum;
                sw = rw;
                onwrite = woclr;
                hw = w;
                reset = 0x0;
            } iraw_stat_up[5:5];

            enum iraw_duplex_up_enum {
                NO_INTERRUPT = 0x0 { desc = "No interrupt is generated."; };
                INTERRUPT = 0x1 { desc = "An interrupt is generated."; };
            };

            field {
                name = "iraw_duplex_up";
                desc = "Raw interrupt status for uplink port duplex mode changes.";
                encode = iraw_duplex_up_enum;
                sw = rw;
                onwrite = woclr;
                hw = w;
                reset = 0x0;
            } iraw_duplex_up[4:4];

            enum iraw_speed_up_enum {
                NO_INTERRUPT = 0x0 { desc = "No interrupt is generated."; };
                INTERRUPT = 0x1 { desc = "An interrupt is generated."; };
            };

            field {
                name = "iraw_speed_up";
                desc = "Raw interrupt status for uplink port speed mode changes.";
                encode = iraw_speed_up_enum;
                sw = rw;
                onwrite = woclr;
                hw = w;
                reset = 0x0;
            } iraw_speed_up[3:3];

            enum iraw_link_up_enum {
                NO_INTERRUPT = 0x0 { desc = "No interrupt is generated."; };
                INTERRUPT = 0x1 { desc = "An interrupt is generated."; };
            };

            field {
                name = "iraw_link_up";
                desc = "Writing 1 clears this register. Raw interrupt status for uplink port link status changes.";
                encode = iraw_link_up_enum;
                sw = rw;
                onwrite = woclr;
                hw = w;
                reset = 0x0;
            } iraw_link_up[2:2];

            enum iraw_tx_up_enum {
                NO_INTERRUPT = 0x0 { desc = "No interrupt is generated."; };
                INTERRUPT = 0x1 { desc = "An interrupt is generated."; };
            };

            field {
                name = "iraw_tx_up";
                desc = "Raw interrupt status for the completion of transmitting a frame from the CPU by the uplink port.";
                encode = iraw_tx_up_enum;
                sw = rw;
                onwrite = woclr;
                hw = w;
                reset = 0x0;
            } iraw_tx_up[1:1];

            enum iraw_rx_up_enum {
                NO_INTERRUPT = 0x0 { desc = "No interrupt is generated."; };
                INTERRUPT = 0x1 { desc = "An interrupt is generated."; };
            };

            field {
                name = "iraw_rx_up";
                desc = "Raw interrupt status for frames on the uplink port to be received by the CPU.";
                encode = iraw_rx_up_enum;
                sw = rw;
                onwrite = woclr;
                hw = w;
                reset = 0x0;
            } iraw_rx_up[0:0];

        } GLB_IRQ_RAW @ 0x0038;

        reg {
            name = "Lower 32-bit register for the filter table MAC0";
            desc = "
                GLB_MAC0_L32 is a lower 32-bit register for the filter table MAC0.

                Data sheet (Hi3520D/Hi3515A/Hi3515C data sheet issue 07 (2015-02-09)): section 5.1.6.3, Table 5-7, page 5-40, register description at text dump line 26395 (build/sdk-survey/datasheet.txt).
            ";

            field {
                name = "flt_mac0";
                desc = "Lower 32 bits of the filter table MAC0.";
                reset = 0x00000000;
            } flt_mac0[31:0];

        } GLB_MAC0_L32 @ 0x0100;

        reg {
            name = "Upper 16-bit register for the filter table MAC0";
            desc = "
                GLB_MAC0_H16 is an upper 16-bit register for the filter table MAC0.

                Data sheet (Hi3520D/Hi3515A/Hi3515C data sheet issue 07 (2015-02-09)): section 5.1.6.3, Table 5-7, page 5-41, register description at text dump line 26420 (build/sdk-survey/datasheet.txt).
            ";

            enum fw2cpu_up_enum {
                NO = 0x0 { desc = "no"; };
                YES = 0x1 { desc = "yes"; };
            };

            field {
                name = "fw2cpu_up";
                desc = "Indicates whether to forward the frames received by the uplink port that match this filter to the CPU port when the uplink port enables this filter.";
                encode = fw2cpu_up_enum;
                reset = 0x0;
            } fw2cpu_up[21:21];

            field {
                name = "fw2cpu_down";
                desc = "Forward the frames received by the down port that match this filter to the CPU port (down-port counterpart of fw2cpu_up). NOT IN THE DATA SHEET (vendor driver hisfv300 glb.h BITS_PKT2CPU_DOWN (filter 0 only is referenced by the vendor driver; the same bit is assumed for all eight filters)).";
                reset = 0x0;
            } fw2cpu_down[19:19];

            field {
                name = "mac0_up";
                desc = "Control for setting this filter to be used by the uplink port. 0: The uplink port does not use this filter.";
                reset = 0x0;
            } mac0_up[17:17];

            field {
                name = "flt_mac0";
                desc = "Upper 16 bits of the filter table MAC0.";
                reset = 0x0000;
            } flt_mac0[15:0];

        } GLB_MAC0_H16 @ 0x0104;

        reg {
            name = "Lower 32-bit register for the filter table MAC1";
            desc = "
                GLB_MAC1_L32 is a lower 32-bit register for the filter table MAC1.

                Data sheet (Hi3520D/Hi3515A/Hi3515C data sheet issue 07 (2015-02-09)): section 5.1.6.3, Table 5-7, page 5-41, register description at text dump line 26457 (build/sdk-survey/datasheet.txt).
            ";

            field {
                name = "flt_mac1";
                desc = "Lower 32 bits of the filter table MAC1.";
                reset = 0x00000000;
            } flt_mac1[31:0];

        } GLB_MAC1_L32 @ 0x0108;

        reg {
            name = "Upper 16-bit register for the filter table MAC1";
            desc = "
                GLB_MAC1_H16 is an upper 16-bit register for the filter table MAC1.

                Data sheet (Hi3520D/Hi3515A/Hi3515C data sheet issue 07 (2015-02-09)): section 5.1.6.3, Table 5-7, page 5-42, register description at text dump line 26483 (build/sdk-survey/datasheet.txt).
            ";

            enum fw2cpu_up_enum {
                NO = 0x0 { desc = "no"; };
                YES = 0x1 { desc = "yes"; };
            };

            field {
                name = "fw2cpu_up";
                desc = "Indicates whether to forward the frames received by the uplink port that match this filter to the CPU port when the uplink port enables this filter.";
                encode = fw2cpu_up_enum;
                reset = 0x0;
            } fw2cpu_up[21:21];

            field {
                name = "fw2cpu_down";
                desc = "Forward the frames received by the down port that match this filter to the CPU port (down-port counterpart of fw2cpu_up). NOT IN THE DATA SHEET (vendor driver hisfv300 glb.h BITS_PKT2CPU_DOWN (filter 0 only is referenced by the vendor driver; the same bit is assumed for all eight filters)).";
                reset = 0x0;
            } fw2cpu_down[19:19];

            field {
                name = "mac1_up";
                desc = "Control for setting this filter to be used by the uplink port. 0: The uplink port does not use this filter.";
                reset = 0x0;
            } mac1_up[17:17];

            field {
                name = "flt_mac1";
                desc = "Upper 16 bits of the filter table MAC1.";
                reset = 0x0000;
            } flt_mac1[15:0];

        } GLB_MAC1_H16 @ 0x010C;

        reg {
            name = "Lower 32-bit register for the filter table MAC2";
            desc = "
                GLB_MAC2_L32 is a lower 32-bit register for the filter table MAC2.

                Data sheet (Hi3520D/Hi3515A/Hi3515C data sheet issue 07 (2015-02-09)): section 5.1.6.3, Table 5-7, page 5-42, register description at text dump line 26520 (build/sdk-survey/datasheet.txt).
            ";

            field {
                name = "flt_mac2";
                desc = "Lower 32 bits of the filter table MAC2.";
                reset = 0x00000000;
            } flt_mac2[31:0];

        } GLB_MAC2_L32 @ 0x0110;

        reg {
            name = "Upper 16-bit register for the filter table MAC2";
            desc = "
                GLB_MAC2_H16 is an upper 16-bit register for the filter table MAC2.

                Data sheet (Hi3520D/Hi3515A/Hi3515C data sheet issue 07 (2015-02-09)): section 5.1.6.3, Table 5-7, page 5-43, register description at text dump line 26545 (build/sdk-survey/datasheet.txt).
            ";

            enum fw2cpu_up_enum {
                NO = 0x0 { desc = "no"; };
                YES = 0x1 { desc = "yes"; };
            };

            field {
                name = "fw2cpu_up";
                desc = "Indicates whether to forward the frames received by the uplink port that match this filter to the CPU port when the uplink port enables this filter.";
                encode = fw2cpu_up_enum;
                reset = 0x0;
            } fw2cpu_up[21:21];

            field {
                name = "fw2cpu_down";
                desc = "Forward the frames received by the down port that match this filter to the CPU port (down-port counterpart of fw2cpu_up). NOT IN THE DATA SHEET (vendor driver hisfv300 glb.h BITS_PKT2CPU_DOWN (filter 0 only is referenced by the vendor driver; the same bit is assumed for all eight filters)).";
                reset = 0x0;
            } fw2cpu_down[19:19];

            field {
                name = "mac2_up";
                desc = "Control for setting this filter to be used by the uplink port. 0: The uplink port does not use this filter.";
                reset = 0x0;
            } mac2_up[17:17];

            field {
                name = "flt_mac2";
                desc = "Upper 16 bits of the filter table MAC2.";
                reset = 0x0000;
            } flt_mac2[15:0];

        } GLB_MAC2_H16 @ 0x0114;

        reg {
            name = "Lower 32-bit register for the filter table MAC3";
            desc = "
                GLB_MAC3_L32 is a lower 32-bit register for the filter table MAC3.

                Data sheet (Hi3520D/Hi3515A/Hi3515C data sheet issue 07 (2015-02-09)): section 5.1.6.3, Table 5-7, page 5-43, register description at text dump line 26581 (build/sdk-survey/datasheet.txt).
            ";

            field {
                name = "flt_mac3";
                desc = "Lower 32 bits of the filter table MAC3.";
                reset = 0x00000000;
            } flt_mac3[31:0];

        } GLB_MAC3_L32 @ 0x0118;

        reg {
            name = "Upper 16-bit register for the filter table MAC3";
            desc = "
                GLB_MAC3_H16 is an upper 16-bit register for the filter table MAC3.

                Data sheet (Hi3520D/Hi3515A/Hi3515C data sheet issue 07 (2015-02-09)): section 5.1.6.3, Table 5-7, page 5-44, register description at text dump line 26606 (build/sdk-survey/datasheet.txt).
            ";

            enum fw2cpu_up_enum {
                NO = 0x0 { desc = "no"; };
                YES = 0x1 { desc = "yes"; };
            };

            field {
                name = "fw2cpu_up";
                desc = "Indicates whether to forward the frames received by the uplink port that match this filter to the CPU port when the uplink port enables this filter.";
                encode = fw2cpu_up_enum;
                reset = 0x0;
            } fw2cpu_up[21:21];

            field {
                name = "fw2cpu_down";
                desc = "Forward the frames received by the down port that match this filter to the CPU port (down-port counterpart of fw2cpu_up). NOT IN THE DATA SHEET (vendor driver hisfv300 glb.h BITS_PKT2CPU_DOWN (filter 0 only is referenced by the vendor driver; the same bit is assumed for all eight filters)).";
                reset = 0x0;
            } fw2cpu_down[19:19];

            enum mac3_up_enum {
                DO_NOT_FORWARD = 0x0 { desc = "Do not forward the frames."; };
                FORWARD_FRAMES = 0x1 { desc = "Forward the frames."; };
            };

            field {
                name = "mac3_up";
                desc = "Indicates whether to forward the frames received by the downlink port that match this filter to the CPU port when the downlink port enables this filter.";
                encode = mac3_up_enum;
                reset = 0x0;
            } mac3_up[17:17];

            field {
                name = "flt_mac3";
                desc = "Upper 16 bits of the filter table MAC3.";
                reset = 0x0000;
            } flt_mac3[15:0];

        } GLB_MAC3_H16 @ 0x011C;

        reg {
            name = "Lower 32-bit register for the filter table MAC4";
            desc = "
                GLB_MAC4_L32 is a lower 32-bit register for the filter table MAC4.

                Data sheet (Hi3520D/Hi3515A/Hi3515C data sheet issue 07 (2015-02-09)): section 5.1.6.3, Table 5-7, page 5-44, register description at text dump line 26643 (build/sdk-survey/datasheet.txt).
            ";

            field {
                name = "flt_mac4";
                desc = "Lower 32 bits of the filter table MAC4.";
                reset = 0x00000000;
            } flt_mac4[31:0];

        } GLB_MAC4_L32 @ 0x0120;

        reg {
            name = "Upper 16-bit register for the filter table MAC4";
            desc = "
                GLB_MAC4_H16 is an upper 16-bit register for the filter table MAC4.

                Data sheet (Hi3520D/Hi3515A/Hi3515C data sheet issue 07 (2015-02-09)): section 5.1.6.3, Table 5-7, page 5-45, register description at text dump line 26671 (build/sdk-survey/datasheet.txt).
            ";

            enum fw2cpu_up_enum {
                NO = 0x0 { desc = "no"; };
                YES = 0x1 { desc = "yes"; };
            };

            field {
                name = "fw2cpu_up";
                desc = "Indicates whether to forward the frames received by the uplink port that match this filter to the CPU port when the uplink port enables this filter.";
                encode = fw2cpu_up_enum;
                reset = 0x0;
            } fw2cpu_up[21:21];

            field {
                name = "fw2cpu_down";
                desc = "Forward the frames received by the down port that match this filter to the CPU port (down-port counterpart of fw2cpu_up). NOT IN THE DATA SHEET (vendor driver hisfv300 glb.h BITS_PKT2CPU_DOWN (filter 0 only is referenced by the vendor driver; the same bit is assumed for all eight filters)).";
                reset = 0x0;
            } fw2cpu_down[19:19];

            field {
                name = "mac4_up";
                desc = "Control for setting this filter to be used by the uplink port. 0: The uplink port does not use this filter.";
                reset = 0x0;
            } mac4_up[17:17];

            field {
                name = "flt_mac4";
                desc = "Upper 16 bits of the filter table MAC4.";
                reset = 0x0000;
            } flt_mac4[15:0];

        } GLB_MAC4_H16 @ 0x0124;

        reg {
            name = "Lower 32-bit register for the filter table MAC5";
            desc = "
                GLB_MAC5_L32 is a lower 32-bit register for the filter table MAC5.

                Data sheet (Hi3520D/Hi3515A/Hi3515C data sheet issue 07 (2015-02-09)): section 5.1.6.3, Table 5-7, page 5-45, register description at text dump line 26708 (build/sdk-survey/datasheet.txt).
            ";

            field {
                name = "flt_mac5";
                desc = "Lower 32 bits of the filter table MAC5.";
                reset = 0x00000000;
            } flt_mac5[31:0];

        } GLB_MAC5_L32 @ 0x0128;

        reg {
            name = "Upper 16-bit register for the filter table MAC5";
            desc = "
                GLB_MAC5_H16 is an upper 16-bit register for the filter table MAC5.

                Data sheet (Hi3520D/Hi3515A/Hi3515C data sheet issue 07 (2015-02-09)): section 5.1.6.3, Table 5-7, page 5-46, register description at text dump line 26735 (build/sdk-survey/datasheet.txt).
            ";

            enum fw2cpu_up_enum {
                NO = 0x0 { desc = "no"; };
                YES = 0x1 { desc = "yes"; };
            };

            field {
                name = "fw2cpu_up";
                desc = "Indicates whether to forward the frames received by the uplink port that match this filter to the CPU port when the uplink port enables this filter.";
                encode = fw2cpu_up_enum;
                reset = 0x0;
            } fw2cpu_up[21:21];

            field {
                name = "fw2cpu_down";
                desc = "Forward the frames received by the down port that match this filter to the CPU port (down-port counterpart of fw2cpu_up). NOT IN THE DATA SHEET (vendor driver hisfv300 glb.h BITS_PKT2CPU_DOWN (filter 0 only is referenced by the vendor driver; the same bit is assumed for all eight filters)).";
                reset = 0x0;
            } fw2cpu_down[19:19];

            field {
                name = "mac5_up";
                desc = "Control for setting this filter to be used by the uplink port. 0: The uplink port does not use this filter.";
                reset = 0x0;
            } mac5_up[17:17];

            field {
                name = "flt_mac5";
                desc = "Upper 16 bits of the filter table MAC5.";
                reset = 0x0000;
            } flt_mac5[15:0];

        } GLB_MAC5_H16 @ 0x012C;

        reg {
            name = "Lower 32-bit register for the filter table MAC6";
            desc = "
                GLB_MAC6_L32 is a lower 32-bit register for the filter table MAC6.

                Data sheet (Hi3520D/Hi3515A/Hi3515C data sheet issue 07 (2015-02-09)): section 5.1.6.3, Table 5-7, page 5-46, register description at text dump line 26770 (build/sdk-survey/datasheet.txt).
            ";

            field {
                name = "flt_mac6";
                desc = "Lower 32 bits of the filter table MAC6.";
                reset = 0x00000000;
            } flt_mac6[31:0];

        } GLB_MAC6_L32 @ 0x0130;

        reg {
            name = "Upper 16-bit register for the filter table MAC6";
            desc = "
                GLB_MAC6_H16 is an upper 16-bit register for the filter table MAC6.

                Data sheet (Hi3520D/Hi3515A/Hi3515C data sheet issue 07 (2015-02-09)): section 5.1.6.3, Table 5-7, page 5-47, register description at text dump line 26796 (build/sdk-survey/datasheet.txt).
            ";

            enum fw2cpu_up_enum {
                NO = 0x0 { desc = "no"; };
                YES = 0x1 { desc = "yes"; };
            };

            field {
                name = "fw2cpu_up";
                desc = "Indicates whether to forward the frames received by the uplink port that match this filter to the CPU port when the uplink port enables this filter.";
                encode = fw2cpu_up_enum;
                reset = 0x0;
            } fw2cpu_up[21:21];

            field {
                name = "fw2cpu_down";
                desc = "Forward the frames received by the down port that match this filter to the CPU port (down-port counterpart of fw2cpu_up). NOT IN THE DATA SHEET (vendor driver hisfv300 glb.h BITS_PKT2CPU_DOWN (filter 0 only is referenced by the vendor driver; the same bit is assumed for all eight filters)).";
                reset = 0x0;
            } fw2cpu_down[19:19];

            field {
                name = "mac6_up";
                desc = "Control for setting this filter to be used by the uplink port. 0: The uplink port does not use this filter.";
                reset = 0x0;
            } mac6_up[17:17];

            field {
                name = "flt_mac6";
                desc = "Upper 16 bits of the filter table MAC6.";
                reset = 0x0000;
            } flt_mac6[15:0];

        } GLB_MAC6_H16 @ 0x0134;

        reg {
            name = "Lower 32-bit register for the filter table MAC7";
            desc = "
                GLB_MAC7_L32 is a lower 32-bit register for the filter table MAC7.

                Data sheet (Hi3520D/Hi3515A/Hi3515C data sheet issue 07 (2015-02-09)): section 5.1.6.3, Table 5-7, page 5-47, register description at text dump line 26832 (build/sdk-survey/datasheet.txt).
            ";

            field {
                name = "flt_mac7";
                desc = "Lower 32 bits of the filter table MAC7.";
                reset = 0x00000000;
            } flt_mac7[31:0];

        } GLB_MAC7_L32 @ 0x0138;

        reg {
            name = "Upper 16-bit register for the filter table MAC7";
            desc = "
                GLB_MAC7_H16 is an upper 16-bit register for the filter table MAC7.

                Data sheet (Hi3520D/Hi3515A/Hi3515C data sheet issue 07 (2015-02-09)): section 5.1.6.3, Table 5-7, page 5-48, register description at text dump line 26858 (build/sdk-survey/datasheet.txt).
            ";

            enum fw2cpu_up_enum {
                NO = 0x0 { desc = "no"; };
                YES = 0x1 { desc = "yes"; };
            };

            field {
                name = "fw2cpu_up";
                desc = "Indicates whether to forward the frames received by the uplink port that match this filter to the CPU port when the uplink port enables this filter.";
                encode = fw2cpu_up_enum;
                reset = 0x0;
            } fw2cpu_up[21:21];

            field {
                name = "fw2cpu_down";
                desc = "Forward the frames received by the down port that match this filter to the CPU port (down-port counterpart of fw2cpu_up). NOT IN THE DATA SHEET (vendor driver hisfv300 glb.h BITS_PKT2CPU_DOWN (filter 0 only is referenced by the vendor driver; the same bit is assumed for all eight filters)).";
                reset = 0x0;
            } fw2cpu_down[19:19];

            field {
                name = "mac7_up";
                desc = "Control for setting this filter to be used by the uplink port. 0: The uplink port does not use this filter.";
                reset = 0x0;
            } mac7_up[17:17];

            field {
                name = "flt_mac7";
                desc = "Upper 16 bits of the filter table MAC7.";
                reset = 0x0000;
            } flt_mac7[15:0];

        } GLB_MAC7_H16 @ 0x013C;
};

regfile eHISI_HIETH_SF {
    name = "ETH Registers";
    desc = "
    The Ethernet (ETH) module of the Hi3520D/Hi3515A/Hi3515C (vendor name HISFV300, Linux/U-Boot driver `hieth`, a switch-fabric style Fast Ethernet MAC) receives and transmits frames at 10 or 100 Mbit/s, half or full duplex, over an MII interface to the embedded FE PHY or an external RMII PHY. It has an MDIO master with a configurable frequency, 64 frame management queues for RX and TX each, eight configurable destination MAC filter table entries, traffic limit/flow control, statistics counters and 802.3az EEE support for the embedded PHY. Frames are exchanged with memory through frame descriptors (header address and length) queued in the RX/TX queues; there is no DMA descriptor ring in memory.

    The Hi3515 (ETH at 0x10090000, VIC interrupt 14; English data sheet issue 02 (2010-04-20), register summary at `Hi3515-Datasheet.txt` line 22220; audit 2026-11-09) has the same two-port switch fabric (its summary table lists every port register at 0x0200 and 0x2200): the register set and bit layouts match this file, except that its data sheet has no EEE registers (`define HISI_HIETH_SF_NO_EEE removes MAC_EEE_INT..MAC_EEE_CLK_CNT) and adds the VLAN/MAC-limit counters VN2OTH_PKTS, VN2CPU_PKTS and MN2OTH_PKTS at 0x640-0x648 (`define HISI_HIETH_SF_VLAN_CNT adds them). Not modelled from that data sheet: MAC_SET bits 31:30 printed as a read-only field named reversed (reserved), GLB_IRQN_SET.int_frm_cnt reset printed as 0 in the bit row while its Total Reset Value header says 0x0800_003A, i.e. 8 (this file: 8, the header and the Hi3520D value), the write-1-to-clear bits marked WC (same behaviour), and the vendor-only MAC_RX_IPGCTRL/MAC_TX_IPGCTRL which it does not document.

    Second data-sheet pass 2026-11-10 (scripted field-by-field compare of every register, field, bit range, access, reset and total reset of the Hi3520D data sheet issue 02 (2013-06-21) and the Hi3515 data sheet issue 02 against this file: no register, field, access or reset mismatch). Differences that are deliberate: the down port (0x2000..0x2FFF) and every `_down` field of the GLB registers are not in either data sheet (the Hi3515 summary table only says 0x0200, 0x2200; the Hi3520D data sheet documents the up port only); they come from the vendor driver. The vendor header glb.h also defines bits that neither data sheet lists and no vendor code uses, they are not modelled: GLB_FWCTRL FW2OTHPORT_ENA/FORCE (bits 4, 6, 8, 10), GLB_MACTCTRL UNI/MULTI/BROAD2OTHPORT (bits 0, 2, 4 up; 8-12 down), GLB_MACn_H16 FW2PORT (bit 20 up, 18 down) and ENA_D (bit 16), and BITS_VLAN_IRQS (GLB_IRQ bit 11). The Hi3520D data sheet total reset of GLB_FC_LEVEL (0x3018_0508) sets bits that its field table calls reserved (modelled as reserved_nz). Both data sheets print the PHY clock/reset glue in PERI_CRG51 (Hi3520D: eth_rmiick_sel[4], mii_rmii_mode[3], fephy_srst_req[2], eth_cken[1], hrst_eth_s[0], reset 0x2; RDL matches) and, on the Hi3515, SC_PERCTRL8[18] eth_srst plus the ethclken/ethclkdis/ethclkstat bits [21] of SC_PERCLKEN/DIS/STAT. Hi3520D interrupts: ETH = GIC SPI 24 (interrupt bit 56), FE PHY = SPI 25 (bit 57).

    ## Layout

    | Offset | Block |
    |--------|-------|
    | 0x0000 | up port registers (`UP`: MDIO status/mask, MAC, queue, EEE, counters) |
    | 0x1100 | MDIO command and read-data registers (`MDIO`) |
    | 0x1300 | global registers and MAC filter table (`GLB`) |
    | 0x2000 | down port registers (`DOWN`, same layout as `UP`) |

    The internal fast Ethernet PHY registers (BMCR, BMSR, ..., 0x00-0x1F, described in the data sheet at lines 28711-29600) are not part of this register space: they are reached through the MDIO master, so they are not described here.

    !!! NOTE
        Hardware-verified with the U-Boot `hieth_sf` driver on a Hi3520D: MDIO_RWCTRL bit 15 is the command-finished flag, read data is at +0x1104, the global block is at +0x1300 and the queue registers U_GLB_QLEN_SET/IQFRM_DES/IQ_ADDR/EQ_ADDR/EQFRM_LEN/ADDRQ_STAT are at 0x344/0x354/0x358/0x360/0x364/0x36C of the up port.
    ";

    eHISI_HIETH_SF_PORT UP   @ 0x0000;
    eHISI_HIETH_SF_MDIO MDIO @ 0x1100;
    eHISI_HIETH_SF_GLB  GLB  @ 0x1300;
    eHISI_HIETH_SF_PORT DOWN @ 0x2000;
};

`endif
