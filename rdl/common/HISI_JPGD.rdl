`ifndef HISI_JPGD_RDL
`define HISI_JPGD_RDL

regfile eHISI_JPGD {
    name = "HiSilicon JPEG decoder";
    desc = "HiSilicon JPEG decoder (JPGD) at 0x20670000, GIC interrupt ID 74, clock and reset in PERI_CRG25 (0x20030064: bit 1 clock enable, bit 0 soft reset, reset value 0x3 = clock on, reset asserted). Register offsets, access order, written values and table memory formats below come from the vendor MPP of the Hi3520D (audit 2026-11-10, docs/rdl-campaign/jpgd-vendor.md): the kernel module hi3520D_jpegd.ko (character device /dev/jpeg: ioremap of 0x20670000 length 0x6BF, clock/reset handling, IRQ 74 handler, mmap of the first 4 KB to user space), its user-space library libjpeg.so (JPEG_HDEC_* functions: the code that actually programs the block), and the vendor U-Boot JPEG decoder (CONFIG_HI3520D, product/hiosd/dec/). The Hi3520D data sheet only has the overview (chapter 7.2, Table 1-1 window 0x20670000-0x2067FFFF, Table 3-16 GIC 74) and no register tables, so no offset or bit can be checked against it. Nothing here was run on hardware; reset values are unknown for every register (the vendor code never reads before writing, except SCALE).

    Data sheet facts (chapter 7.2, Source: data sheet): window 0x20670000-0x2067FFFF (64 KB), GIC interrupt 74, AXI master (DDR access priority via DDRC media0 port 2, out-of-order enable bit `jpgd_ctrl`), interrupt-driven or polled. Partial ITU-T T.81 baseline: sequential DCT, 8-bit precision, three components (Y/U/V) with YUV 4:0:0, 4:2:0, 4:2:2 1x2, 4:2:2 2x1 and 4:4:4, interleaved scans, up to 2 DC + 2 AC Huffman tables and 3 quantization tables; frequency-domain downscale 1/2, 1/4, 1/8; 1x1 to 8192x8192 pixels; segmented stream input; 40 Mpixel/s or 3 channels of D1 Motion-JPEG at 30 fps. Software parses everything above the scan header and programs the registers and tables; hardware parses the entropy-coded segments including RSTn markers. Per picture there are three interrupt causes: picture done, stream segment consumed with an error (decode stops), stream segment consumed and more data needed (software writes the next stream window and writes 1 to the register the data sheet calls JPGD_RESUME_START, which the vendor code shows is bit 0 of JPGD_RESUME at 0x4; each (re)start needs at least 64 bytes of stream).

    Vendor per-picture sequence (libjpeg.so JPEG_HDEC_SetPara 0x1c184 and the JPEG_HDEC_SendStream* functions; the user process holds /dev/jpeg exclusively from open to close): 1. INTMASK = 0. 2. QUANT table memory (64 words). 3. Huffman DC table memory (12 words). 4. Huffman AC min, base, symbol memories (8, 8, 176 words). 5. PICTYPE. 6. SCALE (read-modify-write). 7. PICSIZE. 8. STRIDE. 9. SAMPLINGFACTOR. 10. STADDR, ENDADDR (stream window). 11. YSTADDR, UVSTADDR. 12. OUTTYPE (only when 4:2:0 semi-planar output is forced), LPIXSUM1 = 0x80000000 (only when the luma pixel sum is wanted). 13. STADD, ENDADD (the part of the window that holds data, start of the entropy-coded data after the SOS header to the end of the stream or of the current segment). 14. RESUME = 0 (more segments follow) or 2 (this is the last segment). 15. START = 1. 16. Wait for the interrupt (the vendor waits at most 10 s); INT bit 0 = done, bit 2 = segment consumed, more needed (write the next STADD/ENDADD, RESUME = 1 or 3 for the last segment, no START write), bit 1 = error. The kernel handler acknowledges by writing the INT value it read back to INT. Not verified on hardware.

    Clock and reset (SYS_HAL_JpgdClkEn / SYS_HAL_JpgdResetSel in hi3520D_sys.ko touch only PERI_CRG25 bit 1 / bit 0; hi3520D_jpegd.ko itself ioremaps PERI_CRG25): module init writes 0, then sets bit 1 (clock on), then clears bit 0; every open and the reset ioctl set bit 0, poll START bit 1 until it reads 0, then clear bit 0; module exit clears bit 1. The vendor U-Boot does clock on, reset asserted, poll START bit 1, reset released. A clock-gated block must not be read.

    The register window used by the vendor is 0x6BF bytes (library refuses offsets above 0x6BE); the 0x11C/0x120/0x12C extras of the newer HiSTB revision are never touched by any Hi3520D vendor code and are not modelled. Other chips' JPGD (Hi3531/Hi3520A at 0x10170000, Hi3535/Hi3536 etc.) are other revisions; this file is instantiated by the Hi3520D/Hi3515A/Hi3515C family and by the Hi3536D V100 (JPGD at 0x13110000, GIC SPI 31, PERI_CRG40 0xA0 bit 1 clock / bit 0 reset, reset value 0x2). Hi3536D V100 check 2026-11-22 (source: static analysis of the SDK V1.0.1.0 libjpeg6b.so and hi3536dv100_jpegd.ko, nothing run; confidence HIGH for the listed offsets): the library's JPEG_HDEC_SetPara/SetStreamBuf/SendStreamFromPhyMem/SetDqt/SetDC/SetAC write the same offsets as the Hi3520D library (INTMASK 0x104, PICTYPE 0x14, SCALE 0x40 read-modify-write with bit 3 set, PICSIZE 0x10 with the same 0xFC00FC00 validity mask, STRIDE 0xC, DRI 0x128 (always written here), SAMPLINGFACTOR 0x124, STADDR/ENDADDR 0x20/0x24, STADD/ENDADD 0x28/0x2C, YSTADDR/UVSTADDR 0x30/0x34, OUTTYPE 0x44 = 4 only for the 4:2:0 semi-planar flag, LPIXSUM1 0x118, RESUME 0x4, START written by the kernel shim) and the same table memories (QUANT 0x200 x 256 B, HDC 0x300 x 48 B, HACMIN 0x340 and HACBASE 0x360 x 32 B, HACSYM 0x400 x 704 B), the same size check (width - 1 <= 8095 and height <= 8096, i.e. both sides 1..8096: 8095 is the compare constant, not the limit, in both libraries) and the same 0x6BE access limit; the shim (jpg_osr_ioctl, JpgOsrISR) reads INT 0x100 on GIC 63, writes the whole value back (including the idle bit 25) and writes INTMASK 0x104 = 0 after every reset. Its PERI_CRG40 sequence (executed under QEMU with the module harness, 2026-11-22, shows what the code programs, not what the silicon does): library open = lock: CRG40 = 0, |= 2 (clock on), |= 1 (reset asserted), poll START bit 1 until it reads 0, &= ~1 (reset released), one tick wait, INTMASK = 0; library close = unlock: |= 1, poll START bit 1, &= ~2 (clock off, reset left asserted, CRG40 = 0x1). The shim never reads a SoC ID or revision, and neither does the library: there is no revision handling for this block. The Hi3536D data sheet (Issue 00B04, chapter 7.2) has no register tables either; it adds a minimum size of 8 x 8 and AC/DC/DRI error reporting (the Hi3520D INT bits 3 and 4 may be those, not verified). The vendor load script writes no SCALE value; the board reads SCALE = 0x00000034 after the reset release (2026-11-22, NBD80XXS: outstanding 3, bit 2 set), the library keeps those bits and adds bit 3, so the vendor value on this SoC is 0x3C | scale, which is also what the vendor U-Boot writes on the Hi3520D (whose reset value is 0xB0, board 2026-11-23, earlier read as 0). Static analysis and QEMU execution of the Hi3536D library (2026-11-22, docs/research/jpgd-open-questions-2026-11-22.md): the library writes 0x104, the five table memories, 0x14, 0x40 (read-modify-write), 0x10, 0xC, 0x128, 0x124, 0x20, 0x24, 0x30, 0x34, 0x28, 0x2C, 0x4 and 0x0 per picture, 0x44 = 4 only after HI_JPEG_SetYCbCr420spFlag and 0x118 = 0x80000000 only after HI_JPEG_SetLuPixSumFlag; it reads 0x40, 0x10 and 0x18 (and 0x114/0x118 for the pixel sum) and never touches 0x108, 0x8, 0x110, 0x11C, 0x120 or 0x12C.

    Board measurement 2026-11-11 (Hi3520D nvr0408, read from our U-Boot with md.l, nothing hung; source: board, confidence HIGH for these reads only): with PERI_CRG25 = 0x00000003 (clock gate on, reset asserted, the power-on value) the whole window reads 0 without a bus error; writing PERI_CRG25 = 0x2 (reset released, clock on) wakes the window: JPGD_START reads 0x00000002, JPGD_INT reads 0x02000000, JPGD_DEBUG (0x108) reads 0x00ffffff, every other offset read back 0. So the block exists on this chip and a reset-held block reads zero like the VEDU. Nothing else about its operation (decode, interrupt acknowledge, table memory read-back) is verified on hardware yet; the V4L2 driver hisi-jpgd (docs/jpgd-driver-design.md) is written from the vendor facts above and has not been run.
    ";

    reg {
        name = "Decode start / status";
        desc = "Decode start and busy status. Write 1 to start one picture decode (written last, after RESUME; not rewritten when a stream segment is resumed, RESUME bit 0 does that). Bit 1 is polled until it reads 0 after the soft reset has been asserted (kernel module on open and reset ioctl, vendor U-Boot before releasing reset); meaning 'decoder busy / reset in progress' is inferred from that use. previously: `busy` named from U-Boot's `result & 0x2` only. Source: vendor module hi3520D_jpegd.ko together with its user-space library libjpeg.so of the same MPP (Hi3520D_MPP_V2.0.5.1; the module only maps the registers, the library programs them) (jpg_osr_ioctl cmd 0x6a00/0x6a09, JPEG_HDEC_SendStreamFromPhyMem 0x1dfc8 (START = 1)), confidence HIGH for the start write, MEDIUM for the busy meaning, word-checked: yes; Not verified on hardware. Board 2026-11-11 (source: board read from U-Boot, confidence HIGH for the value): reads 0x00000000 in reset and 0x00000002 right after the reset is released, i.e. bit 1 is SET while the block is idle, not only while it is busy; the vendor poll for bit 1 = 0 after asserting the reset is satisfied trivially because a reset-held block reads zero. The meaning of bit 1 during a decode is not measured (it may be an idle/ready flag; the name busy is inherited from the vendor poll).";

        field {
            name = "busy";
            desc = "Decoder busy (polled until 0 after asserting the soft reset; read-only status).";
            sw = r;
            hw = w;
        } busy[1:1];

        field {
            name = "start";
            desc = "Write 1 to start decoding.";
            sw = rw;
            hw = r;
        } start[0:0];

    } JPGD_START @ 0x0;

    reg {
        name = "Stream continue / last-segment register";
        desc = "Per stream segment control, written before START (first segment) or alone (continuation). Bit 1 = this segment ends the JPEG data (the vendor sets it when the remaining stream fits the window or the data ends with FFD9). Bit 0 = resume: write 1 after programming the next STADD/ENDADD window when INT bit 2 said that more data is needed. First segment: RESUME = 0 or 2, then START = 1. Continuation segments: RESUME = 1 or 3, no START write. The vendor U-Boot writes 2 (the whole stream is one segment). previously: 32-bit `value`, bit meaning unknown, 'probably JPGD_RESUME_START but U-Boot writes 0x2'; resolved: bit 0 is the data sheet's JPGD_RESUME_START, bit 1 is the end-of-stream flag. Source: vendor module hi3520D_jpegd.ko together with its user-space library libjpeg.so of the same MPP (Hi3520D_MPP_V2.0.5.1; the module only maps the registers, the library programs them) (JPEG_HDEC_SendStreamFromVirMem 0x1dd34, SendStreamFromFile 0x1e1e8, SendStreamFromCallBack 0x1e594, SendStreamFromPhyMem 0x1dfc8), confidence HIGH for the written values and their order, MEDIUM for the bit names, word-checked: yes; Not verified on hardware. Bits [31:2] are never written (0).";

        field {
            name = "resume";
            desc = "Write 1 to continue after the next stream segment has been programmed (data sheet: JPGD_RESUME_START).";
            sw = rw;
            hw = r;
        } resume[0:0];

        field {
            name = "last";
            desc = "This stream segment is the last one (end of the JPEG data).";
            sw = rw;
            hw = r;
        } last[1:1];

    } JPGD_RESUME @ 0x4;

    reg {
        name = "Pic_vld_num register";
        desc = "`JPGD_REG_PICVLDNUM` (valid-picture count, name from the vendor U-Boot header only). Never read or written by the Hi3520D kernel module, user library or U-Boot decoder: purpose and layout unknown. Source: vendor U-Boot header product/hiosd/dec/hi_drv_jpeg_reg.h (offset and name only), confidence LOW, word-checked: no; Not verified on hardware. Board 2026-11-23 (Hi3536D V100, NBD80XXS, source: board, confidence HIGH for the readings): reads non-zero after a decode and keeps the value until the next job: 0x0002AB44 after a 1080p 4:2:0 file of 95614 bytes, 0x002EC4BB after a 3.03 MB 1080p file, 0x001D50FD after a 16 MP 4:4:4 file decoded at 1/2 scale; it grows with the stream length, the unit is not known.";

        field {
            name = "value";
            desc = "Register value (layout unknown, never accessed by vendor code).";
            sw = rw;
            hw = r;
        } value[31:0];

    } JPGD_PICVLDNUM @ 0x8;

    reg {
        name = "Output stride register";
        desc = "Line stride in bytes of the semi-planar output: bits [15:0] luma (Y) stride, bits [31:16] chroma (interleaved UV) stride. Vendor: Y stride = scaled output width rounded up to a multiple of 64; UV stride = Y stride for 4:2:0 and 4:2:2 (2x1) and for any format when OUTTYPE forces 4:2:0 semi-planar output, 2 x Y stride for 4:2:2 (1x2) and 4:4:4 (two bytes per chroma sample), 0 for 4:0:0. previously: halves 'which is luma/chroma not stated' (the vendor U-Boot wrote the same value to both). Source: vendor module hi3520D_jpegd.ko together with its user-space library libjpeg.so of the same MPP (Hi3520D_MPP_V2.0.5.1; the module only maps the registers, the library programs them) (JPEG_HDEC_GetImagInfo 0x1a688 (strides), JPEG_HDEC_SetPara 0x1c184 (write 0x0c = Y | UV << 16)), confidence HIGH, word-checked: yes; Not verified on hardware.";

        field {
            name = "uv_stride";
            desc = "Chroma (UV) line stride in bytes.";
            sw = rw;
            hw = r;
        } uv_stride[31:16];

        field {
            name = "y_stride";
            desc = "Luma (Y) line stride in bytes (multiple of 64 in the vendor code).";
            sw = rw;
            hw = r;
        } y_stride[15:0];

    } JPGD_STRIDE @ 0xC;

    reg {
        name = "Picture size register";
        desc = "Picture size of the coded image in MCU-sized units (not the scaled output size): width = ceil(image_width / 8) when the Y horizontal sampling factor is 1, else ceil(image_width / 16); height likewise with the Y vertical sampling factor. Each half must be below 0x400 (the vendor library refuses the picture if (value & 0xFC00FC00) != 0, i.e. each half is at most 1023 units; its support check separately limits both image dimensions to 1..8096 pixels: width - 1 <= 8095 and height <= 8096 in both libraries; the mask alone would allow 1023 units, i.e. 8184 pixels for 8-pixel units and 16368 for 16-pixel units, so the vendor limit is a library choice below the field limit, and the Hi3536D data sheet says 8192 x 8192). The vendor reads the register back after the decode finished (low and high half). previously: 'size in 16x16 MCUs' (the vendor U-Boot doubles the width/height for factor 1 to get the same 8-pixel unit). Source: vendor module hi3520D_jpegd.ko together with its user-space library libjpeg.so of the same MPP (Hi3520D_MPP_V2.0.5.1; the module only maps the registers, the library programs them) (JPEG_HDEC_SetPara 0x1c184 (write 0x10, mask check), JPEG_HDEC_GetImagInfo 0x1a688 (units), SendStream* (read back)), confidence HIGH, word-checked: yes; Not verified on hardware. Board 2026-11-23 (Hi3536D V100, NBD80XXS, source: board, confidence HIGH for the readings): the picture size field accepts everything from 1 x 1 up: 3 x 5, 7 x 7, 8 x 1, 16 x 3, 1 x 1 decode with luma within one count of libjpeg in 4:2:0, 4:2:2, 4:4:4 and gray (the data sheet minimum of 8 x 8 is not a hardware limit), and 8096 x 2000, 4608 x 3456, 4096 x 4096 and 8096 x 64 decode at 1/1 scale.";

        field {
            name = "height_mcu";
            desc = "Picture height in MCU units (8 or 16 lines), rounded up.";
            sw = rw;
            hw = r;
        } height_mcu[31:16];

        field {
            name = "width_mcu";
            desc = "Picture width in MCU units (8 or 16 pixels), rounded up.";
            sw = rw;
            hw = r;
        } width_mcu[15:0];

    } JPGD_PICSIZE @ 0x10;

    reg {
        name = "Picture type register";
        desc = "Sampling format code of the coded image: 0 = YUV 4:0:0 (one component), 3 = YUV 4:2:0, 4 = YUV 4:2:2 with 2:1 horizontal subsampling (2x1), 5 = YUV 4:2:2 with 2:1 vertical subsampling (1x2), 6 = YUV 4:4:4. Codes 1, 2 and 7 are never written (7 = invalid, rejected by the vendor library before the write). The library derives the code from the SOF sampling factors: Y 2x2 with U/V 1x1 = 420, Y 2x1 (width factor twice the chroma one, equal height) = 422 (2x1), equal widths with Y height twice the chroma height = 422 (1x2), all equal = 444, one component = 400. previously: 'value_type computed by the closed-source library, encoding unknown'. Source: vendor module hi3520D_jpegd.ko together with its user-space library libjpeg.so of the same MPP (Hi3520D_MPP_V2.0.5.1; the module only maps the registers, the library programs them) (JPEG_HDEC_SetPara 0x1c184 (jump table to 0/3/4/5/6), SOF handler in libjpeg.so 0x68d8-0x6a84 (type 0..4)), confidence HIGH, word-checked: yes; Not verified on hardware.";

        field {
            name = "pic_type";
            desc = "Sampling format code (0, 3, 4, 5, 6 written by the vendor).";
            sw = rw;
            hw = r;
        } pic_type[2:0];

    } JPGD_PICTYPE @ 0x14;

    reg {
        name = "Decode time register";
        desc = "Picture decode time cost (name and read-only status from the vendor U-Boot header comment). Read by the vendor library API HI_JPEG_GetRegTime; the unit is not known. Source: vendor module hi3520D_jpegd.ko together with its user-space library libjpeg.so of the same MPP (Hi3520D_MPP_V2.0.5.1; the module only maps the registers, the library programs them) (HI_JPEG_GetRegTime 0x1e8a0 (read)), confidence MEDIUM for the access, LOW for the meaning, word-checked: yes; Not verified on hardware. Board 2026-11-23 (Hi3536D V100, NBD80XXS, source: board, confidence HIGH for the readings): read after decodes with the device held active: 0x0017EAD2 (1080p 4:2:0 file, the job took 5.5 ms), 0x003EE274 (1080p, 13.4 ms), 0x00B64951 (16 MP 4:4:4 file at 1/2 scale, 74 ms); it grows with the job time (roughly 160 to 320 thousand ticks per millisecond, not a constant ratio), so it is a tick counter of the decode and the unit is not a fixed clock.";

        field {
            name = "time";
            desc = "Decode time cost (unit unknown; read-only per the vendor header comment).";
            sw = r;
            hw = w;
        } time[31:0];

    } JPGD_TIME @ 0x18;

    reg {
        name = "Stream window start address";
        desc = "Physical start of the stream buffer window the decoder may read; STADD/ENDADD must lie inside STADDR..ENDADDR. Vendor values: mmz stream buffer (64-byte aligned allocation, 512 KB = 0x80000 window, used for the segmented path) or, for a stream already in contiguous memory, ((address - 1) & ~63) - 100 with ENDADDR = address + length + 100 (a 100-byte margin on both sides); the vendor U-Boot uses the 128-byte aligned stream start and aligned end. The data sheet says each (re)start needs at least 64 bytes of stream. Source: vendor module hi3520D_jpegd.ko together with its user-space library libjpeg.so of the same MPP (Hi3520D_MPP_V2.0.5.1; the module only maps the registers, the library programs them) (JPEG_HDEC_SetStreamBuf 0x1c100 (writes 0x20 and 0x24)), confidence HIGH, word-checked: yes; Not verified on hardware.";

        field {
            name = "addr";
            desc = "Physical address.";
            sw = rw;
            hw = r;
        } addr[31:0];

    } JPGD_STADDR @ 0x20;

    reg {
        name = "Stream window end address";
        desc = "Physical end of the stream window, see STADDR. Source: vendor module hi3520D_jpegd.ko together with its user-space library libjpeg.so of the same MPP (Hi3520D_MPP_V2.0.5.1; the module only maps the registers, the library programs them) (JPEG_HDEC_SetStreamBuf 0x1c100), confidence HIGH, word-checked: yes; Not verified on hardware.";

        field {
            name = "addr";
            desc = "Physical address.";
            sw = rw;
            hw = r;
        } addr[31:0];

    } JPGD_ENDADDR @ 0x24;

    reg {
        name = "Stream data start address";
        desc = "Physical address of the first byte of entropy-coded data of the current segment (just after the SOS header; inside the STADDR..ENDADDR window). Rewritten for every segment. Source: vendor module hi3520D_jpegd.ko together with its user-space library libjpeg.so of the same MPP (Hi3520D_MPP_V2.0.5.1; the module only maps the registers, the library programs them) (JPEG_HDEC_SendStreamFromVirMem 0x1dd34 / PhyMem 0x1dfc8 / File 0x1e1e8), confidence HIGH, word-checked: yes; Not verified on hardware.";

        field {
            name = "addr";
            desc = "Physical address.";
            sw = rw;
            hw = r;
        } addr[31:0];

    } JPGD_STADD @ 0x28;

    reg {
        name = "Stream data end address";
        desc = "Physical address just after the last byte of the current segment (end of the JPEG data for the last segment). Rewritten for every segment. Source: vendor module hi3520D_jpegd.ko together with its user-space library libjpeg.so of the same MPP (Hi3520D_MPP_V2.0.5.1; the module only maps the registers, the library programs them) (JPEG_HDEC_SendStreamFromVirMem 0x1dd34 / PhyMem 0x1dfc8 / File 0x1e1e8), confidence HIGH, word-checked: yes; Not verified on hardware.";

        field {
            name = "addr";
            desc = "Physical address.";
            sw = rw;
            hw = r;
        } addr[31:0];

    } JPGD_ENDADD @ 0x2C;

    reg {
        name = "Luminance output address";
        desc = "Physical address of the luma plane (output memory is 128-byte aligned in the vendor library). The plane size is Y stride x output height rounded up to 16 lines (8 lines when the Y vertical sampling factor is 1). Source: vendor module hi3520D_jpegd.ko together with its user-space library libjpeg.so of the same MPP (Hi3520D_MPP_V2.0.5.1; the module only maps the registers, the library programs them) (JPEG_HDEC_SetPara 0x1c184 (write 0x30), JPEG_HDEC_GetYUVMem 0x1bbac (align 128)), confidence HIGH, word-checked: yes; Not verified on hardware.";

        field {
            name = "addr";
            desc = "Physical address.";
            sw = rw;
            hw = r;
        } addr[31:0];

    } JPGD_YSTADDR @ 0x30;

    reg {
        name = "Chrominance output address";
        desc = "Physical address of the interleaved CbCr plane; the vendor places it directly behind the luma plane: YSTADDR + Y stride x aligned height (written even for 4:0:0). previously: 'Y + LineBytes x height aligned to 16' (U-Boot). Source: vendor module hi3520D_jpegd.ko together with its user-space library libjpeg.so of the same MPP (Hi3520D_MPP_V2.0.5.1; the module only maps the registers, the library programs them) (JPEG_HDEC_SetPara 0x1c184 (write 0x34), JPEG_HDEC_GetImagInfo 0x1a688 (plane sizes)), confidence HIGH, word-checked: yes; Not verified on hardware.";

        field {
            name = "addr";
            desc = "Physical address.";
            sw = rw;
            hw = r;
        } addr[31:0];

    } JPGD_UVSTADDR @ 0x34;

    reg {
        name = "Scale / output control register";
        desc = "Bits [1:0] frequency-domain downscale: 0 = 1/1, 1 = 1/2, 2 = 1/4, 3 = 1/8 (the vendor library writes (old & ~3) | scale | 0x8, so the other bits keep the value the system script wrote). Bits [6:4] AXI outstanding setting: the vendor sysctl script (Xiongmai sysctl_hi3520D.sh, OpenIPC load_hisilicon) writes the whole register = 0x70 ('jpgd outstanding') before any decode, the vendor U-Boot writes 0x3C (outstanding 3). Bit 3 is set to 1 by the library for every picture (U-Boot 0x3C also has it); the same name `jidct_emar_en` in an older HiSTB library (other revision) is the YUV-output enable (0 = no YUV to DDR for ARGB output), meaning inferred. Bit 2 is set by U-Boot (0x3C) and reads 1 after the reset of the Hi3536D (0x34), no vendor code ever sets or clears it. Output size limit seen in the library (both the Hi3520D and the Hi3536D libraries, JPEG_HDEC_GetImagInfo): the scale is raised until both scaled dimensions are at most 4095, but only when the requested output colour space is not one of the five semi-planar YUV types; for semi-planar YUV output the library programs the picture as it is, up to the 8096 pixels its support check accepts (QEMU execution of the Hi3536D library 2026-11-22: a 4608 x 3456 file with JCS_YUV420_SP gives SCALE 0x3C, STRIDE 0x12001200; with JCS_RGB it gives SCALE 0x3D and a 2304 x 1728 output). So the 4095 is a property of the library's RGB path, not shown to be a limit of the decoder core. Reset values: Hi3520D 0x000000B0 (board 2026-11-23, Linux driver on the NVR0408: read after every reset release and after repeated manual reset pulses with the clock on, outstanding 3 plus bit 7 set and bit 2 clear; this replaces the 0 read on 2026-11-11, source: board, confidence HIGH), Hi3536D 0x00000034 (board 2026-11-22); the Hi3516A V300 vendor driver writes the 4-bit field [7:4] = 3 after every reset (jpegd_reset), the vendor U-Boot writes 0x3C, so outstanding 3 is the vendor default everywhere; the 7 of the Hi3520D load script is a tuning only that script applies. previously: 'U-Boot writes 0x3C; layout unknown'. Source: vendor module hi3520D_jpegd.ko together with its user-space library libjpeg.so of the same MPP (Hi3520D_MPP_V2.0.5.1; the module only maps the registers, the library programs them) (JPEG_HDEC_SetPara 0x1c184 (read + write 0x40), JPEG_HDEC_GetImagInfo 0x1a688 (scale code), sysctl_hi3520D.sh), confidence HIGH for scale[1:0] and the script value, MEDIUM for outstanding, LOW for bit 3 meaning, word-checked: yes; Not verified on hardware. Neighbor-revision names (older HiSTB jpeg6b library, inferred): Outstanding field, jidct_emar_en. Board 2026-11-23 (Hi3536D V100, NBD80XXS, source: board, confidence HIGH for the readings): bit 2 is REQUIRED: with SCALE written as 0x30 or 0x00 (bit 2 clear) a decode never finishes (no interrupt, the 3 s driver watchdog resets the block; the reset value 0x34 and every tried value with bit 2 set decode correctly: 0x04, 0x14, 0x34, 0x74, 0x0C, 0x3C, 0x5C, 0x6C, 0x7C; the picture bytes are identical for all of them). The outstanding field [6:4] gives no gain above 1: for a 1080p 4:2:0 file 5.5 ms at 1, 3 and 7, 6.8 ms at 0 (0x04 and 0x0C); for a 3 MB high-bit-rate 1080p file 13.4 ms for every value that works. The scale field and bit 3 work as described; the 1/1 decode up to 8096 pixels (4608 x 3456, 8096 x 2000, 4096 x 4096) is correct on this SoC, the 4095 limit is the vendor RGB path only.";

        field {
            name = "outstanding";
            desc = "AXI outstanding configuration (vendor script writes 7, U-Boot writes 3). Meaning inferred from the script comment 'jpgd outstanding'.";
            sw = rw;
            hw = r;
        } outstanding[6:4];

        field {
            name = "jidct_emar_en";
            desc = "Written 1 by the vendor library on every picture (YUV output enable per an older revision of the library, LOW).";
            sw = rw;
            hw = r;
        } jidct_emar_en[3:3];

        field {
            name = "bit2_unk";
            desc = "Unknown purpose, vendor-observed only, confidence LOW, not verified on hardware. Written 1 only by the vendor U-Boot (value 0x3C), never by the Linux library.";
            sw = rw;
            hw = r;
        } bit2_unk[2:2];

        field {
            name = "scale";
            desc = "Downscale: 0 = 1/1, 1 = 1/2, 2 = 1/4, 3 = 1/8.";
            sw = rw;
            hw = r;
        } scale[1:0];

    } JPGD_SCALE @ 0x40;

    reg {
        name = "Output type register";
        desc = "Written 4 only when the application asked for 4:2:0 semi-planar output (HI_JPEG_SetYCbCr420spFlag; then the library also halves the UV stride/plane for 4:2:2 (1x2) and 4:4:4 and refuses 1/8 scale); the vendor U-Boot always writes 4. Bit 2 therefore forces the output to YUV 4:2:0 semi-planar; with the register at 0 the decoder writes the native sampling format. The older HiSTB library (other revision) writes 0x4 under CONFIG_JPEG_OUTPUT_YUV420SP as well and uses bits 0, 3, 4 for ARGB order and median filters, none of which the Hi3520D vendor code uses. previously: 'U-Boot writes 0x4; layout unknown'. Source: vendor module hi3520D_jpegd.ko together with its user-space library libjpeg.so of the same MPP (Hi3520D_MPP_V2.0.5.1; the module only maps the registers, the library programs them) (JPEG_HDEC_SetPara 0x1c184 (write 0x44 = 4), HI_JPEG_SetYCbCr420spFlag 0x1a3b8), confidence MEDIUM, word-checked: yes; Not verified on hardware. Meaning of bit 2 is inferred from the library's size computations; all other bits are never written. Board 2026-11-23 (Hi3536D V100, NBD80XXS, source: board, confidence HIGH for the readings): bit 2 works on this SoC: a 4:4:4 or 4:2:2 file written with OUTTYPE = 4 (UV stride = Y stride, half the chroma rows) gives a correct NV21 picture: luma identical, chroma (Cr first) equal to every second sample of the libjpeg chroma (no averaging), PSNR 66 to 72 dB for 4:4:4 and 45 to 52 dB for 4:2:2 against that reference; the Hi3520D gave 12 to 20 dB (wrong).";

        field {
            name = "out_420sp";
            desc = "Force 4:2:0 semi-planar output (the only value the vendor code writes).";
            sw = rw;
            hw = r;
        } out_420sp[2:2];

    } JPGD_OUTTYPE @ 0x44;

    reg {
        name = "Interrupt status register";
        desc = "Interrupt status. The kernel IRQ handler (IRQ 74, shared) reads the register, writes the same value back (acknowledge, write-one-to-clear assumed, not proven) and wakes the waiter: bit 0 = picture decoded (done), bit 1 = stream segment consumed with an error (the library aborts the decode), bit 2 = stream segment consumed and more data needed (the library programs the next window and resumes). Priority in the handler: bit 0, then bit 1, then bit 2. The vendor U-Boot polls `INT & 0x1f` with INTMASK = 0x17 (bits 0, 1, 2, 4 masked), so the register shows the status even when the interrupt is masked; it never acknowledges. Bits 3 and 4 are never interpreted. previously: bit 0 done, bits [4:1] 'any other bit is an error'. Source: vendor module hi3520D_jpegd.ko together with its user-space library libjpeg.so of the same MPP (Hi3520D_MPP_V2.0.5.1; the module only maps the registers, the library programs them) (JpgOsrISR 0x958, JpgHalGetIntStatus 0x64, JpgHalSetIntStatus 0x88), confidence HIGH for bits 0-2 and the write-back, MEDIUM for the bit names, word-checked: yes; Not verified on hardware. Board 2026-11-11 (source: board read from U-Boot, confidence HIGH for the value): reads 0x02000000 after the reset is released (0 in reset), so bit 25 is set at idle; it is no documented cause and no vendor code looks at it (the vendor ISR tests bits 0..2 only). A driver must mask INT before interpreting it (the Linux driver uses the causes 0..4). The vendor interrupt handlers write the WHOLE value back (the Hi3536D and Hi3520D shims write exactly what they read, which includes bit 25 whenever it is set; the Hi3516A V300 driver writes 0xFFFFFFFF), so writing unknown bits back is what the vendor does; the shim sets the waiter state from bit 0 (done), else bit 1 (error), else bit 2 (more), and a cause in bits 3 or 4 alone sets no state (the library then waits out its 10 s time-out). No vendor code reads an error position or any status register on failure, the only register read after a decode is PICSIZE. Whether bit 25 clears after a decode is not measured. Board 2026-11-23 (Hi3536D V100, NBD80XXS, source: board, confidence HIGH for the readings): bit 1 is set by every stream error tried: eight corrupted files (truncated, bit flips, bad scan data, restart marker damage) and every wrong DRI value ended within milliseconds with INT = 0x2 and nothing else; bit 2 (more data needed) never appeared, not even for truncated files; bit 3 never appeared; bit 4 is the time-out cause (see JPGD_DEBUG: TIMEOUT = 0x10 gives INT = 0x10 and no other bit). Every cause bit is acknowledged by writing it back. Bit 25 reads 0x02000000 at idle, as on the Hi3520D.";

        field {
            name = "bit4_unk";
            desc = "Unknown purpose, vendor-observed only, confidence LOW, not verified on hardware. Seen only in the U-Boot poll mask 0x1f and INTMASK 0x17. Board 2026-11-23 (Hi3536D V100, NBD80XXS, source: board, confidence HIGH for the readings): bit 4 = time-out cause (TIMEOUT 0x10 gave INT 0x10, the job ended in milliseconds).";
            sw = r;
            hw = w;
        } bit4_unk[4:4];

        field {
            name = "bit3_unk";
            desc = "Unknown purpose, vendor-observed only, confidence LOW, not verified on hardware. Seen only in the U-Boot poll mask 0x1f.";
            sw = r;
            hw = w;
        } bit3_unk[3:3];

        field {
            name = "more";
            desc = "Stream segment consumed, more data needed (resume procedure).";
            sw = rw;
            hw = w;
        } more[2:2];

        field {
            name = "err";
            desc = "Stream segment consumed with an error, decode stopped.";
            sw = rw;
            hw = w;
        } err[1:1];

        field {
            name = "done";
            desc = "Picture decode finished.";
            sw = rw;
            hw = w;
        } done[0:0];

    } JPGD_INT @ 0x100;

    reg {
        name = "Interrupt mask register";
        desc = "Interrupt mask ('halt shield'): the kernel module writes 0 at init and the library writes 0 again before every picture, and the decode is then driven purely by the IRQ, so a 0 bit enables the interrupt for that cause and a 1 bit masks it (bits 0-2 inferred from this use; the vendor U-Boot polls INT with 0x17 written here). The status in INT is not affected by the mask. Source: vendor module hi3520D_jpegd.ko together with its user-space library libjpeg.so of the same MPP (Hi3520D_MPP_V2.0.5.1; the module only maps the registers, the library programs them) (JpgHalSetIntMask 0xa8, JpgHalGetIntMask 0xc8, JPEG_HDEC_SetPara 0x1c184 (write 0x104)), confidence MEDIUM, word-checked: yes; Not verified on hardware.";

        field {
            name = "bit4_unk";
            desc = "Unknown purpose, vendor-observed only, confidence LOW, not verified on hardware. Seen only in U-Boot's 0x17.";
            sw = rw;
            hw = r;
        } bit4_unk[4:4];

        field {
            name = "bit3_unk";
            desc = "Unknown purpose, vendor-observed only, confidence LOW, not verified on hardware. Never written as 1 by the vendor code.";
            sw = rw;
            hw = r;
        } bit3_unk[3:3];

        field {
            name = "mask_more";
            desc = "1 = mask the 'more data needed' interrupt.";
            sw = rw;
            hw = r;
        } mask_more[2:2];

        field {
            name = "mask_err";
            desc = "1 = mask the error interrupt.";
            sw = rw;
            hw = r;
        } mask_err[1:1];

        field {
            name = "mask_done";
            desc = "1 = mask the picture-done interrupt.";
            sw = rw;
            hw = r;
        } mask_done[0:0];

    } JPGD_INTMASK @ 0x104;

    reg {
        name = "Debug register";
        desc = "`JPGD_REG_DEBUG` (name from the vendor U-Boot header only). Never accessed by the Hi3520D kernel module, user library or U-Boot decoder: purpose unknown. Source: vendor U-Boot header product/hiosd/dec/hi_drv_jpeg_reg.h (offset and name only), confidence LOW, word-checked: no; Not verified on hardware. Board 2026-11-11 (source: board read from U-Boot, confidence HIGH for the value): reads 0x00ffffff after the reset is released (0 in reset): a 24 bit all-ones reset value, consistent with the time-out limit register the Hi3516A V300 vendor driver programs at the same offset (JPGD_TIMEOUT in HISI_JPGD_AV300). The Hi3520D vendor code never touches it; unit and effect of writing it are not measured (board experiment in docs/research/jpgd-open-questions-2026-11-22.md). Hi3536D V100 board read (2026-11-22, NBD80XXS, source: board, confidence HIGH for the read): the same register reads 0xFFFFFFFF after the reset is released (the Hi3520D reads 0x00ffffff), so it is a 32 bit all-ones register on this SoC or a different reset value. Vendor use (static analysis and QEMU execution of the Hi3536D module and library, 2026-11-22, confidence HIGH): neither the Hi3536D kernel shim nor the library nor the Hi3520D equivalents write or read this register at any point (the Hi3536D library's complete register list is in the block description), so every vendor decode on both SoCs runs with the reset value; the only vendor writer anywhere is the Hi3516A V300 generation driver (jpegd_set_time_out: soft reset, then the caller's limit), which is why the register is probably a time-out limit whose unit is unknown. A decode of 118 ms (1080p at 1/2 scale) succeeded on the Hi3520D with the 24 bit reset value, so it is not a total-decode-time limit in cycles at the reset value; what it counts is not known. The other idle values are equal to the Hi3520D (START 0x00000002, INT 0x02000000, INTMASK 0) and SCALE (0x040) reads 0x00000034; every other offset in 0x000-0x12C reads 0. Board 2026-11-23 (Hi3536D V100, NBD80XXS, source: board, confidence HIGH for the readings): this is a time-out limit: with the register set to N before a decode, 1080p files decode correctly for N >= 0x100 (tried 0x00ffffff, 0x01000000, 0x00400000, 0x00100000, 0x10000, 0x1000, 0x100) and every job fails for N = 0x80, 0x40, 0x20, 0x18, 0x14 and 0x10 with INT bit 4 and no other cause within milliseconds. The counter therefore measures a short wait inside the job (a few hundred ticks, probably a bus or stream wait), not the total decode time (a 13 ms job needs millions of ticks). The reset value 0xFFFFFFFF never fires. The register is not rewritten by a decode and a reset restores the all-ones value.";

        field {
            name = "value";
            desc = "Debug status (only the vendor register name is known).";
            sw = r;
            hw = w;
        } value[31:0];

    } JPGD_DEBUG @ 0x108;

    reg {
        name = "Luminance pixel sum register 0";
        desc = "Low 32 bits of the sum of all decoded luma pixel values, read after the decode when the application asked for it (HI_JPEG_SetLuPixSumFlag). Source: vendor module hi3520D_jpegd.ko together with its user-space library libjpeg.so of the same MPP (Hi3520D_MPP_V2.0.5.1; the module only maps the registers, the library programs them) (JPEG_HDEC_Start 0x1b100 (read 0x114)), confidence HIGH for the access, MEDIUM for the meaning, word-checked: yes; Not verified on hardware.";

        field {
            name = "value";
            desc = "Luma pixel sum, bits 31:0.";
            sw = r;
            hw = w;
        } value[31:0];

    } JPGD_LPIXSUM0 @ 0x114;

    reg {
        name = "Luminance pixel sum register 1";
        desc = "Write 0x80000000 before the decode to enable the luma pixel sum (the vendor U-Boot always does, the library only when the flag is set); after the decode bits [3:0] hold bits 35:32 of the 36-bit sum (the library reads this register and keeps only the low nibble). Bit 31 = enable is inferred from the written value. Source: vendor module hi3520D_jpegd.ko together with its user-space library libjpeg.so of the same MPP (Hi3520D_MPP_V2.0.5.1; the module only maps the registers, the library programs them) (JPEG_HDEC_SetPara 0x1c184 (write 0x118), JPEG_HDEC_Start 0x1b100 (read, mask 0xf)), confidence HIGH for the accesses, MEDIUM for the field meaning, word-checked: yes; Not verified on hardware.";

        field {
            name = "enable";
            desc = "Written 1 to enable the luma pixel sum (inferred).";
            sw = rw;
            hw = r;
        } enable[31:31];

        field {
            name = "sum_hi";
            desc = "Luma pixel sum bits 35:32 (read after the decode).";
            sw = r;
            hw = w;
        } sum_hi[3:0];

    } JPGD_LPIXSUM1 @ 0x118;

    reg {
        name = "Sampling factor register";
        desc = "Component sampling factors from the SOF header, one byte per component with the horizontal factor in the high nibble: Y at [23:16], U at [15:8], V at [7:0]. 4:2:0 is 0x221111, 4:4:4 0x111111, 4:0:0 0x110000 (U and V bytes 0). previously: U-Boot wrote `V_V << 4 | V_V` into [7:0] and the RDL carried a 'probable vendor typo' note; the Linux library writes the real V horizontal factor into [7:4], so the U-Boot value is a bug (resolved). Source: vendor module hi3520D_jpegd.ko together with its user-space library libjpeg.so of the same MPP (Hi3520D_MPP_V2.0.5.1; the module only maps the registers, the library programs them) (JPEG_HDEC_SetPara 0x1c184 (write 0x124), SOF handler in libjpeg.so 0x69c4-0x6a04), confidence HIGH, word-checked: yes; Not verified on hardware.";

        field {
            name = "y_h";
            desc = "Y horizontal sampling factor.";
            sw = rw;
            hw = r;
        } y_h[23:20];

        field {
            name = "y_v";
            desc = "Y vertical sampling factor.";
            sw = rw;
            hw = r;
        } y_v[19:16];

        field {
            name = "u_h";
            desc = "U horizontal sampling factor (0 for 4:0:0).";
            sw = rw;
            hw = r;
        } u_h[15:12];

        field {
            name = "u_v";
            desc = "U vertical sampling factor (0 for 4:0:0).";
            sw = rw;
            hw = r;
        } u_v[11:8];

        field {
            name = "v_h";
            desc = "V horizontal sampling factor (0 for 4:0:0).";
            sw = rw;
            hw = r;
        } v_h[7:4];

        field {
            name = "v_v";
            desc = "V vertical sampling factor (0 for 4:0:0).";
            sw = rw;
            hw = r;
        } v_v[3:0];

    } JPGD_SAMPLINGFACTOR @ 0x124;

    reg {
        name = "Restart interval register";
        desc = "`JPGD_REG_DRI`: JPEG restart interval (DRI marker value). Written by the vendor U-Boot decoder and, since the Hi3536D SDK, by the user library for every picture (JPEG_HDEC_SetPara writes the libjpeg restart_interval, 0 for a file without DRI; QEMU execution 2026-11-22: DRI 1, 4, 3, 5, 6, 40 for the restart test files, 0 otherwise). The Hi3520D library never writes it although Hi3520D streams with restart markers are decoded by the vendor stack (restart markers are recognized by the hardware itself from the RSTn markers; the Hi3536D data sheet adds DRI decoding error reporting, which suggests the register is the expected interval for that check). No other restart-related register is written by any vendor code. Whether the Hi3520D implements this register is not confirmed. Source: vendor U-Boot JPEG decoder (CONFIG_HI3520D, Jpeg_HDEDC_Uboot), confidence LOW, word-checked: no (not used by libjpeg.so); Not verified on hardware. Board 2026-11-23 (Hi3536D V100, NBD80XXS, source: board, confidence HIGH for the readings): the register is REQUIRED for streams with restart markers: the restart test files decode only when DRI holds the interval of the stream; DRI = 0 (marker value 0 and no marker), 1, half and double of the stream interval each ended with INT = 0x2 within milliseconds (10 files, 5 variants of two pictures), the original files decoded correctly. So the block checks the restart markers against this register (the data sheet DRI error reporting), and writing the file value for every picture, as the Hi3536D vendor library does, is necessary.";

        field {
            name = "restart";
            desc = "Restart interval in MCUs.";
            sw = rw;
            hw = r;
        } restart[31:0];

    } JPGD_DRI @ 0x128;

    reg {
        name = "Quantization table memory";
        desc = "64 words, one per coefficient in natural (raster, not zigzag) order: word i = Q_Y[i] | Q_U[i] << 8 | Q_V[i] << 16, 8-bit values only (the vendor does not handle 16-bit DQT precision). The table of each component is the one its SOF Tq selects; a missing U table falls back to Y and a missing V table to U. 256 bytes are written with plain word stores, first thing after INTMASK. Source: vendor module hi3520D_jpegd.ko together with its user-space library libjpeg.so of the same MPP (Hi3520D_MPP_V2.0.5.1; the module only maps the registers, the library programs them) (JPEG_HDEC_SetDqt 0x1db64 (CpyData2Reg offset 0x200, 256 bytes)), confidence HIGH for the packing, MEDIUM for the natural order (libjpeg 6b stores quantval in natural order, the vendor header says so), word-checked: yes; Not verified on hardware.";

        field {
            name = "q";
            desc = "Quantization values for Y [7:0], U [15:8], V [23:16] of one coefficient.";
            sw = rw;
            hw = r;
        } q[31:0];

    } JPGD_QUANT[64] @ 0x200 += 0x4;

    reg {
        name = "Huffman DC table memory";
        desc = "12 words, indexed by the DC symbol (category 0..11): bits [7:0] luma code (low 8 bits of the canonical Huffman code), [11:8] luma code length, [19:12] chroma code (low 8 bits), [23:20] chroma code length, [31:24] 0. Luma = the table the Y component uses, chroma = the table of U/V (a single table is duplicated). Canonical codes are assigned in increasing order by length per T.81 Annex C. 48 bytes written. Source: vendor module hi3520D_jpegd.ko together with its user-space library libjpeg.so of the same MPP (Hi3520D_MPP_V2.0.5.1; the module only maps the registers, the library programs them) (JPEG_HDEC_SetDC 0x1d060 (CpyData2Reg offset 0x300, 48 bytes; shifts 8/12/20, masks 0xff/0xf), vendor U-Boot JPEG_HDEC_Uboot_SetDC (source, same packing)), confidence HIGH, word-checked: yes; Not verified on hardware. Why 8 code bits suffice for longer DC codes is unknown.";

        field {
            name = "data";
            desc = "Packed {chroma length, chroma code, luma length, luma code} of one DC symbol.";
            sw = rw;
            hw = r;
        } data[31:0];

    } JPGD_HDCTABLE[12] @ 0x300 += 0x4;

    reg {
        name = "Huffman AC min-code table memory";
        desc = "8 words for 16 code lengths (index l = code length l + 1): word i = LU_min[2i] | LU_min[2i+1] << 8 | CH_min[2i] << 16 | CH_min[2i+1] << 24, each byte the low 8 bits of the first canonical code of that length, min[l] = (min[l-1] + count[l]) << 1 where count[l] is the DHT count of length l (0 for l = 0); lengths above the longest used code are 0xFF. LU = table of the Y component, CH = table of U/V. 32 bytes written. Source: vendor module hi3520D_jpegd.ko together with its user-space library libjpeg.so of the same MPP (Hi3520D_MPP_V2.0.5.1; the module only maps the registers, the library programs them) (JPEG_HDEC_SetAC 0x1c3ec (CpyData2Reg offset 0x340, 32 bytes), vendor U-Boot JPEG_HDEC_Uboot_SetAC (source)), confidence HIGH for the packing, MEDIUM for the 0xFF fill (from the U-Boot source), word-checked: yes; Not verified on hardware.";

        field {
            name = "data";
            desc = "Four packed min-code bytes (two luma, two chroma lengths).";
            sw = rw;
            hw = r;
        } data[31:0];

    } JPGD_HACMINTABLE[8] @ 0x340 += 0x4;

    reg {
        name = "Huffman AC base table memory";
        desc = "8 words, same packing as HACMINTABLE: byte for code length l = (number of codes shorter than l - min[l]) & 0xFF, written only when the DHT count of that length is non-zero, else 0; symbol index = code + base. 32 bytes written. Source: vendor module hi3520D_jpegd.ko together with its user-space library libjpeg.so of the same MPP (Hi3520D_MPP_V2.0.5.1; the module only maps the registers, the library programs them) (JPEG_HDEC_SetAC 0x1c3ec (CpyData2Reg offset 0x360, 32 bytes), vendor U-Boot JPEG_HDEC_Uboot_SetAC (source)), confidence HIGH for the packing, MEDIUM for the arithmetic (U-Boot source, binary has the same conditional store), word-checked: yes; Not verified on hardware.";

        field {
            name = "data";
            desc = "Four packed base bytes (two luma, two chroma lengths).";
            sw = rw;
            hw = r;
        } data[31:0];

    } JPGD_HACBASETABLE[8] @ 0x360 += 0x4;

    reg {
        name = "Huffman AC symbol table memory";
        desc = "176 words (0x2C0 bytes written; a baseline AC table has at most 162 symbols): word k = luma huffval[k] | chroma huffval[k] << 8, in DHT order (increasing code length), upper half 0. Source: vendor module hi3520D_jpegd.ko together with its user-space library libjpeg.so of the same MPP (Hi3520D_MPP_V2.0.5.1; the module only maps the registers, the library programs them) (JPEG_HDEC_SetAC 0x1c3ec (CpyData2Reg offset 0x400, 704 bytes), vendor U-Boot JPEG_HDEC_Uboot_SetAC (source)), confidence HIGH for size and offset, MEDIUM for the byte order (U-Boot source and the lsl #8 in the binary), word-checked: yes; Not verified on hardware.";

        field {
            name = "data";
            desc = "Luma AC symbol [7:0] and chroma AC symbol [15:8] of one table entry.";
            sw = rw;
            hw = r;
        } data[31:0];

    } JPGD_HACSYMTABLE[176] @ 0x400 += 0x4;

};

`endif
