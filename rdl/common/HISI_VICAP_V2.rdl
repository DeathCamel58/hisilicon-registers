`ifndef HISI_VICAP_V2_RDL
`define HISI_VICAP_V2_RDL

// VICAP (single port / single channel generation with built-in ISP) of the Hi3518EV200 / Hi3516CV200 (data sheet 9.1).
regfile eHISI_VICAP_V2 {
    name = "VICAP (video capture, single channel)";
    desc = "
    Video capture (VICAP) of the Hi3518E V20X / Hi3516C V200 at 0x20580000 (data sheet 9.1), VIC interrupt 22 (shared with the built-in ISP): one external sensor/video input port (PT: BT.656,
    BT.601, BT.1120, DC parallel up to 16 bit / 14-bit RAW, or the MIPI RX output), one capture channel (CH) with crop, the ISP, chrominance resampling and a write channel to DDR
    (SPYCbCr 4:2:2 / 4:2:0, offline) or online output to the VPSS; flash and shutter trigger outputs; maximum 1920 x 1080 input.

    Register groups (data sheet 9.1.5): 0x000-0x0F8 global (WK_MODE, AXI_CFG, MAC_CFG, DES_SEL, ISP_SEL, CHN_MODE, BUF_MODE, APB_TIMEOUT, VICAP_INT / VICAP_INT_MASK), 0x100-0x1F8
    input port PT (interface mode, data offsets, BT.656, timing, flash/shutter, status, interrupts), 0x200-0x2F8 DES (descriptor / crop / frame address / stride of the data path),
    0x500-0x5F8 LINE_BUF, 0x700-0x7F8 SRC, 0x1004-0x10F8 capture channel CH (adapter, Y/C write channels, interrupts). The ISP registers (data sheet chapter 10, offsets 0x20080-0x32324
    of the same window) are the separate `eHISI_ISP` block instantiated at 0x205A0000.

    This is the VICAP generation of the Hi3516CV300 / Hi3519 (PT / DES / CH register names); it is NOT the multi-channel VICAP of the Hi3520D (`eHISI_VICAP`). Register table: data sheet
    9.1.5 / 9.1.6 (`hi3518ev200--Hi3518EV20X-Hi3516CV200-Datasheet.txt` lines 50449-53659), 87 registers transcribed with fields, access types and reset values; vendor driver binary only; no hardware verification.
    ";

    reg {
        name = "Global operating mode configuration register";
        desc = "WK_MODE is a global operating mode configuration register.

Data sheet 9.1.6 WK_MODE (offset 0x0, printed page 9-18, `hi3518ev200--Hi3518EV20X-Hi3516CV200-Datasheet.txt` line 50655).";

        field {
            name = "ros_mem_ema";
            desc = "Speed adjustment configuration for the Q end of the read-only memory";
            sw = rw;
            hw = r;
            reset = 0x2;
        } ros_mem_ema[16:14];

        field {
            name = "rft_mem_emab";
            desc = "Speed adjustment configuration for the D end of the dual-port memory";
            sw = rw;
            hw = r;
            reset = 0x2;
        } rft_mem_emab[13:11];

        field {
            name = "rft_mem_emaa";
            desc = "Speed adjustment configuration for the Q end of the dual-port memory";
            sw = rw;
            hw = r;
            reset = 0x2;
        } rft_mem_emaa[10:8];

        field {
            name = "rfs_mem_emaw";
            desc = "Speed adjustment configuration for the D end of the single-port memory";
            sw = rw;
            hw = r;
            reset = 0x0;
        } rfs_mem_emaw[7:6];

        field {
            name = "rfs_mem_ema";
            desc = "Speed adjustment configuration for the Q end of the single-port memory";
            sw = rw;
            hw = r;
            reset = 0x2;
        } rfs_mem_ema[5:3];

        enum WK_MODE_power_mode_enum {
            LOW_POWER_MODE = 0 { name = "Low Power Mode"; desc = "The low-power mode is disabled."; };
            LOW_POWER_MODE_2 = 1 { name = "Low Power Mode 2"; desc = "The low-power mode is enabled."; };
        };

        field {
            name = "power_mode";
            desc = "Clock mode";
            sw = rw;
            hw = r;
            encode = WK_MODE_power_mode_enum;
            reset = 0x0;
        } power_mode[0:0];
    } WK_MODE @ 0x0;

    reg {
        name = "Bus configuration register";
        desc = "AXI_CFG is a bus configuration register.

Data sheet 9.1.6 AXI_CFG (offset 0x10, printed page 9-19, `hi3518ev200--Hi3518EV20X-Hi3516CV200-Datasheet.txt` line 50711).";

        field {
            name = "reserved_b31_16";
            desc = "Reserved in the data sheet; modelled so that the total reset value 0x10100000 of the data sheet header is reproduced (reads 0x1010).";
            sw = r;
            hw = w;
            reset = 0x1010;
        } reserved_b31_16[31:16];

        field {
            name = "r_outstanding";
            desc = "Number of read request outstandings Value range: [1, 8]";
            sw = rw;
            hw = r;
            reset = 0x0;
        } r_outstanding[15:12];

        field {
            name = "w_outstanding";
            desc = "Number of write request outstandings Value range: [1, 8]";
            sw = rw;
            hw = r;
            reset = 0x0;
        } w_outstanding[7:4];
    } AXI_CFG @ 0x10;

    reg {
        name = "MAC configuration register";
        desc = "MAC_CFG is an MAC configuration register.

Data sheet 9.1.6 MAC_CFG (offset 0x14, printed page 9-19, `hi3518ev200--Hi3518EV20X-Hi3516CV200-Datasheet.txt` line 50737).";

        enum MAC_CFG_r_req_prio_enum {
            LOW_PRIORITY = 0x0 { name = "Low Priority"; desc = "low priority"; };
            HIGH_PRIORITY_BIT = 0x1 { name = "High Priority Bit"; desc = "high priority bit[8]: reserved bit[9]: SRC1 read request priority bit[10]: reserved bit[11]: reserved bit[12]: reserved bit[13]: reserved bit[14]: reserved bit[15]: reserved"; };
        };

        field {
            name = "r_req_prio";
            desc = "Read request arbitration priority";
            sw = rw;
            hw = r;
            encode = MAC_CFG_r_req_prio_enum;
            reset = 0x0;
        } r_req_prio[15:8];

        enum MAC_CFG_w_req_prio_enum {
            LOW_PRIORITY = 0x0 { name = "Low Priority"; desc = "low priority"; };
            HIGH_PRIORITY_BIT = 0x1 { name = "High Priority Bit"; desc = "high priority bit[0]: DES0 write request priority bit[1]: reserved bit[2]: reserved bit[3]: reserved bit[4]: reserved bit[5]: reserved bit[6]: reserved bit[7]: reserved"; };
        };

        field {
            name = "w_req_prio";
            desc = "Write request arbitration priority";
            sw = rw;
            hw = r;
            encode = MAC_CFG_w_req_prio_enum;
            reset = 0x0;
        } w_req_prio[7:0];
    } MAC_CFG @ 0x14;

    reg {
        name = "DES input data selection register";
        desc = "DES_SEL is a DES input data selection register.

Data sheet 9.1.6 DES_SEL (offset 0x40, printed page 9-20, `hi3518ev200--Hi3518EV20X-Hi3516CV200-Datasheet.txt` line 50788).";

        enum DES_SEL_des_sel_enum {
            DES_CONNECTS_PORT = 0 { name = "Des Connects Port"; desc = "The DES connects to the port."; };
            DES_CONNECTS_LINE = 1 { name = "Des Connects Line"; desc = "The DES connects to LINE_BUF."; };
            DES_CONNECTS_FPN = 2 { name = "Des Connects Fpn"; desc = "The DES connects to the FPN."; };
            RESERVED = 3 { name = "Reserved"; desc = "reserved"; };
            DES_CONNECTS_IR = 4 { name = "Des Connects Ir"; desc = "The DES connects to the IR output. Other values: reserved"; };
        };

        field {
            name = "des_sel";
            desc = "DES input data select";
            sw = rw;
            hw = r;
            encode = DES_SEL_des_sel_enum;
            reset = 0x0;
        } des_sel[2:0];
    } DES_SEL @ 0x40;

    reg {
        name = "ISP input data selection register";
        desc = "ISP_SEL is an ISP input data selection register.

Data sheet 9.1.6 ISP_SEL (offset 0x50, printed page 9-21, `hi3518ev200--Hi3518EV20X-Hi3516CV200-Datasheet.txt` line 50825).";

        enum ISP_SEL_isp_sel_enum {
            ISP_CONNECTS_LINE = 0 { name = "Isp Connects Line"; desc = "The ISP connects to LINE_BUF."; };
            ISP_CONNECTS_SRC0 = 1 { name = "Isp Connects Src0"; desc = "The ISP connects to SRC0."; };
            ISP_CONNECTS_SRC1 = 2 { name = "Isp Connects Src1"; desc = "The ISP connects to SRC1."; };
            RESERVED = 3 { name = "Reserved"; desc = "reserved"; };
        };

        field {
            name = "isp_sel";
            desc = "ISP input data select";
            sw = rw;
            hw = r;
            encode = ISP_SEL_isp_sel_enum;
            reset = 0x0;
        } isp_sel[1:0];
    } ISP_SEL @ 0x50;

    reg {
        name = "SRC0/DES0 bus read/write rate control mode register";
        desc = "CHN_MODE is an SRC0/DES0 bus read/write rate control mode register.

Data sheet 9.1.6 CHN_MODE (offset 0x60, printed page 9-21, `hi3518ev200--Hi3518EV20X-Hi3516CV200-Datasheet.txt` line 50850).";

        enum CHN_MODE_chn_mode_enum {
            NO_RATE_CONTROL = 0 { name = "No Rate Control"; desc = "no rate control"; };
            RATE_SRC0_CONTROLLED = 1 { name = "Rate Src0 Controlled"; desc = "The rate of SRC0 is controlled to ensure that it is lower than the DES0 write rate (read after write)"; };
            RATE_DES0_CONTROLLED = 2 { name = "Rate Des0 Controlled"; desc = "The rate of DES0 is controlled to ensure that it is lower than the SRC0 read rate (write after read)"; };
            RESERVED = 3 { name = "Reserved"; desc = "reserved"; };
        };

        field {
            name = "chn_mode";
            desc = "SRC0/DES0 bus read/write rate control mode (used when SRC0 shares the buffer with DES0)";
            sw = rw;
            hw = r;
            encode = CHN_MODE_chn_mode_enum;
            reset = 0x0;
        } chn_mode[1:0];
    } CHN_MODE @ 0x60;

    reg {
        name = "LINE_BUF input data select register";
        desc = "BUF_MODE is a LINE_BUF input data select register.

Data sheet 9.1.6 BUF_MODE (offset 0x70, printed page 9-22, `hi3518ev200--Hi3518EV20X-Hi3516CV200-Datasheet.txt` line 50889).";

        enum BUF_MODE_buf_mode_enum {
            RAW_DATA = 0 { name = "Raw Data"; desc = "raw data"; };
            YUV422 = 1 { name = "Yuv422"; desc = "YUV422"; };
        };

        field {
            name = "buf_mode";
            desc = "Input data mode of LINE_BUF";
            sw = rw;
            hw = r;
            encode = BUF_MODE_buf_mode_enum;
            reset = 0x0;
        } buf_mode[0:0];
    } BUF_MODE @ 0x70;

    reg {
        name = "APB timeout register";
        desc = "APB_TIMEOUT is an APB timeout register.

Data sheet 9.1.6 APB_TIMEOUT (offset 0xE0, printed page 9-22, `hi3518ev200--Hi3518EV20X-Hi3516CV200-Datasheet.txt` line 50917).";

        enum APB_TIMEOUT_enable_f_enum {
            DISABLED = 0 { name = "Disabled"; desc = "disabled"; };
            ENABLED = 1 { name = "Enabled"; desc = "enabled"; };
        };

        field {
            name = "enable";
            desc = "Timeout enable";
            sw = rw;
            hw = r;
            encode = APB_TIMEOUT_enable_f_enum;
            reset = 0x1;
        } enable_f[31:31];

        field {
            name = "timeout";
            desc = "Timeout threshold (in APB clock)";
            sw = rw;
            hw = r;
            reset = 0x180;
        } timeout[15:0];
    } APB_TIMEOUT @ 0xE0;

    reg {
        name = "Interrupt status register";
        desc = "VICAP_INT is an interrupt status register.

Data sheet 9.1.6 VICAP_INT (offset 0xF0, printed page 9-23, `hi3518ev200--Hi3518EV20X-Hi3516CV200-Datasheet.txt` line 50949).";

        enum VICAP_INT_int_isp_enum {
            NO_INTERRUPT_GENERATED = 0 { name = "No Interrupt Generated"; desc = "No interrupt is generated."; };
            INTERRUPT_GENERATED = 1 { name = "Interrupt Generated"; desc = "An interrupt is generated."; };
        };

        field {
            name = "int_isp";
            desc = "ISP interrupt status";
            sw = r;
            hw = w;
            encode = VICAP_INT_int_isp_enum;
            reset = 0x0;
        } int_isp[16:16];

        enum VICAP_INT_int_buf_enum {
            NO_INTERRUPT_GENERATED = 0 { name = "No Interrupt Generated"; desc = "No interrupt is generated."; };
            INTERRUPT_GENERATED = 1 { name = "Interrupt Generated"; desc = "An interrupt is generated."; };
        };

        field {
            name = "int_buf";
            desc = "LINE_BUF interrupt status";
            sw = r;
            hw = w;
            encode = VICAP_INT_int_buf_enum;
            reset = 0x0;
        } int_buf[5:5];

        enum VICAP_INT_int_src1_enum {
            NO_INTERRUPT_GENERATED = 0 { name = "No Interrupt Generated"; desc = "No interrupt is generated."; };
            INTERRUPT_GENERATED = 1 { name = "Interrupt Generated"; desc = "An interrupt is generated."; };
        };

        field {
            name = "int_src1";
            desc = "SRC1 interrupt status";
            sw = r;
            hw = w;
            encode = VICAP_INT_int_src1_enum;
            reset = 0x0;
        } int_src1[4:4];

        enum VICAP_INT_int_des0_enum {
            NO_INTERRUPT_GENERATED = 0 { name = "No Interrupt Generated"; desc = "No interrupt is generated."; };
            INTERRUPT_GENERATED = 1 { name = "Interrupt Generated"; desc = "An interrupt is generated."; };
        };

        field {
            name = "int_des0";
            desc = "DES0 interrupt status";
            sw = r;
            hw = w;
            encode = VICAP_INT_int_des0_enum;
            reset = 0x0;
        } int_des0[2:2];

        enum VICAP_INT_int_ch_enum {
            NO_INTERRUPT_GENERATED = 0 { name = "No Interrupt Generated"; desc = "No interrupt is generated."; };
            INTERRUPT_GENERATED = 1 { name = "Interrupt Generated"; desc = "An interrupt is generated."; };
        };

        field {
            name = "int_ch";
            desc = "Channel interrupt status";
            sw = r;
            hw = w;
            encode = VICAP_INT_int_ch_enum;
            reset = 0x0;
        } int_ch[1:1];

        enum VICAP_INT_int_pt_enum {
            NO_INTERRUPT_GENERATED = 0 { name = "No Interrupt Generated"; desc = "No interrupt is generated."; };
            INTERRUPT_GENERATED = 1 { name = "Interrupt Generated"; desc = "An interrupt is generated."; };
        };

        field {
            name = "int_pt";
            desc = "Port interrupt status";
            sw = r;
            hw = w;
            encode = VICAP_INT_int_pt_enum;
            reset = 0x0;
        } int_pt[0:0];
    } VICAP_INT @ 0xF0;

    reg {
        name = "Interrupt mask register SK";
        desc = "VICAP_INT_MASK is an interrupt mask register.

Data sheet 9.1.6 VICAP_INT_MASK (offset 0xF8, printed page 9-24, `hi3518ev200--Hi3518EV20X-Hi3516CV200-Datasheet.txt` line 51000).";

        enum VICAP_INT_MASK_int_isp_enum {
            MASKED = 0 { name = "Masked"; desc = "masked"; };
            ENABLED = 1 { name = "Enabled"; desc = "enabled"; };
        };

        field {
            name = "int_isp";
            desc = "ISP interrupt enable";
            sw = rw;
            hw = r;
            encode = VICAP_INT_MASK_int_isp_enum;
            reset = 0x0;
        } int_isp[16:16];

        enum VICAP_INT_MASK_int_buf_enum {
            MASKED = 0 { name = "Masked"; desc = "masked"; };
            ENABLED = 1 { name = "Enabled"; desc = "enabled"; };
        };

        field {
            name = "int_buf";
            desc = "LINE_BUF interrupt enable";
            sw = rw;
            hw = r;
            encode = VICAP_INT_MASK_int_buf_enum;
            reset = 0x0;
        } int_buf[5:5];

        enum VICAP_INT_MASK_int_src1_enum {
            MASKED = 0 { name = "Masked"; desc = "masked"; };
            ENABLED = 1 { name = "Enabled"; desc = "enabled"; };
        };

        field {
            name = "int_src1";
            desc = "SRC1 interrupt enable";
            sw = rw;
            hw = r;
            encode = VICAP_INT_MASK_int_src1_enum;
            reset = 0x0;
        } int_src1[4:4];

        enum VICAP_INT_MASK_int_des0_enum {
            MASKED = 0 { name = "Masked"; desc = "masked"; };
            ENABLED = 1 { name = "Enabled"; desc = "enabled"; };
        };

        field {
            name = "int_des0";
            desc = "DES0 interrupt enable";
            sw = rw;
            hw = r;
            encode = VICAP_INT_MASK_int_des0_enum;
            reset = 0x0;
        } int_des0[2:2];

        enum VICAP_INT_MASK_int_ch_enum {
            MASKED = 0 { name = "Masked"; desc = "masked"; };
            ENABLED = 1 { name = "Enabled"; desc = "enabled"; };
        };

        field {
            name = "int_ch";
            desc = "Channel interrupt enable";
            sw = rw;
            hw = r;
            encode = VICAP_INT_MASK_int_ch_enum;
            reset = 0x0;
        } int_ch[1:1];

        enum VICAP_INT_MASK_int_pt_enum {
            MASKED = 0 { name = "Masked"; desc = "masked"; };
            ENABLED = 1 { name = "Enabled"; desc = "enabled"; };
        };

        field {
            name = "int_pt";
            desc = "Port interrupt enable";
            sw = rw;
            hw = r;
            encode = VICAP_INT_MASK_int_pt_enum;
            reset = 0x0;
        } int_pt[0:0];
    } VICAP_INT_MASK @ 0xF8;

    reg {
        name = "Port mode register";
        desc = "PT_INTF_MOD is a port mode register.

Data sheet 9.1.6 PT_INTF_MOD (offset 0x100, printed page 9-25, `hi3518ev200--Hi3518EV20X-Hi3516CV200-Datasheet.txt` line 51051).";

        enum PT_INTF_MOD_enable_f_enum {
            DISABLED = 0 { name = "Disabled"; desc = "disabled"; };
            ENABLED = 1 { name = "Enabled"; desc = "enabled"; };
        };

        field {
            name = "enable";
            desc = "Port enable";
            sw = rw;
            hw = r;
            encode = PT_INTF_MOD_enable_f_enum;
            reset = 0x0;
        } enable_f[31:31];

        enum PT_INTF_MOD_mode_enum {
            EXTERNAL_SYNC = 0 { name = "External Sync"; desc = "external sync"; };
            BT_656 = 1 { name = "Bt 656"; desc = "BT.656"; };
        };

        field {
            name = "mode";
            desc = "Timing mode";
            sw = rw;
            hw = r;
            encode = PT_INTF_MOD_mode_enum;
            reset = 0x0;
        } mode[0:0];
    } PT_INTF_MOD @ 0x100;

    reg {
        name = "Component 0 offset register";
        desc = "PT_OFFSET0 is a component 0 offset register.

Data sheet 9.1.6 PT_OFFSET0 (offset 0x110, printed page 9-25, `hi3518ev200--Hi3518EV20X-Hi3516CV200-Datasheet.txt` line 51077).";

        field {
            name = "mask";
            desc = "Component 0 mask";
            sw = rw;
            hw = r;
            reset = 0xFFF0;
        } mask_f[31:16];

        enum PT_OFFSET0_rev_enum {
            NO = 0 { name = "No"; desc = "no"; };
            YES = 1 { name = "Yes"; desc = "yes"; };
        };

        field {
            name = "rev";
            desc = "Whether the data line is reversed";
            sw = rw;
            hw = r;
            encode = PT_OFFSET0_rev_enum;
            reset = 0x0;
        } rev[15:15];

        field {
            name = "offset";
            desc = "Component 0 offset";
            sw = rw;
            hw = r;
            reset = 0x0;
        } offset[5:0];
    } PT_OFFSET0 @ 0x110;

    reg {
        name = "Component 1 offset register";
        desc = "PT_OFFSET1 is a component 1 offset register.

Data sheet 9.1.6 PT_OFFSET1 (offset 0x114, printed page 9-26, `hi3518ev200--Hi3518EV20X-Hi3516CV200-Datasheet.txt` line 51112).";

        field {
            name = "mask";
            desc = "Component 1 mask";
            sw = rw;
            hw = r;
            reset = 0xFFF0;
        } mask_f[31:16];

        enum PT_OFFSET1_rev_enum {
            NO = 0 { name = "No"; desc = "no"; };
            YES = 1 { name = "Yes"; desc = "yes"; };
        };

        field {
            name = "rev";
            desc = "Whether the data line is reversed";
            sw = rw;
            hw = r;
            encode = PT_OFFSET1_rev_enum;
            reset = 0x0;
        } rev[15:15];

        field {
            name = "offset";
            desc = "Component 1 offset";
            sw = rw;
            hw = r;
            reset = 0x10;
        } offset[5:0];
    } PT_OFFSET1 @ 0x114;

    reg {
        name = "Component 2 offset register";
        desc = "PT_OFFSET2 is a component 2 offset register.

Data sheet 9.1.6 PT_OFFSET2 (offset 0x118, printed page 9-26, `hi3518ev200--Hi3518EV20X-Hi3516CV200-Datasheet.txt` line 51135).";

        field {
            name = "mask";
            desc = "Component 2 mask";
            sw = rw;
            hw = r;
            reset = 0xFFF0;
        } mask_f[31:16];

        enum PT_OFFSET2_rev_enum {
            NO = 0 { name = "No"; desc = "no"; };
            YES = 1 { name = "Yes"; desc = "yes"; };
        };

        field {
            name = "rev";
            desc = "Whether the data line is reversed";
            sw = rw;
            hw = r;
            encode = PT_OFFSET2_rev_enum;
            reset = 0x0;
        } rev[15:15];

        field {
            name = "offset";
            desc = "Component 2 offset";
            sw = rw;
            hw = r;
            reset = 0x20;
        } offset[5:0];
    } PT_OFFSET2 @ 0x118;

    reg {
        name = "BT.656 configuration register";
        desc = "PT_BT656_CFG is a BT.656 configuration register.

Data sheet 9.1.6 PT_BT656_CFG (offset 0x120, printed page 9-27, `hi3518ev200--Hi3518EV20X-Hi3516CV200-Datasheet.txt` line 51169).";

        enum PT_BT656_CFG_enable_f_enum {
            DISABLED = 0 { name = "Disabled"; desc = "disabled"; };
            ENABLED = 1 { name = "Enabled"; desc = "enabled"; };
        };

        field {
            name = "enable";
            desc = "BT.656 enable";
            sw = rw;
            hw = r;
            encode = PT_BT656_CFG_enable_f_enum;
            reset = 0x0;
        } enable_f[31:31];

        enum PT_BT656_CFG_field_inv_enum {
            NOT_REVERSED = 0 { name = "Not Reversed"; desc = "not reversed"; };
            REVERSED = 1 { name = "Reversed"; desc = "reversed"; };
        };

        field {
            name = "field_inv";
            desc = "Reverse control";
            sw = rw;
            hw = r;
            encode = PT_BT656_CFG_field_inv_enum;
            reset = 0x0;
        } field_inv[10:10];

        enum PT_BT656_CFG_vsync_inv_enum {
            NOT_REVERSED = 0 { name = "Not Reversed"; desc = "not reversed"; };
            REVERSED = 1 { name = "Reversed"; desc = "reversed"; };
        };

        field {
            name = "vsync_inv";
            desc = "Reverse control";
            sw = rw;
            hw = r;
            encode = PT_BT656_CFG_vsync_inv_enum;
            reset = 0x1;
        } vsync_inv[9:9];

        enum PT_BT656_CFG_hsync_inv_enum {
            NOT_REVERSED = 0 { name = "Not Reversed"; desc = "not reversed"; };
            REVERSED = 1 { name = "Reversed"; desc = "reversed"; };
        };

        field {
            name = "hsync_inv";
            desc = "Reverse control";
            sw = rw;
            hw = r;
            encode = PT_BT656_CFG_hsync_inv_enum;
            reset = 0x1;
        } hsync_inv[8:8];

        field {
            name = "mode";
            desc = "Mode select mode[0] 0: hsync is not an active signal. 1: hsync is an active signal. mode[1] 0: The hsync output is active low. 1: The hsync output is active high. mode[3:2] 00: Component 0 is parsed. 01: Component 1 is parsed. 10: Component 2 is parsed. 11: reserved";
            sw = rw;
            hw = r;
            reset = 0x3;
        } mode[3:0];
    } PT_BT656_CFG @ 0x120;

    reg {
        name = "Timing configuration register NG_CFG";
        desc = "PT_UNIFY_TIMING_CFG is a timing configuration register.

Data sheet 9.1.6 PT_UNIFY_TIMING_CFG (offset 0x130, printed page 9-28, `hi3518ev200--Hi3518EV20X-Hi3516CV200-Datasheet.txt` line 51225).";

        enum PT_UNIFY_TIMING_CFG_field_inv_enum {
            NOT_INVERTED = 0 { name = "Not Inverted"; desc = "not inverted"; };
            INVERTED = 1 { name = "Inverted"; desc = "inverted"; };
        };

        field {
            name = "field_inv";
            desc = "Field inverse (level-1 field processing)";
            sw = rw;
            hw = r;
            encode = PT_UNIFY_TIMING_CFG_field_inv_enum;
            reset = 0x0;
        } field_inv[26:26];

        enum PT_UNIFY_TIMING_CFG_field_sel_enum {
            INPUT_FIELD = 0 { name = "Input Field"; desc = "input field"; };
            INPUT_VSYNC = 1 { name = "Input Vsync"; desc = "input vsync"; };
            DETECTED_BASED_RELATIONSHIP = 2 { name = "Detected Based Relationship"; desc = "detected based on the relationship between vsync and hsync"; };
            FIXED_AT_0 = 3 { name = "Fixed At 0"; desc = "fixed at 0"; };
        };

        field {
            name = "field_sel";
            desc = "Field source select (level-0 field processing)";
            sw = rw;
            hw = r;
            encode = PT_UNIFY_TIMING_CFG_field_sel_enum;
            reset = 0x0;
        } field_sel[25:24];

        enum PT_UNIFY_TIMING_CFG_vsync_mode_enum {
            NOT_PROCESSED = 0 { name = "Not Processed"; desc = "not processed"; };
            DETECT_RISING_EDGE = 1 { name = "Detect Rising Edge"; desc = "detect the rising edge"; };
            DETECT_RISING_EDGE_2 = 2 { name = "Detect Rising Edge 2"; desc = "detect the rising edge and falling edge"; };
            RESERVED = 3 { name = "Reserved"; desc = "reserved"; };
        };

        field {
            name = "vsync_mode";
            desc = "vsync processing mode (level-2 vsync processing)";
            sw = rw;
            hw = r;
            encode = PT_UNIFY_TIMING_CFG_vsync_mode_enum;
            reset = 0x0;
        } vsync_mode[20:19];

        enum PT_UNIFY_TIMING_CFG_vsync_inv_enum {
            NOT_INVERTED = 0 { name = "Not Inverted"; desc = "not inverted"; };
            INVERTED = 1 { name = "Inverted"; desc = "inverted"; };
        };

        field {
            name = "vsync_inv";
            desc = "vsync inversion (level-1 vsync processing)";
            sw = rw;
            hw = r;
            encode = PT_UNIFY_TIMING_CFG_vsync_inv_enum;
            reset = 0x0;
        } vsync_inv[18:18];

        enum PT_UNIFY_TIMING_CFG_vsync_sel_enum {
            INPUT_VSYNC = 0 { name = "Input Vsync"; desc = "input vsync"; };
            INPUT_FIELD = 1 { name = "Input Field"; desc = "input field"; };
            FIXED_AT_0 = 2 { name = "Fixed At 0"; desc = "fixed at 0"; };
            RESERVED = 3 { name = "Reserved"; desc = "reserved"; };
        };

        field {
            name = "vsync_sel";
            desc = "vsync source select (level-0 vsync processing)";
            sw = rw;
            hw = r;
            encode = PT_UNIFY_TIMING_CFG_vsync_sel_enum;
            reset = 0x0;
        } vsync_sel[17:16];

        enum PT_UNIFY_TIMING_CFG_hsync_mode_enum {
            NOT_PROCESSED = 0 { name = "Not Processed"; desc = "not processed"; };
            DETECT_RISING_EDGE = 1 { name = "Detect Rising Edge"; desc = "detect the rising edge"; };
        };

        field {
            name = "hsync_mode";
            desc = "hsync processing mode (level-3 hsync processing)";
            sw = rw;
            hw = r;
            encode = PT_UNIFY_TIMING_CFG_hsync_mode_enum;
            reset = 0x0;
        } hsync_mode[14:13];

        enum PT_UNIFY_TIMING_CFG_hsync_and_enum {
            NOT_PROCESSED = 0 { name = "Not Processed"; desc = "not processed"; };
            ANDED = 1 { name = "Anded"; desc = "ANDed"; };
            EXCLUSIVE_ORED = 2 { name = "Exclusive Ored"; desc = "exclusive ORed"; };
            RESERVED = 3 { name = "Reserved"; desc = "reserved"; };
        };

        field {
            name = "hsync_and";
            desc = "Whether hsync is operated with the result of level-1 vsync processing (level-2 hsync processing)";
            sw = rw;
            hw = r;
            encode = PT_UNIFY_TIMING_CFG_hsync_and_enum;
            reset = 0x0;
        } hsync_and[12:11];

        enum PT_UNIFY_TIMING_CFG_hsync_inv_enum {
            NOT_INVERTED = 0 { name = "Not Inverted"; desc = "not inverted"; };
            INVERTED = 1 { name = "Inverted"; desc = "inverted"; };
        };

        field {
            name = "hsync_inv";
            desc = "hsync inversion (level-1 hsync processing)";
            sw = rw;
            hw = r;
            encode = PT_UNIFY_TIMING_CFG_hsync_inv_enum;
            reset = 0x0;
        } hsync_inv[10:10];

        enum PT_UNIFY_TIMING_CFG_hsync_sel_enum {
            INPUT_HSYNC = 0 { name = "Input Hsync"; desc = "input hsync"; };
            INPUT_DE = 1 { name = "Input De"; desc = "input de"; };
            FIXED_AT_0 = 2 { name = "Fixed At 0"; desc = "fixed at 0"; };
            RESERVED = 3 { name = "Reserved"; desc = "reserved"; };
        };

        field {
            name = "hsync_sel";
            desc = "hsync source select (level-0 hsync processing)";
            sw = rw;
            hw = r;
            encode = PT_UNIFY_TIMING_CFG_hsync_sel_enum;
            reset = 0x0;
        } hsync_sel[9:8];

        enum PT_UNIFY_TIMING_CFG_de_inv_enum {
            NOT_INVERTED = 0 { name = "Not Inverted"; desc = "not inverted"; };
            INVERTED = 1 { name = "Inverted"; desc = "inverted"; };
        };

        field {
            name = "de_inv";
            desc = "de inversion (level-1 de processing)";
            sw = rw;
            hw = r;
            encode = PT_UNIFY_TIMING_CFG_de_inv_enum;
            reset = 0x0;
        } de_inv[2:2];

        enum PT_UNIFY_TIMING_CFG_de_sel_enum {
            INPUT_DE = 0 { name = "Input De"; desc = "input de"; };
            RESULT_LEVEL_2 = 1 { name = "Result Level 2"; desc = "result of level-2 hsync processing"; };
            FIXED_AT_1 = 2 { name = "Fixed At 1"; desc = "fixed at 1"; };
            FIXED_AT_0 = 3 { name = "Fixed At 0"; desc = "fixed at 0"; };
        };

        field {
            name = "de_sel";
            desc = "de source select (level-0 de processing)";
            sw = rw;
            hw = r;
            encode = PT_UNIFY_TIMING_CFG_de_sel_enum;
            reset = 0x0;
        } de_sel[1:0];
    } PT_UNIFY_TIMING_CFG @ 0x130;

    reg {
        name = "Timing recovery module configuration G_CFG register";
        desc = "PT_GEN_TIMING_CFG is a timing recovery module configuration register.

Data sheet 9.1.6 PT_GEN_TIMING_CFG (offset 0x134, printed page 9-30, `hi3518ev200--Hi3518EV20X-Hi3516CV200-Datasheet.txt` line 51321).";

        enum PT_GEN_TIMING_CFG_enable_f_enum {
            DISABLED = 0 { name = "Disabled"; desc = "disabled"; };
            ENABLED = 1 { name = "Enabled"; desc = "enabled"; };
        };

        field {
            name = "enable";
            desc = "Timing recovery enable (timings are recovered based on timing parameters)";
            sw = rw;
            hw = r;
            encode = PT_GEN_TIMING_CFG_enable_f_enum;
            reset = 0x0;
        } enable_f[31:31];

        enum PT_GEN_TIMING_CFG_mode_enum {
            TIMINGS_GENERATED_BASED = 0 { name = "Timings Generated Based"; desc = "Timings are generated based on the input valid signal of PT."; };
            TIMINGS_INTERNALLY_CALCULATED = 1 { name = "Timings Internally Calculated"; desc = "Timings are internally calculated and generated."; };
        };

        field {
            name = "mode";
            desc = "Timing recovery mode (timings are recovered based on timing parameters)";
            sw = rw;
            hw = r;
            encode = PT_GEN_TIMING_CFG_mode_enum;
            reset = 0x0;
        } mode[30:30];

        enum PT_GEN_TIMING_CFG_vsync_mode_enum {
            NOT_RECOVERED = 0 { name = "Not Recovered"; desc = "not recovered"; };
            RECOVERED = 1 { name = "Recovered"; desc = "recovered"; };
        };

        field {
            name = "vsync_mode";
            desc = "vsync recovery";
            sw = rw;
            hw = r;
            encode = PT_GEN_TIMING_CFG_vsync_mode_enum;
            reset = 0x0;
        } vsync_mode[2:2];

        enum PT_GEN_TIMING_CFG_hsync_mode_enum {
            NOT_RECOVERED = 0 { name = "Not Recovered"; desc = "not recovered"; };
            RECOVERED = 1 { name = "Recovered"; desc = "recovered"; };
        };

        field {
            name = "hsync_mode";
            desc = "hsync recovery";
            sw = rw;
            hw = r;
            encode = PT_GEN_TIMING_CFG_hsync_mode_enum;
            reset = 0x0;
        } hsync_mode[1:1];
    } PT_GEN_TIMING_CFG @ 0x134;

    reg {
        name = "Data configuration register A_CFG";
        desc = "PT_UNIFY_DATA_CFG is a data configuration register.

Data sheet 9.1.6 PT_UNIFY_DATA_CFG (offset 0x140, printed page 9-31, `hi3518ev200--Hi3518EV20X-Hi3516CV200-Datasheet.txt` line 51372).";

        enum PT_UNIFY_DATA_CFG_enable_f_enum {
            DISABLED = 0 { name = "Disabled"; desc = "disabled"; };
            ENABLED = 1 { name = "Enabled"; desc = "enabled"; };
        };

        field {
            name = "enable";
            desc = "Data separation enable";
            sw = rw;
            hw = r;
            encode = PT_UNIFY_DATA_CFG_enable_f_enum;
            reset = 0x0;
        } enable_f[31:31];

        enum PT_UNIFY_DATA_CFG_uv_seq_enum {
            CBCR = 0 { name = "Cbcr"; desc = "CbCr"; };
            CRCB = 1 { name = "Crcb"; desc = "CrCb"; };
        };

        field {
            name = "uv_seq";
            desc = "CbCr sequence";
            sw = rw;
            hw = r;
            encode = PT_UNIFY_DATA_CFG_uv_seq_enum;
            reset = 0x0;
        } uv_seq[3:3];

        enum PT_UNIFY_DATA_CFG_yc_seq_enum {
            CY = 0 { name = "Cy"; desc = "CY"; };
            YC = 1 { name = "Yc"; desc = "YC"; };
        };

        field {
            name = "yc_seq";
            desc = "YC sequence";
            sw = rw;
            hw = r;
            encode = PT_UNIFY_DATA_CFG_yc_seq_enum;
            reset = 0x0;
        } yc_seq[2:2];

        enum PT_UNIFY_DATA_CFG_comp_num_enum {
            COMPONENT_1 = 0 { name = "Component 1"; desc = "component 1"; };
            COMPONENT_2 = 1 { name = "Component 2"; desc = "component 2"; };
            COMPONENT_3 = 2 { name = "Component 3"; desc = "component 3"; };
            RESERVED = 3 { name = "Reserved"; desc = "reserved"; };
        };

        field {
            name = "comp_num";
            desc = "Data component select";
            sw = rw;
            hw = r;
            encode = PT_UNIFY_DATA_CFG_comp_num_enum;
            reset = 0x0;
        } comp_num[1:0];
    } PT_UNIFY_DATA_CFG @ 0x140;

    reg {
        name = "YUV444 configuration register G";
        desc = "PT_YUV444_CFG is a YUV444 configuration register.

Data sheet 9.1.6 PT_YUV444_CFG (offset 0x150, printed page 9-32, `hi3518ev200--Hi3518EV20X-Hi3516CV200-Datasheet.txt` line 51420).";

        enum PT_YUV444_CFG_enable_f_enum {
            DISABLED = 0 { name = "Disabled"; desc = "disabled"; };
            ENABLED = 1 { name = "Enabled"; desc = "enabled"; };
        };

        field {
            name = "enable";
            desc = "YUV enable for converting YUV422 signals into YUV444 signals";
            sw = rw;
            hw = r;
            encode = PT_YUV444_CFG_enable_f_enum;
            reset = 0x0;
        } enable_f[31:31];
    } PT_YUV444_CFG @ 0x150;

    reg {
        name = "Horizontal front blanking width register";
        desc = "PT_INTF_HFB is a horizontal front blanking width register.

Data sheet 9.1.6 PT_INTF_HFB (offset 0x180, printed page 9-32, `hi3518ev200--Hi3518EV20X-Hi3516CV200-Datasheet.txt` line 51444).";

        field {
            name = "hfb";
            desc = "Horizontal front blanking width";
            sw = rw;
            hw = r;
            reset = 0x10;
        } hfb[15:0];
    } PT_INTF_HFB @ 0x180;

    reg {
        name = "Horizontal active width register";
        desc = "PT_INTF_HACT is a horizontal active width register.

Data sheet 9.1.6 PT_INTF_HACT (offset 0x184, printed page 9-32, `hi3518ev200--Hi3518EV20X-Hi3516CV200-Datasheet.txt` line 51463).";

        field {
            name = "hact";
            desc = "Horizontal active width (in clock cycle)";
            sw = rw;
            hw = r;
            reset = 0x10;
        } hact[31:0];
    } PT_INTF_HACT @ 0x184;

    reg {
        name = "Horizontal back blanking width register";
        desc = "PT_INTF_HBB is a horizontal back blanking width register.

Data sheet 9.1.6 PT_INTF_HBB (offset 0x188, printed page 9-33, `hi3518ev200--Hi3518EV20X-Hi3516CV200-Datasheet.txt` line 51490).";

        field {
            name = "hbb";
            desc = "Horizontal back blanking width";
            sw = rw;
            hw = r;
            reset = 0x10;
        } hbb[15:0];
    } PT_INTF_HBB @ 0x188;

    reg {
        name = "Vertical front blanking width register";
        desc = "PT_INTF_VFB is a vertical front blanking width register.

Data sheet 9.1.6 PT_INTF_VFB (offset 0x18C, printed page 9-33, `hi3518ev200--Hi3518EV20X-Hi3516CV200-Datasheet.txt` line 51510).";

        field {
            name = "vfb";
            desc = "Vertical front blanking width";
            sw = rw;
            hw = r;
            reset = 0x10;
        } vfb[15:0];
    } PT_INTF_VFB @ 0x18C;

    reg {
        name = "Vertical active width register";
        desc = "PT_INTF_VACT is a vertical active width register.

Data sheet 9.1.6 PT_INTF_VACT (offset 0x190, printed page 9-34, `hi3518ev200--Hi3518EV20X-Hi3516CV200-Datasheet.txt` line 51539).";

        field {
            name = "vact";
            desc = "Vertical active width";
            sw = rw;
            hw = r;
            reset = 0x10;
        } vact[15:0];
    } PT_INTF_VACT @ 0x190;

    reg {
        name = "Vertical back blanking width register";
        desc = "PT_INTF_VBB is a vertical back blanking width register.

Data sheet 9.1.6 PT_INTF_VBB (offset 0x194, printed page 9-34, `hi3518ev200--Hi3518EV20X-Hi3516CV200-Datasheet.txt` line 51558).";

        field {
            name = "vbb";
            desc = "Vertical back blanking width";
            sw = rw;
            hw = r;
            reset = 0x10;
        } vbb[15:0];
    } PT_INTF_VBB @ 0x194;

    reg {
        name = "Vertical bottom front blanking width register";
        desc = "PT_INTF_VBFB is a vertical bottom front blanking width register.

Data sheet 9.1.6 PT_INTF_VBFB (offset 0x198, printed page 9-34, `hi3518ev200--Hi3518EV20X-Hi3516CV200-Datasheet.txt` line 51578).";

        field {
            name = "vbfb";
            desc = "Vertical bottom front blanking width";
            sw = rw;
            hw = r;
            reset = 0x10;
        } vbfb[15:0];
    } PT_INTF_VBFB @ 0x198;

    reg {
        name = "Vertical bottom active width register T";
        desc = "PT_INTF_VBACT is a vertical bottom active width register.

Data sheet 9.1.6 PT_INTF_VBACT (offset 0x19C, printed page 9-35, `hi3518ev200--Hi3518EV20X-Hi3516CV200-Datasheet.txt` line 51603).";

        field {
            name = "vbact";
            desc = "Vertical bottom active width";
            sw = rw;
            hw = r;
            reset = 0x10;
        } vbact[15:0];
    } PT_INTF_VBACT @ 0x19C;

    reg {
        name = "Vertical bottom back blanking width register";
        desc = "PT_INTF_VBBB is a vertical bottom back blanking width register.

Data sheet 9.1.6 PT_INTF_VBBB (offset 0x1A0, printed page 9-35, `hi3518ev200--Hi3518EV20X-Hi3516CV200-Datasheet.txt` line 51623).";

        field {
            name = "vbbb";
            desc = "Vertical bottom back blanking width";
            sw = rw;
            hw = r;
            reset = 0x10;
        } vbbb[15:0];
    } PT_INTF_VBBB @ 0x1A0;

    reg {
        name = "ID configuration register";
        desc = "PT_ID_CFG is an ID configuration register.

Data sheet 9.1.6 PT_ID_CFG (offset 0x1A4, printed page 9-36, `hi3518ev200--Hi3518EV20X-Hi3516CV200-Datasheet.txt` line 51652).";

        enum PT_ID_CFG_enable_f_enum {
            DISABLED = 0 { name = "Disabled"; desc = "disabled"; };
            ENABLED = 1 { name = "Enabled"; desc = "enabled"; };
        };

        field {
            name = "enable";
            desc = "ID generation enable";
            sw = rw;
            hw = r;
            encode = PT_ID_CFG_enable_f_enum;
            reset = 0x0;
        } enable_f[31:31];

        enum PT_ID_CFG_mode_enum {
            AUTOMATIC_MODE = 0 { name = "Automatic Mode"; desc = "automatic mode (the ID automatically increases for each frame)"; };
            NON_AUTOMATIC_MODE = 1 { name = "Non Automatic Mode"; desc = "non-automatic mode (the ID depends on the configured value)"; };
        };

        field {
            name = "mode";
            desc = "ID generation mode";
            sw = rw;
            hw = r;
            encode = PT_ID_CFG_mode_enum;
            reset = 0x0;
        } mode[30:30];

        field {
            name = "reset";
            desc = "In automatic mode, setting this field to 1 restores the ID of the next frame to the initial value. This field is automatically cleared after restoration.";
            sw = w;
            hw = r;
            reset = 0x0;
        } reset_f[29:29];

        field {
            name = "id_det";
            desc = "ID of the frame whose width and height are detected";
            sw = rw;
            hw = r;
            reset = 0x0;
        } id_det[5:4];

        field {
            name = "id_max";
            desc = "Maximum ID in automatic mode";
            sw = rw;
            hw = r;
            reset = 0x0;
        } id_max[3:2];

        field {
            name = "id";
            desc = "Initial ID in automatic mode or generated ID in non-automatic mode";
            sw = rw;
            hw = r;
            reset = 0x0;
        } id[1:0];
    } PT_ID_CFG @ 0x1A4;

    reg {
        name = "Flash configuration register";
        desc = "PT_FLASH_CFG is a flash configuration register.

Data sheet 9.1.6 PT_FLASH_CFG (offset 0x1B0, printed page 9-37, `hi3518ev200--Hi3518EV20X-Hi3516CV200-Datasheet.txt` line 51697).";

        enum PT_FLASH_CFG_id_sel_enum {
            TRIGGERED_USING_START = 1 { name = "Triggered Using Start"; desc = "triggered by using the start interrupt of the frame whose ID is 0"; };
            TRIGGERED_USING_START_2 = 2 { name = "Triggered Using Start 2"; desc = "triggered by using the start interrupt of the frame whose ID is 1"; };
            TRIGGERED_USING_START_3 = 4 { name = "Triggered Using Start 3"; desc = "triggered by using the start interrupt of the frame whose ID is 2"; };
            TRIGGERED_USING_START_4 = 8 { name = "Triggered Using Start 4"; desc = "triggered by using the start interrupt of the frame whose ID is 3"; };
        };

        field {
            name = "id_sel";
            desc = "Trigger frame ID";
            sw = rw;
            hw = r;
            encode = PT_FLASH_CFG_id_sel_enum;
            reset = 0x1;
        } id_sel[31:28];

        enum PT_FLASH_CFG_shutter_times_enum {
            TWICE = 0 { name = "Twice"; desc = "twice"; };
            ONCE = 1 { name = "Once"; desc = "once"; };
        };

        field {
            name = "shutter_times";
            desc = "Shutter pulse times";
            sw = rw;
            hw = r;
            encode = PT_FLASH_CFG_shutter_times_enum;
            reset = 0x0;
        } shutter_times[18:18];

        enum PT_FLASH_CFG_shutter_phase_enum {
            NOT_REVERSED = 0 { name = "Not Reversed"; desc = "not reversed"; };
            REVERSED = 1 { name = "Reversed"; desc = "reversed"; };
        };

        field {
            name = "shutter_phase";
            desc = "Shutter signal reverse";
            sw = rw;
            hw = r;
            encode = PT_FLASH_CFG_shutter_phase_enum;
            reset = 0x0;
        } shutter_phase[17:17];

        field {
            name = "shutter_en";
            desc = "Shutter trigger enable. This field is automatically cleared.";
            sw = w;
            hw = r;
            reset = 0x0;
        } shutter_en[16:16];

        enum PT_FLASH_CFG_flash_phase_enum {
            NOT_REVERSED = 0 { name = "Not Reversed"; desc = "not reversed"; };
            REVERSED = 1 { name = "Reversed"; desc = "reversed"; };
        };

        field {
            name = "flash_phase";
            desc = "Flash signal reverse";
            sw = rw;
            hw = r;
            encode = PT_FLASH_CFG_flash_phase_enum;
            reset = 0x0;
        } flash_phase[1:1];

        field {
            name = "flash_en";
            desc = "Flash trigger enable. This field is automatically cleared.";
            sw = w;
            hw = r;
            reset = 0x0;
        } flash_en[0:0];
    } PT_FLASH_CFG @ 0x1B0;

    reg {
        name = "Flash timing 0 width register 0";
        desc = "PT_FLASH_CYC0 is a flash timing 0 width register.

Data sheet 9.1.6 PT_FLASH_CYC0 (offset 0x1C0, printed page 9-38, `hi3518ev200--Hi3518EV20X-Hi3516CV200-Datasheet.txt` line 51752).";

        field {
            name = "cyc";
            desc = "Duration of flash timing 0 (in PT clock). The configured value is the actual value minus 1.";
            sw = rw;
            hw = r;
            reset = 0x0;
        } cyc[31:0];
    } PT_FLASH_CYC0 @ 0x1C0;

    reg {
        name = "Flash timing 1 width register 1";
        desc = "PT_FLASH_CYC1 is a flash timing 1 width register.

Data sheet 9.1.6 PT_FLASH_CYC1 (offset 0x1C4, printed page 9-38, `hi3518ev200--Hi3518EV20X-Hi3516CV200-Datasheet.txt` line 51772).";

        field {
            name = "cyc";
            desc = "Duration of flash timing 1 (in PT clock). The configured value is the actual value minus 1.";
            sw = rw;
            hw = r;
            reset = 0x0;
        } cyc[31:0];
    } PT_FLASH_CYC1 @ 0x1C4;

    reg {
        name = "Shutter timing 0 width register YC0";
        desc = "PT_SHUTTER_CYC0 is a shutter timing 0 width register.

Data sheet 9.1.6 PT_SHUTTER_CYC0 (offset 0x1D0, printed page 9-38, `hi3518ev200--Hi3518EV20X-Hi3516CV200-Datasheet.txt` line 51792).";

        field {
            name = "cyc";
            desc = "Duration of shutter timing 0 (in PT clock). The configured value is the actual value minus 1.";
            sw = rw;
            hw = r;
            reset = 0x0;
        } cyc[31:0];
    } PT_SHUTTER_CYC0 @ 0x1D0;

    reg {
        name = "Shutter timing 1 width register YC1";
        desc = "PT_SHUTTER_CYC1 is a shutter timing 1 width register.

Data sheet 9.1.6 PT_SHUTTER_CYC1 (offset 0x1D4, printed page 9-39, `hi3518ev200--Hi3518EV20X-Hi3516CV200-Datasheet.txt` line 51819).";

        field {
            name = "cyc";
            desc = "Duration of shutter timing 1 (in PT clock). The configured value is the actual value minus 1.";
            sw = rw;
            hw = r;
            reset = 0x0;
        } cyc[31:0];
    } PT_SHUTTER_CYC1 @ 0x1D4;

    reg {
        name = "Shutter timing 2 width register YC2";
        desc = "PT_SHUTTER_CYC2 is a shutter timing 2 width register.

Data sheet 9.1.6 PT_SHUTTER_CYC2 (offset 0x1D8, printed page 9-39, `hi3518ev200--Hi3518EV20X-Hi3516CV200-Datasheet.txt` line 51840).";

        field {
            name = "cyc";
            desc = "Duration of shutter timing 2 (in PT clock). The configured value is the actual value minus 1.";
            sw = rw;
            hw = r;
            reset = 0x0;
        } cyc[31:0];
    } PT_SHUTTER_CYC2 @ 0x1D8;

    reg {
        name = "Shutter timing 3 width register YC3";
        desc = "PT_SHUTTER_CYC3 is a shutter timing 3 width register.

Data sheet 9.1.6 PT_SHUTTER_CYC3 (offset 0x1DC, printed page 9-40, `hi3518ev200--Hi3518EV20X-Hi3516CV200-Datasheet.txt` line 51870).";

        field {
            name = "cyc";
            desc = "Duration of shutter timing 3 (in PT clock). The configured value is the actual value minus 1.";
            sw = rw;
            hw = r;
            reset = 0x0;
        } cyc[31:0];
    } PT_SHUTTER_CYC3 @ 0x1DC;

    reg {
        name = "Port status register";
        desc = "PT_STATUS is a port status register.

Data sheet 9.1.6 PT_STATUS (offset 0x1E0, printed page 9-40, `hi3518ev200--Hi3518EV20X-Hi3516CV200-Datasheet.txt` line 51890).";

        field {
            name = "id";
            desc = "Port output ID";
            sw = r;
            hw = w;
            reset = 0x0;
        } id[5:4];

        field {
            name = "field";
            desc = "Field output over the port";
            sw = r;
            hw = w;
            reset = 0x0;
        } field_f[3:3];

        field {
            name = "vsync";
            desc = "vsync signal output over the port (spelt `vysnc` in the Hi3518E V20X data sheet; the Hi3516C V300 data sheet spells it vsync).";
            sw = r;
            hw = w;
            reset = 0x0;
        } vsync[2:2];

        field {
            name = "hsync";
            desc = "hsync signal over the port";
            sw = r;
            hw = w;
            reset = 0x0;
        } hsync[1:1];

        field {
            name = "de";
            desc = "de signal output over the port";
            sw = r;
            hw = w;
            reset = 0x0;
        } de[0:0];
    } PT_STATUS @ 0x1E0;

    reg {
        name = "BT656 status register US";
        desc = "PT_BT656_STATUS is a BT.656 status register.

Data sheet 9.1.6 PT_BT656_STATUS (offset 0x1E4, printed page 9-41, `hi3518ev200--Hi3518EV20X-Hi3516CV200-Datasheet.txt` line 51926).";

        field {
            name = "seav";
            desc = "Sync code";
            sw = r;
            hw = w;
            reset = 0x0;
        } seav[15:8];
    } PT_BT656_STATUS @ 0x1E4;

    reg {
        name = "Input picture size register";
        desc = "PT_SIZE is an input picture size register.

Data sheet 9.1.6 PT_SIZE (offset 0x1EC, printed page 9-41, `hi3518ev200--Hi3518EV20X-Hi3516CV200-Datasheet.txt` line 51946).";

        field {
            name = "height";
            desc = "Picture height";
            sw = r;
            hw = w;
            reset = 0x0;
        } height[31:16];

        field {
            name = "width";
            desc = "Picture width";
            sw = r;
            hw = w;
            reset = 0x0;
        } width[15:0];
    } PT_SIZE @ 0x1EC;

    reg {
        name = "Port interrupt status register";
        desc = "PT_INT is a channel interrupt status register.

Data sheet 9.1.6 PT_INT (offset 0x1F0, printed page 9-42, `hi3518ev200--Hi3518EV20X-Hi3516CV200-Datasheet.txt` line 51976).";

        enum PT_INT_height_err_enum {
            NO_INTERRUPT_GENERATED = 0 { name = "No Interrupt Generated"; desc = "No interrupt is generated."; };
            INTERRUPT_GENERATED = 1 { name = "Interrupt Generated"; desc = "An interrupt is generated."; };
        };

        field {
            name = "height_err";
            desc = "Status of the picture height change interrupt. Writing 1 clears the interrupt.";
            sw = rw;
            hw = w;
            onwrite = woclr;
            encode = PT_INT_height_err_enum;
            reset = 0x0;
        } height_err[2:2];

        enum PT_INT_width_err_enum {
            NO_INTERRUPT_GENERATED = 0 { name = "No Interrupt Generated"; desc = "No interrupt is generated."; };
            INTERRUPT_GENERATED = 1 { name = "Interrupt Generated"; desc = "An interrupt is generated."; };
        };

        field {
            name = "width_err";
            desc = "Status of the picture width change interrupt. Writing 1 clears the interrupt.";
            sw = rw;
            hw = w;
            onwrite = woclr;
            encode = PT_INT_width_err_enum;
            reset = 0x0;
        } width_err[1:1];

        enum PT_INT_fstart_enum {
            NO_INTERRUPT_GENERATED = 0 { name = "No Interrupt Generated"; desc = "No interrupt is generated."; };
            INTERRUPT_GENERATED = 1 { name = "Interrupt Generated"; desc = "An interrupt is generated."; };
        };

        field {
            name = "fstart";
            desc = "Status of the field/frame start interrupt. Writing 1 clears the interrupt.";
            sw = rw;
            hw = w;
            onwrite = woclr;
            encode = PT_INT_fstart_enum;
            reset = 0x0;
        } fstart[0:0];
    } PT_INT @ 0x1F0;

    reg {
        name = "Port interrupt mask register";
        desc = "PT_INT_MASK is a port interrupt mask register.

Data sheet 9.1.6 PT_INT_MASK (offset 0x1F8, printed page 9-42, `hi3518ev200--Hi3518EV20X-Hi3516CV200-Datasheet.txt` line 52014).";

        enum PT_INT_MASK_height_err_enum {
            MASKED = 0 { name = "Masked"; desc = "masked"; };
            ENABLED = 1 { name = "Enabled"; desc = "enabled"; };
        };

        field {
            name = "height_err";
            desc = "Picture height change interrupt enable";
            sw = rw;
            hw = r;
            encode = PT_INT_MASK_height_err_enum;
            reset = 0x0;
        } height_err[2:2];

        enum PT_INT_MASK_width_err_enum {
            MASKED = 0 { name = "Masked"; desc = "masked"; };
            ENABLED = 1 { name = "Enabled"; desc = "enabled"; };
        };

        field {
            name = "width_err";
            desc = "Picture width change interrupt enable";
            sw = rw;
            hw = r;
            encode = PT_INT_MASK_width_err_enum;
            reset = 0x0;
        } width_err[1:1];

        enum PT_INT_MASK_fstart_enum {
            MASKED = 0 { name = "Masked"; desc = "masked"; };
            ENABLED = 1 { name = "Enabled"; desc = "enabled"; };
        };

        field {
            name = "fstart";
            desc = "Frame/Field start interrupt enable";
            sw = rw;
            hw = r;
            encode = PT_INT_MASK_fstart_enum;
            reset = 0x0;
        } fstart[0:0];
    } PT_INT_MASK @ 0x1F8;

    reg {
        name = "DES control register";
        desc = "DES_CTRL is a DES control register.

Data sheet 9.1.6 DES_CTRL (offset 0x200, printed page 9-43, `hi3518ev200--Hi3518EV20X-Hi3516CV200-Datasheet.txt` line 52058).";

        enum DES_CTRL_enable_f_enum {
            DISABLED = 0 { name = "Disabled"; desc = "disabled"; };
            ENABLED = 1 { name = "Enabled"; desc = "enabled"; };
        };

        field {
            name = "enable";
            desc = "DES enable";
            sw = rw;
            hw = r;
            encode = DES_CTRL_enable_f_enum;
            reset = 0x0;
        } enable_f[31:31];

        enum DES_CTRL_bit_width_enum {
            V_8_BITS = 0x8 { name = "V 8 Bits"; desc = "8 bits"; };
            V_10_BITS = 0xA { name = "V 10 Bits"; desc = "10 bits"; };
            V_12_BITS = 0xC { name = "V 12 Bits"; desc = "12 bits"; };
            V_14_BITS = 0xE { name = "V 14 Bits"; desc = "14 bits"; };
            V_16_BITS_OTHER = 0x10 { name = "V 16 Bits Other"; desc = "16 bits Other values: reserved"; };
        };

        field {
            name = "bit_width";
            desc = "Data width";
            sw = rw;
            hw = r;
            encode = DES_CTRL_bit_width_enum;
            reset = 0x0;
        } bit_width[5:0];
    } DES_CTRL @ 0x200;

    reg {
        name = "Capture control register ER";
        desc = "DES_REG_NEWER is a capture control register.

Data sheet 9.1.6 DES_REG_NEWER (offset 0x204, printed page 9-44, `hi3518ev200--Hi3518EV20X-Hi3516CV200-Datasheet.txt` line 52098).";

        field {
            name = "reg_newer";
            desc = "DES update. This bit is automatically cleared for each frame.";
            sw = rw;
            hw = r;
            reset = 0x0;
        } reg_newer[0:0];
    } DES_REG_NEWER @ 0x204;

    reg {
        name = "DES RX ID selection register";
        desc = "DES_ID_CFG is a DES RX ID selection register (instant register).

Data sheet 9.1.6 DES_ID_CFG (offset 0x210, printed page 9-44, `hi3518ev200--Hi3518EV20X-Hi3516CV200-Datasheet.txt` line 52124).";

        enum DES_ID_CFG_id_sel_enum {
            DATA_WITH_THIS = 0 { name = "Data With This"; desc = "Data with this ID is filtered."; };
            DATA_WITH_THIS_2 = 1 { name = "Data With This 2"; desc = "Data with this ID is received. bit[0]: DES RX enable for data with the ID 0 bit[1]: DES RX enable for data with the ID 1 bit[2]: DES RX enable for data with the ID 2 bit[3]: DES RX enable for data with the ID 3"; };
        };

        field {
            name = "id_sel";
            desc = "ID of the data received by the DES";
            sw = rw;
            hw = r;
            encode = DES_ID_CFG_id_sel_enum;
            reset = 0x0;
        } id_sel[3:0];
    } DES_ID_CFG @ 0x210;

    reg {
        name = "Crop enable register";
        desc = "DES_CROP_CFG is a crop enable register.

Data sheet 9.1.6 DES_CROP_CFG (offset 0x220, printed page 9-45, `hi3518ev200--Hi3518EV20X-Hi3516CV200-Datasheet.txt` line 52159).";

        enum DES_CROP_CFG_n0_en_enum {
            DISABLED = 0 { name = "Disabled"; desc = "disabled"; };
            ENABLED = 1 { name = "Enabled"; desc = "enabled"; };
        };

        field {
            name = "n0_en";
            desc = "Region 0 enable";
            sw = rw;
            hw = r;
            encode = DES_CROP_CFG_n0_en_enum;
            reset = 0x0;
        } n0_en[0:0];
    } DES_CROP_CFG @ 0x220;

    reg {
        name = "Crop start position register for region 0 ART";
        desc = "DES_CROP0_START is a crop start position register for region 0.

Data sheet 9.1.6 DES_CROP0_START (offset 0x230, printed page 9-45, `hi3518ev200--Hi3518EV20X-Hi3516CV200-Datasheet.txt` line 52182).";

        field {
            name = "y_start";
            desc = "ID of the line from which pictures start to be captured";
            sw = rw;
            hw = r;
            reset = 0x0;
        } y_start[28:16];

        field {
            name = "x_start";
            desc = "ID of the pixel from which pictures start to be captured";
            sw = rw;
            hw = r;
            reset = 0x0;
        } x_start[12:0];
    } DES_CROP0_START @ 0x230;

    reg {
        name = "Crop size configuration register for E region 0";
        desc = "DES_CROP0_SIZE is a crop size configuration register for region 0.

Data sheet 9.1.6 DES_CROP0_SIZE (offset 0x234, printed page 9-46, `hi3518ev200--Hi3518EV20X-Hi3516CV200-Datasheet.txt` line 52215).";

        field {
            name = "height";
            desc = "Height (in line) of the obtained picture. The configured value is the actual value minus 1.";
            sw = rw;
            hw = r;
            reset = 0x0;
        } height[28:16];

        field {
            name = "width";
            desc = "Width (in pixel) of the obtained picture. The configured value is the actual value minus 1.";
            sw = rw;
            hw = r;
            reset = 0x0;
        } width[12:0];
    } DES_CROP0_SIZE @ 0x234;

    reg {
        name = "DES configuration register";
        desc = "DES_CFG is a DES configuration register.

Data sheet 9.1.6 DES_CFG (offset 0x270, printed page 9-46, `hi3518ev200--Hi3518EV20X-Hi3516CV200-Datasheet.txt` line 52242).";

        enum DES_CFG_cmp_en_enum {
            DISABLED = 0 { name = "Disabled"; desc = "disabled"; };
            ENABLED = 1 { name = "Enabled"; desc = "enabled"; };
        };

        field {
            name = "cmp_en";
            desc = "DES channel frame compress enable";
            sw = rw;
            hw = r;
            encode = DES_CFG_cmp_en_enum;
            reset = 0x0;
        } cmp_en[31:31];

        field {
            name = "k_coef_range";
            desc = "Frame compression rate of the DES channel. The value range is [7:12]. The typical value is the data bit width minus 1. The configured value is 12 when the data bit width is 14 bits.";
            sw = rw;
            hw = r;
            reset = 0x0;
        } k_coef_range[30:27];
    } DES_CFG @ 0x270;

    reg {
        name = "DES storage size register";
        desc = "DES_SIZE is a DES storage size register.

Data sheet 9.1.6 DES_SIZE (offset 0x284, printed page 9-47, `hi3518ev200--Hi3518EV20X-Hi3516CV200-Datasheet.txt` line 52277).";

        field {
            name = "height";
            desc = "Height (in line) of the stored picture. The configured value is the actual value minus 1.";
            sw = rw;
            hw = r;
            reset = 0x0;
        } height[28:16];

        field {
            name = "width";
            desc = "Width (in pixel) of the stored picture. The configured value is the actual value minus 1.";
            sw = rw;
            hw = r;
            reset = 0x0;
        } width[12:0];
    } DES_SIZE @ 0x284;

    reg {
        name = "DES storage base address register";
        desc = "DES_FADDR is a DES storage base address register.

Data sheet 9.1.6 DES_FADDR (offset 0x290, printed page 9-47, `hi3518ev200--Hi3518EV20X-Hi3516CV200-Datasheet.txt` line 52305).";

        field {
            name = "faddr";
            desc = "DES storage base address";
            sw = rw;
            hw = r;
            reset = 0x0;
        } faddr[31:0];
    } DES_FADDR @ 0x290;

    reg {
        name = "DES storage line stride register";
        desc = "DES_STRIDE is a DES storage line stride register.

Data sheet 9.1.6 DES_STRIDE (offset 0x294, printed page 9-48, `hi3518ev200--Hi3518EV20X-Hi3516CV200-Datasheet.txt` line 52334).";

        field {
            name = "stride";
            desc = "Line stride for the DES channel frame";
            sw = rw;
            hw = r;
            reset = 0x0;
        } stride[15:0];
    } DES_STRIDE @ 0x294;

    reg {
        name = "DES bus buffer control register";
        desc = "DES_BUF_CFG is a DES bus buffer control register.

Data sheet 9.1.6 DES_BUF_CFG (offset 0x29C, printed page 9-48, `hi3518ev200--Hi3518EV20X-Hi3516CV200-Datasheet.txt` line 52353).";

        field {
            name = "buf_thd";
            desc = "Bus buffer depth";
            sw = rw;
            hw = r;
            reset = 0x80;
        } buf_thd[15:0];
    } DES_BUF_CFG @ 0x29C;

    reg {
        name = "DES raw interrupt register";
        desc = "DES_INT is a DES raw interrupt register.

Data sheet 9.1.6 DES_INT (offset 0x2F0, printed page 9-48, `hi3518ev200--Hi3518EV20X-Hi3516CV200-Datasheet.txt` line 52373).";

        enum DES_INT_update_cfg_enum {
            NO_INTERRUPT_GENERATED = 0 { name = "No Interrupt Generated"; desc = "No interrupt is generated."; };
            INTERRUPT_GENERATED = 1 { name = "Interrupt Generated"; desc = "An interrupt is generated."; };
        };

        field {
            name = "update_cfg";
            desc = "Status of the register update interrupt. Writing 1 clears the interrupt.";
            sw = rw;
            hw = w;
            onwrite = woclr;
            encode = DES_INT_update_cfg_enum;
            reset = 0x0;
        } update_cfg[4:4];

        enum DES_INT_field_throw_enum {
            NO_INTERRUPT_GENERATED = 0 { name = "No Interrupt Generated"; desc = "No interrupt is generated."; };
            INTERRUPT_GENERATED = 1 { name = "Interrupt Generated"; desc = "An interrupt is generated."; };
        };

        field {
            name = "field_throw";
            desc = "Status of the field/frame loss interrupt. Writing 1 clears the interrupt.";
            sw = rw;
            hw = w;
            onwrite = woclr;
            encode = DES_INT_field_throw_enum;
            reset = 0x0;
        } field_throw[3:3];

        enum DES_INT_buf_ovf_enum {
            NO_INTERRUPT_GENERATED = 0 { name = "No Interrupt Generated"; desc = "No interrupt is generated."; };
            INTERRUPT_GENERATED = 1 { name = "Interrupt Generated"; desc = "An interrupt is generated."; };
        };

        field {
            name = "buf_ovf";
            desc = "Status of the internal FIFO overflow error interrupt. Writing 1 clears the interrupt.";
            sw = rw;
            hw = w;
            onwrite = woclr;
            encode = DES_INT_buf_ovf_enum;
            reset = 0x0;
        } buf_ovf[2:2];

        enum DES_INT_cc_int_enum {
            NO_INTERRUPT_GENERATED = 0 { name = "No Interrupt Generated"; desc = "No interrupt is generated."; };
            INTERRUPT_GENERATED = 1 { name = "Interrupt Generated"; desc = "An interrupt is generated."; };
        };

        field {
            name = "cc_int";
            desc = "Status of the capture completion interrupt. Writing 1 clears the interrupt.";
            sw = rw;
            hw = w;
            onwrite = woclr;
            encode = DES_INT_cc_int_enum;
            reset = 0x0;
        } cc_int[1:1];

        enum DES_INT_fstart_enum {
            NO_INTERRUPT_GENERATED = 0 { name = "No Interrupt Generated"; desc = "No interrupt is generated."; };
            INTERRUPT_GENERATED = 1 { name = "Interrupt Generated"; desc = "An interrupt is generated."; };
        };

        field {
            name = "fstart";
            desc = "Status of the field/frame start interrupt. Writing 1 clears the interrupt.";
            sw = rw;
            hw = w;
            onwrite = woclr;
            encode = DES_INT_fstart_enum;
            reset = 0x0;
        } fstart[0:0];
    } DES_INT @ 0x2F0;

    reg {
        name = "DES interrupt mask register";
        desc = "DES_MASK is a DES interrupt mask register.

Data sheet 9.1.6 DES_MASK (offset 0x2F8, printed page 9-49, `hi3518ev200--Hi3518EV20X-Hi3516CV200-Datasheet.txt` line 52434).";

        enum DES_MASK_update_cfg_enum {
            NO_INTERRUPT_GENERATED = 0 { name = "No Interrupt Generated"; desc = "No interrupt is generated."; };
            INTERRUPT_GENERATED = 1 { name = "Interrupt Generated"; desc = "An interrupt is generated."; };
        };

        field {
            name = "update_cfg";
            desc = "Register update interrupt enable";
            sw = rw;
            hw = r;
            encode = DES_MASK_update_cfg_enum;
            reset = 0x0;
        } update_cfg[4:4];

        enum DES_MASK_field_throw_enum {
            MASKED = 0 { name = "Masked"; desc = "masked"; };
            ENABLED = 1 { name = "Enabled"; desc = "enabled"; };
        };

        field {
            name = "field_throw";
            desc = "Field/Frame loss interrupt enable";
            sw = rw;
            hw = r;
            encode = DES_MASK_field_throw_enum;
            reset = 0x0;
        } field_throw[3:3];

        enum DES_MASK_buf_ovf_enum {
            MASKED = 0 { name = "Masked"; desc = "masked"; };
            ENABLED = 1 { name = "Enabled"; desc = "enabled"; };
        };

        field {
            name = "buf_ovf";
            desc = "Internal FIFO overflow error interrupt enable";
            sw = rw;
            hw = r;
            encode = DES_MASK_buf_ovf_enum;
            reset = 0x0;
        } buf_ovf[2:2];

        enum DES_MASK_cc_int_enum {
            MASKED = 0 { name = "Masked"; desc = "masked"; };
            ENABLED = 1 { name = "Enabled"; desc = "enabled"; };
        };

        field {
            name = "cc_int";
            desc = "Capture completion interrupt enable";
            sw = rw;
            hw = r;
            encode = DES_MASK_cc_int_enum;
            reset = 0x0;
        } cc_int[1:1];

        enum DES_MASK_fstart_enum {
            MASKED = 0 { name = "Masked"; desc = "masked"; };
            ENABLED = 1 { name = "Enabled"; desc = "enabled"; };
        };

        field {
            name = "fstart";
            desc = "Field/Frame start interrupt enable";
            sw = rw;
            hw = r;
            encode = DES_MASK_fstart_enum;
            reset = 0x0;
        } fstart[0:0];
    } DES_MASK @ 0x2F8;

    reg {
        name = "LINE_BUF control register";
        desc = "LINE_BUF_CFG is a LINE_BUF control register.

Data sheet 9.1.6 LINE_BUF_CFG (offset 0x500, printed page 9-50, `hi3518ev200--Hi3518EV20X-Hi3516CV200-Datasheet.txt` line 52485).";

        enum LINE_BUF_CFG_enable_f_enum {
            DISABLED = 0 { name = "Disabled"; desc = "disabled"; };
            ENABLED = 1 { name = "Enabled"; desc = "enabled"; };
        };

        field {
            name = "enable";
            desc = "LINE_BUF enable";
            sw = rw;
            hw = r;
            encode = LINE_BUF_CFG_enable_f_enum;
            reset = 0x0;
        } enable_f[31:31];

        enum LINE_BUF_CFG_vsync_mode_enum {
            BOTH_DATA_VSYNC = 0 { name = "Both Data Vsync"; desc = "Both data and the vsync signal are discarded during frame discarding."; };
            ONLY_DATA_DISCARDED = 1 { name = "Only Data Discarded"; desc = "Only data is discarded during frame discarding."; };
        };

        field {
            name = "vsync_mode";
            desc = "vsync_mode";
            sw = rw;
            hw = r;
            encode = LINE_BUF_CFG_vsync_mode_enum;
            reset = 0x0;
        } vsync_mode[0:0];
    } LINE_BUF_CFG @ 0x500;

    reg {
        name = "LINE_BUF updating register NEWER";
        desc = "LINE_BUF_REG_NEWER is a LINE_BUF update register.

Data sheet 9.1.6 LINE_BUF_REG_NEWER (offset 0x504, printed page 9-51, `hi3518ev200--Hi3518EV20X-Hi3516CV200-Datasheet.txt` line 52526).";

        field {
            name = "reg_newer";
            desc = "LINE_BUF update. This bit is automatically cleared for each frame.";
            sw = w;
            hw = r;
            reset = 0x0;
        } reg_newer[0:0];
    } LINE_BUF_REG_NEWER @ 0x504;

    reg {
        name = "LINE_BUF RX ID selection register FG";
        desc = "LINE_BUF_ID_CFG is a LINE_BUF RX ID selection register (instant register).

Data sheet 9.1.6 LINE_BUF_ID_CFG (offset 0x510, printed page 9-51, `hi3518ev200--Hi3518EV20X-Hi3516CV200-Datasheet.txt` line 52554).";

        enum LINE_BUF_ID_CFG_id_sel_enum {
            DATA_WITH_THIS = 0 { name = "Data With This"; desc = "Data with this ID is filtered."; };
            DATA_WITH_THIS_2 = 1 { name = "Data With This 2"; desc = "Data with this ID is received. bit[0]: LINE_BUF RX enable for data with the ID 0 bit[1]: LINE_BUF RX enable for data with the ID 1 bit[2]: LINE_BUF RX enable for data with the ID 2 bit[3]: LINE_BUF RX enable for data with the ID 3"; };
        };

        field {
            name = "id_sel";
            desc = "ID of the data received by the LINE_BUF";
            sw = rw;
            hw = r;
            encode = LINE_BUF_ID_CFG_id_sel_enum;
            reset = 0x0;
        } id_sel[3:0];
    } LINE_BUF_ID_CFG @ 0x510;

    reg {
        name = "Crop enable register P_CFG";
        desc = "LINE_BUF_CROP_CFG is a crop register.

Data sheet 9.1.6 LINE_BUF_CROP_CFG (offset 0x520, printed page 9-52, `hi3518ev200--Hi3518EV20X-Hi3516CV200-Datasheet.txt` line 52590).";

        enum LINE_BUF_CROP_CFG_n0_en_enum {
            DISABLED = 0 { name = "Disabled"; desc = "disabled"; };
            ENABLED = 1 { name = "Enabled"; desc = "enabled"; };
        };

        field {
            name = "n0_en";
            desc = "Region 0 enable";
            sw = rw;
            hw = r;
            encode = LINE_BUF_CROP_CFG_n0_en_enum;
            reset = 0x0;
        } n0_en[0:0];
    } LINE_BUF_CROP_CFG @ 0x520;

    reg {
        name = "Crop start position register for region 0 P0_START";
        desc = "LINE_BUF_CROP0_START is a crop start position register for region 0.

Data sheet 9.1.6 LINE_BUF_CROP0_START (offset 0x530, printed page 9-52, `hi3518ev200--Hi3518EV20X-Hi3516CV200-Datasheet.txt` line 52613).";

        field {
            name = "y_start";
            desc = "ID of the line from which pictures start to be captured";
            sw = rw;
            hw = r;
            reset = 0x0;
        } y_start[28:16];

        field {
            name = "x_start";
            desc = "ID of the pixel from which pictures start to be captured";
            sw = rw;
            hw = r;
            reset = 0x0;
        } x_start[12:0];
    } LINE_BUF_CROP0_START @ 0x530;

    reg {
        name = "Crop size configuration register for P0_SIZE region 0";
        desc = "LINE_BUF_CROP0_SIZE is a crop size configuration register for region 0.

Data sheet 9.1.6 LINE_BUF_CROP0_SIZE (offset 0x534, printed page 9-53, `hi3518ev200--Hi3518EV20X-Hi3516CV200-Datasheet.txt` line 52646).";

        field {
            name = "height";
            desc = "Height (in line) of the obtained picture. The configured value is the actual value minus 1.";
            sw = rw;
            hw = r;
            reset = 0x0;
        } height[28:16];

        field {
            name = "width";
            desc = "Width (in pixel) of the obtained picture. The configured value is the actual value minus 1.";
            sw = rw;
            hw = r;
            reset = 0x0;
        } width[12:0];
    } LINE_BUF_CROP0_SIZE @ 0x534;

    reg {
        name = "LINE_BUF picture width register TH";
        desc = "LINE_BUF_WIDTH is a LINE_BUF picture width register.

Data sheet 9.1.6 LINE_BUF_WIDTH (offset 0x550, printed page 9-53, `hi3518ev200--Hi3518EV20X-Hi3516CV200-Datasheet.txt` line 52674).";

        field {
            name = "line_buf_thd";
            desc = "Threshold for starting the LINE_BUF RAM read operation";
            sw = rw;
            hw = r;
            reset = 0x77F;
        } line_buf_thd[27:16];

        field {
            name = "line_buf_width";
            desc = "LINE_BUF picture width";
            sw = rw;
            hw = r;
            reset = 0x77F;
        } line_buf_width[11:0];
    } LINE_BUF_WIDTH @ 0x550;

    reg {
        name = "LINE_BUF picture height register HT";
        desc = "LINE_BUF_HEIGHT is a LINE_BUF picture height register.

Data sheet 9.1.6 LINE_BUF_HEIGHT (offset 0x554, printed page 9-54, `hi3518ev200--Hi3518EV20X-Hi3516CV200-Datasheet.txt` line 52705).";

        field {
            name = "line_buf_height";
            desc = "LINE_BUF picture height";
            sw = rw;
            hw = r;
            reset = 0x437;
        } line_buf_height[11:0];
    } LINE_BUF_HEIGHT @ 0x554;

    reg {
        name = "LINE_BUF raw interrupt register";
        desc = "LINE_BUF_INT is a LINE_BUF raw interrupt register.

Data sheet 9.1.6 LINE_BUF_INT (offset 0x5F0, printed page 9-54, `hi3518ev200--Hi3518EV20X-Hi3516CV200-Datasheet.txt` line 52724).";

        enum LINE_BUF_INT_update_cfg_enum {
            NO_INTERRUPT_GENERATED = 0 { name = "No Interrupt Generated"; desc = "No interrupt is generated."; };
            INTERRUPT_GENERATED = 1 { name = "Interrupt Generated"; desc = "An interrupt is generated."; };
        };

        field {
            name = "update_cfg";
            desc = "Status of the register update interrupt. Writing 1 clears the interrupt.";
            sw = rw;
            hw = w;
            onwrite = woclr;
            encode = LINE_BUF_INT_update_cfg_enum;
            reset = 0x0;
        } update_cfg[4:4];

        enum LINE_BUF_INT_field_throw_enum {
            NO_INTERRUPT_GENERATED = 0 { name = "No Interrupt Generated"; desc = "No interrupt is generated."; };
            INTERRUPT_GENERATED = 1 { name = "Interrupt Generated"; desc = "An interrupt is generated."; };
        };

        field {
            name = "field_throw";
            desc = "Status of the field/frame loss interrupt. Writing 1 clears the interrupt.";
            sw = rw;
            hw = w;
            onwrite = woclr;
            encode = LINE_BUF_INT_field_throw_enum;
            reset = 0x0;
        } field_throw[3:3];

        enum LINE_BUF_INT_fstart_enum {
            NO_INTERRUPT_GENERATED = 0 { name = "No Interrupt Generated"; desc = "No interrupt is generated."; };
            INTERRUPT_GENERATED = 1 { name = "Interrupt Generated"; desc = "An interrupt is generated."; };
        };

        field {
            name = "fstart";
            desc = "Status of the field/frame start interrupt. Writing 1 clears the interrupt.";
            sw = rw;
            hw = w;
            onwrite = woclr;
            encode = LINE_BUF_INT_fstart_enum;
            reset = 0x0;
        } fstart[0:0];
    } LINE_BUF_INT @ 0x5F0;

    reg {
        name = "LINE_BUF interrupt mask register K";
        desc = "LINE_BUF_MASK is a LINE_BUF interrupt mask register.

Data sheet 9.1.6 LINE_BUF_MASK (offset 0x5F8, printed page 9-55, `hi3518ev200--Hi3518EV20X-Hi3516CV200-Datasheet.txt` line 52777).";

        enum LINE_BUF_MASK_update_cfg_enum {
            NO_INTERRUPT_GENERATED = 0 { name = "No Interrupt Generated"; desc = "No interrupt is generated."; };
            INTERRUPT_GENERATED = 1 { name = "Interrupt Generated"; desc = "An interrupt is generated."; };
        };

        field {
            name = "update_cfg";
            desc = "Register update interrupt enable";
            sw = rw;
            hw = r;
            encode = LINE_BUF_MASK_update_cfg_enum;
            reset = 0x0;
        } update_cfg[4:4];

        enum LINE_BUF_MASK_field_throw_enum {
            MASKED = 0 { name = "Masked"; desc = "masked"; };
            ENABLED = 1 { name = "Enabled"; desc = "enabled"; };
        };

        field {
            name = "field_throw";
            desc = "Field/Frame loss interrupt enable";
            sw = rw;
            hw = r;
            encode = LINE_BUF_MASK_field_throw_enum;
            reset = 0x0;
        } field_throw[3:3];

        enum LINE_BUF_MASK_fstart_enum {
            MASKED = 0 { name = "Masked"; desc = "masked"; };
            ENABLED = 1 { name = "Enabled"; desc = "enabled"; };
        };

        field {
            name = "fstart";
            desc = "Field/Frame start interrupt enable";
            sw = rw;
            hw = r;
            encode = LINE_BUF_MASK_fstart_enum;
            reset = 0x0;
        } fstart[0:0];
    } LINE_BUF_MASK @ 0x5F8;

    reg {
        name = "SRC control register";
        desc = "SRC_CTRL is an SRC control register.

Data sheet 9.1.6 SRC_CTRL (offset 0x700, printed page 9-56, `hi3518ev200--Hi3518EV20X-Hi3516CV200-Datasheet.txt` line 52822).";

        enum SRC_CTRL_enable_f_enum {
            DISABLED = 0 { name = "Disabled"; desc = "disabled"; };
            ENABLED_0X700_0X7FF = 1 { name = "Enabled 0X700 0X7Ff"; desc = "enabled 0x700-0x7FF: address space of the SRC1 register"; };
        };

        field {
            name = "enable";
            desc = "SRC enable";
            sw = rw;
            hw = r;
            encode = SRC_CTRL_enable_f_enum;
            reset = 0x0;
        } enable_f[31:31];

        enum SRC_CTRL_bit_width_enum {
            V_8_BITS = 0x8 { name = "V 8 Bits"; desc = "8 bits"; };
            V_10_BITS = 0xA { name = "V 10 Bits"; desc = "10 bits"; };
            V_12_BITS = 0xC { name = "V 12 Bits"; desc = "12 bits"; };
            V_14_BITS = 0xE { name = "V 14 Bits"; desc = "14 bits"; };
            V_16_BITS_OTHER = 0x10 { name = "V 16 Bits Other"; desc = "16 bits Other values: reserved"; };
        };

        field {
            name = "bit_width";
            desc = "Data bit width";
            sw = rw;
            hw = r;
            encode = SRC_CTRL_bit_width_enum;
            reset = 0x0;
        } bit_width[5:0];
    } SRC_CTRL @ 0x700;

    reg {
        name = "Capture control register ER";
        desc = "SRC_REG_NEWER is a capture control register.

Data sheet 9.1.6 SRC_REG_NEWER (offset 0x704, printed page 9-56, `hi3518ev200--Hi3518EV20X-Hi3516CV200-Datasheet.txt` line 52855).";

        field {
            name = "reg_newer";
            desc = "SRC update. This bit is automatically cleared for each frame.";
            sw = rw;
            hw = r;
            reset = 0x0;
        } reg_newer[0:0];
    } SRC_REG_NEWER @ 0x704;

    reg {
        name = "SRC configuration register";
        desc = "SRC_CFG is a configuration register.

Data sheet 9.1.6 SRC_CFG (offset 0x770, printed page 9-57, `hi3518ev200--Hi3518EV20X-Hi3516CV200-Datasheet.txt` line 52887).";

        enum SRC_CFG_dcmp_en_enum {
            DISABLED = 0 { name = "Disabled"; desc = "disabled"; };
            ENABLED = 1 { name = "Enabled"; desc = "enabled"; };
        };

        field {
            name = "dcmp_en";
            desc = "SRC read channel frame compress enable";
            sw = rw;
            hw = r;
            encode = SRC_CFG_dcmp_en_enum;
            reset = 0x0;
        } dcmp_en[31:31];

        field {
            name = "k_coef_range";
            desc = "Frame compression rate of the SRC channel. The value range is [7:12]. The configuration during decompression must be the same as the that during data compression. The typical value is the bit width minus 1. The configured value is 12 when the bit width is 14 bits.";
            sw = rw;
            hw = r;
            reset = 0x0;
        } k_coef_range[30:27];
    } SRC_CFG @ 0x770;

    reg {
        name = "SRC storage size register";
        desc = "SRC_SIZE is an SRC storage size register.

Data sheet 9.1.6 SRC_SIZE (offset 0x784, printed page 9-57, `hi3518ev200--Hi3518EV20X-Hi3516CV200-Datasheet.txt` line 52920).";

        field {
            name = "height";
            desc = "Height (in line) of the stored picture. The configured value is the actual value minus 1.";
            sw = rw;
            hw = r;
            reset = 0x0;
        } height[28:16];

        field {
            name = "width";
            desc = "Width (in pixel) of the stored picture. The configured value is the actual value minus 1.";
            sw = rw;
            hw = r;
            reset = 0x0;
        } width[12:0];
    } SRC_SIZE @ 0x784;

    reg {
        name = "SRC storage base address register";
        desc = "SRC_FADDR is an SRC storage base address register.

Data sheet 9.1.6 SRC_FADDR (offset 0x790, printed page 9-58, `hi3518ev200--Hi3518EV20X-Hi3516CV200-Datasheet.txt` line 52958).";

        field {
            name = "faddr";
            desc = "SRC storage base address";
            sw = rw;
            hw = r;
            reset = 0x0;
        } faddr[31:0];
    } SRC_FADDR @ 0x790;

    reg {
        name = "SRC storage line stride register";
        desc = "SRC_STRIDE is an SRC storage line stride register.

Data sheet 9.1.6 SRC_STRIDE (offset 0x794, printed page 9-58, `hi3518ev200--Hi3518EV20X-Hi3516CV200-Datasheet.txt` line 52977).";

        field {
            name = "stride";
            desc = "Line stride for the SRC channel frame";
            sw = rw;
            hw = r;
            reset = 0x0;
        } stride[15:0];
    } SRC_STRIDE @ 0x794;

    reg {
        name = "SRC bus buffer control register";
        desc = "SRC_BUF_CFG is an SRC bus buffer control register.

Data sheet 9.1.6 SRC_BUF_CFG (offset 0x79C, printed page 9-59, `hi3518ev200--Hi3518EV20X-Hi3516CV200-Datasheet.txt` line 53006).";

        field {
            name = "buf_thd";
            desc = "Depth of the bus buffer";
            sw = rw;
            hw = r;
            reset = 0x80;
        } buf_thd[15:0];
    } SRC_BUF_CFG @ 0x79C;

    reg {
        name = "SRC raw interrupt register";
        desc = "SRC_INT is an SRC raw interrupt register.

Data sheet 9.1.6 SRC_INT (offset 0x7F0, printed page 9-59, `hi3518ev200--Hi3518EV20X-Hi3516CV200-Datasheet.txt` line 53025).";

        enum SRC_INT_dcmp_wrong_enum {
            NO_INTERRUPT_GENERATED = 0 { name = "No Interrupt Generated"; desc = "No interrupt is generated."; };
            INTERRUPT_GENERATED = 1 { name = "Interrupt Generated"; desc = "An interrupt is generated."; };
        };

        field {
            name = "dcmp_wrong";
            desc = "Status of the decompress error interrupt. Writing 1 clears the interrupt.";
            sw = rw;
            hw = w;
            onwrite = woclr;
            encode = SRC_INT_dcmp_wrong_enum;
            reset = 0x0;
        } dcmp_wrong[5:5];

        enum SRC_INT_update_cfg_enum {
            NO_INTERRUPT_GENERATED = 0 { name = "No Interrupt Generated"; desc = "No interrupt is generated."; };
            INTERRUPT_GENERATED = 1 { name = "Interrupt Generated"; desc = "An interrupt is generated."; };
        };

        field {
            name = "update_cfg";
            desc = "Status of the register update interrupt. Writing 1 clears the interrupt.";
            sw = rw;
            hw = w;
            onwrite = woclr;
            encode = SRC_INT_update_cfg_enum;
            reset = 0x0;
        } update_cfg[4:4];

        enum SRC_INT_field_throw_enum {
            NO_INTERRUPT_GENERATED = 0 { name = "No Interrupt Generated"; desc = "No interrupt is generated."; };
            INTERRUPT_GENERATED = 1 { name = "Interrupt Generated"; desc = "An interrupt is generated."; };
        };

        field {
            name = "field_throw";
            desc = "Status of the field/frame loss interrupt. Writing 1 clears the interrupt.";
            sw = rw;
            hw = w;
            onwrite = woclr;
            encode = SRC_INT_field_throw_enum;
            reset = 0x0;
        } field_throw[3:3];

        enum SRC_INT_buf_ovf_enum {
            NO_INTERRUPT_GENERATED = 0 { name = "No Interrupt Generated"; desc = "No interrupt is generated."; };
            INTERRUPT_GENERATED = 1 { name = "Interrupt Generated"; desc = "An interrupt is generated."; };
        };

        field {
            name = "buf_ovf";
            desc = "Status of the internal FIFO overflow error interrupt. Writing 1 clears the interrupt.";
            sw = rw;
            hw = w;
            onwrite = woclr;
            encode = SRC_INT_buf_ovf_enum;
            reset = 0x0;
        } buf_ovf[2:2];

        enum SRC_INT_cc_int_enum {
            NO_INTERRUPT_GENERATED = 0 { name = "No Interrupt Generated"; desc = "No interrupt is generated."; };
            INTERRUPT_GENERATED = 1 { name = "Interrupt Generated"; desc = "An interrupt is generated."; };
        };

        field {
            name = "cc_int";
            desc = "Status of the capture completion interrupt. Writing 1 clears the interrupt.";
            sw = rw;
            hw = w;
            onwrite = woclr;
            encode = SRC_INT_cc_int_enum;
            reset = 0x0;
        } cc_int[1:1];

        enum SRC_INT_fstart_enum {
            NO_INTERRUPT_GENERATED = 0 { name = "No Interrupt Generated"; desc = "No interrupt is generated."; };
            INTERRUPT_GENERATED = 1 { name = "Interrupt Generated"; desc = "An interrupt is generated."; };
        };

        field {
            name = "fstart";
            desc = "Status of the field/frame start interrupt. Writing 1 clears the interrupt.";
            sw = rw;
            hw = w;
            onwrite = woclr;
            encode = SRC_INT_fstart_enum;
            reset = 0x0;
        } fstart[0:0];
    } SRC_INT @ 0x7F0;

    reg {
        name = "SRC interrupt mask register";
        desc = "SRC_MASK is an SRC interrupt mask register.

Data sheet 9.1.6 SRC_MASK (offset 0x7F8, printed page 9-60, `hi3518ev200--Hi3518EV20X-Hi3516CV200-Datasheet.txt` line 53091).";

        enum SRC_MASK_dcmp_wrong_enum {
            NO_INTERRUPT_GENERATED = 0 { name = "No Interrupt Generated"; desc = "No interrupt is generated."; };
            INTERRUPT_GENERATED = 1 { name = "Interrupt Generated"; desc = "An interrupt is generated."; };
        };

        field {
            name = "dcmp_wrong";
            desc = "Decompress error interrupt enable";
            sw = rw;
            hw = r;
            encode = SRC_MASK_dcmp_wrong_enum;
            reset = 0x0;
        } dcmp_wrong[5:5];

        enum SRC_MASK_update_cfg_enum {
            NO_INTERRUPT_GENERATED = 0 { name = "No Interrupt Generated"; desc = "No interrupt is generated."; };
            INTERRUPT_GENERATED = 1 { name = "Interrupt Generated"; desc = "An interrupt is generated."; };
        };

        field {
            name = "update_cfg";
            desc = "Register update interrupt enable";
            sw = rw;
            hw = r;
            encode = SRC_MASK_update_cfg_enum;
            reset = 0x0;
        } update_cfg[4:4];

        enum SRC_MASK_field_throw_enum {
            MASKED = 0 { name = "Masked"; desc = "masked"; };
            ENABLED = 1 { name = "Enabled"; desc = "enabled"; };
        };

        field {
            name = "field_throw";
            desc = "Field/Frame loss interrupt enable";
            sw = rw;
            hw = r;
            encode = SRC_MASK_field_throw_enum;
            reset = 0x0;
        } field_throw[3:3];

        enum SRC_MASK_buf_ovf_enum {
            MASKED = 0 { name = "Masked"; desc = "masked"; };
            ENABLED = 1 { name = "Enabled"; desc = "enabled"; };
        };

        field {
            name = "buf_ovf";
            desc = "Internal FIFO overflow error interrupt enable";
            sw = rw;
            hw = r;
            encode = SRC_MASK_buf_ovf_enum;
            reset = 0x0;
        } buf_ovf[2:2];

        enum SRC_MASK_cc_int_enum {
            MASKED = 0 { name = "Masked"; desc = "masked"; };
            ENABLED = 1 { name = "Enabled"; desc = "enabled"; };
        };

        field {
            name = "cc_int";
            desc = "Capture completion interrupt enable";
            sw = rw;
            hw = r;
            encode = SRC_MASK_cc_int_enum;
            reset = 0x0;
        } cc_int[1:1];

        enum SRC_MASK_fstart_enum {
            MASKED = 0 { name = "Masked"; desc = "masked"; };
            ENABLED = 1 { name = "Enabled"; desc = "enabled"; };
        };

        field {
            name = "fstart";
            desc = "Field/Frame start interrupt enable";
            sw = rw;
            hw = r;
            encode = SRC_MASK_fstart_enum;
            reset = 0x0;
        } fstart[0:0];
    } SRC_MASK @ 0x7F8;

    reg {
        name = "Capture control register R";
        desc = "CH_REG_NEWER is a capture control register.

Data sheet 9.1.6 CH_REG_NEWER (offset 0x1004, printed page 9-61, `hi3518ev200--Hi3518EV20X-Hi3516CV200-Datasheet.txt` line 53143).";

        field {
            name = "reg_newer";
            desc = "Channel update. This bit is automatically cleared for each frame.";
            sw = rw;
            hw = r;
            reset = 0x0;
        } reg_newer[0:0];
    } CH_REG_NEWER @ 0x1004;

    reg {
        name = "Timing adaptation register FG";
        desc = "CH_ADAPTER_CFG is a timing adaptation register.

Data sheet 9.1.6 CH_ADAPTER_CFG (offset 0x1010, printed page 9-61, `hi3518ev200--Hi3518EV20X-Hi3516CV200-Datasheet.txt` line 53168).";

        enum CH_ADAPTER_CFG_vsync_mode_enum {
            NOT_PROCESSED = 0 { name = "Not Processed"; desc = "not processed"; };
            PROCESSED = 1 { name = "Processed"; desc = "processed"; };
        };

        field {
            name = "vsync_mode";
            desc = "Whether to perform delay processing on the vsync signal The delay processing is performed on the vsync signal only when both sharpen and uvnr are enabled.";
            sw = rw;
            hw = r;
            encode = CH_ADAPTER_CFG_vsync_mode_enum;
            reset = 0x0;
        } vsync_mode[1:1];

        enum CH_ADAPTER_CFG_hsync_mode_enum {
            NOT_PROCESSED = 0 { name = "Not Processed"; desc = "not processed"; };
            PROCESSED = 1 { name = "Processed"; desc = "processed"; };
        };

        field {
            name = "hsync_mode";
            desc = "Whether to perform delay processing on the hsync signal";
            sw = rw;
            hw = r;
            encode = CH_ADAPTER_CFG_hsync_mode_enum;
            reset = 0x0;
        } hsync_mode[0:0];
    } CH_ADAPTER_CFG @ 0x1010;

    reg {
        name = "Y component configuration register for G the WCH module";
        desc = "CH_WCH_Y_CFG is a Y component configuration register for the WCH module.

Data sheet 9.1.6 CH_WCH_Y_CFG (offset 0x1080, printed page 9-62, `hi3518ev200--Hi3518EV20X-Hi3516CV200-Datasheet.txt` line 53212).";

        enum CH_WCH_Y_CFG_enable_f_enum {
            DISABLED = 0 { name = "Disabled"; desc = "disabled"; };
            ENABLED = 1 { name = "Enabled"; desc = "enabled"; };
        };

        field {
            name = "enable";
            desc = "CH write channel enable";
            sw = rw;
            hw = r;
            encode = CH_WCH_Y_CFG_enable_f_enum;
            reset = 0x0;
        } enable_f[31:31];

        enum CH_WCH_Y_CFG_interleave_enum {
            OUTPUT_DATA_PROGRESSIVE = 0 { name = "Output Data Progressive"; desc = "The output data is progressive or interlaced and does not need to be interleaved as frames for storing."; };
            OUTPUT_DATA_INTERLACED = 1 { name = "Output Data Interlaced"; desc = "The output data interlaced and needs to be interleaved as frames for storing."; };
        };

        field {
            name = "interleave";
            desc = "Progressive/Interlaced flag";
            sw = rw;
            hw = r;
            encode = CH_WCH_Y_CFG_interleave_enum;
            reset = 0x0;
        } interleave[19:19];

        enum CH_WCH_Y_CFG_bfield_enum {
            TOP_FIELD = 0 { name = "Top Field"; desc = "top field"; };
            BOTTOM_FIELD = 1 { name = "Bottom Field"; desc = "bottom field"; };
        };

        field {
            name = "bfield";
            desc = "Top/Bottom field flag. This field is used when the output data interlaced and needs to be interleaved as frames for storing.";
            sw = rw;
            hw = r;
            encode = CH_WCH_Y_CFG_bfield_enum;
            reset = 0x0;
        } bfield[18:18];

        enum CH_WCH_Y_CFG_bit_width_enum {
            V_8_BITS = 0 { name = "V 8 Bits"; desc = "8 bits"; };
            V_16_BITS_OTHER = 2 { name = "V 16 Bits Other"; desc = "16 bits Other values: reserved"; };
        };

        field {
            name = "bit_width";
            desc = "Data width";
            sw = rw;
            hw = r;
            encode = CH_WCH_Y_CFG_bit_width_enum;
            reset = 0x0;
        } bit_width[17:16];

        enum CH_WCH_Y_CFG_flip_enum {
            DISABLED = 0 { name = "Disabled"; desc = "disabled"; };
            ENABLED = 1 { name = "Enabled"; desc = "enabled"; };
        };

        field {
            name = "flip";
            desc = "Channel flip enable";
            sw = rw;
            hw = r;
            encode = CH_WCH_Y_CFG_flip_enum;
            reset = 0x0;
        } flip[4:4];

        enum CH_WCH_Y_CFG_mirror_enum {
            DISABLED = 0 { name = "Disabled"; desc = "disabled"; };
            ENABLED = 1 { name = "Enabled"; desc = "enabled"; };
        };

        field {
            name = "mirror";
            desc = "Channel mirror enable";
            sw = rw;
            hw = r;
            encode = CH_WCH_Y_CFG_mirror_enum;
            reset = 0x0;
        } mirror[3:3];

        enum CH_WCH_Y_CFG_head_tword_enum {
            V_128_BITS = 0 { name = "V 128 Bits"; desc = "128 bits (128 bits/line)"; };
            V_256_BITS = 1 { name = "V 256 Bits"; desc = "256 bits (256 bits/line)"; };
        };

        field {
            name = "head_tword";
            desc = "Header information stride";
            sw = rw;
            hw = r;
            encode = CH_WCH_Y_CFG_head_tword_enum;
            reset = 0x0;
        } head_tword[2:2];

        enum CH_WCH_Y_CFG_cmp_mode_enum {
            V_128_PIXELS = 0 { name = "V 128 Pixels"; desc = "128 pixels"; };
            V_256_PIXELS = 1 { name = "V 256 Pixels"; desc = "256 pixels"; };
        };

        field {
            name = "cmp_mode";
            desc = "Compressed segment length";
            sw = rw;
            hw = r;
            encode = CH_WCH_Y_CFG_cmp_mode_enum;
            reset = 0x1;
        } cmp_mode[1:1];

        enum CH_WCH_Y_CFG_cmp_en_enum {
            DISABLED = 0 { name = "Disabled"; desc = "disabled"; };
            ENABLED = 1 { name = "Enabled"; desc = "enabled"; };
        };

        field {
            name = "cmp_en";
            desc = "Compression enable";
            sw = rw;
            hw = r;
            encode = CH_WCH_Y_CFG_cmp_en_enum;
            reset = 0x0;
        } cmp_en[0:0];
    } CH_WCH_Y_CFG @ 0x1080;

    reg {
        name = "Y component storage size register for E the WCH module";
        desc = "CH_WCH_Y_SIZE is a Y component storage size register for the WCH module.

Data sheet 9.1.6 CH_WCH_Y_SIZE (offset 0x1084, printed page 9-63, `hi3518ev200--Hi3518EV20X-Hi3516CV200-Datasheet.txt` line 53281).";

        field {
            name = "height";
            desc = "Height (in line) of the stored picture. The configured value is the actual value minus 1.";
            sw = rw;
            hw = r;
            reset = 0x0;
        } height[28:16];

        field {
            name = "width";
            desc = "Width (in pixel) of the stored picture. The configured value is the actual value minus 1.";
            sw = rw;
            hw = r;
            reset = 0x0;
        } width[12:0];
    } CH_WCH_Y_SIZE @ 0x1084;

    reg {
        name = "Y component storage base address DDR register for the WCH module";
        desc = "CH_WCH_Y_FADDR is a Y component storage base address register for the WCH module.

Data sheet 9.1.6 CH_WCH_Y_FADDR (offset 0x1090, printed page 9-64, `hi3518ev200--Hi3518EV20X-Hi3516CV200-Datasheet.txt` line 53315).";

        field {
            name = "faddr";
            desc = "Base address for storing the Y component";
            sw = rw;
            hw = r;
            reset = 0x0;
        } faddr[31:0];
    } CH_WCH_Y_FADDR @ 0x1090;

    reg {
        name = "Y component header information DDR storage base address register for the WCH module";
        desc = "CH_WCH_Y_HADDR is a Y component header information storage base address register for the WCH module.

Data sheet 9.1.6 CH_WCH_Y_HADDR (offset 0x1094, printed page 9-64, `hi3518ev200--Hi3518EV20X-Hi3516CV200-Datasheet.txt` line 53335).";

        field {
            name = "haddr";
            desc = "Base address for storing the Y component header information";
            sw = rw;
            hw = r;
            reset = 0x0;
        } haddr[31:0];
    } CH_WCH_Y_HADDR @ 0x1094;

    reg {
        name = "Y component line offset register for RIDE the WCH module";
        desc = "CH_WCH_Y_STRIDE is a Y component line offset register for the WCH module.

Data sheet 9.1.6 CH_WCH_Y_STRIDE (offset 0x1098, printed page 9-64, `hi3518ev200--Hi3518EV20X-Hi3516CV200-Datasheet.txt` line 53353).";

        field {
            name = "stride";
            desc = "Stride (in byte) for storing the Y component";
            sw = rw;
            hw = r;
            reset = 0x0;
        } stride[15:0];
    } CH_WCH_Y_STRIDE @ 0x1098;

    reg {
        name = "C component configuration register for G the WCH module";
        desc = "CH_WCH_C_CFG is a C component configuration register for the WCH module.

Data sheet 9.1.6 CH_WCH_C_CFG (offset 0x10A0, printed page 9-65, `hi3518ev200--Hi3518EV20X-Hi3516CV200-Datasheet.txt` line 53382).";

        enum CH_WCH_C_CFG_enable_f_enum {
            DISABLED = 0 { name = "Disabled"; desc = "disabled"; };
            ENABLED = 1 { name = "Enabled"; desc = "enabled"; };
        };

        field {
            name = "enable";
            desc = "CH write channel enable";
            sw = rw;
            hw = r;
            encode = CH_WCH_C_CFG_enable_f_enum;
            reset = 0x0;
        } enable_f[31:31];

        enum CH_WCH_C_CFG_interleave_enum {
            OUTPUT_DATA_PROGRESSIVE = 0 { name = "Output Data Progressive"; desc = "The output data is progressive or interlaced and does not need to be interleaved as frames for storing."; };
            OUTPUT_DATA_INTERLACED = 1 { name = "Output Data Interlaced"; desc = "The output data interlaced and needs to be interleaved as frames for storing."; };
        };

        field {
            name = "interleave";
            desc = "Progressive/Interlaced flag";
            sw = rw;
            hw = r;
            encode = CH_WCH_C_CFG_interleave_enum;
            reset = 0x0;
        } interleave[19:19];

        enum CH_WCH_C_CFG_bfield_enum {
            TOP_FIELD = 0 { name = "Top Field"; desc = "top field"; };
            BOTTOM_FIELD = 1 { name = "Bottom Field"; desc = "bottom field"; };
        };

        field {
            name = "bfield";
            desc = "Top/Bottom field flag. This field is used when the output data interlaced and needs to be interleaved as frames for storing.";
            sw = rw;
            hw = r;
            encode = CH_WCH_C_CFG_bfield_enum;
            reset = 0x0;
        } bfield[18:18];

        enum CH_WCH_C_CFG_bit_width_enum {
            V_8_BITS = 0 { name = "V 8 Bits"; desc = "8 bits"; };
            V_16_BITS_OTHER = 2 { name = "V 16 Bits Other"; desc = "16 bits Other values: reserved"; };
        };

        field {
            name = "bit_width";
            desc = "Data width";
            sw = rw;
            hw = r;
            encode = CH_WCH_C_CFG_bit_width_enum;
            reset = 0x0;
        } bit_width[17:16];

        enum CH_WCH_C_CFG_flip_enum {
            DISABLED = 0 { name = "Disabled"; desc = "disabled"; };
            ENABLED = 1 { name = "Enabled"; desc = "enabled"; };
        };

        field {
            name = "flip";
            desc = "Channel flip enable";
            sw = rw;
            hw = r;
            encode = CH_WCH_C_CFG_flip_enum;
            reset = 0x0;
        } flip[4:4];

        enum CH_WCH_C_CFG_mirror_enum {
            DISABLED = 0 { name = "Disabled"; desc = "disabled"; };
            ENABLED = 1 { name = "Enabled"; desc = "enabled"; };
        };

        field {
            name = "mirror";
            desc = "Channel mirror enable";
            sw = rw;
            hw = r;
            encode = CH_WCH_C_CFG_mirror_enum;
            reset = 0x0;
        } mirror[3:3];

        enum CH_WCH_C_CFG_head_tword_enum {
            V_128_BITS = 0 { name = "V 128 Bits"; desc = "128 bits (128 bits/line)"; };
            V_256_BITS = 1 { name = "V 256 Bits"; desc = "256 bits (256 bits/line)"; };
        };

        field {
            name = "head_tword";
            desc = "Header information stride";
            sw = rw;
            hw = r;
            encode = CH_WCH_C_CFG_head_tword_enum;
            reset = 0x0;
        } head_tword[2:2];

        enum CH_WCH_C_CFG_cmp_mode_enum {
            V_128_PIXELS = 0 { name = "V 128 Pixels"; desc = "128 pixels"; };
            V_256_PIXELS = 1 { name = "V 256 Pixels"; desc = "256 pixels"; };
        };

        field {
            name = "cmp_mode";
            desc = "Compressed segment length";
            sw = rw;
            hw = r;
            encode = CH_WCH_C_CFG_cmp_mode_enum;
            reset = 0x1;
        } cmp_mode[1:1];

        enum CH_WCH_C_CFG_cmp_en_enum {
            DISABLED = 0 { name = "Disabled"; desc = "disabled"; };
            ENABLED = 1 { name = "Enabled"; desc = "enabled"; };
        };

        field {
            name = "cmp_en";
            desc = "Compression enable";
            sw = rw;
            hw = r;
            encode = CH_WCH_C_CFG_cmp_en_enum;
            reset = 0x0;
        } cmp_en[0:0];
    } CH_WCH_C_CFG @ 0x10A0;

    reg {
        name = "C component storage size register for E the WCH module";
        desc = "CH_WCH_C_SIZE is a C component storage size register for the WCH module.

Data sheet 9.1.6 CH_WCH_C_SIZE (offset 0x10A4, printed page 9-66, `hi3518ev200--Hi3518EV20X-Hi3516CV200-Datasheet.txt` line 53450).";

        field {
            name = "height";
            desc = "Height (in line) of the stored picture. The configured value is the actual value minus 1.";
            sw = rw;
            hw = r;
            reset = 0x0;
        } height[28:16];

        field {
            name = "width";
            desc = "Width (in pixel) of the stored picture. The configured value is the actual value minus 1.";
            sw = rw;
            hw = r;
            reset = 0x0;
        } width[12:0];
    } CH_WCH_C_SIZE @ 0x10A4;

    reg {
        name = "C component storage base address DDR register for the WCH module";
        desc = "CH_WCH_C_FADDR is a C component storage base address register for the WCH module.

Data sheet 9.1.6 CH_WCH_C_FADDR (offset 0x10B0, printed page 9-67, `hi3518ev200--Hi3518EV20X-Hi3516CV200-Datasheet.txt` line 53488).";

        field {
            name = "faddr";
            desc = "Base address for storing the C component";
            sw = rw;
            hw = r;
            reset = 0x0;
        } faddr[31:0];
    } CH_WCH_C_FADDR @ 0x10B0;

    reg {
        name = "C component header information DDR storage base address register for the WCH module";
        desc = "CH_WCH_C_HADDR is a C component header information storage base address register for the WCH module.

Data sheet 9.1.6 CH_WCH_C_HADDR (offset 0x10B4, printed page 9-67, `hi3518ev200--Hi3518EV20X-Hi3516CV200-Datasheet.txt` line 53507).";

        field {
            name = "haddr";
            desc = "Base address for storing the C component header information";
            sw = rw;
            hw = r;
            reset = 0x0;
        } haddr[31:0];
    } CH_WCH_C_HADDR @ 0x10B4;

    reg {
        name = "C component line offset register for the IDE WCH module";
        desc = "CH_WCH_C_STRIDE is a C component line offset register for the WCH module.

Data sheet 9.1.6 CH_WCH_C_STRIDE (offset 0x10B8, printed page 9-67, `hi3518ev200--Hi3518EV20X-Hi3516CV200-Datasheet.txt` line 53525).";

        field {
            name = "stride";
            desc = "Stride (in byte) for storing the C component";
            sw = rw;
            hw = r;
            reset = 0x0;
        } stride[15:0];
    } CH_WCH_C_STRIDE @ 0x10B8;

    reg {
        name = "Channel raw interrupt register";
        desc = "CH_INT is a channel raw interrupt register.

Data sheet 9.1.6 CH_INT (offset 0x10F0, printed page 9-68, `hi3518ev200--Hi3518EV20X-Hi3516CV200-Datasheet.txt` line 53551).";

        enum CH_INT_fstart_dly_enum {
            NO_INTERRUPT_GENERATED = 0 { name = "No Interrupt Generated"; desc = "No interrupt is generated."; };
            INTERRUPT_GENERATED = 1 { name = "Interrupt Generated"; desc = "An interrupt is generated."; };
        };

        field {
            name = "fstart_dly";
            desc = "Status of the delayed field/frame start interrupt. Writing 1 clears the interrupt.";
            sw = rw;
            hw = w;
            onwrite = woclr;
            encode = CH_INT_fstart_dly_enum;
            reset = 0x0;
        } fstart_dly[15:15];

        enum CH_INT_update_cfg_enum {
            NO_INTERRUPT_GENERATED = 0 { name = "No Interrupt Generated"; desc = "No interrupt is generated."; };
            INTERRUPT_GENERATED = 1 { name = "Interrupt Generated"; desc = "An interrupt is generated."; };
        };

        field {
            name = "update_cfg";
            desc = "Status of the register update interrupt. Writing 1 clears the interrupt.";
            sw = rw;
            hw = w;
            onwrite = woclr;
            encode = CH_INT_update_cfg_enum;
            reset = 0x0;
        } update_cfg[4:4];

        enum CH_INT_field_throw_enum {
            NO_INTERRUPT_GENERATED = 0 { name = "No Interrupt Generated"; desc = "No interrupt is generated."; };
            INTERRUPT_GENERATED = 1 { name = "Interrupt Generated"; desc = "An interrupt is generated."; };
        };

        field {
            name = "field_throw";
            desc = "Status of the field/frame loss interrupt. Writing 1 clears the interrupt.";
            sw = rw;
            hw = w;
            onwrite = woclr;
            encode = CH_INT_field_throw_enum;
            reset = 0x0;
        } field_throw[3:3];

        enum CH_INT_buf_ovf_enum {
            NO_INTERRUPT_GENERATED = 0 { name = "No Interrupt Generated"; desc = "No interrupt is generated."; };
            INTERRUPT_GENERATED = 1 { name = "Interrupt Generated"; desc = "An interrupt is generated."; };
        };

        field {
            name = "buf_ovf";
            desc = "Status of the internal FIFO overflow error interrupt. Writing 1 clears the interrupt.";
            sw = rw;
            hw = w;
            onwrite = woclr;
            encode = CH_INT_buf_ovf_enum;
            reset = 0x0;
        } buf_ovf[2:2];

        enum CH_INT_cc_int_enum {
            NO_INTERRUPT_GENERATED = 0 { name = "No Interrupt Generated"; desc = "No interrupt is generated."; };
            INTERRUPT_GENERATED = 1 { name = "Interrupt Generated"; desc = "An interrupt is generated."; };
        };

        field {
            name = "cc_int";
            desc = "Status of the capture completion interrupt. Writing 1 clears the interrupt.";
            sw = rw;
            hw = w;
            onwrite = woclr;
            encode = CH_INT_cc_int_enum;
            reset = 0x0;
        } cc_int[1:1];

        enum CH_INT_fstart_enum {
            NO_INTERRUPT_GENERATED = 0 { name = "No Interrupt Generated"; desc = "No interrupt is generated."; };
            INTERRUPT_GENERATED = 1 { name = "Interrupt Generated"; desc = "An interrupt is generated."; };
        };

        field {
            name = "fstart";
            desc = "Status of the field/frame start interrupt. Writing 1 clears the interrupt.";
            sw = rw;
            hw = w;
            onwrite = woclr;
            encode = CH_INT_fstart_enum;
            reset = 0x0;
        } fstart[0:0];
    } CH_INT @ 0x10F0;

    reg {
        name = "Channel interrupt mask register";
        desc = "CH_INT_MASK is a channel interrupt mask register.

Data sheet 9.1.6 CH_INT_MASK (offset 0x10F8, printed page 9-69, `hi3518ev200--Hi3518EV20X-Hi3516CV200-Datasheet.txt` line 53613).";

        enum CH_INT_MASK_fstart_dly_enum {
            NO_INTERRUPT_GENERATED = 0 { name = "No Interrupt Generated"; desc = "No interrupt is generated."; };
            INTERRUPT_GENERATED = 1 { name = "Interrupt Generated"; desc = "An interrupt is generated."; };
        };

        field {
            name = "fstart_dly";
            desc = "Delayed field/frame start interrupt enable";
            sw = rw;
            hw = r;
            encode = CH_INT_MASK_fstart_dly_enum;
            reset = 0x0;
        } fstart_dly[15:15];

        enum CH_INT_MASK_update_cfg_enum {
            NO_INTERRUPT_GENERATED = 0 { name = "No Interrupt Generated"; desc = "No interrupt is generated."; };
            INTERRUPT_GENERATED = 1 { name = "Interrupt Generated"; desc = "An interrupt is generated."; };
        };

        field {
            name = "update_cfg";
            desc = "Register update interrupt enable";
            sw = rw;
            hw = r;
            encode = CH_INT_MASK_update_cfg_enum;
            reset = 0x0;
        } update_cfg[4:4];

        enum CH_INT_MASK_field_throw_enum {
            MASKED = 0 { name = "Masked"; desc = "masked"; };
            ENABLED = 1 { name = "Enabled"; desc = "enabled"; };
        };

        field {
            name = "field_throw";
            desc = "Field/Frame loss interrupt enable";
            sw = rw;
            hw = r;
            encode = CH_INT_MASK_field_throw_enum;
            reset = 0x0;
        } field_throw[3:3];

        enum CH_INT_MASK_buf_ovf_enum {
            MASKED = 0 { name = "Masked"; desc = "masked"; };
            ENABLED = 1 { name = "Enabled"; desc = "enabled"; };
        };

        field {
            name = "buf_ovf";
            desc = "Internal FIFO overflow error interrupt enable";
            sw = rw;
            hw = r;
            encode = CH_INT_MASK_buf_ovf_enum;
            reset = 0x0;
        } buf_ovf[2:2];

        enum CH_INT_MASK_cc_int_enum {
            MASKED = 0 { name = "Masked"; desc = "masked"; };
            ENABLED = 1 { name = "Enabled"; desc = "enabled"; };
        };

        field {
            name = "cc_int";
            desc = "Capture completion interrupt enable";
            sw = rw;
            hw = r;
            encode = CH_INT_MASK_cc_int_enum;
            reset = 0x0;
        } cc_int[1:1];

        enum CH_INT_MASK_fstart_enum {
            MASKED = 0 { name = "Masked"; desc = "masked"; };
            ENABLED = 1 { name = "Enabled"; desc = "enabled"; };
        };

        field {
            name = "fstart";
            desc = "Field/Frame start interrupt enable";
            sw = rw;
            hw = r;
            encode = CH_INT_MASK_fstart_enum;
            reset = 0x0;
        } fstart[0:0];
    } CH_INT_MASK @ 0x10F8;
};

`endif
