`ifndef HI3516EV200_DDR_RDL
`define HI3516EV200_DDR_RDL

`ifndef HI3516EV200_DDR_AXI_RDL
`define HI3516EV200_DDR_AXI_RDL

regfile eDDR_AXI_EV200 {
    name = "DDR AXI/QoS switch (window 0x120D0000), Hi3516E V200";
    desc = "Only registers named by the vendor U-Boot DDR trainer headers are listed. Confidence legend (no hardware was read for this block): PROVEN = offset and bits are used by vendor source code or by the vendor boot binary (Xiongmai stock U-Boot of a Hi3516E V200 camera) exactly as described; INFERRED = deduced from naming, from sibling chips or from a value without a bit map; GUESS = plausible only.";

    reg {
        name = "AXI region 0 attributes (channel mode)";
        desc = "AXI_REGION_ATTRIB0 - AXI region 0 attributes (channel mode). Confidence **PROVEN**. Evidence: cijliu-uboot drivers/ddr/hisilicon/default/ddr_ddrc_v520.h DDR_AXI_REGION_ATTRIB0 (0x104), channel field [3:0] cleared by the trainer (AXI_REGION_ATTRIB_CH_MASK 0xFFFFFFF0); values 0..3 select the DMC channel start (AXI_RNG_ATTR_CH_START_n), 4 = channel mode. Hardware not read; reset values unknown.";
        field { name = "region_ch"; desc = "Channel / interleave select of address region 0. [PROVEN]"; sw = rw; hw = r; } region_ch[3:0];
    } AXI_REGION_ATTRIB0 @ 0x104;

    reg {
        name = "AXI region 1 attributes (channel mode)";
        desc = "AXI_REGION_ATTRIB1 - AXI region 1 attributes (channel mode). Confidence **PROVEN**. Evidence: ddr_ddrc_v520.h DDR_AXI_REGION_ATTRIB1 (0x114). Hardware not read; reset values unknown.";
        field { name = "region_ch"; desc = "Channel / interleave select of address region 1. [PROVEN]"; sw = rw; hw = r; } region_ch[3:0];
    } AXI_REGION_ATTRIB1 @ 0x114;

    reg {
        name = "AXI/QoS register 0x410C (vendor boot value 0xB)";
        desc = "AXI_QOS_410C - AXI/QoS register 0x410C (vendor boot value 0xB). Confidence **INFERRED**. Evidence: Written 0x0000000B by the vendor boot table and by sys_config sys_ctl(). Hardware not read; reset values unknown.";
        field { name = "v"; desc = "Unknown QoS parameter. [GUESS]"; sw = rw; hw = r; } v[31:0];
    } AXI_QOS_410C @ 0x410C;

    reg {
        name = "AXI/QoS register 0x4110 (vendor boot value 0xB)";
        desc = "AXI_QOS_4110 - AXI/QoS register 0x4110 (vendor boot value 0xB). Confidence **INFERRED**. Evidence: Same as 0x410C. Hardware not read; reset values unknown.";
        field { name = "v"; desc = "Unknown QoS parameter. [GUESS]"; sw = rw; hw = r; } v[31:0];
    } AXI_QOS_4110 @ 0x4110;

    reg {
        name = "AXI/QoS register 0x41F0 (vendor boot value 1)";
        desc = "AXI_QOS_41F0 - AXI/QoS register 0x41F0 (vendor boot value 1). Confidence **INFERRED**. Evidence: Same as 0x410C. Hardware not read; reset values unknown.";
        field { name = "v"; desc = "Unknown. [GUESS]"; sw = rw; hw = r; } v[31:0];
    } AXI_QOS_41F0 @ 0x41F0;

    reg {
        name = "AXI/QoS register 0x4300 (vendor boot value 0x80)";
        desc = "AXI_QOS_4300 - AXI/QoS register 0x4300 (vendor boot value 0x80). Confidence **INFERRED**. Evidence: Same as 0x410C. Hardware not read; reset values unknown.";
        field { name = "v"; desc = "Unknown. [GUESS]"; sw = rw; hw = r; } v[31:0];
    } AXI_QOS_4300 @ 0x4300;

};
`endif

`ifndef HI3516EV200_DDR_DMC_RDL
`define HI3516EV200_DDR_DMC_RDL

regfile eDDR_DMC_EV200 {
    name = "DDR DMC (DDRC V520), Hi3516E V200 (window 0x120D8000)";
    desc = "DDRC type DDR_DDRC_V520 per cijliu-uboot ddr_training_custom.h (PHY T28, DDRT V2.0 SHF0). Only registers named by the vendor U-Boot DDR trainer headers are listed. Confidence legend (no hardware was read for this block): PROVEN = offset and bits are used by vendor source code or by the vendor boot binary (Xiongmai stock U-Boot of a Hi3516E V200 camera) exactly as described; INFERRED = deduced from naming, from sibling chips or from a value without a bit map; GUESS = plausible only.";

    reg {
        name = "Self-refresh control";
        desc = "DMC_CTRL_SREF - Self-refresh control. Confidence **PROVEN**. Evidence: ddr_ddrc_v520.h DDR_DMC_CTRL_SREF = 0x0; lowlevel_init_v300.c: write 1 = enter, 2 = exit self-refresh (DMC_CTRL_SREF_ENTER/EXIT). Hardware not read; reset values unknown.";
        field { name = "sref_enter"; desc = "1 = enter self-refresh. [PROVEN]"; sw = rw; hw = r; } sref_enter[0:0];
        field { name = "sref_exit"; desc = "1 = exit self-refresh. [PROVEN]"; sw = rw; hw = r; } sref_exit[1:1];
    } DMC_CTRL_SREF @ 0x0;

    reg {
        name = "SFC (software command) request";
        desc = "DMC_SFCREQ - SFC (software command) request. Confidence **PROVEN**. Evidence: ddr_ddrc_v520.h DDR_DMC_SFCREQ = 0xC. Hardware not read; reset values unknown.";
        field { name = "sfcreq"; desc = "Software DRAM command request/done. [PROVEN]"; sw = rw; hw = r; } sfcreq[31:0];
    } DMC_SFCREQ @ 0xC;

    reg {
        name = "Self-refresh configuration";
        desc = "DMC_CFG_SREF - Self-refresh configuration. Confidence **PROVEN**. Evidence: ddr_ddrc_v520.h DDR_DMC_CFG_SREF = 0x20. Hardware not read; reset values unknown.";
        field { name = "cfg_sref"; desc = "Auto self-refresh timing/enable. [PROVEN]"; sw = rw; hw = r; } cfg_sref[31:0];
    } DMC_CFG_SREF @ 0x20;

    reg {
        name = "Power-down configuration";
        desc = "DMC_CFG_PD - Power-down configuration. Confidence **PROVEN**. Evidence: ddr_ddrc_v520.h DDR_DMC_CFG_PD = 0x28 (DMC_POWER_DOWN_DIS = ~1: bit 0 enables power-down). Hardware not read; reset values unknown.";
        field { name = "pd_en"; desc = "Power-down enable. [PROVEN]"; sw = rw; hw = r; } pd_en[0:0];
    } DMC_CFG_PD @ 0x28;

    reg {
        name = "DDR mode";
        desc = "DMC_CFG_DDRMODE - DDR mode. Confidence **PROVEN**. Evidence: ddr_ddrc_v520.h DDR_DMC_CFG_DDRMODE = 0x50: [3:0] DRAM type (7 DDR4, 8 LPDDR4 per the common header; DDR2/DDR3 on this chip), [5:4] memory width (DMC_MEM_WIDTH_BIT 4), [11:10] bank groups (DMC_CFG_MEM_BG_BIT 10); lowlevel_init_v300.c: the channel is valid when [3:0] != 0. Hardware not read; reset values unknown.";
        field { name = "dram_type"; desc = "DRAM type code; 0 = channel not present. [PROVEN]"; sw = rw; hw = r; } dram_type[3:0];
        field { name = "mem_width"; desc = "Memory data width code. [PROVEN]"; sw = rw; hw = r; } mem_width[5:4];
        field { name = "mem_bg"; desc = "Bank-group count code. [PROVEN]"; sw = rw; hw = r; } mem_bg[11:10];
    } DMC_CFG_DDRMODE @ 0x50;

    reg {
        name = "Data scrambling configuration";
        desc = "DMC_CFG_SCRAMB - Data scrambling configuration. Confidence **PROVEN**. Evidence: ddr_ddrc_v520.h DDR_DMC_CFG_SCRAMB = 0x58: bit 14 scrambling enable (DMC_SCRAMB_DIS = 0xFFFFBFFF), low bits 3..4 configured by DMC_SCRAMB_CFG (0xFFFFFFE8 mask). Hardware not read; reset values unknown.";
        field { name = "scramb_en"; desc = "Scrambler enable. [PROVEN]"; sw = rw; hw = r; } scramb_en[14:14];
    } DMC_CFG_SCRAMB @ 0x58;

    reg {
        name = "Rank 0 volume configuration";
        desc = "DMC_CFG_RNKVOL0 - Rank 0 volume configuration. Confidence **PROVEN**. Evidence: ddr_ddrc_v520.h DDR_DMC_CFG_RNKVOL(n) = 0x60 + n x 4: [9:8] bank (DMC_RNKVOL_MEM_BANK_BIT 8), [6:4] row (bit 4), [2:0] column. Hardware not read; reset values unknown.";
        field { name = "mem_col"; desc = "Column address bits code. [PROVEN]"; sw = rw; hw = r; } mem_col[2:0];
        field { name = "mem_row"; desc = "Row address bits code. [PROVEN]"; sw = rw; hw = r; } mem_row[6:4];
        field { name = "mem_bank"; desc = "Bank count code. [PROVEN]"; sw = rw; hw = r; } mem_bank[9:8];
    } DMC_CFG_RNKVOL0 @ 0x60;

    reg {
        name = "Rank 1 volume configuration";
        desc = "DMC_CFG_RNKVOL1 - Rank 1 volume configuration. Confidence **PROVEN**. Evidence: DDR_DMC_CFG_RNKVOL(1) = 0x64, same layout as rank 0. Hardware not read; reset values unknown.";
        field { name = "mem_col"; desc = "Column address bits code. [PROVEN]"; sw = rw; hw = r; } mem_col[2:0];
        field { name = "mem_row"; desc = "Row address bits code. [PROVEN]"; sw = rw; hw = r; } mem_row[6:4];
        field { name = "mem_bank"; desc = "Bank count code. [PROVEN]"; sw = rw; hw = r; } mem_bank[9:8];
    } DMC_CFG_RNKVOL1 @ 0x64;

    reg {
        name = "Extended mode registers 0/1";
        desc = "DMC_CFG_EMRS01 - Extended mode registers 0/1. Confidence **PROVEN**. Evidence: ddr_ddrc_v520.h DDR_DMC_CFG_EMRS01 = 0xF0. Hardware not read; reset values unknown.";
        field { name = "emrs01"; desc = "MR1/MR0 image used by the DMC for initialization. [PROVEN]"; sw = rw; hw = r; } emrs01[31:0];
    } DMC_CFG_EMRS01 @ 0xF0;

    reg {
        name = "Timing register 2";
        desc = "DMC_TIMING2 - Timing register 2. Confidence **PROVEN**. Evidence: ddr_ddrc_v520.h DDR_DMC_TIMING2 = 0x108 (DMC_AUTO_TIMING_DIS = 0xFFFFF000: low 12 bits hold the auto refresh timing). Hardware not read; reset values unknown.";
        field { name = "auto_timing"; desc = "Auto-refresh timing field. [PROVEN]"; sw = rw; hw = r; } auto_timing[11:0];
    } DMC_TIMING2 @ 0x108;

    reg {
        name = "SFC command";
        desc = "DMC_SFCCMD - SFC command. Confidence **PROVEN**. Evidence: ddr_ddrc_v520.h DDR_DMC_SFCCMD = 0x210: [3:0] command type (2 LMR, 5 READ, 6 PRECHARGE_ALL), [12] MRS (DMC_SFC_CMD_MRS_BIT 12), [16] rank (DMC_SFC_RANK_BIT 16), [30] pre-disable. Hardware not read; reset values unknown.";
        field { name = "cmd"; desc = "SFC command type. [PROVEN]"; sw = rw; hw = r; } cmd[3:0];
        field { name = "mrs"; desc = "MRS value / flag field. [INFERRED]"; sw = rw; hw = r; } mrs[15:12];
        field { name = "rank"; desc = "Rank select mask. [PROVEN]"; sw = rw; hw = r; } rank[17:16];
        field { name = "pre_dis"; desc = "Precharge disable. [PROVEN]"; sw = rw; hw = r; } pre_dis[30:30];
    } DMC_SFCCMD @ 0x210;

    reg {
        name = "SFC address";
        desc = "DMC_SFCADDR - SFC address. Confidence **PROVEN**. Evidence: ddr_ddrc_v520.h DDR_DMC_SFCADDR = 0x214. Hardware not read; reset values unknown.";
        field { name = "addr"; desc = "SFC command address. [PROVEN]"; sw = rw; hw = r; } addr[31:0];
    } DMC_SFCADDR @ 0x214;

    reg {
        name = "SFC bank";
        desc = "DMC_SFCBANK - SFC bank. Confidence **PROVEN**. Evidence: ddr_ddrc_v520.h DDR_DMC_SFCBANK = 0x218. Hardware not read; reset values unknown.";
        field { name = "bank"; desc = "SFC command bank (DMC_BANK_MR1 = 1, MR3 = 3). [PROVEN]"; sw = rw; hw = r; } bank[31:0];
    } DMC_SFCBANK @ 0x218;

    reg {
        name = "Current function status";
        desc = "DMC_CURR_FUNC - Current function status. Confidence **PROVEN**. Evidence: ddr_ddrc_v520.h DDR_DMC_CURR_FUNC = 0x294; bit 0 = in self-refresh (DMC_CURR_FUNC_IN_SREF_MASK). Hardware not read; reset values unknown.";
        field { name = "in_sref"; desc = "1 = the controller is in self-refresh. [PROVEN]"; sw = rw; hw = r; } in_sref[0:0];
    } DMC_CURR_FUNC @ 0x294;

    reg {
        name = "SFC read data 0";
        desc = "DMC_SFC_RDATA0 - SFC read data 0. Confidence **PROVEN**. Evidence: ddr_ddrc_v520.h DDR_DMC_SFC_RDATA0 = 0x4A8 (RDATA0..7 at 0x4A8..0x4C4). Hardware not read; reset values unknown.";
        field { name = "rdata"; desc = "Read data of the last SFC read. [PROVEN]"; sw = rw; hw = r; } rdata[31:0];
    } DMC_SFC_RDATA0 @ 0x4A8;

};
`endif

`ifndef HI3516EV200_DDR_PHY_RDL
`define HI3516EV200_DDR_PHY_RDL

regfile eDDR_PHY_EV200 {
    name = "DDR PHY (T28), Hi3516E V200 (window 0x120DC000, extends to 0x120DD000)";
    desc = "DDR PHY type DDR_PHY_T28 per cijliu-uboot. Only registers named by the vendor U-Boot DDR trainer headers are listed. Confidence legend (no hardware was read for this block): PROVEN = offset and bits are used by vendor source code or by the vendor boot binary (Xiongmai stock U-Boot of a Hi3516E V200 camera) exactly as described; INFERRED = deduced from naming, from sibling chips or from a value without a bit map; GUESS = plausible only.";

    reg {
        name = "PHY initialization control";
        desc = "PHYINITCTRL - PHY initialization control. Confidence **PROVEN**. Evidence: ddr_phy_t28.h DDR_PHY_PHYINITCTRL = 0x4 with the per-step enable bits (INIT_EN, PLL_INIT_EN, DLYMEAS, ZCAL, WL, GT, GDST, WL2, RDET, WDET, DRAM_INIT, CAT, DRAM_RST, PHY_RST, PACK_RST, PHYCONN_RST bit 15, DVREFT, HVREFT, ... JTMT/CST, REFRET, PHYUPD_REQ); exact positions are given by PHY_PHYINITCTRL_* in the header, not copied here. Hardware not read; reset values unknown.";
        field { name = "init_en"; desc = "Bit 0 = INIT_EN (start of hardware initialization); other bits per the vendor header. [INFERRED]"; sw = rw; hw = r; } init_en[0:0];
        field { name = "phyconn_rst"; desc = "PHYCONN_RST (PHY_PHYCONN_RST_BIT = 15). [PROVEN]"; sw = rw; hw = r; } phyconn_rst[15:15];
    } PHYINITCTRL @ 0x4;

    reg {
        name = "PHY initialization status";
        desc = "PHYINITSTATUS - PHY initialization status. Confidence **PROVEN**. Evidence: ddr_phy_t28.h DDR_PHY_PHYINITSTATUS = 0x8; bit 8 = read detect error (PHY_PHYINITSTATUS_RDET_ERR 0x100), bit 5 = gate-training error (PHY_INITSTATUS_GT_MASK 0x20). Hardware not read; reset values unknown.";
        field { name = "gt_err"; desc = "Gate training error. [PROVEN]"; sw = rw; hw = r; } gt_err[5:5];
        field { name = "rdet_err"; desc = "Read-eye detect error. [PROVEN]"; sw = rw; hw = r; } rdet_err[8:8];
    } PHYINITSTATUS @ 0x8;

    reg {
        name = "Impedance calibration status";
        desc = "IMPSTATUS - Impedance calibration status. Confidence **PROVEN**. Evidence: ddr_phy_t28.h DDR_PHY_IMPSTATUS = 0x28; ZCODE PDRV field at [21:16] (PHY_ZCODE_PDRV_BIT 16, mask 0x3F). Hardware not read; reset values unknown.";
        field { name = "zcode_pdrv"; desc = "Calibrated pull-down drive code. [PROVEN]"; sw = rw; hw = r; } zcode_pdrv[21:16];
    } IMPSTATUS @ 0x28;

    reg {
        name = "DRAM configuration";
        desc = "DRAMCFG - DRAM configuration. Confidence **PROVEN**. Evidence: ddr_phy_t28.h DDR_PHY_DRAMCFG = 0x2C: [3:0] DRAM type (DDR2 1, DDR3 2, DDR3L 3, LPDDR2/3 5, LPDDR4 6, DDR4 0xA), bit 5 = MA2T (2T command timing). Hardware not read; reset values unknown.";
        field { name = "dram_type"; desc = "PHY DRAM type code. [PROVEN]"; sw = rw; hw = r; } dram_type[3:0];
        field { name = "ma2t"; desc = "2T command mode. [PROVEN]"; sw = rw; hw = r; } ma2t[5:5];
    } DRAMCFG @ 0x2C;

    reg {
        name = "Training control 0";
        desc = "TRAINCTRL0 - Training control 0. Confidence **PROVEN**. Evidence: ddr_phy_t28.h DDR_PHY_TRAINCTRL0 = 0x48 (mask 0xF). Hardware not read; reset values unknown.";
        field { name = "trainctrl0"; desc = "Training control nibble. [PROVEN]"; sw = rw; hw = r; } trainctrl0[3:0];
    } TRAINCTRL0 @ 0x48;

    reg {
        name = "Mode registers 0/1";
        desc = "MODEREG01 - Mode registers 0/1. Confidence **PROVEN**. Evidence: ddr_phy_t28.h DDR_PHY_MODEREG01 = 0x64, MR1 at [31:16]. Hardware not read; reset values unknown.";
        field { name = "mr0"; desc = "MR0. [PROVEN]"; sw = rw; hw = r; } mr0[15:0];
        field { name = "mr1"; desc = "MR1. [PROVEN]"; sw = rw; hw = r; } mr1[31:16];
    } MODEREG01 @ 0x64;

    reg {
        name = "Mode registers 2/3";
        desc = "MODEREG23 - Mode registers 2/3. Confidence **PROVEN**. Evidence: ddr_phy_t28.h DDR_PHY_MODEREG23 = 0x68. Hardware not read; reset values unknown.";
        field { name = "mr2"; desc = "MR2. [PROVEN]"; sw = rw; hw = r; } mr2[15:0];
        field { name = "mr3"; desc = "MR3. [PROVEN]"; sw = rw; hw = r; } mr3[31:16];
    } MODEREG23 @ 0x68;

    reg {
        name = "PHY miscellaneous control";
        desc = "MISC - PHY miscellaneous control. Confidence **PROVEN**. Evidence: ddr_phy_t28.h DDR_PHY_MISC = 0x70; bit 19 = update (PHY_MISC_UPDATE_BIT 19), bit 16 = scrambling (PHY_MISC_SCRAMB_DIS = 0xFFFEFFFF). Hardware not read; reset values unknown.";
        field { name = "scramb"; desc = "Data scrambling enable. [PROVEN]"; sw = rw; hw = r; } scramb[16:16];
        field { name = "update"; desc = "Delay update trigger. [PROVEN]"; sw = rw; hw = r; } update[19:19];
    } MISC @ 0x70;

    reg {
        name = "Data-mask select";
        desc = "DMSEL - Data-mask select. Confidence **PROVEN**. Evidence: ddr_phy_t28.h DDR_PHY_DMSEL = 0x84 (PHY_DMSEL_SWAPDFIBYTE mask 0xF8FFFFFF: DFI byte swap field [26:24]). Hardware not read; reset values unknown.";
        field { name = "swap_dfi_byte"; desc = "DFI byte swap select. [PROVEN]"; sw = rw; hw = r; } swap_dfi_byte[26:24];
    } DMSEL @ 0x84;

    reg {
        name = "Software training mode";
        desc = "SWTMODE - Software training mode. Confidence **PROVEN**. Evidence: ddr_phy_t28.h DDR_PHY_SWTMODE = 0xA0; bit 1 = SW_GTMODE (PHY_SWTMODE_SW_GTMODE_BIT 1). Hardware not read; reset values unknown.";
        field { name = "sw_gtmode"; desc = "Software gate-training mode. [PROVEN]"; sw = rw; hw = r; } sw_gtmode[1:1];
    } SWTMODE @ 0xA0;

    reg {
        name = "Software WL DQS";
        desc = "SWTWLDQS - Software WL DQS. Confidence **PROVEN**. Evidence: ddr_phy_t28.h DDR_PHY_SWTWLDQS = 0xA4. Hardware not read; reset values unknown.";
        field { name = "v"; desc = "Write-leveling DQS software value. [PROVEN]"; sw = rw; hw = r; } v[31:0];
    } SWTWLDQS @ 0xA4;

    reg {
        name = "Software training result";
        desc = "SWTRLT - Software training result. Confidence **PROVEN**. Evidence: ddr_phy_t28.h DDR_PHY_SWTRLT = 0xA8 (WL result mask 0xF, gate result mask 0xF). Hardware not read; reset values unknown.";
        field { name = "v"; desc = "Training result flags. [PROVEN]"; sw = rw; hw = r; } v[31:0];
    } SWTRLT @ 0xA8;

    reg {
        name = "PHY reset control";
        desc = "PHYRSCTRL - PHY reset control. Confidence **PROVEN**. Evidence: ddr_phy_t28.h DDR_PHY_PHYRSCTRL = 0xB0. Hardware not read; reset values unknown.";
        field { name = "v"; desc = "PHY reset/sync control. [PROVEN]"; sw = rw; hw = r; } v[31:0];
    } PHYRSCTRL @ 0xB0;

    reg {
        name = "IO control 2";
        desc = "IOCTL2 - IO control 2. Confidence **PROVEN**. Evidence: ddr_phy_t28.h DDR_PHY_IOCTL2 = 0xB4. Hardware not read; reset values unknown.";
        field { name = "v"; desc = "IO control. [PROVEN]"; sw = rw; hw = r; } v[31:0];
    } IOCTL2 @ 0xB4;

    reg {
        name = "VREF training control";
        desc = "VREFTCTRL - VREF training control. Confidence **PROVEN**. Evidence: ddr_phy_t28.h DDR_PHY_VREFTCTRL = 0xC0. Hardware not read; reset values unknown.";
        field { name = "v"; desc = "VREF training control. [PROVEN]"; sw = rw; hw = r; } v[31:0];
    } VREFTCTRL @ 0xC0;

    reg {
        name = "DQ VREF training control";
        desc = "DVRFTCTRL - DQ VREF training control. Confidence **PROVEN**. Evidence: ddr_phy_t28.h DDR_PHY_DVRFTCTRL = 0xC4; bit 31 = PDAEN (PHY_DVRFTCTRL_PDAEN_EN 0x80000000). Hardware not read; reset values unknown.";
        field { name = "pdaen"; desc = "Per-DRAM addressability enable. [PROVEN]"; sw = rw; hw = r; } pdaen[31:31];
    } DVRFTCTRL @ 0xC4;

    reg {
        name = "Address-line bit delay 0";
        desc = "ACADDRBDL0 - Address-line bit delay 0. Confidence **PROVEN**. Evidence: ddr_phy_t28.h DDR_PHY_ACADDRBDL(n) = 0x140 + n x 4 (mask 0x7F per field, ADDR1 at bit 16). Hardware not read; reset values unknown.";
        field { name = "addr0_bdl"; desc = "Address line bit delay. [PROVEN]"; sw = rw; hw = r; } addr0_bdl[6:0];
        field { name = "addr1_bdl"; desc = "Address line bit delay. [PROVEN]"; sw = rw; hw = r; } addr1_bdl[22:16];
    } ACADDRBDL0 @ 0x140;

    reg {
        name = "Impedance control 1";
        desc = "IMP_CTRL1 - Impedance control 1. Confidence **PROVEN**. Evidence: ddr_phy_t28.h DDR_PHY_IMP_CTRL1 = 0x170. Hardware not read; reset values unknown.";
        field { name = "v"; desc = "Impedance control. [PROVEN]"; sw = rw; hw = r; } v[31:0];
    } IMP_CTRL1 @ 0x170;

    reg {
        name = "Impedance status 1";
        desc = "IMP_STATUS1 - Impedance status 1. Confidence **PROVEN**. Evidence: ddr_phy_t28.h DDR_PHY_IMP_STATUS1 = 0x174. Hardware not read; reset values unknown.";
        field { name = "v"; desc = "Impedance status. [PROVEN]"; sw = rw; hw = r; } v[31:0];
    } IMP_STATUS1 @ 0x174;

    reg {
        name = "Command/address training swap index";
        desc = "CATSWAPINDEX - Command/address training swap index. Confidence **PROVEN**. Evidence: ddr_phy_t28.h DDR_PHY_CATSWAPINDEX = 0x1B8. Hardware not read; reset values unknown.";
        field { name = "v"; desc = "CA swap index. [PROVEN]"; sw = rw; hw = r; } v[31:0];
    } CATSWAPINDEX @ 0x1B8;

    reg {
        name = "Command/address training swap select";
        desc = "CATSWAPSEL - Command/address training swap select. Confidence **PROVEN**. Evidence: ddr_phy_t28.h DDR_PHY_CATSWAPSEL = 0x1BC (bit mask 0xFF). Hardware not read; reset values unknown.";
        field { name = "v"; desc = "CA swap select. [PROVEN]"; sw = rw; hw = r; } v[7:0];
    } CATSWAPSEL @ 0x1BC;

    reg {
        name = "Command/address training configuration";
        desc = "CATCONFIG - Command/address training configuration. Confidence **PROVEN**. Evidence: ddr_phy_t28.h DDR_PHY_CATCONFIG = 0x1C8. Hardware not read; reset values unknown.";
        field { name = "v"; desc = "CA training configuration. [PROVEN]"; sw = rw; hw = r; } v[31:0];
    } CATCONFIG @ 0x1C8;

    reg {
        name = "DQ result";
        desc = "PHYDQRESULT - DQ result. Confidence **PROVEN**. Evidence: ddr_phy_t28.h DDR_PHY_PHYDQRESULT = 0x1D0. Hardware not read; reset values unknown.";
        field { name = "v"; desc = "DQ training result. [PROVEN]"; sw = rw; hw = r; } v[31:0];
    } PHYDQRESULT @ 0x1D0;

    reg {
        name = "Address phase boundary";
        desc = "ADDRPHBOUND - Address phase boundary. Confidence **PROVEN**. Evidence: ddr_phy_t28.h DDR_PHY_ADDRPHBOUND = 0x1D4 (mask 0x1F). Hardware not read; reset values unknown.";
        field { name = "v"; desc = "Address phase boundary. [PROVEN]"; sw = rw; hw = r; } v[4:0];
    } ADDRPHBOUND @ 0x1D4;

    reg {
        name = "CA training pattern (P)";
        desc = "SWCATPATTERN_P - CA training pattern (P). Confidence **PROVEN**. Evidence: ddr_phy_t28.h DDR_PHY_SWCATPATTERN_P = 0x1D8 (mask 0x3FF). Hardware not read; reset values unknown.";
        field { name = "v"; desc = "CA pattern. [PROVEN]"; sw = rw; hw = r; } v[9:0];
    } SWCATPATTERN_P @ 0x1D8;

    reg {
        name = "CA training pattern (N)";
        desc = "SWCATPATTERN_N - CA training pattern (N). Confidence **PROVEN**. Evidence: ddr_phy_t28.h DDR_PHY_SWCATPATTERN_N = 0x1DC. Hardware not read; reset values unknown.";
        field { name = "v"; desc = "CA pattern. [PROVEN]"; sw = rw; hw = r; } v[9:0];
    } SWCATPATTERN_N @ 0x1DC;

    reg {
        name = "Process corner detector";
        desc = "CORNER_DETECTOR - Process corner detector. Confidence **PROVEN**. Evidence: ddr_phy_t28.h DDR_PHY_CORNER_DETECTOR = 0x104C. The PHY window therefore spans at least 0x1000 + (spans PHY0 0x120DC000 and PHY1 0x120DD000: the vendor table also programs 0x120DD0xx/0x120DD2xx). Hardware not read; reset values unknown.";
        field { name = "v"; desc = "Corner detector status. [PROVEN]"; sw = rw; hw = r; } v[31:0];
    } CORNER_DETECTOR @ 0x104C;

    reg {
        name = "AC PHY control 4";
        desc = "ACPHYCTL4 - AC PHY control 4. Confidence **PROVEN**. Evidence: ddr_phy_t28.h DDR_PHY_ACPHYCTL4 = 0x1064. Hardware not read; reset values unknown.";
        field { name = "v"; desc = "AC PHY control. [PROVEN]"; sw = rw; hw = r; } v[31:0];
    } ACPHYCTL4 @ 0x1064;

    reg {
        name = "AC PHY control 7";
        desc = "ACPHYCTL7 - AC PHY control 7. Confidence **PROVEN**. Evidence: ddr_phy_t28.h DDR_PHY_ACPHYCTL7 = 0x1070. Hardware not read; reset values unknown.";
        field { name = "v"; desc = "AC PHY control. [PROVEN]"; sw = rw; hw = r; } v[31:0];
    } ACPHYCTL7 @ 0x1070;

};
`endif

`endif
