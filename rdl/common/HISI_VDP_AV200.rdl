`ifndef HISI_VDP_AV200_RDL
`define HISI_VDP_AV200_RDL


regfile eHISI_VDP_AV200 {
    name = "HiSilicon video display processor (Hi3516A V200, Hi3519 V101)";
    desc = "
    HiSilicon video display processor (VDP) of the Hi3516A V200 and Hi3519 V101 at 0x11000000 (interrupt 59). The two data sheets (Hi3516AV200 9.2.6, Hi3519V101 9.2.6) list the same 116 registers: video layer V1 (0x1000, with DCMP decompression state), graphics layer G2 (0x7000), display channel DHD1 (0xC400), BT.1120 interface (BT_* 0xD200) and the LCD interface (LCD_CTRL 0xD400). The vendor header (hi3519/vou_reg.h == hi3516av200/vou_reg.h, byte-identical) adds the full V0 layer (0x0800, 16 regions, scaler, DCMP), the video-processing block VP0 (0x4000: ACC/ACM, CSC, DOF), graphics layers G0 (0x6000), G1 (0x6800), G3 (0x7800), graphics-processing GP0/GP1, write-back channels, DHD0 (0xC000), the parameter loader (COEF_DATA/`*_PARARD` 0x400-0x4F4), DAC control and the interface/dither/clip registers. Non-instant registers take effect after the `*_UPD` bits. The Hi3516A V300 VDP (120 data-sheet registers) is a close relative; Hi3516C V300 shares 59 of these registers by name.

    Generated 2026-11-10 by build/rdl-audit/video-rdl-scratch/gen_blocks.py: mechanical transcription of the data sheet register tables (ds_extract2 + description extraction from the PDF) merged with the vendor header; not hardware verified.

    Register sources: 116 registers from the data sheet (hi3516av200--Hi3516AV200-Datasheet.txt, section 9.2.6); 561 registers (5 of them arrays) and 101 fields from vendor U-Boot 2010.06 `product/hiosd/vo/hi3519/vou_reg.h` (GPL-2.0 U-Boot tree, HiSilicon copyright, created 2015-05-26; mirror github.com/OpenIPC/u-boot-hi3516cv200) (GPL-2.0, same-chip vendor header, byte-identical for Hi3516A V200 and Hi3519 V101), each marked `[inferred]` in its desc (names from the header, meanings inferred from the names, reset/access unknown). Name differences, data sheet kept: 0x134 name DS VO_DAC_0_CTRL / header VO_DAC_R_CTRL.";

    reg {
        name = "VO control register";
        desc = "VOCTRL is a VO control register. It is used to configure the arbitration mode of surface bus requests.

Data sheet 9.2.6 VOCTRL (offset 0x0, printed page 9-88, `hi3516av200--Hi3516AV200-Datasheet.txt` line 42316).";

        enum VOCTRL_vo_ck_gt_en_enum {
            DISABLED = 0 { name = "Disabled"; desc = "disabled"; };
            ENABLED = 1 { name = "Enabled"; desc = "enabled"; };
        };

        field {
            name = "vo_ck_gt_en";
            desc = "VDP clock gating enable";
            sw = rw;
            hw = r;
            encode = VOCTRL_vo_ck_gt_en_enum;
            reset = 0x0;
        } vo_ck_gt_en[31:31];

        field {
            name = "chk_sum_en";
            desc = "[inferred] Chk sum enable. (bits reserved in the data sheet; vendor header `product/hiosd/vo/hi3519/vou_reg.h` field `chk_sum_en`; access and reset unknown, modelled RW)";
            sw = rw;
            hw = r;
        } chk_sum_en[30:30];

        field {
            name = "one_sync2_en";
            desc = "[inferred] One sync2 enable. (bits reserved in the data sheet; vendor header `product/hiosd/vo/hi3519/vou_reg.h` field `one_sync2_en`; access and reset unknown, modelled RW)";
            sw = rw;
            hw = r;
        } one_sync2_en[28:28];

        field {
            name = "chn2_select";
            desc = "[inferred] Chn2 select. (bits reserved in the data sheet; vendor header `product/hiosd/vo/hi3519/vou_reg.h` field `chn2_select`; access and reset unknown, modelled RW)";
            sw = rw;
            hw = r;
        } chn2_select[27:27];

        enum VOCTRL_m0_arb_mode_enum {
            POLLING = 0 { name = "Polling"; desc = "polling"; };
            GRAPHICS_LAYER_FIRST = 1 { name = "Graphics Layer First"; desc = "graphics layer first Other values: reserved"; };
        };

        field {
            name = "m0_arb_mode";
            desc = "Arbitration mode of data requests of internal surface buses of VO MAC0";
            sw = rw;
            hw = r;
            encode = VOCTRL_m0_arb_mode_enum;
            reset = 0x0;
        } m0_arb_mode[3:0];
    } VOCTRL @ 0x0;

    reg {
        name = "VO interrupt status register (read-only)";
        desc = "VOINTSTA is a VO interrupt status register (read-only). Hi3516A V200 Professional HD IP Camera SoC

Data sheet 9.2.6 VOINTSTA (offset 0x4, printed page 9-89, `hi3516av200--Hi3516AV200-Datasheet.txt` line 42360).";

        field {
            name = "m0_be_int";
            desc = "[inferred] M0 be interrupt. (bits reserved in the data sheet; vendor header `product/hiosd/vo/hi3519/vou_reg.h` field `m0_be_int`; access and reset unknown, modelled RW)";
            sw = rw;
            hw = r;
        } m0_be_int[30:30];

        field {
            name = "ut_end_int";
            desc = "[inferred] Ut end interrupt. (bits reserved in the data sheet; vendor header `product/hiosd/vo/hi3519/vou_reg.h` field `ut_end_int`; access and reset unknown, modelled RW)";
            sw = rw;
            hw = r;
        } ut_end_int[29:29];

        field {
            name = "wbcdhd_partfns_int";
            desc = "[inferred] Wbcdhd partfns interrupt. (bits reserved in the data sheet; vendor header `product/hiosd/vo/hi3519/vou_reg.h` field `wbcdhd_partfns_int`; access and reset unknown, modelled RW)";
            sw = rw;
            hw = r;
        } wbcdhd_partfns_int[28:28];

        field {
            name = "g5rr_int";
            desc = "[inferred] G5rr interrupt. (bits reserved in the data sheet; vendor header `product/hiosd/vo/hi3519/vou_reg.h` field `g5rr_int`; access and reset unknown, modelled RW)";
            sw = rw;
            hw = r;
        } g5rr_int[27:27];

        field {
            name = "g4rr_int";
            desc = "[inferred] G4rr interrupt. (bits reserved in the data sheet; vendor header `product/hiosd/vo/hi3519/vou_reg.h` field `g4rr_int`; access and reset unknown, modelled RW)";
            sw = rw;
            hw = r;
        } g4rr_int[26:26];

        field {
            name = "g3rr_int";
            desc = "[inferred] G3rr interrupt. (bits reserved in the data sheet; vendor header `product/hiosd/vo/hi3519/vou_reg.h` field `g3rr_int`; access and reset unknown, modelled RW)";
            sw = rw;
            hw = r;
        } g3rr_int[25:25];

        field {
            name = "g2rr_int";
            desc = "[inferred] G2rr interrupt. (bits reserved in the data sheet; vendor header `product/hiosd/vo/hi3519/vou_reg.h` field `g2rr_int`; access and reset unknown, modelled RW)";
            sw = rw;
            hw = r;
        } g2rr_int[24:24];

        field {
            name = "g1rr_int";
            desc = "[inferred] G1rr interrupt. (bits reserved in the data sheet; vendor header `product/hiosd/vo/hi3519/vou_reg.h` field `g1rr_int`; access and reset unknown, modelled RW)";
            sw = rw;
            hw = r;
        } g1rr_int[23:23];

        field {
            name = "g0rr_int";
            desc = "[inferred] G0rr interrupt. (bits reserved in the data sheet; vendor header `product/hiosd/vo/hi3519/vou_reg.h` field `g0rr_int`; access and reset unknown, modelled RW)";
            sw = rw;
            hw = r;
        } g0rr_int[22:22];

        field {
            name = "v5rr_int";
            desc = "[inferred] V5rr interrupt. (bits reserved in the data sheet; vendor header `product/hiosd/vo/hi3519/vou_reg.h` field `v5rr_int`; access and reset unknown, modelled RW)";
            sw = rw;
            hw = r;
        } v5rr_int[21:21];

        field {
            name = "v4rr_int";
            desc = "[inferred] V4rr interrupt. (bits reserved in the data sheet; vendor header `product/hiosd/vo/hi3519/vou_reg.h` field `v4rr_int`; access and reset unknown, modelled RW)";
            sw = rw;
            hw = r;
        } v4rr_int[20:20];

        field {
            name = "v3rr_int";
            desc = "[inferred] V3rr interrupt. (bits reserved in the data sheet; vendor header `product/hiosd/vo/hi3519/vou_reg.h` field `v3rr_int`; access and reset unknown, modelled RW)";
            sw = rw;
            hw = r;
        } v3rr_int[19:19];

        field {
            name = "v2rr_int";
            desc = "[inferred] V2rr interrupt. (bits reserved in the data sheet; vendor header `product/hiosd/vo/hi3519/vou_reg.h` field `v2rr_int`; access and reset unknown, modelled RW)";
            sw = rw;
            hw = r;
        } v2rr_int[18:18];

        field {
            name = "dsd0uf_int";
            desc = "[inferred] Dsd0uf interrupt. (bits reserved in the data sheet; vendor header `product/hiosd/vo/hi3519/vou_reg.h` field `dsd0uf_int`; access and reset unknown, modelled RW)";
            sw = rw;
            hw = r;
        } dsd0uf_int[17:17];

        field {
            name = "dsd0vtthd1_int";
            desc = "[inferred] Dsd0vtthd1 interrupt. (bits reserved in the data sheet; vendor header `product/hiosd/vo/hi3519/vou_reg.h` field `dsd0vtthd1_int`; access and reset unknown, modelled RW)";
            sw = rw;
            hw = r;
        } dsd0vtthd1_int[16:16];

        field {
            name = "g4wbc_vte_int";
            desc = "[inferred] G4wbc vertical timing end interrupt. (bits reserved in the data sheet; vendor header `product/hiosd/vo/hi3519/vou_reg.h` field `g4wbc_vte_int`; access and reset unknown, modelled RW)";
            sw = rw;
            hw = r;
        } g4wbc_vte_int[11:11];

        field {
            name = "g0wbc_vte_int";
            desc = "[inferred] G0wbc vertical timing end interrupt. (bits reserved in the data sheet; vendor header `product/hiosd/vo/hi3519/vou_reg.h` field `g0wbc_vte_int`; access and reset unknown, modelled RW)";
            sw = rw;
            hw = r;
        } g0wbc_vte_int[10:10];

        field {
            name = "dwbc0_vte_int";
            desc = "[inferred] Dwbc0 vertical timing end interrupt. (bits reserved in the data sheet; vendor header `product/hiosd/vo/hi3519/vou_reg.h` field `dwbc0_vte_int`; access and reset unknown, modelled RW)";
            sw = rw;
            hw = r;
        } dwbc0_vte_int[9:9];

        field {
            name = "gwbc0_vte_int";
            desc = "[inferred] Gwbc0 vertical timing end interrupt. (bits reserved in the data sheet; vendor header `product/hiosd/vo/hi3519/vou_reg.h` field `gwbc0_vte_int`; access and reset unknown, modelled RW)";
            sw = rw;
            hw = r;
        } gwbc0_vte_int[8:8];

        enum VOINTSTA_dhd1uf_int_enum {
            INTERRUPT_REPORTED = 0 { name = "Interrupt Reported"; desc = "An interrupt is reported."; };
            NO_INTERRUPT_REPORTED = 1 { name = "No Interrupt Reported"; desc = "No interrupt is reported."; };
        };

        field {
            name = "dhd1uf_int";
            desc = "DHD1 low-bandwidth alarm interrupt";
            sw = r;
            hw = w;
            encode = VOINTSTA_dhd1uf_int_enum;
            reset = 0x0;
        } dhd1uf_int[7:7];

        field {
            name = "dhd1vtthd3_int";
            desc = "[inferred] Dhd1vtthd3 interrupt. (bits reserved in the data sheet; vendor header `product/hiosd/vo/hi3519/vou_reg.h` field `dhd1vtthd3_int`; access and reset unknown, modelled RW)";
            sw = rw;
            hw = r;
        } dhd1vtthd3_int[6:6];

        field {
            name = "dhd1vtthd2_int";
            desc = "[inferred] Dhd1vtthd2 interrupt. (bits reserved in the data sheet; vendor header `product/hiosd/vo/hi3519/vou_reg.h` field `dhd1vtthd2_int`; access and reset unknown, modelled RW)";
            sw = rw;
            hw = r;
        } dhd1vtthd2_int[5:5];

        enum VOINTSTA_dhd1vtthd1_int_enum {
            INTERRUPT_REPORTED = 0 { name = "Interrupt Reported"; desc = "An interrupt is reported."; };
            NO_INTERRUPT_REPORTED = 1 { name = "No Interrupt Reported"; desc = "No interrupt is reported."; };
        };

        field {
            name = "dhd1vtthd1_int";
            desc = "DHD1 vertical timing interrupt 1";
            sw = r;
            hw = w;
            encode = VOINTSTA_dhd1vtthd1_int_enum;
            reset = 0x0;
        } dhd1vtthd1_int[4:4];

        field {
            name = "dhd0uf_int";
            desc = "[inferred] Dhd0uf interrupt. (bits reserved in the data sheet; vendor header `product/hiosd/vo/hi3519/vou_reg.h` field `dhd0uf_int`; access and reset unknown, modelled RW)";
            sw = rw;
            hw = r;
        } dhd0uf_int[3:3];

        field {
            name = "dhd0vtthd3_int";
            desc = "[inferred] Dhd0vtthd3 interrupt. (bits reserved in the data sheet; vendor header `product/hiosd/vo/hi3519/vou_reg.h` field `dhd0vtthd3_int`; access and reset unknown, modelled RW)";
            sw = rw;
            hw = r;
        } dhd0vtthd3_int[2:2];

        field {
            name = "dhd0vtthd2_int";
            desc = "[inferred] Dhd0vtthd2 interrupt. (bits reserved in the data sheet; vendor header `product/hiosd/vo/hi3519/vou_reg.h` field `dhd0vtthd2_int`; access and reset unknown, modelled RW)";
            sw = rw;
            hw = r;
        } dhd0vtthd2_int[1:1];

        field {
            name = "dhd0vtthd1_int";
            desc = "[inferred] Dhd0vtthd1 interrupt. (bits reserved in the data sheet; vendor header `product/hiosd/vo/hi3519/vou_reg.h` field `dhd0vtthd1_int`; access and reset unknown, modelled RW)";
            sw = rw;
            hw = r;
        } dhd0vtthd1_int[0:0];
    } VOINTSTA @ 0x4;

    reg {
        name = "VO masked interrupt status register TA";
        desc = "VOMSKINTSTA is a VO masked interrupt status register. Writing 1 clears this register. Hi3516A V200 Professional HD IP Camera SoC

Data sheet 9.2.6 VOMSKINTSTA (offset 0x8, printed page 9-90, `hi3516av200--Hi3516AV200-Datasheet.txt` line 42407).";

        field {
            name = "m0_be_clr";
            desc = "[inferred] M0 be clear. (bits reserved in the data sheet; vendor header `product/hiosd/vo/hi3519/vou_reg.h` field `m0_be_clr`; access and reset unknown, modelled RW)";
            sw = rw;
            hw = r;
        } m0_be_clr[30:30];

        field {
            name = "ut_end_clr";
            desc = "[inferred] Ut end clear. (bits reserved in the data sheet; vendor header `product/hiosd/vo/hi3519/vou_reg.h` field `ut_end_clr`; access and reset unknown, modelled RW)";
            sw = rw;
            hw = r;
        } ut_end_clr[29:29];

        field {
            name = "wbcdhd_partfns_clr";
            desc = "[inferred] Wbcdhd partfns clear. (bits reserved in the data sheet; vendor header `product/hiosd/vo/hi3519/vou_reg.h` field `wbcdhd_partfns_clr`; access and reset unknown, modelled RW)";
            sw = rw;
            hw = r;
        } wbcdhd_partfns_clr[28:28];

        field {
            name = "g5rr_clr";
            desc = "[inferred] G5rr clear. (bits reserved in the data sheet; vendor header `product/hiosd/vo/hi3519/vou_reg.h` field `g5rr_clr`; access and reset unknown, modelled RW)";
            sw = rw;
            hw = r;
        } g5rr_clr[27:27];

        field {
            name = "g4rr_clr";
            desc = "[inferred] G4rr clear. (bits reserved in the data sheet; vendor header `product/hiosd/vo/hi3519/vou_reg.h` field `g4rr_clr`; access and reset unknown, modelled RW)";
            sw = rw;
            hw = r;
        } g4rr_clr[26:26];

        field {
            name = "g3rr_clr";
            desc = "[inferred] G3rr clear. (bits reserved in the data sheet; vendor header `product/hiosd/vo/hi3519/vou_reg.h` field `g3rr_clr`; access and reset unknown, modelled RW)";
            sw = rw;
            hw = r;
        } g3rr_clr[25:25];

        field {
            name = "g2rr_clr";
            desc = "[inferred] G2rr clear. (bits reserved in the data sheet; vendor header `product/hiosd/vo/hi3519/vou_reg.h` field `g2rr_clr`; access and reset unknown, modelled RW)";
            sw = rw;
            hw = r;
        } g2rr_clr[24:24];

        field {
            name = "g1rr_clr";
            desc = "[inferred] G1rr clear. (bits reserved in the data sheet; vendor header `product/hiosd/vo/hi3519/vou_reg.h` field `g1rr_clr`; access and reset unknown, modelled RW)";
            sw = rw;
            hw = r;
        } g1rr_clr[23:23];

        field {
            name = "g0rr_clr";
            desc = "[inferred] G0rr clear. (bits reserved in the data sheet; vendor header `product/hiosd/vo/hi3519/vou_reg.h` field `g0rr_clr`; access and reset unknown, modelled RW)";
            sw = rw;
            hw = r;
        } g0rr_clr[22:22];

        field {
            name = "v5rr_clr";
            desc = "[inferred] V5rr clear. (bits reserved in the data sheet; vendor header `product/hiosd/vo/hi3519/vou_reg.h` field `v5rr_clr`; access and reset unknown, modelled RW)";
            sw = rw;
            hw = r;
        } v5rr_clr[21:21];

        field {
            name = "v4rr_clr";
            desc = "[inferred] V4rr clear. (bits reserved in the data sheet; vendor header `product/hiosd/vo/hi3519/vou_reg.h` field `v4rr_clr`; access and reset unknown, modelled RW)";
            sw = rw;
            hw = r;
        } v4rr_clr[20:20];

        field {
            name = "v3rr_clr";
            desc = "[inferred] V3rr clear. (bits reserved in the data sheet; vendor header `product/hiosd/vo/hi3519/vou_reg.h` field `v3rr_clr`; access and reset unknown, modelled RW)";
            sw = rw;
            hw = r;
        } v3rr_clr[19:19];

        field {
            name = "v2rr_clr";
            desc = "[inferred] V2rr clear. (bits reserved in the data sheet; vendor header `product/hiosd/vo/hi3519/vou_reg.h` field `v2rr_clr`; access and reset unknown, modelled RW)";
            sw = rw;
            hw = r;
        } v2rr_clr[18:18];

        field {
            name = "dsd0uf_clr";
            desc = "[inferred] Dsd0uf clear. (bits reserved in the data sheet; vendor header `product/hiosd/vo/hi3519/vou_reg.h` field `dsd0uf_clr`; access and reset unknown, modelled RW)";
            sw = rw;
            hw = r;
        } dsd0uf_clr[17:17];

        field {
            name = "dsd0vtthd1_clr";
            desc = "[inferred] Dsd0vtthd1 clear. (bits reserved in the data sheet; vendor header `product/hiosd/vo/hi3519/vou_reg.h` field `dsd0vtthd1_clr`; access and reset unknown, modelled RW)";
            sw = rw;
            hw = r;
        } dsd0vtthd1_clr[16:16];

        enum VOMSKINTSTA_vdac0_unload_int_enum {
            INTERRUPT_REPORTED = 0 { name = "Interrupt Reported"; desc = "An interrupt is reported."; };
            NO_INTERRUPT_REPORTED = 1 { name = "No Interrupt Reported"; desc = "No interrupt is reported."; };
        };

        field {
            name = "vdac0_unload_int";
            desc = "DAC0 offload interrupt";
            sw = rw;
            hw = w;
            onwrite = woclr;
            encode = VOMSKINTSTA_vdac0_unload_int_enum;
            reset = 0x0;
        } vdac0_unload_int[12:12];

        field {
            name = "g4wbc_vte_clr";
            desc = "[inferred] G4wbc vertical timing end clear. (bits reserved in the data sheet; vendor header `product/hiosd/vo/hi3519/vou_reg.h` field `g4wbc_vte_clr`; access and reset unknown, modelled RW)";
            sw = rw;
            hw = r;
        } g4wbc_vte_clr[11:11];

        field {
            name = "g0wbc_vte_clr";
            desc = "[inferred] G0wbc vertical timing end clear. (bits reserved in the data sheet; vendor header `product/hiosd/vo/hi3519/vou_reg.h` field `g0wbc_vte_clr`; access and reset unknown, modelled RW)";
            sw = rw;
            hw = r;
        } g0wbc_vte_clr[10:10];

        field {
            name = "dwbc0_vte_clr";
            desc = "[inferred] Dwbc0 vertical timing end clear. (bits reserved in the data sheet; vendor header `product/hiosd/vo/hi3519/vou_reg.h` field `dwbc0_vte_clr`; access and reset unknown, modelled RW)";
            sw = rw;
            hw = r;
        } dwbc0_vte_clr[9:9];

        field {
            name = "gwbc0_vte_clr";
            desc = "[inferred] Gwbc0 vertical timing end clear. (bits reserved in the data sheet; vendor header `product/hiosd/vo/hi3519/vou_reg.h` field `gwbc0_vte_clr`; access and reset unknown, modelled RW)";
            sw = rw;
            hw = r;
        } gwbc0_vte_clr[8:8];

        enum VOMSKINTSTA_dhd1uf_clr_enum {
            INTERRUPT_REPORTED = 0 { name = "Interrupt Reported"; desc = "An interrupt is reported."; };
            NO_INTERRUPT_REPORTED = 1 { name = "No Interrupt Reported"; desc = "No interrupt is reported."; };
        };

        field {
            name = "dhd1uf_clr";
            desc = "DHD1 low-bandwidth alarm interrupt";
            sw = rw;
            hw = w;
            onwrite = woclr;
            encode = VOMSKINTSTA_dhd1uf_clr_enum;
            reset = 0x0;
        } dhd1uf_clr[7:7];

        field {
            name = "dhd1vtthd3_clr";
            desc = "[inferred] Dhd1vtthd3 clear. (bits reserved in the data sheet; vendor header `product/hiosd/vo/hi3519/vou_reg.h` field `dhd1vtthd3_clr`; access and reset unknown, modelled RW)";
            sw = rw;
            hw = r;
        } dhd1vtthd3_clr[6:6];

        field {
            name = "dhd1vtthd2_clr";
            desc = "[inferred] Dhd1vtthd2 clear. (bits reserved in the data sheet; vendor header `product/hiosd/vo/hi3519/vou_reg.h` field `dhd1vtthd2_clr`; access and reset unknown, modelled RW)";
            sw = rw;
            hw = r;
        } dhd1vtthd2_clr[5:5];

        enum VOMSKINTSTA_dhd1vtthd1_clr_enum {
            INTERRUPT_REPORTED = 0 { name = "Interrupt Reported"; desc = "An interrupt is reported."; };
            NO_INTERRUPT_REPORTED = 1 { name = "No Interrupt Reported"; desc = "No interrupt is reported."; };
        };

        field {
            name = "dhd1vtthd1_clr";
            desc = "DHD1 vertical timing interrupt 1";
            sw = rw;
            hw = w;
            onwrite = woclr;
            encode = VOMSKINTSTA_dhd1vtthd1_clr_enum;
            reset = 0x0;
        } dhd1vtthd1_clr[4:4];

        field {
            name = "dhd0uf_clr";
            desc = "[inferred] Dhd0uf clear. (bits reserved in the data sheet; vendor header `product/hiosd/vo/hi3519/vou_reg.h` field `dhd0uf_clr`; access and reset unknown, modelled RW)";
            sw = rw;
            hw = r;
        } dhd0uf_clr[3:3];

        field {
            name = "dhd0vtthd3_clr";
            desc = "[inferred] Dhd0vtthd3 clear. (bits reserved in the data sheet; vendor header `product/hiosd/vo/hi3519/vou_reg.h` field `dhd0vtthd3_clr`; access and reset unknown, modelled RW)";
            sw = rw;
            hw = r;
        } dhd0vtthd3_clr[2:2];

        field {
            name = "dhd0vtthd2_clr";
            desc = "[inferred] Dhd0vtthd2 clear. (bits reserved in the data sheet; vendor header `product/hiosd/vo/hi3519/vou_reg.h` field `dhd0vtthd2_clr`; access and reset unknown, modelled RW)";
            sw = rw;
            hw = r;
        } dhd0vtthd2_clr[1:1];

        field {
            name = "dhd0vtthd1_clr";
            desc = "[inferred] Dhd0vtthd1 clear. (bits reserved in the data sheet; vendor header `product/hiosd/vo/hi3519/vou_reg.h` field `dhd0vtthd1_clr`; access and reset unknown, modelled RW)";
            sw = rw;
            hw = r;
        } dhd0vtthd1_clr[0:0];
    } VOMSKINTSTA @ 0x8;

    reg {
        name = "VDP interrupt mask register";
        desc = "VOINTMSK is a VDP interrupt mask register. It corresponds to VOINTSTA. When the corresponding bit is set to 1, the interrupt is enabled; when the corresponding bit is set to 0, the interrupt is masked. Hi3516A V200 Professional HD IP Camera SoC

Data sheet 9.2.6 VOINTMSK (offset 0xC, printed page 9-91, `hi3516av200--Hi3516AV200-Datasheet.txt` line 42462).";

        field {
            name = "m0_be_intmsk";
            desc = "[inferred] M0 be interrupt mask. (bits reserved in the data sheet; vendor header `product/hiosd/vo/hi3519/vou_reg.h` field `m0_be_intmsk`; access and reset unknown, modelled RW)";
            sw = rw;
            hw = r;
        } m0_be_intmsk[30:30];

        field {
            name = "ut_end_intmsk";
            desc = "[inferred] Ut end interrupt mask. (bits reserved in the data sheet; vendor header `product/hiosd/vo/hi3519/vou_reg.h` field `ut_end_intmsk`; access and reset unknown, modelled RW)";
            sw = rw;
            hw = r;
        } ut_end_intmsk[29:29];

        field {
            name = "wbcdhd_partfns_intmsk";
            desc = "[inferred] Wbcdhd partfns interrupt mask. (bits reserved in the data sheet; vendor header `product/hiosd/vo/hi3519/vou_reg.h` field `wbcdhd_partfns_intmsk`; access and reset unknown, modelled RW)";
            sw = rw;
            hw = r;
        } wbcdhd_partfns_intmsk[28:28];

        field {
            name = "g5rr_intmsk";
            desc = "[inferred] G5rr interrupt mask. (bits reserved in the data sheet; vendor header `product/hiosd/vo/hi3519/vou_reg.h` field `g5rr_intmsk`; access and reset unknown, modelled RW)";
            sw = rw;
            hw = r;
        } g5rr_intmsk[27:27];

        field {
            name = "g4rr_intmsk";
            desc = "[inferred] G4rr interrupt mask. (bits reserved in the data sheet; vendor header `product/hiosd/vo/hi3519/vou_reg.h` field `g4rr_intmsk`; access and reset unknown, modelled RW)";
            sw = rw;
            hw = r;
        } g4rr_intmsk[26:26];

        field {
            name = "g3rr_intmsk";
            desc = "[inferred] G3rr interrupt mask. (bits reserved in the data sheet; vendor header `product/hiosd/vo/hi3519/vou_reg.h` field `g3rr_intmsk`; access and reset unknown, modelled RW)";
            sw = rw;
            hw = r;
        } g3rr_intmsk[25:25];

        field {
            name = "g2rr_intmsk";
            desc = "[inferred] G2rr interrupt mask. (bits reserved in the data sheet; vendor header `product/hiosd/vo/hi3519/vou_reg.h` field `g2rr_intmsk`; access and reset unknown, modelled RW)";
            sw = rw;
            hw = r;
        } g2rr_intmsk[24:24];

        field {
            name = "g1rr_intmsk";
            desc = "[inferred] G1rr interrupt mask. (bits reserved in the data sheet; vendor header `product/hiosd/vo/hi3519/vou_reg.h` field `g1rr_intmsk`; access and reset unknown, modelled RW)";
            sw = rw;
            hw = r;
        } g1rr_intmsk[23:23];

        field {
            name = "g0rr_intmsk";
            desc = "[inferred] G0rr interrupt mask. (bits reserved in the data sheet; vendor header `product/hiosd/vo/hi3519/vou_reg.h` field `g0rr_intmsk`; access and reset unknown, modelled RW)";
            sw = rw;
            hw = r;
        } g0rr_intmsk[22:22];

        field {
            name = "v5rr_intmsk";
            desc = "[inferred] V5rr interrupt mask. (bits reserved in the data sheet; vendor header `product/hiosd/vo/hi3519/vou_reg.h` field `v5rr_intmsk`; access and reset unknown, modelled RW)";
            sw = rw;
            hw = r;
        } v5rr_intmsk[21:21];

        field {
            name = "v4rr_intmsk";
            desc = "[inferred] V4rr interrupt mask. (bits reserved in the data sheet; vendor header `product/hiosd/vo/hi3519/vou_reg.h` field `v4rr_intmsk`; access and reset unknown, modelled RW)";
            sw = rw;
            hw = r;
        } v4rr_intmsk[20:20];

        field {
            name = "v3rr_intmsk";
            desc = "[inferred] V3rr interrupt mask. (bits reserved in the data sheet; vendor header `product/hiosd/vo/hi3519/vou_reg.h` field `v3rr_intmsk`; access and reset unknown, modelled RW)";
            sw = rw;
            hw = r;
        } v3rr_intmsk[19:19];

        field {
            name = "v2rr_intmsk";
            desc = "[inferred] V2rr interrupt mask. (bits reserved in the data sheet; vendor header `product/hiosd/vo/hi3519/vou_reg.h` field `v2rr_intmsk`; access and reset unknown, modelled RW)";
            sw = rw;
            hw = r;
        } v2rr_intmsk[18:18];

        field {
            name = "dsd0uf_intmsk";
            desc = "[inferred] Dsd0uf interrupt mask. (bits reserved in the data sheet; vendor header `product/hiosd/vo/hi3519/vou_reg.h` field `dsd0uf_intmsk`; access and reset unknown, modelled RW)";
            sw = rw;
            hw = r;
        } dsd0uf_intmsk[17:17];

        field {
            name = "dsd0vtthd1_intmsk";
            desc = "[inferred] Dsd0vtthd1 interrupt mask. (bits reserved in the data sheet; vendor header `product/hiosd/vo/hi3519/vou_reg.h` field `dsd0vtthd1_intmsk`; access and reset unknown, modelled RW)";
            sw = rw;
            hw = r;
        } dsd0vtthd1_intmsk[16:16];

        field {
            name = "g4wbc_vte_intmsk";
            desc = "[inferred] G4wbc vertical timing end interrupt mask. (bits reserved in the data sheet; vendor header `product/hiosd/vo/hi3519/vou_reg.h` field `g4wbc_vte_intmsk`; access and reset unknown, modelled RW)";
            sw = rw;
            hw = r;
        } g4wbc_vte_intmsk[11:11];

        field {
            name = "g0wbc_vte_intmsk";
            desc = "[inferred] G0wbc vertical timing end interrupt mask. (bits reserved in the data sheet; vendor header `product/hiosd/vo/hi3519/vou_reg.h` field `g0wbc_vte_intmsk`; access and reset unknown, modelled RW)";
            sw = rw;
            hw = r;
        } g0wbc_vte_intmsk[10:10];

        field {
            name = "dwbc0_vte_intmsk";
            desc = "[inferred] Dwbc0 vertical timing end interrupt mask. (bits reserved in the data sheet; vendor header `product/hiosd/vo/hi3519/vou_reg.h` field `dwbc0_vte_intmsk`; access and reset unknown, modelled RW)";
            sw = rw;
            hw = r;
        } dwbc0_vte_intmsk[9:9];

        field {
            name = "gwbc0_vte_intmsk";
            desc = "[inferred] Gwbc0 vertical timing end interrupt mask. (bits reserved in the data sheet; vendor header `product/hiosd/vo/hi3519/vou_reg.h` field `gwbc0_vte_intmsk`; access and reset unknown, modelled RW)";
            sw = rw;
            hw = r;
        } gwbc0_vte_intmsk[8:8];

        enum VOINTMSK_dhd1uf_intmsk_enum {
            MASKED = 0 { name = "Masked"; desc = "masked"; };
            ENABLED = 1 { name = "Enabled"; desc = "enabled"; };
        };

        field {
            name = "dhd1uf_intmsk";
            desc = "Mask for the DHD1 low-bandwidth alarm interrupt";
            sw = rw;
            hw = r;
            encode = VOINTMSK_dhd1uf_intmsk_enum;
            reset = 0x0;
        } dhd1uf_intmsk[7:7];

        field {
            name = "dhd1vtthd3_intmsk";
            desc = "[inferred] Dhd1vtthd3 interrupt mask. (bits reserved in the data sheet; vendor header `product/hiosd/vo/hi3519/vou_reg.h` field `dhd1vtthd3_intmsk`; access and reset unknown, modelled RW)";
            sw = rw;
            hw = r;
        } dhd1vtthd3_intmsk[6:6];

        field {
            name = "dhd1vtthd2_intmsk";
            desc = "[inferred] Dhd1vtthd2 interrupt mask. (bits reserved in the data sheet; vendor header `product/hiosd/vo/hi3519/vou_reg.h` field `dhd1vtthd2_intmsk`; access and reset unknown, modelled RW)";
            sw = rw;
            hw = r;
        } dhd1vtthd2_intmsk[5:5];

        enum VOINTMSK_dhd1vtthd1_intmsk_enum {
            MASKED = 0 { name = "Masked"; desc = "masked"; };
            ENABLED = 1 { name = "Enabled"; desc = "enabled"; };
        };

        field {
            name = "dhd1vtthd1_intmsk";
            desc = "Mask for DHD1 vertical timing interrupt 1";
            sw = rw;
            hw = r;
            encode = VOINTMSK_dhd1vtthd1_intmsk_enum;
            reset = 0x0;
        } dhd1vtthd1_intmsk[4:4];

        field {
            name = "dhd0uf_intmsk";
            desc = "[inferred] Dhd0uf interrupt mask. (bits reserved in the data sheet; vendor header `product/hiosd/vo/hi3519/vou_reg.h` field `dhd0uf_intmsk`; access and reset unknown, modelled RW)";
            sw = rw;
            hw = r;
        } dhd0uf_intmsk[3:3];

        field {
            name = "dhd0vtthd3_intmsk";
            desc = "[inferred] Dhd0vtthd3 interrupt mask. (bits reserved in the data sheet; vendor header `product/hiosd/vo/hi3519/vou_reg.h` field `dhd0vtthd3_intmsk`; access and reset unknown, modelled RW)";
            sw = rw;
            hw = r;
        } dhd0vtthd3_intmsk[2:2];

        field {
            name = "dhd0vtthd2_intmsk";
            desc = "[inferred] Dhd0vtthd2 interrupt mask. (bits reserved in the data sheet; vendor header `product/hiosd/vo/hi3519/vou_reg.h` field `dhd0vtthd2_intmsk`; access and reset unknown, modelled RW)";
            sw = rw;
            hw = r;
        } dhd0vtthd2_intmsk[1:1];

        field {
            name = "dhd0vtthd1_intmsk";
            desc = "[inferred] Dhd0vtthd1 interrupt mask. (bits reserved in the data sheet; vendor header `product/hiosd/vo/hi3519/vou_reg.h` field `dhd0vtthd1_intmsk`; access and reset unknown, modelled RW)";
            sw = rw;
            hw = r;
        } dhd0vtthd1_intmsk[0:0];
    } VOINTMSK @ 0xC;

    reg {
        name = "VDP version register 1 N1";
        desc = "VDPVERSION1 is VDP version register 1.

Data sheet 9.2.6 VDPVERSION1 (offset 0x10, printed page 9-91, `hi3516av200--Hi3516AV200-Datasheet.txt` line 42496).";

        field {
            name = "vdpversion1";
            desc = "VDP version 1";
            sw = r;
            hw = w;
            reset = 0x76756F76;
        } vdpversion1[31:0];
    } VDPVERSION1 @ 0x10;

    reg {
        name = "VDP version register 2 N2";
        desc = "VDPVERSION2 is VDP version register 2.

Data sheet 9.2.6 VDPVERSION2 (offset 0x14, printed page 9-92, `hi3516av200--Hi3516AV200-Datasheet.txt` line 42521).";

        field {
            name = "vdpversion2";
            desc = "VDP version 2";
            sw = r;
            hw = w;
            reset = 0x30313134;
        } vdpversion2[31:0];
    } VDPVERSION2 @ 0x14;

    reg {
        name = "VODEBUG";
        desc = "[inferred] VODEBUG. Not in the data sheet. Source: vendor U-Boot 2010.06 `product/hiosd/vo/hi3519/vou_reg.h` (GPL-2.0 U-Boot tree, HiSilicon copyright, created 2015-05-26; mirror github.com/OpenIPC/u-boot-hi3516cv200), union `U_VODEBUG`, struct offset 0x20 (GPL-2.0, same-chip vendor header, byte-identical for Hi3516A V200 and Hi3519 V101). Reset value and access type unknown (modelled RW, no reset). Confidence: medium (vendor header for this chip family, not hardware verified).";

        field {
            name = "bfm_mode";
            desc = "[inferred] Bfm mode. (vendor header `product/hiosd/vo/hi3519/vou_reg.h` field `bfm_mode`; access and reset unknown, modelled RW)";
            sw = rw;
            hw = r;
        } bfm_mode[28:26];

        field {
            name = "wbc_cmp_mode";
            desc = "[inferred] Wbc compare mode. (vendor header `product/hiosd/vo/hi3519/vou_reg.h` field `wbc_cmp_mode`; access and reset unknown, modelled RW)";
            sw = rw;
            hw = r;
        } wbc_cmp_mode[25:24];

        field {
            name = "node_num";
            desc = "[inferred] Node number. (vendor header `product/hiosd/vo/hi3519/vou_reg.h` field `node_num`; access and reset unknown, modelled RW)";
            sw = rw;
            hw = r;
        } node_num[23:20];

        field {
            name = "wbc_mode";
            desc = "[inferred] Wbc mode. (vendor header `product/hiosd/vo/hi3519/vou_reg.h` field `wbc_mode`; access and reset unknown, modelled RW)";
            sw = rw;
            hw = r;
        } wbc_mode[19:16];

        field {
            name = "wbc2_ff_info";
            desc = "[inferred] Wbc2 FIFO info. (vendor header `product/hiosd/vo/hi3519/vou_reg.h` field `wbc2_ff_info`; access and reset unknown, modelled RW)";
            sw = rw;
            hw = r;
        } wbc2_ff_info[15:14];

        field {
            name = "bfm_bt1120_en";
            desc = "[inferred] Bfm bt1120 enable. (vendor header `product/hiosd/vo/hi3519/vou_reg.h` field `bfm_bt1120_en`; access and reset unknown, modelled RW)";
            sw = rw;
            hw = r;
        } bfm_bt1120_en[13:13];

        field {
            name = "bfm_lcd_en";
            desc = "[inferred] Bfm lcd enable. (vendor header `product/hiosd/vo/hi3519/vou_reg.h` field `bfm_lcd_en`; access and reset unknown, modelled RW)";
            sw = rw;
            hw = r;
        } bfm_lcd_en[12:12];

        field {
            name = "bfm_cvbs_en";
            desc = "[inferred] Bfm cvbs enable. (vendor header `product/hiosd/vo/hi3519/vou_reg.h` field `bfm_cvbs_en`; access and reset unknown, modelled RW)";
            sw = rw;
            hw = r;
        } bfm_cvbs_en[11:11];

        field {
            name = "bfm_vga_en";
            desc = "[inferred] Bfm vga enable. (vendor header `product/hiosd/vo/hi3519/vou_reg.h` field `bfm_vga_en`; access and reset unknown, modelled RW)";
            sw = rw;
            hw = r;
        } bfm_vga_en[10:10];

        field {
            name = "dsd0_ff_info";
            desc = "[inferred] Dsd0 FIFO info. (vendor header `product/hiosd/vo/hi3519/vou_reg.h` field `dsd0_ff_info`; access and reset unknown, modelled RW)";
            sw = rw;
            hw = r;
        } dsd0_ff_info[9:8];

        field {
            name = "dhd1_ff_info";
            desc = "[inferred] Dhd1 FIFO info. (vendor header `product/hiosd/vo/hi3519/vou_reg.h` field `dhd1_ff_info`; access and reset unknown, modelled RW)";
            sw = rw;
            hw = r;
        } dhd1_ff_info[7:6];

        field {
            name = "dhd0_ff_info";
            desc = "[inferred] Dhd0 FIFO info. (vendor header `product/hiosd/vo/hi3519/vou_reg.h` field `dhd0_ff_info`; access and reset unknown, modelled RW)";
            sw = rw;
            hw = r;
        } dhd0_ff_info[5:4];

        field {
            name = "rm_en_chn";
            desc = "[inferred] Rm enable chn. (vendor header `product/hiosd/vo/hi3519/vou_reg.h` field `rm_en_chn`; access and reset unknown, modelled RW)";
            sw = rw;
            hw = r;
        } rm_en_chn[3:0];
    } VODEBUG @ 0x20;

    reg {
        name = "VDP memory debugging control register";
        desc = "VOMEM_CTRL is a VDP memory debugging control register.

Data sheet 9.2.6 VOMEM_CTRL (offset 0x24, printed page 9-92, `hi3516av200--Hi3516AV200-Datasheet.txt` line 42540).";

        field {
            name = "rft_emab";
            desc = "Speed adjustment for the EMAB end of the RFT memory";
            sw = rw;
            hw = r;
            reset = 0x3;
        } rft_emab[13:11];

        field {
            name = "rft_emaa";
            desc = "Speed adjustment for the EMAA end of the RFT memory";
            sw = rw;
            hw = r;
            reset = 0x3;
        } rft_emaa[10:8];

        field {
            name = "rfs_emaw";
            desc = "Speed adjustment for the EMAW end of the RFS memory";
            sw = rw;
            hw = r;
            reset = 0x1;
        } rfs_emaw[4:3];

        field {
            name = "rfs_ema";
            desc = "Speed adjustment for the EMA end of the RFS memory";
            sw = rw;
            hw = r;
            reset = 0x3;
        } rfs_ema[2:0];
    } VOMEM_CTRL @ 0x24;

    reg {
        name = "VO boundary split register for the multi-ID R application command";
        desc = "VOMIDORDER is a VO boundary split register for the multi-ID application command. Hi3516A V200 Professional HD IP Camera SoC

Data sheet 9.2.6 VOMIDORDER (offset 0x28, printed page 9-93, `hi3516av200--Hi3516AV200-Datasheet.txt` line 42579).";

        enum VOMIDORDER_edge_mode_enum {
            V_256_BYTE_SPLIT = 1 { name = "V 256 Byte Split"; desc = "256-byte split"; };
            V_4096_BYTE_SPLIT = 2 { name = "V 4096 Byte Split"; desc = "4096-byte split Other values: reserved"; };
        };

        field {
            name = "edge_mode";
            desc = "Boundary split for the multi-ID application command";
            sw = rw;
            hw = r;
            encode = VOMIDORDER_edge_mode_enum;
            reset = 0x1;
        } edge_mode[1:0];
    } VOMIDORDER @ 0x28;

    reg {
        name = "VO AXI bus configuration register";
        desc = "VOAXICTRL is a VO AXI bus configuration register.

Data sheet 9.2.6 VOAXICTRL (offset 0x34, printed page 9-93, `hi3516av200--Hi3516AV200-Datasheet.txt` line 42609).";

        enum VOAXICTRL_m0_v0_id_sel_enum {
            ONE_ID_OUTPUT = 0 { name = "One Id Output"; desc = "One ID is output."; };
            MULTIPLE_IDS_OUTPUT = 1 { name = "Multiple Ids Output"; desc = "Multiple IDs are output."; };
        };

        field {
            name = "m0_v0_id_sel";
            desc = "M0 multiple read ID output enable";
            sw = rw;
            hw = r;
            encode = VOAXICTRL_m0_v0_id_sel_enum;
            reset = 0x0;
        } m0_v0_id_sel[15:15];

        field {
            name = "m0_wr_ostd";
            desc = "[inferred] M0 write outstanding. (bits reserved in the data sheet; vendor header `product/hiosd/vo/hi3519/vou_reg.h` field `m0_wr_ostd`; access and reset unknown, modelled RW)";
            sw = rw;
            hw = r;
        } m0_wr_ostd[11:8];

        field {
            name = "m0_outstd_rid1";
            desc = "[inferred] M0 outstd rid1. (bits reserved in the data sheet; vendor header `product/hiosd/vo/hi3519/vou_reg.h` field `m0_outstd_rid1`; access and reset unknown, modelled RW)";
            sw = rw;
            hw = r;
        } m0_outstd_rid1[7:4];

        field {
            name = "m0_outstd_rid0";
            desc = "Read ID0 outstanding of AXI master 0. The value ranges from 0 to 7.";
            sw = rw;
            hw = r;
            reset = 0x1;
        } m0_outstd_rid0[3:0];
    } VOAXICTRL @ 0x34;

    reg {
        name = "VOWBCARB0";
        desc = "[inferred] VOWBCARB0. Not in the data sheet. Source: vendor U-Boot 2010.06 `product/hiosd/vo/hi3519/vou_reg.h` (GPL-2.0 U-Boot tree, HiSilicon copyright, created 2015-05-26; mirror github.com/OpenIPC/u-boot-hi3516cv200), union `U_VOWBCARB0`, struct offset 0x38 (GPL-2.0, same-chip vendor header, byte-identical for Hi3516A V200 and Hi3519 V101). Reset value and access type unknown (modelled RW, no reset). Confidence: medium (vendor header for this chip family, not hardware verified).";

        field {
            name = "w_arb_mode";
            desc = "[inferred] W arb mode. (vendor header `product/hiosd/vo/hi3519/vou_reg.h` field `w_arb_mode`; access and reset unknown, modelled RW)";
            sw = rw;
            hw = r;
        } w_arb_mode[31:28];

        field {
            name = "prio6";
            desc = "[inferred] Prio6. (vendor header `product/hiosd/vo/hi3519/vou_reg.h` field `prio6`; access and reset unknown, modelled RW)";
            sw = rw;
            hw = r;
        } prio6[20:18];

        field {
            name = "prio5";
            desc = "[inferred] Prio5. (vendor header `product/hiosd/vo/hi3519/vou_reg.h` field `prio5`; access and reset unknown, modelled RW)";
            sw = rw;
            hw = r;
        } prio5[17:15];

        field {
            name = "prio4";
            desc = "[inferred] Prio4. (vendor header `product/hiosd/vo/hi3519/vou_reg.h` field `prio4`; access and reset unknown, modelled RW)";
            sw = rw;
            hw = r;
        } prio4[14:12];

        field {
            name = "prio3";
            desc = "[inferred] Prio3. (vendor header `product/hiosd/vo/hi3519/vou_reg.h` field `prio3`; access and reset unknown, modelled RW)";
            sw = rw;
            hw = r;
        } prio3[11:9];

        field {
            name = "prio2";
            desc = "[inferred] Prio2. (vendor header `product/hiosd/vo/hi3519/vou_reg.h` field `prio2`; access and reset unknown, modelled RW)";
            sw = rw;
            hw = r;
        } prio2[8:6];

        field {
            name = "prio1";
            desc = "[inferred] Prio1. (vendor header `product/hiosd/vo/hi3519/vou_reg.h` field `prio1`; access and reset unknown, modelled RW)";
            sw = rw;
            hw = r;
        } prio1[5:3];

        field {
            name = "prio0";
            desc = "[inferred] Prio0. (vendor header `product/hiosd/vo/hi3519/vou_reg.h` field `prio0`; access and reset unknown, modelled RW)";
            sw = rw;
            hw = r;
        } prio0[2:0];
    } VOWBCARB0 @ 0x38;

    reg {
        name = "VOWBCARB1";
        desc = "[inferred] VOWBCARB1. Not in the data sheet. Source: vendor U-Boot 2010.06 `product/hiosd/vo/hi3519/vou_reg.h` (GPL-2.0 U-Boot tree, HiSilicon copyright, created 2015-05-26; mirror github.com/OpenIPC/u-boot-hi3516cv200), union `U_VOWBCARB1`, struct offset 0x3C (GPL-2.0, same-chip vendor header, byte-identical for Hi3516A V200 and Hi3519 V101). Reset value and access type unknown (modelled RW, no reset). Confidence: medium (vendor header for this chip family, not hardware verified).";

        field {
            name = "w_arb_mode";
            desc = "[inferred] W arb mode. (vendor header `product/hiosd/vo/hi3519/vou_reg.h` field `w_arb_mode`; access and reset unknown, modelled RW)";
            sw = rw;
            hw = r;
        } w_arb_mode[31:28];

        field {
            name = "prio6";
            desc = "[inferred] Prio6. (vendor header `product/hiosd/vo/hi3519/vou_reg.h` field `prio6`; access and reset unknown, modelled RW)";
            sw = rw;
            hw = r;
        } prio6[20:18];

        field {
            name = "prio5";
            desc = "[inferred] Prio5. (vendor header `product/hiosd/vo/hi3519/vou_reg.h` field `prio5`; access and reset unknown, modelled RW)";
            sw = rw;
            hw = r;
        } prio5[17:15];

        field {
            name = "prio4";
            desc = "[inferred] Prio4. (vendor header `product/hiosd/vo/hi3519/vou_reg.h` field `prio4`; access and reset unknown, modelled RW)";
            sw = rw;
            hw = r;
        } prio4[14:12];

        field {
            name = "prio3";
            desc = "[inferred] Prio3. (vendor header `product/hiosd/vo/hi3519/vou_reg.h` field `prio3`; access and reset unknown, modelled RW)";
            sw = rw;
            hw = r;
        } prio3[11:9];

        field {
            name = "prio2";
            desc = "[inferred] Prio2. (vendor header `product/hiosd/vo/hi3519/vou_reg.h` field `prio2`; access and reset unknown, modelled RW)";
            sw = rw;
            hw = r;
        } prio2[8:6];

        field {
            name = "prio1";
            desc = "[inferred] Prio1. (vendor header `product/hiosd/vo/hi3519/vou_reg.h` field `prio1`; access and reset unknown, modelled RW)";
            sw = rw;
            hw = r;
        } prio1[5:3];

        field {
            name = "prio0";
            desc = "[inferred] Prio0. (vendor header `product/hiosd/vo/hi3519/vou_reg.h` field `prio0`; access and reset unknown, modelled RW)";
            sw = rw;
            hw = r;
        } prio0[2:0];
    } VOWBCARB1 @ 0x3C;

    reg {
        name = "VOUFSTA";
        desc = "[inferred] VOUFSTA. Not in the data sheet. Source: vendor U-Boot 2010.06 `product/hiosd/vo/hi3519/vou_reg.h` (GPL-2.0 U-Boot tree, HiSilicon copyright, created 2015-05-26; mirror github.com/OpenIPC/u-boot-hi3516cv200), union `U_VOUFSTA`, struct offset 0x40 (GPL-2.0, same-chip vendor header, byte-identical for Hi3516A V200 and Hi3519 V101). Reset value and access type unknown (modelled RW, no reset). Confidence: medium (vendor header for this chip family, not hardware verified).";

        field {
            name = "g4_uf_sta";
            desc = "[inferred] G4 underflow status. (vendor header `product/hiosd/vo/hi3519/vou_reg.h` field `g4_uf_sta`; access and reset unknown, modelled RW)";
            sw = rw;
            hw = r;
        } g4_uf_sta[12:12];

        field {
            name = "g3_uf_sta";
            desc = "[inferred] G3 underflow status. (vendor header `product/hiosd/vo/hi3519/vou_reg.h` field `g3_uf_sta`; access and reset unknown, modelled RW)";
            sw = rw;
            hw = r;
        } g3_uf_sta[11:11];

        field {
            name = "g2_uf_sta";
            desc = "[inferred] G2 underflow status. (vendor header `product/hiosd/vo/hi3519/vou_reg.h` field `g2_uf_sta`; access and reset unknown, modelled RW)";
            sw = rw;
            hw = r;
        } g2_uf_sta[10:10];

        field {
            name = "g1_uf_sta";
            desc = "[inferred] G1 underflow status. (vendor header `product/hiosd/vo/hi3519/vou_reg.h` field `g1_uf_sta`; access and reset unknown, modelled RW)";
            sw = rw;
            hw = r;
        } g1_uf_sta[9:9];

        field {
            name = "g0_uf_sta";
            desc = "[inferred] G0 underflow status. (vendor header `product/hiosd/vo/hi3519/vou_reg.h` field `g0_uf_sta`; access and reset unknown, modelled RW)";
            sw = rw;
            hw = r;
        } g0_uf_sta[8:8];

        field {
            name = "v3_uf_sta";
            desc = "[inferred] V3 underflow status. (vendor header `product/hiosd/vo/hi3519/vou_reg.h` field `v3_uf_sta`; access and reset unknown, modelled RW)";
            sw = rw;
            hw = r;
        } v3_uf_sta[3:3];

        field {
            name = "v1_uf_sta";
            desc = "[inferred] V1 underflow status. (vendor header `product/hiosd/vo/hi3519/vou_reg.h` field `v1_uf_sta`; access and reset unknown, modelled RW)";
            sw = rw;
            hw = r;
        } v1_uf_sta[1:1];

        field {
            name = "v0_uf_sta";
            desc = "[inferred] V0 underflow status. (vendor header `product/hiosd/vo/hi3519/vou_reg.h` field `v0_uf_sta`; access and reset unknown, modelled RW)";
            sw = rw;
            hw = r;
        } v0_uf_sta[0:0];
    } VOUFSTA @ 0x40;

    reg {
        name = "VOUFCLR";
        desc = "[inferred] VOUFCLR. Not in the data sheet. Source: vendor U-Boot 2010.06 `product/hiosd/vo/hi3519/vou_reg.h` (GPL-2.0 U-Boot tree, HiSilicon copyright, created 2015-05-26; mirror github.com/OpenIPC/u-boot-hi3516cv200), union `U_VOUFCLR`, struct offset 0x44 (GPL-2.0, same-chip vendor header, byte-identical for Hi3516A V200 and Hi3519 V101). Reset value and access type unknown (modelled RW, no reset). Confidence: medium (vendor header for this chip family, not hardware verified).";

        field {
            name = "g4_uf_clr";
            desc = "[inferred] G4 underflow clear. (vendor header `product/hiosd/vo/hi3519/vou_reg.h` field `g4_uf_clr`; access and reset unknown, modelled RW)";
            sw = rw;
            hw = r;
        } g4_uf_clr[12:12];

        field {
            name = "g3_uf_clr";
            desc = "[inferred] G3 underflow clear. (vendor header `product/hiosd/vo/hi3519/vou_reg.h` field `g3_uf_clr`; access and reset unknown, modelled RW)";
            sw = rw;
            hw = r;
        } g3_uf_clr[11:11];

        field {
            name = "g2_uf_clr";
            desc = "[inferred] G2 underflow clear. (vendor header `product/hiosd/vo/hi3519/vou_reg.h` field `g2_uf_clr`; access and reset unknown, modelled RW)";
            sw = rw;
            hw = r;
        } g2_uf_clr[10:10];

        field {
            name = "g1_uf_clr";
            desc = "[inferred] G1 underflow clear. (vendor header `product/hiosd/vo/hi3519/vou_reg.h` field `g1_uf_clr`; access and reset unknown, modelled RW)";
            sw = rw;
            hw = r;
        } g1_uf_clr[9:9];

        field {
            name = "g0_uf_clr";
            desc = "[inferred] G0 underflow clear. (vendor header `product/hiosd/vo/hi3519/vou_reg.h` field `g0_uf_clr`; access and reset unknown, modelled RW)";
            sw = rw;
            hw = r;
        } g0_uf_clr[8:8];

        field {
            name = "v3_uf_clr";
            desc = "[inferred] V3 underflow clear. (vendor header `product/hiosd/vo/hi3519/vou_reg.h` field `v3_uf_clr`; access and reset unknown, modelled RW)";
            sw = rw;
            hw = r;
        } v3_uf_clr[3:3];

        field {
            name = "v1_uf_clr";
            desc = "[inferred] V1 underflow clear. (vendor header `product/hiosd/vo/hi3519/vou_reg.h` field `v1_uf_clr`; access and reset unknown, modelled RW)";
            sw = rw;
            hw = r;
        } v1_uf_clr[1:1];

        field {
            name = "v0_uf_clr";
            desc = "[inferred] V0 underflow clear. (vendor header `product/hiosd/vo/hi3519/vou_reg.h` field `v0_uf_clr`; access and reset unknown, modelled RW)";
            sw = rw;
            hw = r;
        } v0_uf_clr[0:0];
    } VOUFCLR @ 0x44;

    reg {
        name = "VOINTPROC TIM";
        desc = "[inferred] VOINTPROC TIM. Not in the data sheet. Source: vendor U-Boot 2010.06 `product/hiosd/vo/hi3519/vou_reg.h` (GPL-2.0 U-Boot tree, HiSilicon copyright, created 2015-05-26; mirror github.com/OpenIPC/u-boot-hi3516cv200), union `U_VOINTPROC_TIM`, struct offset 0x50 (GPL-2.0, same-chip vendor header, byte-identical for Hi3516A V200 and Hi3519 V101). Reset value and access type unknown (modelled RW, no reset). Confidence: medium (vendor header for this chip family, not hardware verified).";

        field {
            name = "vointproc_time";
            desc = "[inferred] Vointproc time. (vendor header `product/hiosd/vo/hi3519/vou_reg.h` field `vointproc_time`; access and reset unknown, modelled RW)";
            sw = rw;
            hw = r;
        } vointproc_time[23:0];
    } VOINTPROC_TIM @ 0x50;

    reg {
        name = "VO interface multiplexing register";
        desc = "VO_MUX is a VO interface multiplexing register.

Data sheet 9.2.6 VO_MUX (offset 0x100, printed page 9-94, `hi3516av200--Hi3516AV200-Datasheet.txt` line 42648).";

        enum VO_MUX_digital_sel_enum {
            BT_1120 = 0 { name = "Bt 1120"; desc = "BT.1120"; };
            BT_656 = 1 { name = "Bt 656"; desc = "BT.656"; };
            LCD_OTHER_VALUES = 2 { name = "Lcd Other Values"; desc = "LCD Other values: reserved"; };
        };

        field {
            name = "digital_sel";
            desc = "Digital interface data select. The default value is 0.";
            sw = rw;
            hw = r;
            encode = VO_MUX_digital_sel_enum;
            reset = 0x0;
        } digital_sel[31:28];

        field {
            name = "bt656_sel";
            desc = "[inferred] Bt656 select. (bits reserved in the data sheet; vendor header `product/hiosd/vo/hi3519/vou_reg.h` field `bt656_sel`; access and reset unknown, modelled RW)";
            sw = rw;
            hw = r;
        } bt656_sel[27:24];

        field {
            name = "bt1120_sel";
            desc = "[inferred] Bt1120 select. (bits reserved in the data sheet; vendor header `product/hiosd/vo/hi3519/vou_reg.h` field `bt1120_sel`; access and reset unknown, modelled RW)";
            sw = rw;
            hw = r;
        } bt1120_sel[23:20];

        field {
            name = "lcd_sel";
            desc = "[inferred] Lcd select. (bits reserved in the data sheet; vendor header `product/hiosd/vo/hi3519/vou_reg.h` field `lcd_sel`; access and reset unknown, modelled RW)";
            sw = rw;
            hw = r;
        } lcd_sel[19:16];

        field {
            name = "hdmi_sel";
            desc = "[inferred] Hdmi select. (bits reserved in the data sheet; vendor header `product/hiosd/vo/hi3519/vou_reg.h` field `hdmi_sel`; access and reset unknown, modelled RW)";
            sw = rw;
            hw = r;
        } hdmi_sel[15:12];

        field {
            name = "vga_sel";
            desc = "[inferred] Vga select. (bits reserved in the data sheet; vendor header `product/hiosd/vo/hi3519/vou_reg.h` field `vga_sel`; access and reset unknown, modelled RW)";
            sw = rw;
            hw = r;
        } vga_sel[11:8];

        field {
            name = "hddate_sel";
            desc = "[inferred] Hddate select. (bits reserved in the data sheet; vendor header `product/hiosd/vo/hi3519/vou_reg.h` field `hddate_sel`; access and reset unknown, modelled RW)";
            sw = rw;
            hw = r;
        } hddate_sel[7:4];

        field {
            name = "sddate_sel";
            desc = "[inferred] Sddate select. (bits reserved in the data sheet; vendor header `product/hiosd/vo/hi3519/vou_reg.h` field `sddate_sel`; access and reset unknown, modelled RW)";
            sw = rw;
            hw = r;
        } sddate_sel[3:0];
    } VO_MUX @ 0x100;

    reg {
        name = "VO MUX DAC";
        desc = "[inferred] VO MUX DAC. Not in the data sheet. Source: vendor U-Boot 2010.06 `product/hiosd/vo/hi3519/vou_reg.h` (GPL-2.0 U-Boot tree, HiSilicon copyright, created 2015-05-26; mirror github.com/OpenIPC/u-boot-hi3516cv200), union `U_VO_MUX_DAC`, struct offset 0x104 (GPL-2.0, same-chip vendor header, byte-identical for Hi3516A V200 and Hi3519 V101). Reset value and access type unknown (modelled RW, no reset). Confidence: medium (vendor header for this chip family, not hardware verified).";

        field {
            name = "dac3_sel";
            desc = "[inferred] Dac3 select. (vendor header `product/hiosd/vo/hi3519/vou_reg.h` field `dac3_sel`; access and reset unknown, modelled RW)";
            sw = rw;
            hw = r;
        } dac3_sel[15:12];

        field {
            name = "dac2_sel";
            desc = "[inferred] Dac2 select. (vendor header `product/hiosd/vo/hi3519/vou_reg.h` field `dac2_sel`; access and reset unknown, modelled RW)";
            sw = rw;
            hw = r;
        } dac2_sel[11:8];

        field {
            name = "dac1_sel";
            desc = "[inferred] Dac1 select. (vendor header `product/hiosd/vo/hi3519/vou_reg.h` field `dac1_sel`; access and reset unknown, modelled RW)";
            sw = rw;
            hw = r;
        } dac1_sel[7:4];

        field {
            name = "dac0_sel";
            desc = "[inferred] Dac0 select. (vendor header `product/hiosd/vo/hi3519/vou_reg.h` field `dac0_sel`; access and reset unknown, modelled RW)";
            sw = rw;
            hw = r;
        } dac0_sel[3:0];
    } VO_MUX_DAC @ 0x104;

    reg {
        name = "VO interface test register STSYNC";
        desc = "VO_MUX_TESTSYNC is a VO interface test register.

Data sheet 9.2.6 VO_MUX_TESTSYNC (offset 0x108, printed page 9-94, `hi3516av200--Hi3516AV200-Datasheet.txt` line 42675).";

        enum VO_MUX_TESTSYNC_vo_test_en_enum {
            DISABLED = 0 { name = "Disabled"; desc = "disabled"; };
            ENABLED = 1 { name = "Enabled"; desc = "enabled"; };
        };

        field {
            name = "vo_test_en";
            desc = "VDP output interface test mode enable";
            sw = rw;
            hw = r;
            encode = VO_MUX_TESTSYNC_vo_test_en_enum;
            reset = 0x0;
        } vo_test_en[31:31];

        field {
            name = "test_field";
            desc = "Test value of the field signal";
            sw = rw;
            hw = r;
            reset = 0x0;
        } test_field[3:3];

        field {
            name = "test_vsync";
            desc = "Test value of the vsync signal";
            sw = rw;
            hw = r;
            reset = 0x1;
        } test_vsync[2:2];

        field {
            name = "test_hsync";
            desc = "Test value of the hsync signal";
            sw = rw;
            hw = r;
            reset = 0x0;
        } test_hsync[1:1];

        field {
            name = "test_dv";
            desc = "Test value of the dv signal";
            sw = rw;
            hw = r;
            reset = 0x0;
        } test_dv[0:0];
    } VO_MUX_TESTSYNC @ 0x108;

    reg {
        name = "VO interface test data register STDATA";
        desc = "VO_MUX_TESTDATA is a VO interface test data register.

Data sheet 9.2.6 VO_MUX_TESTDATA (offset 0x10C, printed page 9-95, `hi3516av200--Hi3516AV200-Datasheet.txt` line 42719).";

        field {
            name = "test_data";
            desc = "Output data in test mode The output of DAC channels is the lower 10 bits of the register value, the output of the BT.1120 channel is the lower 16 bits of the register value, the output of the LCD channel is bits 29-22, 19-12, and 9-2 of the register, and the output of other channels is the register value. The output is in the RGB or YUV format from upper bits to lower bits.";
            sw = rw;
            hw = r;
            reset = 0x0;
        } test_data[29:0];
    } VO_MUX_TESTDATA @ 0x10C;

    reg {
        name = "VO DAC control register RL";
        desc = "VO_DAC_CTRL is a VO DAC control register. Hi3516A V200 Professional HD IP Camera SoC

Data sheet 9.2.6 VO_DAC_CTRL (offset 0x120, printed page 9-96, `hi3516av200--Hi3516AV200-Datasheet.txt` line 42759).";

        enum VO_DAC_CTRL_envbg_enum {
            DISABLED = 0 { name = "Disabled"; desc = "disabled"; };
            ENABLED = 1 { name = "Enabled"; desc = "enabled"; };
        };

        field {
            name = "envbg";
            desc = "VBG reference voltage enable";
            sw = rw;
            hw = r;
            encode = VO_DAC_CTRL_envbg_enum;
            reset = 0x0;
        } envbg[22:22];

        enum VO_DAC_CTRL_pdchopper_enum {
            ENABLED = 0 { name = "Enabled"; desc = "enabled"; };
            DISABLED = 1 { name = "Disabled"; desc = "disabled"; };
        };

        field {
            name = "pdchopper";
            desc = "VBG chopper enable";
            sw = rw;
            hw = r;
            encode = VO_DAC_CTRL_pdchopper_enum;
            reset = 0x0;
        } pdchopper[21:21];

        enum VO_DAC_CTRL_enextref_enum {
            INTERNAL_VBG_USED = 0 { name = "Internal Vbg Used"; desc = "The internal VBG is used. The VBG is not output to the test pin."; };
            VBG_OUTPUT_EXTERNAL = 1 { name = "Vbg Output External"; desc = "The VBG is output for external tests."; };
        };

        field {
            name = "enextref";
            desc = "VBG output test enable";
            sw = rw;
            hw = r;
            encode = VO_DAC_CTRL_enextref_enum;
            reset = 0x0;
        } enextref[20:20];

        field {
            name = "enctr";
            desc = "[inferred] Enctr. (bits reserved in the data sheet; vendor header `product/hiosd/vo/hi3519/vou_reg.h` field `enctr`; access and reset unknown, modelled RW)";
            sw = rw;
            hw = r;
        } enctr[19:16];

        field {
            name = "dac_reg_rev";
            desc = "The test is reserved.";
            sw = rw;
            hw = r;
            reset = 0x4000;
        } dac_reg_rev[15:0];
    } VO_DAC_CTRL @ 0x120;

    reg {
        name = "VO DAC OTP";
        desc = "[inferred] VO DAC OTP. Not in the data sheet. Source: vendor U-Boot 2010.06 `product/hiosd/vo/hi3519/vou_reg.h` (GPL-2.0 U-Boot tree, HiSilicon copyright, created 2015-05-26; mirror github.com/OpenIPC/u-boot-hi3516cv200), union `U_VO_DAC_OTP`, struct offset 0x124 (GPL-2.0, same-chip vendor header, byte-identical for Hi3516A V200 and Hi3519 V101). Reset value and access type unknown (modelled RW, no reset). Confidence: medium (vendor header for this chip family, not hardware verified).";

        field {
            name = "efus_res";
            desc = "[inferred] Efus res. (vendor header `product/hiosd/vo/hi3519/vou_reg.h` field `efus_res`; access and reset unknown, modelled RW)";
            sw = rw;
            hw = r;
        } efus_res[15:8];

        field {
            name = "poly_res";
            desc = "[inferred] Poly res. (vendor header `product/hiosd/vo/hi3519/vou_reg.h` field `poly_res`; access and reset unknown, modelled RW)";
            sw = rw;
            hw = r;
        } poly_res[7:2];

        field {
            name = "otp_res";
            desc = "[inferred] Otp res. (vendor header `product/hiosd/vo/hi3519/vou_reg.h` field `otp_res`; access and reset unknown, modelled RW)";
            sw = rw;
            hw = r;
        } otp_res[1:0];
    } VO_DAC_OTP @ 0x124;

    reg {
        name = "VO DAC C control";
        desc = "[inferred] VO DAC C control. Not in the data sheet. Source: vendor U-Boot 2010.06 `product/hiosd/vo/hi3519/vou_reg.h` (GPL-2.0 U-Boot tree, HiSilicon copyright, created 2015-05-26; mirror github.com/OpenIPC/u-boot-hi3516cv200), union `U_VO_DAC_C_CTRL`, struct offset 0x130 (GPL-2.0, same-chip vendor header, byte-identical for Hi3516A V200 and Hi3519 V101). Reset value and access type unknown (modelled RW, no reset). Confidence: medium (vendor header for this chip family, not hardware verified).";

        field {
            name = "en_c";
            desc = "[inferred] Enable c. (vendor header `product/hiosd/vo/hi3519/vou_reg.h` field `en_c`; access and reset unknown, modelled RW)";
            sw = rw;
            hw = r;
        } en_c[31:31];

        field {
            name = "en_buf_c";
            desc = "[inferred] Enable buf c. (vendor header `product/hiosd/vo/hi3519/vou_reg.h` field `en_buf_c`; access and reset unknown, modelled RW)";
            sw = rw;
            hw = r;
        } en_buf_c[30:30];

        field {
            name = "iso_c";
            desc = "[inferred] Iso c. (vendor header `product/hiosd/vo/hi3519/vou_reg.h` field `iso_c`; access and reset unknown, modelled RW)";
            sw = rw;
            hw = r;
        } iso_c[28:28];

        field {
            name = "mode_c";
            desc = "[inferred] Mode c. (vendor header `product/hiosd/vo/hi3519/vou_reg.h` field `mode_c`; access and reset unknown, modelled RW)";
            sw = rw;
            hw = r;
        } mode_c[27:27];

        field {
            name = "sel_c";
            desc = "[inferred] Select c. (vendor header `product/hiosd/vo/hi3519/vou_reg.h` field `sel_c`; access and reset unknown, modelled RW)";
            sw = rw;
            hw = r;
        } sel_c[26:25];

        field {
            name = "rc_c";
            desc = "[inferred] Rc c. (vendor header `product/hiosd/vo/hi3519/vou_reg.h` field `rc_c`; access and reset unknown, modelled RW)";
            sw = rw;
            hw = r;
        } rc_c[24:21];

        field {
            name = "ct_c";
            desc = "[inferred] Ct c. (vendor header `product/hiosd/vo/hi3519/vou_reg.h` field `ct_c`; access and reset unknown, modelled RW)";
            sw = rw;
            hw = r;
        } ct_c[20:15];

        field {
            name = "dem_c";
            desc = "[inferred] Dem c. (vendor header `product/hiosd/vo/hi3519/vou_reg.h` field `dem_c`; access and reset unknown, modelled RW)";
            sw = rw;
            hw = r;
        } dem_c[14:13];

        field {
            name = "cla_step_c";
            desc = "[inferred] Cla step c. (vendor header `product/hiosd/vo/hi3519/vou_reg.h` field `cla_step_c`; access and reset unknown, modelled RW)";
            sw = rw;
            hw = r;
        } cla_step_c[12:11];

        field {
            name = "ctrl_in_c";
            desc = "[inferred] Control in c. (vendor header `product/hiosd/vo/hi3519/vou_reg.h` field `ctrl_in_c`; access and reset unknown, modelled RW)";
            sw = rw;
            hw = r;
        } ctrl_in_c[10:3];

        field {
            name = "prg_en_c";
            desc = "[inferred] Prg enable c. (vendor header `product/hiosd/vo/hi3519/vou_reg.h` field `prg_en_c`; access and reset unknown, modelled RW)";
            sw = rw;
            hw = r;
        } prg_en_c[2:2];
    } VO_DAC_C_CTRL @ 0x130;

    reg {
        name = "VO DAC 0 channel control register TRL";
        desc = "VO_DAC_0_CTRL is a VO DAC 0 channel control register. Hi3516A V200 Professional HD IP Camera SoC

Data sheet 9.2.6 VO_DAC_0_CTRL (offset 0x134, printed page 9-97, `hi3516av200--Hi3516AV200-Datasheet.txt` line 42805).";

        enum VO_DAC_0_CTRL_dac0en_enum {
            DISABLED = 0 { name = "Disabled"; desc = "disabled"; };
            ENABLED = 1 { name = "Enabled"; desc = "enabled"; };
        };

        field {
            name = "dac0en";
            desc = "DAC enable";
            sw = rw;
            hw = r;
            encode = VO_DAC_0_CTRL_dac0en_enum;
            reset = 0x0;
        } dac0en[31:31];

        enum VO_DAC_0_CTRL_dac0gc_enum {
            V_0_52_V = 0x0 { name = "V 0 52 V"; desc = "0.52 V …"; };
            V_1_37_V = 0x3F { name = "V 1 37 V"; desc = "1.37 V"; };
        };

        field {
            name = "dac0gc";
            desc = "DAC output amplitude control The output voltage of the DAC at full scale ranges from 0.52 V to 1.37 V. The output amplitude is adjusted in 64 phases and the adjustment precision is 1%. The formula is as follows: Ifs = 13.9 + Gain x 0.358 (mA)";
            sw = rw;
            hw = r;
            encode = VO_DAC_0_CTRL_dac0gc_enum;
            reset = 0x0;
        } dac0gc[9:4];

        enum VO_DAC_0_CTRL_cablectr0_enum {
            NORMAL_DEFAULT = 0 { name = "Normal Default"; desc = "normal by default"; };
            V_10 = 1 { name = "V 10"; desc = "-10%"; };
            V_20 = 2 { name = "V 20"; desc = "-20%"; };
            V_10_2 = 3 { name = "V 10 2"; desc = "+10%"; };
        };

        field {
            name = "cablectr0";
            desc = "DAC VREF_CABLE reference voltage adjustment";
            sw = rw;
            hw = r;
            encode = VO_DAC_0_CTRL_cablectr0_enum;
            reset = 0x0;
        } cablectr0[1:0];
    } VO_DAC_0_CTRL @ 0x134;

    reg {
        name = "VO DAC G control";
        desc = "[inferred] VO DAC G control. Not in the data sheet. Source: vendor U-Boot 2010.06 `product/hiosd/vo/hi3519/vou_reg.h` (GPL-2.0 U-Boot tree, HiSilicon copyright, created 2015-05-26; mirror github.com/OpenIPC/u-boot-hi3516cv200), union `U_VO_DAC_G_CTRL`, struct offset 0x138 (GPL-2.0, same-chip vendor header, byte-identical for Hi3516A V200 and Hi3519 V101). Reset value and access type unknown (modelled RW, no reset). Confidence: medium (vendor header for this chip family, not hardware verified).";

        field {
            name = "en_g";
            desc = "[inferred] Enable g. (vendor header `product/hiosd/vo/hi3519/vou_reg.h` field `en_g`; access and reset unknown, modelled RW)";
            sw = rw;
            hw = r;
        } en_g[31:31];

        field {
            name = "en_buf_g";
            desc = "[inferred] Enable buf g. (vendor header `product/hiosd/vo/hi3519/vou_reg.h` field `en_buf_g`; access and reset unknown, modelled RW)";
            sw = rw;
            hw = r;
        } en_buf_g[30:30];

        field {
            name = "iso_g";
            desc = "[inferred] Iso g. (vendor header `product/hiosd/vo/hi3519/vou_reg.h` field `iso_g`; access and reset unknown, modelled RW)";
            sw = rw;
            hw = r;
        } iso_g[28:28];

        field {
            name = "mode_g";
            desc = "[inferred] Mode g. (vendor header `product/hiosd/vo/hi3519/vou_reg.h` field `mode_g`; access and reset unknown, modelled RW)";
            sw = rw;
            hw = r;
        } mode_g[27:27];

        field {
            name = "sel_g";
            desc = "[inferred] Select g. (vendor header `product/hiosd/vo/hi3519/vou_reg.h` field `sel_g`; access and reset unknown, modelled RW)";
            sw = rw;
            hw = r;
        } sel_g[26:25];

        field {
            name = "rc_g";
            desc = "[inferred] Rc g. (vendor header `product/hiosd/vo/hi3519/vou_reg.h` field `rc_g`; access and reset unknown, modelled RW)";
            sw = rw;
            hw = r;
        } rc_g[24:21];

        field {
            name = "ct_g";
            desc = "[inferred] Ct g. (vendor header `product/hiosd/vo/hi3519/vou_reg.h` field `ct_g`; access and reset unknown, modelled RW)";
            sw = rw;
            hw = r;
        } ct_g[20:15];

        field {
            name = "dem_g";
            desc = "[inferred] Dem g. (vendor header `product/hiosd/vo/hi3519/vou_reg.h` field `dem_g`; access and reset unknown, modelled RW)";
            sw = rw;
            hw = r;
        } dem_g[14:13];

        field {
            name = "cla_step_g";
            desc = "[inferred] Cla step g. (vendor header `product/hiosd/vo/hi3519/vou_reg.h` field `cla_step_g`; access and reset unknown, modelled RW)";
            sw = rw;
            hw = r;
        } cla_step_g[12:11];

        field {
            name = "ctrl_in_g";
            desc = "[inferred] Control in g. (vendor header `product/hiosd/vo/hi3519/vou_reg.h` field `ctrl_in_g`; access and reset unknown, modelled RW)";
            sw = rw;
            hw = r;
        } ctrl_in_g[10:3];

        field {
            name = "prg_en_g";
            desc = "[inferred] Prg enable g. (vendor header `product/hiosd/vo/hi3519/vou_reg.h` field `prg_en_g`; access and reset unknown, modelled RW)";
            sw = rw;
            hw = r;
        } prg_en_g[2:2];
    } VO_DAC_G_CTRL @ 0x138;

    reg {
        name = "VO DAC B control";
        desc = "[inferred] VO DAC B control. Not in the data sheet. Source: vendor U-Boot 2010.06 `product/hiosd/vo/hi3519/vou_reg.h` (GPL-2.0 U-Boot tree, HiSilicon copyright, created 2015-05-26; mirror github.com/OpenIPC/u-boot-hi3516cv200), union `U_VO_DAC_B_CTRL`, struct offset 0x13C (GPL-2.0, same-chip vendor header, byte-identical for Hi3516A V200 and Hi3519 V101). Reset value and access type unknown (modelled RW, no reset). Confidence: medium (vendor header for this chip family, not hardware verified).";

        field {
            name = "en_b";
            desc = "[inferred] Enable b. (vendor header `product/hiosd/vo/hi3519/vou_reg.h` field `en_b`; access and reset unknown, modelled RW)";
            sw = rw;
            hw = r;
        } en_b[31:31];

        field {
            name = "en_buf_b";
            desc = "[inferred] Enable buf b. (vendor header `product/hiosd/vo/hi3519/vou_reg.h` field `en_buf_b`; access and reset unknown, modelled RW)";
            sw = rw;
            hw = r;
        } en_buf_b[30:30];

        field {
            name = "iso_b";
            desc = "[inferred] Iso b. (vendor header `product/hiosd/vo/hi3519/vou_reg.h` field `iso_b`; access and reset unknown, modelled RW)";
            sw = rw;
            hw = r;
        } iso_b[28:28];

        field {
            name = "mode_b";
            desc = "[inferred] Mode b. (vendor header `product/hiosd/vo/hi3519/vou_reg.h` field `mode_b`; access and reset unknown, modelled RW)";
            sw = rw;
            hw = r;
        } mode_b[27:27];

        field {
            name = "sel_b";
            desc = "[inferred] Select b. (vendor header `product/hiosd/vo/hi3519/vou_reg.h` field `sel_b`; access and reset unknown, modelled RW)";
            sw = rw;
            hw = r;
        } sel_b[26:25];

        field {
            name = "rc_b";
            desc = "[inferred] Rc b. (vendor header `product/hiosd/vo/hi3519/vou_reg.h` field `rc_b`; access and reset unknown, modelled RW)";
            sw = rw;
            hw = r;
        } rc_b[24:21];

        field {
            name = "ct_b";
            desc = "[inferred] Ct b. (vendor header `product/hiosd/vo/hi3519/vou_reg.h` field `ct_b`; access and reset unknown, modelled RW)";
            sw = rw;
            hw = r;
        } ct_b[20:15];

        field {
            name = "dem_b";
            desc = "[inferred] Dem b. (vendor header `product/hiosd/vo/hi3519/vou_reg.h` field `dem_b`; access and reset unknown, modelled RW)";
            sw = rw;
            hw = r;
        } dem_b[14:13];

        field {
            name = "cla_step_b";
            desc = "[inferred] Cla step b. (vendor header `product/hiosd/vo/hi3519/vou_reg.h` field `cla_step_b`; access and reset unknown, modelled RW)";
            sw = rw;
            hw = r;
        } cla_step_b[12:11];

        field {
            name = "ctrl_in_b";
            desc = "[inferred] Control in b. (vendor header `product/hiosd/vo/hi3519/vou_reg.h` field `ctrl_in_b`; access and reset unknown, modelled RW)";
            sw = rw;
            hw = r;
        } ctrl_in_b[10:3];

        field {
            name = "prg_en_b";
            desc = "[inferred] Prg enable b. (vendor header `product/hiosd/vo/hi3519/vou_reg.h` field `prg_en_b`; access and reset unknown, modelled RW)";
            sw = rw;
            hw = r;
        } prg_en_b[2:2];
    } VO_DAC_B_CTRL @ 0x13C;

    reg {
        name = "VO DAC status 0 register AT0";
        desc = "VO_DAC_STAT0 is a VO DAC status 0 register. Hi3516A V200 Professional HD IP Camera SoC

Data sheet 9.2.6 VO_DAC_STAT0 (offset 0x140, printed page 9-98, `hi3516av200--Hi3516AV200-Datasheet.txt` line 42857).";

        field {
            name = "cableout0";
            desc = "cableout0 feedback signal";
            sw = r;
            hw = w;
            reset = 0x0;
        } cableout0[16:16];

        field {
            name = "dout_rct";
            desc = "[inferred] Dout rct. (bits reserved in the data sheet; vendor header `product/hiosd/vo/hi3519/vou_reg.h` field `dout_rct`; access and reset unknown, modelled RW)";
            sw = rw;
            hw = r;
        } dout_rct[5:0];
    } VO_DAC_STAT0 @ 0x140;

    reg {
        name = "VO DAC STAT1";
        desc = "[inferred] VO DAC STAT1. Not in the data sheet. Source: vendor U-Boot 2010.06 `product/hiosd/vo/hi3519/vou_reg.h` (GPL-2.0 U-Boot tree, HiSilicon copyright, created 2015-05-26; mirror github.com/OpenIPC/u-boot-hi3516cv200), union `U_VO_DAC_STAT1`, struct offset 0x144 (GPL-2.0, same-chip vendor header, byte-identical for Hi3516A V200 and Hi3519 V101). Reset value and access type unknown (modelled RW, no reset). Confidence: medium (vendor header for this chip family, not hardware verified).";

        field {
            name = "ctrl_out_r";
            desc = "[inferred] Control out r. (vendor header `product/hiosd/vo/hi3519/vou_reg.h` field `ctrl_out_r`; access and reset unknown, modelled RW)";
            sw = rw;
            hw = r;
        } ctrl_out_r[31:24];

        field {
            name = "ctrl_out_g";
            desc = "[inferred] Control out g. (vendor header `product/hiosd/vo/hi3519/vou_reg.h` field `ctrl_out_g`; access and reset unknown, modelled RW)";
            sw = rw;
            hw = r;
        } ctrl_out_g[23:16];

        field {
            name = "ctrl_out_b";
            desc = "[inferred] Control out b. (vendor header `product/hiosd/vo/hi3519/vou_reg.h` field `ctrl_out_b`; access and reset unknown, modelled RW)";
            sw = rw;
            hw = r;
        } ctrl_out_b[15:8];

        field {
            name = "ctbl_out_c";
            desc = "[inferred] Ctbl out c. (vendor header `product/hiosd/vo/hi3519/vou_reg.h` field `ctbl_out_c`; access and reset unknown, modelled RW)";
            sw = rw;
            hw = r;
        } ctbl_out_c[7:0];
    } VO_DAC_STAT1 @ 0x144;

    reg {
        name = "WBC DHD LOCATE";
        desc = "[inferred] WBC DHD LOCATE. Not in the data sheet. Source: vendor U-Boot 2010.06 `product/hiosd/vo/hi3519/vou_reg.h` (GPL-2.0 U-Boot tree, HiSilicon copyright, created 2015-05-26; mirror github.com/OpenIPC/u-boot-hi3516cv200), union `U_WBC_DHD_LOCATE`, struct offset 0x300 (GPL-2.0, same-chip vendor header, byte-identical for Hi3516A V200 and Hi3519 V101). Reset value and access type unknown (modelled RW, no reset). Confidence: medium (vendor header for this chip family, not hardware verified).";

        field {
            name = "wbc_dsd0_locate";
            desc = "[inferred] Wbc dsd0 locate. (vendor header `product/hiosd/vo/hi3519/vou_reg.h` field `wbc_dsd0_locate`; access and reset unknown, modelled RW)";
            sw = rw;
            hw = r;
        } wbc_dsd0_locate[2:2];

        field {
            name = "wbc_dhd1_locate";
            desc = "[inferred] Wbc dhd1 locate. (vendor header `product/hiosd/vo/hi3519/vou_reg.h` field `wbc_dhd1_locate`; access and reset unknown, modelled RW)";
            sw = rw;
            hw = r;
        } wbc_dhd1_locate[1:1];

        field {
            name = "wbc_dhd0_locate";
            desc = "[inferred] Wbc dhd0 locate. (vendor header `product/hiosd/vo/hi3519/vou_reg.h` field `wbc_dhd0_locate`; access and reset unknown, modelled RW)";
            sw = rw;
            hw = r;
        } wbc_dhd0_locate[0:0];
    } WBC_DHD_LOCATE @ 0x300;

    reg {
        name = "WBC OFL enable";
        desc = "[inferred] WBC OFL enable. Not in the data sheet. Source: vendor U-Boot 2010.06 `product/hiosd/vo/hi3519/vou_reg.h` (GPL-2.0 U-Boot tree, HiSilicon copyright, created 2015-05-26; mirror github.com/OpenIPC/u-boot-hi3516cv200), union `U_WBC_OFL_EN`, struct offset 0x304 (GPL-2.0, same-chip vendor header, byte-identical for Hi3516A V200 and Hi3519 V101). Reset value and access type unknown (modelled RW, no reset). Confidence: medium (vendor header for this chip family, not hardware verified).";

        field {
            name = "wbc2_ofl_pro";
            desc = "[inferred] Wbc2 ofl pro. (vendor header `product/hiosd/vo/hi3519/vou_reg.h` field `wbc2_ofl_pro`; access and reset unknown, modelled RW)";
            sw = rw;
            hw = r;
        } wbc2_ofl_pro[5:5];

        field {
            name = "wbc2_ofl_en";
            desc = "[inferred] Wbc2 ofl enable. (vendor header `product/hiosd/vo/hi3519/vou_reg.h` field `wbc2_ofl_en`; access and reset unknown, modelled RW)";
            sw = rw;
            hw = r;
        } wbc2_ofl_en[4:4];

        field {
            name = "wbc1_ofl_pro";
            desc = "[inferred] Wbc1 ofl pro. (vendor header `product/hiosd/vo/hi3519/vou_reg.h` field `wbc1_ofl_pro`; access and reset unknown, modelled RW)";
            sw = rw;
            hw = r;
        } wbc1_ofl_pro[3:3];

        field {
            name = "wbc1_ofl_en";
            desc = "[inferred] Wbc1 ofl enable. (vendor header `product/hiosd/vo/hi3519/vou_reg.h` field `wbc1_ofl_en`; access and reset unknown, modelled RW)";
            sw = rw;
            hw = r;
        } wbc1_ofl_en[2:2];

        field {
            name = "wbc0_ofl_pro";
            desc = "[inferred] Wbc0 ofl pro. (vendor header `product/hiosd/vo/hi3519/vou_reg.h` field `wbc0_ofl_pro`; access and reset unknown, modelled RW)";
            sw = rw;
            hw = r;
        } wbc0_ofl_pro[1:1];

        field {
            name = "wbc0_ofl_en";
            desc = "[inferred] Wbc0 ofl enable. (vendor header `product/hiosd/vo/hi3519/vou_reg.h` field `wbc0_ofl_en`; access and reset unknown, modelled RW)";
            sw = rw;
            hw = r;
        } wbc0_ofl_en[0:0];
    } WBC_OFL_EN @ 0x304;

    reg {
        name = "VHD CORRESP";
        desc = "[inferred] VHD CORRESP. Not in the data sheet. Source: vendor U-Boot 2010.06 `product/hiosd/vo/hi3519/vou_reg.h` (GPL-2.0 U-Boot tree, HiSilicon copyright, created 2015-05-26; mirror github.com/OpenIPC/u-boot-hi3516cv200), union `U_VHD_CORRESP`, struct offset 0x308 (GPL-2.0, same-chip vendor header, byte-identical for Hi3516A V200 and Hi3519 V101). Reset value and access type unknown (modelled RW, no reset). Confidence: medium (vendor header for this chip family, not hardware verified).";

        field {
            name = "v1_corresp";
            desc = "[inferred] V1 corresp. (vendor header `product/hiosd/vo/hi3519/vou_reg.h` field `v1_corresp`; access and reset unknown, modelled RW)";
            sw = rw;
            hw = r;
        } v1_corresp[7:4];
    } VHD_CORRESP @ 0x308;

    reg {
        name = "GDC CORRESP";
        desc = "[inferred] GDC CORRESP. Not in the data sheet. Source: vendor U-Boot 2010.06 `product/hiosd/vo/hi3519/vou_reg.h` (GPL-2.0 U-Boot tree, HiSilicon copyright, created 2015-05-26; mirror github.com/OpenIPC/u-boot-hi3516cv200), union `U_GDC_CORRESP`, struct offset 0x30C (GPL-2.0, same-chip vendor header, byte-identical for Hi3516A V200 and Hi3519 V101). Reset value and access type unknown (modelled RW, no reset). Confidence: medium (vendor header for this chip family, not hardware verified).";

        field {
            name = "g2_corresp";
            desc = "[inferred] G2 corresp. (vendor header `product/hiosd/vo/hi3519/vou_reg.h` field `g2_corresp`; access and reset unknown, modelled RW)";
            sw = rw;
            hw = r;
        } g2_corresp[11:8];
    } GDC_CORRESP @ 0x30C;

    reg {
        name = "WBC CORRESP";
        desc = "[inferred] WBC CORRESP. Not in the data sheet. Source: vendor U-Boot 2010.06 `product/hiosd/vo/hi3519/vou_reg.h` (GPL-2.0 U-Boot tree, HiSilicon copyright, created 2015-05-26; mirror github.com/OpenIPC/u-boot-hi3516cv200), union `U_WBC_CORRESP`, struct offset 0x310 (GPL-2.0, same-chip vendor header, byte-identical for Hi3516A V200 and Hi3519 V101). Reset value and access type unknown (modelled RW, no reset). Confidence: medium (vendor header for this chip family, not hardware verified).";

        field {
            name = "wbc_corresp";
            desc = "[inferred] Wbc corresp. (vendor header `product/hiosd/vo/hi3519/vou_reg.h` field `wbc_corresp`; access and reset unknown, modelled RW)";
            sw = rw;
            hw = r;
        } wbc_corresp[5:0];
    } WBC_CORRESP @ 0x310;

    reg {
        name = "Coefficient DATA";
        desc = "[inferred] Coefficient DATA. Not in the data sheet. Source: vendor U-Boot 2010.06 `product/hiosd/vo/hi3519/vou_reg.h` (GPL-2.0 U-Boot tree, HiSilicon copyright, created 2015-05-26; mirror github.com/OpenIPC/u-boot-hi3516cv200), union `U_COEF_DATA`, struct offset 0x400 (GPL-2.0, same-chip vendor header, byte-identical for Hi3516A V200 and Hi3519 V101). Reset value and access type unknown (modelled RW, no reset). Confidence: medium (vendor header for this chip family, not hardware verified).";

        field {
            name = "coef_data";
            desc = "[inferred] Coefficient data. (vendor header `product/hiosd/vo/hi3519/vou_reg.h` field `coef_data`; access and reset unknown, modelled RW)";
            sw = rw;
            hw = r;
        } coef_data[31:0];
    } COEF_DATA @ 0x400;

    reg {
        name = "V0 PARARD";
        desc = "[inferred] V0 PARARD. Not in the data sheet. Source: vendor U-Boot 2010.06 `product/hiosd/vo/hi3519/vou_reg.h` (GPL-2.0 U-Boot tree, HiSilicon copyright, created 2015-05-26; mirror github.com/OpenIPC/u-boot-hi3516cv200), union `U_V0_PARARD`, struct offset 0x410 (GPL-2.0, same-chip vendor header, byte-identical for Hi3516A V200 and Hi3519 V101). Reset value and access type unknown (modelled RW, no reset). Confidence: medium (vendor header for this chip family, not hardware verified).";

        field {
            name = "v0_vccoef_rd";
            desc = "[inferred] V0 vccoef read. (vendor header `product/hiosd/vo/hi3519/vou_reg.h` field `v0_vccoef_rd`; access and reset unknown, modelled RW)";
            sw = rw;
            hw = r;
        } v0_vccoef_rd[3:3];

        field {
            name = "v0_vlcoef_rd";
            desc = "[inferred] V0 vlcoef read. (vendor header `product/hiosd/vo/hi3519/vou_reg.h` field `v0_vlcoef_rd`; access and reset unknown, modelled RW)";
            sw = rw;
            hw = r;
        } v0_vlcoef_rd[2:2];

        field {
            name = "v0_hccoef_rd";
            desc = "[inferred] V0 hccoef read. (vendor header `product/hiosd/vo/hi3519/vou_reg.h` field `v0_hccoef_rd`; access and reset unknown, modelled RW)";
            sw = rw;
            hw = r;
        } v0_hccoef_rd[1:1];

        field {
            name = "v0_hlcoef_rd";
            desc = "[inferred] V0 hlcoef read. (vendor header `product/hiosd/vo/hi3519/vou_reg.h` field `v0_hlcoef_rd`; access and reset unknown, modelled RW)";
            sw = rw;
            hw = r;
        } v0_hlcoef_rd[0:0];
    } V0_PARARD @ 0x410;

    reg {
        name = "V1 PARARD";
        desc = "[inferred] V1 PARARD. Not in the data sheet. Source: vendor U-Boot 2010.06 `product/hiosd/vo/hi3519/vou_reg.h` (GPL-2.0 U-Boot tree, HiSilicon copyright, created 2015-05-26; mirror github.com/OpenIPC/u-boot-hi3516cv200), union `U_V1_PARARD`, struct offset 0x414 (GPL-2.0, same-chip vendor header, byte-identical for Hi3516A V200 and Hi3519 V101). Reset value and access type unknown (modelled RW, no reset). Confidence: medium (vendor header for this chip family, not hardware verified).";

        field {
            name = "v1_vccoef_rd";
            desc = "[inferred] V1 vccoef read. (vendor header `product/hiosd/vo/hi3519/vou_reg.h` field `v1_vccoef_rd`; access and reset unknown, modelled RW)";
            sw = rw;
            hw = r;
        } v1_vccoef_rd[3:3];

        field {
            name = "v1_vlcoef_rd";
            desc = "[inferred] V1 vlcoef read. (vendor header `product/hiosd/vo/hi3519/vou_reg.h` field `v1_vlcoef_rd`; access and reset unknown, modelled RW)";
            sw = rw;
            hw = r;
        } v1_vlcoef_rd[2:2];

        field {
            name = "v1_hccoef_rd";
            desc = "[inferred] V1 hccoef read. (vendor header `product/hiosd/vo/hi3519/vou_reg.h` field `v1_hccoef_rd`; access and reset unknown, modelled RW)";
            sw = rw;
            hw = r;
        } v1_hccoef_rd[1:1];

        field {
            name = "v1_hlcoef_rd";
            desc = "[inferred] V1 hlcoef read. (vendor header `product/hiosd/vo/hi3519/vou_reg.h` field `v1_hlcoef_rd`; access and reset unknown, modelled RW)";
            sw = rw;
            hw = r;
        } v1_hlcoef_rd[0:0];
    } V1_PARARD @ 0x414;

    reg {
        name = "V3 PARARD";
        desc = "[inferred] V3 PARARD. Not in the data sheet. Source: vendor U-Boot 2010.06 `product/hiosd/vo/hi3519/vou_reg.h` (GPL-2.0 U-Boot tree, HiSilicon copyright, created 2015-05-26; mirror github.com/OpenIPC/u-boot-hi3516cv200), union `U_V3_PARARD`, struct offset 0x41C (GPL-2.0, same-chip vendor header, byte-identical for Hi3516A V200 and Hi3519 V101). Reset value and access type unknown (modelled RW, no reset). Confidence: medium (vendor header for this chip family, not hardware verified).";

        field {
            name = "v3_vccoef_rd";
            desc = "[inferred] V3 vccoef read. (vendor header `product/hiosd/vo/hi3519/vou_reg.h` field `v3_vccoef_rd`; access and reset unknown, modelled RW)";
            sw = rw;
            hw = r;
        } v3_vccoef_rd[3:3];

        field {
            name = "v3_vlcoef_rd";
            desc = "[inferred] V3 vlcoef read. (vendor header `product/hiosd/vo/hi3519/vou_reg.h` field `v3_vlcoef_rd`; access and reset unknown, modelled RW)";
            sw = rw;
            hw = r;
        } v3_vlcoef_rd[2:2];

        field {
            name = "v3_hccoef_rd";
            desc = "[inferred] V3 hccoef read. (vendor header `product/hiosd/vo/hi3519/vou_reg.h` field `v3_hccoef_rd`; access and reset unknown, modelled RW)";
            sw = rw;
            hw = r;
        } v3_hccoef_rd[1:1];

        field {
            name = "v3_hlcoef_rd";
            desc = "[inferred] V3 hlcoef read. (vendor header `product/hiosd/vo/hi3519/vou_reg.h` field `v3_hlcoef_rd`; access and reset unknown, modelled RW)";
            sw = rw;
            hw = r;
        } v3_hlcoef_rd[0:0];
    } V3_PARARD @ 0x41C;

    reg {
        name = "VP0 PARARD";
        desc = "[inferred] VP0 PARARD. Not in the data sheet. Source: vendor U-Boot 2010.06 `product/hiosd/vo/hi3519/vou_reg.h` (GPL-2.0 U-Boot tree, HiSilicon copyright, created 2015-05-26; mirror github.com/OpenIPC/u-boot-hi3516cv200), union `U_VP0_PARARD`, struct offset 0x440 (GPL-2.0, same-chip vendor header, byte-identical for Hi3516A V200 and Hi3519 V101). Reset value and access type unknown (modelled RW, no reset). Confidence: medium (vendor header for this chip family, not hardware verified).";

        field {
            name = "vp0_acmlut_rd";
            desc = "[inferred] Vp0 acmlut read. (vendor header `product/hiosd/vo/hi3519/vou_reg.h` field `vp0_acmlut_rd`; access and reset unknown, modelled RW)";
            sw = rw;
            hw = r;
        } vp0_acmlut_rd[0:0];
    } VP0_PARARD @ 0x440;

    reg {
        name = "GP0 PARARD";
        desc = "[inferred] GP0 PARARD. Not in the data sheet. Source: vendor U-Boot 2010.06 `product/hiosd/vo/hi3519/vou_reg.h` (GPL-2.0 U-Boot tree, HiSilicon copyright, created 2015-05-26; mirror github.com/OpenIPC/u-boot-hi3516cv200), union `U_GP0_PARARD`, struct offset 0x490 (GPL-2.0, same-chip vendor header, byte-identical for Hi3516A V200 and Hi3519 V101). Reset value and access type unknown (modelled RW, no reset). Confidence: medium (vendor header for this chip family, not hardware verified).";

        field {
            name = "gp0_gti_vccoef_rd";
            desc = "[inferred] Gp0 gti vccoef read. (vendor header `product/hiosd/vo/hi3519/vou_reg.h` field `gp0_gti_vccoef_rd`; access and reset unknown, modelled RW)";
            sw = rw;
            hw = r;
        } gp0_gti_vccoef_rd[7:7];

        field {
            name = "gp0_gti_vlcoef_rd";
            desc = "[inferred] Gp0 gti vlcoef read. (vendor header `product/hiosd/vo/hi3519/vou_reg.h` field `gp0_gti_vlcoef_rd`; access and reset unknown, modelled RW)";
            sw = rw;
            hw = r;
        } gp0_gti_vlcoef_rd[6:6];

        field {
            name = "gp0_gti_hccoef_rd";
            desc = "[inferred] Gp0 gti hccoef read. (vendor header `product/hiosd/vo/hi3519/vou_reg.h` field `gp0_gti_hccoef_rd`; access and reset unknown, modelled RW)";
            sw = rw;
            hw = r;
        } gp0_gti_hccoef_rd[5:5];

        field {
            name = "gp0_gti_hlcoef_rd";
            desc = "[inferred] Gp0 gti hlcoef read. (vendor header `product/hiosd/vo/hi3519/vou_reg.h` field `gp0_gti_hlcoef_rd`; access and reset unknown, modelled RW)";
            sw = rw;
            hw = r;
        } gp0_gti_hlcoef_rd[4:4];

        field {
            name = "gp0_vccoef_rd";
            desc = "[inferred] Gp0 vccoef read. (vendor header `product/hiosd/vo/hi3519/vou_reg.h` field `gp0_vccoef_rd`; access and reset unknown, modelled RW)";
            sw = rw;
            hw = r;
        } gp0_vccoef_rd[3:3];

        field {
            name = "gp0_vlcoef_rd";
            desc = "[inferred] Gp0 vlcoef read. (vendor header `product/hiosd/vo/hi3519/vou_reg.h` field `gp0_vlcoef_rd`; access and reset unknown, modelled RW)";
            sw = rw;
            hw = r;
        } gp0_vlcoef_rd[2:2];

        field {
            name = "gp0_hccoef_rd";
            desc = "[inferred] Gp0 hccoef read. (vendor header `product/hiosd/vo/hi3519/vou_reg.h` field `gp0_hccoef_rd`; access and reset unknown, modelled RW)";
            sw = rw;
            hw = r;
        } gp0_hccoef_rd[1:1];

        field {
            name = "gp0_hlcoef_rd";
            desc = "[inferred] Gp0 hlcoef read. (vendor header `product/hiosd/vo/hi3519/vou_reg.h` field `gp0_hlcoef_rd`; access and reset unknown, modelled RW)";
            sw = rw;
            hw = r;
        } gp0_hlcoef_rd[0:0];
    } GP0_PARARD @ 0x490;

    reg {
        name = "GP1 PARARD";
        desc = "[inferred] GP1 PARARD. Not in the data sheet. Source: vendor U-Boot 2010.06 `product/hiosd/vo/hi3519/vou_reg.h` (GPL-2.0 U-Boot tree, HiSilicon copyright, created 2015-05-26; mirror github.com/OpenIPC/u-boot-hi3516cv200), union `U_GP1_PARARD`, struct offset 0x494 (GPL-2.0, same-chip vendor header, byte-identical for Hi3516A V200 and Hi3519 V101). Reset value and access type unknown (modelled RW, no reset). Confidence: medium (vendor header for this chip family, not hardware verified).";

        field {
            name = "gp1_gti_vccoef_rd";
            desc = "[inferred] Gp1 gti vccoef read. (vendor header `product/hiosd/vo/hi3519/vou_reg.h` field `gp1_gti_vccoef_rd`; access and reset unknown, modelled RW)";
            sw = rw;
            hw = r;
        } gp1_gti_vccoef_rd[7:7];

        field {
            name = "gp1_gti_vlcoef_rd";
            desc = "[inferred] Gp1 gti vlcoef read. (vendor header `product/hiosd/vo/hi3519/vou_reg.h` field `gp1_gti_vlcoef_rd`; access and reset unknown, modelled RW)";
            sw = rw;
            hw = r;
        } gp1_gti_vlcoef_rd[6:6];

        field {
            name = "gp1_gti_hccoef_rd";
            desc = "[inferred] Gp1 gti hccoef read. (vendor header `product/hiosd/vo/hi3519/vou_reg.h` field `gp1_gti_hccoef_rd`; access and reset unknown, modelled RW)";
            sw = rw;
            hw = r;
        } gp1_gti_hccoef_rd[5:5];

        field {
            name = "gp1_gti_hlcoef_rd";
            desc = "[inferred] Gp1 gti hlcoef read. (vendor header `product/hiosd/vo/hi3519/vou_reg.h` field `gp1_gti_hlcoef_rd`; access and reset unknown, modelled RW)";
            sw = rw;
            hw = r;
        } gp1_gti_hlcoef_rd[4:4];

        field {
            name = "gp1_vccoef_rd";
            desc = "[inferred] Gp1 vccoef read. (vendor header `product/hiosd/vo/hi3519/vou_reg.h` field `gp1_vccoef_rd`; access and reset unknown, modelled RW)";
            sw = rw;
            hw = r;
        } gp1_vccoef_rd[3:3];

        field {
            name = "gp1_vlcoef_rd";
            desc = "[inferred] Gp1 vlcoef read. (vendor header `product/hiosd/vo/hi3519/vou_reg.h` field `gp1_vlcoef_rd`; access and reset unknown, modelled RW)";
            sw = rw;
            hw = r;
        } gp1_vlcoef_rd[2:2];

        field {
            name = "gp1_hccoef_rd";
            desc = "[inferred] Gp1 hccoef read. (vendor header `product/hiosd/vo/hi3519/vou_reg.h` field `gp1_hccoef_rd`; access and reset unknown, modelled RW)";
            sw = rw;
            hw = r;
        } gp1_hccoef_rd[1:1];

        field {
            name = "gp1_hlcoef_rd";
            desc = "[inferred] Gp1 hlcoef read. (vendor header `product/hiosd/vo/hi3519/vou_reg.h` field `gp1_hlcoef_rd`; access and reset unknown, modelled RW)";
            sw = rw;
            hw = r;
        } gp1_hlcoef_rd[0:0];
    } GP1_PARARD @ 0x494;

    reg {
        name = "WBCDHD PARARD";
        desc = "[inferred] WBCDHD PARARD. Not in the data sheet. Source: vendor U-Boot 2010.06 `product/hiosd/vo/hi3519/vou_reg.h` (GPL-2.0 U-Boot tree, HiSilicon copyright, created 2015-05-26; mirror github.com/OpenIPC/u-boot-hi3516cv200), union `U_WBCDHD_PARARD`, struct offset 0x4C0 (GPL-2.0, same-chip vendor header, byte-identical for Hi3516A V200 and Hi3519 V101). Reset value and access type unknown (modelled RW, no reset). Confidence: medium (vendor header for this chip family, not hardware verified).";

        field {
            name = "wbcdhd_vccoef_rd";
            desc = "[inferred] Wbcdhd vccoef read. (vendor header `product/hiosd/vo/hi3519/vou_reg.h` field `wbcdhd_vccoef_rd`; access and reset unknown, modelled RW)";
            sw = rw;
            hw = r;
        } wbcdhd_vccoef_rd[3:3];

        field {
            name = "wbcdhd_vlcoef_rd";
            desc = "[inferred] Wbcdhd vlcoef read. (vendor header `product/hiosd/vo/hi3519/vou_reg.h` field `wbcdhd_vlcoef_rd`; access and reset unknown, modelled RW)";
            sw = rw;
            hw = r;
        } wbcdhd_vlcoef_rd[2:2];

        field {
            name = "wbcdhd_hccoef_rd";
            desc = "[inferred] Wbcdhd hccoef read. (vendor header `product/hiosd/vo/hi3519/vou_reg.h` field `wbcdhd_hccoef_rd`; access and reset unknown, modelled RW)";
            sw = rw;
            hw = r;
        } wbcdhd_hccoef_rd[1:1];

        field {
            name = "wbcdhd_hlcoef_rd";
            desc = "[inferred] Wbcdhd hlcoef read. (vendor header `product/hiosd/vo/hi3519/vou_reg.h` field `wbcdhd_hlcoef_rd`; access and reset unknown, modelled RW)";
            sw = rw;
            hw = r;
        } wbcdhd_hlcoef_rd[0:0];
    } WBCDHD_PARARD @ 0x4C0;

    reg {
        name = "DHD0 PARARD";
        desc = "[inferred] DHD0 PARARD. Not in the data sheet. Source: vendor U-Boot 2010.06 `product/hiosd/vo/hi3519/vou_reg.h` (GPL-2.0 U-Boot tree, HiSilicon copyright, created 2015-05-26; mirror github.com/OpenIPC/u-boot-hi3516cv200), union `U_DHD0_PARARD`, struct offset 0x4F0 (GPL-2.0, same-chip vendor header, byte-identical for Hi3516A V200 and Hi3519 V101). Reset value and access type unknown (modelled RW, no reset). Confidence: medium (vendor header for this chip family, not hardware verified).";

        field {
            name = "dhd0_gmmb_rd";
            desc = "[inferred] Dhd0 gmmb read. (vendor header `product/hiosd/vo/hi3519/vou_reg.h` field `dhd0_gmmb_rd`; access and reset unknown, modelled RW)";
            sw = rw;
            hw = r;
        } dhd0_gmmb_rd[2:2];

        field {
            name = "dhd0_gmmg_rd";
            desc = "[inferred] Dhd0 gmmg read. (vendor header `product/hiosd/vo/hi3519/vou_reg.h` field `dhd0_gmmg_rd`; access and reset unknown, modelled RW)";
            sw = rw;
            hw = r;
        } dhd0_gmmg_rd[1:1];

        field {
            name = "dhd0_gmmr_rd";
            desc = "[inferred] Dhd0 gmmr read. (vendor header `product/hiosd/vo/hi3519/vou_reg.h` field `dhd0_gmmr_rd`; access and reset unknown, modelled RW)";
            sw = rw;
            hw = r;
        } dhd0_gmmr_rd[0:0];
    } DHD0_PARARD @ 0x4F0;

    reg {
        name = "DHD1 PARARD";
        desc = "[inferred] DHD1 PARARD. Not in the data sheet. Source: vendor U-Boot 2010.06 `product/hiosd/vo/hi3519/vou_reg.h` (GPL-2.0 U-Boot tree, HiSilicon copyright, created 2015-05-26; mirror github.com/OpenIPC/u-boot-hi3516cv200), union `U_DHD1_PARARD`, struct offset 0x4F4 (GPL-2.0, same-chip vendor header, byte-identical for Hi3516A V200 and Hi3519 V101). Reset value and access type unknown (modelled RW, no reset). Confidence: medium (vendor header for this chip family, not hardware verified).";

        field {
            name = "dhd1_gmmb_rd";
            desc = "[inferred] Dhd1 gmmb read. (vendor header `product/hiosd/vo/hi3519/vou_reg.h` field `dhd1_gmmb_rd`; access and reset unknown, modelled RW)";
            sw = rw;
            hw = r;
        } dhd1_gmmb_rd[2:2];

        field {
            name = "dhd1_gmmg_rd";
            desc = "[inferred] Dhd1 gmmg read. (vendor header `product/hiosd/vo/hi3519/vou_reg.h` field `dhd1_gmmg_rd`; access and reset unknown, modelled RW)";
            sw = rw;
            hw = r;
        } dhd1_gmmg_rd[1:1];

        field {
            name = "dhd1_gmmr_rd";
            desc = "[inferred] Dhd1 gmmr read. (vendor header `product/hiosd/vo/hi3519/vou_reg.h` field `dhd1_gmmr_rd`; access and reset unknown, modelled RW)";
            sw = rw;
            hw = r;
        } dhd1_gmmr_rd[0:0];
    } DHD1_PARARD @ 0x4F4;

    reg {
        name = "V0 control";
        desc = "[inferred] V0 control. Not in the data sheet. Source: vendor U-Boot 2010.06 `product/hiosd/vo/hi3519/vou_reg.h` (GPL-2.0 U-Boot tree, HiSilicon copyright, created 2015-05-26; mirror github.com/OpenIPC/u-boot-hi3516cv200), union `U_V0_CTRL`, struct offset 0x800 (GPL-2.0, same-chip vendor header, byte-identical for Hi3516A V200 and Hi3519 V101). Reset value and access type unknown (modelled RW, no reset). Confidence: medium (vendor header for this chip family, not hardware verified).";

        field {
            name = "surface_en";
            desc = "[inferred] Surface enable. (vendor header `product/hiosd/vo/hi3519/vou_reg.h` field `surface_en`; access and reset unknown, modelled RW)";
            sw = rw;
            hw = r;
        } surface_en[31:31];

        field {
            name = "die_rd_en";
            desc = "[inferred] Die read enable. (vendor header `product/hiosd/vo/hi3519/vou_reg.h` field `die_rd_en`; access and reset unknown, modelled RW)";
            sw = rw;
            hw = r;
        } die_rd_en[28:28];

        field {
            name = "mute_en";
            desc = "[inferred] Mute enable. (vendor header `product/hiosd/vo/hi3519/vou_reg.h` field `mute_en`; access and reset unknown, modelled RW)";
            sw = rw;
            hw = r;
        } mute_en[27:27];

        field {
            name = "flip_en";
            desc = "[inferred] Flip enable. (vendor header `product/hiosd/vo/hi3519/vou_reg.h` field `flip_en`; access and reset unknown, modelled RW)";
            sw = rw;
            hw = r;
        } flip_en[26:26];

        field {
            name = "crop_en";
            desc = "[inferred] Crop enable. (vendor header `product/hiosd/vo/hi3519/vou_reg.h` field `crop_en`; access and reset unknown, modelled RW)";
            sw = rw;
            hw = r;
        } crop_en[23:23];

        field {
            name = "precharge_en";
            desc = "[inferred] Precharge enable. (vendor header `product/hiosd/vo/hi3519/vou_reg.h` field `precharge_en`; access and reset unknown, modelled RW)";
            sw = rw;
            hw = r;
        } precharge_en[21:21];

        field {
            name = "precharge_mode";
            desc = "[inferred] Precharge mode. (vendor header `product/hiosd/vo/hi3519/vou_reg.h` field `precharge_mode`; access and reset unknown, modelled RW)";
            sw = rw;
            hw = r;
        } precharge_mode[20:20];

        field {
            name = "ifir_mode";
            desc = "[inferred] Input FIR filter mode. (vendor header `product/hiosd/vo/hi3519/vou_reg.h` field `ifir_mode`; access and reset unknown, modelled RW)";
            sw = rw;
            hw = r;
        } ifir_mode[19:18];

        field {
            name = "vup_mode";
            desc = "[inferred] Vup mode. (vendor header `product/hiosd/vo/hi3519/vou_reg.h` field `vup_mode`; access and reset unknown, modelled RW)";
            sw = rw;
            hw = r;
        } vup_mode[17:17];

        field {
            name = "lm_rmode";
            desc = "[inferred] Lm rmode. (vendor header `product/hiosd/vo/hi3519/vou_reg.h` field `lm_rmode`; access and reset unknown, modelled RW)";
            sw = rw;
            hw = r;
        } lm_rmode[15:14];

        field {
            name = "chm_rmode";
            desc = "[inferred] Chm rmode. (vendor header `product/hiosd/vo/hi3519/vou_reg.h` field `chm_rmode`; access and reset unknown, modelled RW)";
            sw = rw;
            hw = r;
        } chm_rmode[13:12];

        field {
            name = "uv_order";
            desc = "[inferred] Uv order. (vendor header `product/hiosd/vo/hi3519/vou_reg.h` field `uv_order`; access and reset unknown, modelled RW)";
            sw = rw;
            hw = r;
        } uv_order[11:11];

        field {
            name = "nosec_flag";
            desc = "[inferred] Nosec flag. (vendor header `product/hiosd/vo/hi3519/vou_reg.h` field `nosec_flag`; access and reset unknown, modelled RW)";
            sw = rw;
            hw = r;
        } nosec_flag[10:10];

        field {
            name = "dcmp_en";
            desc = "[inferred] Decompression enable. (vendor header `product/hiosd/vo/hi3519/vou_reg.h` field `dcmp_en`; access and reset unknown, modelled RW)";
            sw = rw;
            hw = r;
        } dcmp_en[8:8];

        field {
            name = "time_out";
            desc = "[inferred] Time out. (vendor header `product/hiosd/vo/hi3519/vou_reg.h` field `time_out`; access and reset unknown, modelled RW)";
            sw = rw;
            hw = r;
        } time_out[7:5];

        field {
            name = "ifmt";
            desc = "[inferred] Input format. (vendor header `product/hiosd/vo/hi3519/vou_reg.h` field `ifmt`; access and reset unknown, modelled RW)";
            sw = rw;
            hw = r;
        } ifmt[3:0];
    } V0_CTRL @ 0x800;

    reg {
        name = "V0 update";
        desc = "[inferred] V0 update. Not in the data sheet. Source: vendor U-Boot 2010.06 `product/hiosd/vo/hi3519/vou_reg.h` (GPL-2.0 U-Boot tree, HiSilicon copyright, created 2015-05-26; mirror github.com/OpenIPC/u-boot-hi3516cv200), union `U_V0_UPD`, struct offset 0x804 (GPL-2.0, same-chip vendor header, byte-identical for Hi3516A V200 and Hi3519 V101). Reset value and access type unknown (modelled RW, no reset). Confidence: medium (vendor header for this chip family, not hardware verified).";

        field {
            name = "regup";
            desc = "[inferred] Regup. (vendor header `product/hiosd/vo/hi3519/vou_reg.h` field `regup`; access and reset unknown, modelled RW)";
            sw = rw;
            hw = r;
        } regup[0:0];
    } V0_UPD @ 0x804;

    reg {
        name = "V0 PRERD";
        desc = "[inferred] V0 PRERD. Not in the data sheet. Source: vendor U-Boot 2010.06 `product/hiosd/vo/hi3519/vou_reg.h` (GPL-2.0 U-Boot tree, HiSilicon copyright, created 2015-05-26; mirror github.com/OpenIPC/u-boot-hi3516cv200), union `U_V0_PRERD`, struct offset 0x820 (GPL-2.0, same-chip vendor header, byte-identical for Hi3516A V200 and Hi3519 V101). Reset value and access type unknown (modelled RW, no reset). Confidence: medium (vendor header for this chip family, not hardware verified).";

        field {
            name = "pre_rd_en";
            desc = "[inferred] Pre read enable. (vendor header `product/hiosd/vo/hi3519/vou_reg.h` field `pre_rd_en`; access and reset unknown, modelled RW)";
            sw = rw;
            hw = r;
        } pre_rd_en[31:31];
    } V0_PRERD @ 0x820;

    reg {
        name = "V0 IRESO";
        desc = "[inferred] V0 IRESO. Not in the data sheet. Source: vendor U-Boot 2010.06 `product/hiosd/vo/hi3519/vou_reg.h` (GPL-2.0 U-Boot tree, HiSilicon copyright, created 2015-05-26; mirror github.com/OpenIPC/u-boot-hi3516cv200), union `U_V0_IRESO`, struct offset 0x828 (GPL-2.0, same-chip vendor header, byte-identical for Hi3516A V200 and Hi3519 V101). Reset value and access type unknown (modelled RW, no reset). Confidence: medium (vendor header for this chip family, not hardware verified).";

        field {
            name = "ih";
            desc = "[inferred] Ih. (vendor header `product/hiosd/vo/hi3519/vou_reg.h` field `ih`; access and reset unknown, modelled RW)";
            sw = rw;
            hw = r;
        } ih[23:12];

        field {
            name = "iw";
            desc = "[inferred] Iw. (vendor header `product/hiosd/vo/hi3519/vou_reg.h` field `iw`; access and reset unknown, modelled RW)";
            sw = rw;
            hw = r;
        } iw[11:0];
    } V0_IRESO @ 0x828;

    reg {
        name = "V0 ORESO";
        desc = "[inferred] V0 ORESO. Not in the data sheet. Source: vendor U-Boot 2010.06 `product/hiosd/vo/hi3519/vou_reg.h` (GPL-2.0 U-Boot tree, HiSilicon copyright, created 2015-05-26; mirror github.com/OpenIPC/u-boot-hi3516cv200), union `U_V0_ORESO`, struct offset 0x82C (GPL-2.0, same-chip vendor header, byte-identical for Hi3516A V200 and Hi3519 V101). Reset value and access type unknown (modelled RW, no reset). Confidence: medium (vendor header for this chip family, not hardware verified).";

        field {
            name = "oh";
            desc = "[inferred] Oh. (vendor header `product/hiosd/vo/hi3519/vou_reg.h` field `oh`; access and reset unknown, modelled RW)";
            sw = rw;
            hw = r;
        } oh[23:12];

        field {
            name = "ow";
            desc = "[inferred] Ow. (vendor header `product/hiosd/vo/hi3519/vou_reg.h` field `ow`; access and reset unknown, modelled RW)";
            sw = rw;
            hw = r;
        } ow[11:0];
    } V0_ORESO @ 0x82C;

    reg {
        name = "V0 decompression SGMT CROP";
        desc = "[inferred] V0 decompression SGMT CROP. Not in the data sheet. Source: vendor U-Boot 2010.06 `product/hiosd/vo/hi3519/vou_reg.h` (GPL-2.0 U-Boot tree, HiSilicon copyright, created 2015-05-26; mirror github.com/OpenIPC/u-boot-hi3516cv200), union `U_V0_DCMP_SGMT_CROP`, struct offset 0x834 (GPL-2.0, same-chip vendor header, byte-identical for Hi3516A V200 and Hi3519 V101). Reset value and access type unknown (modelled RW, no reset). Confidence: medium (vendor header for this chip family, not hardware verified).";

        field {
            name = "dcmp_xlsgmt";
            desc = "[inferred] Decompression xlsgmt. (vendor header `product/hiosd/vo/hi3519/vou_reg.h` field `dcmp_xlsgmt`; access and reset unknown, modelled RW)";
            sw = rw;
            hw = r;
        } dcmp_xlsgmt[7:4];

        field {
            name = "dcmp_xfsgmt";
            desc = "[inferred] Decompression xfsgmt. (vendor header `product/hiosd/vo/hi3519/vou_reg.h` field `dcmp_xfsgmt`; access and reset unknown, modelled RW)";
            sw = rw;
            hw = r;
        } dcmp_xfsgmt[3:0];
    } V0_DCMP_SGMT_CROP @ 0x834;

    reg {
        name = "V0 CBMPARA";
        desc = "[inferred] V0 CBMPARA. Not in the data sheet. Source: vendor U-Boot 2010.06 `product/hiosd/vo/hi3519/vou_reg.h` (GPL-2.0 U-Boot tree, HiSilicon copyright, created 2015-05-26; mirror github.com/OpenIPC/u-boot-hi3516cv200), union `U_V0_CBMPARA`, struct offset 0x838 (GPL-2.0, same-chip vendor header, byte-identical for Hi3516A V200 and Hi3519 V101). Reset value and access type unknown (modelled RW, no reset). Confidence: medium (vendor header for this chip family, not hardware verified).";

        field {
            name = "galpha";
            desc = "[inferred] Galpha. (vendor header `product/hiosd/vo/hi3519/vou_reg.h` field `galpha`; access and reset unknown, modelled RW)";
            sw = rw;
            hw = r;
        } galpha[7:0];
    } V0_CBMPARA @ 0x838;

    reg {
        name = "V0 PARAUP";
        desc = "[inferred] V0 PARAUP. Not in the data sheet. Source: vendor U-Boot 2010.06 `product/hiosd/vo/hi3519/vou_reg.h` (GPL-2.0 U-Boot tree, HiSilicon copyright, created 2015-05-26; mirror github.com/OpenIPC/u-boot-hi3516cv200), union `U_V0_PARAUP`, struct offset 0x840 (GPL-2.0, same-chip vendor header, byte-identical for Hi3516A V200 and Hi3519 V101). Reset value and access type unknown (modelled RW, no reset). Confidence: medium (vendor header for this chip family, not hardware verified).";

        field {
            name = "v0_vccoef_upd";
            desc = "[inferred] V0 vccoef update. (vendor header `product/hiosd/vo/hi3519/vou_reg.h` field `v0_vccoef_upd`; access and reset unknown, modelled RW)";
            sw = rw;
            hw = r;
        } v0_vccoef_upd[3:3];

        field {
            name = "v0_vlcoef_upd";
            desc = "[inferred] V0 vlcoef update. (vendor header `product/hiosd/vo/hi3519/vou_reg.h` field `v0_vlcoef_upd`; access and reset unknown, modelled RW)";
            sw = rw;
            hw = r;
        } v0_vlcoef_upd[2:2];

        field {
            name = "v0_hccoef_upd";
            desc = "[inferred] V0 hccoef update. (vendor header `product/hiosd/vo/hi3519/vou_reg.h` field `v0_hccoef_upd`; access and reset unknown, modelled RW)";
            sw = rw;
            hw = r;
        } v0_hccoef_upd[1:1];

        field {
            name = "v0_hlcoef_upd";
            desc = "[inferred] V0 hlcoef update. (vendor header `product/hiosd/vo/hi3519/vou_reg.h` field `v0_hlcoef_upd`; access and reset unknown, modelled RW)";
            sw = rw;
            hw = r;
        } v0_hlcoef_upd[0:0];
    } V0_PARAUP @ 0x840;

    reg {
        name = "V0 CPOS";
        desc = "[inferred] V0 CPOS. Not in the data sheet. Source: vendor U-Boot 2010.06 `product/hiosd/vo/hi3519/vou_reg.h` (GPL-2.0 U-Boot tree, HiSilicon copyright, created 2015-05-26; mirror github.com/OpenIPC/u-boot-hi3516cv200), union `U_V0_CPOS`, struct offset 0x844 (GPL-2.0, same-chip vendor header, byte-identical for Hi3516A V200 and Hi3519 V101). Reset value and access type unknown (modelled RW, no reset). Confidence: medium (vendor header for this chip family, not hardware verified).";

        field {
            name = "src_xlpos";
            desc = "[inferred] Source xlpos. (vendor header `product/hiosd/vo/hi3519/vou_reg.h` field `src_xlpos`; access and reset unknown, modelled RW)";
            sw = rw;
            hw = r;
        } src_xlpos[23:12];

        field {
            name = "src_xfpos";
            desc = "[inferred] Source xfpos. (vendor header `product/hiosd/vo/hi3519/vou_reg.h` field `src_xfpos`; access and reset unknown, modelled RW)";
            sw = rw;
            hw = r;
        } src_xfpos[11:0];
    } V0_CPOS @ 0x844;

    reg {
        name = "V0 DRAWMODE";
        desc = "[inferred] V0 DRAWMODE. Not in the data sheet. Source: vendor U-Boot 2010.06 `product/hiosd/vo/hi3519/vou_reg.h` (GPL-2.0 U-Boot tree, HiSilicon copyright, created 2015-05-26; mirror github.com/OpenIPC/u-boot-hi3516cv200), union `U_V0_DRAWMODE`, struct offset 0x848 (GPL-2.0, same-chip vendor header, byte-identical for Hi3516A V200 and Hi3519 V101). Reset value and access type unknown (modelled RW, no reset). Confidence: medium (vendor header for this chip family, not hardware verified).";

        field {
            name = "draw_mode";
            desc = "[inferred] Draw mode. (vendor header `product/hiosd/vo/hi3519/vou_reg.h` field `draw_mode`; access and reset unknown, modelled RW)";
            sw = rw;
            hw = r;
        } draw_mode[1:0];
    } V0_DRAWMODE @ 0x848;

    reg {
        name = "V0 HLCOEFAD";
        desc = "[inferred] V0 HLCOEFAD. Not in the data sheet. Source: vendor U-Boot 2010.06 `product/hiosd/vo/hi3519/vou_reg.h` (GPL-2.0 U-Boot tree, HiSilicon copyright, created 2015-05-26; mirror github.com/OpenIPC/u-boot-hi3516cv200), union `U_V0_HLCOEFAD`, struct offset 0x850 (GPL-2.0, same-chip vendor header, byte-identical for Hi3516A V200 and Hi3519 V101). Reset value and access type unknown (modelled RW, no reset). Confidence: medium (vendor header for this chip family, not hardware verified).";

        field {
            name = "coef_addr";
            desc = "[inferred] Coefficient address. (vendor header `product/hiosd/vo/hi3519/vou_reg.h` field `coef_addr`; access and reset unknown, modelled RW)";
            sw = rw;
            hw = r;
        } coef_addr[31:0];
    } V0_HLCOEFAD @ 0x850;

    reg {
        name = "V0 HCCOEFAD";
        desc = "[inferred] V0 HCCOEFAD. Not in the data sheet. Source: vendor U-Boot 2010.06 `product/hiosd/vo/hi3519/vou_reg.h` (GPL-2.0 U-Boot tree, HiSilicon copyright, created 2015-05-26; mirror github.com/OpenIPC/u-boot-hi3516cv200), union `U_V0_HCCOEFAD`, struct offset 0x854 (GPL-2.0, same-chip vendor header, byte-identical for Hi3516A V200 and Hi3519 V101). Reset value and access type unknown (modelled RW, no reset). Confidence: medium (vendor header for this chip family, not hardware verified).";

        field {
            name = "coef_addr";
            desc = "[inferred] Coefficient address. (vendor header `product/hiosd/vo/hi3519/vou_reg.h` field `coef_addr`; access and reset unknown, modelled RW)";
            sw = rw;
            hw = r;
        } coef_addr[31:0];
    } V0_HCCOEFAD @ 0x854;

    reg {
        name = "V0 VLCOEFAD";
        desc = "[inferred] V0 VLCOEFAD. Not in the data sheet. Source: vendor U-Boot 2010.06 `product/hiosd/vo/hi3519/vou_reg.h` (GPL-2.0 U-Boot tree, HiSilicon copyright, created 2015-05-26; mirror github.com/OpenIPC/u-boot-hi3516cv200), union `U_V0_VLCOEFAD`, struct offset 0x858 (GPL-2.0, same-chip vendor header, byte-identical for Hi3516A V200 and Hi3519 V101). Reset value and access type unknown (modelled RW, no reset). Confidence: medium (vendor header for this chip family, not hardware verified).";

        field {
            name = "coef_addr";
            desc = "[inferred] Coefficient address. (vendor header `product/hiosd/vo/hi3519/vou_reg.h` field `coef_addr`; access and reset unknown, modelled RW)";
            sw = rw;
            hw = r;
        } coef_addr[31:0];
    } V0_VLCOEFAD @ 0x858;

    reg {
        name = "V0 VCCOEFAD";
        desc = "[inferred] V0 VCCOEFAD. Not in the data sheet. Source: vendor U-Boot 2010.06 `product/hiosd/vo/hi3519/vou_reg.h` (GPL-2.0 U-Boot tree, HiSilicon copyright, created 2015-05-26; mirror github.com/OpenIPC/u-boot-hi3516cv200), union `U_V0_VCCOEFAD`, struct offset 0x85C (GPL-2.0, same-chip vendor header, byte-identical for Hi3516A V200 and Hi3519 V101). Reset value and access type unknown (modelled RW, no reset). Confidence: medium (vendor header for this chip family, not hardware verified).";

        field {
            name = "coef_addr";
            desc = "[inferred] Coefficient address. (vendor header `product/hiosd/vo/hi3519/vou_reg.h` field `coef_addr`; access and reset unknown, modelled RW)";
            sw = rw;
            hw = r;
        } coef_addr[31:0];
    } V0_VCCOEFAD @ 0x85C;

    reg {
        name = "V0 DFPOS";
        desc = "[inferred] V0 DFPOS. Not in the data sheet. Source: vendor U-Boot 2010.06 `product/hiosd/vo/hi3519/vou_reg.h` (GPL-2.0 U-Boot tree, HiSilicon copyright, created 2015-05-26; mirror github.com/OpenIPC/u-boot-hi3516cv200), union `U_V0_DFPOS`, struct offset 0x860 (GPL-2.0, same-chip vendor header, byte-identical for Hi3516A V200 and Hi3519 V101). Reset value and access type unknown (modelled RW, no reset). Confidence: medium (vendor header for this chip family, not hardware verified).";

        field {
            name = "disp_yfpos";
            desc = "[inferred] Disp yfpos. (vendor header `product/hiosd/vo/hi3519/vou_reg.h` field `disp_yfpos`; access and reset unknown, modelled RW)";
            sw = rw;
            hw = r;
        } disp_yfpos[23:12];

        field {
            name = "disp_xfpos";
            desc = "[inferred] Disp xfpos. (vendor header `product/hiosd/vo/hi3519/vou_reg.h` field `disp_xfpos`; access and reset unknown, modelled RW)";
            sw = rw;
            hw = r;
        } disp_xfpos[11:0];
    } V0_DFPOS @ 0x860;

    reg {
        name = "V0 DLPOS";
        desc = "[inferred] V0 DLPOS. Not in the data sheet. Source: vendor U-Boot 2010.06 `product/hiosd/vo/hi3519/vou_reg.h` (GPL-2.0 U-Boot tree, HiSilicon copyright, created 2015-05-26; mirror github.com/OpenIPC/u-boot-hi3516cv200), union `U_V0_DLPOS`, struct offset 0x864 (GPL-2.0, same-chip vendor header, byte-identical for Hi3516A V200 and Hi3519 V101). Reset value and access type unknown (modelled RW, no reset). Confidence: medium (vendor header for this chip family, not hardware verified).";

        field {
            name = "disp_ylpos";
            desc = "[inferred] Disp ylpos. (vendor header `product/hiosd/vo/hi3519/vou_reg.h` field `disp_ylpos`; access and reset unknown, modelled RW)";
            sw = rw;
            hw = r;
        } disp_ylpos[23:12];

        field {
            name = "disp_xlpos";
            desc = "[inferred] Disp xlpos. (vendor header `product/hiosd/vo/hi3519/vou_reg.h` field `disp_xlpos`; access and reset unknown, modelled RW)";
            sw = rw;
            hw = r;
        } disp_xlpos[11:0];
    } V0_DLPOS @ 0x864;

    reg {
        name = "V0 VFPOS";
        desc = "[inferred] V0 VFPOS. Not in the data sheet. Source: vendor U-Boot 2010.06 `product/hiosd/vo/hi3519/vou_reg.h` (GPL-2.0 U-Boot tree, HiSilicon copyright, created 2015-05-26; mirror github.com/OpenIPC/u-boot-hi3516cv200), union `U_V0_VFPOS`, struct offset 0x868 (GPL-2.0, same-chip vendor header, byte-identical for Hi3516A V200 and Hi3519 V101). Reset value and access type unknown (modelled RW, no reset). Confidence: medium (vendor header for this chip family, not hardware verified).";

        field {
            name = "video_yfpos";
            desc = "[inferred] Video yfpos. (vendor header `product/hiosd/vo/hi3519/vou_reg.h` field `video_yfpos`; access and reset unknown, modelled RW)";
            sw = rw;
            hw = r;
        } video_yfpos[23:12];

        field {
            name = "video_xfpos";
            desc = "[inferred] Video xfpos. (vendor header `product/hiosd/vo/hi3519/vou_reg.h` field `video_xfpos`; access and reset unknown, modelled RW)";
            sw = rw;
            hw = r;
        } video_xfpos[11:0];
    } V0_VFPOS @ 0x868;

    reg {
        name = "V0 VLPOS";
        desc = "[inferred] V0 VLPOS. Not in the data sheet. Source: vendor U-Boot 2010.06 `product/hiosd/vo/hi3519/vou_reg.h` (GPL-2.0 U-Boot tree, HiSilicon copyright, created 2015-05-26; mirror github.com/OpenIPC/u-boot-hi3516cv200), union `U_V0_VLPOS`, struct offset 0x86C (GPL-2.0, same-chip vendor header, byte-identical for Hi3516A V200 and Hi3519 V101). Reset value and access type unknown (modelled RW, no reset). Confidence: medium (vendor header for this chip family, not hardware verified).";

        field {
            name = "video_ylpos";
            desc = "[inferred] Video ylpos. (vendor header `product/hiosd/vo/hi3519/vou_reg.h` field `video_ylpos`; access and reset unknown, modelled RW)";
            sw = rw;
            hw = r;
        } video_ylpos[23:12];

        field {
            name = "video_xlpos";
            desc = "[inferred] Video xlpos. (vendor header `product/hiosd/vo/hi3519/vou_reg.h` field `video_xlpos`; access and reset unknown, modelled RW)";
            sw = rw;
            hw = r;
        } video_xlpos[11:0];
    } V0_VLPOS @ 0x86C;

    reg {
        name = "V0 background";
        desc = "[inferred] V0 background. Not in the data sheet. Source: vendor U-Boot 2010.06 `product/hiosd/vo/hi3519/vou_reg.h` (GPL-2.0 U-Boot tree, HiSilicon copyright, created 2015-05-26; mirror github.com/OpenIPC/u-boot-hi3516cv200), union `U_V0_BK`, struct offset 0x870 (GPL-2.0, same-chip vendor header, byte-identical for Hi3516A V200 and Hi3519 V101). Reset value and access type unknown (modelled RW, no reset). Confidence: medium (vendor header for this chip family, not hardware verified).";

        field {
            name = "vbk_y";
            desc = "[inferred] Vbk y. (vendor header `product/hiosd/vo/hi3519/vou_reg.h` field `vbk_y`; access and reset unknown, modelled RW)";
            sw = rw;
            hw = r;
        } vbk_y[29:20];

        field {
            name = "vbk_cb";
            desc = "[inferred] Vbk cb. (vendor header `product/hiosd/vo/hi3519/vou_reg.h` field `vbk_cb`; access and reset unknown, modelled RW)";
            sw = rw;
            hw = r;
        } vbk_cb[19:10];

        field {
            name = "vbk_cr";
            desc = "[inferred] Vbk cr. (vendor header `product/hiosd/vo/hi3519/vou_reg.h` field `vbk_cr`; access and reset unknown, modelled RW)";
            sw = rw;
            hw = r;
        } vbk_cr[9:0];
    } V0_BK @ 0x870;

    reg {
        name = "V0 alpha";
        desc = "[inferred] V0 alpha. Not in the data sheet. Source: vendor U-Boot 2010.06 `product/hiosd/vo/hi3519/vou_reg.h` (GPL-2.0 U-Boot tree, HiSilicon copyright, created 2015-05-26; mirror github.com/OpenIPC/u-boot-hi3516cv200), union `U_V0_ALPHA`, struct offset 0x874 (GPL-2.0, same-chip vendor header, byte-identical for Hi3516A V200 and Hi3519 V101). Reset value and access type unknown (modelled RW, no reset). Confidence: medium (vendor header for this chip family, not hardware verified).";

        field {
            name = "vbk_alpha";
            desc = "[inferred] Vbk alpha. (vendor header `product/hiosd/vo/hi3519/vou_reg.h` field `vbk_alpha`; access and reset unknown, modelled RW)";
            sw = rw;
            hw = r;
        } vbk_alpha[7:0];
    } V0_ALPHA @ 0x874;

    reg {
        name = "V0 colour-space conversion IDC";
        desc = "[inferred] V0 colour-space conversion IDC. Not in the data sheet. Source: vendor U-Boot 2010.06 `product/hiosd/vo/hi3519/vou_reg.h` (GPL-2.0 U-Boot tree, HiSilicon copyright, created 2015-05-26; mirror github.com/OpenIPC/u-boot-hi3516cv200), union `U_V0_CSC_IDC`, struct offset 0x880 (GPL-2.0, same-chip vendor header, byte-identical for Hi3516A V200 and Hi3519 V101). Reset value and access type unknown (modelled RW, no reset). Confidence: medium (vendor header for this chip family, not hardware verified).";

        field {
            name = "csc_en";
            desc = "[inferred] Colour-space conversion enable. (vendor header `product/hiosd/vo/hi3519/vou_reg.h` field `csc_en`; access and reset unknown, modelled RW)";
            sw = rw;
            hw = r;
        } csc_en[22:22];

        field {
            name = "cscidc1";
            desc = "[inferred] Cscidc1. (vendor header `product/hiosd/vo/hi3519/vou_reg.h` field `cscidc1`; access and reset unknown, modelled RW)";
            sw = rw;
            hw = r;
        } cscidc1[21:11];

        field {
            name = "cscidc0";
            desc = "[inferred] Cscidc0. (vendor header `product/hiosd/vo/hi3519/vou_reg.h` field `cscidc0`; access and reset unknown, modelled RW)";
            sw = rw;
            hw = r;
        } cscidc0[10:0];
    } V0_CSC_IDC @ 0x880;

    reg {
        name = "V0 colour-space conversion ODC";
        desc = "[inferred] V0 colour-space conversion ODC. Not in the data sheet. Source: vendor U-Boot 2010.06 `product/hiosd/vo/hi3519/vou_reg.h` (GPL-2.0 U-Boot tree, HiSilicon copyright, created 2015-05-26; mirror github.com/OpenIPC/u-boot-hi3516cv200), union `U_V0_CSC_ODC`, struct offset 0x884 (GPL-2.0, same-chip vendor header, byte-identical for Hi3516A V200 and Hi3519 V101). Reset value and access type unknown (modelled RW, no reset). Confidence: medium (vendor header for this chip family, not hardware verified).";

        field {
            name = "csc_sign_mode";
            desc = "[inferred] Colour-space conversion sign mode. (vendor header `product/hiosd/vo/hi3519/vou_reg.h` field `csc_sign_mode`; access and reset unknown, modelled RW)";
            sw = rw;
            hw = r;
        } csc_sign_mode[22:22];

        field {
            name = "cscodc1";
            desc = "[inferred] Cscodc1. (vendor header `product/hiosd/vo/hi3519/vou_reg.h` field `cscodc1`; access and reset unknown, modelled RW)";
            sw = rw;
            hw = r;
        } cscodc1[21:11];

        field {
            name = "cscodc0";
            desc = "[inferred] Cscodc0. (vendor header `product/hiosd/vo/hi3519/vou_reg.h` field `cscodc0`; access and reset unknown, modelled RW)";
            sw = rw;
            hw = r;
        } cscodc0[10:0];
    } V0_CSC_ODC @ 0x884;

    reg {
        name = "V0 colour-space conversion IODC";
        desc = "[inferred] V0 colour-space conversion IODC. Not in the data sheet. Source: vendor U-Boot 2010.06 `product/hiosd/vo/hi3519/vou_reg.h` (GPL-2.0 U-Boot tree, HiSilicon copyright, created 2015-05-26; mirror github.com/OpenIPC/u-boot-hi3516cv200), union `U_V0_CSC_IODC`, struct offset 0x888 (GPL-2.0, same-chip vendor header, byte-identical for Hi3516A V200 and Hi3519 V101). Reset value and access type unknown (modelled RW, no reset). Confidence: medium (vendor header for this chip family, not hardware verified).";

        field {
            name = "cscodc2";
            desc = "[inferred] Cscodc2. (vendor header `product/hiosd/vo/hi3519/vou_reg.h` field `cscodc2`; access and reset unknown, modelled RW)";
            sw = rw;
            hw = r;
        } cscodc2[21:11];

        field {
            name = "cscidc2";
            desc = "[inferred] Cscidc2. (vendor header `product/hiosd/vo/hi3519/vou_reg.h` field `cscidc2`; access and reset unknown, modelled RW)";
            sw = rw;
            hw = r;
        } cscidc2[10:0];
    } V0_CSC_IODC @ 0x888;

    reg {
        name = "V0 colour-space conversion P0";
        desc = "[inferred] V0 colour-space conversion P0. Not in the data sheet. Source: vendor U-Boot 2010.06 `product/hiosd/vo/hi3519/vou_reg.h` (GPL-2.0 U-Boot tree, HiSilicon copyright, created 2015-05-26; mirror github.com/OpenIPC/u-boot-hi3516cv200), union `U_V0_CSC_P0`, struct offset 0x88C (GPL-2.0, same-chip vendor header, byte-identical for Hi3516A V200 and Hi3519 V101). Reset value and access type unknown (modelled RW, no reset). Confidence: medium (vendor header for this chip family, not hardware verified).";

        field {
            name = "cscp01";
            desc = "[inferred] Cscp01. (vendor header `product/hiosd/vo/hi3519/vou_reg.h` field `cscp01`; access and reset unknown, modelled RW)";
            sw = rw;
            hw = r;
        } cscp01[30:16];

        field {
            name = "cscp00";
            desc = "[inferred] Cscp00. (vendor header `product/hiosd/vo/hi3519/vou_reg.h` field `cscp00`; access and reset unknown, modelled RW)";
            sw = rw;
            hw = r;
        } cscp00[14:0];
    } V0_CSC_P0 @ 0x88C;

    reg {
        name = "V0 colour-space conversion P1";
        desc = "[inferred] V0 colour-space conversion P1. Not in the data sheet. Source: vendor U-Boot 2010.06 `product/hiosd/vo/hi3519/vou_reg.h` (GPL-2.0 U-Boot tree, HiSilicon copyright, created 2015-05-26; mirror github.com/OpenIPC/u-boot-hi3516cv200), union `U_V0_CSC_P1`, struct offset 0x890 (GPL-2.0, same-chip vendor header, byte-identical for Hi3516A V200 and Hi3519 V101). Reset value and access type unknown (modelled RW, no reset). Confidence: medium (vendor header for this chip family, not hardware verified).";

        field {
            name = "cscp10";
            desc = "[inferred] Cscp10. (vendor header `product/hiosd/vo/hi3519/vou_reg.h` field `cscp10`; access and reset unknown, modelled RW)";
            sw = rw;
            hw = r;
        } cscp10[30:16];

        field {
            name = "cscp02";
            desc = "[inferred] Cscp02. (vendor header `product/hiosd/vo/hi3519/vou_reg.h` field `cscp02`; access and reset unknown, modelled RW)";
            sw = rw;
            hw = r;
        } cscp02[14:0];
    } V0_CSC_P1 @ 0x890;

    reg {
        name = "V0 colour-space conversion P2";
        desc = "[inferred] V0 colour-space conversion P2. Not in the data sheet. Source: vendor U-Boot 2010.06 `product/hiosd/vo/hi3519/vou_reg.h` (GPL-2.0 U-Boot tree, HiSilicon copyright, created 2015-05-26; mirror github.com/OpenIPC/u-boot-hi3516cv200), union `U_V0_CSC_P2`, struct offset 0x894 (GPL-2.0, same-chip vendor header, byte-identical for Hi3516A V200 and Hi3519 V101). Reset value and access type unknown (modelled RW, no reset). Confidence: medium (vendor header for this chip family, not hardware verified).";

        field {
            name = "cscp12";
            desc = "[inferred] Cscp12. (vendor header `product/hiosd/vo/hi3519/vou_reg.h` field `cscp12`; access and reset unknown, modelled RW)";
            sw = rw;
            hw = r;
        } cscp12[30:16];

        field {
            name = "cscp11";
            desc = "[inferred] Cscp11. (vendor header `product/hiosd/vo/hi3519/vou_reg.h` field `cscp11`; access and reset unknown, modelled RW)";
            sw = rw;
            hw = r;
        } cscp11[14:0];
    } V0_CSC_P2 @ 0x894;

    reg {
        name = "V0 colour-space conversion P3";
        desc = "[inferred] V0 colour-space conversion P3. Not in the data sheet. Source: vendor U-Boot 2010.06 `product/hiosd/vo/hi3519/vou_reg.h` (GPL-2.0 U-Boot tree, HiSilicon copyright, created 2015-05-26; mirror github.com/OpenIPC/u-boot-hi3516cv200), union `U_V0_CSC_P3`, struct offset 0x898 (GPL-2.0, same-chip vendor header, byte-identical for Hi3516A V200 and Hi3519 V101). Reset value and access type unknown (modelled RW, no reset). Confidence: medium (vendor header for this chip family, not hardware verified).";

        field {
            name = "cscp21";
            desc = "[inferred] Cscp21. (vendor header `product/hiosd/vo/hi3519/vou_reg.h` field `cscp21`; access and reset unknown, modelled RW)";
            sw = rw;
            hw = r;
        } cscp21[30:16];

        field {
            name = "cscp20";
            desc = "[inferred] Cscp20. (vendor header `product/hiosd/vo/hi3519/vou_reg.h` field `cscp20`; access and reset unknown, modelled RW)";
            sw = rw;
            hw = r;
        } cscp20[14:0];
    } V0_CSC_P3 @ 0x898;

    reg {
        name = "V0 colour-space conversion P4";
        desc = "[inferred] V0 colour-space conversion P4. Not in the data sheet. Source: vendor U-Boot 2010.06 `product/hiosd/vo/hi3519/vou_reg.h` (GPL-2.0 U-Boot tree, HiSilicon copyright, created 2015-05-26; mirror github.com/OpenIPC/u-boot-hi3516cv200), union `U_V0_CSC_P4`, struct offset 0x89C (GPL-2.0, same-chip vendor header, byte-identical for Hi3516A V200 and Hi3519 V101). Reset value and access type unknown (modelled RW, no reset). Confidence: medium (vendor header for this chip family, not hardware verified).";

        field {
            name = "cscp22";
            desc = "[inferred] Cscp22. (vendor header `product/hiosd/vo/hi3519/vou_reg.h` field `cscp22`; access and reset unknown, modelled RW)";
            sw = rw;
            hw = r;
        } cscp22[14:0];
    } V0_CSC_P4 @ 0x89C;

    reg {
        name = "V0 HSP";
        desc = "[inferred] V0 HSP. Not in the data sheet. Source: vendor U-Boot 2010.06 `product/hiosd/vo/hi3519/vou_reg.h` (GPL-2.0 U-Boot tree, HiSilicon copyright, created 2015-05-26; mirror github.com/OpenIPC/u-boot-hi3516cv200), union `U_V0_HSP`, struct offset 0x8C0 (GPL-2.0, same-chip vendor header, byte-identical for Hi3516A V200 and Hi3519 V101). Reset value and access type unknown (modelled RW, no reset). Confidence: medium (vendor header for this chip family, not hardware verified).";

        field {
            name = "hlmsc_en";
            desc = "[inferred] Hlmsc enable. (vendor header `product/hiosd/vo/hi3519/vou_reg.h` field `hlmsc_en`; access and reset unknown, modelled RW)";
            sw = rw;
            hw = r;
        } hlmsc_en[31:31];

        field {
            name = "hchmsc_en";
            desc = "[inferred] Hchmsc enable. (vendor header `product/hiosd/vo/hi3519/vou_reg.h` field `hchmsc_en`; access and reset unknown, modelled RW)";
            sw = rw;
            hw = r;
        } hchmsc_en[30:30];

        field {
            name = "hlmid_en";
            desc = "[inferred] Hlmid enable. (vendor header `product/hiosd/vo/hi3519/vou_reg.h` field `hlmid_en`; access and reset unknown, modelled RW)";
            sw = rw;
            hw = r;
        } hlmid_en[29:29];

        field {
            name = "hchmid_en";
            desc = "[inferred] Hchmid enable. (vendor header `product/hiosd/vo/hi3519/vou_reg.h` field `hchmid_en`; access and reset unknown, modelled RW)";
            sw = rw;
            hw = r;
        } hchmid_en[28:28];

        field {
            name = "non_lnr_en";
            desc = "[inferred] Non lnr enable. (vendor header `product/hiosd/vo/hi3519/vou_reg.h` field `non_lnr_en`; access and reset unknown, modelled RW)";
            sw = rw;
            hw = r;
        } non_lnr_en[27:27];

        field {
            name = "hlfir_en";
            desc = "[inferred] Hlfir enable. (vendor header `product/hiosd/vo/hi3519/vou_reg.h` field `hlfir_en`; access and reset unknown, modelled RW)";
            sw = rw;
            hw = r;
        } hlfir_en[26:26];

        field {
            name = "hchfir_en";
            desc = "[inferred] Hchfir enable. (vendor header `product/hiosd/vo/hi3519/vou_reg.h` field `hchfir_en`; access and reset unknown, modelled RW)";
            sw = rw;
            hw = r;
        } hchfir_en[25:25];

        field {
            name = "hfir_order";
            desc = "[inferred] Hfir order. (vendor header `product/hiosd/vo/hi3519/vou_reg.h` field `hfir_order`; access and reset unknown, modelled RW)";
            sw = rw;
            hw = r;
        } hfir_order[24:24];

        field {
            name = "hratio";
            desc = "[inferred] Hratio. (vendor header `product/hiosd/vo/hi3519/vou_reg.h` field `hratio`; access and reset unknown, modelled RW)";
            sw = rw;
            hw = r;
        } hratio[23:0];
    } V0_HSP @ 0x8C0;

    reg {
        name = "V0 HLOFFSET";
        desc = "[inferred] V0 HLOFFSET. Not in the data sheet. Source: vendor U-Boot 2010.06 `product/hiosd/vo/hi3519/vou_reg.h` (GPL-2.0 U-Boot tree, HiSilicon copyright, created 2015-05-26; mirror github.com/OpenIPC/u-boot-hi3516cv200), union `U_V0_HLOFFSET`, struct offset 0x8C4 (GPL-2.0, same-chip vendor header, byte-identical for Hi3516A V200 and Hi3519 V101). Reset value and access type unknown (modelled RW, no reset). Confidence: medium (vendor header for this chip family, not hardware verified).";

        field {
            name = "hor_loffset";
            desc = "[inferred] Hor loffset. (vendor header `product/hiosd/vo/hi3519/vou_reg.h` field `hor_loffset`; access and reset unknown, modelled RW)";
            sw = rw;
            hw = r;
        } hor_loffset[27:0];
    } V0_HLOFFSET @ 0x8C4;

    reg {
        name = "V0 HCOFFSET";
        desc = "[inferred] V0 HCOFFSET. Not in the data sheet. Source: vendor U-Boot 2010.06 `product/hiosd/vo/hi3519/vou_reg.h` (GPL-2.0 U-Boot tree, HiSilicon copyright, created 2015-05-26; mirror github.com/OpenIPC/u-boot-hi3516cv200), union `U_V0_HCOFFSET`, struct offset 0x8C8 (GPL-2.0, same-chip vendor header, byte-identical for Hi3516A V200 and Hi3519 V101). Reset value and access type unknown (modelled RW, no reset). Confidence: medium (vendor header for this chip family, not hardware verified).";

        field {
            name = "hor_coffset";
            desc = "[inferred] Hor coffset. (vendor header `product/hiosd/vo/hi3519/vou_reg.h` field `hor_coffset`; access and reset unknown, modelled RW)";
            sw = rw;
            hw = r;
        } hor_coffset[27:0];
    } V0_HCOFFSET @ 0x8C8;

    reg {
        name = "V0 VSP";
        desc = "[inferred] V0 VSP. Not in the data sheet. Source: vendor U-Boot 2010.06 `product/hiosd/vo/hi3519/vou_reg.h` (GPL-2.0 U-Boot tree, HiSilicon copyright, created 2015-05-26; mirror github.com/OpenIPC/u-boot-hi3516cv200), union `U_V0_VSP`, struct offset 0x8D8 (GPL-2.0, same-chip vendor header, byte-identical for Hi3516A V200 and Hi3519 V101). Reset value and access type unknown (modelled RW, no reset). Confidence: medium (vendor header for this chip family, not hardware verified).";

        field {
            name = "vlmsc_en";
            desc = "[inferred] Vlmsc enable. (vendor header `product/hiosd/vo/hi3519/vou_reg.h` field `vlmsc_en`; access and reset unknown, modelled RW)";
            sw = rw;
            hw = r;
        } vlmsc_en[31:31];

        field {
            name = "vchmsc_en";
            desc = "[inferred] Vchmsc enable. (vendor header `product/hiosd/vo/hi3519/vou_reg.h` field `vchmsc_en`; access and reset unknown, modelled RW)";
            sw = rw;
            hw = r;
        } vchmsc_en[30:30];

        field {
            name = "vlmid_en";
            desc = "[inferred] Vlmid enable. (vendor header `product/hiosd/vo/hi3519/vou_reg.h` field `vlmid_en`; access and reset unknown, modelled RW)";
            sw = rw;
            hw = r;
        } vlmid_en[29:29];

        field {
            name = "vchmid_en";
            desc = "[inferred] Vchmid enable. (vendor header `product/hiosd/vo/hi3519/vou_reg.h` field `vchmid_en`; access and reset unknown, modelled RW)";
            sw = rw;
            hw = r;
        } vchmid_en[28:28];

        field {
            name = "vsc_chroma_tap";
            desc = "[inferred] Vsc chroma tap. (vendor header `product/hiosd/vo/hi3519/vou_reg.h` field `vsc_chroma_tap`; access and reset unknown, modelled RW)";
            sw = rw;
            hw = r;
        } vsc_chroma_tap[26:26];

        field {
            name = "vlfir_en";
            desc = "[inferred] Vlfir enable. (vendor header `product/hiosd/vo/hi3519/vou_reg.h` field `vlfir_en`; access and reset unknown, modelled RW)";
            sw = rw;
            hw = r;
        } vlfir_en[24:24];

        field {
            name = "vchfir_en";
            desc = "[inferred] Vchfir enable. (vendor header `product/hiosd/vo/hi3519/vou_reg.h` field `vchfir_en`; access and reset unknown, modelled RW)";
            sw = rw;
            hw = r;
        } vchfir_en[23:23];

        field {
            name = "zme_out_fmt";
            desc = "[inferred] Scaler out format. (vendor header `product/hiosd/vo/hi3519/vou_reg.h` field `zme_out_fmt`; access and reset unknown, modelled RW)";
            sw = rw;
            hw = r;
        } zme_out_fmt[22:21];

        field {
            name = "zme_in_fmt";
            desc = "[inferred] Scaler in format. (vendor header `product/hiosd/vo/hi3519/vou_reg.h` field `zme_in_fmt`; access and reset unknown, modelled RW)";
            sw = rw;
            hw = r;
        } zme_in_fmt[20:19];
    } V0_VSP @ 0x8D8;

    reg {
        name = "V0 VSR";
        desc = "[inferred] V0 VSR. Not in the data sheet. Source: vendor U-Boot 2010.06 `product/hiosd/vo/hi3519/vou_reg.h` (GPL-2.0 U-Boot tree, HiSilicon copyright, created 2015-05-26; mirror github.com/OpenIPC/u-boot-hi3516cv200), union `U_V0_VSR`, struct offset 0x8DC (GPL-2.0, same-chip vendor header, byte-identical for Hi3516A V200 and Hi3519 V101). Reset value and access type unknown (modelled RW, no reset). Confidence: medium (vendor header for this chip family, not hardware verified).";

        field {
            name = "vratio";
            desc = "[inferred] Vratio. (vendor header `product/hiosd/vo/hi3519/vou_reg.h` field `vratio`; access and reset unknown, modelled RW)";
            sw = rw;
            hw = r;
        } vratio[15:0];
    } V0_VSR @ 0x8DC;

    reg {
        name = "V0 VOFFSET";
        desc = "[inferred] V0 VOFFSET. Not in the data sheet. Source: vendor U-Boot 2010.06 `product/hiosd/vo/hi3519/vou_reg.h` (GPL-2.0 U-Boot tree, HiSilicon copyright, created 2015-05-26; mirror github.com/OpenIPC/u-boot-hi3516cv200), union `U_V0_VOFFSET`, struct offset 0x8E0 (GPL-2.0, same-chip vendor header, byte-identical for Hi3516A V200 and Hi3519 V101). Reset value and access type unknown (modelled RW, no reset). Confidence: medium (vendor header for this chip family, not hardware verified).";

        field {
            name = "vluma_offset";
            desc = "[inferred] Vluma offset. (vendor header `product/hiosd/vo/hi3519/vou_reg.h` field `vluma_offset`; access and reset unknown, modelled RW)";
            sw = rw;
            hw = r;
        } vluma_offset[31:16];

        field {
            name = "vchroma_offset";
            desc = "[inferred] Vchroma offset. (vendor header `product/hiosd/vo/hi3519/vou_reg.h` field `vchroma_offset`; access and reset unknown, modelled RW)";
            sw = rw;
            hw = r;
        } vchroma_offset[15:0];
    } V0_VOFFSET @ 0x8E0;

    reg {
        name = "V0 VBOFFSET";
        desc = "[inferred] V0 VBOFFSET. Not in the data sheet. Source: vendor U-Boot 2010.06 `product/hiosd/vo/hi3519/vou_reg.h` (GPL-2.0 U-Boot tree, HiSilicon copyright, created 2015-05-26; mirror github.com/OpenIPC/u-boot-hi3516cv200), union `U_V0_VBOFFSET`, struct offset 0x8E4 (GPL-2.0, same-chip vendor header, byte-identical for Hi3516A V200 and Hi3519 V101). Reset value and access type unknown (modelled RW, no reset). Confidence: medium (vendor header for this chip family, not hardware verified).";

        field {
            name = "vbluma_offset";
            desc = "[inferred] Vbluma offset. (vendor header `product/hiosd/vo/hi3519/vou_reg.h` field `vbluma_offset`; access and reset unknown, modelled RW)";
            sw = rw;
            hw = r;
        } vbluma_offset[31:16];

        field {
            name = "vbchroma_offset";
            desc = "[inferred] Vbchroma offset. (vendor header `product/hiosd/vo/hi3519/vou_reg.h` field `vbchroma_offset`; access and reset unknown, modelled RW)";
            sw = rw;
            hw = r;
        } vbchroma_offset[15:0];
    } V0_VBOFFSET @ 0x8E4;

    reg {
        name = "V0 IFIRCOEF01";
        desc = "[inferred] V0 IFIRCOEF01. Not in the data sheet. Source: vendor U-Boot 2010.06 `product/hiosd/vo/hi3519/vou_reg.h` (GPL-2.0 U-Boot tree, HiSilicon copyright, created 2015-05-26; mirror github.com/OpenIPC/u-boot-hi3516cv200), union `U_V0_IFIRCOEF01`, struct offset 0x980 (GPL-2.0, same-chip vendor header, byte-identical for Hi3516A V200 and Hi3519 V101). Reset value and access type unknown (modelled RW, no reset). Confidence: medium (vendor header for this chip family, not hardware verified).";

        field {
            name = "coef1";
            desc = "[inferred] Coef1. (vendor header `product/hiosd/vo/hi3519/vou_reg.h` field `coef1`; access and reset unknown, modelled RW)";
            sw = rw;
            hw = r;
        } coef1[25:16];

        field {
            name = "coef0";
            desc = "[inferred] Coef0. (vendor header `product/hiosd/vo/hi3519/vou_reg.h` field `coef0`; access and reset unknown, modelled RW)";
            sw = rw;
            hw = r;
        } coef0[9:0];
    } V0_IFIRCOEF01 @ 0x980;

    reg {
        name = "V0 IFIRCOEF23";
        desc = "[inferred] V0 IFIRCOEF23. Not in the data sheet. Source: vendor U-Boot 2010.06 `product/hiosd/vo/hi3519/vou_reg.h` (GPL-2.0 U-Boot tree, HiSilicon copyright, created 2015-05-26; mirror github.com/OpenIPC/u-boot-hi3516cv200), union `U_V0_IFIRCOEF23`, struct offset 0x984 (GPL-2.0, same-chip vendor header, byte-identical for Hi3516A V200 and Hi3519 V101). Reset value and access type unknown (modelled RW, no reset). Confidence: medium (vendor header for this chip family, not hardware verified).";

        field {
            name = "coef3";
            desc = "[inferred] Coef3. (vendor header `product/hiosd/vo/hi3519/vou_reg.h` field `coef3`; access and reset unknown, modelled RW)";
            sw = rw;
            hw = r;
        } coef3[25:16];

        field {
            name = "coef2";
            desc = "[inferred] Coef2. (vendor header `product/hiosd/vo/hi3519/vou_reg.h` field `coef2`; access and reset unknown, modelled RW)";
            sw = rw;
            hw = r;
        } coef2[9:0];
    } V0_IFIRCOEF23 @ 0x984;

    reg {
        name = "V0 IFIRCOEF45";
        desc = "[inferred] V0 IFIRCOEF45. Not in the data sheet. Source: vendor U-Boot 2010.06 `product/hiosd/vo/hi3519/vou_reg.h` (GPL-2.0 U-Boot tree, HiSilicon copyright, created 2015-05-26; mirror github.com/OpenIPC/u-boot-hi3516cv200), union `U_V0_IFIRCOEF45`, struct offset 0x988 (GPL-2.0, same-chip vendor header, byte-identical for Hi3516A V200 and Hi3519 V101). Reset value and access type unknown (modelled RW, no reset). Confidence: medium (vendor header for this chip family, not hardware verified).";

        field {
            name = "coef5";
            desc = "[inferred] Coef5. (vendor header `product/hiosd/vo/hi3519/vou_reg.h` field `coef5`; access and reset unknown, modelled RW)";
            sw = rw;
            hw = r;
        } coef5[25:16];

        field {
            name = "coef4";
            desc = "[inferred] Coef4. (vendor header `product/hiosd/vo/hi3519/vou_reg.h` field `coef4`; access and reset unknown, modelled RW)";
            sw = rw;
            hw = r;
        } coef4[9:0];
    } V0_IFIRCOEF45 @ 0x988;

    reg {
        name = "V0 IFIRCOEF67";
        desc = "[inferred] V0 IFIRCOEF67. Not in the data sheet. Source: vendor U-Boot 2010.06 `product/hiosd/vo/hi3519/vou_reg.h` (GPL-2.0 U-Boot tree, HiSilicon copyright, created 2015-05-26; mirror github.com/OpenIPC/u-boot-hi3516cv200), union `U_V0_IFIRCOEF67`, struct offset 0x98C (GPL-2.0, same-chip vendor header, byte-identical for Hi3516A V200 and Hi3519 V101). Reset value and access type unknown (modelled RW, no reset). Confidence: medium (vendor header for this chip family, not hardware verified).";

        field {
            name = "coef7";
            desc = "[inferred] Coef7. (vendor header `product/hiosd/vo/hi3519/vou_reg.h` field `coef7`; access and reset unknown, modelled RW)";
            sw = rw;
            hw = r;
        } coef7[25:16];

        field {
            name = "coef6";
            desc = "[inferred] Coef6. (vendor header `product/hiosd/vo/hi3519/vou_reg.h` field `coef6`; access and reset unknown, modelled RW)";
            sw = rw;
            hw = r;
        } coef6[9:0];
    } V0_IFIRCOEF67 @ 0x98C;

    reg {
        name = "V0 P0RESO";
        desc = "[inferred] V0 P0RESO. Not in the data sheet. Source: vendor U-Boot 2010.06 `product/hiosd/vo/hi3519/vou_reg.h` (GPL-2.0 U-Boot tree, HiSilicon copyright, created 2015-05-26; mirror github.com/OpenIPC/u-boot-hi3516cv200), union `U_V0_P0RESO`, struct offset 0xA00 (GPL-2.0, same-chip vendor header, byte-identical for Hi3516A V200 and Hi3519 V101). Reset value and access type unknown (modelled RW, no reset). Confidence: medium (vendor header for this chip family, not hardware verified).";

        field {
            name = "w";
            desc = "[inferred] W. (vendor header `product/hiosd/vo/hi3519/vou_reg.h` field `w`; access and reset unknown, modelled RW)";
            sw = rw;
            hw = r;
        } w_f[11:0];
    } V0_P0RESO @ 0xA00;

    reg {
        name = "V0 P0LADDR";
        desc = "[inferred] V0 P0LADDR. Not in the data sheet. Source: vendor U-Boot 2010.06 `product/hiosd/vo/hi3519/vou_reg.h` (GPL-2.0 U-Boot tree, HiSilicon copyright, created 2015-05-26; mirror github.com/OpenIPC/u-boot-hi3516cv200), union `U_V0_P0LADDR`, struct offset 0xA04 (GPL-2.0, same-chip vendor header, byte-identical for Hi3516A V200 and Hi3519 V101). Reset value and access type unknown (modelled RW, no reset). Confidence: medium (vendor header for this chip family, not hardware verified).";

        field {
            name = "surface_addr";
            desc = "[inferred] Surface address. (vendor header `product/hiosd/vo/hi3519/vou_reg.h` field `surface_addr`; access and reset unknown, modelled RW)";
            sw = rw;
            hw = r;
        } surface_addr[31:0];
    } V0_P0LADDR @ 0xA04;

    reg {
        name = "V0 P0CADDR";
        desc = "[inferred] V0 P0CADDR. Not in the data sheet. Source: vendor U-Boot 2010.06 `product/hiosd/vo/hi3519/vou_reg.h` (GPL-2.0 U-Boot tree, HiSilicon copyright, created 2015-05-26; mirror github.com/OpenIPC/u-boot-hi3516cv200), union `U_V0_P0CADDR`, struct offset 0xA08 (GPL-2.0, same-chip vendor header, byte-identical for Hi3516A V200 and Hi3519 V101). Reset value and access type unknown (modelled RW, no reset). Confidence: medium (vendor header for this chip family, not hardware verified).";

        field {
            name = "surface_addr";
            desc = "[inferred] Surface address. (vendor header `product/hiosd/vo/hi3519/vou_reg.h` field `surface_addr`; access and reset unknown, modelled RW)";
            sw = rw;
            hw = r;
        } surface_addr[31:0];
    } V0_P0CADDR @ 0xA08;

    reg {
        name = "V0 P0STRIDE";
        desc = "[inferred] V0 P0STRIDE. Not in the data sheet. Source: vendor U-Boot 2010.06 `product/hiosd/vo/hi3519/vou_reg.h` (GPL-2.0 U-Boot tree, HiSilicon copyright, created 2015-05-26; mirror github.com/OpenIPC/u-boot-hi3516cv200), union `U_V0_P0STRIDE`, struct offset 0xA0C (GPL-2.0, same-chip vendor header, byte-identical for Hi3516A V200 and Hi3519 V101). Reset value and access type unknown (modelled RW, no reset). Confidence: medium (vendor header for this chip family, not hardware verified).";

        field {
            name = "surface_cstride";
            desc = "[inferred] Surface cstride. (vendor header `product/hiosd/vo/hi3519/vou_reg.h` field `surface_cstride`; access and reset unknown, modelled RW)";
            sw = rw;
            hw = r;
        } surface_cstride[31:16];

        field {
            name = "surface_stride";
            desc = "[inferred] Surface stride. (vendor header `product/hiosd/vo/hi3519/vou_reg.h` field `surface_stride`; access and reset unknown, modelled RW)";
            sw = rw;
            hw = r;
        } surface_stride[15:0];
    } V0_P0STRIDE @ 0xA0C;

    reg {
        name = "V0 P0VFPOS";
        desc = "[inferred] V0 P0VFPOS. Not in the data sheet. Source: vendor U-Boot 2010.06 `product/hiosd/vo/hi3519/vou_reg.h` (GPL-2.0 U-Boot tree, HiSilicon copyright, created 2015-05-26; mirror github.com/OpenIPC/u-boot-hi3516cv200), union `U_V0_P0VFPOS`, struct offset 0xA10 (GPL-2.0, same-chip vendor header, byte-identical for Hi3516A V200 and Hi3519 V101). Reset value and access type unknown (modelled RW, no reset). Confidence: medium (vendor header for this chip family, not hardware verified).";

        field {
            name = "video_yfpos";
            desc = "[inferred] Video yfpos. (vendor header `product/hiosd/vo/hi3519/vou_reg.h` field `video_yfpos`; access and reset unknown, modelled RW)";
            sw = rw;
            hw = r;
        } video_yfpos[23:12];

        field {
            name = "video_xfpos";
            desc = "[inferred] Video xfpos. (vendor header `product/hiosd/vo/hi3519/vou_reg.h` field `video_xfpos`; access and reset unknown, modelled RW)";
            sw = rw;
            hw = r;
        } video_xfpos[11:0];
    } V0_P0VFPOS @ 0xA10;

    reg {
        name = "V0 P0VLPOS";
        desc = "[inferred] V0 P0VLPOS. Not in the data sheet. Source: vendor U-Boot 2010.06 `product/hiosd/vo/hi3519/vou_reg.h` (GPL-2.0 U-Boot tree, HiSilicon copyright, created 2015-05-26; mirror github.com/OpenIPC/u-boot-hi3516cv200), union `U_V0_P0VLPOS`, struct offset 0xA14 (GPL-2.0, same-chip vendor header, byte-identical for Hi3516A V200 and Hi3519 V101). Reset value and access type unknown (modelled RW, no reset). Confidence: medium (vendor header for this chip family, not hardware verified).";

        field {
            name = "video_ylpos";
            desc = "[inferred] Video ylpos. (vendor header `product/hiosd/vo/hi3519/vou_reg.h` field `video_ylpos`; access and reset unknown, modelled RW)";
            sw = rw;
            hw = r;
        } video_ylpos[23:12];

        field {
            name = "video_xlpos";
            desc = "[inferred] Video xlpos. (vendor header `product/hiosd/vo/hi3519/vou_reg.h` field `video_xlpos`; access and reset unknown, modelled RW)";
            sw = rw;
            hw = r;
        } video_xlpos[11:0];
    } V0_P0VLPOS @ 0xA14;

    reg {
        name = "V0 P1RESO";
        desc = "[inferred] V0 P1RESO. Not in the data sheet. Source: vendor U-Boot 2010.06 `product/hiosd/vo/hi3519/vou_reg.h` (GPL-2.0 U-Boot tree, HiSilicon copyright, created 2015-05-26; mirror github.com/OpenIPC/u-boot-hi3516cv200), union `U_V0_P1RESO`, struct offset 0xA20 (GPL-2.0, same-chip vendor header, byte-identical for Hi3516A V200 and Hi3519 V101). Reset value and access type unknown (modelled RW, no reset). Confidence: medium (vendor header for this chip family, not hardware verified).";

        field {
            name = "w";
            desc = "[inferred] W. (vendor header `product/hiosd/vo/hi3519/vou_reg.h` field `w`; access and reset unknown, modelled RW)";
            sw = rw;
            hw = r;
        } w_f[11:0];
    } V0_P1RESO @ 0xA20;

    reg {
        name = "V0 P1LADDR";
        desc = "[inferred] V0 P1LADDR. Not in the data sheet. Source: vendor U-Boot 2010.06 `product/hiosd/vo/hi3519/vou_reg.h` (GPL-2.0 U-Boot tree, HiSilicon copyright, created 2015-05-26; mirror github.com/OpenIPC/u-boot-hi3516cv200), union `U_V0_P1LADDR`, struct offset 0xA24 (GPL-2.0, same-chip vendor header, byte-identical for Hi3516A V200 and Hi3519 V101). Reset value and access type unknown (modelled RW, no reset). Confidence: medium (vendor header for this chip family, not hardware verified).";

        field {
            name = "surface_addr";
            desc = "[inferred] Surface address. (vendor header `product/hiosd/vo/hi3519/vou_reg.h` field `surface_addr`; access and reset unknown, modelled RW)";
            sw = rw;
            hw = r;
        } surface_addr[31:0];
    } V0_P1LADDR @ 0xA24;

    reg {
        name = "V0 P1CADDR";
        desc = "[inferred] V0 P1CADDR. Not in the data sheet. Source: vendor U-Boot 2010.06 `product/hiosd/vo/hi3519/vou_reg.h` (GPL-2.0 U-Boot tree, HiSilicon copyright, created 2015-05-26; mirror github.com/OpenIPC/u-boot-hi3516cv200), union `U_V0_P1CADDR`, struct offset 0xA28 (GPL-2.0, same-chip vendor header, byte-identical for Hi3516A V200 and Hi3519 V101). Reset value and access type unknown (modelled RW, no reset). Confidence: medium (vendor header for this chip family, not hardware verified).";

        field {
            name = "surface_addr";
            desc = "[inferred] Surface address. (vendor header `product/hiosd/vo/hi3519/vou_reg.h` field `surface_addr`; access and reset unknown, modelled RW)";
            sw = rw;
            hw = r;
        } surface_addr[31:0];
    } V0_P1CADDR @ 0xA28;

    reg {
        name = "V0 P1STRIDE";
        desc = "[inferred] V0 P1STRIDE. Not in the data sheet. Source: vendor U-Boot 2010.06 `product/hiosd/vo/hi3519/vou_reg.h` (GPL-2.0 U-Boot tree, HiSilicon copyright, created 2015-05-26; mirror github.com/OpenIPC/u-boot-hi3516cv200), union `U_V0_P1STRIDE`, struct offset 0xA2C (GPL-2.0, same-chip vendor header, byte-identical for Hi3516A V200 and Hi3519 V101). Reset value and access type unknown (modelled RW, no reset). Confidence: medium (vendor header for this chip family, not hardware verified).";

        field {
            name = "surface_cstride";
            desc = "[inferred] Surface cstride. (vendor header `product/hiosd/vo/hi3519/vou_reg.h` field `surface_cstride`; access and reset unknown, modelled RW)";
            sw = rw;
            hw = r;
        } surface_cstride[31:16];

        field {
            name = "surface_stride";
            desc = "[inferred] Surface stride. (vendor header `product/hiosd/vo/hi3519/vou_reg.h` field `surface_stride`; access and reset unknown, modelled RW)";
            sw = rw;
            hw = r;
        } surface_stride[15:0];
    } V0_P1STRIDE @ 0xA2C;

    reg {
        name = "V0 P1VFPOS";
        desc = "[inferred] V0 P1VFPOS. Not in the data sheet. Source: vendor U-Boot 2010.06 `product/hiosd/vo/hi3519/vou_reg.h` (GPL-2.0 U-Boot tree, HiSilicon copyright, created 2015-05-26; mirror github.com/OpenIPC/u-boot-hi3516cv200), union `U_V0_P1VFPOS`, struct offset 0xA30 (GPL-2.0, same-chip vendor header, byte-identical for Hi3516A V200 and Hi3519 V101). Reset value and access type unknown (modelled RW, no reset). Confidence: medium (vendor header for this chip family, not hardware verified).";

        field {
            name = "video_yfpos";
            desc = "[inferred] Video yfpos. (vendor header `product/hiosd/vo/hi3519/vou_reg.h` field `video_yfpos`; access and reset unknown, modelled RW)";
            sw = rw;
            hw = r;
        } video_yfpos[23:12];

        field {
            name = "video_xfpos";
            desc = "[inferred] Video xfpos. (vendor header `product/hiosd/vo/hi3519/vou_reg.h` field `video_xfpos`; access and reset unknown, modelled RW)";
            sw = rw;
            hw = r;
        } video_xfpos[11:0];
    } V0_P1VFPOS @ 0xA30;

    reg {
        name = "V0 P1VLPOS";
        desc = "[inferred] V0 P1VLPOS. Not in the data sheet. Source: vendor U-Boot 2010.06 `product/hiosd/vo/hi3519/vou_reg.h` (GPL-2.0 U-Boot tree, HiSilicon copyright, created 2015-05-26; mirror github.com/OpenIPC/u-boot-hi3516cv200), union `U_V0_P1VLPOS`, struct offset 0xA34 (GPL-2.0, same-chip vendor header, byte-identical for Hi3516A V200 and Hi3519 V101). Reset value and access type unknown (modelled RW, no reset). Confidence: medium (vendor header for this chip family, not hardware verified).";

        field {
            name = "video_ylpos";
            desc = "[inferred] Video ylpos. (vendor header `product/hiosd/vo/hi3519/vou_reg.h` field `video_ylpos`; access and reset unknown, modelled RW)";
            sw = rw;
            hw = r;
        } video_ylpos[23:12];

        field {
            name = "video_xlpos";
            desc = "[inferred] Video xlpos. (vendor header `product/hiosd/vo/hi3519/vou_reg.h` field `video_xlpos`; access and reset unknown, modelled RW)";
            sw = rw;
            hw = r;
        } video_xlpos[11:0];
    } V0_P1VLPOS @ 0xA34;

    reg {
        name = "V0 P2RESO";
        desc = "[inferred] V0 P2RESO. Not in the data sheet. Source: vendor U-Boot 2010.06 `product/hiosd/vo/hi3519/vou_reg.h` (GPL-2.0 U-Boot tree, HiSilicon copyright, created 2015-05-26; mirror github.com/OpenIPC/u-boot-hi3516cv200), union `U_V0_P2RESO`, struct offset 0xA40 (GPL-2.0, same-chip vendor header, byte-identical for Hi3516A V200 and Hi3519 V101). Reset value and access type unknown (modelled RW, no reset). Confidence: medium (vendor header for this chip family, not hardware verified).";

        field {
            name = "w";
            desc = "[inferred] W. (vendor header `product/hiosd/vo/hi3519/vou_reg.h` field `w`; access and reset unknown, modelled RW)";
            sw = rw;
            hw = r;
        } w_f[11:0];
    } V0_P2RESO @ 0xA40;

    reg {
        name = "V0 P2LADDR";
        desc = "[inferred] V0 P2LADDR. Not in the data sheet. Source: vendor U-Boot 2010.06 `product/hiosd/vo/hi3519/vou_reg.h` (GPL-2.0 U-Boot tree, HiSilicon copyright, created 2015-05-26; mirror github.com/OpenIPC/u-boot-hi3516cv200), union `U_V0_P2LADDR`, struct offset 0xA44 (GPL-2.0, same-chip vendor header, byte-identical for Hi3516A V200 and Hi3519 V101). Reset value and access type unknown (modelled RW, no reset). Confidence: medium (vendor header for this chip family, not hardware verified).";

        field {
            name = "surface_addr";
            desc = "[inferred] Surface address. (vendor header `product/hiosd/vo/hi3519/vou_reg.h` field `surface_addr`; access and reset unknown, modelled RW)";
            sw = rw;
            hw = r;
        } surface_addr[31:0];
    } V0_P2LADDR @ 0xA44;

    reg {
        name = "V0 P2CADDR";
        desc = "[inferred] V0 P2CADDR. Not in the data sheet. Source: vendor U-Boot 2010.06 `product/hiosd/vo/hi3519/vou_reg.h` (GPL-2.0 U-Boot tree, HiSilicon copyright, created 2015-05-26; mirror github.com/OpenIPC/u-boot-hi3516cv200), union `U_V0_P2CADDR`, struct offset 0xA48 (GPL-2.0, same-chip vendor header, byte-identical for Hi3516A V200 and Hi3519 V101). Reset value and access type unknown (modelled RW, no reset). Confidence: medium (vendor header for this chip family, not hardware verified).";

        field {
            name = "surface_addr";
            desc = "[inferred] Surface address. (vendor header `product/hiosd/vo/hi3519/vou_reg.h` field `surface_addr`; access and reset unknown, modelled RW)";
            sw = rw;
            hw = r;
        } surface_addr[31:0];
    } V0_P2CADDR @ 0xA48;

    reg {
        name = "V0 P2STRIDE";
        desc = "[inferred] V0 P2STRIDE. Not in the data sheet. Source: vendor U-Boot 2010.06 `product/hiosd/vo/hi3519/vou_reg.h` (GPL-2.0 U-Boot tree, HiSilicon copyright, created 2015-05-26; mirror github.com/OpenIPC/u-boot-hi3516cv200), union `U_V0_P2STRIDE`, struct offset 0xA4C (GPL-2.0, same-chip vendor header, byte-identical for Hi3516A V200 and Hi3519 V101). Reset value and access type unknown (modelled RW, no reset). Confidence: medium (vendor header for this chip family, not hardware verified).";

        field {
            name = "surface_cstride";
            desc = "[inferred] Surface cstride. (vendor header `product/hiosd/vo/hi3519/vou_reg.h` field `surface_cstride`; access and reset unknown, modelled RW)";
            sw = rw;
            hw = r;
        } surface_cstride[31:16];

        field {
            name = "surface_stride";
            desc = "[inferred] Surface stride. (vendor header `product/hiosd/vo/hi3519/vou_reg.h` field `surface_stride`; access and reset unknown, modelled RW)";
            sw = rw;
            hw = r;
        } surface_stride[15:0];
    } V0_P2STRIDE @ 0xA4C;

    reg {
        name = "V0 P2VFPOS";
        desc = "[inferred] V0 P2VFPOS. Not in the data sheet. Source: vendor U-Boot 2010.06 `product/hiosd/vo/hi3519/vou_reg.h` (GPL-2.0 U-Boot tree, HiSilicon copyright, created 2015-05-26; mirror github.com/OpenIPC/u-boot-hi3516cv200), union `U_V0_P2VFPOS`, struct offset 0xA50 (GPL-2.0, same-chip vendor header, byte-identical for Hi3516A V200 and Hi3519 V101). Reset value and access type unknown (modelled RW, no reset). Confidence: medium (vendor header for this chip family, not hardware verified).";

        field {
            name = "video_yfpos";
            desc = "[inferred] Video yfpos. (vendor header `product/hiosd/vo/hi3519/vou_reg.h` field `video_yfpos`; access and reset unknown, modelled RW)";
            sw = rw;
            hw = r;
        } video_yfpos[23:12];

        field {
            name = "video_xfpos";
            desc = "[inferred] Video xfpos. (vendor header `product/hiosd/vo/hi3519/vou_reg.h` field `video_xfpos`; access and reset unknown, modelled RW)";
            sw = rw;
            hw = r;
        } video_xfpos[11:0];
    } V0_P2VFPOS @ 0xA50;

    reg {
        name = "V0 P2VLPOS";
        desc = "[inferred] V0 P2VLPOS. Not in the data sheet. Source: vendor U-Boot 2010.06 `product/hiosd/vo/hi3519/vou_reg.h` (GPL-2.0 U-Boot tree, HiSilicon copyright, created 2015-05-26; mirror github.com/OpenIPC/u-boot-hi3516cv200), union `U_V0_P2VLPOS`, struct offset 0xA54 (GPL-2.0, same-chip vendor header, byte-identical for Hi3516A V200 and Hi3519 V101). Reset value and access type unknown (modelled RW, no reset). Confidence: medium (vendor header for this chip family, not hardware verified).";

        field {
            name = "video_ylpos";
            desc = "[inferred] Video ylpos. (vendor header `product/hiosd/vo/hi3519/vou_reg.h` field `video_ylpos`; access and reset unknown, modelled RW)";
            sw = rw;
            hw = r;
        } video_ylpos[23:12];

        field {
            name = "video_xlpos";
            desc = "[inferred] Video xlpos. (vendor header `product/hiosd/vo/hi3519/vou_reg.h` field `video_xlpos`; access and reset unknown, modelled RW)";
            sw = rw;
            hw = r;
        } video_xlpos[11:0];
    } V0_P2VLPOS @ 0xA54;

    reg {
        name = "V0 P3RESO";
        desc = "[inferred] V0 P3RESO. Not in the data sheet. Source: vendor U-Boot 2010.06 `product/hiosd/vo/hi3519/vou_reg.h` (GPL-2.0 U-Boot tree, HiSilicon copyright, created 2015-05-26; mirror github.com/OpenIPC/u-boot-hi3516cv200), union `U_V0_P3RESO`, struct offset 0xA60 (GPL-2.0, same-chip vendor header, byte-identical for Hi3516A V200 and Hi3519 V101). Reset value and access type unknown (modelled RW, no reset). Confidence: medium (vendor header for this chip family, not hardware verified).";

        field {
            name = "w";
            desc = "[inferred] W. (vendor header `product/hiosd/vo/hi3519/vou_reg.h` field `w`; access and reset unknown, modelled RW)";
            sw = rw;
            hw = r;
        } w_f[11:0];
    } V0_P3RESO @ 0xA60;

    reg {
        name = "V0 P3LADDR";
        desc = "[inferred] V0 P3LADDR. Not in the data sheet. Source: vendor U-Boot 2010.06 `product/hiosd/vo/hi3519/vou_reg.h` (GPL-2.0 U-Boot tree, HiSilicon copyright, created 2015-05-26; mirror github.com/OpenIPC/u-boot-hi3516cv200), union `U_V0_P3LADDR`, struct offset 0xA64 (GPL-2.0, same-chip vendor header, byte-identical for Hi3516A V200 and Hi3519 V101). Reset value and access type unknown (modelled RW, no reset). Confidence: medium (vendor header for this chip family, not hardware verified).";

        field {
            name = "surface_addr";
            desc = "[inferred] Surface address. (vendor header `product/hiosd/vo/hi3519/vou_reg.h` field `surface_addr`; access and reset unknown, modelled RW)";
            sw = rw;
            hw = r;
        } surface_addr[31:0];
    } V0_P3LADDR @ 0xA64;

    reg {
        name = "V0 P3CADDR";
        desc = "[inferred] V0 P3CADDR. Not in the data sheet. Source: vendor U-Boot 2010.06 `product/hiosd/vo/hi3519/vou_reg.h` (GPL-2.0 U-Boot tree, HiSilicon copyright, created 2015-05-26; mirror github.com/OpenIPC/u-boot-hi3516cv200), union `U_V0_P3CADDR`, struct offset 0xA68 (GPL-2.0, same-chip vendor header, byte-identical for Hi3516A V200 and Hi3519 V101). Reset value and access type unknown (modelled RW, no reset). Confidence: medium (vendor header for this chip family, not hardware verified).";

        field {
            name = "surface_addr";
            desc = "[inferred] Surface address. (vendor header `product/hiosd/vo/hi3519/vou_reg.h` field `surface_addr`; access and reset unknown, modelled RW)";
            sw = rw;
            hw = r;
        } surface_addr[31:0];
    } V0_P3CADDR @ 0xA68;

    reg {
        name = "V0 P3STRIDE";
        desc = "[inferred] V0 P3STRIDE. Not in the data sheet. Source: vendor U-Boot 2010.06 `product/hiosd/vo/hi3519/vou_reg.h` (GPL-2.0 U-Boot tree, HiSilicon copyright, created 2015-05-26; mirror github.com/OpenIPC/u-boot-hi3516cv200), union `U_V0_P3STRIDE`, struct offset 0xA6C (GPL-2.0, same-chip vendor header, byte-identical for Hi3516A V200 and Hi3519 V101). Reset value and access type unknown (modelled RW, no reset). Confidence: medium (vendor header for this chip family, not hardware verified).";

        field {
            name = "surface_cstride";
            desc = "[inferred] Surface cstride. (vendor header `product/hiosd/vo/hi3519/vou_reg.h` field `surface_cstride`; access and reset unknown, modelled RW)";
            sw = rw;
            hw = r;
        } surface_cstride[31:16];

        field {
            name = "surface_stride";
            desc = "[inferred] Surface stride. (vendor header `product/hiosd/vo/hi3519/vou_reg.h` field `surface_stride`; access and reset unknown, modelled RW)";
            sw = rw;
            hw = r;
        } surface_stride[15:0];
    } V0_P3STRIDE @ 0xA6C;

    reg {
        name = "V0 P3VFPOS";
        desc = "[inferred] V0 P3VFPOS. Not in the data sheet. Source: vendor U-Boot 2010.06 `product/hiosd/vo/hi3519/vou_reg.h` (GPL-2.0 U-Boot tree, HiSilicon copyright, created 2015-05-26; mirror github.com/OpenIPC/u-boot-hi3516cv200), union `U_V0_P3VFPOS`, struct offset 0xA70 (GPL-2.0, same-chip vendor header, byte-identical for Hi3516A V200 and Hi3519 V101). Reset value and access type unknown (modelled RW, no reset). Confidence: medium (vendor header for this chip family, not hardware verified).";

        field {
            name = "video_yfpos";
            desc = "[inferred] Video yfpos. (vendor header `product/hiosd/vo/hi3519/vou_reg.h` field `video_yfpos`; access and reset unknown, modelled RW)";
            sw = rw;
            hw = r;
        } video_yfpos[23:12];

        field {
            name = "video_xfpos";
            desc = "[inferred] Video xfpos. (vendor header `product/hiosd/vo/hi3519/vou_reg.h` field `video_xfpos`; access and reset unknown, modelled RW)";
            sw = rw;
            hw = r;
        } video_xfpos[11:0];
    } V0_P3VFPOS @ 0xA70;

    reg {
        name = "V0 P3VLPOS";
        desc = "[inferred] V0 P3VLPOS. Not in the data sheet. Source: vendor U-Boot 2010.06 `product/hiosd/vo/hi3519/vou_reg.h` (GPL-2.0 U-Boot tree, HiSilicon copyright, created 2015-05-26; mirror github.com/OpenIPC/u-boot-hi3516cv200), union `U_V0_P3VLPOS`, struct offset 0xA74 (GPL-2.0, same-chip vendor header, byte-identical for Hi3516A V200 and Hi3519 V101). Reset value and access type unknown (modelled RW, no reset). Confidence: medium (vendor header for this chip family, not hardware verified).";

        field {
            name = "video_ylpos";
            desc = "[inferred] Video ylpos. (vendor header `product/hiosd/vo/hi3519/vou_reg.h` field `video_ylpos`; access and reset unknown, modelled RW)";
            sw = rw;
            hw = r;
        } video_ylpos[23:12];

        field {
            name = "video_xlpos";
            desc = "[inferred] Video xlpos. (vendor header `product/hiosd/vo/hi3519/vou_reg.h` field `video_xlpos`; access and reset unknown, modelled RW)";
            sw = rw;
            hw = r;
        } video_xlpos[11:0];
    } V0_P3VLPOS @ 0xA74;

    reg {
        name = "V0 P4RESO";
        desc = "[inferred] V0 P4RESO. Not in the data sheet. Source: vendor U-Boot 2010.06 `product/hiosd/vo/hi3519/vou_reg.h` (GPL-2.0 U-Boot tree, HiSilicon copyright, created 2015-05-26; mirror github.com/OpenIPC/u-boot-hi3516cv200), union `U_V0_P4RESO`, struct offset 0xA80 (GPL-2.0, same-chip vendor header, byte-identical for Hi3516A V200 and Hi3519 V101). Reset value and access type unknown (modelled RW, no reset). Confidence: medium (vendor header for this chip family, not hardware verified).";

        field {
            name = "w";
            desc = "[inferred] W. (vendor header `product/hiosd/vo/hi3519/vou_reg.h` field `w`; access and reset unknown, modelled RW)";
            sw = rw;
            hw = r;
        } w_f[11:0];
    } V0_P4RESO @ 0xA80;

    reg {
        name = "V0 P4LADDR";
        desc = "[inferred] V0 P4LADDR. Not in the data sheet. Source: vendor U-Boot 2010.06 `product/hiosd/vo/hi3519/vou_reg.h` (GPL-2.0 U-Boot tree, HiSilicon copyright, created 2015-05-26; mirror github.com/OpenIPC/u-boot-hi3516cv200), union `U_V0_P4LADDR`, struct offset 0xA84 (GPL-2.0, same-chip vendor header, byte-identical for Hi3516A V200 and Hi3519 V101). Reset value and access type unknown (modelled RW, no reset). Confidence: medium (vendor header for this chip family, not hardware verified).";

        field {
            name = "surface_addr";
            desc = "[inferred] Surface address. (vendor header `product/hiosd/vo/hi3519/vou_reg.h` field `surface_addr`; access and reset unknown, modelled RW)";
            sw = rw;
            hw = r;
        } surface_addr[31:0];
    } V0_P4LADDR @ 0xA84;

    reg {
        name = "V0 P4CADDR";
        desc = "[inferred] V0 P4CADDR. Not in the data sheet. Source: vendor U-Boot 2010.06 `product/hiosd/vo/hi3519/vou_reg.h` (GPL-2.0 U-Boot tree, HiSilicon copyright, created 2015-05-26; mirror github.com/OpenIPC/u-boot-hi3516cv200), union `U_V0_P4CADDR`, struct offset 0xA88 (GPL-2.0, same-chip vendor header, byte-identical for Hi3516A V200 and Hi3519 V101). Reset value and access type unknown (modelled RW, no reset). Confidence: medium (vendor header for this chip family, not hardware verified).";

        field {
            name = "surface_addr";
            desc = "[inferred] Surface address. (vendor header `product/hiosd/vo/hi3519/vou_reg.h` field `surface_addr`; access and reset unknown, modelled RW)";
            sw = rw;
            hw = r;
        } surface_addr[31:0];
    } V0_P4CADDR @ 0xA88;

    reg {
        name = "V0 P4STRIDE";
        desc = "[inferred] V0 P4STRIDE. Not in the data sheet. Source: vendor U-Boot 2010.06 `product/hiosd/vo/hi3519/vou_reg.h` (GPL-2.0 U-Boot tree, HiSilicon copyright, created 2015-05-26; mirror github.com/OpenIPC/u-boot-hi3516cv200), union `U_V0_P4STRIDE`, struct offset 0xA8C (GPL-2.0, same-chip vendor header, byte-identical for Hi3516A V200 and Hi3519 V101). Reset value and access type unknown (modelled RW, no reset). Confidence: medium (vendor header for this chip family, not hardware verified).";

        field {
            name = "surface_cstride";
            desc = "[inferred] Surface cstride. (vendor header `product/hiosd/vo/hi3519/vou_reg.h` field `surface_cstride`; access and reset unknown, modelled RW)";
            sw = rw;
            hw = r;
        } surface_cstride[31:16];

        field {
            name = "surface_stride";
            desc = "[inferred] Surface stride. (vendor header `product/hiosd/vo/hi3519/vou_reg.h` field `surface_stride`; access and reset unknown, modelled RW)";
            sw = rw;
            hw = r;
        } surface_stride[15:0];
    } V0_P4STRIDE @ 0xA8C;

    reg {
        name = "V0 P4VFPOS";
        desc = "[inferred] V0 P4VFPOS. Not in the data sheet. Source: vendor U-Boot 2010.06 `product/hiosd/vo/hi3519/vou_reg.h` (GPL-2.0 U-Boot tree, HiSilicon copyright, created 2015-05-26; mirror github.com/OpenIPC/u-boot-hi3516cv200), union `U_V0_P4VFPOS`, struct offset 0xA90 (GPL-2.0, same-chip vendor header, byte-identical for Hi3516A V200 and Hi3519 V101). Reset value and access type unknown (modelled RW, no reset). Confidence: medium (vendor header for this chip family, not hardware verified).";

        field {
            name = "video_yfpos";
            desc = "[inferred] Video yfpos. (vendor header `product/hiosd/vo/hi3519/vou_reg.h` field `video_yfpos`; access and reset unknown, modelled RW)";
            sw = rw;
            hw = r;
        } video_yfpos[23:12];

        field {
            name = "video_xfpos";
            desc = "[inferred] Video xfpos. (vendor header `product/hiosd/vo/hi3519/vou_reg.h` field `video_xfpos`; access and reset unknown, modelled RW)";
            sw = rw;
            hw = r;
        } video_xfpos[11:0];
    } V0_P4VFPOS @ 0xA90;

    reg {
        name = "V0 P4VLPOS";
        desc = "[inferred] V0 P4VLPOS. Not in the data sheet. Source: vendor U-Boot 2010.06 `product/hiosd/vo/hi3519/vou_reg.h` (GPL-2.0 U-Boot tree, HiSilicon copyright, created 2015-05-26; mirror github.com/OpenIPC/u-boot-hi3516cv200), union `U_V0_P4VLPOS`, struct offset 0xA94 (GPL-2.0, same-chip vendor header, byte-identical for Hi3516A V200 and Hi3519 V101). Reset value and access type unknown (modelled RW, no reset). Confidence: medium (vendor header for this chip family, not hardware verified).";

        field {
            name = "video_ylpos";
            desc = "[inferred] Video ylpos. (vendor header `product/hiosd/vo/hi3519/vou_reg.h` field `video_ylpos`; access and reset unknown, modelled RW)";
            sw = rw;
            hw = r;
        } video_ylpos[23:12];

        field {
            name = "video_xlpos";
            desc = "[inferred] Video xlpos. (vendor header `product/hiosd/vo/hi3519/vou_reg.h` field `video_xlpos`; access and reset unknown, modelled RW)";
            sw = rw;
            hw = r;
        } video_xlpos[11:0];
    } V0_P4VLPOS @ 0xA94;

    reg {
        name = "V0 P5RESO";
        desc = "[inferred] V0 P5RESO. Not in the data sheet. Source: vendor U-Boot 2010.06 `product/hiosd/vo/hi3519/vou_reg.h` (GPL-2.0 U-Boot tree, HiSilicon copyright, created 2015-05-26; mirror github.com/OpenIPC/u-boot-hi3516cv200), union `U_V0_P5RESO`, struct offset 0xAA0 (GPL-2.0, same-chip vendor header, byte-identical for Hi3516A V200 and Hi3519 V101). Reset value and access type unknown (modelled RW, no reset). Confidence: medium (vendor header for this chip family, not hardware verified).";

        field {
            name = "w";
            desc = "[inferred] W. (vendor header `product/hiosd/vo/hi3519/vou_reg.h` field `w`; access and reset unknown, modelled RW)";
            sw = rw;
            hw = r;
        } w_f[11:0];
    } V0_P5RESO @ 0xAA0;

    reg {
        name = "V0 P5LADDR";
        desc = "[inferred] V0 P5LADDR. Not in the data sheet. Source: vendor U-Boot 2010.06 `product/hiosd/vo/hi3519/vou_reg.h` (GPL-2.0 U-Boot tree, HiSilicon copyright, created 2015-05-26; mirror github.com/OpenIPC/u-boot-hi3516cv200), union `U_V0_P5LADDR`, struct offset 0xAA4 (GPL-2.0, same-chip vendor header, byte-identical for Hi3516A V200 and Hi3519 V101). Reset value and access type unknown (modelled RW, no reset). Confidence: medium (vendor header for this chip family, not hardware verified).";

        field {
            name = "surface_addr";
            desc = "[inferred] Surface address. (vendor header `product/hiosd/vo/hi3519/vou_reg.h` field `surface_addr`; access and reset unknown, modelled RW)";
            sw = rw;
            hw = r;
        } surface_addr[31:0];
    } V0_P5LADDR @ 0xAA4;

    reg {
        name = "V0 P5CADDR";
        desc = "[inferred] V0 P5CADDR. Not in the data sheet. Source: vendor U-Boot 2010.06 `product/hiosd/vo/hi3519/vou_reg.h` (GPL-2.0 U-Boot tree, HiSilicon copyright, created 2015-05-26; mirror github.com/OpenIPC/u-boot-hi3516cv200), union `U_V0_P5CADDR`, struct offset 0xAA8 (GPL-2.0, same-chip vendor header, byte-identical for Hi3516A V200 and Hi3519 V101). Reset value and access type unknown (modelled RW, no reset). Confidence: medium (vendor header for this chip family, not hardware verified).";

        field {
            name = "surface_addr";
            desc = "[inferred] Surface address. (vendor header `product/hiosd/vo/hi3519/vou_reg.h` field `surface_addr`; access and reset unknown, modelled RW)";
            sw = rw;
            hw = r;
        } surface_addr[31:0];
    } V0_P5CADDR @ 0xAA8;

    reg {
        name = "V0 P5STRIDE";
        desc = "[inferred] V0 P5STRIDE. Not in the data sheet. Source: vendor U-Boot 2010.06 `product/hiosd/vo/hi3519/vou_reg.h` (GPL-2.0 U-Boot tree, HiSilicon copyright, created 2015-05-26; mirror github.com/OpenIPC/u-boot-hi3516cv200), union `U_V0_P5STRIDE`, struct offset 0xAAC (GPL-2.0, same-chip vendor header, byte-identical for Hi3516A V200 and Hi3519 V101). Reset value and access type unknown (modelled RW, no reset). Confidence: medium (vendor header for this chip family, not hardware verified).";

        field {
            name = "surface_cstride";
            desc = "[inferred] Surface cstride. (vendor header `product/hiosd/vo/hi3519/vou_reg.h` field `surface_cstride`; access and reset unknown, modelled RW)";
            sw = rw;
            hw = r;
        } surface_cstride[31:16];

        field {
            name = "surface_stride";
            desc = "[inferred] Surface stride. (vendor header `product/hiosd/vo/hi3519/vou_reg.h` field `surface_stride`; access and reset unknown, modelled RW)";
            sw = rw;
            hw = r;
        } surface_stride[15:0];
    } V0_P5STRIDE @ 0xAAC;

    reg {
        name = "V0 P5VFPOS";
        desc = "[inferred] V0 P5VFPOS. Not in the data sheet. Source: vendor U-Boot 2010.06 `product/hiosd/vo/hi3519/vou_reg.h` (GPL-2.0 U-Boot tree, HiSilicon copyright, created 2015-05-26; mirror github.com/OpenIPC/u-boot-hi3516cv200), union `U_V0_P5VFPOS`, struct offset 0xAB0 (GPL-2.0, same-chip vendor header, byte-identical for Hi3516A V200 and Hi3519 V101). Reset value and access type unknown (modelled RW, no reset). Confidence: medium (vendor header for this chip family, not hardware verified).";

        field {
            name = "video_yfpos";
            desc = "[inferred] Video yfpos. (vendor header `product/hiosd/vo/hi3519/vou_reg.h` field `video_yfpos`; access and reset unknown, modelled RW)";
            sw = rw;
            hw = r;
        } video_yfpos[23:12];

        field {
            name = "video_xfpos";
            desc = "[inferred] Video xfpos. (vendor header `product/hiosd/vo/hi3519/vou_reg.h` field `video_xfpos`; access and reset unknown, modelled RW)";
            sw = rw;
            hw = r;
        } video_xfpos[11:0];
    } V0_P5VFPOS @ 0xAB0;

    reg {
        name = "V0 P5VLPOS";
        desc = "[inferred] V0 P5VLPOS. Not in the data sheet. Source: vendor U-Boot 2010.06 `product/hiosd/vo/hi3519/vou_reg.h` (GPL-2.0 U-Boot tree, HiSilicon copyright, created 2015-05-26; mirror github.com/OpenIPC/u-boot-hi3516cv200), union `U_V0_P5VLPOS`, struct offset 0xAB4 (GPL-2.0, same-chip vendor header, byte-identical for Hi3516A V200 and Hi3519 V101). Reset value and access type unknown (modelled RW, no reset). Confidence: medium (vendor header for this chip family, not hardware verified).";

        field {
            name = "video_ylpos";
            desc = "[inferred] Video ylpos. (vendor header `product/hiosd/vo/hi3519/vou_reg.h` field `video_ylpos`; access and reset unknown, modelled RW)";
            sw = rw;
            hw = r;
        } video_ylpos[23:12];

        field {
            name = "video_xlpos";
            desc = "[inferred] Video xlpos. (vendor header `product/hiosd/vo/hi3519/vou_reg.h` field `video_xlpos`; access and reset unknown, modelled RW)";
            sw = rw;
            hw = r;
        } video_xlpos[11:0];
    } V0_P5VLPOS @ 0xAB4;

    reg {
        name = "V0 P6RESO";
        desc = "[inferred] V0 P6RESO. Not in the data sheet. Source: vendor U-Boot 2010.06 `product/hiosd/vo/hi3519/vou_reg.h` (GPL-2.0 U-Boot tree, HiSilicon copyright, created 2015-05-26; mirror github.com/OpenIPC/u-boot-hi3516cv200), union `U_V0_P6RESO`, struct offset 0xAC0 (GPL-2.0, same-chip vendor header, byte-identical for Hi3516A V200 and Hi3519 V101). Reset value and access type unknown (modelled RW, no reset). Confidence: medium (vendor header for this chip family, not hardware verified).";

        field {
            name = "w";
            desc = "[inferred] W. (vendor header `product/hiosd/vo/hi3519/vou_reg.h` field `w`; access and reset unknown, modelled RW)";
            sw = rw;
            hw = r;
        } w_f[11:0];
    } V0_P6RESO @ 0xAC0;

    reg {
        name = "V0 P6LADDR";
        desc = "[inferred] V0 P6LADDR. Not in the data sheet. Source: vendor U-Boot 2010.06 `product/hiosd/vo/hi3519/vou_reg.h` (GPL-2.0 U-Boot tree, HiSilicon copyright, created 2015-05-26; mirror github.com/OpenIPC/u-boot-hi3516cv200), union `U_V0_P6LADDR`, struct offset 0xAC4 (GPL-2.0, same-chip vendor header, byte-identical for Hi3516A V200 and Hi3519 V101). Reset value and access type unknown (modelled RW, no reset). Confidence: medium (vendor header for this chip family, not hardware verified).";

        field {
            name = "surface_addr";
            desc = "[inferred] Surface address. (vendor header `product/hiosd/vo/hi3519/vou_reg.h` field `surface_addr`; access and reset unknown, modelled RW)";
            sw = rw;
            hw = r;
        } surface_addr[31:0];
    } V0_P6LADDR @ 0xAC4;

    reg {
        name = "V0 P6CADDR";
        desc = "[inferred] V0 P6CADDR. Not in the data sheet. Source: vendor U-Boot 2010.06 `product/hiosd/vo/hi3519/vou_reg.h` (GPL-2.0 U-Boot tree, HiSilicon copyright, created 2015-05-26; mirror github.com/OpenIPC/u-boot-hi3516cv200), union `U_V0_P6CADDR`, struct offset 0xAC8 (GPL-2.0, same-chip vendor header, byte-identical for Hi3516A V200 and Hi3519 V101). Reset value and access type unknown (modelled RW, no reset). Confidence: medium (vendor header for this chip family, not hardware verified).";

        field {
            name = "surface_addr";
            desc = "[inferred] Surface address. (vendor header `product/hiosd/vo/hi3519/vou_reg.h` field `surface_addr`; access and reset unknown, modelled RW)";
            sw = rw;
            hw = r;
        } surface_addr[31:0];
    } V0_P6CADDR @ 0xAC8;

    reg {
        name = "V0 P6STRIDE";
        desc = "[inferred] V0 P6STRIDE. Not in the data sheet. Source: vendor U-Boot 2010.06 `product/hiosd/vo/hi3519/vou_reg.h` (GPL-2.0 U-Boot tree, HiSilicon copyright, created 2015-05-26; mirror github.com/OpenIPC/u-boot-hi3516cv200), union `U_V0_P6STRIDE`, struct offset 0xACC (GPL-2.0, same-chip vendor header, byte-identical for Hi3516A V200 and Hi3519 V101). Reset value and access type unknown (modelled RW, no reset). Confidence: medium (vendor header for this chip family, not hardware verified).";

        field {
            name = "surface_cstride";
            desc = "[inferred] Surface cstride. (vendor header `product/hiosd/vo/hi3519/vou_reg.h` field `surface_cstride`; access and reset unknown, modelled RW)";
            sw = rw;
            hw = r;
        } surface_cstride[31:16];

        field {
            name = "surface_stride";
            desc = "[inferred] Surface stride. (vendor header `product/hiosd/vo/hi3519/vou_reg.h` field `surface_stride`; access and reset unknown, modelled RW)";
            sw = rw;
            hw = r;
        } surface_stride[15:0];
    } V0_P6STRIDE @ 0xACC;

    reg {
        name = "V0 P6VFPOS";
        desc = "[inferred] V0 P6VFPOS. Not in the data sheet. Source: vendor U-Boot 2010.06 `product/hiosd/vo/hi3519/vou_reg.h` (GPL-2.0 U-Boot tree, HiSilicon copyright, created 2015-05-26; mirror github.com/OpenIPC/u-boot-hi3516cv200), union `U_V0_P6VFPOS`, struct offset 0xAD0 (GPL-2.0, same-chip vendor header, byte-identical for Hi3516A V200 and Hi3519 V101). Reset value and access type unknown (modelled RW, no reset). Confidence: medium (vendor header for this chip family, not hardware verified).";

        field {
            name = "video_yfpos";
            desc = "[inferred] Video yfpos. (vendor header `product/hiosd/vo/hi3519/vou_reg.h` field `video_yfpos`; access and reset unknown, modelled RW)";
            sw = rw;
            hw = r;
        } video_yfpos[23:12];

        field {
            name = "video_xfpos";
            desc = "[inferred] Video xfpos. (vendor header `product/hiosd/vo/hi3519/vou_reg.h` field `video_xfpos`; access and reset unknown, modelled RW)";
            sw = rw;
            hw = r;
        } video_xfpos[11:0];
    } V0_P6VFPOS @ 0xAD0;

    reg {
        name = "V0 P6VLPOS";
        desc = "[inferred] V0 P6VLPOS. Not in the data sheet. Source: vendor U-Boot 2010.06 `product/hiosd/vo/hi3519/vou_reg.h` (GPL-2.0 U-Boot tree, HiSilicon copyright, created 2015-05-26; mirror github.com/OpenIPC/u-boot-hi3516cv200), union `U_V0_P6VLPOS`, struct offset 0xAD4 (GPL-2.0, same-chip vendor header, byte-identical for Hi3516A V200 and Hi3519 V101). Reset value and access type unknown (modelled RW, no reset). Confidence: medium (vendor header for this chip family, not hardware verified).";

        field {
            name = "video_ylpos";
            desc = "[inferred] Video ylpos. (vendor header `product/hiosd/vo/hi3519/vou_reg.h` field `video_ylpos`; access and reset unknown, modelled RW)";
            sw = rw;
            hw = r;
        } video_ylpos[23:12];

        field {
            name = "video_xlpos";
            desc = "[inferred] Video xlpos. (vendor header `product/hiosd/vo/hi3519/vou_reg.h` field `video_xlpos`; access and reset unknown, modelled RW)";
            sw = rw;
            hw = r;
        } video_xlpos[11:0];
    } V0_P6VLPOS @ 0xAD4;

    reg {
        name = "V0 P7RESO";
        desc = "[inferred] V0 P7RESO. Not in the data sheet. Source: vendor U-Boot 2010.06 `product/hiosd/vo/hi3519/vou_reg.h` (GPL-2.0 U-Boot tree, HiSilicon copyright, created 2015-05-26; mirror github.com/OpenIPC/u-boot-hi3516cv200), union `U_V0_P7RESO`, struct offset 0xAE0 (GPL-2.0, same-chip vendor header, byte-identical for Hi3516A V200 and Hi3519 V101). Reset value and access type unknown (modelled RW, no reset). Confidence: medium (vendor header for this chip family, not hardware verified).";

        field {
            name = "w";
            desc = "[inferred] W. (vendor header `product/hiosd/vo/hi3519/vou_reg.h` field `w`; access and reset unknown, modelled RW)";
            sw = rw;
            hw = r;
        } w_f[11:0];
    } V0_P7RESO @ 0xAE0;

    reg {
        name = "V0 P7LADDR";
        desc = "[inferred] V0 P7LADDR. Not in the data sheet. Source: vendor U-Boot 2010.06 `product/hiosd/vo/hi3519/vou_reg.h` (GPL-2.0 U-Boot tree, HiSilicon copyright, created 2015-05-26; mirror github.com/OpenIPC/u-boot-hi3516cv200), union `U_V0_P7LADDR`, struct offset 0xAE4 (GPL-2.0, same-chip vendor header, byte-identical for Hi3516A V200 and Hi3519 V101). Reset value and access type unknown (modelled RW, no reset). Confidence: medium (vendor header for this chip family, not hardware verified).";

        field {
            name = "surface_addr";
            desc = "[inferred] Surface address. (vendor header `product/hiosd/vo/hi3519/vou_reg.h` field `surface_addr`; access and reset unknown, modelled RW)";
            sw = rw;
            hw = r;
        } surface_addr[31:0];
    } V0_P7LADDR @ 0xAE4;

    reg {
        name = "V0 P7CADDR";
        desc = "[inferred] V0 P7CADDR. Not in the data sheet. Source: vendor U-Boot 2010.06 `product/hiosd/vo/hi3519/vou_reg.h` (GPL-2.0 U-Boot tree, HiSilicon copyright, created 2015-05-26; mirror github.com/OpenIPC/u-boot-hi3516cv200), union `U_V0_P7CADDR`, struct offset 0xAE8 (GPL-2.0, same-chip vendor header, byte-identical for Hi3516A V200 and Hi3519 V101). Reset value and access type unknown (modelled RW, no reset). Confidence: medium (vendor header for this chip family, not hardware verified).";

        field {
            name = "surface_addr";
            desc = "[inferred] Surface address. (vendor header `product/hiosd/vo/hi3519/vou_reg.h` field `surface_addr`; access and reset unknown, modelled RW)";
            sw = rw;
            hw = r;
        } surface_addr[31:0];
    } V0_P7CADDR @ 0xAE8;

    reg {
        name = "V0 P7STRIDE";
        desc = "[inferred] V0 P7STRIDE. Not in the data sheet. Source: vendor U-Boot 2010.06 `product/hiosd/vo/hi3519/vou_reg.h` (GPL-2.0 U-Boot tree, HiSilicon copyright, created 2015-05-26; mirror github.com/OpenIPC/u-boot-hi3516cv200), union `U_V0_P7STRIDE`, struct offset 0xAEC (GPL-2.0, same-chip vendor header, byte-identical for Hi3516A V200 and Hi3519 V101). Reset value and access type unknown (modelled RW, no reset). Confidence: medium (vendor header for this chip family, not hardware verified).";

        field {
            name = "surface_cstride";
            desc = "[inferred] Surface cstride. (vendor header `product/hiosd/vo/hi3519/vou_reg.h` field `surface_cstride`; access and reset unknown, modelled RW)";
            sw = rw;
            hw = r;
        } surface_cstride[31:16];

        field {
            name = "surface_stride";
            desc = "[inferred] Surface stride. (vendor header `product/hiosd/vo/hi3519/vou_reg.h` field `surface_stride`; access and reset unknown, modelled RW)";
            sw = rw;
            hw = r;
        } surface_stride[15:0];
    } V0_P7STRIDE @ 0xAEC;

    reg {
        name = "V0 P7VFPOS";
        desc = "[inferred] V0 P7VFPOS. Not in the data sheet. Source: vendor U-Boot 2010.06 `product/hiosd/vo/hi3519/vou_reg.h` (GPL-2.0 U-Boot tree, HiSilicon copyright, created 2015-05-26; mirror github.com/OpenIPC/u-boot-hi3516cv200), union `U_V0_P7VFPOS`, struct offset 0xAF0 (GPL-2.0, same-chip vendor header, byte-identical for Hi3516A V200 and Hi3519 V101). Reset value and access type unknown (modelled RW, no reset). Confidence: medium (vendor header for this chip family, not hardware verified).";

        field {
            name = "video_yfpos";
            desc = "[inferred] Video yfpos. (vendor header `product/hiosd/vo/hi3519/vou_reg.h` field `video_yfpos`; access and reset unknown, modelled RW)";
            sw = rw;
            hw = r;
        } video_yfpos[23:12];

        field {
            name = "video_xfpos";
            desc = "[inferred] Video xfpos. (vendor header `product/hiosd/vo/hi3519/vou_reg.h` field `video_xfpos`; access and reset unknown, modelled RW)";
            sw = rw;
            hw = r;
        } video_xfpos[11:0];
    } V0_P7VFPOS @ 0xAF0;

    reg {
        name = "V0 P7VLPOS";
        desc = "[inferred] V0 P7VLPOS. Not in the data sheet. Source: vendor U-Boot 2010.06 `product/hiosd/vo/hi3519/vou_reg.h` (GPL-2.0 U-Boot tree, HiSilicon copyright, created 2015-05-26; mirror github.com/OpenIPC/u-boot-hi3516cv200), union `U_V0_P7VLPOS`, struct offset 0xAF4 (GPL-2.0, same-chip vendor header, byte-identical for Hi3516A V200 and Hi3519 V101). Reset value and access type unknown (modelled RW, no reset). Confidence: medium (vendor header for this chip family, not hardware verified).";

        field {
            name = "video_ylpos";
            desc = "[inferred] Video ylpos. (vendor header `product/hiosd/vo/hi3519/vou_reg.h` field `video_ylpos`; access and reset unknown, modelled RW)";
            sw = rw;
            hw = r;
        } video_ylpos[23:12];

        field {
            name = "video_xlpos";
            desc = "[inferred] Video xlpos. (vendor header `product/hiosd/vo/hi3519/vou_reg.h` field `video_xlpos`; access and reset unknown, modelled RW)";
            sw = rw;
            hw = r;
        } video_xlpos[11:0];
    } V0_P7VLPOS @ 0xAF4;

    reg {
        name = "V0 P8RESO";
        desc = "[inferred] V0 P8RESO. Not in the data sheet. Source: vendor U-Boot 2010.06 `product/hiosd/vo/hi3519/vou_reg.h` (GPL-2.0 U-Boot tree, HiSilicon copyright, created 2015-05-26; mirror github.com/OpenIPC/u-boot-hi3516cv200), union `U_V0_P8RESO`, struct offset 0xB00 (GPL-2.0, same-chip vendor header, byte-identical for Hi3516A V200 and Hi3519 V101). Reset value and access type unknown (modelled RW, no reset). Confidence: medium (vendor header for this chip family, not hardware verified).";

        field {
            name = "w";
            desc = "[inferred] W. (vendor header `product/hiosd/vo/hi3519/vou_reg.h` field `w`; access and reset unknown, modelled RW)";
            sw = rw;
            hw = r;
        } w_f[11:0];
    } V0_P8RESO @ 0xB00;

    reg {
        name = "V0 P8LADDR";
        desc = "[inferred] V0 P8LADDR. Not in the data sheet. Source: vendor U-Boot 2010.06 `product/hiosd/vo/hi3519/vou_reg.h` (GPL-2.0 U-Boot tree, HiSilicon copyright, created 2015-05-26; mirror github.com/OpenIPC/u-boot-hi3516cv200), union `U_V0_P8LADDR`, struct offset 0xB04 (GPL-2.0, same-chip vendor header, byte-identical for Hi3516A V200 and Hi3519 V101). Reset value and access type unknown (modelled RW, no reset). Confidence: medium (vendor header for this chip family, not hardware verified).";

        field {
            name = "surface_addr";
            desc = "[inferred] Surface address. (vendor header `product/hiosd/vo/hi3519/vou_reg.h` field `surface_addr`; access and reset unknown, modelled RW)";
            sw = rw;
            hw = r;
        } surface_addr[31:0];
    } V0_P8LADDR @ 0xB04;

    reg {
        name = "V0 P8CADDR";
        desc = "[inferred] V0 P8CADDR. Not in the data sheet. Source: vendor U-Boot 2010.06 `product/hiosd/vo/hi3519/vou_reg.h` (GPL-2.0 U-Boot tree, HiSilicon copyright, created 2015-05-26; mirror github.com/OpenIPC/u-boot-hi3516cv200), union `U_V0_P8CADDR`, struct offset 0xB08 (GPL-2.0, same-chip vendor header, byte-identical for Hi3516A V200 and Hi3519 V101). Reset value and access type unknown (modelled RW, no reset). Confidence: medium (vendor header for this chip family, not hardware verified).";

        field {
            name = "surface_addr";
            desc = "[inferred] Surface address. (vendor header `product/hiosd/vo/hi3519/vou_reg.h` field `surface_addr`; access and reset unknown, modelled RW)";
            sw = rw;
            hw = r;
        } surface_addr[31:0];
    } V0_P8CADDR @ 0xB08;

    reg {
        name = "V0 P8STRIDE";
        desc = "[inferred] V0 P8STRIDE. Not in the data sheet. Source: vendor U-Boot 2010.06 `product/hiosd/vo/hi3519/vou_reg.h` (GPL-2.0 U-Boot tree, HiSilicon copyright, created 2015-05-26; mirror github.com/OpenIPC/u-boot-hi3516cv200), union `U_V0_P8STRIDE`, struct offset 0xB0C (GPL-2.0, same-chip vendor header, byte-identical for Hi3516A V200 and Hi3519 V101). Reset value and access type unknown (modelled RW, no reset). Confidence: medium (vendor header for this chip family, not hardware verified).";

        field {
            name = "surface_cstride";
            desc = "[inferred] Surface cstride. (vendor header `product/hiosd/vo/hi3519/vou_reg.h` field `surface_cstride`; access and reset unknown, modelled RW)";
            sw = rw;
            hw = r;
        } surface_cstride[31:16];

        field {
            name = "surface_stride";
            desc = "[inferred] Surface stride. (vendor header `product/hiosd/vo/hi3519/vou_reg.h` field `surface_stride`; access and reset unknown, modelled RW)";
            sw = rw;
            hw = r;
        } surface_stride[15:0];
    } V0_P8STRIDE @ 0xB0C;

    reg {
        name = "V0 P8VFPOS";
        desc = "[inferred] V0 P8VFPOS. Not in the data sheet. Source: vendor U-Boot 2010.06 `product/hiosd/vo/hi3519/vou_reg.h` (GPL-2.0 U-Boot tree, HiSilicon copyright, created 2015-05-26; mirror github.com/OpenIPC/u-boot-hi3516cv200), union `U_V0_P8VFPOS`, struct offset 0xB10 (GPL-2.0, same-chip vendor header, byte-identical for Hi3516A V200 and Hi3519 V101). Reset value and access type unknown (modelled RW, no reset). Confidence: medium (vendor header for this chip family, not hardware verified).";

        field {
            name = "video_yfpos";
            desc = "[inferred] Video yfpos. (vendor header `product/hiosd/vo/hi3519/vou_reg.h` field `video_yfpos`; access and reset unknown, modelled RW)";
            sw = rw;
            hw = r;
        } video_yfpos[23:12];

        field {
            name = "video_xfpos";
            desc = "[inferred] Video xfpos. (vendor header `product/hiosd/vo/hi3519/vou_reg.h` field `video_xfpos`; access and reset unknown, modelled RW)";
            sw = rw;
            hw = r;
        } video_xfpos[11:0];
    } V0_P8VFPOS @ 0xB10;

    reg {
        name = "V0 P8VLPOS";
        desc = "[inferred] V0 P8VLPOS. Not in the data sheet. Source: vendor U-Boot 2010.06 `product/hiosd/vo/hi3519/vou_reg.h` (GPL-2.0 U-Boot tree, HiSilicon copyright, created 2015-05-26; mirror github.com/OpenIPC/u-boot-hi3516cv200), union `U_V0_P8VLPOS`, struct offset 0xB14 (GPL-2.0, same-chip vendor header, byte-identical for Hi3516A V200 and Hi3519 V101). Reset value and access type unknown (modelled RW, no reset). Confidence: medium (vendor header for this chip family, not hardware verified).";

        field {
            name = "video_ylpos";
            desc = "[inferred] Video ylpos. (vendor header `product/hiosd/vo/hi3519/vou_reg.h` field `video_ylpos`; access and reset unknown, modelled RW)";
            sw = rw;
            hw = r;
        } video_ylpos[23:12];

        field {
            name = "video_xlpos";
            desc = "[inferred] Video xlpos. (vendor header `product/hiosd/vo/hi3519/vou_reg.h` field `video_xlpos`; access and reset unknown, modelled RW)";
            sw = rw;
            hw = r;
        } video_xlpos[11:0];
    } V0_P8VLPOS @ 0xB14;

    reg {
        name = "V0 P9RESO";
        desc = "[inferred] V0 P9RESO. Not in the data sheet. Source: vendor U-Boot 2010.06 `product/hiosd/vo/hi3519/vou_reg.h` (GPL-2.0 U-Boot tree, HiSilicon copyright, created 2015-05-26; mirror github.com/OpenIPC/u-boot-hi3516cv200), union `U_V0_P9RESO`, struct offset 0xB20 (GPL-2.0, same-chip vendor header, byte-identical for Hi3516A V200 and Hi3519 V101). Reset value and access type unknown (modelled RW, no reset). Confidence: medium (vendor header for this chip family, not hardware verified).";

        field {
            name = "w";
            desc = "[inferred] W. (vendor header `product/hiosd/vo/hi3519/vou_reg.h` field `w`; access and reset unknown, modelled RW)";
            sw = rw;
            hw = r;
        } w_f[11:0];
    } V0_P9RESO @ 0xB20;

    reg {
        name = "V0 P9LADDR";
        desc = "[inferred] V0 P9LADDR. Not in the data sheet. Source: vendor U-Boot 2010.06 `product/hiosd/vo/hi3519/vou_reg.h` (GPL-2.0 U-Boot tree, HiSilicon copyright, created 2015-05-26; mirror github.com/OpenIPC/u-boot-hi3516cv200), union `U_V0_P9LADDR`, struct offset 0xB24 (GPL-2.0, same-chip vendor header, byte-identical for Hi3516A V200 and Hi3519 V101). Reset value and access type unknown (modelled RW, no reset). Confidence: medium (vendor header for this chip family, not hardware verified).";

        field {
            name = "surface_addr";
            desc = "[inferred] Surface address. (vendor header `product/hiosd/vo/hi3519/vou_reg.h` field `surface_addr`; access and reset unknown, modelled RW)";
            sw = rw;
            hw = r;
        } surface_addr[31:0];
    } V0_P9LADDR @ 0xB24;

    reg {
        name = "V0 P9CADDR";
        desc = "[inferred] V0 P9CADDR. Not in the data sheet. Source: vendor U-Boot 2010.06 `product/hiosd/vo/hi3519/vou_reg.h` (GPL-2.0 U-Boot tree, HiSilicon copyright, created 2015-05-26; mirror github.com/OpenIPC/u-boot-hi3516cv200), union `U_V0_P9CADDR`, struct offset 0xB28 (GPL-2.0, same-chip vendor header, byte-identical for Hi3516A V200 and Hi3519 V101). Reset value and access type unknown (modelled RW, no reset). Confidence: medium (vendor header for this chip family, not hardware verified).";

        field {
            name = "surface_addr";
            desc = "[inferred] Surface address. (vendor header `product/hiosd/vo/hi3519/vou_reg.h` field `surface_addr`; access and reset unknown, modelled RW)";
            sw = rw;
            hw = r;
        } surface_addr[31:0];
    } V0_P9CADDR @ 0xB28;

    reg {
        name = "V0 P9STRIDE";
        desc = "[inferred] V0 P9STRIDE. Not in the data sheet. Source: vendor U-Boot 2010.06 `product/hiosd/vo/hi3519/vou_reg.h` (GPL-2.0 U-Boot tree, HiSilicon copyright, created 2015-05-26; mirror github.com/OpenIPC/u-boot-hi3516cv200), union `U_V0_P9STRIDE`, struct offset 0xB2C (GPL-2.0, same-chip vendor header, byte-identical for Hi3516A V200 and Hi3519 V101). Reset value and access type unknown (modelled RW, no reset). Confidence: medium (vendor header for this chip family, not hardware verified).";

        field {
            name = "surface_cstride";
            desc = "[inferred] Surface cstride. (vendor header `product/hiosd/vo/hi3519/vou_reg.h` field `surface_cstride`; access and reset unknown, modelled RW)";
            sw = rw;
            hw = r;
        } surface_cstride[31:16];

        field {
            name = "surface_stride";
            desc = "[inferred] Surface stride. (vendor header `product/hiosd/vo/hi3519/vou_reg.h` field `surface_stride`; access and reset unknown, modelled RW)";
            sw = rw;
            hw = r;
        } surface_stride[15:0];
    } V0_P9STRIDE @ 0xB2C;

    reg {
        name = "V0 P9VFPOS";
        desc = "[inferred] V0 P9VFPOS. Not in the data sheet. Source: vendor U-Boot 2010.06 `product/hiosd/vo/hi3519/vou_reg.h` (GPL-2.0 U-Boot tree, HiSilicon copyright, created 2015-05-26; mirror github.com/OpenIPC/u-boot-hi3516cv200), union `U_V0_P9VFPOS`, struct offset 0xB30 (GPL-2.0, same-chip vendor header, byte-identical for Hi3516A V200 and Hi3519 V101). Reset value and access type unknown (modelled RW, no reset). Confidence: medium (vendor header for this chip family, not hardware verified).";

        field {
            name = "video_yfpos";
            desc = "[inferred] Video yfpos. (vendor header `product/hiosd/vo/hi3519/vou_reg.h` field `video_yfpos`; access and reset unknown, modelled RW)";
            sw = rw;
            hw = r;
        } video_yfpos[23:12];

        field {
            name = "video_xfpos";
            desc = "[inferred] Video xfpos. (vendor header `product/hiosd/vo/hi3519/vou_reg.h` field `video_xfpos`; access and reset unknown, modelled RW)";
            sw = rw;
            hw = r;
        } video_xfpos[11:0];
    } V0_P9VFPOS @ 0xB30;

    reg {
        name = "V0 P9VLPOS";
        desc = "[inferred] V0 P9VLPOS. Not in the data sheet. Source: vendor U-Boot 2010.06 `product/hiosd/vo/hi3519/vou_reg.h` (GPL-2.0 U-Boot tree, HiSilicon copyright, created 2015-05-26; mirror github.com/OpenIPC/u-boot-hi3516cv200), union `U_V0_P9VLPOS`, struct offset 0xB34 (GPL-2.0, same-chip vendor header, byte-identical for Hi3516A V200 and Hi3519 V101). Reset value and access type unknown (modelled RW, no reset). Confidence: medium (vendor header for this chip family, not hardware verified).";

        field {
            name = "video_ylpos";
            desc = "[inferred] Video ylpos. (vendor header `product/hiosd/vo/hi3519/vou_reg.h` field `video_ylpos`; access and reset unknown, modelled RW)";
            sw = rw;
            hw = r;
        } video_ylpos[23:12];

        field {
            name = "video_xlpos";
            desc = "[inferred] Video xlpos. (vendor header `product/hiosd/vo/hi3519/vou_reg.h` field `video_xlpos`; access and reset unknown, modelled RW)";
            sw = rw;
            hw = r;
        } video_xlpos[11:0];
    } V0_P9VLPOS @ 0xB34;

    reg {
        name = "V0 P10RESO";
        desc = "[inferred] V0 P10RESO. Not in the data sheet. Source: vendor U-Boot 2010.06 `product/hiosd/vo/hi3519/vou_reg.h` (GPL-2.0 U-Boot tree, HiSilicon copyright, created 2015-05-26; mirror github.com/OpenIPC/u-boot-hi3516cv200), union `U_V0_P10RESO`, struct offset 0xB40 (GPL-2.0, same-chip vendor header, byte-identical for Hi3516A V200 and Hi3519 V101). Reset value and access type unknown (modelled RW, no reset). Confidence: medium (vendor header for this chip family, not hardware verified).";

        field {
            name = "w";
            desc = "[inferred] W. (vendor header `product/hiosd/vo/hi3519/vou_reg.h` field `w`; access and reset unknown, modelled RW)";
            sw = rw;
            hw = r;
        } w_f[11:0];
    } V0_P10RESO @ 0xB40;

    reg {
        name = "V0 P10LADDR";
        desc = "[inferred] V0 P10LADDR. Not in the data sheet. Source: vendor U-Boot 2010.06 `product/hiosd/vo/hi3519/vou_reg.h` (GPL-2.0 U-Boot tree, HiSilicon copyright, created 2015-05-26; mirror github.com/OpenIPC/u-boot-hi3516cv200), union `U_V0_P10LADDR`, struct offset 0xB44 (GPL-2.0, same-chip vendor header, byte-identical for Hi3516A V200 and Hi3519 V101). Reset value and access type unknown (modelled RW, no reset). Confidence: medium (vendor header for this chip family, not hardware verified).";

        field {
            name = "surface_addr";
            desc = "[inferred] Surface address. (vendor header `product/hiosd/vo/hi3519/vou_reg.h` field `surface_addr`; access and reset unknown, modelled RW)";
            sw = rw;
            hw = r;
        } surface_addr[31:0];
    } V0_P10LADDR @ 0xB44;

    reg {
        name = "V0 P10CADDR";
        desc = "[inferred] V0 P10CADDR. Not in the data sheet. Source: vendor U-Boot 2010.06 `product/hiosd/vo/hi3519/vou_reg.h` (GPL-2.0 U-Boot tree, HiSilicon copyright, created 2015-05-26; mirror github.com/OpenIPC/u-boot-hi3516cv200), union `U_V0_P10CADDR`, struct offset 0xB48 (GPL-2.0, same-chip vendor header, byte-identical for Hi3516A V200 and Hi3519 V101). Reset value and access type unknown (modelled RW, no reset). Confidence: medium (vendor header for this chip family, not hardware verified).";

        field {
            name = "surface_addr";
            desc = "[inferred] Surface address. (vendor header `product/hiosd/vo/hi3519/vou_reg.h` field `surface_addr`; access and reset unknown, modelled RW)";
            sw = rw;
            hw = r;
        } surface_addr[31:0];
    } V0_P10CADDR @ 0xB48;

    reg {
        name = "V0 P10STRIDE";
        desc = "[inferred] V0 P10STRIDE. Not in the data sheet. Source: vendor U-Boot 2010.06 `product/hiosd/vo/hi3519/vou_reg.h` (GPL-2.0 U-Boot tree, HiSilicon copyright, created 2015-05-26; mirror github.com/OpenIPC/u-boot-hi3516cv200), union `U_V0_P10STRIDE`, struct offset 0xB4C (GPL-2.0, same-chip vendor header, byte-identical for Hi3516A V200 and Hi3519 V101). Reset value and access type unknown (modelled RW, no reset). Confidence: medium (vendor header for this chip family, not hardware verified).";

        field {
            name = "surface_cstride";
            desc = "[inferred] Surface cstride. (vendor header `product/hiosd/vo/hi3519/vou_reg.h` field `surface_cstride`; access and reset unknown, modelled RW)";
            sw = rw;
            hw = r;
        } surface_cstride[31:16];

        field {
            name = "surface_stride";
            desc = "[inferred] Surface stride. (vendor header `product/hiosd/vo/hi3519/vou_reg.h` field `surface_stride`; access and reset unknown, modelled RW)";
            sw = rw;
            hw = r;
        } surface_stride[15:0];
    } V0_P10STRIDE @ 0xB4C;

    reg {
        name = "V0 P10VFPOS";
        desc = "[inferred] V0 P10VFPOS. Not in the data sheet. Source: vendor U-Boot 2010.06 `product/hiosd/vo/hi3519/vou_reg.h` (GPL-2.0 U-Boot tree, HiSilicon copyright, created 2015-05-26; mirror github.com/OpenIPC/u-boot-hi3516cv200), union `U_V0_P10VFPOS`, struct offset 0xB50 (GPL-2.0, same-chip vendor header, byte-identical for Hi3516A V200 and Hi3519 V101). Reset value and access type unknown (modelled RW, no reset). Confidence: medium (vendor header for this chip family, not hardware verified).";

        field {
            name = "video_yfpos";
            desc = "[inferred] Video yfpos. (vendor header `product/hiosd/vo/hi3519/vou_reg.h` field `video_yfpos`; access and reset unknown, modelled RW)";
            sw = rw;
            hw = r;
        } video_yfpos[23:12];

        field {
            name = "video_xfpos";
            desc = "[inferred] Video xfpos. (vendor header `product/hiosd/vo/hi3519/vou_reg.h` field `video_xfpos`; access and reset unknown, modelled RW)";
            sw = rw;
            hw = r;
        } video_xfpos[11:0];
    } V0_P10VFPOS @ 0xB50;

    reg {
        name = "V0 P10VLPOS";
        desc = "[inferred] V0 P10VLPOS. Not in the data sheet. Source: vendor U-Boot 2010.06 `product/hiosd/vo/hi3519/vou_reg.h` (GPL-2.0 U-Boot tree, HiSilicon copyright, created 2015-05-26; mirror github.com/OpenIPC/u-boot-hi3516cv200), union `U_V0_P10VLPOS`, struct offset 0xB54 (GPL-2.0, same-chip vendor header, byte-identical for Hi3516A V200 and Hi3519 V101). Reset value and access type unknown (modelled RW, no reset). Confidence: medium (vendor header for this chip family, not hardware verified).";

        field {
            name = "video_ylpos";
            desc = "[inferred] Video ylpos. (vendor header `product/hiosd/vo/hi3519/vou_reg.h` field `video_ylpos`; access and reset unknown, modelled RW)";
            sw = rw;
            hw = r;
        } video_ylpos[23:12];

        field {
            name = "video_xlpos";
            desc = "[inferred] Video xlpos. (vendor header `product/hiosd/vo/hi3519/vou_reg.h` field `video_xlpos`; access and reset unknown, modelled RW)";
            sw = rw;
            hw = r;
        } video_xlpos[11:0];
    } V0_P10VLPOS @ 0xB54;

    reg {
        name = "V0 P11RESO";
        desc = "[inferred] V0 P11RESO. Not in the data sheet. Source: vendor U-Boot 2010.06 `product/hiosd/vo/hi3519/vou_reg.h` (GPL-2.0 U-Boot tree, HiSilicon copyright, created 2015-05-26; mirror github.com/OpenIPC/u-boot-hi3516cv200), union `U_V0_P11RESO`, struct offset 0xB60 (GPL-2.0, same-chip vendor header, byte-identical for Hi3516A V200 and Hi3519 V101). Reset value and access type unknown (modelled RW, no reset). Confidence: medium (vendor header for this chip family, not hardware verified).";

        field {
            name = "w";
            desc = "[inferred] W. (vendor header `product/hiosd/vo/hi3519/vou_reg.h` field `w`; access and reset unknown, modelled RW)";
            sw = rw;
            hw = r;
        } w_f[11:0];
    } V0_P11RESO @ 0xB60;

    reg {
        name = "V0 P11LADDR";
        desc = "[inferred] V0 P11LADDR. Not in the data sheet. Source: vendor U-Boot 2010.06 `product/hiosd/vo/hi3519/vou_reg.h` (GPL-2.0 U-Boot tree, HiSilicon copyright, created 2015-05-26; mirror github.com/OpenIPC/u-boot-hi3516cv200), union `U_V0_P11LADDR`, struct offset 0xB64 (GPL-2.0, same-chip vendor header, byte-identical for Hi3516A V200 and Hi3519 V101). Reset value and access type unknown (modelled RW, no reset). Confidence: medium (vendor header for this chip family, not hardware verified).";

        field {
            name = "surface_addr";
            desc = "[inferred] Surface address. (vendor header `product/hiosd/vo/hi3519/vou_reg.h` field `surface_addr`; access and reset unknown, modelled RW)";
            sw = rw;
            hw = r;
        } surface_addr[31:0];
    } V0_P11LADDR @ 0xB64;

    reg {
        name = "V0 P11CADDR";
        desc = "[inferred] V0 P11CADDR. Not in the data sheet. Source: vendor U-Boot 2010.06 `product/hiosd/vo/hi3519/vou_reg.h` (GPL-2.0 U-Boot tree, HiSilicon copyright, created 2015-05-26; mirror github.com/OpenIPC/u-boot-hi3516cv200), union `U_V0_P11CADDR`, struct offset 0xB68 (GPL-2.0, same-chip vendor header, byte-identical for Hi3516A V200 and Hi3519 V101). Reset value and access type unknown (modelled RW, no reset). Confidence: medium (vendor header for this chip family, not hardware verified).";

        field {
            name = "surface_addr";
            desc = "[inferred] Surface address. (vendor header `product/hiosd/vo/hi3519/vou_reg.h` field `surface_addr`; access and reset unknown, modelled RW)";
            sw = rw;
            hw = r;
        } surface_addr[31:0];
    } V0_P11CADDR @ 0xB68;

    reg {
        name = "V0 P11STRIDE";
        desc = "[inferred] V0 P11STRIDE. Not in the data sheet. Source: vendor U-Boot 2010.06 `product/hiosd/vo/hi3519/vou_reg.h` (GPL-2.0 U-Boot tree, HiSilicon copyright, created 2015-05-26; mirror github.com/OpenIPC/u-boot-hi3516cv200), union `U_V0_P11STRIDE`, struct offset 0xB6C (GPL-2.0, same-chip vendor header, byte-identical for Hi3516A V200 and Hi3519 V101). Reset value and access type unknown (modelled RW, no reset). Confidence: medium (vendor header for this chip family, not hardware verified).";

        field {
            name = "surface_cstride";
            desc = "[inferred] Surface cstride. (vendor header `product/hiosd/vo/hi3519/vou_reg.h` field `surface_cstride`; access and reset unknown, modelled RW)";
            sw = rw;
            hw = r;
        } surface_cstride[31:16];

        field {
            name = "surface_stride";
            desc = "[inferred] Surface stride. (vendor header `product/hiosd/vo/hi3519/vou_reg.h` field `surface_stride`; access and reset unknown, modelled RW)";
            sw = rw;
            hw = r;
        } surface_stride[15:0];
    } V0_P11STRIDE @ 0xB6C;

    reg {
        name = "V0 P11VFPOS";
        desc = "[inferred] V0 P11VFPOS. Not in the data sheet. Source: vendor U-Boot 2010.06 `product/hiosd/vo/hi3519/vou_reg.h` (GPL-2.0 U-Boot tree, HiSilicon copyright, created 2015-05-26; mirror github.com/OpenIPC/u-boot-hi3516cv200), union `U_V0_P11VFPOS`, struct offset 0xB70 (GPL-2.0, same-chip vendor header, byte-identical for Hi3516A V200 and Hi3519 V101). Reset value and access type unknown (modelled RW, no reset). Confidence: medium (vendor header for this chip family, not hardware verified).";

        field {
            name = "video_yfpos";
            desc = "[inferred] Video yfpos. (vendor header `product/hiosd/vo/hi3519/vou_reg.h` field `video_yfpos`; access and reset unknown, modelled RW)";
            sw = rw;
            hw = r;
        } video_yfpos[23:12];

        field {
            name = "video_xfpos";
            desc = "[inferred] Video xfpos. (vendor header `product/hiosd/vo/hi3519/vou_reg.h` field `video_xfpos`; access and reset unknown, modelled RW)";
            sw = rw;
            hw = r;
        } video_xfpos[11:0];
    } V0_P11VFPOS @ 0xB70;

    reg {
        name = "V0 P11VLPOS";
        desc = "[inferred] V0 P11VLPOS. Not in the data sheet. Source: vendor U-Boot 2010.06 `product/hiosd/vo/hi3519/vou_reg.h` (GPL-2.0 U-Boot tree, HiSilicon copyright, created 2015-05-26; mirror github.com/OpenIPC/u-boot-hi3516cv200), union `U_V0_P11VLPOS`, struct offset 0xB74 (GPL-2.0, same-chip vendor header, byte-identical for Hi3516A V200 and Hi3519 V101). Reset value and access type unknown (modelled RW, no reset). Confidence: medium (vendor header for this chip family, not hardware verified).";

        field {
            name = "video_ylpos";
            desc = "[inferred] Video ylpos. (vendor header `product/hiosd/vo/hi3519/vou_reg.h` field `video_ylpos`; access and reset unknown, modelled RW)";
            sw = rw;
            hw = r;
        } video_ylpos[23:12];

        field {
            name = "video_xlpos";
            desc = "[inferred] Video xlpos. (vendor header `product/hiosd/vo/hi3519/vou_reg.h` field `video_xlpos`; access and reset unknown, modelled RW)";
            sw = rw;
            hw = r;
        } video_xlpos[11:0];
    } V0_P11VLPOS @ 0xB74;

    reg {
        name = "V0 P12RESO";
        desc = "[inferred] V0 P12RESO. Not in the data sheet. Source: vendor U-Boot 2010.06 `product/hiosd/vo/hi3519/vou_reg.h` (GPL-2.0 U-Boot tree, HiSilicon copyright, created 2015-05-26; mirror github.com/OpenIPC/u-boot-hi3516cv200), union `U_V0_P12RESO`, struct offset 0xB80 (GPL-2.0, same-chip vendor header, byte-identical for Hi3516A V200 and Hi3519 V101). Reset value and access type unknown (modelled RW, no reset). Confidence: medium (vendor header for this chip family, not hardware verified).";

        field {
            name = "w";
            desc = "[inferred] W. (vendor header `product/hiosd/vo/hi3519/vou_reg.h` field `w`; access and reset unknown, modelled RW)";
            sw = rw;
            hw = r;
        } w_f[11:0];
    } V0_P12RESO @ 0xB80;

    reg {
        name = "V0 P12LADDR";
        desc = "[inferred] V0 P12LADDR. Not in the data sheet. Source: vendor U-Boot 2010.06 `product/hiosd/vo/hi3519/vou_reg.h` (GPL-2.0 U-Boot tree, HiSilicon copyright, created 2015-05-26; mirror github.com/OpenIPC/u-boot-hi3516cv200), union `U_V0_P12LADDR`, struct offset 0xB84 (GPL-2.0, same-chip vendor header, byte-identical for Hi3516A V200 and Hi3519 V101). Reset value and access type unknown (modelled RW, no reset). Confidence: medium (vendor header for this chip family, not hardware verified).";

        field {
            name = "surface_addr";
            desc = "[inferred] Surface address. (vendor header `product/hiosd/vo/hi3519/vou_reg.h` field `surface_addr`; access and reset unknown, modelled RW)";
            sw = rw;
            hw = r;
        } surface_addr[31:0];
    } V0_P12LADDR @ 0xB84;

    reg {
        name = "V0 P12CADDR";
        desc = "[inferred] V0 P12CADDR. Not in the data sheet. Source: vendor U-Boot 2010.06 `product/hiosd/vo/hi3519/vou_reg.h` (GPL-2.0 U-Boot tree, HiSilicon copyright, created 2015-05-26; mirror github.com/OpenIPC/u-boot-hi3516cv200), union `U_V0_P12CADDR`, struct offset 0xB88 (GPL-2.0, same-chip vendor header, byte-identical for Hi3516A V200 and Hi3519 V101). Reset value and access type unknown (modelled RW, no reset). Confidence: medium (vendor header for this chip family, not hardware verified).";

        field {
            name = "surface_addr";
            desc = "[inferred] Surface address. (vendor header `product/hiosd/vo/hi3519/vou_reg.h` field `surface_addr`; access and reset unknown, modelled RW)";
            sw = rw;
            hw = r;
        } surface_addr[31:0];
    } V0_P12CADDR @ 0xB88;

    reg {
        name = "V0 P12STRIDE";
        desc = "[inferred] V0 P12STRIDE. Not in the data sheet. Source: vendor U-Boot 2010.06 `product/hiosd/vo/hi3519/vou_reg.h` (GPL-2.0 U-Boot tree, HiSilicon copyright, created 2015-05-26; mirror github.com/OpenIPC/u-boot-hi3516cv200), union `U_V0_P12STRIDE`, struct offset 0xB8C (GPL-2.0, same-chip vendor header, byte-identical for Hi3516A V200 and Hi3519 V101). Reset value and access type unknown (modelled RW, no reset). Confidence: medium (vendor header for this chip family, not hardware verified).";

        field {
            name = "surface_cstride";
            desc = "[inferred] Surface cstride. (vendor header `product/hiosd/vo/hi3519/vou_reg.h` field `surface_cstride`; access and reset unknown, modelled RW)";
            sw = rw;
            hw = r;
        } surface_cstride[31:16];

        field {
            name = "surface_stride";
            desc = "[inferred] Surface stride. (vendor header `product/hiosd/vo/hi3519/vou_reg.h` field `surface_stride`; access and reset unknown, modelled RW)";
            sw = rw;
            hw = r;
        } surface_stride[15:0];
    } V0_P12STRIDE @ 0xB8C;

    reg {
        name = "V0 P12VFPOS";
        desc = "[inferred] V0 P12VFPOS. Not in the data sheet. Source: vendor U-Boot 2010.06 `product/hiosd/vo/hi3519/vou_reg.h` (GPL-2.0 U-Boot tree, HiSilicon copyright, created 2015-05-26; mirror github.com/OpenIPC/u-boot-hi3516cv200), union `U_V0_P12VFPOS`, struct offset 0xB90 (GPL-2.0, same-chip vendor header, byte-identical for Hi3516A V200 and Hi3519 V101). Reset value and access type unknown (modelled RW, no reset). Confidence: medium (vendor header for this chip family, not hardware verified).";

        field {
            name = "video_yfpos";
            desc = "[inferred] Video yfpos. (vendor header `product/hiosd/vo/hi3519/vou_reg.h` field `video_yfpos`; access and reset unknown, modelled RW)";
            sw = rw;
            hw = r;
        } video_yfpos[23:12];

        field {
            name = "video_xfpos";
            desc = "[inferred] Video xfpos. (vendor header `product/hiosd/vo/hi3519/vou_reg.h` field `video_xfpos`; access and reset unknown, modelled RW)";
            sw = rw;
            hw = r;
        } video_xfpos[11:0];
    } V0_P12VFPOS @ 0xB90;

    reg {
        name = "V0 P12VLPOS";
        desc = "[inferred] V0 P12VLPOS. Not in the data sheet. Source: vendor U-Boot 2010.06 `product/hiosd/vo/hi3519/vou_reg.h` (GPL-2.0 U-Boot tree, HiSilicon copyright, created 2015-05-26; mirror github.com/OpenIPC/u-boot-hi3516cv200), union `U_V0_P12VLPOS`, struct offset 0xB94 (GPL-2.0, same-chip vendor header, byte-identical for Hi3516A V200 and Hi3519 V101). Reset value and access type unknown (modelled RW, no reset). Confidence: medium (vendor header for this chip family, not hardware verified).";

        field {
            name = "video_ylpos";
            desc = "[inferred] Video ylpos. (vendor header `product/hiosd/vo/hi3519/vou_reg.h` field `video_ylpos`; access and reset unknown, modelled RW)";
            sw = rw;
            hw = r;
        } video_ylpos[23:12];

        field {
            name = "video_xlpos";
            desc = "[inferred] Video xlpos. (vendor header `product/hiosd/vo/hi3519/vou_reg.h` field `video_xlpos`; access and reset unknown, modelled RW)";
            sw = rw;
            hw = r;
        } video_xlpos[11:0];
    } V0_P12VLPOS @ 0xB94;

    reg {
        name = "V0 P13RESO";
        desc = "[inferred] V0 P13RESO. Not in the data sheet. Source: vendor U-Boot 2010.06 `product/hiosd/vo/hi3519/vou_reg.h` (GPL-2.0 U-Boot tree, HiSilicon copyright, created 2015-05-26; mirror github.com/OpenIPC/u-boot-hi3516cv200), union `U_V0_P13RESO`, struct offset 0xBA0 (GPL-2.0, same-chip vendor header, byte-identical for Hi3516A V200 and Hi3519 V101). Reset value and access type unknown (modelled RW, no reset). Confidence: medium (vendor header for this chip family, not hardware verified).";

        field {
            name = "w";
            desc = "[inferred] W. (vendor header `product/hiosd/vo/hi3519/vou_reg.h` field `w`; access and reset unknown, modelled RW)";
            sw = rw;
            hw = r;
        } w_f[11:0];
    } V0_P13RESO @ 0xBA0;

    reg {
        name = "V0 P13LADDR";
        desc = "[inferred] V0 P13LADDR. Not in the data sheet. Source: vendor U-Boot 2010.06 `product/hiosd/vo/hi3519/vou_reg.h` (GPL-2.0 U-Boot tree, HiSilicon copyright, created 2015-05-26; mirror github.com/OpenIPC/u-boot-hi3516cv200), union `U_V0_P13LADDR`, struct offset 0xBA4 (GPL-2.0, same-chip vendor header, byte-identical for Hi3516A V200 and Hi3519 V101). Reset value and access type unknown (modelled RW, no reset). Confidence: medium (vendor header for this chip family, not hardware verified).";

        field {
            name = "surface_addr";
            desc = "[inferred] Surface address. (vendor header `product/hiosd/vo/hi3519/vou_reg.h` field `surface_addr`; access and reset unknown, modelled RW)";
            sw = rw;
            hw = r;
        } surface_addr[31:0];
    } V0_P13LADDR @ 0xBA4;

    reg {
        name = "V0 P13CADDR";
        desc = "[inferred] V0 P13CADDR. Not in the data sheet. Source: vendor U-Boot 2010.06 `product/hiosd/vo/hi3519/vou_reg.h` (GPL-2.0 U-Boot tree, HiSilicon copyright, created 2015-05-26; mirror github.com/OpenIPC/u-boot-hi3516cv200), union `U_V0_P13CADDR`, struct offset 0xBA8 (GPL-2.0, same-chip vendor header, byte-identical for Hi3516A V200 and Hi3519 V101). Reset value and access type unknown (modelled RW, no reset). Confidence: medium (vendor header for this chip family, not hardware verified).";

        field {
            name = "surface_addr";
            desc = "[inferred] Surface address. (vendor header `product/hiosd/vo/hi3519/vou_reg.h` field `surface_addr`; access and reset unknown, modelled RW)";
            sw = rw;
            hw = r;
        } surface_addr[31:0];
    } V0_P13CADDR @ 0xBA8;

    reg {
        name = "V0 P13STRIDE";
        desc = "[inferred] V0 P13STRIDE. Not in the data sheet. Source: vendor U-Boot 2010.06 `product/hiosd/vo/hi3519/vou_reg.h` (GPL-2.0 U-Boot tree, HiSilicon copyright, created 2015-05-26; mirror github.com/OpenIPC/u-boot-hi3516cv200), union `U_V0_P13STRIDE`, struct offset 0xBAC (GPL-2.0, same-chip vendor header, byte-identical for Hi3516A V200 and Hi3519 V101). Reset value and access type unknown (modelled RW, no reset). Confidence: medium (vendor header for this chip family, not hardware verified).";

        field {
            name = "surface_cstride";
            desc = "[inferred] Surface cstride. (vendor header `product/hiosd/vo/hi3519/vou_reg.h` field `surface_cstride`; access and reset unknown, modelled RW)";
            sw = rw;
            hw = r;
        } surface_cstride[31:16];

        field {
            name = "surface_stride";
            desc = "[inferred] Surface stride. (vendor header `product/hiosd/vo/hi3519/vou_reg.h` field `surface_stride`; access and reset unknown, modelled RW)";
            sw = rw;
            hw = r;
        } surface_stride[15:0];
    } V0_P13STRIDE @ 0xBAC;

    reg {
        name = "V0 P13VFPOS";
        desc = "[inferred] V0 P13VFPOS. Not in the data sheet. Source: vendor U-Boot 2010.06 `product/hiosd/vo/hi3519/vou_reg.h` (GPL-2.0 U-Boot tree, HiSilicon copyright, created 2015-05-26; mirror github.com/OpenIPC/u-boot-hi3516cv200), union `U_V0_P13VFPOS`, struct offset 0xBB0 (GPL-2.0, same-chip vendor header, byte-identical for Hi3516A V200 and Hi3519 V101). Reset value and access type unknown (modelled RW, no reset). Confidence: medium (vendor header for this chip family, not hardware verified).";

        field {
            name = "video_yfpos";
            desc = "[inferred] Video yfpos. (vendor header `product/hiosd/vo/hi3519/vou_reg.h` field `video_yfpos`; access and reset unknown, modelled RW)";
            sw = rw;
            hw = r;
        } video_yfpos[23:12];

        field {
            name = "video_xfpos";
            desc = "[inferred] Video xfpos. (vendor header `product/hiosd/vo/hi3519/vou_reg.h` field `video_xfpos`; access and reset unknown, modelled RW)";
            sw = rw;
            hw = r;
        } video_xfpos[11:0];
    } V0_P13VFPOS @ 0xBB0;

    reg {
        name = "V0 P13VLPOS";
        desc = "[inferred] V0 P13VLPOS. Not in the data sheet. Source: vendor U-Boot 2010.06 `product/hiosd/vo/hi3519/vou_reg.h` (GPL-2.0 U-Boot tree, HiSilicon copyright, created 2015-05-26; mirror github.com/OpenIPC/u-boot-hi3516cv200), union `U_V0_P13VLPOS`, struct offset 0xBB4 (GPL-2.0, same-chip vendor header, byte-identical for Hi3516A V200 and Hi3519 V101). Reset value and access type unknown (modelled RW, no reset). Confidence: medium (vendor header for this chip family, not hardware verified).";

        field {
            name = "video_ylpos";
            desc = "[inferred] Video ylpos. (vendor header `product/hiosd/vo/hi3519/vou_reg.h` field `video_ylpos`; access and reset unknown, modelled RW)";
            sw = rw;
            hw = r;
        } video_ylpos[23:12];

        field {
            name = "video_xlpos";
            desc = "[inferred] Video xlpos. (vendor header `product/hiosd/vo/hi3519/vou_reg.h` field `video_xlpos`; access and reset unknown, modelled RW)";
            sw = rw;
            hw = r;
        } video_xlpos[11:0];
    } V0_P13VLPOS @ 0xBB4;

    reg {
        name = "V0 P14RESO";
        desc = "[inferred] V0 P14RESO. Not in the data sheet. Source: vendor U-Boot 2010.06 `product/hiosd/vo/hi3519/vou_reg.h` (GPL-2.0 U-Boot tree, HiSilicon copyright, created 2015-05-26; mirror github.com/OpenIPC/u-boot-hi3516cv200), union `U_V0_P14RESO`, struct offset 0xBC0 (GPL-2.0, same-chip vendor header, byte-identical for Hi3516A V200 and Hi3519 V101). Reset value and access type unknown (modelled RW, no reset). Confidence: medium (vendor header for this chip family, not hardware verified).";

        field {
            name = "w";
            desc = "[inferred] W. (vendor header `product/hiosd/vo/hi3519/vou_reg.h` field `w`; access and reset unknown, modelled RW)";
            sw = rw;
            hw = r;
        } w_f[11:0];
    } V0_P14RESO @ 0xBC0;

    reg {
        name = "V0 P14LADDR";
        desc = "[inferred] V0 P14LADDR. Not in the data sheet. Source: vendor U-Boot 2010.06 `product/hiosd/vo/hi3519/vou_reg.h` (GPL-2.0 U-Boot tree, HiSilicon copyright, created 2015-05-26; mirror github.com/OpenIPC/u-boot-hi3516cv200), union `U_V0_P14LADDR`, struct offset 0xBC4 (GPL-2.0, same-chip vendor header, byte-identical for Hi3516A V200 and Hi3519 V101). Reset value and access type unknown (modelled RW, no reset). Confidence: medium (vendor header for this chip family, not hardware verified).";

        field {
            name = "surface_addr";
            desc = "[inferred] Surface address. (vendor header `product/hiosd/vo/hi3519/vou_reg.h` field `surface_addr`; access and reset unknown, modelled RW)";
            sw = rw;
            hw = r;
        } surface_addr[31:0];
    } V0_P14LADDR @ 0xBC4;

    reg {
        name = "V0 P14CADDR";
        desc = "[inferred] V0 P14CADDR. Not in the data sheet. Source: vendor U-Boot 2010.06 `product/hiosd/vo/hi3519/vou_reg.h` (GPL-2.0 U-Boot tree, HiSilicon copyright, created 2015-05-26; mirror github.com/OpenIPC/u-boot-hi3516cv200), union `U_V0_P14CADDR`, struct offset 0xBC8 (GPL-2.0, same-chip vendor header, byte-identical for Hi3516A V200 and Hi3519 V101). Reset value and access type unknown (modelled RW, no reset). Confidence: medium (vendor header for this chip family, not hardware verified).";

        field {
            name = "surface_addr";
            desc = "[inferred] Surface address. (vendor header `product/hiosd/vo/hi3519/vou_reg.h` field `surface_addr`; access and reset unknown, modelled RW)";
            sw = rw;
            hw = r;
        } surface_addr[31:0];
    } V0_P14CADDR @ 0xBC8;

    reg {
        name = "V0 P14STRIDE";
        desc = "[inferred] V0 P14STRIDE. Not in the data sheet. Source: vendor U-Boot 2010.06 `product/hiosd/vo/hi3519/vou_reg.h` (GPL-2.0 U-Boot tree, HiSilicon copyright, created 2015-05-26; mirror github.com/OpenIPC/u-boot-hi3516cv200), union `U_V0_P14STRIDE`, struct offset 0xBCC (GPL-2.0, same-chip vendor header, byte-identical for Hi3516A V200 and Hi3519 V101). Reset value and access type unknown (modelled RW, no reset). Confidence: medium (vendor header for this chip family, not hardware verified).";

        field {
            name = "surface_cstride";
            desc = "[inferred] Surface cstride. (vendor header `product/hiosd/vo/hi3519/vou_reg.h` field `surface_cstride`; access and reset unknown, modelled RW)";
            sw = rw;
            hw = r;
        } surface_cstride[31:16];

        field {
            name = "surface_stride";
            desc = "[inferred] Surface stride. (vendor header `product/hiosd/vo/hi3519/vou_reg.h` field `surface_stride`; access and reset unknown, modelled RW)";
            sw = rw;
            hw = r;
        } surface_stride[15:0];
    } V0_P14STRIDE @ 0xBCC;

    reg {
        name = "V0 P14VFPOS";
        desc = "[inferred] V0 P14VFPOS. Not in the data sheet. Source: vendor U-Boot 2010.06 `product/hiosd/vo/hi3519/vou_reg.h` (GPL-2.0 U-Boot tree, HiSilicon copyright, created 2015-05-26; mirror github.com/OpenIPC/u-boot-hi3516cv200), union `U_V0_P14VFPOS`, struct offset 0xBD0 (GPL-2.0, same-chip vendor header, byte-identical for Hi3516A V200 and Hi3519 V101). Reset value and access type unknown (modelled RW, no reset). Confidence: medium (vendor header for this chip family, not hardware verified).";

        field {
            name = "video_yfpos";
            desc = "[inferred] Video yfpos. (vendor header `product/hiosd/vo/hi3519/vou_reg.h` field `video_yfpos`; access and reset unknown, modelled RW)";
            sw = rw;
            hw = r;
        } video_yfpos[23:12];

        field {
            name = "video_xfpos";
            desc = "[inferred] Video xfpos. (vendor header `product/hiosd/vo/hi3519/vou_reg.h` field `video_xfpos`; access and reset unknown, modelled RW)";
            sw = rw;
            hw = r;
        } video_xfpos[11:0];
    } V0_P14VFPOS @ 0xBD0;

    reg {
        name = "V0 P14VLPOS";
        desc = "[inferred] V0 P14VLPOS. Not in the data sheet. Source: vendor U-Boot 2010.06 `product/hiosd/vo/hi3519/vou_reg.h` (GPL-2.0 U-Boot tree, HiSilicon copyright, created 2015-05-26; mirror github.com/OpenIPC/u-boot-hi3516cv200), union `U_V0_P14VLPOS`, struct offset 0xBD4 (GPL-2.0, same-chip vendor header, byte-identical for Hi3516A V200 and Hi3519 V101). Reset value and access type unknown (modelled RW, no reset). Confidence: medium (vendor header for this chip family, not hardware verified).";

        field {
            name = "video_ylpos";
            desc = "[inferred] Video ylpos. (vendor header `product/hiosd/vo/hi3519/vou_reg.h` field `video_ylpos`; access and reset unknown, modelled RW)";
            sw = rw;
            hw = r;
        } video_ylpos[23:12];

        field {
            name = "video_xlpos";
            desc = "[inferred] Video xlpos. (vendor header `product/hiosd/vo/hi3519/vou_reg.h` field `video_xlpos`; access and reset unknown, modelled RW)";
            sw = rw;
            hw = r;
        } video_xlpos[11:0];
    } V0_P14VLPOS @ 0xBD4;

    reg {
        name = "V0 P15RESO";
        desc = "[inferred] V0 P15RESO. Not in the data sheet. Source: vendor U-Boot 2010.06 `product/hiosd/vo/hi3519/vou_reg.h` (GPL-2.0 U-Boot tree, HiSilicon copyright, created 2015-05-26; mirror github.com/OpenIPC/u-boot-hi3516cv200), union `U_V0_P15RESO`, struct offset 0xBE0 (GPL-2.0, same-chip vendor header, byte-identical for Hi3516A V200 and Hi3519 V101). Reset value and access type unknown (modelled RW, no reset). Confidence: medium (vendor header for this chip family, not hardware verified).";

        field {
            name = "w";
            desc = "[inferred] W. (vendor header `product/hiosd/vo/hi3519/vou_reg.h` field `w`; access and reset unknown, modelled RW)";
            sw = rw;
            hw = r;
        } w_f[11:0];
    } V0_P15RESO @ 0xBE0;

    reg {
        name = "V0 P15LADDR";
        desc = "[inferred] V0 P15LADDR. Not in the data sheet. Source: vendor U-Boot 2010.06 `product/hiosd/vo/hi3519/vou_reg.h` (GPL-2.0 U-Boot tree, HiSilicon copyright, created 2015-05-26; mirror github.com/OpenIPC/u-boot-hi3516cv200), union `U_V0_P15LADDR`, struct offset 0xBE4 (GPL-2.0, same-chip vendor header, byte-identical for Hi3516A V200 and Hi3519 V101). Reset value and access type unknown (modelled RW, no reset). Confidence: medium (vendor header for this chip family, not hardware verified).";

        field {
            name = "surface_addr";
            desc = "[inferred] Surface address. (vendor header `product/hiosd/vo/hi3519/vou_reg.h` field `surface_addr`; access and reset unknown, modelled RW)";
            sw = rw;
            hw = r;
        } surface_addr[31:0];
    } V0_P15LADDR @ 0xBE4;

    reg {
        name = "V0 P15CADDR";
        desc = "[inferred] V0 P15CADDR. Not in the data sheet. Source: vendor U-Boot 2010.06 `product/hiosd/vo/hi3519/vou_reg.h` (GPL-2.0 U-Boot tree, HiSilicon copyright, created 2015-05-26; mirror github.com/OpenIPC/u-boot-hi3516cv200), union `U_V0_P15CADDR`, struct offset 0xBE8 (GPL-2.0, same-chip vendor header, byte-identical for Hi3516A V200 and Hi3519 V101). Reset value and access type unknown (modelled RW, no reset). Confidence: medium (vendor header for this chip family, not hardware verified).";

        field {
            name = "surface_addr";
            desc = "[inferred] Surface address. (vendor header `product/hiosd/vo/hi3519/vou_reg.h` field `surface_addr`; access and reset unknown, modelled RW)";
            sw = rw;
            hw = r;
        } surface_addr[31:0];
    } V0_P15CADDR @ 0xBE8;

    reg {
        name = "V0 P15STRIDE";
        desc = "[inferred] V0 P15STRIDE. Not in the data sheet. Source: vendor U-Boot 2010.06 `product/hiosd/vo/hi3519/vou_reg.h` (GPL-2.0 U-Boot tree, HiSilicon copyright, created 2015-05-26; mirror github.com/OpenIPC/u-boot-hi3516cv200), union `U_V0_P15STRIDE`, struct offset 0xBEC (GPL-2.0, same-chip vendor header, byte-identical for Hi3516A V200 and Hi3519 V101). Reset value and access type unknown (modelled RW, no reset). Confidence: medium (vendor header for this chip family, not hardware verified).";

        field {
            name = "surface_cstride";
            desc = "[inferred] Surface cstride. (vendor header `product/hiosd/vo/hi3519/vou_reg.h` field `surface_cstride`; access and reset unknown, modelled RW)";
            sw = rw;
            hw = r;
        } surface_cstride[31:16];

        field {
            name = "surface_stride";
            desc = "[inferred] Surface stride. (vendor header `product/hiosd/vo/hi3519/vou_reg.h` field `surface_stride`; access and reset unknown, modelled RW)";
            sw = rw;
            hw = r;
        } surface_stride[15:0];
    } V0_P15STRIDE @ 0xBEC;

    reg {
        name = "V0 P15VFPOS";
        desc = "[inferred] V0 P15VFPOS. Not in the data sheet. Source: vendor U-Boot 2010.06 `product/hiosd/vo/hi3519/vou_reg.h` (GPL-2.0 U-Boot tree, HiSilicon copyright, created 2015-05-26; mirror github.com/OpenIPC/u-boot-hi3516cv200), union `U_V0_P15VFPOS`, struct offset 0xBF0 (GPL-2.0, same-chip vendor header, byte-identical for Hi3516A V200 and Hi3519 V101). Reset value and access type unknown (modelled RW, no reset). Confidence: medium (vendor header for this chip family, not hardware verified).";

        field {
            name = "video_yfpos";
            desc = "[inferred] Video yfpos. (vendor header `product/hiosd/vo/hi3519/vou_reg.h` field `video_yfpos`; access and reset unknown, modelled RW)";
            sw = rw;
            hw = r;
        } video_yfpos[23:12];

        field {
            name = "video_xfpos";
            desc = "[inferred] Video xfpos. (vendor header `product/hiosd/vo/hi3519/vou_reg.h` field `video_xfpos`; access and reset unknown, modelled RW)";
            sw = rw;
            hw = r;
        } video_xfpos[11:0];
    } V0_P15VFPOS @ 0xBF0;

    reg {
        name = "V0 P15VLPOS";
        desc = "[inferred] V0 P15VLPOS. Not in the data sheet. Source: vendor U-Boot 2010.06 `product/hiosd/vo/hi3519/vou_reg.h` (GPL-2.0 U-Boot tree, HiSilicon copyright, created 2015-05-26; mirror github.com/OpenIPC/u-boot-hi3516cv200), union `U_V0_P15VLPOS`, struct offset 0xBF4 (GPL-2.0, same-chip vendor header, byte-identical for Hi3516A V200 and Hi3519 V101). Reset value and access type unknown (modelled RW, no reset). Confidence: medium (vendor header for this chip family, not hardware verified).";

        field {
            name = "video_ylpos";
            desc = "[inferred] Video ylpos. (vendor header `product/hiosd/vo/hi3519/vou_reg.h` field `video_ylpos`; access and reset unknown, modelled RW)";
            sw = rw;
            hw = r;
        } video_ylpos[23:12];

        field {
            name = "video_xlpos";
            desc = "[inferred] Video xlpos. (vendor header `product/hiosd/vo/hi3519/vou_reg.h` field `video_xlpos`; access and reset unknown, modelled RW)";
            sw = rw;
            hw = r;
        } video_xlpos[11:0];
    } V0_P15VLPOS @ 0xBF4;

    reg {
        name = "V0 NADDR";
        desc = "[inferred] V0 NADDR. Not in the data sheet. Source: vendor U-Boot 2010.06 `product/hiosd/vo/hi3519/vou_reg.h` (GPL-2.0 U-Boot tree, HiSilicon copyright, created 2015-05-26; mirror github.com/OpenIPC/u-boot-hi3516cv200), union `U_V0_NADDR`, struct offset 0xE00 (GPL-2.0, same-chip vendor header, byte-identical for Hi3516A V200 and Hi3519 V101). Reset value and access type unknown (modelled RW, no reset). Confidence: medium (vendor header for this chip family, not hardware verified).";

        field {
            name = "surface_naddr";
            desc = "[inferred] Surface naddr. (vendor header `product/hiosd/vo/hi3519/vou_reg.h` field `surface_naddr`; access and reset unknown, modelled RW)";
            sw = rw;
            hw = r;
        } surface_naddr[31:0];
    } V0_NADDR @ 0xE00;

    reg {
        name = "V0 NCADDR";
        desc = "[inferred] V0 NCADDR. Not in the data sheet. Source: vendor U-Boot 2010.06 `product/hiosd/vo/hi3519/vou_reg.h` (GPL-2.0 U-Boot tree, HiSilicon copyright, created 2015-05-26; mirror github.com/OpenIPC/u-boot-hi3516cv200), union `U_V0_NCADDR`, struct offset 0xE04 (GPL-2.0, same-chip vendor header, byte-identical for Hi3516A V200 and Hi3519 V101). Reset value and access type unknown (modelled RW, no reset). Confidence: medium (vendor header for this chip family, not hardware verified).";

        field {
            name = "surface_ncaddr";
            desc = "[inferred] Surface ncaddr. (vendor header `product/hiosd/vo/hi3519/vou_reg.h` field `surface_ncaddr`; access and reset unknown, modelled RW)";
            sw = rw;
            hw = r;
        } surface_ncaddr[31:0];
    } V0_NCADDR @ 0xE04;

    reg {
        name = "V0 MULTI mode";
        desc = "[inferred] V0 MULTI mode. Not in the data sheet. Source: vendor U-Boot 2010.06 `product/hiosd/vo/hi3519/vou_reg.h` (GPL-2.0 U-Boot tree, HiSilicon copyright, created 2015-05-26; mirror github.com/OpenIPC/u-boot-hi3516cv200), union `U_V0_MULTI_MODE`, struct offset 0xE30 (GPL-2.0, same-chip vendor header, byte-identical for Hi3516A V200 and Hi3519 V101). Reset value and access type unknown (modelled RW, no reset). Confidence: medium (vendor header for this chip family, not hardware verified).";

        field {
            name = "mrg_mode";
            desc = "[inferred] Mrg mode. (vendor header `product/hiosd/vo/hi3519/vou_reg.h` field `mrg_mode`; access and reset unknown, modelled RW)";
            sw = rw;
            hw = r;
        } mrg_mode[0:0];
    } V0_MULTI_MODE @ 0xE30;

    reg {
        name = "V0 LADDROFFSET";
        desc = "[inferred] V0 LADDROFFSET. Not in the data sheet. Source: vendor U-Boot 2010.06 `product/hiosd/vo/hi3519/vou_reg.h` (GPL-2.0 U-Boot tree, HiSilicon copyright, created 2015-05-26; mirror github.com/OpenIPC/u-boot-hi3516cv200), union `U_V0_LADDROFFSET`, struct offset 0xE40 (GPL-2.0, same-chip vendor header, byte-identical for Hi3516A V200 and Hi3519 V101). Reset value and access type unknown (modelled RW, no reset). Confidence: medium (vendor header for this chip family, not hardware verified).";

        field {
            name = "laddr_offset";
            desc = "[inferred] Laddr offset. (vendor header `product/hiosd/vo/hi3519/vou_reg.h` field `laddr_offset`; access and reset unknown, modelled RW)";
            sw = rw;
            hw = r;
        } laddr_offset[31:0];
    } V0_LADDROFFSET @ 0xE40;

    reg {
        name = "V0 CADDROFFSET";
        desc = "[inferred] V0 CADDROFFSET. Not in the data sheet. Source: vendor U-Boot 2010.06 `product/hiosd/vo/hi3519/vou_reg.h` (GPL-2.0 U-Boot tree, HiSilicon copyright, created 2015-05-26; mirror github.com/OpenIPC/u-boot-hi3516cv200), union `U_V0_CADDROFFSET`, struct offset 0xE44 (GPL-2.0, same-chip vendor header, byte-identical for Hi3516A V200 and Hi3519 V101). Reset value and access type unknown (modelled RW, no reset). Confidence: medium (vendor header for this chip family, not hardware verified).";

        field {
            name = "caddr_offset";
            desc = "[inferred] Caddr offset. (vendor header `product/hiosd/vo/hi3519/vou_reg.h` field `caddr_offset`; access and reset unknown, modelled RW)";
            sw = rw;
            hw = r;
        } caddr_offset[31:0];
    } V0_CADDROFFSET @ 0xE44;

    reg {
        name = "V0 16REGIONENL";
        desc = "[inferred] V0 16REGIONENL. Not in the data sheet. Source: vendor U-Boot 2010.06 `product/hiosd/vo/hi3519/vou_reg.h` (GPL-2.0 U-Boot tree, HiSilicon copyright, created 2015-05-26; mirror github.com/OpenIPC/u-boot-hi3516cv200), union `U_V0_16REGIONENL`, struct offset 0xF00 (GPL-2.0, same-chip vendor header, byte-identical for Hi3516A V200 and Hi3519 V101). Reset value and access type unknown (modelled RW, no reset). Confidence: medium (vendor header for this chip family, not hardware verified).";

        field {
            name = "p15_en";
            desc = "[inferred] P15 enable. (vendor header `product/hiosd/vo/hi3519/vou_reg.h` field `p15_en`; access and reset unknown, modelled RW)";
            sw = rw;
            hw = r;
        } p15_en[15:15];

        field {
            name = "p14_en";
            desc = "[inferred] P14 enable. (vendor header `product/hiosd/vo/hi3519/vou_reg.h` field `p14_en`; access and reset unknown, modelled RW)";
            sw = rw;
            hw = r;
        } p14_en[14:14];

        field {
            name = "p13_en";
            desc = "[inferred] P13 enable. (vendor header `product/hiosd/vo/hi3519/vou_reg.h` field `p13_en`; access and reset unknown, modelled RW)";
            sw = rw;
            hw = r;
        } p13_en[13:13];

        field {
            name = "p12_en";
            desc = "[inferred] P12 enable. (vendor header `product/hiosd/vo/hi3519/vou_reg.h` field `p12_en`; access and reset unknown, modelled RW)";
            sw = rw;
            hw = r;
        } p12_en[12:12];

        field {
            name = "p11_en";
            desc = "[inferred] P11 enable. (vendor header `product/hiosd/vo/hi3519/vou_reg.h` field `p11_en`; access and reset unknown, modelled RW)";
            sw = rw;
            hw = r;
        } p11_en[11:11];

        field {
            name = "p10_en";
            desc = "[inferred] P10 enable. (vendor header `product/hiosd/vo/hi3519/vou_reg.h` field `p10_en`; access and reset unknown, modelled RW)";
            sw = rw;
            hw = r;
        } p10_en[10:10];

        field {
            name = "p9_en";
            desc = "[inferred] P9 enable. (vendor header `product/hiosd/vo/hi3519/vou_reg.h` field `p9_en`; access and reset unknown, modelled RW)";
            sw = rw;
            hw = r;
        } p9_en[9:9];

        field {
            name = "p8_en";
            desc = "[inferred] P8 enable. (vendor header `product/hiosd/vo/hi3519/vou_reg.h` field `p8_en`; access and reset unknown, modelled RW)";
            sw = rw;
            hw = r;
        } p8_en[8:8];

        field {
            name = "p7_en";
            desc = "[inferred] P7 enable. (vendor header `product/hiosd/vo/hi3519/vou_reg.h` field `p7_en`; access and reset unknown, modelled RW)";
            sw = rw;
            hw = r;
        } p7_en[7:7];

        field {
            name = "p6_en";
            desc = "[inferred] P6 enable. (vendor header `product/hiosd/vo/hi3519/vou_reg.h` field `p6_en`; access and reset unknown, modelled RW)";
            sw = rw;
            hw = r;
        } p6_en[6:6];

        field {
            name = "p5_en";
            desc = "[inferred] P5 enable. (vendor header `product/hiosd/vo/hi3519/vou_reg.h` field `p5_en`; access and reset unknown, modelled RW)";
            sw = rw;
            hw = r;
        } p5_en[5:5];

        field {
            name = "p4_en";
            desc = "[inferred] P4 enable. (vendor header `product/hiosd/vo/hi3519/vou_reg.h` field `p4_en`; access and reset unknown, modelled RW)";
            sw = rw;
            hw = r;
        } p4_en[4:4];

        field {
            name = "p3_en";
            desc = "[inferred] P3 enable. (vendor header `product/hiosd/vo/hi3519/vou_reg.h` field `p3_en`; access and reset unknown, modelled RW)";
            sw = rw;
            hw = r;
        } p3_en[3:3];

        field {
            name = "p2_en";
            desc = "[inferred] P2 enable. (vendor header `product/hiosd/vo/hi3519/vou_reg.h` field `p2_en`; access and reset unknown, modelled RW)";
            sw = rw;
            hw = r;
        } p2_en[2:2];

        field {
            name = "p1_en";
            desc = "[inferred] P1 enable. (vendor header `product/hiosd/vo/hi3519/vou_reg.h` field `p1_en`; access and reset unknown, modelled RW)";
            sw = rw;
            hw = r;
        } p1_en[1:1];

        field {
            name = "p0_en";
            desc = "[inferred] P0 enable. (vendor header `product/hiosd/vo/hi3519/vou_reg.h` field `p0_en`; access and reset unknown, modelled RW)";
            sw = rw;
            hw = r;
        } p0_en[0:0];
    } V0_16REGIONENL @ 0xF00;

    reg {
        name = "V0 16MUTE";
        desc = "[inferred] V0 16MUTE. Not in the data sheet. Source: vendor U-Boot 2010.06 `product/hiosd/vo/hi3519/vou_reg.h` (GPL-2.0 U-Boot tree, HiSilicon copyright, created 2015-05-26; mirror github.com/OpenIPC/u-boot-hi3516cv200), union `U_V0_16MUTE`, struct offset 0xF08 (GPL-2.0, same-chip vendor header, byte-identical for Hi3516A V200 and Hi3519 V101). Reset value and access type unknown (modelled RW, no reset). Confidence: medium (vendor header for this chip family, not hardware verified).";

        field {
            name = "p15_mute_en";
            desc = "[inferred] P15 mute enable. (vendor header `product/hiosd/vo/hi3519/vou_reg.h` field `p15_mute_en`; access and reset unknown, modelled RW)";
            sw = rw;
            hw = r;
        } p15_mute_en[15:15];

        field {
            name = "p14_mute_en";
            desc = "[inferred] P14 mute enable. (vendor header `product/hiosd/vo/hi3519/vou_reg.h` field `p14_mute_en`; access and reset unknown, modelled RW)";
            sw = rw;
            hw = r;
        } p14_mute_en[14:14];

        field {
            name = "p13_mute_en";
            desc = "[inferred] P13 mute enable. (vendor header `product/hiosd/vo/hi3519/vou_reg.h` field `p13_mute_en`; access and reset unknown, modelled RW)";
            sw = rw;
            hw = r;
        } p13_mute_en[13:13];

        field {
            name = "p12_mute_en";
            desc = "[inferred] P12 mute enable. (vendor header `product/hiosd/vo/hi3519/vou_reg.h` field `p12_mute_en`; access and reset unknown, modelled RW)";
            sw = rw;
            hw = r;
        } p12_mute_en[12:12];

        field {
            name = "p11_mute_en";
            desc = "[inferred] P11 mute enable. (vendor header `product/hiosd/vo/hi3519/vou_reg.h` field `p11_mute_en`; access and reset unknown, modelled RW)";
            sw = rw;
            hw = r;
        } p11_mute_en[11:11];

        field {
            name = "p10_mute_en";
            desc = "[inferred] P10 mute enable. (vendor header `product/hiosd/vo/hi3519/vou_reg.h` field `p10_mute_en`; access and reset unknown, modelled RW)";
            sw = rw;
            hw = r;
        } p10_mute_en[10:10];

        field {
            name = "p9_mute_en";
            desc = "[inferred] P9 mute enable. (vendor header `product/hiosd/vo/hi3519/vou_reg.h` field `p9_mute_en`; access and reset unknown, modelled RW)";
            sw = rw;
            hw = r;
        } p9_mute_en[9:9];

        field {
            name = "p8_mute_en";
            desc = "[inferred] P8 mute enable. (vendor header `product/hiosd/vo/hi3519/vou_reg.h` field `p8_mute_en`; access and reset unknown, modelled RW)";
            sw = rw;
            hw = r;
        } p8_mute_en[8:8];

        field {
            name = "p7_mute_en";
            desc = "[inferred] P7 mute enable. (vendor header `product/hiosd/vo/hi3519/vou_reg.h` field `p7_mute_en`; access and reset unknown, modelled RW)";
            sw = rw;
            hw = r;
        } p7_mute_en[7:7];

        field {
            name = "p6_mute_en";
            desc = "[inferred] P6 mute enable. (vendor header `product/hiosd/vo/hi3519/vou_reg.h` field `p6_mute_en`; access and reset unknown, modelled RW)";
            sw = rw;
            hw = r;
        } p6_mute_en[6:6];

        field {
            name = "p5_mute_en";
            desc = "[inferred] P5 mute enable. (vendor header `product/hiosd/vo/hi3519/vou_reg.h` field `p5_mute_en`; access and reset unknown, modelled RW)";
            sw = rw;
            hw = r;
        } p5_mute_en[5:5];

        field {
            name = "p4_mute_en";
            desc = "[inferred] P4 mute enable. (vendor header `product/hiosd/vo/hi3519/vou_reg.h` field `p4_mute_en`; access and reset unknown, modelled RW)";
            sw = rw;
            hw = r;
        } p4_mute_en[4:4];

        field {
            name = "p3_mute_en";
            desc = "[inferred] P3 mute enable. (vendor header `product/hiosd/vo/hi3519/vou_reg.h` field `p3_mute_en`; access and reset unknown, modelled RW)";
            sw = rw;
            hw = r;
        } p3_mute_en[3:3];

        field {
            name = "p2_mute_en";
            desc = "[inferred] P2 mute enable. (vendor header `product/hiosd/vo/hi3519/vou_reg.h` field `p2_mute_en`; access and reset unknown, modelled RW)";
            sw = rw;
            hw = r;
        } p2_mute_en[2:2];

        field {
            name = "p1_mute_en";
            desc = "[inferred] P1 mute enable. (vendor header `product/hiosd/vo/hi3519/vou_reg.h` field `p1_mute_en`; access and reset unknown, modelled RW)";
            sw = rw;
            hw = r;
        } p1_mute_en[1:1];

        field {
            name = "p0_mute_en";
            desc = "[inferred] P0 mute enable. (vendor header `product/hiosd/vo/hi3519/vou_reg.h` field `p0_mute_en`; access and reset unknown, modelled RW)";
            sw = rw;
            hw = r;
        } p0_mute_en[0:0];
    } V0_16MUTE @ 0xF08;

    reg {
        name = "V0 decompression LSTATE0";
        desc = "[inferred] V0 decompression LSTATE0. Not in the data sheet. Source: vendor U-Boot 2010.06 `product/hiosd/vo/hi3519/vou_reg.h` (GPL-2.0 U-Boot tree, HiSilicon copyright, created 2015-05-26; mirror github.com/OpenIPC/u-boot-hi3516cv200), union `U_V0_DCMP_LSTATE0`, struct offset 0xF20 (GPL-2.0, same-chip vendor header, byte-identical for Hi3516A V200 and Hi3519 V101). Reset value and access type unknown (modelled RW, no reset). Confidence: medium (vendor header for this chip family, not hardware verified).";

        field {
            name = "dcmp_l_state0";
            desc = "[inferred] Decompression l state0. (vendor header `product/hiosd/vo/hi3519/vou_reg.h` field `dcmp_l_state0`; access and reset unknown, modelled RW)";
            sw = rw;
            hw = r;
        } dcmp_l_state0[31:0];
    } V0_DCMP_LSTATE0 @ 0xF20;

    reg {
        name = "V0 decompression LSTATE1";
        desc = "[inferred] V0 decompression LSTATE1. Not in the data sheet. Source: vendor U-Boot 2010.06 `product/hiosd/vo/hi3519/vou_reg.h` (GPL-2.0 U-Boot tree, HiSilicon copyright, created 2015-05-26; mirror github.com/OpenIPC/u-boot-hi3516cv200), union `U_V0_DCMP_LSTATE1`, struct offset 0xF24 (GPL-2.0, same-chip vendor header, byte-identical for Hi3516A V200 and Hi3519 V101). Reset value and access type unknown (modelled RW, no reset). Confidence: medium (vendor header for this chip family, not hardware verified).";

        field {
            name = "dcmp_l_state1";
            desc = "[inferred] Decompression l state1. (vendor header `product/hiosd/vo/hi3519/vou_reg.h` field `dcmp_l_state1`; access and reset unknown, modelled RW)";
            sw = rw;
            hw = r;
        } dcmp_l_state1[31:0];
    } V0_DCMP_LSTATE1 @ 0xF24;

    reg {
        name = "V0 decompression CSTATE0";
        desc = "[inferred] V0 decompression CSTATE0. Not in the data sheet. Source: vendor U-Boot 2010.06 `product/hiosd/vo/hi3519/vou_reg.h` (GPL-2.0 U-Boot tree, HiSilicon copyright, created 2015-05-26; mirror github.com/OpenIPC/u-boot-hi3516cv200), union `U_V0_DCMP_CSTATE0`, struct offset 0xF28 (GPL-2.0, same-chip vendor header, byte-identical for Hi3516A V200 and Hi3519 V101). Reset value and access type unknown (modelled RW, no reset). Confidence: medium (vendor header for this chip family, not hardware verified).";

        field {
            name = "dcmp_c_state0";
            desc = "[inferred] Decompression c state0. (vendor header `product/hiosd/vo/hi3519/vou_reg.h` field `dcmp_c_state0`; access and reset unknown, modelled RW)";
            sw = rw;
            hw = r;
        } dcmp_c_state0[31:0];
    } V0_DCMP_CSTATE0 @ 0xF28;

    reg {
        name = "V0 decompression CSTATE1";
        desc = "[inferred] V0 decompression CSTATE1. Not in the data sheet. Source: vendor U-Boot 2010.06 `product/hiosd/vo/hi3519/vou_reg.h` (GPL-2.0 U-Boot tree, HiSilicon copyright, created 2015-05-26; mirror github.com/OpenIPC/u-boot-hi3516cv200), union `U_V0_DCMP_CSTATE1`, struct offset 0xF2C (GPL-2.0, same-chip vendor header, byte-identical for Hi3516A V200 and Hi3519 V101). Reset value and access type unknown (modelled RW, no reset). Confidence: medium (vendor header for this chip family, not hardware verified).";

        field {
            name = "dcmp_c_state1";
            desc = "[inferred] Decompression c state1. (vendor header `product/hiosd/vo/hi3519/vou_reg.h` field `dcmp_c_state1`; access and reset unknown, modelled RW)";
            sw = rw;
            hw = r;
        } dcmp_c_state1[31:0];
    } V0_DCMP_CSTATE1 @ 0xF2C;

    reg {
        name = "VO DCMPERRCLR";
        desc = "[inferred] VO DCMPERRCLR. Not in the data sheet. Source: vendor U-Boot 2010.06 `product/hiosd/vo/hi3519/vou_reg.h` (GPL-2.0 U-Boot tree, HiSilicon copyright, created 2015-05-26; mirror github.com/OpenIPC/u-boot-hi3516cv200), union `U_VO_DCMPERRCLR`, struct offset 0xF30 (GPL-2.0, same-chip vendor header, byte-identical for Hi3516A V200 and Hi3519 V101). Reset value and access type unknown (modelled RW, no reset). Confidence: medium (vendor header for this chip family, not hardware verified).";

        field {
            name = "dcmp_c_errclr";
            desc = "[inferred] Decompression c errclr. (vendor header `product/hiosd/vo/hi3519/vou_reg.h` field `dcmp_c_errclr`; access and reset unknown, modelled RW)";
            sw = rw;
            hw = r;
        } dcmp_c_errclr[1:1];

        field {
            name = "dcmp_l_errclr";
            desc = "[inferred] Decompression l errclr. (vendor header `product/hiosd/vo/hi3519/vou_reg.h` field `dcmp_l_errclr`; access and reset unknown, modelled RW)";
            sw = rw;
            hw = r;
        } dcmp_l_errclr[0:0];
    } VO_DCMPERRCLR @ 0xF30;

    reg {
        name = "V0 decompression error";
        desc = "[inferred] V0 decompression error. Not in the data sheet. Source: vendor U-Boot 2010.06 `product/hiosd/vo/hi3519/vou_reg.h` (GPL-2.0 U-Boot tree, HiSilicon copyright, created 2015-05-26; mirror github.com/OpenIPC/u-boot-hi3516cv200), union `U_V0_DCMP_ERR`, struct offset 0xF34 (GPL-2.0, same-chip vendor header, byte-identical for Hi3516A V200 and Hi3519 V101). Reset value and access type unknown (modelled RW, no reset). Confidence: medium (vendor header for this chip family, not hardware verified).";

        field {
            name = "dcmp_c_wrong";
            desc = "[inferred] Decompression c wrong. (vendor header `product/hiosd/vo/hi3519/vou_reg.h` field `dcmp_c_wrong`; access and reset unknown, modelled RW)";
            sw = rw;
            hw = r;
        } dcmp_c_wrong[1:1];

        field {
            name = "dcmp_l_wrong";
            desc = "[inferred] Decompression l wrong. (vendor header `product/hiosd/vo/hi3519/vou_reg.h` field `dcmp_l_wrong`; access and reset unknown, modelled RW)";
            sw = rw;
            hw = r;
        } dcmp_l_wrong[0:0];
    } V0_DCMP_ERR @ 0xF34;

    reg {
        name = "V1 configuration register";
        desc = "V1_CTRL is a V1 configuration register (non-instant register).

Data sheet 9.2.6 V1_CTRL (offset 0x1000, printed page 9-98, `hi3516av200--Hi3516AV200-Datasheet.txt` line 42884).";

        enum V1_CTRL_surface_en_enum {
            DISABLED = 0 { name = "Disabled"; desc = "disabled"; };
            ENABLED = 1 { name = "Enabled"; desc = "enabled"; };
        };

        field {
            name = "surface_en";
            desc = "Surface enable (non-instant)";
            sw = rw;
            hw = r;
            encode = V1_CTRL_surface_en_enum;
            reset = 0x0;
        } surface_en[31:31];

        enum V1_CTRL_die_rd_en_enum {
            DISABLED = 0 { name = "Disabled"; desc = "disabled"; };
            ENABLED = 1 { name = "Enabled"; desc = "enabled"; };
        };

        field {
            name = "die_rd_en";
            desc = "Chrominance channel read repeat enable (valid only when the input is 420 data)";
            sw = rw;
            hw = r;
            encode = V1_CTRL_die_rd_en_enum;
            reset = 0x0;
        } die_rd_en[28:28];

        enum V1_CTRL_crop_en_enum {
            DISABLED = 0 { name = "Disabled"; desc = "disabled"; };
            ENABLED = 1 { name = "Enabled"; desc = "enabled"; };
        };

        field {
            name = "crop_en";
            desc = "Crop enable (non-instant)";
            sw = rw;
            hw = r;
            encode = V1_CTRL_crop_en_enum;
            reset = 0x0;
        } crop_en[23:23];

        enum V1_CTRL_precharge_en_enum {
            DISABLED = 0 { name = "Disabled"; desc = "disabled"; };
            ENABLED = 1 { name = "Enabled"; desc = "enabled"; };
        };

        field {
            name = "precharge_en";
            desc = "Pre-charge enable. This field is valid when the precharge_mode field is 1 (software mode).";
            sw = rw;
            hw = r;
            encode = V1_CTRL_precharge_en_enum;
            reset = 0x0;
        } precharge_en[21:21];

        enum V1_CTRL_precharge_mode_enum {
            HARDWARE_MODE_HARDWARE = 0 { name = "Hardware Mode Hardware"; desc = "hardware mode. Hardware automatically enters the pre-charge status on the frame trailer."; };
            SOFTWARE_MODE_SOFTWARE = 1 { name = "Software Mode Software"; desc = "software mode. Software controls whether to enter or exit the pre-charge status."; };
        };

        field {
            name = "precharge_mode";
            desc = "Pre-charge mode of the FDR FIFO";
            sw = rw;
            hw = r;
            encode = V1_CTRL_precharge_mode_enum;
            reset = 0x0;
        } precharge_mode[20:20];

        enum V1_CTRL_ifir_mode_enum {
            RESERVED = 0 { name = "Reserved"; desc = "reserved"; };
            CHROMINANCE_IFIR_REPLICATION = 1 { name = "Chrominance Ifir Replication"; desc = "chrominance IFIR replication mode"; };
            BILINEAR_INTERPOLATION = 2 { name = "Bilinear Interpolation"; desc = "bilinear interpolation"; };
            V_16_ORDER_HALF = 3 { name = "V 16 Order Half"; desc = "16-order half-band filtering"; };
        };

        field {
            name = "ifir_mode";
            desc = "Horizontal chrominance IFIR mode";
            sw = rw;
            hw = r;
            encode = V1_CTRL_ifir_mode_enum;
            reset = 0x0;
        } ifir_mode[19:18];

        enum V1_CTRL_lm_rmode_enum {
            READ_MODE_BOUND = 0 { name = "Read Mode Bound"; desc = "The read mode is bound to the interface."; };
            FRAME_BUFFER_DATA = 1 { name = "Frame Buffer Data"; desc = "The frame buffer data is read in progressive mode."; };
            TOP_FIELD_READ = 2 { name = "Top Field Read"; desc = "The top field is read in interlaced mode."; };
            BOTTOM_FIELD_READ = 3 { name = "Bottom Field Read"; desc = "The bottom field is read in interlaced mode."; };
        };

        field {
            name = "lm_rmode";
            desc = "Luminance read mode";
            sw = rw;
            hw = r;
            encode = V1_CTRL_lm_rmode_enum;
            reset = 0x0;
        } lm_rmode[15:14];

        enum V1_CTRL_chm_rmode_enum {
            READ_MODE_BOUND = 0 { name = "Read Mode Bound"; desc = "The read mode is bound to the interface."; };
            FRAME_BUFFER_DATA = 1 { name = "Frame Buffer Data"; desc = "The frame buffer data is read in progressive mode."; };
            TOP_FIELD_READ = 2 { name = "Top Field Read"; desc = "The top field is read in interlaced mode."; };
            BOTTOM_FIELD_READ = 3 { name = "Bottom Field Read"; desc = "The bottom field is read in interlaced mode."; };
        };

        field {
            name = "chm_rmode";
            desc = "Chrominance read mode";
            sw = rw;
            hw = r;
            encode = V1_CTRL_chm_rmode_enum;
            reset = 0x0;
        } chm_rmode[13:12];

        enum V1_CTRL_dcmp_en_enum {
            DISABLE = 0 { name = "Disable"; desc = "disable"; };
            ENABLE_F = 1 { name = "Enable F"; desc = "enable"; };
        };

        field {
            name = "dcmp_en";
            desc = "Decompression enable";
            sw = rw;
            hw = r;
            encode = V1_CTRL_dcmp_en_enum;
            reset = 0x0;
        } dcmp_en[8:8];

        enum V1_CTRL_ifmt_enum {
            SPYCBCR400 = 1 { name = "Spycbcr400"; desc = "SPYCbCr400"; };
            SPYCBCR420 = 3 { name = "Spycbcr420"; desc = "SPYCbCr420"; };
            SPYCBCR422_OTHER_VALUES = 4 { name = "Spycbcr422 Other Values"; desc = "SPYCbCr422 Other values: reserved"; };
        };

        field {
            name = "ifmt";
            desc = "Format of the input data";
            sw = rw;
            hw = r;
            encode = V1_CTRL_ifmt_enum;
            reset = 0x0;
        } ifmt[3:0];
    } V1_CTRL @ 0x1000;

    reg {
        name = "V1 channel update enable register";
        desc = "V1_UPD is a V1 channel update enable register.

Data sheet 9.2.6 V1_UPD (offset 0x1004, printed page 9-100, `hi3516av200--Hi3516AV200-Datasheet.txt` line 42978).";

        field {
            name = "regup";
            desc = "Surface register update. After the registers at this layer are configured, the registers are updated when the value 1 is written to this bit. After the registers are updated, this bit is automatically cleared by the hardware.";
            sw = rw;
            hw = w;
            onwrite = woclr;
            reset = 0x0;
        } regup[0:0];
    } V1_UPD @ 0x1004;

    reg {
        name = "V1 input resolution register";
        desc = "V1_IRESO is a V1 input resolution register (non-instant register).

Data sheet 9.2.6 V1_IRESO (offset 0x1028, printed page 9-100, `hi3516av200--Hi3516AV200-Datasheet.txt` line 43003).";

        field {
            name = "ih";
            desc = "Height (in line). The configured value is the actual height minus 1. The frame height is referenced and its unit is line.";
            sw = rw;
            hw = r;
            reset = 0x0;
        } ih[23:12];

        field {
            name = "iw";
            desc = "Width (in pixel). The configured value is the actual width minus 1.";
            sw = rw;
            hw = r;
            reset = 0x0;
        } iw[11:0];
    } V1_IRESO @ 0x1028;

    reg {
        name = "V1 output resolution register";
        desc = "V1_ORESO is a V1 output resolution register (non-instant register). Hi3516A V200 Professional HD IP Camera SoC

Data sheet 9.2.6 V1_ORESO (offset 0x102C, printed page 9-101, `hi3516av200--Hi3516AV200-Datasheet.txt` line 43036).";

        field {
            name = "oh";
            desc = "Height (in line). The configured value is the actual height minus 1. The frame height is referenced and its unit is line.";
            sw = rw;
            hw = r;
            reset = 0x0;
        } oh[23:12];

        field {
            name = "ow";
            desc = "Width (in pixel). The configured value is the actual width minus 1.";
            sw = rw;
            hw = r;
            reset = 0x0;
        } ow[11:0];
    } V1_ORESO @ 0x102C;

    reg {
        name = "Input segment decompression crop register GMT_CROP";
        desc = "V1_DCMP_SGMT_CROP is an input segment decompression crop register (non-instant register).

Data sheet 9.2.6 V1_DCMP_SGMT_CROP (offset 0x1034, printed page 9-101, `hi3516av200--Hi3516AV200-Datasheet.txt` line 43059).";

        field {
            name = "dcmp_xlsgmt";
            desc = "End segment for segment decompression";
            sw = rw;
            hw = r;
            reset = 0x0;
        } dcmp_xlsgmt[7:4];

        field {
            name = "dcmp_xfsgmt";
            desc = "Start segment for segment decompression";
            sw = rw;
            hw = r;
            reset = 0x0;
        } dcmp_xfsgmt[3:0];
    } V1_DCMP_SGMT_CROP @ 0x1034;

    reg {
        name = "V1 overlay parameter register A";
        desc = "V1_CBMPARA is a V1 overlay parameter register (non-instant register). Hi3516A V200 Professional HD IP Camera SoC

Data sheet 9.2.6 V1_CBMPARA (offset 0x1038, printed page 9-102, `hi3516av200--Hi3516AV200-Datasheet.txt` line 43090).";

        field {
            name = "galpha";
            desc = "Overlay global alpha value. The value ranges from 0 to 255. The value 255 indicates opaque, and the value 0 indicates completely transparent.";
            sw = rw;
            hw = r;
            reset = 0x0;
        } galpha[7:0];
    } V1_CBMPARA @ 0x1038;

    reg {
        name = "Horizontal crop coordinate register for the source image";
        desc = "V1_CPOS is a horizontal crop coordinate register for the source image.

Data sheet 9.2.6 V1_CPOS (offset 0x1044, printed page 9-102, `hi3516av200--Hi3516AV200-Datasheet.txt` line 43111).";

        field {
            name = "src_xlpos";
            desc = "End coordinates for horizontally cropping the source image";
            sw = rw;
            hw = r;
            reset = 0x0;
        } src_xlpos[23:12];

        field {
            name = "src_xfpos";
            desc = "Start coordinates for horizontally cropping the source image";
            sw = rw;
            hw = r;
            reset = 0x0;
        } src_xfpos[11:0];
    } V1_CPOS @ 0x1044;

    reg {
        name = "V1 surface start position (in the display window) register";
        desc = "V1_DFPOS is a V1 surface start position (in the display window) register (non-instant register). Hi3516A V200 Professional HD IP Camera SoC

Data sheet 9.2.6 V1_DFPOS (offset 0x1060, printed page 9-103, `hi3516av200--Hi3516AV200-Datasheet.txt` line 43142).";

        field {
            name = "disp_yfpos";
            desc = "Start coordinates of the display column The frame height is referenced and its unit is line.";
            sw = rw;
            hw = r;
            reset = 0x0;
        } disp_yfpos[23:12];

        field {
            name = "disp_xfpos";
            desc = "Start coordinates of the display row";
            sw = rw;
            hw = r;
            reset = 0x0;
        } disp_xfpos[11:0];
    } V1_DFPOS @ 0x1060;

    reg {
        name = "V1 surface end position (in the display window)";
        desc = "V1_DLPOS is a V1 surface end position (in the display window) register (non-instant register).

Data sheet 9.2.6 V1_DLPOS (offset 0x1064, printed page 9-103, `hi3516av200--Hi3516AV200-Datasheet.txt` line 43165).";

        field {
            name = "disp_ylpos";
            desc = "End coordinates of the display column The frame height is referenced and its unit is line.";
            sw = rw;
            hw = r;
            reset = 0x0;
        } disp_ylpos[23:12];

        field {
            name = "disp_xlpos";
            desc = "End coordinates of the display row";
            sw = rw;
            hw = r;
            reset = 0x0;
        } disp_xlpos[11:0];
    } V1_DLPOS @ 0x1064;

    reg {
        name = "V1 CSC input DC component register";
        desc = "V1_CSC_IDC is a V1 CSC input DC component register (instant register). Hi3516A V200 Professional HD IP Camera SoC

Data sheet 9.2.6 V1_CSC_IDC (offset 0x1080, printed page 9-104, `hi3516av200--Hi3516AV200-Datasheet.txt` line 43198).";

        enum V1_CSC_IDC_csc_en_enum {
            DISABLED = 0 { name = "Disabled"; desc = "disabled"; };
            ENABLED = 1 { name = "Enabled"; desc = "enabled"; };
        };

        field {
            name = "csc_en";
            desc = "CSC enable";
            sw = rw;
            hw = r;
            encode = V1_CSC_IDC_csc_en_enum;
            reset = 0x0;
        } csc_en[22:22];

        field {
            name = "cscidc1";
            desc = "DC parameter of the input U/G component. The MSB is the signed bit. The value is expressed as a two's complement.";
            sw = rw;
            hw = r;
            reset = 0x0;
        } cscidc1[21:11];

        field {
            name = "cscidc0";
            desc = "DC parameter of the input V/B component. The MSB is the signed bit. The value is expressed as a two's complement.";
            sw = rw;
            hw = r;
            reset = 0x0;
        } cscidc0[10:0];
    } V1_CSC_IDC @ 0x1080;

    reg {
        name = "V1 CSC output DC component register";
        desc = "V1_CSC_ODC is a V1 CSC output DC component register (instant register).

Data sheet 9.2.6 V1_CSC_ODC (offset 0x1084, printed page 9-104, `hi3516av200--Hi3516AV200-Datasheet.txt` line 43228).";

        enum V1_CSC_ODC_csc_sign_mode_enum {
            CSC_OUTPUT_10 = 0 { name = "Csc Output 10"; desc = "The CSC output is a 10-bit unsigned number."; };
            CSC_OUTPUT_12 = 1 { name = "Csc Output 12"; desc = "The CSC output is a 12-bit signed number."; };
        };

        field {
            name = "csc_sign_mode";
            desc = "CSC output mode";
            sw = rw;
            hw = r;
            encode = V1_CSC_ODC_csc_sign_mode_enum;
            reset = 0x0;
        } csc_sign_mode[22:22];

        field {
            name = "cscodc1";
            desc = "DC parameter of the output U/G component. The MSB is the signed bit. The value is expressed as a two's complement.";
            sw = rw;
            hw = r;
            reset = 0x0;
        } cscodc1[21:11];

        field {
            name = "cscodc0";
            desc = "DC parameter of the output Y/R component. The MSB is the signed bit. The value is expressed as a two's complement.";
            sw = rw;
            hw = r;
            reset = 0x0;
        } cscodc0[10:0];
    } V1_CSC_ODC @ 0x1084;

    reg {
        name = "V1 CSC input/output DC component C register";
        desc = "V1_CSC_IODC is a V1 CSC input/output DC component register (instant register).

Data sheet 9.2.6 V1_CSC_IODC (offset 0x1088, printed page 9-105, `hi3516av200--Hi3516AV200-Datasheet.txt` line 43274).";

        field {
            name = "cscodc2";
            desc = "DC parameter of the output V/B component. The MSB is the signed bit. The value is expressed as a two's complement.";
            sw = rw;
            hw = r;
            reset = 0x0;
        } cscodc2[21:11];

        field {
            name = "cscidc2";
            desc = "DC parameter of the input Y/R component. The MSB is the signed bit. The value is expressed as a two's complement.";
            sw = rw;
            hw = r;
            reset = 0x0;
        } cscidc2[10:0];
    } V1_CSC_IODC @ 0x1088;

    reg {
        name = "V1 CSC parameter 0 register";
        desc = "V1_CSC_P0 is a V1 CSC parameter 0 register (instant register).

Data sheet 9.2.6 V1_CSC_P0 (offset 0x108C, printed page 9-105, `hi3516av200--Hi3516AV200-Datasheet.txt` line 43299).";

        field {
            name = "cscp01";
            desc = "5.10 data format that consists of a 1-bit sign part, a 4-bit integer part, and an 8-bit decimal part. The value is expressed as a two's complement.";
            sw = rw;
            hw = r;
            reset = 0x0;
        } cscp01[30:16];

        field {
            name = "cscp00";
            desc = "5.10 data format that consists of a 1-bit sign part, a 4-bit integer part, and an 8-bit decimal part. The value is expressed as a two's complement.";
            sw = rw;
            hw = r;
            reset = 0x0;
        } cscp00[14:0];
    } V1_CSC_P0 @ 0x108C;

    reg {
        name = "V1 CSC parameter 1 register";
        desc = "V1_CSC_P1 is a V1 CSC parameter 1 register (instant register).

Data sheet 9.2.6 V1_CSC_P1 (offset 0x1090, printed page 9-106, `hi3516av200--Hi3516AV200-Datasheet.txt` line 43340).";

        field {
            name = "cscp10";
            desc = "5.10 data format that consists of a 1-bit sign part, a 4-bit integer part, and an 8-bit decimal part. The value is expressed as a two's complement.";
            sw = rw;
            hw = r;
            reset = 0x0;
        } cscp10[30:16];

        field {
            name = "cscp02";
            desc = "5.10 data format that consists of a 1-bit sign part, a 4-bit integer part, and an 8-bit decimal part. The value is expressed as a two's complement.";
            sw = rw;
            hw = r;
            reset = 0x0;
        } cscp02[14:0];
    } V1_CSC_P1 @ 0x1090;

    reg {
        name = "V1 CSC parameter 2 register";
        desc = "V1_CSC_P2 is a V1 CSC parameter 2 register (instant register).

Data sheet 9.2.6 V1_CSC_P2 (offset 0x1094, printed page 9-106, `hi3516av200--Hi3516AV200-Datasheet.txt` line 43369).";

        field {
            name = "cscp12";
            desc = "5.10 data format that consists of a 1-bit sign part, a 4-bit integer part, and an 8-bit decimal part. The value is expressed as a two's complement.";
            sw = rw;
            hw = r;
            reset = 0x0;
        } cscp12[30:16];

        field {
            name = "cscp11";
            desc = "5.10 data format that consists of a 1-bit sign part, a 4-bit integer part, and an 8-bit decimal part. The value is expressed as a two's complement.";
            sw = rw;
            hw = r;
            reset = 0x0;
        } cscp11[14:0];
    } V1_CSC_P2 @ 0x1094;

    reg {
        name = "V1 CSC parameter 3 register";
        desc = "V1_CSC_P3 is a V1 CSC parameter 3 register (instant register).

Data sheet 9.2.6 V1_CSC_P3 (offset 0x1098, printed page 9-107, `hi3516av200--Hi3516AV200-Datasheet.txt` line 43408).";

        field {
            name = "cscp21";
            desc = "5.10 data format that consists of a 1-bit sign part, a 4-bit integer part, and an 8-bit decimal part. The value is expressed as a two's complement.";
            sw = rw;
            hw = r;
            reset = 0x0;
        } cscp21[30:16];

        field {
            name = "cscp20";
            desc = "5.10 data format that consists of a 1-bit sign part, a 4-bit integer part, and an 8-bit decimal part. The value is expressed as a two's complement.";
            sw = rw;
            hw = r;
            reset = 0x0;
        } cscp20[14:0];
    } V1_CSC_P3 @ 0x1098;

    reg {
        name = "V1 CSC parameter 4 register";
        desc = "V1_CSC_P4 is a V1 CSC parameter 4 register (instant register). Hi3516A V200 Professional HD IP Camera SoC

Data sheet 9.2.6 V1_CSC_P4 (offset 0x109C, printed page 9-108, `hi3516av200--Hi3516AV200-Datasheet.txt` line 43447).";

        field {
            name = "cscp22";
            desc = "5.10 data format that consists of a 1-bit sign part, a 4-bit integer part, and an 8-bit decimal part. The value is expressed as a two's complement.";
            sw = rw;
            hw = r;
            reset = 0x0;
        } cscp22[14:0];
    } V1_CSC_P4 @ 0x109C;

    reg {
        name = "V1 luminance address register";
        desc = "V1_P0LADDR is a V1 luminance address register.

Data sheet 9.2.6 V1_P0LADDR (offset 0x1204, printed page 9-108, `hi3516av200--Hi3516AV200-Datasheet.txt` line 43468).";

        field {
            name = "surface_addr";
            desc = "Luminance start address for the video layer";
            sw = rw;
            hw = r;
            reset = 0x0;
        } surface_addr[31:0];
    } V1_P0LADDR @ 0x1204;

    reg {
        name = "V1 chrominance address register";
        desc = "V1_P0CADDR is a V1 chrominance address register.

Data sheet 9.2.6 V1_P0CADDR (offset 0x1208, printed page 9-108, `hi3516av200--Hi3516AV200-Datasheet.txt` line 43486).";

        field {
            name = "surface_addr";
            desc = "Chrominance start address for the video layer";
            sw = rw;
            hw = r;
            reset = 0x0;
        } surface_addr[31:0];
    } V1_P0CADDR @ 0x1208;

    reg {
        name = "V1 stride register";
        desc = "V1_P0STRIDE is a V1 stride register.

Data sheet 9.2.6 V1_P0STRIDE (offset 0x120C, printed page 9-109, `hi3516av200--Hi3516AV200-Datasheet.txt` line 43511).";

        field {
            name = "surface_cstride";
            desc = "Stride of the chrominance buffer of the video layer (valid in semi- planar format), 128-bit alignment";
            sw = rw;
            hw = r;
            reset = 0x0;
        } surface_cstride[31:16];

        field {
            name = "surface_stride";
            desc = "Stride of the video layer buffer (luminance stride in semi-planar format), 128-bit alignment";
            sw = rw;
            hw = r;
            reset = 0x0;
        } surface_stride[15:0];
    } V1_P0STRIDE @ 0x120C;

    reg {
        name = "Offset (luminance compressed data address FFSET relative to the header information address) register, valid only when the decompression function is enabled";
        desc = "V1_LADDROFFSET is an offset (luminance compressed data address relative to the header information address) register (non-instant register). This register is valid only when the decompression function is enabled.

Data sheet 9.2.6 V1_LADDROFFSET (offset 0x1640, printed page 9-109, `hi3516av200--Hi3516AV200-Datasheet.txt` line 43537).";

        field {
            name = "laddr_offset";
            desc = "laddr_offset";
            sw = rw;
            hw = r;
            reset = 0x0;
        } laddr_offset[31:0];
    } V1_LADDROFFSET @ 0x1640;

    reg {
        name = "Offset (chrominance compressed data FFSET address relative to the header information address) register, valid only when the decompression function is enabled";
        desc = "Offset (chrominance compressed data FFSET address relative to the header information address) register, valid only when the decompression function is enabled.

Data sheet 9.2.6 V1_CADDROFFSET (offset 0x1644, printed page 9-110, `hi3516av200--Hi3516AV200-Datasheet.txt` line 43570).";

        field {
            name = "caddr_offset";
            desc = "caddr_offset";
            sw = rw;
            hw = r;
            reset = 0x0;
        } caddr_offset[31:0];
    } V1_CADDROFFSET @ 0x1644;

    reg {
        name = "Decompression status register 0 for the V1 TATE0 luminance channel";
        desc = "V1_DCMP_LSTATE0 is decompression status register 0 for the V1 luminance channel.

Data sheet 9.2.6 V1_DCMP_LSTATE0 (offset 0x1720, printed page 9-110, `hi3516av200--Hi3516AV200-Datasheet.txt` line 43590).";

        field {
            name = "dcmp_l_state0";
            desc = "Decompression status register 0 for the V1 luminance channel";
            sw = r;
            hw = w;
            reset = 0x0;
        } dcmp_l_state0[31:0];
    } V1_DCMP_LSTATE0 @ 0x1720;

    reg {
        name = "Decompression status register 1 for the V1 TATE1 luminance channel";
        desc = "V1_DCMP_LSTATE1 is decompression status register 1 for the V1 luminance channel.

Data sheet 9.2.6 V1_DCMP_LSTATE1 (offset 0x1724, printed page 9-110, `hi3516av200--Hi3516AV200-Datasheet.txt` line 43608).";

        field {
            name = "dcmp_l_state1";
            desc = "Decompression status register 1 for the V1 luminance channel";
            sw = r;
            hw = w;
            reset = 0x0;
        } dcmp_l_state1[31:0];
    } V1_DCMP_LSTATE1 @ 0x1724;

    reg {
        name = "Decompression status register 0 for the V1 TATE0 chrominance channel";
        desc = "V1_DCMP_CSTATE0 is decompression status register 0 for the V1 chrominance channel. Hi3516A V200 Professional HD IP Camera SoC

Data sheet 9.2.6 V1_DCMP_CSTATE0 (offset 0x1728, printed page 9-111, `hi3516av200--Hi3516AV200-Datasheet.txt` line 43636).";

        field {
            name = "dcmp_c_state0";
            desc = "Decompression status register 0 for the V1 chrominance channel";
            sw = r;
            hw = w;
            reset = 0x0;
        } dcmp_c_state0[31:0];
    } V1_DCMP_CSTATE0 @ 0x1728;

    reg {
        name = "Decompression status register 1 for the V1 TATE1 chrominance channel";
        desc = "V1_DCMP_CSTATE1 is decompression status register 1 for the V1 chrominance channel.

Data sheet 9.2.6 V1_DCMP_CSTATE1 (offset 0x172C, printed page 9-111, `hi3516av200--Hi3516AV200-Datasheet.txt` line 43654).";

        field {
            name = "dcmp_c_state1";
            desc = "Decompression status register 1 for the V1 chrominance channel";
            sw = r;
            hw = w;
            reset = 0x0;
        } dcmp_c_state1[31:0];
    } V1_DCMP_CSTATE1 @ 0x172C;

    reg {
        name = "V1 decompression error status clear RCLR register";
        desc = "V1_DCMPERRCLR is a V1 decompression error status clear register. Writing 1 clears this register.

Data sheet 9.2.6 V1_DCMPERRCLR (offset 0x1730, printed page 9-111, `hi3516av200--Hi3516AV200-Datasheet.txt` line 43674).";

        enum V1_DCMPERRCLR_dcmp_c_errclr_enum {
            NOT_CLEARED = 0 { name = "Not Cleared"; desc = "not cleared"; };
            CLEARED = 1 { name = "Cleared"; desc = "cleared"; };
        };

        field {
            name = "dcmp_c_errclr";
            desc = "Decompression error status clear for the chrominance channel";
            sw = rw;
            hw = w;
            onwrite = woclr;
            encode = V1_DCMPERRCLR_dcmp_c_errclr_enum;
            reset = 0x0;
        } dcmp_c_errclr[1:1];

        enum V1_DCMPERRCLR_dcmp_l_errclr_enum {
            NOT_CLEARED = 0 { name = "Not Cleared"; desc = "not cleared"; };
            CLEARED = 1 { name = "Cleared"; desc = "cleared"; };
        };

        field {
            name = "dcmp_l_errclr";
            desc = "Decompression error status clear for the luminance channel";
            sw = rw;
            hw = w;
            onwrite = woclr;
            encode = V1_DCMPERRCLR_dcmp_l_errclr_enum;
            reset = 0x0;
        } dcmp_l_errclr[0:0];
    } V1_DCMPERRCLR @ 0x1730;

    reg {
        name = "V1 decompression error signal register RR";
        desc = "V1_DCMP_ERR is a V1 decompression error signal register.

Data sheet 9.2.6 V1_DCMP_ERR (offset 0x1734, printed page 9-112, `hi3516av200--Hi3516AV200-Datasheet.txt` line 43716).";

        enum V1_DCMP_ERR_dcmp_c_wrong_enum {
            NO_DECOMPRESSION_ERROR = 0 { name = "No Decompression Error"; desc = "No decompression error occurs."; };
            DECOMPRESSION_ERROR_OCCURS = 1 { name = "Decompression Error Occurs"; desc = "A decompression error occurs."; };
        };

        field {
            name = "dcmp_c_wrong";
            desc = "Decompression error signal for the chrominance channel";
            sw = r;
            hw = w;
            encode = V1_DCMP_ERR_dcmp_c_wrong_enum;
            reset = 0x0;
        } dcmp_c_wrong[1:1];

        enum V1_DCMP_ERR_dcmp_l_wrong_enum {
            NO_DECOMPRESSION_ERROR = 0 { name = "No Decompression Error"; desc = "No decompression error occurs."; };
            DECOMPRESSION_ERROR_OCCURS = 1 { name = "Decompression Error Occurs"; desc = "A decompression error occurs."; };
        };

        field {
            name = "dcmp_l_wrong";
            desc = "Decompression error signal for the luminance channel";
            sw = r;
            hw = w;
            encode = V1_DCMP_ERR_dcmp_l_wrong_enum;
            reset = 0x0;
        } dcmp_l_wrong[0:0];
    } V1_DCMP_ERR @ 0x1734;

    reg {
        name = "VP0 control";
        desc = "[inferred] VP0 control. Not in the data sheet. Source: vendor U-Boot 2010.06 `product/hiosd/vo/hi3519/vou_reg.h` (GPL-2.0 U-Boot tree, HiSilicon copyright, created 2015-05-26; mirror github.com/OpenIPC/u-boot-hi3516cv200), union `U_VP0_CTRL`, struct offset 0x4000 (GPL-2.0, same-chip vendor header, byte-identical for Hi3516A V200 and Hi3519 V101). Reset value and access type unknown (modelled RW, no reset). Confidence: medium (vendor header for this chip family, not hardware verified).";

        field {
            name = "mute_en";
            desc = "[inferred] Mute enable. (vendor header `product/hiosd/vo/hi3519/vou_reg.h` field `mute_en`; access and reset unknown, modelled RW)";
            sw = rw;
            hw = r;
        } mute_en[8:8];

        field {
            name = "vp_galpha";
            desc = "[inferred] Vp galpha. (vendor header `product/hiosd/vo/hi3519/vou_reg.h` field `vp_galpha`; access and reset unknown, modelled RW)";
            sw = rw;
            hw = r;
        } vp_galpha[7:0];
    } VP0_CTRL @ 0x4000;

    reg {
        name = "VP0 update";
        desc = "[inferred] VP0 update. Not in the data sheet. Source: vendor U-Boot 2010.06 `product/hiosd/vo/hi3519/vou_reg.h` (GPL-2.0 U-Boot tree, HiSilicon copyright, created 2015-05-26; mirror github.com/OpenIPC/u-boot-hi3516cv200), union `U_VP0_UPD`, struct offset 0x4004 (GPL-2.0, same-chip vendor header, byte-identical for Hi3516A V200 and Hi3519 V101). Reset value and access type unknown (modelled RW, no reset). Confidence: medium (vendor header for this chip family, not hardware verified).";

        field {
            name = "regup";
            desc = "[inferred] Regup. (vendor header `product/hiosd/vo/hi3519/vou_reg.h` field `regup`; access and reset unknown, modelled RW)";
            sw = rw;
            hw = r;
        } regup[0:0];
    } VP0_UPD @ 0x4004;

    reg {
        name = "VP0 ACC CAD";
        desc = "[inferred] VP0 ACC CAD. Not in the data sheet. Source: vendor U-Boot 2010.06 `product/hiosd/vo/hi3519/vou_reg.h` (GPL-2.0 U-Boot tree, HiSilicon copyright, created 2015-05-26; mirror github.com/OpenIPC/u-boot-hi3516cv200), union `U_VP0_ACC_CAD`, struct offset 0x4010 (GPL-2.0, same-chip vendor header, byte-identical for Hi3516A V200 and Hi3519 V101). Reset value and access type unknown (modelled RW, no reset). Confidence: medium (vendor header for this chip family, not hardware verified).";

        field {
            name = "coef_addr";
            desc = "[inferred] Coefficient address. (vendor header `product/hiosd/vo/hi3519/vou_reg.h` field `coef_addr`; access and reset unknown, modelled RW)";
            sw = rw;
            hw = r;
        } coef_addr[31:0];
    } VP0_ACC_CAD @ 0x4010;

    reg {
        name = "VP0 ACM CAD";
        desc = "[inferred] VP0 ACM CAD. Not in the data sheet. Source: vendor U-Boot 2010.06 `product/hiosd/vo/hi3519/vou_reg.h` (GPL-2.0 U-Boot tree, HiSilicon copyright, created 2015-05-26; mirror github.com/OpenIPC/u-boot-hi3516cv200), union `U_VP0_ACM_CAD`, struct offset 0x4014 (GPL-2.0, same-chip vendor header, byte-identical for Hi3516A V200 and Hi3519 V101). Reset value and access type unknown (modelled RW, no reset). Confidence: medium (vendor header for this chip family, not hardware verified).";

        field {
            name = "coef_addr";
            desc = "[inferred] Coefficient address. (vendor header `product/hiosd/vo/hi3519/vou_reg.h` field `coef_addr`; access and reset unknown, modelled RW)";
            sw = rw;
            hw = r;
        } coef_addr[31:0];
    } VP0_ACM_CAD @ 0x4014;

    reg {
        name = "VP0 PARAUP";
        desc = "[inferred] VP0 PARAUP. Not in the data sheet. Source: vendor U-Boot 2010.06 `product/hiosd/vo/hi3519/vou_reg.h` (GPL-2.0 U-Boot tree, HiSilicon copyright, created 2015-05-26; mirror github.com/OpenIPC/u-boot-hi3516cv200), union `U_VP0_PARAUP`, struct offset 0x4018 (GPL-2.0, same-chip vendor header, byte-identical for Hi3516A V200 and Hi3519 V101). Reset value and access type unknown (modelled RW, no reset). Confidence: medium (vendor header for this chip family, not hardware verified).";

        field {
            name = "v0_acccoef_upd";
            desc = "[inferred] V0 acccoef update. (vendor header `product/hiosd/vo/hi3519/vou_reg.h` field `v0_acccoef_upd`; access and reset unknown, modelled RW)";
            sw = rw;
            hw = r;
        } v0_acccoef_upd[1:1];

        field {
            name = "v0_acmcoef_upd";
            desc = "[inferred] V0 acmcoef update. (vendor header `product/hiosd/vo/hi3519/vou_reg.h` field `v0_acmcoef_upd`; access and reset unknown, modelled RW)";
            sw = rw;
            hw = r;
        } v0_acmcoef_upd[0:0];
    } VP0_PARAUP @ 0x4018;

    reg {
        name = "VP0 IRESO";
        desc = "[inferred] VP0 IRESO. Not in the data sheet. Source: vendor U-Boot 2010.06 `product/hiosd/vo/hi3519/vou_reg.h` (GPL-2.0 U-Boot tree, HiSilicon copyright, created 2015-05-26; mirror github.com/OpenIPC/u-boot-hi3516cv200), union `U_VP0_IRESO`, struct offset 0x4020 (GPL-2.0, same-chip vendor header, byte-identical for Hi3516A V200 and Hi3519 V101). Reset value and access type unknown (modelled RW, no reset). Confidence: medium (vendor header for this chip family, not hardware verified).";

        field {
            name = "ih";
            desc = "[inferred] Ih. (vendor header `product/hiosd/vo/hi3519/vou_reg.h` field `ih`; access and reset unknown, modelled RW)";
            sw = rw;
            hw = r;
        } ih[23:12];

        field {
            name = "iw";
            desc = "[inferred] Iw. (vendor header `product/hiosd/vo/hi3519/vou_reg.h` field `iw`; access and reset unknown, modelled RW)";
            sw = rw;
            hw = r;
        } iw[11:0];
    } VP0_IRESO @ 0x4020;

    reg {
        name = "VP0 DOF control";
        desc = "[inferred] VP0 DOF control. Not in the data sheet. Source: vendor U-Boot 2010.06 `product/hiosd/vo/hi3519/vou_reg.h` (GPL-2.0 U-Boot tree, HiSilicon copyright, created 2015-05-26; mirror github.com/OpenIPC/u-boot-hi3516cv200), union `U_VP0_DOF_CTRL`, struct offset 0x40A0 (GPL-2.0, same-chip vendor header, byte-identical for Hi3516A V200 and Hi3519 V101). Reset value and access type unknown (modelled RW, no reset). Confidence: medium (vendor header for this chip family, not hardware verified).";

        field {
            name = "dof_en";
            desc = "[inferred] Dof enable. (vendor header `product/hiosd/vo/hi3519/vou_reg.h` field `dof_en`; access and reset unknown, modelled RW)";
            sw = rw;
            hw = r;
        } dof_en[31:31];
    } VP0_DOF_CTRL @ 0x40A0;

    reg {
        name = "VP0 DOF STEP";
        desc = "[inferred] VP0 DOF STEP. Not in the data sheet. Source: vendor U-Boot 2010.06 `product/hiosd/vo/hi3519/vou_reg.h` (GPL-2.0 U-Boot tree, HiSilicon copyright, created 2015-05-26; mirror github.com/OpenIPC/u-boot-hi3516cv200), union `U_VP0_DOF_STEP`, struct offset 0x40A4 (GPL-2.0, same-chip vendor header, byte-identical for Hi3516A V200 and Hi3519 V101). Reset value and access type unknown (modelled RW, no reset). Confidence: medium (vendor header for this chip family, not hardware verified).";

        field {
            name = "right_step";
            desc = "[inferred] Right step. (vendor header `product/hiosd/vo/hi3519/vou_reg.h` field `right_step`; access and reset unknown, modelled RW)";
            sw = rw;
            hw = r;
        } right_step[15:8];

        field {
            name = "left_step";
            desc = "[inferred] Left step. (vendor header `product/hiosd/vo/hi3519/vou_reg.h` field `left_step`; access and reset unknown, modelled RW)";
            sw = rw;
            hw = r;
        } left_step[7:0];
    } VP0_DOF_STEP @ 0x40A4;

    reg {
        name = "VP0 ACCTHD1";
        desc = "[inferred] VP0 ACCTHD1. Not in the data sheet. Source: vendor U-Boot 2010.06 `product/hiosd/vo/hi3519/vou_reg.h` (GPL-2.0 U-Boot tree, HiSilicon copyright, created 2015-05-26; mirror github.com/OpenIPC/u-boot-hi3516cv200), union `U_VP0_ACCTHD1`, struct offset 0x4100 (GPL-2.0, same-chip vendor header, byte-identical for Hi3516A V200 and Hi3519 V101). Reset value and access type unknown (modelled RW, no reset). Confidence: medium (vendor header for this chip family, not hardware verified).";

        field {
            name = "acc_en";
            desc = "[inferred] ACC enable. (vendor header `product/hiosd/vo/hi3519/vou_reg.h` field `acc_en`; access and reset unknown, modelled RW)";
            sw = rw;
            hw = r;
        } acc_en[31:31];

        field {
            name = "acc_mode";
            desc = "[inferred] ACC mode. (vendor header `product/hiosd/vo/hi3519/vou_reg.h` field `acc_mode`; access and reset unknown, modelled RW)";
            sw = rw;
            hw = r;
        } acc_mode[30:30];

        field {
            name = "thd_med_low";
            desc = "[inferred] Threshold med low. (vendor header `product/hiosd/vo/hi3519/vou_reg.h` field `thd_med_low`; access and reset unknown, modelled RW)";
            sw = rw;
            hw = r;
        } thd_med_low[29:20];

        field {
            name = "thd_high";
            desc = "[inferred] Threshold high. (vendor header `product/hiosd/vo/hi3519/vou_reg.h` field `thd_high`; access and reset unknown, modelled RW)";
            sw = rw;
            hw = r;
        } thd_high[19:10];

        field {
            name = "thd_low";
            desc = "[inferred] Threshold low. (vendor header `product/hiosd/vo/hi3519/vou_reg.h` field `thd_low`; access and reset unknown, modelled RW)";
            sw = rw;
            hw = r;
        } thd_low[9:0];
    } VP0_ACCTHD1 @ 0x4100;

    reg {
        name = "VP0 ACCTHD2";
        desc = "[inferred] VP0 ACCTHD2. Not in the data sheet. Source: vendor U-Boot 2010.06 `product/hiosd/vo/hi3519/vou_reg.h` (GPL-2.0 U-Boot tree, HiSilicon copyright, created 2015-05-26; mirror github.com/OpenIPC/u-boot-hi3516cv200), union `U_VP0_ACCTHD2`, struct offset 0x4104 (GPL-2.0, same-chip vendor header, byte-identical for Hi3516A V200 and Hi3519 V101). Reset value and access type unknown (modelled RW, no reset). Confidence: medium (vendor header for this chip family, not hardware verified).";

        field {
            name = "acc_rst";
            desc = "[inferred] ACC rst. (vendor header `product/hiosd/vo/hi3519/vou_reg.h` field `acc_rst`; access and reset unknown, modelled RW)";
            sw = rw;
            hw = r;
        } acc_rst[18:18];

        field {
            name = "acc_multiple";
            desc = "[inferred] ACC multiple. (vendor header `product/hiosd/vo/hi3519/vou_reg.h` field `acc_multiple`; access and reset unknown, modelled RW)";
            sw = rw;
            hw = r;
        } acc_multiple[17:10];

        field {
            name = "thd_med_high";
            desc = "[inferred] Threshold med high. (vendor header `product/hiosd/vo/hi3519/vou_reg.h` field `thd_med_high`; access and reset unknown, modelled RW)";
            sw = rw;
            hw = r;
        } thd_med_high[9:0];
    } VP0_ACCTHD2 @ 0x4104;

    reg {
        name = "VP0 ACCLOWN";
        desc = "[inferred] VP0 ACCLOWN. Array of 3 consecutive 32-bit words (header `VP0_ACCLOWN[3]`). Not in the data sheet. Source: vendor U-Boot 2010.06 `product/hiosd/vo/hi3519/vou_reg.h` (GPL-2.0 U-Boot tree, HiSilicon copyright, created 2015-05-26; mirror github.com/OpenIPC/u-boot-hi3516cv200), union `U_VP0_ACCLOWN`, struct offset 0x4110 (GPL-2.0, same-chip vendor header, byte-identical for Hi3516A V200 and Hi3519 V101). Reset value and access type unknown (modelled RW, no reset). Confidence: medium (vendor header for this chip family, not hardware verified).";

        field {
            name = "table_data3n";
            desc = "[inferred] Table data3n. (vendor header `product/hiosd/vo/hi3519/vou_reg.h` field `table_data3n`; access and reset unknown, modelled RW)";
            sw = rw;
            hw = r;
        } table_data3n[29:20];

        field {
            name = "table_data2n";
            desc = "[inferred] Table data2n. (vendor header `product/hiosd/vo/hi3519/vou_reg.h` field `table_data2n`; access and reset unknown, modelled RW)";
            sw = rw;
            hw = r;
        } table_data2n[19:10];

        field {
            name = "table_data1n";
            desc = "[inferred] Table data1n. (vendor header `product/hiosd/vo/hi3519/vou_reg.h` field `table_data1n`; access and reset unknown, modelled RW)";
            sw = rw;
            hw = r;
        } table_data1n[9:0];
    } VP0_ACCLOWN[3] @ 0x4110 += 0x4;

    reg {
        name = "VP0 ACCMEDN";
        desc = "[inferred] VP0 ACCMEDN. Array of 3 consecutive 32-bit words (header `VP0_ACCMEDN[3]`). Not in the data sheet. Source: vendor U-Boot 2010.06 `product/hiosd/vo/hi3519/vou_reg.h` (GPL-2.0 U-Boot tree, HiSilicon copyright, created 2015-05-26; mirror github.com/OpenIPC/u-boot-hi3516cv200), union `U_VP0_ACCMEDN`, struct offset 0x4120 (GPL-2.0, same-chip vendor header, byte-identical for Hi3516A V200 and Hi3519 V101). Reset value and access type unknown (modelled RW, no reset). Confidence: medium (vendor header for this chip family, not hardware verified).";

        field {
            name = "table_data3n";
            desc = "[inferred] Table data3n. (vendor header `product/hiosd/vo/hi3519/vou_reg.h` field `table_data3n`; access and reset unknown, modelled RW)";
            sw = rw;
            hw = r;
        } table_data3n[29:20];

        field {
            name = "table_data2n";
            desc = "[inferred] Table data2n. (vendor header `product/hiosd/vo/hi3519/vou_reg.h` field `table_data2n`; access and reset unknown, modelled RW)";
            sw = rw;
            hw = r;
        } table_data2n[19:10];

        field {
            name = "table_data1n";
            desc = "[inferred] Table data1n. (vendor header `product/hiosd/vo/hi3519/vou_reg.h` field `table_data1n`; access and reset unknown, modelled RW)";
            sw = rw;
            hw = r;
        } table_data1n[9:0];
    } VP0_ACCMEDN[3] @ 0x4120 += 0x4;

    reg {
        name = "VP0 ACCHIGHN";
        desc = "[inferred] VP0 ACCHIGHN. Array of 3 consecutive 32-bit words (header `VP0_ACCHIGHN[3]`). Not in the data sheet. Source: vendor U-Boot 2010.06 `product/hiosd/vo/hi3519/vou_reg.h` (GPL-2.0 U-Boot tree, HiSilicon copyright, created 2015-05-26; mirror github.com/OpenIPC/u-boot-hi3516cv200), union `U_VP0_ACCHIGHN`, struct offset 0x4130 (GPL-2.0, same-chip vendor header, byte-identical for Hi3516A V200 and Hi3519 V101). Reset value and access type unknown (modelled RW, no reset). Confidence: medium (vendor header for this chip family, not hardware verified).";

        field {
            name = "table_data3n";
            desc = "[inferred] Table data3n. (vendor header `product/hiosd/vo/hi3519/vou_reg.h` field `table_data3n`; access and reset unknown, modelled RW)";
            sw = rw;
            hw = r;
        } table_data3n[29:20];

        field {
            name = "table_data2n";
            desc = "[inferred] Table data2n. (vendor header `product/hiosd/vo/hi3519/vou_reg.h` field `table_data2n`; access and reset unknown, modelled RW)";
            sw = rw;
            hw = r;
        } table_data2n[19:10];

        field {
            name = "table_data1n";
            desc = "[inferred] Table data1n. (vendor header `product/hiosd/vo/hi3519/vou_reg.h` field `table_data1n`; access and reset unknown, modelled RW)";
            sw = rw;
            hw = r;
        } table_data1n[9:0];
    } VP0_ACCHIGHN[3] @ 0x4130 += 0x4;

    reg {
        name = "VP0 ACCMLN";
        desc = "[inferred] VP0 ACCMLN. Array of 3 consecutive 32-bit words (header `VP0_ACCMLN[3]`). Not in the data sheet. Source: vendor U-Boot 2010.06 `product/hiosd/vo/hi3519/vou_reg.h` (GPL-2.0 U-Boot tree, HiSilicon copyright, created 2015-05-26; mirror github.com/OpenIPC/u-boot-hi3516cv200), union `U_VP0_ACCMLN`, struct offset 0x4140 (GPL-2.0, same-chip vendor header, byte-identical for Hi3516A V200 and Hi3519 V101). Reset value and access type unknown (modelled RW, no reset). Confidence: medium (vendor header for this chip family, not hardware verified).";

        field {
            name = "table_data3n";
            desc = "[inferred] Table data3n. (vendor header `product/hiosd/vo/hi3519/vou_reg.h` field `table_data3n`; access and reset unknown, modelled RW)";
            sw = rw;
            hw = r;
        } table_data3n[29:20];

        field {
            name = "table_data2n";
            desc = "[inferred] Table data2n. (vendor header `product/hiosd/vo/hi3519/vou_reg.h` field `table_data2n`; access and reset unknown, modelled RW)";
            sw = rw;
            hw = r;
        } table_data2n[19:10];

        field {
            name = "table_data1n";
            desc = "[inferred] Table data1n. (vendor header `product/hiosd/vo/hi3519/vou_reg.h` field `table_data1n`; access and reset unknown, modelled RW)";
            sw = rw;
            hw = r;
        } table_data1n[9:0];
    } VP0_ACCMLN[3] @ 0x4140 += 0x4;

    reg {
        name = "VP0 ACCMHN";
        desc = "[inferred] VP0 ACCMHN. Array of 3 consecutive 32-bit words (header `VP0_ACCMHN[3]`). Not in the data sheet. Source: vendor U-Boot 2010.06 `product/hiosd/vo/hi3519/vou_reg.h` (GPL-2.0 U-Boot tree, HiSilicon copyright, created 2015-05-26; mirror github.com/OpenIPC/u-boot-hi3516cv200), union `U_VP0_ACCMHN`, struct offset 0x4150 (GPL-2.0, same-chip vendor header, byte-identical for Hi3516A V200 and Hi3519 V101). Reset value and access type unknown (modelled RW, no reset). Confidence: medium (vendor header for this chip family, not hardware verified).";

        field {
            name = "table_data3n";
            desc = "[inferred] Table data3n. (vendor header `product/hiosd/vo/hi3519/vou_reg.h` field `table_data3n`; access and reset unknown, modelled RW)";
            sw = rw;
            hw = r;
        } table_data3n[29:20];

        field {
            name = "table_data2n";
            desc = "[inferred] Table data2n. (vendor header `product/hiosd/vo/hi3519/vou_reg.h` field `table_data2n`; access and reset unknown, modelled RW)";
            sw = rw;
            hw = r;
        } table_data2n[19:10];

        field {
            name = "table_data1n";
            desc = "[inferred] Table data1n. (vendor header `product/hiosd/vo/hi3519/vou_reg.h` field `table_data1n`; access and reset unknown, modelled RW)";
            sw = rw;
            hw = r;
        } table_data1n[9:0];
    } VP0_ACCMHN[3] @ 0x4150 += 0x4;

    reg {
        name = "VP0 ACC3LOW";
        desc = "[inferred] VP0 ACC3LOW. Not in the data sheet. Source: vendor U-Boot 2010.06 `product/hiosd/vo/hi3519/vou_reg.h` (GPL-2.0 U-Boot tree, HiSilicon copyright, created 2015-05-26; mirror github.com/OpenIPC/u-boot-hi3516cv200), union `U_VP0_ACC3LOW`, struct offset 0x4160 (GPL-2.0, same-chip vendor header, byte-identical for Hi3516A V200 and Hi3519 V101). Reset value and access type unknown (modelled RW, no reset). Confidence: medium (vendor header for this chip family, not hardware verified).";

        field {
            name = "cnt3_low";
            desc = "[inferred] Cnt3 low. (vendor header `product/hiosd/vo/hi3519/vou_reg.h` field `cnt3_low`; access and reset unknown, modelled RW)";
            sw = rw;
            hw = r;
        } cnt3_low[20:0];
    } VP0_ACC3LOW @ 0x4160;

    reg {
        name = "VP0 ACC3MED";
        desc = "[inferred] VP0 ACC3MED. Not in the data sheet. Source: vendor U-Boot 2010.06 `product/hiosd/vo/hi3519/vou_reg.h` (GPL-2.0 U-Boot tree, HiSilicon copyright, created 2015-05-26; mirror github.com/OpenIPC/u-boot-hi3516cv200), union `U_VP0_ACC3MED`, struct offset 0x4164 (GPL-2.0, same-chip vendor header, byte-identical for Hi3516A V200 and Hi3519 V101). Reset value and access type unknown (modelled RW, no reset). Confidence: medium (vendor header for this chip family, not hardware verified).";

        field {
            name = "cnt3_med";
            desc = "[inferred] Cnt3 med. (vendor header `product/hiosd/vo/hi3519/vou_reg.h` field `cnt3_med`; access and reset unknown, modelled RW)";
            sw = rw;
            hw = r;
        } cnt3_med[20:0];
    } VP0_ACC3MED @ 0x4164;

    reg {
        name = "VP0 ACC3HIGH";
        desc = "[inferred] VP0 ACC3HIGH. Not in the data sheet. Source: vendor U-Boot 2010.06 `product/hiosd/vo/hi3519/vou_reg.h` (GPL-2.0 U-Boot tree, HiSilicon copyright, created 2015-05-26; mirror github.com/OpenIPC/u-boot-hi3516cv200), union `U_VP0_ACC3HIGH`, struct offset 0x4168 (GPL-2.0, same-chip vendor header, byte-identical for Hi3516A V200 and Hi3519 V101). Reset value and access type unknown (modelled RW, no reset). Confidence: medium (vendor header for this chip family, not hardware verified).";

        field {
            name = "cnt3_high";
            desc = "[inferred] Cnt3 high. (vendor header `product/hiosd/vo/hi3519/vou_reg.h` field `cnt3_high`; access and reset unknown, modelled RW)";
            sw = rw;
            hw = r;
        } cnt3_high[20:0];
    } VP0_ACC3HIGH @ 0x4168;

    reg {
        name = "VP0 ACC8MLOW";
        desc = "[inferred] VP0 ACC8MLOW. Not in the data sheet. Source: vendor U-Boot 2010.06 `product/hiosd/vo/hi3519/vou_reg.h` (GPL-2.0 U-Boot tree, HiSilicon copyright, created 2015-05-26; mirror github.com/OpenIPC/u-boot-hi3516cv200), union `U_VP0_ACC8MLOW`, struct offset 0x416C (GPL-2.0, same-chip vendor header, byte-identical for Hi3516A V200 and Hi3519 V101). Reset value and access type unknown (modelled RW, no reset). Confidence: medium (vendor header for this chip family, not hardware verified).";

        field {
            name = "cnt8_med_low";
            desc = "[inferred] Cnt8 med low. (vendor header `product/hiosd/vo/hi3519/vou_reg.h` field `cnt8_med_low`; access and reset unknown, modelled RW)";
            sw = rw;
            hw = r;
        } cnt8_med_low[20:0];
    } VP0_ACC8MLOW @ 0x416C;

    reg {
        name = "VP0 ACC8MHIGH";
        desc = "[inferred] VP0 ACC8MHIGH. Not in the data sheet. Source: vendor U-Boot 2010.06 `product/hiosd/vo/hi3519/vou_reg.h` (GPL-2.0 U-Boot tree, HiSilicon copyright, created 2015-05-26; mirror github.com/OpenIPC/u-boot-hi3516cv200), union `U_VP0_ACC8MHIGH`, struct offset 0x4170 (GPL-2.0, same-chip vendor header, byte-identical for Hi3516A V200 and Hi3519 V101). Reset value and access type unknown (modelled RW, no reset). Confidence: medium (vendor header for this chip family, not hardware verified).";

        field {
            name = "cnt8_med_high";
            desc = "[inferred] Cnt8 med high. (vendor header `product/hiosd/vo/hi3519/vou_reg.h` field `cnt8_med_high`; access and reset unknown, modelled RW)";
            sw = rw;
            hw = r;
        } cnt8_med_high[20:0];
    } VP0_ACC8MHIGH @ 0x4170;

    reg {
        name = "VP0 ACCTOTAL";
        desc = "[inferred] VP0 ACCTOTAL. Not in the data sheet. Source: vendor U-Boot 2010.06 `product/hiosd/vo/hi3519/vou_reg.h` (GPL-2.0 U-Boot tree, HiSilicon copyright, created 2015-05-26; mirror github.com/OpenIPC/u-boot-hi3516cv200), union `U_VP0_ACCTOTAL`, struct offset 0x4174 (GPL-2.0, same-chip vendor header, byte-identical for Hi3516A V200 and Hi3519 V101). Reset value and access type unknown (modelled RW, no reset). Confidence: medium (vendor header for this chip family, not hardware verified).";

        field {
            name = "acc_pix_total";
            desc = "[inferred] ACC pix total. (vendor header `product/hiosd/vo/hi3519/vou_reg.h` field `acc_pix_total`; access and reset unknown, modelled RW)";
            sw = rw;
            hw = r;
        } acc_pix_total[20:0];
    } VP0_ACCTOTAL @ 0x4174;

    reg {
        name = "VP0 ACM control";
        desc = "[inferred] VP0 ACM control. Not in the data sheet. Source: vendor U-Boot 2010.06 `product/hiosd/vo/hi3519/vou_reg.h` (GPL-2.0 U-Boot tree, HiSilicon copyright, created 2015-05-26; mirror github.com/OpenIPC/u-boot-hi3516cv200), union `U_VP0_ACM_CTRL`, struct offset 0x4190 (GPL-2.0, same-chip vendor header, byte-identical for Hi3516A V200 and Hi3519 V101). Reset value and access type unknown (modelled RW, no reset). Confidence: medium (vendor header for this chip family, not hardware verified).";

        field {
            name = "acm_en";
            desc = "[inferred] ACM enable. (vendor header `product/hiosd/vo/hi3519/vou_reg.h` field `acm_en`; access and reset unknown, modelled RW)";
            sw = rw;
            hw = r;
        } acm_en[31:31];

        field {
            name = "acm_dbg_en";
            desc = "[inferred] ACM dbg enable. (vendor header `product/hiosd/vo/hi3519/vou_reg.h` field `acm_dbg_en`; access and reset unknown, modelled RW)";
            sw = rw;
            hw = r;
        } acm_dbg_en[30:30];

        field {
            name = "acm_stretch";
            desc = "[inferred] ACM stretch. (vendor header `product/hiosd/vo/hi3519/vou_reg.h` field `acm_stretch`; access and reset unknown, modelled RW)";
            sw = rw;
            hw = r;
        } acm_stretch[29:29];

        field {
            name = "acm_cliprange";
            desc = "[inferred] ACM cliprange. (vendor header `product/hiosd/vo/hi3519/vou_reg.h` field `acm_cliprange`; access and reset unknown, modelled RW)";
            sw = rw;
            hw = r;
        } acm_cliprange[28:28];

        field {
            name = "acm_cliporwrap";
            desc = "[inferred] ACM cliporwrap. (vendor header `product/hiosd/vo/hi3519/vou_reg.h` field `acm_cliporwrap`; access and reset unknown, modelled RW)";
            sw = rw;
            hw = r;
        } acm_cliporwrap[27:27];

        field {
            name = "acm_cbcrthr";
            desc = "[inferred] ACM cbcrthr. (vendor header `product/hiosd/vo/hi3519/vou_reg.h` field `acm_cbcrthr`; access and reset unknown, modelled RW)";
            sw = rw;
            hw = r;
        } acm_cbcrthr[7:0];
    } VP0_ACM_CTRL @ 0x4190;

    reg {
        name = "VP0 ACM ADJ";
        desc = "[inferred] VP0 ACM ADJ. Not in the data sheet. Source: vendor U-Boot 2010.06 `product/hiosd/vo/hi3519/vou_reg.h` (GPL-2.0 U-Boot tree, HiSilicon copyright, created 2015-05-26; mirror github.com/OpenIPC/u-boot-hi3516cv200), union `U_VP0_ACM_ADJ`, struct offset 0x4194 (GPL-2.0, same-chip vendor header, byte-identical for Hi3516A V200 and Hi3519 V101). Reset value and access type unknown (modelled RW, no reset). Confidence: medium (vendor header for this chip family, not hardware verified).";

        field {
            name = "acm_gain0";
            desc = "[inferred] ACM gain0. (vendor header `product/hiosd/vo/hi3519/vou_reg.h` field `acm_gain0`; access and reset unknown, modelled RW)";
            sw = rw;
            hw = r;
        } acm_gain0[29:20];

        field {
            name = "acm_gain1";
            desc = "[inferred] ACM gain1. (vendor header `product/hiosd/vo/hi3519/vou_reg.h` field `acm_gain1`; access and reset unknown, modelled RW)";
            sw = rw;
            hw = r;
        } acm_gain1[19:10];

        field {
            name = "acm_gain2";
            desc = "[inferred] ACM gain2. (vendor header `product/hiosd/vo/hi3519/vou_reg.h` field `acm_gain2`; access and reset unknown, modelled RW)";
            sw = rw;
            hw = r;
        } acm_gain2[9:0];
    } VP0_ACM_ADJ @ 0x4194;

    reg {
        name = "VP0 DFPOS";
        desc = "[inferred] VP0 DFPOS. Not in the data sheet. Source: vendor U-Boot 2010.06 `product/hiosd/vo/hi3519/vou_reg.h` (GPL-2.0 U-Boot tree, HiSilicon copyright, created 2015-05-26; mirror github.com/OpenIPC/u-boot-hi3516cv200), union `U_VP0_DFPOS`, struct offset 0x4200 (GPL-2.0, same-chip vendor header, byte-identical for Hi3516A V200 and Hi3519 V101). Reset value and access type unknown (modelled RW, no reset). Confidence: medium (vendor header for this chip family, not hardware verified).";

        field {
            name = "disp_yfpos";
            desc = "[inferred] Disp yfpos. (vendor header `product/hiosd/vo/hi3519/vou_reg.h` field `disp_yfpos`; access and reset unknown, modelled RW)";
            sw = rw;
            hw = r;
        } disp_yfpos[23:12];

        field {
            name = "disp_xfpos";
            desc = "[inferred] Disp xfpos. (vendor header `product/hiosd/vo/hi3519/vou_reg.h` field `disp_xfpos`; access and reset unknown, modelled RW)";
            sw = rw;
            hw = r;
        } disp_xfpos[11:0];
    } VP0_DFPOS @ 0x4200;

    reg {
        name = "VP0 DLPOS";
        desc = "[inferred] VP0 DLPOS. Not in the data sheet. Source: vendor U-Boot 2010.06 `product/hiosd/vo/hi3519/vou_reg.h` (GPL-2.0 U-Boot tree, HiSilicon copyright, created 2015-05-26; mirror github.com/OpenIPC/u-boot-hi3516cv200), union `U_VP0_DLPOS`, struct offset 0x4204 (GPL-2.0, same-chip vendor header, byte-identical for Hi3516A V200 and Hi3519 V101). Reset value and access type unknown (modelled RW, no reset). Confidence: medium (vendor header for this chip family, not hardware verified).";

        field {
            name = "disp_ylpos";
            desc = "[inferred] Disp ylpos. (vendor header `product/hiosd/vo/hi3519/vou_reg.h` field `disp_ylpos`; access and reset unknown, modelled RW)";
            sw = rw;
            hw = r;
        } disp_ylpos[23:12];

        field {
            name = "disp_xlpos";
            desc = "[inferred] Disp xlpos. (vendor header `product/hiosd/vo/hi3519/vou_reg.h` field `disp_xlpos`; access and reset unknown, modelled RW)";
            sw = rw;
            hw = r;
        } disp_xlpos[11:0];
    } VP0_DLPOS @ 0x4204;

    reg {
        name = "VP0 VFPOS";
        desc = "[inferred] VP0 VFPOS. Not in the data sheet. Source: vendor U-Boot 2010.06 `product/hiosd/vo/hi3519/vou_reg.h` (GPL-2.0 U-Boot tree, HiSilicon copyright, created 2015-05-26; mirror github.com/OpenIPC/u-boot-hi3516cv200), union `U_VP0_VFPOS`, struct offset 0x4208 (GPL-2.0, same-chip vendor header, byte-identical for Hi3516A V200 and Hi3519 V101). Reset value and access type unknown (modelled RW, no reset). Confidence: medium (vendor header for this chip family, not hardware verified).";

        field {
            name = "video_yfpos";
            desc = "[inferred] Video yfpos. (vendor header `product/hiosd/vo/hi3519/vou_reg.h` field `video_yfpos`; access and reset unknown, modelled RW)";
            sw = rw;
            hw = r;
        } video_yfpos[23:12];

        field {
            name = "video_xfpos";
            desc = "[inferred] Video xfpos. (vendor header `product/hiosd/vo/hi3519/vou_reg.h` field `video_xfpos`; access and reset unknown, modelled RW)";
            sw = rw;
            hw = r;
        } video_xfpos[11:0];
    } VP0_VFPOS @ 0x4208;

    reg {
        name = "VP0 VLPOS";
        desc = "[inferred] VP0 VLPOS. Not in the data sheet. Source: vendor U-Boot 2010.06 `product/hiosd/vo/hi3519/vou_reg.h` (GPL-2.0 U-Boot tree, HiSilicon copyright, created 2015-05-26; mirror github.com/OpenIPC/u-boot-hi3516cv200), union `U_VP0_VLPOS`, struct offset 0x420C (GPL-2.0, same-chip vendor header, byte-identical for Hi3516A V200 and Hi3519 V101). Reset value and access type unknown (modelled RW, no reset). Confidence: medium (vendor header for this chip family, not hardware verified).";

        field {
            name = "video_ylpos";
            desc = "[inferred] Video ylpos. (vendor header `product/hiosd/vo/hi3519/vou_reg.h` field `video_ylpos`; access and reset unknown, modelled RW)";
            sw = rw;
            hw = r;
        } video_ylpos[23:12];

        field {
            name = "video_xlpos";
            desc = "[inferred] Video xlpos. (vendor header `product/hiosd/vo/hi3519/vou_reg.h` field `video_xlpos`; access and reset unknown, modelled RW)";
            sw = rw;
            hw = r;
        } video_xlpos[11:0];
    } VP0_VLPOS @ 0x420C;

    reg {
        name = "VP0 background";
        desc = "[inferred] VP0 background. Not in the data sheet. Source: vendor U-Boot 2010.06 `product/hiosd/vo/hi3519/vou_reg.h` (GPL-2.0 U-Boot tree, HiSilicon copyright, created 2015-05-26; mirror github.com/OpenIPC/u-boot-hi3516cv200), union `U_VP0_BK`, struct offset 0x4210 (GPL-2.0, same-chip vendor header, byte-identical for Hi3516A V200 and Hi3519 V101). Reset value and access type unknown (modelled RW, no reset). Confidence: medium (vendor header for this chip family, not hardware verified).";

        field {
            name = "vbk_y";
            desc = "[inferred] Vbk y. (vendor header `product/hiosd/vo/hi3519/vou_reg.h` field `vbk_y`; access and reset unknown, modelled RW)";
            sw = rw;
            hw = r;
        } vbk_y[29:20];

        field {
            name = "vbk_cb";
            desc = "[inferred] Vbk cb. (vendor header `product/hiosd/vo/hi3519/vou_reg.h` field `vbk_cb`; access and reset unknown, modelled RW)";
            sw = rw;
            hw = r;
        } vbk_cb[19:10];

        field {
            name = "vbk_cr";
            desc = "[inferred] Vbk cr. (vendor header `product/hiosd/vo/hi3519/vou_reg.h` field `vbk_cr`; access and reset unknown, modelled RW)";
            sw = rw;
            hw = r;
        } vbk_cr[9:0];
    } VP0_BK @ 0x4210;

    reg {
        name = "VP0 alpha";
        desc = "[inferred] VP0 alpha. Not in the data sheet. Source: vendor U-Boot 2010.06 `product/hiosd/vo/hi3519/vou_reg.h` (GPL-2.0 U-Boot tree, HiSilicon copyright, created 2015-05-26; mirror github.com/OpenIPC/u-boot-hi3516cv200), union `U_VP0_ALPHA`, struct offset 0x4214 (GPL-2.0, same-chip vendor header, byte-identical for Hi3516A V200 and Hi3519 V101). Reset value and access type unknown (modelled RW, no reset). Confidence: medium (vendor header for this chip family, not hardware verified).";

        field {
            name = "vbk_alpha";
            desc = "[inferred] Vbk alpha. (vendor header `product/hiosd/vo/hi3519/vou_reg.h` field `vbk_alpha`; access and reset unknown, modelled RW)";
            sw = rw;
            hw = r;
        } vbk_alpha[7:0];
    } VP0_ALPHA @ 0x4214;

    reg {
        name = "VP0 CSC0 IDC";
        desc = "[inferred] VP0 CSC0 IDC. Not in the data sheet. Source: vendor U-Boot 2010.06 `product/hiosd/vo/hi3519/vou_reg.h` (GPL-2.0 U-Boot tree, HiSilicon copyright, created 2015-05-26; mirror github.com/OpenIPC/u-boot-hi3516cv200), union `U_VP0_CSC0_IDC`, struct offset 0x4300 (GPL-2.0, same-chip vendor header, byte-identical for Hi3516A V200 and Hi3519 V101). Reset value and access type unknown (modelled RW, no reset). Confidence: medium (vendor header for this chip family, not hardware verified).";

        field {
            name = "csc_en";
            desc = "[inferred] Colour-space conversion enable. (vendor header `product/hiosd/vo/hi3519/vou_reg.h` field `csc_en`; access and reset unknown, modelled RW)";
            sw = rw;
            hw = r;
        } csc_en[22:22];

        field {
            name = "cscidc1";
            desc = "[inferred] Cscidc1. (vendor header `product/hiosd/vo/hi3519/vou_reg.h` field `cscidc1`; access and reset unknown, modelled RW)";
            sw = rw;
            hw = r;
        } cscidc1[21:11];

        field {
            name = "cscidc0";
            desc = "[inferred] Cscidc0. (vendor header `product/hiosd/vo/hi3519/vou_reg.h` field `cscidc0`; access and reset unknown, modelled RW)";
            sw = rw;
            hw = r;
        } cscidc0[10:0];
    } VP0_CSC0_IDC @ 0x4300;

    reg {
        name = "VP0 CSC0 ODC";
        desc = "[inferred] VP0 CSC0 ODC. Not in the data sheet. Source: vendor U-Boot 2010.06 `product/hiosd/vo/hi3519/vou_reg.h` (GPL-2.0 U-Boot tree, HiSilicon copyright, created 2015-05-26; mirror github.com/OpenIPC/u-boot-hi3516cv200), union `U_VP0_CSC0_ODC`, struct offset 0x4304 (GPL-2.0, same-chip vendor header, byte-identical for Hi3516A V200 and Hi3519 V101). Reset value and access type unknown (modelled RW, no reset). Confidence: medium (vendor header for this chip family, not hardware verified).";

        field {
            name = "csc_sign_mode";
            desc = "[inferred] Colour-space conversion sign mode. (vendor header `product/hiosd/vo/hi3519/vou_reg.h` field `csc_sign_mode`; access and reset unknown, modelled RW)";
            sw = rw;
            hw = r;
        } csc_sign_mode[22:22];

        field {
            name = "cscodc1";
            desc = "[inferred] Cscodc1. (vendor header `product/hiosd/vo/hi3519/vou_reg.h` field `cscodc1`; access and reset unknown, modelled RW)";
            sw = rw;
            hw = r;
        } cscodc1[21:11];

        field {
            name = "cscodc0";
            desc = "[inferred] Cscodc0. (vendor header `product/hiosd/vo/hi3519/vou_reg.h` field `cscodc0`; access and reset unknown, modelled RW)";
            sw = rw;
            hw = r;
        } cscodc0[10:0];
    } VP0_CSC0_ODC @ 0x4304;

    reg {
        name = "VP0 CSC0 IODC";
        desc = "[inferred] VP0 CSC0 IODC. Not in the data sheet. Source: vendor U-Boot 2010.06 `product/hiosd/vo/hi3519/vou_reg.h` (GPL-2.0 U-Boot tree, HiSilicon copyright, created 2015-05-26; mirror github.com/OpenIPC/u-boot-hi3516cv200), union `U_VP0_CSC0_IODC`, struct offset 0x4308 (GPL-2.0, same-chip vendor header, byte-identical for Hi3516A V200 and Hi3519 V101). Reset value and access type unknown (modelled RW, no reset). Confidence: medium (vendor header for this chip family, not hardware verified).";

        field {
            name = "cscodc2";
            desc = "[inferred] Cscodc2. (vendor header `product/hiosd/vo/hi3519/vou_reg.h` field `cscodc2`; access and reset unknown, modelled RW)";
            sw = rw;
            hw = r;
        } cscodc2[21:11];

        field {
            name = "cscidc2";
            desc = "[inferred] Cscidc2. (vendor header `product/hiosd/vo/hi3519/vou_reg.h` field `cscidc2`; access and reset unknown, modelled RW)";
            sw = rw;
            hw = r;
        } cscidc2[10:0];
    } VP0_CSC0_IODC @ 0x4308;

    reg {
        name = "VP0 CSC0 P0";
        desc = "[inferred] VP0 CSC0 P0. Not in the data sheet. Source: vendor U-Boot 2010.06 `product/hiosd/vo/hi3519/vou_reg.h` (GPL-2.0 U-Boot tree, HiSilicon copyright, created 2015-05-26; mirror github.com/OpenIPC/u-boot-hi3516cv200), union `U_VP0_CSC0_P0`, struct offset 0x430C (GPL-2.0, same-chip vendor header, byte-identical for Hi3516A V200 and Hi3519 V101). Reset value and access type unknown (modelled RW, no reset). Confidence: medium (vendor header for this chip family, not hardware verified).";

        field {
            name = "cscp01";
            desc = "[inferred] Cscp01. (vendor header `product/hiosd/vo/hi3519/vou_reg.h` field `cscp01`; access and reset unknown, modelled RW)";
            sw = rw;
            hw = r;
        } cscp01[30:16];

        field {
            name = "cscp00";
            desc = "[inferred] Cscp00. (vendor header `product/hiosd/vo/hi3519/vou_reg.h` field `cscp00`; access and reset unknown, modelled RW)";
            sw = rw;
            hw = r;
        } cscp00[14:0];
    } VP0_CSC0_P0 @ 0x430C;

    reg {
        name = "VP0 CSC0 P1";
        desc = "[inferred] VP0 CSC0 P1. Not in the data sheet. Source: vendor U-Boot 2010.06 `product/hiosd/vo/hi3519/vou_reg.h` (GPL-2.0 U-Boot tree, HiSilicon copyright, created 2015-05-26; mirror github.com/OpenIPC/u-boot-hi3516cv200), union `U_VP0_CSC0_P1`, struct offset 0x4310 (GPL-2.0, same-chip vendor header, byte-identical for Hi3516A V200 and Hi3519 V101). Reset value and access type unknown (modelled RW, no reset). Confidence: medium (vendor header for this chip family, not hardware verified).";

        field {
            name = "cscp10";
            desc = "[inferred] Cscp10. (vendor header `product/hiosd/vo/hi3519/vou_reg.h` field `cscp10`; access and reset unknown, modelled RW)";
            sw = rw;
            hw = r;
        } cscp10[30:16];

        field {
            name = "cscp02";
            desc = "[inferred] Cscp02. (vendor header `product/hiosd/vo/hi3519/vou_reg.h` field `cscp02`; access and reset unknown, modelled RW)";
            sw = rw;
            hw = r;
        } cscp02[14:0];
    } VP0_CSC0_P1 @ 0x4310;

    reg {
        name = "VP0 CSC0 P2";
        desc = "[inferred] VP0 CSC0 P2. Not in the data sheet. Source: vendor U-Boot 2010.06 `product/hiosd/vo/hi3519/vou_reg.h` (GPL-2.0 U-Boot tree, HiSilicon copyright, created 2015-05-26; mirror github.com/OpenIPC/u-boot-hi3516cv200), union `U_VP0_CSC0_P2`, struct offset 0x4314 (GPL-2.0, same-chip vendor header, byte-identical for Hi3516A V200 and Hi3519 V101). Reset value and access type unknown (modelled RW, no reset). Confidence: medium (vendor header for this chip family, not hardware verified).";

        field {
            name = "cscp12";
            desc = "[inferred] Cscp12. (vendor header `product/hiosd/vo/hi3519/vou_reg.h` field `cscp12`; access and reset unknown, modelled RW)";
            sw = rw;
            hw = r;
        } cscp12[30:16];

        field {
            name = "cscp11";
            desc = "[inferred] Cscp11. (vendor header `product/hiosd/vo/hi3519/vou_reg.h` field `cscp11`; access and reset unknown, modelled RW)";
            sw = rw;
            hw = r;
        } cscp11[14:0];
    } VP0_CSC0_P2 @ 0x4314;

    reg {
        name = "VP0 CSC0 P3";
        desc = "[inferred] VP0 CSC0 P3. Not in the data sheet. Source: vendor U-Boot 2010.06 `product/hiosd/vo/hi3519/vou_reg.h` (GPL-2.0 U-Boot tree, HiSilicon copyright, created 2015-05-26; mirror github.com/OpenIPC/u-boot-hi3516cv200), union `U_VP0_CSC0_P3`, struct offset 0x4318 (GPL-2.0, same-chip vendor header, byte-identical for Hi3516A V200 and Hi3519 V101). Reset value and access type unknown (modelled RW, no reset). Confidence: medium (vendor header for this chip family, not hardware verified).";

        field {
            name = "cscp21";
            desc = "[inferred] Cscp21. (vendor header `product/hiosd/vo/hi3519/vou_reg.h` field `cscp21`; access and reset unknown, modelled RW)";
            sw = rw;
            hw = r;
        } cscp21[30:16];

        field {
            name = "cscp20";
            desc = "[inferred] Cscp20. (vendor header `product/hiosd/vo/hi3519/vou_reg.h` field `cscp20`; access and reset unknown, modelled RW)";
            sw = rw;
            hw = r;
        } cscp20[14:0];
    } VP0_CSC0_P3 @ 0x4318;

    reg {
        name = "VP0 CSC0 P4";
        desc = "[inferred] VP0 CSC0 P4. Not in the data sheet. Source: vendor U-Boot 2010.06 `product/hiosd/vo/hi3519/vou_reg.h` (GPL-2.0 U-Boot tree, HiSilicon copyright, created 2015-05-26; mirror github.com/OpenIPC/u-boot-hi3516cv200), union `U_VP0_CSC0_P4`, struct offset 0x431C (GPL-2.0, same-chip vendor header, byte-identical for Hi3516A V200 and Hi3519 V101). Reset value and access type unknown (modelled RW, no reset). Confidence: medium (vendor header for this chip family, not hardware verified).";

        field {
            name = "cscp22";
            desc = "[inferred] Cscp22. (vendor header `product/hiosd/vo/hi3519/vou_reg.h` field `cscp22`; access and reset unknown, modelled RW)";
            sw = rw;
            hw = r;
        } cscp22[14:0];
    } VP0_CSC0_P4 @ 0x431C;

    reg {
        name = "VP0 CSC1 IDC";
        desc = "[inferred] VP0 CSC1 IDC. Not in the data sheet. Source: vendor U-Boot 2010.06 `product/hiosd/vo/hi3519/vou_reg.h` (GPL-2.0 U-Boot tree, HiSilicon copyright, created 2015-05-26; mirror github.com/OpenIPC/u-boot-hi3516cv200), union `U_VP0_CSC1_IDC`, struct offset 0x4320 (GPL-2.0, same-chip vendor header, byte-identical for Hi3516A V200 and Hi3519 V101). Reset value and access type unknown (modelled RW, no reset). Confidence: medium (vendor header for this chip family, not hardware verified).";

        field {
            name = "csc_en";
            desc = "[inferred] Colour-space conversion enable. (vendor header `product/hiosd/vo/hi3519/vou_reg.h` field `csc_en`; access and reset unknown, modelled RW)";
            sw = rw;
            hw = r;
        } csc_en[22:22];

        field {
            name = "cscidc1";
            desc = "[inferred] Cscidc1. (vendor header `product/hiosd/vo/hi3519/vou_reg.h` field `cscidc1`; access and reset unknown, modelled RW)";
            sw = rw;
            hw = r;
        } cscidc1[21:11];

        field {
            name = "cscidc0";
            desc = "[inferred] Cscidc0. (vendor header `product/hiosd/vo/hi3519/vou_reg.h` field `cscidc0`; access and reset unknown, modelled RW)";
            sw = rw;
            hw = r;
        } cscidc0[10:0];
    } VP0_CSC1_IDC @ 0x4320;

    reg {
        name = "VP0 CSC1 ODC";
        desc = "[inferred] VP0 CSC1 ODC. Not in the data sheet. Source: vendor U-Boot 2010.06 `product/hiosd/vo/hi3519/vou_reg.h` (GPL-2.0 U-Boot tree, HiSilicon copyright, created 2015-05-26; mirror github.com/OpenIPC/u-boot-hi3516cv200), union `U_VP0_CSC1_ODC`, struct offset 0x4324 (GPL-2.0, same-chip vendor header, byte-identical for Hi3516A V200 and Hi3519 V101). Reset value and access type unknown (modelled RW, no reset). Confidence: medium (vendor header for this chip family, not hardware verified).";

        field {
            name = "csc_sign_mode";
            desc = "[inferred] Colour-space conversion sign mode. (vendor header `product/hiosd/vo/hi3519/vou_reg.h` field `csc_sign_mode`; access and reset unknown, modelled RW)";
            sw = rw;
            hw = r;
        } csc_sign_mode[22:22];

        field {
            name = "cscodc1";
            desc = "[inferred] Cscodc1. (vendor header `product/hiosd/vo/hi3519/vou_reg.h` field `cscodc1`; access and reset unknown, modelled RW)";
            sw = rw;
            hw = r;
        } cscodc1[21:11];

        field {
            name = "cscodc0";
            desc = "[inferred] Cscodc0. (vendor header `product/hiosd/vo/hi3519/vou_reg.h` field `cscodc0`; access and reset unknown, modelled RW)";
            sw = rw;
            hw = r;
        } cscodc0[10:0];
    } VP0_CSC1_ODC @ 0x4324;

    reg {
        name = "VP0 CSC1 IODC";
        desc = "[inferred] VP0 CSC1 IODC. Not in the data sheet. Source: vendor U-Boot 2010.06 `product/hiosd/vo/hi3519/vou_reg.h` (GPL-2.0 U-Boot tree, HiSilicon copyright, created 2015-05-26; mirror github.com/OpenIPC/u-boot-hi3516cv200), union `U_VP0_CSC1_IODC`, struct offset 0x4328 (GPL-2.0, same-chip vendor header, byte-identical for Hi3516A V200 and Hi3519 V101). Reset value and access type unknown (modelled RW, no reset). Confidence: medium (vendor header for this chip family, not hardware verified).";

        field {
            name = "cscodc2";
            desc = "[inferred] Cscodc2. (vendor header `product/hiosd/vo/hi3519/vou_reg.h` field `cscodc2`; access and reset unknown, modelled RW)";
            sw = rw;
            hw = r;
        } cscodc2[21:11];

        field {
            name = "cscidc2";
            desc = "[inferred] Cscidc2. (vendor header `product/hiosd/vo/hi3519/vou_reg.h` field `cscidc2`; access and reset unknown, modelled RW)";
            sw = rw;
            hw = r;
        } cscidc2[10:0];
    } VP0_CSC1_IODC @ 0x4328;

    reg {
        name = "VP0 CSC1 P0";
        desc = "[inferred] VP0 CSC1 P0. Not in the data sheet. Source: vendor U-Boot 2010.06 `product/hiosd/vo/hi3519/vou_reg.h` (GPL-2.0 U-Boot tree, HiSilicon copyright, created 2015-05-26; mirror github.com/OpenIPC/u-boot-hi3516cv200), union `U_VP0_CSC1_P0`, struct offset 0x432C (GPL-2.0, same-chip vendor header, byte-identical for Hi3516A V200 and Hi3519 V101). Reset value and access type unknown (modelled RW, no reset). Confidence: medium (vendor header for this chip family, not hardware verified).";

        field {
            name = "cscp01";
            desc = "[inferred] Cscp01. (vendor header `product/hiosd/vo/hi3519/vou_reg.h` field `cscp01`; access and reset unknown, modelled RW)";
            sw = rw;
            hw = r;
        } cscp01[30:16];

        field {
            name = "cscp00";
            desc = "[inferred] Cscp00. (vendor header `product/hiosd/vo/hi3519/vou_reg.h` field `cscp00`; access and reset unknown, modelled RW)";
            sw = rw;
            hw = r;
        } cscp00[14:0];
    } VP0_CSC1_P0 @ 0x432C;

    reg {
        name = "VP0 CSC1 P1";
        desc = "[inferred] VP0 CSC1 P1. Not in the data sheet. Source: vendor U-Boot 2010.06 `product/hiosd/vo/hi3519/vou_reg.h` (GPL-2.0 U-Boot tree, HiSilicon copyright, created 2015-05-26; mirror github.com/OpenIPC/u-boot-hi3516cv200), union `U_VP0_CSC1_P1`, struct offset 0x4330 (GPL-2.0, same-chip vendor header, byte-identical for Hi3516A V200 and Hi3519 V101). Reset value and access type unknown (modelled RW, no reset). Confidence: medium (vendor header for this chip family, not hardware verified).";

        field {
            name = "cscp10";
            desc = "[inferred] Cscp10. (vendor header `product/hiosd/vo/hi3519/vou_reg.h` field `cscp10`; access and reset unknown, modelled RW)";
            sw = rw;
            hw = r;
        } cscp10[30:16];

        field {
            name = "cscp02";
            desc = "[inferred] Cscp02. (vendor header `product/hiosd/vo/hi3519/vou_reg.h` field `cscp02`; access and reset unknown, modelled RW)";
            sw = rw;
            hw = r;
        } cscp02[14:0];
    } VP0_CSC1_P1 @ 0x4330;

    reg {
        name = "VP0 CSC1 P2";
        desc = "[inferred] VP0 CSC1 P2. Not in the data sheet. Source: vendor U-Boot 2010.06 `product/hiosd/vo/hi3519/vou_reg.h` (GPL-2.0 U-Boot tree, HiSilicon copyright, created 2015-05-26; mirror github.com/OpenIPC/u-boot-hi3516cv200), union `U_VP0_CSC1_P2`, struct offset 0x4334 (GPL-2.0, same-chip vendor header, byte-identical for Hi3516A V200 and Hi3519 V101). Reset value and access type unknown (modelled RW, no reset). Confidence: medium (vendor header for this chip family, not hardware verified).";

        field {
            name = "cscp12";
            desc = "[inferred] Cscp12. (vendor header `product/hiosd/vo/hi3519/vou_reg.h` field `cscp12`; access and reset unknown, modelled RW)";
            sw = rw;
            hw = r;
        } cscp12[30:16];

        field {
            name = "cscp11";
            desc = "[inferred] Cscp11. (vendor header `product/hiosd/vo/hi3519/vou_reg.h` field `cscp11`; access and reset unknown, modelled RW)";
            sw = rw;
            hw = r;
        } cscp11[14:0];
    } VP0_CSC1_P2 @ 0x4334;

    reg {
        name = "VP0 CSC1 P3";
        desc = "[inferred] VP0 CSC1 P3. Not in the data sheet. Source: vendor U-Boot 2010.06 `product/hiosd/vo/hi3519/vou_reg.h` (GPL-2.0 U-Boot tree, HiSilicon copyright, created 2015-05-26; mirror github.com/OpenIPC/u-boot-hi3516cv200), union `U_VP0_CSC1_P3`, struct offset 0x4338 (GPL-2.0, same-chip vendor header, byte-identical for Hi3516A V200 and Hi3519 V101). Reset value and access type unknown (modelled RW, no reset). Confidence: medium (vendor header for this chip family, not hardware verified).";

        field {
            name = "cscp21";
            desc = "[inferred] Cscp21. (vendor header `product/hiosd/vo/hi3519/vou_reg.h` field `cscp21`; access and reset unknown, modelled RW)";
            sw = rw;
            hw = r;
        } cscp21[30:16];

        field {
            name = "cscp20";
            desc = "[inferred] Cscp20. (vendor header `product/hiosd/vo/hi3519/vou_reg.h` field `cscp20`; access and reset unknown, modelled RW)";
            sw = rw;
            hw = r;
        } cscp20[14:0];
    } VP0_CSC1_P3 @ 0x4338;

    reg {
        name = "VP0 CSC1 P4";
        desc = "[inferred] VP0 CSC1 P4. Not in the data sheet. Source: vendor U-Boot 2010.06 `product/hiosd/vo/hi3519/vou_reg.h` (GPL-2.0 U-Boot tree, HiSilicon copyright, created 2015-05-26; mirror github.com/OpenIPC/u-boot-hi3516cv200), union `U_VP0_CSC1_P4`, struct offset 0x433C (GPL-2.0, same-chip vendor header, byte-identical for Hi3516A V200 and Hi3519 V101). Reset value and access type unknown (modelled RW, no reset). Confidence: medium (vendor header for this chip family, not hardware verified).";

        field {
            name = "cscp22";
            desc = "[inferred] Cscp22. (vendor header `product/hiosd/vo/hi3519/vou_reg.h` field `cscp22`; access and reset unknown, modelled RW)";
            sw = rw;
            hw = r;
        } cscp22[14:0];
    } VP0_CSC1_P4 @ 0x433C;

    reg {
        name = "G0 control";
        desc = "[inferred] G0 control. Not in the data sheet. Source: vendor U-Boot 2010.06 `product/hiosd/vo/hi3519/vou_reg.h` (GPL-2.0 U-Boot tree, HiSilicon copyright, created 2015-05-26; mirror github.com/OpenIPC/u-boot-hi3516cv200), union `U_G0_CTRL`, struct offset 0x6000 (GPL-2.0, same-chip vendor header, byte-identical for Hi3516A V200 and Hi3519 V101). Reset value and access type unknown (modelled RW, no reset). Confidence: medium (vendor header for this chip family, not hardware verified).";

        field {
            name = "surface_en";
            desc = "[inferred] Surface enable. (vendor header `product/hiosd/vo/hi3519/vou_reg.h` field `surface_en`; access and reset unknown, modelled RW)";
            sw = rw;
            hw = r;
        } surface_en[31:31];

        field {
            name = "nosec_flag";
            desc = "[inferred] Nosec flag. (vendor header `product/hiosd/vo/hi3519/vou_reg.h` field `nosec_flag`; access and reset unknown, modelled RW)";
            sw = rw;
            hw = r;
        } nosec_flag[30:30];

        field {
            name = "mute_en";
            desc = "[inferred] Mute enable. (vendor header `product/hiosd/vo/hi3519/vou_reg.h` field `mute_en`; access and reset unknown, modelled RW)";
            sw = rw;
            hw = r;
        } mute_en[28:28];

        field {
            name = "upd_mode";
            desc = "[inferred] Update mode. (vendor header `product/hiosd/vo/hi3519/vou_reg.h` field `upd_mode`; access and reset unknown, modelled RW)";
            sw = rw;
            hw = r;
        } upd_mode[27:27];

        field {
            name = "read_mode";
            desc = "[inferred] Read mode. (vendor header `product/hiosd/vo/hi3519/vou_reg.h` field `read_mode`; access and reset unknown, modelled RW)";
            sw = rw;
            hw = r;
        } read_mode[26:26];

        field {
            name = "dcmp_en";
            desc = "[inferred] Decompression enable. (vendor header `product/hiosd/vo/hi3519/vou_reg.h` field `dcmp_en`; access and reset unknown, modelled RW)";
            sw = rw;
            hw = r;
        } dcmp_en[25:25];

        field {
            name = "flip_en";
            desc = "[inferred] Flip enable. (vendor header `product/hiosd/vo/hi3519/vou_reg.h` field `flip_en`; access and reset unknown, modelled RW)";
            sw = rw;
            hw = r;
        } flip_en[24:24];

        field {
            name = "precharge_en";
            desc = "[inferred] Precharge enable. (vendor header `product/hiosd/vo/hi3519/vou_reg.h` field `precharge_en`; access and reset unknown, modelled RW)";
            sw = rw;
            hw = r;
        } precharge_en[21:21];

        field {
            name = "precharge_mode";
            desc = "[inferred] Precharge mode. (vendor header `product/hiosd/vo/hi3519/vou_reg.h` field `precharge_mode`; access and reset unknown, modelled RW)";
            sw = rw;
            hw = r;
        } precharge_mode[20:20];

        field {
            name = "bitext";
            desc = "[inferred] Bitext. (vendor header `product/hiosd/vo/hi3519/vou_reg.h` field `bitext`; access and reset unknown, modelled RW)";
            sw = rw;
            hw = r;
        } bitext[9:8];

        field {
            name = "ifmt";
            desc = "[inferred] Input format. (vendor header `product/hiosd/vo/hi3519/vou_reg.h` field `ifmt`; access and reset unknown, modelled RW)";
            sw = rw;
            hw = r;
        } ifmt[7:0];
    } G0_CTRL @ 0x6000;

    reg {
        name = "G0 update";
        desc = "[inferred] G0 update. Not in the data sheet. Source: vendor U-Boot 2010.06 `product/hiosd/vo/hi3519/vou_reg.h` (GPL-2.0 U-Boot tree, HiSilicon copyright, created 2015-05-26; mirror github.com/OpenIPC/u-boot-hi3516cv200), union `U_G0_UPD`, struct offset 0x6004 (GPL-2.0, same-chip vendor header, byte-identical for Hi3516A V200 and Hi3519 V101). Reset value and access type unknown (modelled RW, no reset). Confidence: medium (vendor header for this chip family, not hardware verified).";

        field {
            name = "regup";
            desc = "[inferred] Regup. (vendor header `product/hiosd/vo/hi3519/vou_reg.h` field `regup`; access and reset unknown, modelled RW)";
            sw = rw;
            hw = r;
        } regup[0:0];
    } G0_UPD @ 0x6004;

    reg {
        name = "G0 address";
        desc = "[inferred] G0 address. Not in the data sheet. Source: vendor U-Boot 2010.06 `product/hiosd/vo/hi3519/vou_reg.h` (GPL-2.0 U-Boot tree, HiSilicon copyright, created 2015-05-26; mirror github.com/OpenIPC/u-boot-hi3516cv200), union `U_G0_ADDR`, struct offset 0x6010 (GPL-2.0, same-chip vendor header, byte-identical for Hi3516A V200 and Hi3519 V101). Reset value and access type unknown (modelled RW, no reset). Confidence: medium (vendor header for this chip family, not hardware verified).";

        field {
            name = "surface_addr";
            desc = "[inferred] Surface address. (vendor header `product/hiosd/vo/hi3519/vou_reg.h` field `surface_addr`; access and reset unknown, modelled RW)";
            sw = rw;
            hw = r;
        } surface_addr[31:0];
    } G0_ADDR @ 0x6010;

    reg {
        name = "G0 NADDR";
        desc = "[inferred] G0 NADDR. Not in the data sheet. Source: vendor U-Boot 2010.06 `product/hiosd/vo/hi3519/vou_reg.h` (GPL-2.0 U-Boot tree, HiSilicon copyright, created 2015-05-26; mirror github.com/OpenIPC/u-boot-hi3516cv200), union `U_G0_NADDR`, struct offset 0x6018 (GPL-2.0, same-chip vendor header, byte-identical for Hi3516A V200 and Hi3519 V101). Reset value and access type unknown (modelled RW, no reset). Confidence: medium (vendor header for this chip family, not hardware verified).";

        field {
            name = "surface_addr";
            desc = "[inferred] Surface address. (vendor header `product/hiosd/vo/hi3519/vou_reg.h` field `surface_addr`; access and reset unknown, modelled RW)";
            sw = rw;
            hw = r;
        } surface_addr[31:0];
    } G0_NADDR @ 0x6018;

    reg {
        name = "G0 stride";
        desc = "[inferred] G0 stride. Not in the data sheet. Source: vendor U-Boot 2010.06 `product/hiosd/vo/hi3519/vou_reg.h` (GPL-2.0 U-Boot tree, HiSilicon copyright, created 2015-05-26; mirror github.com/OpenIPC/u-boot-hi3516cv200), union `U_G0_STRIDE`, struct offset 0x601C (GPL-2.0, same-chip vendor header, byte-identical for Hi3516A V200 and Hi3519 V101). Reset value and access type unknown (modelled RW, no reset). Confidence: medium (vendor header for this chip family, not hardware verified).";

        field {
            name = "surface_stride";
            desc = "[inferred] Surface stride. (vendor header `product/hiosd/vo/hi3519/vou_reg.h` field `surface_stride`; access and reset unknown, modelled RW)";
            sw = rw;
            hw = r;
        } surface_stride[15:0];
    } G0_STRIDE @ 0x601C;

    reg {
        name = "G0 IRESO";
        desc = "[inferred] G0 IRESO. Not in the data sheet. Source: vendor U-Boot 2010.06 `product/hiosd/vo/hi3519/vou_reg.h` (GPL-2.0 U-Boot tree, HiSilicon copyright, created 2015-05-26; mirror github.com/OpenIPC/u-boot-hi3516cv200), union `U_G0_IRESO`, struct offset 0x6020 (GPL-2.0, same-chip vendor header, byte-identical for Hi3516A V200 and Hi3519 V101). Reset value and access type unknown (modelled RW, no reset). Confidence: medium (vendor header for this chip family, not hardware verified).";

        field {
            name = "ih";
            desc = "[inferred] Ih. (vendor header `product/hiosd/vo/hi3519/vou_reg.h` field `ih`; access and reset unknown, modelled RW)";
            sw = rw;
            hw = r;
        } ih[23:12];

        field {
            name = "iw";
            desc = "[inferred] Iw. (vendor header `product/hiosd/vo/hi3519/vou_reg.h` field `iw`; access and reset unknown, modelled RW)";
            sw = rw;
            hw = r;
        } iw[11:0];
    } G0_IRESO @ 0x6020;

    reg {
        name = "G0 SFPOS";
        desc = "[inferred] G0 SFPOS. Not in the data sheet. Source: vendor U-Boot 2010.06 `product/hiosd/vo/hi3519/vou_reg.h` (GPL-2.0 U-Boot tree, HiSilicon copyright, created 2015-05-26; mirror github.com/OpenIPC/u-boot-hi3516cv200), union `U_G0_SFPOS`, struct offset 0x6024 (GPL-2.0, same-chip vendor header, byte-identical for Hi3516A V200 and Hi3519 V101). Reset value and access type unknown (modelled RW, no reset). Confidence: medium (vendor header for this chip family, not hardware verified).";

        field {
            name = "src_xfpos";
            desc = "[inferred] Source xfpos. (vendor header `product/hiosd/vo/hi3519/vou_reg.h` field `src_xfpos`; access and reset unknown, modelled RW)";
            sw = rw;
            hw = r;
        } src_xfpos[6:0];
    } G0_SFPOS @ 0x6024;

    reg {
        name = "G0 CBMPARA";
        desc = "[inferred] G0 CBMPARA. Not in the data sheet. Source: vendor U-Boot 2010.06 `product/hiosd/vo/hi3519/vou_reg.h` (GPL-2.0 U-Boot tree, HiSilicon copyright, created 2015-05-26; mirror github.com/OpenIPC/u-boot-hi3516cv200), union `U_G0_CBMPARA`, struct offset 0x6030 (GPL-2.0, same-chip vendor header, byte-identical for Hi3516A V200 and Hi3519 V101). Reset value and access type unknown (modelled RW, no reset). Confidence: medium (vendor header for this chip family, not hardware verified).";

        field {
            name = "key_mode";
            desc = "[inferred] Key mode. (vendor header `product/hiosd/vo/hi3519/vou_reg.h` field `key_mode`; access and reset unknown, modelled RW)";
            sw = rw;
            hw = r;
        } key_mode[15:15];

        field {
            name = "key_en";
            desc = "[inferred] Key enable. (vendor header `product/hiosd/vo/hi3519/vou_reg.h` field `key_en`; access and reset unknown, modelled RW)";
            sw = rw;
            hw = r;
        } key_en[14:14];

        field {
            name = "premult_en";
            desc = "[inferred] Premult enable. (vendor header `product/hiosd/vo/hi3519/vou_reg.h` field `premult_en`; access and reset unknown, modelled RW)";
            sw = rw;
            hw = r;
        } premult_en[13:13];

        field {
            name = "palpha_en";
            desc = "[inferred] Palpha enable. (vendor header `product/hiosd/vo/hi3519/vou_reg.h` field `palpha_en`; access and reset unknown, modelled RW)";
            sw = rw;
            hw = r;
        } palpha_en[12:12];

        field {
            name = "hedge_p";
            desc = "[inferred] Hedge p. (vendor header `product/hiosd/vo/hi3519/vou_reg.h` field `hedge_p`; access and reset unknown, modelled RW)";
            sw = rw;
            hw = r;
        } hedge_p[11:11];

        field {
            name = "vedge_p";
            desc = "[inferred] Vedge p. (vendor header `product/hiosd/vo/hi3519/vou_reg.h` field `vedge_p`; access and reset unknown, modelled RW)";
            sw = rw;
            hw = r;
        } vedge_p[10:10];

        field {
            name = "palpha_range";
            desc = "[inferred] Palpha range. (vendor header `product/hiosd/vo/hi3519/vou_reg.h` field `palpha_range`; access and reset unknown, modelled RW)";
            sw = rw;
            hw = r;
        } palpha_range[8:8];

        field {
            name = "galpha";
            desc = "[inferred] Galpha. (vendor header `product/hiosd/vo/hi3519/vou_reg.h` field `galpha`; access and reset unknown, modelled RW)";
            sw = rw;
            hw = r;
        } galpha[7:0];
    } G0_CBMPARA @ 0x6030;

    reg {
        name = "G0 CKEYMAX";
        desc = "[inferred] G0 CKEYMAX. Not in the data sheet. Source: vendor U-Boot 2010.06 `product/hiosd/vo/hi3519/vou_reg.h` (GPL-2.0 U-Boot tree, HiSilicon copyright, created 2015-05-26; mirror github.com/OpenIPC/u-boot-hi3516cv200), union `U_G0_CKEYMAX`, struct offset 0x6034 (GPL-2.0, same-chip vendor header, byte-identical for Hi3516A V200 and Hi3519 V101). Reset value and access type unknown (modelled RW, no reset). Confidence: medium (vendor header for this chip family, not hardware verified).";

        field {
            name = "va0";
            desc = "[inferred] Va0. (vendor header `product/hiosd/vo/hi3519/vou_reg.h` field `va0`; access and reset unknown, modelled RW)";
            sw = rw;
            hw = r;
        } va0[31:24];

        field {
            name = "keyr_max";
            desc = "[inferred] Keyr max. (vendor header `product/hiosd/vo/hi3519/vou_reg.h` field `keyr_max`; access and reset unknown, modelled RW)";
            sw = rw;
            hw = r;
        } keyr_max[23:16];

        field {
            name = "keyg_max";
            desc = "[inferred] Keyg max. (vendor header `product/hiosd/vo/hi3519/vou_reg.h` field `keyg_max`; access and reset unknown, modelled RW)";
            sw = rw;
            hw = r;
        } keyg_max[15:8];

        field {
            name = "keyb_max";
            desc = "[inferred] Keyb max. (vendor header `product/hiosd/vo/hi3519/vou_reg.h` field `keyb_max`; access and reset unknown, modelled RW)";
            sw = rw;
            hw = r;
        } keyb_max[7:0];
    } G0_CKEYMAX @ 0x6034;

    reg {
        name = "G0 CKEYMIN";
        desc = "[inferred] G0 CKEYMIN. Not in the data sheet. Source: vendor U-Boot 2010.06 `product/hiosd/vo/hi3519/vou_reg.h` (GPL-2.0 U-Boot tree, HiSilicon copyright, created 2015-05-26; mirror github.com/OpenIPC/u-boot-hi3516cv200), union `U_G0_CKEYMIN`, struct offset 0x6038 (GPL-2.0, same-chip vendor header, byte-identical for Hi3516A V200 and Hi3519 V101). Reset value and access type unknown (modelled RW, no reset). Confidence: medium (vendor header for this chip family, not hardware verified).";

        field {
            name = "va1";
            desc = "[inferred] Va1. (vendor header `product/hiosd/vo/hi3519/vou_reg.h` field `va1`; access and reset unknown, modelled RW)";
            sw = rw;
            hw = r;
        } va1[31:24];

        field {
            name = "keyr_min";
            desc = "[inferred] Keyr min. (vendor header `product/hiosd/vo/hi3519/vou_reg.h` field `keyr_min`; access and reset unknown, modelled RW)";
            sw = rw;
            hw = r;
        } keyr_min[23:16];

        field {
            name = "keyg_min";
            desc = "[inferred] Keyg min. (vendor header `product/hiosd/vo/hi3519/vou_reg.h` field `keyg_min`; access and reset unknown, modelled RW)";
            sw = rw;
            hw = r;
        } keyg_min[15:8];

        field {
            name = "keyb_min";
            desc = "[inferred] Keyb min. (vendor header `product/hiosd/vo/hi3519/vou_reg.h` field `keyb_min`; access and reset unknown, modelled RW)";
            sw = rw;
            hw = r;
        } keyb_min[7:0];
    } G0_CKEYMIN @ 0x6038;

    reg {
        name = "G0 CMASK";
        desc = "[inferred] G0 CMASK. Not in the data sheet. Source: vendor U-Boot 2010.06 `product/hiosd/vo/hi3519/vou_reg.h` (GPL-2.0 U-Boot tree, HiSilicon copyright, created 2015-05-26; mirror github.com/OpenIPC/u-boot-hi3516cv200), union `U_G0_CMASK`, struct offset 0x603C (GPL-2.0, same-chip vendor header, byte-identical for Hi3516A V200 and Hi3519 V101). Reset value and access type unknown (modelled RW, no reset). Confidence: medium (vendor header for this chip family, not hardware verified).";

        field {
            name = "kmsk_r";
            desc = "[inferred] Kmsk r. (vendor header `product/hiosd/vo/hi3519/vou_reg.h` field `kmsk_r`; access and reset unknown, modelled RW)";
            sw = rw;
            hw = r;
        } kmsk_r[23:16];

        field {
            name = "kmsk_g";
            desc = "[inferred] Kmsk g. (vendor header `product/hiosd/vo/hi3519/vou_reg.h` field `kmsk_g`; access and reset unknown, modelled RW)";
            sw = rw;
            hw = r;
        } kmsk_g[15:8];

        field {
            name = "kmsk_b";
            desc = "[inferred] Kmsk b. (vendor header `product/hiosd/vo/hi3519/vou_reg.h` field `kmsk_b`; access and reset unknown, modelled RW)";
            sw = rw;
            hw = r;
        } kmsk_b[7:0];
    } G0_CMASK @ 0x603C;

    reg {
        name = "G0 PARAADDR";
        desc = "[inferred] G0 PARAADDR. Not in the data sheet. Source: vendor U-Boot 2010.06 `product/hiosd/vo/hi3519/vou_reg.h` (GPL-2.0 U-Boot tree, HiSilicon copyright, created 2015-05-26; mirror github.com/OpenIPC/u-boot-hi3516cv200), union `U_G0_PARAADDR`, struct offset 0x6040 (GPL-2.0, same-chip vendor header, byte-identical for Hi3516A V200 and Hi3519 V101). Reset value and access type unknown (modelled RW, no reset). Confidence: medium (vendor header for this chip family, not hardware verified).";

        field {
            name = "surface_addr";
            desc = "[inferred] Surface address. (vendor header `product/hiosd/vo/hi3519/vou_reg.h` field `surface_addr`; access and reset unknown, modelled RW)";
            sw = rw;
            hw = r;
        } surface_addr[31:0];
    } G0_PARAADDR @ 0x6040;

    reg {
        name = "G0 PARAUP";
        desc = "[inferred] G0 PARAUP. Not in the data sheet. Source: vendor U-Boot 2010.06 `product/hiosd/vo/hi3519/vou_reg.h` (GPL-2.0 U-Boot tree, HiSilicon copyright, created 2015-05-26; mirror github.com/OpenIPC/u-boot-hi3516cv200), union `U_G0_PARAUP`, struct offset 0x6044 (GPL-2.0, same-chip vendor header, byte-identical for Hi3516A V200 and Hi3519 V101). Reset value and access type unknown (modelled RW, no reset). Confidence: medium (vendor header for this chip family, not hardware verified).";

        field {
            name = "gdc_paraup";
            desc = "[inferred] Gdc paraup. (vendor header `product/hiosd/vo/hi3519/vou_reg.h` field `gdc_paraup`; access and reset unknown, modelled RW)";
            sw = rw;
            hw = r;
        } gdc_paraup[0:0];
    } G0_PARAUP @ 0x6044;

    reg {
        name = "G0 decompression address";
        desc = "[inferred] G0 decompression address. Not in the data sheet. Source: vendor U-Boot 2010.06 `product/hiosd/vo/hi3519/vou_reg.h` (GPL-2.0 U-Boot tree, HiSilicon copyright, created 2015-05-26; mirror github.com/OpenIPC/u-boot-hi3516cv200), union `U_G0_DCMP_ADDR`, struct offset 0x6050 (GPL-2.0, same-chip vendor header, byte-identical for Hi3516A V200 and Hi3519 V101). Reset value and access type unknown (modelled RW, no reset). Confidence: medium (vendor header for this chip family, not hardware verified).";

        field {
            name = "surface_addr";
            desc = "[inferred] Surface address. (vendor header `product/hiosd/vo/hi3519/vou_reg.h` field `surface_addr`; access and reset unknown, modelled RW)";
            sw = rw;
            hw = r;
        } surface_addr[31:0];
    } G0_DCMP_ADDR @ 0x6050;

    reg {
        name = "G0 decompression NADDR";
        desc = "[inferred] G0 decompression NADDR. Not in the data sheet. Source: vendor U-Boot 2010.06 `product/hiosd/vo/hi3519/vou_reg.h` (GPL-2.0 U-Boot tree, HiSilicon copyright, created 2015-05-26; mirror github.com/OpenIPC/u-boot-hi3516cv200), union `U_G0_DCMP_NADDR`, struct offset 0x6054 (GPL-2.0, same-chip vendor header, byte-identical for Hi3516A V200 and Hi3519 V101). Reset value and access type unknown (modelled RW, no reset). Confidence: medium (vendor header for this chip family, not hardware verified).";

        field {
            name = "surface_addr";
            desc = "[inferred] Surface address. (vendor header `product/hiosd/vo/hi3519/vou_reg.h` field `surface_addr`; access and reset unknown, modelled RW)";
            sw = rw;
            hw = r;
        } surface_addr[31:0];
    } G0_DCMP_NADDR @ 0x6054;

    reg {
        name = "G0 decompression OFFSET";
        desc = "[inferred] G0 decompression OFFSET. Not in the data sheet. Source: vendor U-Boot 2010.06 `product/hiosd/vo/hi3519/vou_reg.h` (GPL-2.0 U-Boot tree, HiSilicon copyright, created 2015-05-26; mirror github.com/OpenIPC/u-boot-hi3516cv200), union `U_G0_DCMP_OFFSET`, struct offset 0x6058 (GPL-2.0, same-chip vendor header, byte-identical for Hi3516A V200 and Hi3519 V101). Reset value and access type unknown (modelled RW, no reset). Confidence: medium (vendor header for this chip family, not hardware verified).";

        field {
            name = "offset";
            desc = "[inferred] Offset. (vendor header `product/hiosd/vo/hi3519/vou_reg.h` field `offset`; access and reset unknown, modelled RW)";
            sw = rw;
            hw = r;
        } offset[31:0];
    } G0_DCMP_OFFSET @ 0x6058;

    reg {
        name = "G0 DFPOS";
        desc = "[inferred] G0 DFPOS. Not in the data sheet. Source: vendor U-Boot 2010.06 `product/hiosd/vo/hi3519/vou_reg.h` (GPL-2.0 U-Boot tree, HiSilicon copyright, created 2015-05-26; mirror github.com/OpenIPC/u-boot-hi3516cv200), union `U_G0_DFPOS`, struct offset 0x6080 (GPL-2.0, same-chip vendor header, byte-identical for Hi3516A V200 and Hi3519 V101). Reset value and access type unknown (modelled RW, no reset). Confidence: medium (vendor header for this chip family, not hardware verified).";

        field {
            name = "disp_yfpos";
            desc = "[inferred] Disp yfpos. (vendor header `product/hiosd/vo/hi3519/vou_reg.h` field `disp_yfpos`; access and reset unknown, modelled RW)";
            sw = rw;
            hw = r;
        } disp_yfpos[23:12];

        field {
            name = "disp_xfpos";
            desc = "[inferred] Disp xfpos. (vendor header `product/hiosd/vo/hi3519/vou_reg.h` field `disp_xfpos`; access and reset unknown, modelled RW)";
            sw = rw;
            hw = r;
        } disp_xfpos[11:0];
    } G0_DFPOS @ 0x6080;

    reg {
        name = "G0 DLPOS";
        desc = "[inferred] G0 DLPOS. Not in the data sheet. Source: vendor U-Boot 2010.06 `product/hiosd/vo/hi3519/vou_reg.h` (GPL-2.0 U-Boot tree, HiSilicon copyright, created 2015-05-26; mirror github.com/OpenIPC/u-boot-hi3516cv200), union `U_G0_DLPOS`, struct offset 0x6084 (GPL-2.0, same-chip vendor header, byte-identical for Hi3516A V200 and Hi3519 V101). Reset value and access type unknown (modelled RW, no reset). Confidence: medium (vendor header for this chip family, not hardware verified).";

        field {
            name = "disp_ylpos";
            desc = "[inferred] Disp ylpos. (vendor header `product/hiosd/vo/hi3519/vou_reg.h` field `disp_ylpos`; access and reset unknown, modelled RW)";
            sw = rw;
            hw = r;
        } disp_ylpos[23:12];

        field {
            name = "disp_xlpos";
            desc = "[inferred] Disp xlpos. (vendor header `product/hiosd/vo/hi3519/vou_reg.h` field `disp_xlpos`; access and reset unknown, modelled RW)";
            sw = rw;
            hw = r;
        } disp_xlpos[11:0];
    } G0_DLPOS @ 0x6084;

    reg {
        name = "G0 VFPOS";
        desc = "[inferred] G0 VFPOS. Not in the data sheet. Source: vendor U-Boot 2010.06 `product/hiosd/vo/hi3519/vou_reg.h` (GPL-2.0 U-Boot tree, HiSilicon copyright, created 2015-05-26; mirror github.com/OpenIPC/u-boot-hi3516cv200), union `U_G0_VFPOS`, struct offset 0x6088 (GPL-2.0, same-chip vendor header, byte-identical for Hi3516A V200 and Hi3519 V101). Reset value and access type unknown (modelled RW, no reset). Confidence: medium (vendor header for this chip family, not hardware verified).";

        field {
            name = "video_yfpos";
            desc = "[inferred] Video yfpos. (vendor header `product/hiosd/vo/hi3519/vou_reg.h` field `video_yfpos`; access and reset unknown, modelled RW)";
            sw = rw;
            hw = r;
        } video_yfpos[23:12];

        field {
            name = "video_xfpos";
            desc = "[inferred] Video xfpos. (vendor header `product/hiosd/vo/hi3519/vou_reg.h` field `video_xfpos`; access and reset unknown, modelled RW)";
            sw = rw;
            hw = r;
        } video_xfpos[11:0];
    } G0_VFPOS @ 0x6088;

    reg {
        name = "G0 VLPOS";
        desc = "[inferred] G0 VLPOS. Not in the data sheet. Source: vendor U-Boot 2010.06 `product/hiosd/vo/hi3519/vou_reg.h` (GPL-2.0 U-Boot tree, HiSilicon copyright, created 2015-05-26; mirror github.com/OpenIPC/u-boot-hi3516cv200), union `U_G0_VLPOS`, struct offset 0x608C (GPL-2.0, same-chip vendor header, byte-identical for Hi3516A V200 and Hi3519 V101). Reset value and access type unknown (modelled RW, no reset). Confidence: medium (vendor header for this chip family, not hardware verified).";

        field {
            name = "video_ylpos";
            desc = "[inferred] Video ylpos. (vendor header `product/hiosd/vo/hi3519/vou_reg.h` field `video_ylpos`; access and reset unknown, modelled RW)";
            sw = rw;
            hw = r;
        } video_ylpos[23:12];

        field {
            name = "video_xlpos";
            desc = "[inferred] Video xlpos. (vendor header `product/hiosd/vo/hi3519/vou_reg.h` field `video_xlpos`; access and reset unknown, modelled RW)";
            sw = rw;
            hw = r;
        } video_xlpos[11:0];
    } G0_VLPOS @ 0x608C;

    reg {
        name = "G0 background";
        desc = "[inferred] G0 background. Not in the data sheet. Source: vendor U-Boot 2010.06 `product/hiosd/vo/hi3519/vou_reg.h` (GPL-2.0 U-Boot tree, HiSilicon copyright, created 2015-05-26; mirror github.com/OpenIPC/u-boot-hi3516cv200), union `U_G0_BK`, struct offset 0x6090 (GPL-2.0, same-chip vendor header, byte-identical for Hi3516A V200 and Hi3519 V101). Reset value and access type unknown (modelled RW, no reset). Confidence: medium (vendor header for this chip family, not hardware verified).";

        field {
            name = "vbk_y";
            desc = "[inferred] Vbk y. (vendor header `product/hiosd/vo/hi3519/vou_reg.h` field `vbk_y`; access and reset unknown, modelled RW)";
            sw = rw;
            hw = r;
        } vbk_y[29:20];

        field {
            name = "vbk_cb";
            desc = "[inferred] Vbk cb. (vendor header `product/hiosd/vo/hi3519/vou_reg.h` field `vbk_cb`; access and reset unknown, modelled RW)";
            sw = rw;
            hw = r;
        } vbk_cb[19:10];

        field {
            name = "vbk_cr";
            desc = "[inferred] Vbk cr. (vendor header `product/hiosd/vo/hi3519/vou_reg.h` field `vbk_cr`; access and reset unknown, modelled RW)";
            sw = rw;
            hw = r;
        } vbk_cr[9:0];
    } G0_BK @ 0x6090;

    reg {
        name = "G0 alpha";
        desc = "[inferred] G0 alpha. Not in the data sheet. Source: vendor U-Boot 2010.06 `product/hiosd/vo/hi3519/vou_reg.h` (GPL-2.0 U-Boot tree, HiSilicon copyright, created 2015-05-26; mirror github.com/OpenIPC/u-boot-hi3516cv200), union `U_G0_ALPHA`, struct offset 0x6094 (GPL-2.0, same-chip vendor header, byte-identical for Hi3516A V200 and Hi3519 V101). Reset value and access type unknown (modelled RW, no reset). Confidence: medium (vendor header for this chip family, not hardware verified).";

        field {
            name = "vbk_alpha";
            desc = "[inferred] Vbk alpha. (vendor header `product/hiosd/vo/hi3519/vou_reg.h` field `vbk_alpha`; access and reset unknown, modelled RW)";
            sw = rw;
            hw = r;
        } vbk_alpha[7:0];
    } G0_ALPHA @ 0x6094;

    reg {
        name = "G0 DOF control";
        desc = "[inferred] G0 DOF control. Not in the data sheet. Source: vendor U-Boot 2010.06 `product/hiosd/vo/hi3519/vou_reg.h` (GPL-2.0 U-Boot tree, HiSilicon copyright, created 2015-05-26; mirror github.com/OpenIPC/u-boot-hi3516cv200), union `U_G0_DOF_CTRL`, struct offset 0x60A0 (GPL-2.0, same-chip vendor header, byte-identical for Hi3516A V200 and Hi3519 V101). Reset value and access type unknown (modelled RW, no reset). Confidence: medium (vendor header for this chip family, not hardware verified).";

        field {
            name = "dof_en";
            desc = "[inferred] Dof enable. (vendor header `product/hiosd/vo/hi3519/vou_reg.h` field `dof_en`; access and reset unknown, modelled RW)";
            sw = rw;
            hw = r;
        } dof_en[31:31];
    } G0_DOF_CTRL @ 0x60A0;

    reg {
        name = "G0 DOF STEP";
        desc = "[inferred] G0 DOF STEP. Not in the data sheet. Source: vendor U-Boot 2010.06 `product/hiosd/vo/hi3519/vou_reg.h` (GPL-2.0 U-Boot tree, HiSilicon copyright, created 2015-05-26; mirror github.com/OpenIPC/u-boot-hi3516cv200), union `U_G0_DOF_STEP`, struct offset 0x60A4 (GPL-2.0, same-chip vendor header, byte-identical for Hi3516A V200 and Hi3519 V101). Reset value and access type unknown (modelled RW, no reset). Confidence: medium (vendor header for this chip family, not hardware verified).";

        field {
            name = "right_step";
            desc = "[inferred] Right step. (vendor header `product/hiosd/vo/hi3519/vou_reg.h` field `right_step`; access and reset unknown, modelled RW)";
            sw = rw;
            hw = r;
        } right_step[15:8];

        field {
            name = "left_step";
            desc = "[inferred] Left step. (vendor header `product/hiosd/vo/hi3519/vou_reg.h` field `left_step`; access and reset unknown, modelled RW)";
            sw = rw;
            hw = r;
        } left_step[7:0];
    } G0_DOF_STEP @ 0x60A4;

    reg {
        name = "G0 colour-space conversion IDC";
        desc = "[inferred] G0 colour-space conversion IDC. Not in the data sheet. Source: vendor U-Boot 2010.06 `product/hiosd/vo/hi3519/vou_reg.h` (GPL-2.0 U-Boot tree, HiSilicon copyright, created 2015-05-26; mirror github.com/OpenIPC/u-boot-hi3516cv200), union `U_G0_CSC_IDC`, struct offset 0x60C0 (GPL-2.0, same-chip vendor header, byte-identical for Hi3516A V200 and Hi3519 V101). Reset value and access type unknown (modelled RW, no reset). Confidence: medium (vendor header for this chip family, not hardware verified).";

        field {
            name = "csc_mode";
            desc = "[inferred] Colour-space conversion mode. (vendor header `product/hiosd/vo/hi3519/vou_reg.h` field `csc_mode`; access and reset unknown, modelled RW)";
            sw = rw;
            hw = r;
        } csc_mode[25:23];

        field {
            name = "csc_en";
            desc = "[inferred] Colour-space conversion enable. (vendor header `product/hiosd/vo/hi3519/vou_reg.h` field `csc_en`; access and reset unknown, modelled RW)";
            sw = rw;
            hw = r;
        } csc_en[22:22];

        field {
            name = "cscidc1";
            desc = "[inferred] Cscidc1. (vendor header `product/hiosd/vo/hi3519/vou_reg.h` field `cscidc1`; access and reset unknown, modelled RW)";
            sw = rw;
            hw = r;
        } cscidc1[21:11];

        field {
            name = "cscidc0";
            desc = "[inferred] Cscidc0. (vendor header `product/hiosd/vo/hi3519/vou_reg.h` field `cscidc0`; access and reset unknown, modelled RW)";
            sw = rw;
            hw = r;
        } cscidc0[10:0];
    } G0_CSC_IDC @ 0x60C0;

    reg {
        name = "G0 colour-space conversion ODC";
        desc = "[inferred] G0 colour-space conversion ODC. Not in the data sheet. Source: vendor U-Boot 2010.06 `product/hiosd/vo/hi3519/vou_reg.h` (GPL-2.0 U-Boot tree, HiSilicon copyright, created 2015-05-26; mirror github.com/OpenIPC/u-boot-hi3516cv200), union `U_G0_CSC_ODC`, struct offset 0x60C4 (GPL-2.0, same-chip vendor header, byte-identical for Hi3516A V200 and Hi3519 V101). Reset value and access type unknown (modelled RW, no reset). Confidence: medium (vendor header for this chip family, not hardware verified).";

        field {
            name = "csc_sign_mode";
            desc = "[inferred] Colour-space conversion sign mode. (vendor header `product/hiosd/vo/hi3519/vou_reg.h` field `csc_sign_mode`; access and reset unknown, modelled RW)";
            sw = rw;
            hw = r;
        } csc_sign_mode[22:22];

        field {
            name = "cscodc1";
            desc = "[inferred] Cscodc1. (vendor header `product/hiosd/vo/hi3519/vou_reg.h` field `cscodc1`; access and reset unknown, modelled RW)";
            sw = rw;
            hw = r;
        } cscodc1[21:11];

        field {
            name = "cscodc0";
            desc = "[inferred] Cscodc0. (vendor header `product/hiosd/vo/hi3519/vou_reg.h` field `cscodc0`; access and reset unknown, modelled RW)";
            sw = rw;
            hw = r;
        } cscodc0[10:0];
    } G0_CSC_ODC @ 0x60C4;

    reg {
        name = "G0 colour-space conversion IODC";
        desc = "[inferred] G0 colour-space conversion IODC. Not in the data sheet. Source: vendor U-Boot 2010.06 `product/hiosd/vo/hi3519/vou_reg.h` (GPL-2.0 U-Boot tree, HiSilicon copyright, created 2015-05-26; mirror github.com/OpenIPC/u-boot-hi3516cv200), union `U_G0_CSC_IODC`, struct offset 0x60C8 (GPL-2.0, same-chip vendor header, byte-identical for Hi3516A V200 and Hi3519 V101). Reset value and access type unknown (modelled RW, no reset). Confidence: medium (vendor header for this chip family, not hardware verified).";

        field {
            name = "cscodc2";
            desc = "[inferred] Cscodc2. (vendor header `product/hiosd/vo/hi3519/vou_reg.h` field `cscodc2`; access and reset unknown, modelled RW)";
            sw = rw;
            hw = r;
        } cscodc2[21:11];

        field {
            name = "cscidc2";
            desc = "[inferred] Cscidc2. (vendor header `product/hiosd/vo/hi3519/vou_reg.h` field `cscidc2`; access and reset unknown, modelled RW)";
            sw = rw;
            hw = r;
        } cscidc2[10:0];
    } G0_CSC_IODC @ 0x60C8;

    reg {
        name = "G0 colour-space conversion P0";
        desc = "[inferred] G0 colour-space conversion P0. Not in the data sheet. Source: vendor U-Boot 2010.06 `product/hiosd/vo/hi3519/vou_reg.h` (GPL-2.0 U-Boot tree, HiSilicon copyright, created 2015-05-26; mirror github.com/OpenIPC/u-boot-hi3516cv200), union `U_G0_CSC_P0`, struct offset 0x60CC (GPL-2.0, same-chip vendor header, byte-identical for Hi3516A V200 and Hi3519 V101). Reset value and access type unknown (modelled RW, no reset). Confidence: medium (vendor header for this chip family, not hardware verified).";

        field {
            name = "cscp01";
            desc = "[inferred] Cscp01. (vendor header `product/hiosd/vo/hi3519/vou_reg.h` field `cscp01`; access and reset unknown, modelled RW)";
            sw = rw;
            hw = r;
        } cscp01[30:16];

        field {
            name = "cscp00";
            desc = "[inferred] Cscp00. (vendor header `product/hiosd/vo/hi3519/vou_reg.h` field `cscp00`; access and reset unknown, modelled RW)";
            sw = rw;
            hw = r;
        } cscp00[14:0];
    } G0_CSC_P0 @ 0x60CC;

    reg {
        name = "G0 colour-space conversion P1";
        desc = "[inferred] G0 colour-space conversion P1. Not in the data sheet. Source: vendor U-Boot 2010.06 `product/hiosd/vo/hi3519/vou_reg.h` (GPL-2.0 U-Boot tree, HiSilicon copyright, created 2015-05-26; mirror github.com/OpenIPC/u-boot-hi3516cv200), union `U_G0_CSC_P1`, struct offset 0x60D0 (GPL-2.0, same-chip vendor header, byte-identical for Hi3516A V200 and Hi3519 V101). Reset value and access type unknown (modelled RW, no reset). Confidence: medium (vendor header for this chip family, not hardware verified).";

        field {
            name = "cscp10";
            desc = "[inferred] Cscp10. (vendor header `product/hiosd/vo/hi3519/vou_reg.h` field `cscp10`; access and reset unknown, modelled RW)";
            sw = rw;
            hw = r;
        } cscp10[30:16];

        field {
            name = "cscp02";
            desc = "[inferred] Cscp02. (vendor header `product/hiosd/vo/hi3519/vou_reg.h` field `cscp02`; access and reset unknown, modelled RW)";
            sw = rw;
            hw = r;
        } cscp02[14:0];
    } G0_CSC_P1 @ 0x60D0;

    reg {
        name = "G0 colour-space conversion P2";
        desc = "[inferred] G0 colour-space conversion P2. Not in the data sheet. Source: vendor U-Boot 2010.06 `product/hiosd/vo/hi3519/vou_reg.h` (GPL-2.0 U-Boot tree, HiSilicon copyright, created 2015-05-26; mirror github.com/OpenIPC/u-boot-hi3516cv200), union `U_G0_CSC_P2`, struct offset 0x60D4 (GPL-2.0, same-chip vendor header, byte-identical for Hi3516A V200 and Hi3519 V101). Reset value and access type unknown (modelled RW, no reset). Confidence: medium (vendor header for this chip family, not hardware verified).";

        field {
            name = "cscp12";
            desc = "[inferred] Cscp12. (vendor header `product/hiosd/vo/hi3519/vou_reg.h` field `cscp12`; access and reset unknown, modelled RW)";
            sw = rw;
            hw = r;
        } cscp12[30:16];

        field {
            name = "cscp11";
            desc = "[inferred] Cscp11. (vendor header `product/hiosd/vo/hi3519/vou_reg.h` field `cscp11`; access and reset unknown, modelled RW)";
            sw = rw;
            hw = r;
        } cscp11[14:0];
    } G0_CSC_P2 @ 0x60D4;

    reg {
        name = "G0 colour-space conversion P3";
        desc = "[inferred] G0 colour-space conversion P3. Not in the data sheet. Source: vendor U-Boot 2010.06 `product/hiosd/vo/hi3519/vou_reg.h` (GPL-2.0 U-Boot tree, HiSilicon copyright, created 2015-05-26; mirror github.com/OpenIPC/u-boot-hi3516cv200), union `U_G0_CSC_P3`, struct offset 0x60D8 (GPL-2.0, same-chip vendor header, byte-identical for Hi3516A V200 and Hi3519 V101). Reset value and access type unknown (modelled RW, no reset). Confidence: medium (vendor header for this chip family, not hardware verified).";

        field {
            name = "cscp21";
            desc = "[inferred] Cscp21. (vendor header `product/hiosd/vo/hi3519/vou_reg.h` field `cscp21`; access and reset unknown, modelled RW)";
            sw = rw;
            hw = r;
        } cscp21[30:16];

        field {
            name = "cscp20";
            desc = "[inferred] Cscp20. (vendor header `product/hiosd/vo/hi3519/vou_reg.h` field `cscp20`; access and reset unknown, modelled RW)";
            sw = rw;
            hw = r;
        } cscp20[14:0];
    } G0_CSC_P3 @ 0x60D8;

    reg {
        name = "G0 colour-space conversion P4";
        desc = "[inferred] G0 colour-space conversion P4. Not in the data sheet. Source: vendor U-Boot 2010.06 `product/hiosd/vo/hi3519/vou_reg.h` (GPL-2.0 U-Boot tree, HiSilicon copyright, created 2015-05-26; mirror github.com/OpenIPC/u-boot-hi3516cv200), union `U_G0_CSC_P4`, struct offset 0x60DC (GPL-2.0, same-chip vendor header, byte-identical for Hi3516A V200 and Hi3519 V101). Reset value and access type unknown (modelled RW, no reset). Confidence: medium (vendor header for this chip family, not hardware verified).";

        field {
            name = "cscp22";
            desc = "[inferred] Cscp22. (vendor header `product/hiosd/vo/hi3519/vou_reg.h` field `cscp22`; access and reset unknown, modelled RW)";
            sw = rw;
            hw = r;
        } cscp22[14:0];
    } G0_CSC_P4 @ 0x60DC;

    reg {
        name = "G2 configuration register";
        desc = "G2_CTR is a G2 configuration register (non-instant register). Hi3516A V200 Professional HD IP Camera SoC

Data sheet 9.2.6 G2_CTRL (offset 0x7000, printed page 9-113, `hi3516av200--Hi3516AV200-Datasheet.txt` line 43757).";

        enum G2_CTRL_surface_en_enum {
            DISABLED = 0 { name = "Disabled"; desc = "disabled"; };
            ENABLED = 1 { name = "Enabled"; desc = "enabled"; };
        };

        field {
            name = "surface_en";
            desc = "Surface enable (non-instant)";
            sw = rw;
            hw = r;
            encode = G2_CTRL_surface_en_enum;
            reset = 0x0;
        } surface_en[31:31];

        enum G2_CTRL_nosec_flag_enum {
            SECURITY_ATTRIBUTE = 0 { name = "Security Attribute"; desc = "security attribute"; };
            NON_SECURITY_ATTRIBUTE = 1 { name = "Non Security Attribute"; desc = "non-security attribute"; };
        };

        field {
            name = "nosec_flag";
            desc = "Operation security attribute flag for the bus interface";
            sw = rw;
            hw = r;
            encode = G2_CTRL_nosec_flag_enum;
            reset = 0x1;
        } nosec_flag[30:30];

        enum G2_CTRL_upd_mode_enum {
            UPDATE_FAME = 0 { name = "Update Fame"; desc = "update by fame"; };
            UPDATE_FIELD = 1 { name = "Update Field"; desc = "update by field"; };
        };

        field {
            name = "upd_mode";
            desc = "Update mode";
            sw = rw;
            hw = r;
            encode = G2_CTRL_upd_mode_enum;
            reset = 0x0;
        } upd_mode[27:27];

        enum G2_CTRL_read_mode_enum {
            READ_MODE_AUTOMATICALLY = 0 { name = "Read Mode Automatically"; desc = "The read mode is automatically selected based on the interface read mode. That is, the progressive read mode is selected in progressive display mode, and the interlaced read mode is selected in interlaced display mode."; };
            PROGRESSIVE_READ_MODE = 1 { name = "Progressive Read Mode"; desc = "The progressive read mode is selected forcibly."; };
        };

        field {
            name = "read_mode";
            desc = "Data read mode";
            sw = rw;
            hw = r;
            encode = G2_CTRL_read_mode_enum;
            reset = 0x0;
        } read_mode[26:26];

        enum G2_CTRL_precharge_en_enum {
            DISABLED = 0 { name = "Disabled"; desc = "disabled"; };
            ENABLED = 1 { name = "Enabled"; desc = "enabled"; };
        };

        field {
            name = "precharge_en";
            desc = "Pre-charge enable. This field is valid when the precharge_mode field is 1 (software mode).";
            sw = rw;
            hw = r;
            encode = G2_CTRL_precharge_en_enum;
            reset = 0x0;
        } precharge_en[21:21];

        enum G2_CTRL_precharge_mode_enum {
            HARDWARE_MODE_HARDWARE = 0 { name = "Hardware Mode Hardware"; desc = "hardware mode. Hardware automatically enters the pre-charge status on the frame trailer."; };
            SOFTWARE_MODE_SOFTWARE = 1 { name = "Software Mode Software"; desc = "software mode. Software controls whether to enter or exit the pre-charge status."; };
        };

        field {
            name = "precharge_mode";
            desc = "Pre-charge mode of the FDR FIFO";
            sw = rw;
            hw = r;
            encode = G2_CTRL_precharge_mode_enum;
            reset = 0x0;
        } precharge_mode[20:20];

        enum G2_CTRL_bitext_enum {
            EXTEND_0S_LOWER = 0 { name = "Extend 0S Lower"; desc = "extend 0s to lower bits"; };
            EXTEND_VALUE_MSB = 2 { name = "Extend Value Msb"; desc = "extend the value of the MSB to a lower bit"; };
            EXTEND_VALUES_UPPER = 3 { name = "Extend Values Upper"; desc = "extend the values of upper bits to lower bits"; };
        };

        field {
            name = "bitext";
            desc = "Bit extend mode of the input bitmap";
            sw = rw;
            hw = r;
            encode = G2_CTRL_bitext_enum;
            reset = 0x0;
        } bitext[9:8];

        enum G2_CTRL_ifmt_enum {
            ARGB4444 = 0x48 { name = "Argb4444"; desc = "ARGB4444"; };
            ARGB1555_OTHER_VALUES = 0x49 { name = "Argb1555 Other Values"; desc = "ARGB1555 Other values: reserved"; };
        };

        field {
            name = "ifmt";
            desc = "Format of the input data";
            sw = rw;
            hw = r;
            encode = G2_CTRL_ifmt_enum;
            reset = 0x0;
        } ifmt[7:0];
    } G2_CTRL @ 0x7000;

    reg {
        name = "G2 update enable register";
        desc = "G2_UPD is a G2 update enable register.

Data sheet 9.2.6 G2_UPD (offset 0x7004, printed page 9-114, `hi3516av200--Hi3516AV200-Datasheet.txt` line 43832).";

        field {
            name = "regup";
            desc = "Surface register update. After the registers at this layer are configured, the registers are updated when the value 1 is written to this bit. After updates, this bit is automatically cleared by the hardware.";
            sw = w;
            hw = r;
            reset = 0x0;
        } regup[0:0];
    } G2_UPD @ 0x7004;

    reg {
        name = "G2 address register";
        desc = "G2_ADDR is a G2 address register. When the horizontal pixel offsets, the address is calculated by following the description of G2_SFPOS. Hi3516A V200 Professional HD IP Camera SoC

Data sheet 9.2.6 G2_ADDR (offset 0x7010, printed page 9-115, `hi3516av200--Hi3516AV200-Datasheet.txt` line 43868).";

        field {
            name = "surface_addr";
            desc = "Address for the surface frame buffer";
            sw = rw;
            hw = r;
            reset = 0x0;
        } surface_addr[31:0];
    } G2_ADDR @ 0x7010;

    reg {
        name = "G2 stride register";
        desc = "G2_STRIDE is a G2 stride register.

Data sheet 9.2.6 G2_STRIDE (offset 0x701C, printed page 9-115, `hi3516av200--Hi3516AV200-Datasheet.txt` line 43886).";

        field {
            name = "surface_stride";
            desc = "Frame buffer stride";
            sw = rw;
            hw = r;
            reset = 0x0;
        } surface_stride[15:0];
    } G2_STRIDE @ 0x701C;

    reg {
        name = "G2 input resolution register";
        desc = "G2_IRESO is a G2 input resolution register (non-instant register).

Data sheet 9.2.6 G2_IRESO (offset 0x7020, printed page 9-115, `hi3516av200--Hi3516AV200-Datasheet.txt` line 43906).";

        field {
            name = "ih";
            desc = "Height (in line). The configured value is the actual height minus 1. Note: In interlaced output mode, the actual layer height must be an even number. There is no such limitation in progressive output mode.";
            sw = rw;
            hw = r;
            reset = 0x0;
        } ih[23:12];

        field {
            name = "iw";
            desc = "Width (in pixel). The configured value is the actual width minus 1. Note: The actual layer width must be an even number.";
            sw = rw;
            hw = r;
            reset = 0x0;
        } iw[11:0];
    } G2_IRESO @ 0x7020;

    reg {
        name = "G2 surface read data start position (in the source bitmap) register";
        desc = "G2 surface read data start position (in the source bitmap) register.

Data sheet 9.2.6 G2_SFPOS (offset 0x7024, printed page 9-116, `hi3516av200--Hi3516AV200-Datasheet.txt` line 43953).";

        field {
            name = "src_xfpos";
            desc = "Start horizontal coordinate of the source image. The value 0 indicates the first pixel of a line.";
            sw = rw;
            hw = r;
            reset = 0x0;
        } src_xfpos[6:0];
    } G2_SFPOS @ 0x7024;

    reg {
        name = "Overlay parameter register A";
        desc = "G2_CBMPARA is a G2 overlay parameter register (non-instant register). Hi3516A V200 Professional HD IP Camera SoC

Data sheet 9.2.6 G2_CBMPARA (offset 0x7030, printed page 9-117, `hi3516av200--Hi3516AV200-Datasheet.txt` line 43985).";

        enum G2_CBMPARA_key_mode_enum {
            COLOR_REGARDED_AS = 0 { name = "Color Regarded As"; desc = "The color is regarded as the color key when the following condition is met: Keymin <= Pixel <= Keymax"; };
            COLOR_REGARDED_AS_2 = 1 { name = "Color Regarded As 2"; desc = "The color is regarded as the color key when either of the following conditions is met: Pixel <= Keymin or Pixel >= Keymax"; };
        };

        field {
            name = "key_mode";
            desc = "Color key mode";
            sw = rw;
            hw = r;
            encode = G2_CBMPARA_key_mode_enum;
            reset = 0x0;
        } key_mode[15:15];

        enum G2_CBMPARA_key_en_enum {
            DISABLED = 0 { name = "Disabled"; desc = "disabled"; };
            ENABLED = 1 { name = "Enabled"; desc = "enabled"; };
        };

        field {
            name = "key_en";
            desc = "Color key enable";
            sw = rw;
            hw = r;
            encode = G2_CBMPARA_key_en_enum;
            reset = 0x0;
        } key_en[14:14];

        enum G2_CBMPARA_premult_en_enum {
            NON_PREMULTIPLIED_BITMAP = 0 { name = "Non Premultiplied Bitmap"; desc = "non-premultiplied bitmap"; };
            PREMULTIPLIED_BITMAP = 1 { name = "Premultiplied Bitmap"; desc = "premultiplied bitmap"; };
        };

        field {
            name = "premult_en";
            desc = "Whether the input bitmap is a premultiplied bitmap";
            sw = rw;
            hw = r;
            encode = G2_CBMPARA_premult_en_enum;
            reset = 0x0;
        } premult_en[13:13];

        enum G2_CBMPARA_palpha_en_enum {
            DISABLED = 0 { name = "Disabled"; desc = "disabled"; };
            ENABLED = 1 { name = "Enabled"; desc = "enabled"; };
        };

        field {
            name = "palpha_en";
            desc = "Pixel alpha enable";
            sw = rw;
            hw = r;
            encode = G2_CBMPARA_palpha_en_enum;
            reset = 0x0;
        } palpha_en[12:12];

        field {
            name = "galpha";
            desc = "Overlay global alpha value. The value ranges from 0 to 255. The value 255 indicates opaque, and the value 0 indicates completely transparent.";
            sw = rw;
            hw = r;
            reset = 0x0;
        } galpha[7:0];
    } G2_CBMPARA @ 0x7030;

    reg {
        name = "Maximum color key value register X";
        desc = "G2_CKEYMAX is a maximum color key value register (non-instant register). Hi3516A V200 Professional HD IP Camera SoC

Data sheet 9.2.6 G2_CKEYMAX (offset 0x7034, printed page 9-118, `hi3516av200--Hi3516AV200-Datasheet.txt` line 44039).";

        field {
            name = "va0";
            desc = "Alpha0 value. When the data format is alphaRGB1555 and the alpha value is 0, the alpha0 value is used.";
            sw = rw;
            hw = r;
            reset = 0x0;
        } va0[31:24];

        field {
            name = "keyr_max";
            desc = "Maximum value of the color key R component";
            sw = rw;
            hw = r;
            reset = 0x0;
        } keyr_max[23:16];

        field {
            name = "keyg_max";
            desc = "Maximum value of the color key G component";
            sw = rw;
            hw = r;
            reset = 0x0;
        } keyg_max[15:8];

        field {
            name = "keyb_max";
            desc = "Maximum value of the color key B component";
            sw = rw;
            hw = r;
            reset = 0x0;
        } keyb_max[7:0];
    } G2_CKEYMAX @ 0x7034;

    reg {
        name = "Minimum color key value register N";
        desc = "G2_CKEYMIN is a minimum color key value register (non-instant register).

Data sheet 9.2.6 G2_CKEYMIN (offset 0x7038, printed page 9-118, `hi3516av200--Hi3516AV200-Datasheet.txt` line 44062).";

        field {
            name = "va1";
            desc = "Alpha1 value. When the data format is alphaRGB1555 and the alpha value is 1, the alpha1 value is used.";
            sw = rw;
            hw = r;
            reset = 0x0;
        } va1[31:24];

        field {
            name = "keyr_min";
            desc = "Minimum value of the color key R component";
            sw = rw;
            hw = r;
            reset = 0x0;
        } keyr_min[23:16];

        field {
            name = "keyg_min";
            desc = "Minimum value of the color key G component";
            sw = rw;
            hw = r;
            reset = 0x0;
        } keyg_min[15:8];

        field {
            name = "keyb_min";
            desc = "Minimum value of the color key B component";
            sw = rw;
            hw = r;
            reset = 0x0;
        } keyb_min[7:0];
    } G2_CKEYMIN @ 0x7038;

    reg {
        name = "Color key mask value register";
        desc = "Color key mask value register.

Data sheet 9.2.6 G2_CMASK (offset 0x703C, printed page 9-119, `hi3516av200--Hi3516AV200-Datasheet.txt` line 44099).";

        field {
            name = "kmsk_r";
            desc = "R component of the masked color key";
            sw = rw;
            hw = r;
            reset = 0xFF;
        } kmsk_r[23:16];

        field {
            name = "kmsk_g";
            desc = "G component of the masked color key";
            sw = rw;
            hw = r;
            reset = 0xFF;
        } kmsk_g[15:8];

        field {
            name = "kmsk_b";
            desc = "B component of the masked color key";
            sw = rw;
            hw = r;
            reset = 0xFF;
        } kmsk_b[7:0];
    } G2_CMASK @ 0x703C;

    reg {
        name = "G2 surface start position (in the display window) register";
        desc = "G2_DFPOS is a G2 surface start position (in the display window) register (non-instant register). The position unit is pixel.

Data sheet 9.2.6 G2_DFPOS (offset 0x7080, printed page 9-119, `hi3516av200--Hi3516AV200-Datasheet.txt` line 44121).";

        field {
            name = "disp_yfpos";
            desc = "Column start coordinates";
            sw = rw;
            hw = r;
            reset = 0x0;
        } disp_yfpos[23:12];

        field {
            name = "disp_xfpos";
            desc = "Row start coordinates";
            sw = rw;
            hw = r;
            reset = 0x0;
        } disp_xfpos[11:0];
    } G2_DFPOS @ 0x7080;

    reg {
        name = "G2 surface end position (in the display window) register";
        desc = "G2_DLPOS is a G2 surface end position (in the display window) register (non-instant register). The position unit is pixel. Hi3516A V200 Professional HD IP Camera SoC

Data sheet 9.2.6 G2_DLPOS (offset 0x7084, printed page 9-120, `hi3516av200--Hi3516AV200-Datasheet.txt` line 44153).";

        field {
            name = "disp_ylpos";
            desc = "Column end coordinates";
            sw = rw;
            hw = r;
            reset = 0x0;
        } disp_ylpos[23:12];

        field {
            name = "disp_xlpos";
            desc = "Row end coordinates";
            sw = rw;
            hw = r;
            reset = 0x0;
        } disp_xlpos[11:0];
    } G2_DLPOS @ 0x7084;

    reg {
        name = "G2 CSC input DC component register";
        desc = "G2_CSC_IDC is a G2 CSC input DC component register (instant register).

Data sheet 9.2.6 G2_CSC_IDC (offset 0x70C0, printed page 9-120, `hi3516av200--Hi3516AV200-Datasheet.txt` line 44173).";

        enum G2_CSC_IDC_csc_mode_enum {
            RESERVED = 0 { name = "Reserved"; desc = "reserved"; };
            YUV2YUV = 1 { name = "Yuv2Yuv"; desc = "YUV2YUV"; };
            YUV601_RGB = 2 { name = "Yuv601 Rgb"; desc = "YUV601_RGB"; };
            YUV709_RGB = 3 { name = "Yuv709 Rgb"; desc = "YUV709_RGB"; };
            YUV2YUV_709_601 = 4 { name = "Yuv2Yuv 709 601"; desc = "YUV2YUV_709_601"; };
            YUV2YUV_601_709 = 5 { name = "Yuv2Yuv 601 709"; desc = "YUV2YUV_601_709"; };
            RGB2YUV_601 = 6 { name = "Rgb2Yuv 601"; desc = "RGB2YUV_601"; };
            RGB2YUV_709 = 7 { name = "Rgb2Yuv 709"; desc = "RGB2YUV_709"; };
        };

        field {
            name = "csc_mode";
            desc = "This field is valid only when the G2 CSC coefficients are fixed.";
            sw = rw;
            hw = r;
            encode = G2_CSC_IDC_csc_mode_enum;
            reset = 0x0;
        } csc_mode[25:23];

        enum G2_CSC_IDC_csc_en_enum {
            DISABLED = 0 { name = "Disabled"; desc = "disabled"; };
            ENABLED = 1 { name = "Enabled"; desc = "enabled"; };
        };

        field {
            name = "csc_en";
            desc = "CSC enable";
            sw = rw;
            hw = r;
            encode = G2_CSC_IDC_csc_en_enum;
            reset = 0x0;
        } csc_en[22:22];

        field {
            name = "cscidc1";
            desc = "DC parameter of the input U/G component. The MSB is the signed bit. The value is expressed as a two's complement.";
            sw = r;
            hw = w;
            reset = 0x0;
        } cscidc1[21:11];

        field {
            name = "cscidc0";
            desc = "DC parameter of the input V/B component. The MSB is the signed bit. The value is expressed as a two's complement.";
            sw = r;
            hw = w;
            reset = 0x0;
        } cscidc0[10:0];
    } G2_CSC_IDC @ 0x70C0;

    reg {
        name = "G2 CSC output DC component register";
        desc = "G2_CSC_ODC is a G2 CSC output DC component register (instant register).

Data sheet 9.2.6 G2_CSC_ODC (offset 0x70C4, printed page 9-121, `hi3516av200--Hi3516AV200-Datasheet.txt` line 44223).";

        enum G2_CSC_ODC_csc_sign_mode_enum {
            CSC_OUTPUT_10 = 0 { name = "Csc Output 10"; desc = "The CSC output is a 10-bit unsigned number."; };
            CSC_OUTPUT_12 = 1 { name = "Csc Output 12"; desc = "The CSC output is a 12-bit signed number."; };
        };

        field {
            name = "csc_sign_mode";
            desc = "CSC output mode";
            sw = r;
            hw = w;
            encode = G2_CSC_ODC_csc_sign_mode_enum;
            reset = 0x0;
        } csc_sign_mode[22:22];

        field {
            name = "cscodc1";
            desc = "DC parameter of the output U/G component. The MSB is the signed bit. The value is expressed as a two's complement.";
            sw = r;
            hw = w;
            reset = 0x0;
        } cscodc1[21:11];

        field {
            name = "cscodc0";
            desc = "DC parameter of the output Y/R component. The MSB is the signed bit. The value is expressed as a two's complement.";
            sw = r;
            hw = w;
            reset = 0x0;
        } cscodc0[10:0];
    } G2_CSC_ODC @ 0x70C4;

    reg {
        name = "G2 CSC input/output DC component C register";
        desc = "G2_CSC_IODC is a G2 CSC input/output DC component register (instant register).

Data sheet 9.2.6 G2_CSC_IODC (offset 0x70C8, printed page 9-121, `hi3516av200--Hi3516AV200-Datasheet.txt` line 44258).";

        field {
            name = "cscodc2";
            desc = "DC parameter of the output V/B component. The MSB is the signed bit. The value is expressed as a two's complement.";
            sw = r;
            hw = w;
            reset = 0x0;
        } cscodc2[21:11];

        field {
            name = "cscidc2";
            desc = "DC parameter of the input Y/R component. The MSB is the signed bit. The value is expressed as a two's complement.";
            sw = r;
            hw = w;
            reset = 0x0;
        } cscidc2[10:0];
    } G2_CSC_IODC @ 0x70C8;

    reg {
        name = "G2 CSC parameter 0 register";
        desc = "G2_CSC_P0 is a G2 CSC parameter 0 register (instant register).

Data sheet 9.2.6 G2_CSC_P0 (offset 0x70CC, printed page 9-122, `hi3516av200--Hi3516AV200-Datasheet.txt` line 44292).";

        field {
            name = "cscp01";
            desc = "5.10 data format that consists of a 1-bit sign part, a 4-bit integer part, and an 8-bit decimal part. The value is expressed as a two's complement.";
            sw = r;
            hw = w;
            reset = 0x0;
        } cscp01[30:16];

        field {
            name = "cscp00";
            desc = "5.10 data format that consists of a 1-bit sign part, a 4-bit integer part, and an 8-bit decimal part. The value is expressed as a two's complement.";
            sw = r;
            hw = w;
            reset = 0x0;
        } cscp00[14:0];
    } G2_CSC_P0 @ 0x70CC;

    reg {
        name = "G2 CSC parameter 1 register";
        desc = "G2_CSC_P1 is a G2 CSC parameter 1 register (instant register). Hi3516A V200 Professional HD IP Camera SoC

Data sheet 9.2.6 G2_CSC_P1 (offset 0x70D0, printed page 9-123, `hi3516av200--Hi3516AV200-Datasheet.txt` line 44332).";

        field {
            name = "cscp10";
            desc = "5.10 data format that consists of a 1-bit sign part, a 4-bit integer part, and an 8-bit decimal part. The value is expressed as a two's complement.";
            sw = r;
            hw = w;
            reset = 0x0;
        } cscp10[30:16];

        field {
            name = "cscp02";
            desc = "5.10 data format that consists of a 1-bit sign part, a 4-bit integer part, and an 8-bit decimal part. The value is expressed as a two's complement.";
            sw = r;
            hw = w;
            reset = 0x0;
        } cscp02[14:0];
    } G2_CSC_P1 @ 0x70D0;

    reg {
        name = "G2 CSC parameter 2 register";
        desc = "G2_CSC_P2 is a G2 CSC parameter 2 register (instant register).

Data sheet 9.2.6 G2_CSC_P2 (offset 0x70D4, printed page 9-123, `hi3516av200--Hi3516AV200-Datasheet.txt` line 44362).";

        field {
            name = "cscp12";
            desc = "5.10 data format that consists of a 1-bit sign part, a 4-bit integer part, and an 8-bit decimal part. The value is expressed as a two's complement.";
            sw = r;
            hw = w;
            reset = 0x0;
        } cscp12[30:16];

        field {
            name = "cscp11";
            desc = "5.10 data format that consists of a 1-bit sign part, a 4-bit integer part, and an 8-bit decimal part. The value is expressed as a two's complement.";
            sw = r;
            hw = w;
            reset = 0x0;
        } cscp11[14:0];
    } G2_CSC_P2 @ 0x70D4;

    reg {
        name = "G2 CSC parameter 3 register";
        desc = "G2_CSC_P3 is a G2 CSC parameter 3 register (instant register).

Data sheet 9.2.6 G2_CSC_P3 (offset 0x70D8, printed page 9-124, `hi3516av200--Hi3516AV200-Datasheet.txt` line 44395).";

        field {
            name = "cscp21";
            desc = "5.10 data format that consists of a 1-bit sign part, a 4-bit integer part, and an 8-bit decimal part. The value is expressed as a two's complement.";
            sw = r;
            hw = w;
            reset = 0x0;
        } cscp21[30:16];

        field {
            name = "cscp20";
            desc = "5.10 data format that consists of a 1-bit sign part, a 4-bit integer part, and an 8-bit decimal part. The value is expressed as a two's complement.";
            sw = r;
            hw = w;
            reset = 0x0;
        } cscp20[14:0];
    } G2_CSC_P3 @ 0x70D8;

    reg {
        name = "G2 CSC parameter 4 register";
        desc = "G2_CSC_P4 is a G2 CSC parameter 4 register (instant register).

Data sheet 9.2.6 G2_CSC_P4 (offset 0x70DC, printed page 9-124, `hi3516av200--Hi3516AV200-Datasheet.txt` line 44425).";

        field {
            name = "cscp22";
            desc = "5.10 data format that consists of a 1-bit sign part, a 4-bit integer part, and an 8-bit decimal part. The value is expressed as a two's complement.";
            sw = r;
            hw = w;
            reset = 0x0;
        } cscp22[14:0];
    } G2_CSC_P4 @ 0x70DC;

    reg {
        name = "GP0 control";
        desc = "[inferred] GP0 control. Not in the data sheet. Source: vendor U-Boot 2010.06 `product/hiosd/vo/hi3519/vou_reg.h` (GPL-2.0 U-Boot tree, HiSilicon copyright, created 2015-05-26; mirror github.com/OpenIPC/u-boot-hi3516cv200), union `U_GP0_CTRL`, struct offset 0x9000 (GPL-2.0, same-chip vendor header, byte-identical for Hi3516A V200 and Hi3519 V101). Reset value and access type unknown (modelled RW, no reset). Confidence: medium (vendor header for this chip family, not hardware verified).";

        field {
            name = "read_mode";
            desc = "[inferred] Read mode. (vendor header `product/hiosd/vo/hi3519/vou_reg.h` field `read_mode`; access and reset unknown, modelled RW)";
            sw = rw;
            hw = r;
        } read_mode[31:31];

        field {
            name = "mute_en";
            desc = "[inferred] Mute enable. (vendor header `product/hiosd/vo/hi3519/vou_reg.h` field `mute_en`; access and reset unknown, modelled RW)";
            sw = rw;
            hw = r;
        } mute_en[30:30];

        field {
            name = "ffc_sel";
            desc = "[inferred] Ffc select. (vendor header `product/hiosd/vo/hi3519/vou_reg.h` field `ffc_sel`; access and reset unknown, modelled RW)";
            sw = rw;
            hw = r;
        } ffc_sel[26:26];

        field {
            name = "bout_sel";
            desc = "[inferred] Bout select. (vendor header `product/hiosd/vo/hi3519/vou_reg.h` field `bout_sel`; access and reset unknown, modelled RW)";
            sw = rw;
            hw = r;
        } bout_sel[13:12];

        field {
            name = "aout_sel";
            desc = "[inferred] Aout select. (vendor header `product/hiosd/vo/hi3519/vou_reg.h` field `aout_sel`; access and reset unknown, modelled RW)";
            sw = rw;
            hw = r;
        } aout_sel[9:8];

        field {
            name = "mux2_sel";
            desc = "[inferred] Mux2 select. (vendor header `product/hiosd/vo/hi3519/vou_reg.h` field `mux2_sel`; access and reset unknown, modelled RW)";
            sw = rw;
            hw = r;
        } mux2_sel[5:4];

        field {
            name = "mux1_sel";
            desc = "[inferred] Mux1 select. (vendor header `product/hiosd/vo/hi3519/vou_reg.h` field `mux1_sel`; access and reset unknown, modelled RW)";
            sw = rw;
            hw = r;
        } mux1_sel[1:0];
    } GP0_CTRL @ 0x9000;

    reg {
        name = "GP0 update";
        desc = "[inferred] GP0 update. Not in the data sheet. Source: vendor U-Boot 2010.06 `product/hiosd/vo/hi3519/vou_reg.h` (GPL-2.0 U-Boot tree, HiSilicon copyright, created 2015-05-26; mirror github.com/OpenIPC/u-boot-hi3516cv200), union `U_GP0_UPD`, struct offset 0x9004 (GPL-2.0, same-chip vendor header, byte-identical for Hi3516A V200 and Hi3519 V101). Reset value and access type unknown (modelled RW, no reset). Confidence: medium (vendor header for this chip family, not hardware verified).";

        field {
            name = "regup";
            desc = "[inferred] Regup. (vendor header `product/hiosd/vo/hi3519/vou_reg.h` field `regup`; access and reset unknown, modelled RW)";
            sw = rw;
            hw = r;
        } regup[0:0];
    } GP0_UPD @ 0x9004;

    reg {
        name = "GP0 ORESO";
        desc = "[inferred] GP0 ORESO. Not in the data sheet. Source: vendor U-Boot 2010.06 `product/hiosd/vo/hi3519/vou_reg.h` (GPL-2.0 U-Boot tree, HiSilicon copyright, created 2015-05-26; mirror github.com/OpenIPC/u-boot-hi3516cv200), union `U_GP0_ORESO`, struct offset 0x9008 (GPL-2.0, same-chip vendor header, byte-identical for Hi3516A V200 and Hi3519 V101). Reset value and access type unknown (modelled RW, no reset). Confidence: medium (vendor header for this chip family, not hardware verified).";

        field {
            name = "oh";
            desc = "[inferred] Oh. (vendor header `product/hiosd/vo/hi3519/vou_reg.h` field `oh`; access and reset unknown, modelled RW)";
            sw = rw;
            hw = r;
        } oh[23:12];

        field {
            name = "ow";
            desc = "[inferred] Ow. (vendor header `product/hiosd/vo/hi3519/vou_reg.h` field `ow`; access and reset unknown, modelled RW)";
            sw = rw;
            hw = r;
        } ow[11:0];
    } GP0_ORESO @ 0x9008;

    reg {
        name = "GP0 IRESO";
        desc = "[inferred] GP0 IRESO. Not in the data sheet. Source: vendor U-Boot 2010.06 `product/hiosd/vo/hi3519/vou_reg.h` (GPL-2.0 U-Boot tree, HiSilicon copyright, created 2015-05-26; mirror github.com/OpenIPC/u-boot-hi3516cv200), union `U_GP0_IRESO`, struct offset 0x900C (GPL-2.0, same-chip vendor header, byte-identical for Hi3516A V200 and Hi3519 V101). Reset value and access type unknown (modelled RW, no reset). Confidence: medium (vendor header for this chip family, not hardware verified).";

        field {
            name = "ih";
            desc = "[inferred] Ih. (vendor header `product/hiosd/vo/hi3519/vou_reg.h` field `ih`; access and reset unknown, modelled RW)";
            sw = rw;
            hw = r;
        } ih[23:12];

        field {
            name = "iw";
            desc = "[inferred] Iw. (vendor header `product/hiosd/vo/hi3519/vou_reg.h` field `iw`; access and reset unknown, modelled RW)";
            sw = rw;
            hw = r;
        } iw[11:0];
    } GP0_IRESO @ 0x900C;

    reg {
        name = "GP0 HCOEFAD";
        desc = "[inferred] GP0 HCOEFAD. Not in the data sheet. Source: vendor U-Boot 2010.06 `product/hiosd/vo/hi3519/vou_reg.h` (GPL-2.0 U-Boot tree, HiSilicon copyright, created 2015-05-26; mirror github.com/OpenIPC/u-boot-hi3516cv200), union `U_GP0_HCOEFAD`, struct offset 0x9010 (GPL-2.0, same-chip vendor header, byte-identical for Hi3516A V200 and Hi3519 V101). Reset value and access type unknown (modelled RW, no reset). Confidence: medium (vendor header for this chip family, not hardware verified).";

        field {
            name = "coef_addr";
            desc = "[inferred] Coefficient address. (vendor header `product/hiosd/vo/hi3519/vou_reg.h` field `coef_addr`; access and reset unknown, modelled RW)";
            sw = rw;
            hw = r;
        } coef_addr[31:0];
    } GP0_HCOEFAD @ 0x9010;

    reg {
        name = "GP0 VCOEFAD";
        desc = "[inferred] GP0 VCOEFAD. Not in the data sheet. Source: vendor U-Boot 2010.06 `product/hiosd/vo/hi3519/vou_reg.h` (GPL-2.0 U-Boot tree, HiSilicon copyright, created 2015-05-26; mirror github.com/OpenIPC/u-boot-hi3516cv200), union `U_GP0_VCOEFAD`, struct offset 0x9014 (GPL-2.0, same-chip vendor header, byte-identical for Hi3516A V200 and Hi3519 V101). Reset value and access type unknown (modelled RW, no reset). Confidence: medium (vendor header for this chip family, not hardware verified).";

        field {
            name = "coef_addr";
            desc = "[inferred] Coefficient address. (vendor header `product/hiosd/vo/hi3519/vou_reg.h` field `coef_addr`; access and reset unknown, modelled RW)";
            sw = rw;
            hw = r;
        } coef_addr[31:0];
    } GP0_VCOEFAD @ 0x9014;

    reg {
        name = "GP0 PARAUP";
        desc = "[inferred] GP0 PARAUP. Not in the data sheet. Source: vendor U-Boot 2010.06 `product/hiosd/vo/hi3519/vou_reg.h` (GPL-2.0 U-Boot tree, HiSilicon copyright, created 2015-05-26; mirror github.com/OpenIPC/u-boot-hi3516cv200), union `U_GP0_PARAUP`, struct offset 0x9018 (GPL-2.0, same-chip vendor header, byte-identical for Hi3516A V200 and Hi3519 V101). Reset value and access type unknown (modelled RW, no reset). Confidence: medium (vendor header for this chip family, not hardware verified).";

        field {
            name = "gp0_vcoef_upd";
            desc = "[inferred] Gp0 vcoef update. (vendor header `product/hiosd/vo/hi3519/vou_reg.h` field `gp0_vcoef_upd`; access and reset unknown, modelled RW)";
            sw = rw;
            hw = r;
        } gp0_vcoef_upd[1:1];

        field {
            name = "gp0_hcoef_upd";
            desc = "[inferred] Gp0 hcoef update. (vendor header `product/hiosd/vo/hi3519/vou_reg.h` field `gp0_hcoef_upd`; access and reset unknown, modelled RW)";
            sw = rw;
            hw = r;
        } gp0_hcoef_upd[0:0];
    } GP0_PARAUP @ 0x9018;

    reg {
        name = "GP0 GALPHA";
        desc = "[inferred] GP0 GALPHA. Not in the data sheet. Source: vendor U-Boot 2010.06 `product/hiosd/vo/hi3519/vou_reg.h` (GPL-2.0 U-Boot tree, HiSilicon copyright, created 2015-05-26; mirror github.com/OpenIPC/u-boot-hi3516cv200), union `U_GP0_GALPHA`, struct offset 0x9020 (GPL-2.0, same-chip vendor header, byte-identical for Hi3516A V200 and Hi3519 V101). Reset value and access type unknown (modelled RW, no reset). Confidence: medium (vendor header for this chip family, not hardware verified).";

        field {
            name = "galpha";
            desc = "[inferred] Galpha. (vendor header `product/hiosd/vo/hi3519/vou_reg.h` field `galpha`; access and reset unknown, modelled RW)";
            sw = rw;
            hw = r;
        } galpha[7:0];
    } GP0_GALPHA @ 0x9020;

    reg {
        name = "GP0 DFPOS";
        desc = "[inferred] GP0 DFPOS. Not in the data sheet. Source: vendor U-Boot 2010.06 `product/hiosd/vo/hi3519/vou_reg.h` (GPL-2.0 U-Boot tree, HiSilicon copyright, created 2015-05-26; mirror github.com/OpenIPC/u-boot-hi3516cv200), union `U_GP0_DFPOS`, struct offset 0x9100 (GPL-2.0, same-chip vendor header, byte-identical for Hi3516A V200 and Hi3519 V101). Reset value and access type unknown (modelled RW, no reset). Confidence: medium (vendor header for this chip family, not hardware verified).";

        field {
            name = "disp_yfpos";
            desc = "[inferred] Disp yfpos. (vendor header `product/hiosd/vo/hi3519/vou_reg.h` field `disp_yfpos`; access and reset unknown, modelled RW)";
            sw = rw;
            hw = r;
        } disp_yfpos[23:12];

        field {
            name = "disp_xfpos";
            desc = "[inferred] Disp xfpos. (vendor header `product/hiosd/vo/hi3519/vou_reg.h` field `disp_xfpos`; access and reset unknown, modelled RW)";
            sw = rw;
            hw = r;
        } disp_xfpos[11:0];
    } GP0_DFPOS @ 0x9100;

    reg {
        name = "GP0 DLPOS";
        desc = "[inferred] GP0 DLPOS. Not in the data sheet. Source: vendor U-Boot 2010.06 `product/hiosd/vo/hi3519/vou_reg.h` (GPL-2.0 U-Boot tree, HiSilicon copyright, created 2015-05-26; mirror github.com/OpenIPC/u-boot-hi3516cv200), union `U_GP0_DLPOS`, struct offset 0x9104 (GPL-2.0, same-chip vendor header, byte-identical for Hi3516A V200 and Hi3519 V101). Reset value and access type unknown (modelled RW, no reset). Confidence: medium (vendor header for this chip family, not hardware verified).";

        field {
            name = "disp_ylpos";
            desc = "[inferred] Disp ylpos. (vendor header `product/hiosd/vo/hi3519/vou_reg.h` field `disp_ylpos`; access and reset unknown, modelled RW)";
            sw = rw;
            hw = r;
        } disp_ylpos[23:12];

        field {
            name = "disp_xlpos";
            desc = "[inferred] Disp xlpos. (vendor header `product/hiosd/vo/hi3519/vou_reg.h` field `disp_xlpos`; access and reset unknown, modelled RW)";
            sw = rw;
            hw = r;
        } disp_xlpos[11:0];
    } GP0_DLPOS @ 0x9104;

    reg {
        name = "GP0 VFPOS";
        desc = "[inferred] GP0 VFPOS. Not in the data sheet. Source: vendor U-Boot 2010.06 `product/hiosd/vo/hi3519/vou_reg.h` (GPL-2.0 U-Boot tree, HiSilicon copyright, created 2015-05-26; mirror github.com/OpenIPC/u-boot-hi3516cv200), union `U_GP0_VFPOS`, struct offset 0x9108 (GPL-2.0, same-chip vendor header, byte-identical for Hi3516A V200 and Hi3519 V101). Reset value and access type unknown (modelled RW, no reset). Confidence: medium (vendor header for this chip family, not hardware verified).";

        field {
            name = "video_yfpos";
            desc = "[inferred] Video yfpos. (vendor header `product/hiosd/vo/hi3519/vou_reg.h` field `video_yfpos`; access and reset unknown, modelled RW)";
            sw = rw;
            hw = r;
        } video_yfpos[23:12];

        field {
            name = "video_xfpos";
            desc = "[inferred] Video xfpos. (vendor header `product/hiosd/vo/hi3519/vou_reg.h` field `video_xfpos`; access and reset unknown, modelled RW)";
            sw = rw;
            hw = r;
        } video_xfpos[11:0];
    } GP0_VFPOS @ 0x9108;

    reg {
        name = "GP0 VLPOS";
        desc = "[inferred] GP0 VLPOS. Not in the data sheet. Source: vendor U-Boot 2010.06 `product/hiosd/vo/hi3519/vou_reg.h` (GPL-2.0 U-Boot tree, HiSilicon copyright, created 2015-05-26; mirror github.com/OpenIPC/u-boot-hi3516cv200), union `U_GP0_VLPOS`, struct offset 0x910C (GPL-2.0, same-chip vendor header, byte-identical for Hi3516A V200 and Hi3519 V101). Reset value and access type unknown (modelled RW, no reset). Confidence: medium (vendor header for this chip family, not hardware verified).";

        field {
            name = "video_ylpos";
            desc = "[inferred] Video ylpos. (vendor header `product/hiosd/vo/hi3519/vou_reg.h` field `video_ylpos`; access and reset unknown, modelled RW)";
            sw = rw;
            hw = r;
        } video_ylpos[23:12];

        field {
            name = "video_xlpos";
            desc = "[inferred] Video xlpos. (vendor header `product/hiosd/vo/hi3519/vou_reg.h` field `video_xlpos`; access and reset unknown, modelled RW)";
            sw = rw;
            hw = r;
        } video_xlpos[11:0];
    } GP0_VLPOS @ 0x910C;

    reg {
        name = "GP0 background";
        desc = "[inferred] GP0 background. Not in the data sheet. Source: vendor U-Boot 2010.06 `product/hiosd/vo/hi3519/vou_reg.h` (GPL-2.0 U-Boot tree, HiSilicon copyright, created 2015-05-26; mirror github.com/OpenIPC/u-boot-hi3516cv200), union `U_GP0_BK`, struct offset 0x9110 (GPL-2.0, same-chip vendor header, byte-identical for Hi3516A V200 and Hi3519 V101). Reset value and access type unknown (modelled RW, no reset). Confidence: medium (vendor header for this chip family, not hardware verified).";

        field {
            name = "vbk_y";
            desc = "[inferred] Vbk y. (vendor header `product/hiosd/vo/hi3519/vou_reg.h` field `vbk_y`; access and reset unknown, modelled RW)";
            sw = rw;
            hw = r;
        } vbk_y[29:20];

        field {
            name = "vbk_cb";
            desc = "[inferred] Vbk cb. (vendor header `product/hiosd/vo/hi3519/vou_reg.h` field `vbk_cb`; access and reset unknown, modelled RW)";
            sw = rw;
            hw = r;
        } vbk_cb[19:10];

        field {
            name = "vbk_cr";
            desc = "[inferred] Vbk cr. (vendor header `product/hiosd/vo/hi3519/vou_reg.h` field `vbk_cr`; access and reset unknown, modelled RW)";
            sw = rw;
            hw = r;
        } vbk_cr[9:0];
    } GP0_BK @ 0x9110;

    reg {
        name = "GP0 alpha";
        desc = "[inferred] GP0 alpha. Not in the data sheet. Source: vendor U-Boot 2010.06 `product/hiosd/vo/hi3519/vou_reg.h` (GPL-2.0 U-Boot tree, HiSilicon copyright, created 2015-05-26; mirror github.com/OpenIPC/u-boot-hi3516cv200), union `U_GP0_ALPHA`, struct offset 0x9114 (GPL-2.0, same-chip vendor header, byte-identical for Hi3516A V200 and Hi3519 V101). Reset value and access type unknown (modelled RW, no reset). Confidence: medium (vendor header for this chip family, not hardware verified).";

        field {
            name = "vbk_alpha";
            desc = "[inferred] Vbk alpha. (vendor header `product/hiosd/vo/hi3519/vou_reg.h` field `vbk_alpha`; access and reset unknown, modelled RW)";
            sw = rw;
            hw = r;
        } vbk_alpha[7:0];
    } GP0_ALPHA @ 0x9114;

    reg {
        name = "GP0 colour-space conversion IDC";
        desc = "[inferred] GP0 colour-space conversion IDC. Not in the data sheet. Source: vendor U-Boot 2010.06 `product/hiosd/vo/hi3519/vou_reg.h` (GPL-2.0 U-Boot tree, HiSilicon copyright, created 2015-05-26; mirror github.com/OpenIPC/u-boot-hi3516cv200), union `U_GP0_CSC_IDC`, struct offset 0x9120 (GPL-2.0, same-chip vendor header, byte-identical for Hi3516A V200 and Hi3519 V101). Reset value and access type unknown (modelled RW, no reset). Confidence: medium (vendor header for this chip family, not hardware verified).";

        field {
            name = "csc_en";
            desc = "[inferred] Colour-space conversion enable. (vendor header `product/hiosd/vo/hi3519/vou_reg.h` field `csc_en`; access and reset unknown, modelled RW)";
            sw = rw;
            hw = r;
        } csc_en[22:22];

        field {
            name = "cscidc1";
            desc = "[inferred] Cscidc1. (vendor header `product/hiosd/vo/hi3519/vou_reg.h` field `cscidc1`; access and reset unknown, modelled RW)";
            sw = rw;
            hw = r;
        } cscidc1[21:11];

        field {
            name = "cscidc0";
            desc = "[inferred] Cscidc0. (vendor header `product/hiosd/vo/hi3519/vou_reg.h` field `cscidc0`; access and reset unknown, modelled RW)";
            sw = rw;
            hw = r;
        } cscidc0[10:0];
    } GP0_CSC_IDC @ 0x9120;

    reg {
        name = "GP0 colour-space conversion ODC";
        desc = "[inferred] GP0 colour-space conversion ODC. Not in the data sheet. Source: vendor U-Boot 2010.06 `product/hiosd/vo/hi3519/vou_reg.h` (GPL-2.0 U-Boot tree, HiSilicon copyright, created 2015-05-26; mirror github.com/OpenIPC/u-boot-hi3516cv200), union `U_GP0_CSC_ODC`, struct offset 0x9124 (GPL-2.0, same-chip vendor header, byte-identical for Hi3516A V200 and Hi3519 V101). Reset value and access type unknown (modelled RW, no reset). Confidence: medium (vendor header for this chip family, not hardware verified).";

        field {
            name = "csc_sign_mode";
            desc = "[inferred] Colour-space conversion sign mode. (vendor header `product/hiosd/vo/hi3519/vou_reg.h` field `csc_sign_mode`; access and reset unknown, modelled RW)";
            sw = rw;
            hw = r;
        } csc_sign_mode[22:22];

        field {
            name = "cscodc1";
            desc = "[inferred] Cscodc1. (vendor header `product/hiosd/vo/hi3519/vou_reg.h` field `cscodc1`; access and reset unknown, modelled RW)";
            sw = rw;
            hw = r;
        } cscodc1[21:11];

        field {
            name = "cscodc0";
            desc = "[inferred] Cscodc0. (vendor header `product/hiosd/vo/hi3519/vou_reg.h` field `cscodc0`; access and reset unknown, modelled RW)";
            sw = rw;
            hw = r;
        } cscodc0[10:0];
    } GP0_CSC_ODC @ 0x9124;

    reg {
        name = "GP0 colour-space conversion IODC";
        desc = "[inferred] GP0 colour-space conversion IODC. Not in the data sheet. Source: vendor U-Boot 2010.06 `product/hiosd/vo/hi3519/vou_reg.h` (GPL-2.0 U-Boot tree, HiSilicon copyright, created 2015-05-26; mirror github.com/OpenIPC/u-boot-hi3516cv200), union `U_GP0_CSC_IODC`, struct offset 0x9128 (GPL-2.0, same-chip vendor header, byte-identical for Hi3516A V200 and Hi3519 V101). Reset value and access type unknown (modelled RW, no reset). Confidence: medium (vendor header for this chip family, not hardware verified).";

        field {
            name = "cscodc2";
            desc = "[inferred] Cscodc2. (vendor header `product/hiosd/vo/hi3519/vou_reg.h` field `cscodc2`; access and reset unknown, modelled RW)";
            sw = rw;
            hw = r;
        } cscodc2[21:11];

        field {
            name = "cscidc2";
            desc = "[inferred] Cscidc2. (vendor header `product/hiosd/vo/hi3519/vou_reg.h` field `cscidc2`; access and reset unknown, modelled RW)";
            sw = rw;
            hw = r;
        } cscidc2[10:0];
    } GP0_CSC_IODC @ 0x9128;

    reg {
        name = "GP0 colour-space conversion P0";
        desc = "[inferred] GP0 colour-space conversion P0. Not in the data sheet. Source: vendor U-Boot 2010.06 `product/hiosd/vo/hi3519/vou_reg.h` (GPL-2.0 U-Boot tree, HiSilicon copyright, created 2015-05-26; mirror github.com/OpenIPC/u-boot-hi3516cv200), union `U_GP0_CSC_P0`, struct offset 0x912C (GPL-2.0, same-chip vendor header, byte-identical for Hi3516A V200 and Hi3519 V101). Reset value and access type unknown (modelled RW, no reset). Confidence: medium (vendor header for this chip family, not hardware verified).";

        field {
            name = "cscp01";
            desc = "[inferred] Cscp01. (vendor header `product/hiosd/vo/hi3519/vou_reg.h` field `cscp01`; access and reset unknown, modelled RW)";
            sw = rw;
            hw = r;
        } cscp01[30:16];

        field {
            name = "cscp00";
            desc = "[inferred] Cscp00. (vendor header `product/hiosd/vo/hi3519/vou_reg.h` field `cscp00`; access and reset unknown, modelled RW)";
            sw = rw;
            hw = r;
        } cscp00[14:0];
    } GP0_CSC_P0 @ 0x912C;

    reg {
        name = "GP0 colour-space conversion P1";
        desc = "[inferred] GP0 colour-space conversion P1. Not in the data sheet. Source: vendor U-Boot 2010.06 `product/hiosd/vo/hi3519/vou_reg.h` (GPL-2.0 U-Boot tree, HiSilicon copyright, created 2015-05-26; mirror github.com/OpenIPC/u-boot-hi3516cv200), union `U_GP0_CSC_P1`, struct offset 0x9130 (GPL-2.0, same-chip vendor header, byte-identical for Hi3516A V200 and Hi3519 V101). Reset value and access type unknown (modelled RW, no reset). Confidence: medium (vendor header for this chip family, not hardware verified).";

        field {
            name = "cscp10";
            desc = "[inferred] Cscp10. (vendor header `product/hiosd/vo/hi3519/vou_reg.h` field `cscp10`; access and reset unknown, modelled RW)";
            sw = rw;
            hw = r;
        } cscp10[30:16];

        field {
            name = "cscp02";
            desc = "[inferred] Cscp02. (vendor header `product/hiosd/vo/hi3519/vou_reg.h` field `cscp02`; access and reset unknown, modelled RW)";
            sw = rw;
            hw = r;
        } cscp02[14:0];
    } GP0_CSC_P1 @ 0x9130;

    reg {
        name = "GP0 colour-space conversion P2";
        desc = "[inferred] GP0 colour-space conversion P2. Not in the data sheet. Source: vendor U-Boot 2010.06 `product/hiosd/vo/hi3519/vou_reg.h` (GPL-2.0 U-Boot tree, HiSilicon copyright, created 2015-05-26; mirror github.com/OpenIPC/u-boot-hi3516cv200), union `U_GP0_CSC_P2`, struct offset 0x9134 (GPL-2.0, same-chip vendor header, byte-identical for Hi3516A V200 and Hi3519 V101). Reset value and access type unknown (modelled RW, no reset). Confidence: medium (vendor header for this chip family, not hardware verified).";

        field {
            name = "cscp12";
            desc = "[inferred] Cscp12. (vendor header `product/hiosd/vo/hi3519/vou_reg.h` field `cscp12`; access and reset unknown, modelled RW)";
            sw = rw;
            hw = r;
        } cscp12[30:16];

        field {
            name = "cscp11";
            desc = "[inferred] Cscp11. (vendor header `product/hiosd/vo/hi3519/vou_reg.h` field `cscp11`; access and reset unknown, modelled RW)";
            sw = rw;
            hw = r;
        } cscp11[14:0];
    } GP0_CSC_P2 @ 0x9134;

    reg {
        name = "GP0 colour-space conversion P3";
        desc = "[inferred] GP0 colour-space conversion P3. Not in the data sheet. Source: vendor U-Boot 2010.06 `product/hiosd/vo/hi3519/vou_reg.h` (GPL-2.0 U-Boot tree, HiSilicon copyright, created 2015-05-26; mirror github.com/OpenIPC/u-boot-hi3516cv200), union `U_GP0_CSC_P3`, struct offset 0x9138 (GPL-2.0, same-chip vendor header, byte-identical for Hi3516A V200 and Hi3519 V101). Reset value and access type unknown (modelled RW, no reset). Confidence: medium (vendor header for this chip family, not hardware verified).";

        field {
            name = "cscp21";
            desc = "[inferred] Cscp21. (vendor header `product/hiosd/vo/hi3519/vou_reg.h` field `cscp21`; access and reset unknown, modelled RW)";
            sw = rw;
            hw = r;
        } cscp21[30:16];

        field {
            name = "cscp20";
            desc = "[inferred] Cscp20. (vendor header `product/hiosd/vo/hi3519/vou_reg.h` field `cscp20`; access and reset unknown, modelled RW)";
            sw = rw;
            hw = r;
        } cscp20[14:0];
    } GP0_CSC_P3 @ 0x9138;

    reg {
        name = "GP0 colour-space conversion P4";
        desc = "[inferred] GP0 colour-space conversion P4. Not in the data sheet. Source: vendor U-Boot 2010.06 `product/hiosd/vo/hi3519/vou_reg.h` (GPL-2.0 U-Boot tree, HiSilicon copyright, created 2015-05-26; mirror github.com/OpenIPC/u-boot-hi3516cv200), union `U_GP0_CSC_P4`, struct offset 0x913C (GPL-2.0, same-chip vendor header, byte-identical for Hi3516A V200 and Hi3519 V101). Reset value and access type unknown (modelled RW, no reset). Confidence: medium (vendor header for this chip family, not hardware verified).";

        field {
            name = "cscp22";
            desc = "[inferred] Cscp22. (vendor header `product/hiosd/vo/hi3519/vou_reg.h` field `cscp22`; access and reset unknown, modelled RW)";
            sw = rw;
            hw = r;
        } cscp22[14:0];
    } GP0_CSC_P4 @ 0x913C;

    reg {
        name = "GP0 scaler HSP";
        desc = "[inferred] GP0 scaler HSP. Not in the data sheet. Source: vendor U-Boot 2010.06 `product/hiosd/vo/hi3519/vou_reg.h` (GPL-2.0 U-Boot tree, HiSilicon copyright, created 2015-05-26; mirror github.com/OpenIPC/u-boot-hi3516cv200), union `U_GP0_ZME_HSP`, struct offset 0x9140 (GPL-2.0, same-chip vendor header, byte-identical for Hi3516A V200 and Hi3519 V101). Reset value and access type unknown (modelled RW, no reset). Confidence: medium (vendor header for this chip family, not hardware verified).";

        field {
            name = "hsc_en";
            desc = "[inferred] Hsc enable. (vendor header `product/hiosd/vo/hi3519/vou_reg.h` field `hsc_en`; access and reset unknown, modelled RW)";
            sw = rw;
            hw = r;
        } hsc_en[31:31];

        field {
            name = "hamid_en";
            desc = "[inferred] Hamid enable. (vendor header `product/hiosd/vo/hi3519/vou_reg.h` field `hamid_en`; access and reset unknown, modelled RW)";
            sw = rw;
            hw = r;
        } hamid_en[30:30];

        field {
            name = "hlmid_en";
            desc = "[inferred] Hlmid enable. (vendor header `product/hiosd/vo/hi3519/vou_reg.h` field `hlmid_en`; access and reset unknown, modelled RW)";
            sw = rw;
            hw = r;
        } hlmid_en[29:29];

        field {
            name = "hchmid_en";
            desc = "[inferred] Hchmid enable. (vendor header `product/hiosd/vo/hi3519/vou_reg.h` field `hchmid_en`; access and reset unknown, modelled RW)";
            sw = rw;
            hw = r;
        } hchmid_en[28:28];

        field {
            name = "hfir_en";
            desc = "[inferred] Hfir enable. (vendor header `product/hiosd/vo/hi3519/vou_reg.h` field `hfir_en`; access and reset unknown, modelled RW)";
            sw = rw;
            hw = r;
        } hfir_en[24:24];

        field {
            name = "hafir_en";
            desc = "[inferred] Hafir enable. (vendor header `product/hiosd/vo/hi3519/vou_reg.h` field `hafir_en`; access and reset unknown, modelled RW)";
            sw = rw;
            hw = r;
        } hafir_en[23:23];

        field {
            name = "hfir_order";
            desc = "[inferred] Hfir order. (vendor header `product/hiosd/vo/hi3519/vou_reg.h` field `hfir_order`; access and reset unknown, modelled RW)";
            sw = rw;
            hw = r;
        } hfir_order[19:19];

        field {
            name = "hratio";
            desc = "[inferred] Hratio. (vendor header `product/hiosd/vo/hi3519/vou_reg.h` field `hratio`; access and reset unknown, modelled RW)";
            sw = rw;
            hw = r;
        } hratio[15:0];
    } GP0_ZME_HSP @ 0x9140;

    reg {
        name = "GP0 scaler HOFFSET";
        desc = "[inferred] GP0 scaler HOFFSET. Not in the data sheet. Source: vendor U-Boot 2010.06 `product/hiosd/vo/hi3519/vou_reg.h` (GPL-2.0 U-Boot tree, HiSilicon copyright, created 2015-05-26; mirror github.com/OpenIPC/u-boot-hi3516cv200), union `U_GP0_ZME_HOFFSET`, struct offset 0x9144 (GPL-2.0, same-chip vendor header, byte-identical for Hi3516A V200 and Hi3519 V101). Reset value and access type unknown (modelled RW, no reset). Confidence: medium (vendor header for this chip family, not hardware verified).";

        field {
            name = "hor_loffset";
            desc = "[inferred] Hor loffset. (vendor header `product/hiosd/vo/hi3519/vou_reg.h` field `hor_loffset`; access and reset unknown, modelled RW)";
            sw = rw;
            hw = r;
        } hor_loffset[31:16];

        field {
            name = "hor_coffset";
            desc = "[inferred] Hor coffset. (vendor header `product/hiosd/vo/hi3519/vou_reg.h` field `hor_coffset`; access and reset unknown, modelled RW)";
            sw = rw;
            hw = r;
        } hor_coffset[15:0];
    } GP0_ZME_HOFFSET @ 0x9144;

    reg {
        name = "GP0 scaler VSP";
        desc = "[inferred] GP0 scaler VSP. Not in the data sheet. Source: vendor U-Boot 2010.06 `product/hiosd/vo/hi3519/vou_reg.h` (GPL-2.0 U-Boot tree, HiSilicon copyright, created 2015-05-26; mirror github.com/OpenIPC/u-boot-hi3516cv200), union `U_GP0_ZME_VSP`, struct offset 0x9148 (GPL-2.0, same-chip vendor header, byte-identical for Hi3516A V200 and Hi3519 V101). Reset value and access type unknown (modelled RW, no reset). Confidence: medium (vendor header for this chip family, not hardware verified).";

        field {
            name = "vsc_en";
            desc = "[inferred] Vsc enable. (vendor header `product/hiosd/vo/hi3519/vou_reg.h` field `vsc_en`; access and reset unknown, modelled RW)";
            sw = rw;
            hw = r;
        } vsc_en[31:31];

        field {
            name = "vamid_en";
            desc = "[inferred] Vamid enable. (vendor header `product/hiosd/vo/hi3519/vou_reg.h` field `vamid_en`; access and reset unknown, modelled RW)";
            sw = rw;
            hw = r;
        } vamid_en[30:30];

        field {
            name = "vlmid_en";
            desc = "[inferred] Vlmid enable. (vendor header `product/hiosd/vo/hi3519/vou_reg.h` field `vlmid_en`; access and reset unknown, modelled RW)";
            sw = rw;
            hw = r;
        } vlmid_en[29:29];

        field {
            name = "vchmid_en";
            desc = "[inferred] Vchmid enable. (vendor header `product/hiosd/vo/hi3519/vou_reg.h` field `vchmid_en`; access and reset unknown, modelled RW)";
            sw = rw;
            hw = r;
        } vchmid_en[28:28];

        field {
            name = "vsc_luma_tap";
            desc = "[inferred] Vsc luma tap. (vendor header `product/hiosd/vo/hi3519/vou_reg.h` field `vsc_luma_tap`; access and reset unknown, modelled RW)";
            sw = rw;
            hw = r;
        } vsc_luma_tap[27:27];

        field {
            name = "vfir_en";
            desc = "[inferred] Vfir enable. (vendor header `product/hiosd/vo/hi3519/vou_reg.h` field `vfir_en`; access and reset unknown, modelled RW)";
            sw = rw;
            hw = r;
        } vfir_en[24:24];

        field {
            name = "vafir_en";
            desc = "[inferred] Vafir enable. (vendor header `product/hiosd/vo/hi3519/vou_reg.h` field `vafir_en`; access and reset unknown, modelled RW)";
            sw = rw;
            hw = r;
        } vafir_en[23:23];
    } GP0_ZME_VSP @ 0x9148;

    reg {
        name = "GP0 scaler VSR";
        desc = "[inferred] GP0 scaler VSR. Not in the data sheet. Source: vendor U-Boot 2010.06 `product/hiosd/vo/hi3519/vou_reg.h` (GPL-2.0 U-Boot tree, HiSilicon copyright, created 2015-05-26; mirror github.com/OpenIPC/u-boot-hi3516cv200), union `U_GP0_ZME_VSR`, struct offset 0x914C (GPL-2.0, same-chip vendor header, byte-identical for Hi3516A V200 and Hi3519 V101). Reset value and access type unknown (modelled RW, no reset). Confidence: medium (vendor header for this chip family, not hardware verified).";

        field {
            name = "vratio";
            desc = "[inferred] Vratio. (vendor header `product/hiosd/vo/hi3519/vou_reg.h` field `vratio`; access and reset unknown, modelled RW)";
            sw = rw;
            hw = r;
        } vratio[15:0];
    } GP0_ZME_VSR @ 0x914C;

    reg {
        name = "GP0 scaler VOFFSET";
        desc = "[inferred] GP0 scaler VOFFSET. Not in the data sheet. Source: vendor U-Boot 2010.06 `product/hiosd/vo/hi3519/vou_reg.h` (GPL-2.0 U-Boot tree, HiSilicon copyright, created 2015-05-26; mirror github.com/OpenIPC/u-boot-hi3516cv200), union `U_GP0_ZME_VOFFSET`, struct offset 0x9150 (GPL-2.0, same-chip vendor header, byte-identical for Hi3516A V200 and Hi3519 V101). Reset value and access type unknown (modelled RW, no reset). Confidence: medium (vendor header for this chip family, not hardware verified).";

        field {
            name = "vtp_offset";
            desc = "[inferred] Vtp offset. (vendor header `product/hiosd/vo/hi3519/vou_reg.h` field `vtp_offset`; access and reset unknown, modelled RW)";
            sw = rw;
            hw = r;
        } vtp_offset[31:16];

        field {
            name = "vbtm_offset";
            desc = "[inferred] Vbtm offset. (vendor header `product/hiosd/vo/hi3519/vou_reg.h` field `vbtm_offset`; access and reset unknown, modelled RW)";
            sw = rw;
            hw = r;
        } vbtm_offset[15:0];
    } GP0_ZME_VOFFSET @ 0x9150;

    reg {
        name = "GP0 scaler LTICTRL";
        desc = "[inferred] GP0 scaler LTICTRL. Not in the data sheet. Source: vendor U-Boot 2010.06 `product/hiosd/vo/hi3519/vou_reg.h` (GPL-2.0 U-Boot tree, HiSilicon copyright, created 2015-05-26; mirror github.com/OpenIPC/u-boot-hi3516cv200), union `U_GP0_ZME_LTICTRL`, struct offset 0x9160 (GPL-2.0, same-chip vendor header, byte-identical for Hi3516A V200 and Hi3519 V101). Reset value and access type unknown (modelled RW, no reset). Confidence: medium (vendor header for this chip family, not hardware verified).";

        field {
            name = "lti_en";
            desc = "[inferred] Lti enable. (vendor header `product/hiosd/vo/hi3519/vou_reg.h` field `lti_en`; access and reset unknown, modelled RW)";
            sw = rw;
            hw = r;
        } lti_en[31:31];

        field {
            name = "lgain_ratio";
            desc = "[inferred] Lgain ratio. (vendor header `product/hiosd/vo/hi3519/vou_reg.h` field `lgain_ratio`; access and reset unknown, modelled RW)";
            sw = rw;
            hw = r;
        } lgain_ratio[27:16];

        field {
            name = "lmixing_ratio";
            desc = "[inferred] Lmixing ratio. (vendor header `product/hiosd/vo/hi3519/vou_reg.h` field `lmixing_ratio`; access and reset unknown, modelled RW)";
            sw = rw;
            hw = r;
        } lmixing_ratio[15:8];

        field {
            name = "lhpass_coef4";
            desc = "[inferred] Lhpass coef4. (vendor header `product/hiosd/vo/hi3519/vou_reg.h` field `lhpass_coef4`; access and reset unknown, modelled RW)";
            sw = rw;
            hw = r;
        } lhpass_coef4[7:0];
    } GP0_ZME_LTICTRL @ 0x9160;

    reg {
        name = "GP0 scaler LHPASSCOEF";
        desc = "[inferred] GP0 scaler LHPASSCOEF. Not in the data sheet. Source: vendor U-Boot 2010.06 `product/hiosd/vo/hi3519/vou_reg.h` (GPL-2.0 U-Boot tree, HiSilicon copyright, created 2015-05-26; mirror github.com/OpenIPC/u-boot-hi3516cv200), union `U_GP0_ZME_LHPASSCOEF`, struct offset 0x9164 (GPL-2.0, same-chip vendor header, byte-identical for Hi3516A V200 and Hi3519 V101). Reset value and access type unknown (modelled RW, no reset). Confidence: medium (vendor header for this chip family, not hardware verified).";

        field {
            name = "lhpass_coef3";
            desc = "[inferred] Lhpass coef3. (vendor header `product/hiosd/vo/hi3519/vou_reg.h` field `lhpass_coef3`; access and reset unknown, modelled RW)";
            sw = rw;
            hw = r;
        } lhpass_coef3[31:24];

        field {
            name = "lhpass_coef2";
            desc = "[inferred] Lhpass coef2. (vendor header `product/hiosd/vo/hi3519/vou_reg.h` field `lhpass_coef2`; access and reset unknown, modelled RW)";
            sw = rw;
            hw = r;
        } lhpass_coef2[23:16];

        field {
            name = "lhpass_coef1";
            desc = "[inferred] Lhpass coef1. (vendor header `product/hiosd/vo/hi3519/vou_reg.h` field `lhpass_coef1`; access and reset unknown, modelled RW)";
            sw = rw;
            hw = r;
        } lhpass_coef1[15:8];

        field {
            name = "lhpass_coef0";
            desc = "[inferred] Lhpass coef0. (vendor header `product/hiosd/vo/hi3519/vou_reg.h` field `lhpass_coef0`; access and reset unknown, modelled RW)";
            sw = rw;
            hw = r;
        } lhpass_coef0[7:0];
    } GP0_ZME_LHPASSCOEF @ 0x9164;

    reg {
        name = "GP0 scaler LTITHD";
        desc = "[inferred] GP0 scaler LTITHD. Not in the data sheet. Source: vendor U-Boot 2010.06 `product/hiosd/vo/hi3519/vou_reg.h` (GPL-2.0 U-Boot tree, HiSilicon copyright, created 2015-05-26; mirror github.com/OpenIPC/u-boot-hi3516cv200), union `U_GP0_ZME_LTITHD`, struct offset 0x9168 (GPL-2.0, same-chip vendor header, byte-identical for Hi3516A V200 and Hi3519 V101). Reset value and access type unknown (modelled RW, no reset). Confidence: medium (vendor header for this chip family, not hardware verified).";

        field {
            name = "lcoring_thd";
            desc = "[inferred] Lcoring threshold. (vendor header `product/hiosd/vo/hi3519/vou_reg.h` field `lcoring_thd`; access and reset unknown, modelled RW)";
            sw = rw;
            hw = r;
        } lcoring_thd[31:20];

        field {
            name = "lunder_swing";
            desc = "[inferred] Lunder swing. (vendor header `product/hiosd/vo/hi3519/vou_reg.h` field `lunder_swing`; access and reset unknown, modelled RW)";
            sw = rw;
            hw = r;
        } lunder_swing[19:10];

        field {
            name = "lover_swing";
            desc = "[inferred] Lover swing. (vendor header `product/hiosd/vo/hi3519/vou_reg.h` field `lover_swing`; access and reset unknown, modelled RW)";
            sw = rw;
            hw = r;
        } lover_swing[9:0];
    } GP0_ZME_LTITHD @ 0x9168;

    reg {
        name = "GP0 scaler LHFREQTHD";
        desc = "[inferred] GP0 scaler LHFREQTHD. Not in the data sheet. Source: vendor U-Boot 2010.06 `product/hiosd/vo/hi3519/vou_reg.h` (GPL-2.0 U-Boot tree, HiSilicon copyright, created 2015-05-26; mirror github.com/OpenIPC/u-boot-hi3516cv200), union `U_GP0_ZME_LHFREQTHD`, struct offset 0x9170 (GPL-2.0, same-chip vendor header, byte-identical for Hi3516A V200 and Hi3519 V101). Reset value and access type unknown (modelled RW, no reset). Confidence: medium (vendor header for this chip family, not hardware verified).";

        field {
            name = "lhfreq_thd1";
            desc = "[inferred] Lhfreq thd1. (vendor header `product/hiosd/vo/hi3519/vou_reg.h` field `lhfreq_thd1`; access and reset unknown, modelled RW)";
            sw = rw;
            hw = r;
        } lhfreq_thd1[31:16];

        field {
            name = "lhfreq_thd0";
            desc = "[inferred] Lhfreq thd0. (vendor header `product/hiosd/vo/hi3519/vou_reg.h` field `lhfreq_thd0`; access and reset unknown, modelled RW)";
            sw = rw;
            hw = r;
        } lhfreq_thd0[15:0];
    } GP0_ZME_LHFREQTHD @ 0x9170;

    reg {
        name = "GP0 scaler LGAINCOEF";
        desc = "[inferred] GP0 scaler LGAINCOEF. Not in the data sheet. Source: vendor U-Boot 2010.06 `product/hiosd/vo/hi3519/vou_reg.h` (GPL-2.0 U-Boot tree, HiSilicon copyright, created 2015-05-26; mirror github.com/OpenIPC/u-boot-hi3516cv200), union `U_GP0_ZME_LGAINCOEF`, struct offset 0x9174 (GPL-2.0, same-chip vendor header, byte-identical for Hi3516A V200 and Hi3519 V101). Reset value and access type unknown (modelled RW, no reset). Confidence: medium (vendor header for this chip family, not hardware verified).";

        field {
            name = "lgain_coef2";
            desc = "[inferred] Lgain coef2. (vendor header `product/hiosd/vo/hi3519/vou_reg.h` field `lgain_coef2`; access and reset unknown, modelled RW)";
            sw = rw;
            hw = r;
        } lgain_coef2[23:16];

        field {
            name = "lgain_coef1";
            desc = "[inferred] Lgain coef1. (vendor header `product/hiosd/vo/hi3519/vou_reg.h` field `lgain_coef1`; access and reset unknown, modelled RW)";
            sw = rw;
            hw = r;
        } lgain_coef1[15:8];

        field {
            name = "lgain_coef0";
            desc = "[inferred] Lgain coef0. (vendor header `product/hiosd/vo/hi3519/vou_reg.h` field `lgain_coef0`; access and reset unknown, modelled RW)";
            sw = rw;
            hw = r;
        } lgain_coef0[7:0];
    } GP0_ZME_LGAINCOEF @ 0x9174;

    reg {
        name = "GP0 scaler CTICTRL";
        desc = "[inferred] GP0 scaler CTICTRL. Not in the data sheet. Source: vendor U-Boot 2010.06 `product/hiosd/vo/hi3519/vou_reg.h` (GPL-2.0 U-Boot tree, HiSilicon copyright, created 2015-05-26; mirror github.com/OpenIPC/u-boot-hi3516cv200), union `U_GP0_ZME_CTICTRL`, struct offset 0x9180 (GPL-2.0, same-chip vendor header, byte-identical for Hi3516A V200 and Hi3519 V101). Reset value and access type unknown (modelled RW, no reset). Confidence: medium (vendor header for this chip family, not hardware verified).";

        field {
            name = "cti_en";
            desc = "[inferred] Cti enable. (vendor header `product/hiosd/vo/hi3519/vou_reg.h` field `cti_en`; access and reset unknown, modelled RW)";
            sw = rw;
            hw = r;
        } cti_en[31:31];

        field {
            name = "cgain_ratio";
            desc = "[inferred] Cgain ratio. (vendor header `product/hiosd/vo/hi3519/vou_reg.h` field `cgain_ratio`; access and reset unknown, modelled RW)";
            sw = rw;
            hw = r;
        } cgain_ratio[27:16];

        field {
            name = "cmixing_ratio";
            desc = "[inferred] Cmixing ratio. (vendor header `product/hiosd/vo/hi3519/vou_reg.h` field `cmixing_ratio`; access and reset unknown, modelled RW)";
            sw = rw;
            hw = r;
        } cmixing_ratio[15:8];
    } GP0_ZME_CTICTRL @ 0x9180;

    reg {
        name = "GP0 scaler CHPASSCOEF";
        desc = "[inferred] GP0 scaler CHPASSCOEF. Not in the data sheet. Source: vendor U-Boot 2010.06 `product/hiosd/vo/hi3519/vou_reg.h` (GPL-2.0 U-Boot tree, HiSilicon copyright, created 2015-05-26; mirror github.com/OpenIPC/u-boot-hi3516cv200), union `U_GP0_ZME_CHPASSCOEF`, struct offset 0x9184 (GPL-2.0, same-chip vendor header, byte-identical for Hi3516A V200 and Hi3519 V101). Reset value and access type unknown (modelled RW, no reset). Confidence: medium (vendor header for this chip family, not hardware verified).";

        field {
            name = "chpass_coef2";
            desc = "[inferred] Chpass coef2. (vendor header `product/hiosd/vo/hi3519/vou_reg.h` field `chpass_coef2`; access and reset unknown, modelled RW)";
            sw = rw;
            hw = r;
        } chpass_coef2[23:16];

        field {
            name = "chpass_coef1";
            desc = "[inferred] Chpass coef1. (vendor header `product/hiosd/vo/hi3519/vou_reg.h` field `chpass_coef1`; access and reset unknown, modelled RW)";
            sw = rw;
            hw = r;
        } chpass_coef1[15:8];

        field {
            name = "chpass_coef0";
            desc = "[inferred] Chpass coef0. (vendor header `product/hiosd/vo/hi3519/vou_reg.h` field `chpass_coef0`; access and reset unknown, modelled RW)";
            sw = rw;
            hw = r;
        } chpass_coef0[7:0];
    } GP0_ZME_CHPASSCOEF @ 0x9184;

    reg {
        name = "GP0 scaler CTITHD";
        desc = "[inferred] GP0 scaler CTITHD. Not in the data sheet. Source: vendor U-Boot 2010.06 `product/hiosd/vo/hi3519/vou_reg.h` (GPL-2.0 U-Boot tree, HiSilicon copyright, created 2015-05-26; mirror github.com/OpenIPC/u-boot-hi3516cv200), union `U_GP0_ZME_CTITHD`, struct offset 0x9188 (GPL-2.0, same-chip vendor header, byte-identical for Hi3516A V200 and Hi3519 V101). Reset value and access type unknown (modelled RW, no reset). Confidence: medium (vendor header for this chip family, not hardware verified).";

        field {
            name = "ccoring_thd";
            desc = "[inferred] Ccoring threshold. (vendor header `product/hiosd/vo/hi3519/vou_reg.h` field `ccoring_thd`; access and reset unknown, modelled RW)";
            sw = rw;
            hw = r;
        } ccoring_thd[31:20];

        field {
            name = "cunder_swing";
            desc = "[inferred] Cunder swing. (vendor header `product/hiosd/vo/hi3519/vou_reg.h` field `cunder_swing`; access and reset unknown, modelled RW)";
            sw = rw;
            hw = r;
        } cunder_swing[19:10];

        field {
            name = "cover_swing";
            desc = "[inferred] Cover swing. (vendor header `product/hiosd/vo/hi3519/vou_reg.h` field `cover_swing`; access and reset unknown, modelled RW)";
            sw = rw;
            hw = r;
        } cover_swing[9:0];
    } GP0_ZME_CTITHD @ 0x9188;

    reg {
        name = "WBC G0 control";
        desc = "[inferred] WBC G0 control. Not in the data sheet. Source: vendor U-Boot 2010.06 `product/hiosd/vo/hi3519/vou_reg.h` (GPL-2.0 U-Boot tree, HiSilicon copyright, created 2015-05-26; mirror github.com/OpenIPC/u-boot-hi3516cv200), union `U_WBC_G0_CTRL`, struct offset 0xA000 (GPL-2.0, same-chip vendor header, byte-identical for Hi3516A V200 and Hi3519 V101). Reset value and access type unknown (modelled RW, no reset). Confidence: medium (vendor header for this chip family, not hardware verified).";

        field {
            name = "wbc_en";
            desc = "[inferred] Wbc enable. (vendor header `product/hiosd/vo/hi3519/vou_reg.h` field `wbc_en`; access and reset unknown, modelled RW)";
            sw = rw;
            hw = r;
        } wbc_en[31:31];

        field {
            name = "format_out";
            desc = "[inferred] Format out. (vendor header `product/hiosd/vo/hi3519/vou_reg.h` field `format_out`; access and reset unknown, modelled RW)";
            sw = rw;
            hw = r;
        } format_out[27:26];

        field {
            name = "auto_stop_en";
            desc = "[inferred] Auto stop enable. (vendor header `product/hiosd/vo/hi3519/vou_reg.h` field `auto_stop_en`; access and reset unknown, modelled RW)";
            sw = rw;
            hw = r;
        } auto_stop_en[10:10];

        field {
            name = "req_interval";
            desc = "[inferred] Request interval. (vendor header `product/hiosd/vo/hi3519/vou_reg.h` field `req_interval`; access and reset unknown, modelled RW)";
            sw = rw;
            hw = r;
        } req_interval[9:0];
    } WBC_G0_CTRL @ 0xA000;

    reg {
        name = "WBC G0 update";
        desc = "[inferred] WBC G0 update. Not in the data sheet. Source: vendor U-Boot 2010.06 `product/hiosd/vo/hi3519/vou_reg.h` (GPL-2.0 U-Boot tree, HiSilicon copyright, created 2015-05-26; mirror github.com/OpenIPC/u-boot-hi3516cv200), union `U_WBC_G0_UPD`, struct offset 0xA004 (GPL-2.0, same-chip vendor header, byte-identical for Hi3516A V200 and Hi3519 V101). Reset value and access type unknown (modelled RW, no reset). Confidence: medium (vendor header for this chip family, not hardware verified).";

        field {
            name = "regup";
            desc = "[inferred] Regup. (vendor header `product/hiosd/vo/hi3519/vou_reg.h` field `regup`; access and reset unknown, modelled RW)";
            sw = rw;
            hw = r;
        } regup[0:0];
    } WBC_G0_UPD @ 0xA004;

    reg {
        name = "WBC G0 compare";
        desc = "[inferred] WBC G0 compare. Not in the data sheet. Source: vendor U-Boot 2010.06 `product/hiosd/vo/hi3519/vou_reg.h` (GPL-2.0 U-Boot tree, HiSilicon copyright, created 2015-05-26; mirror github.com/OpenIPC/u-boot-hi3516cv200), union `U_WBC_G0_CMP`, struct offset 0xA008 (GPL-2.0, same-chip vendor header, byte-identical for Hi3516A V200 and Hi3519 V101). Reset value and access type unknown (modelled RW, no reset). Confidence: medium (vendor header for this chip family, not hardware verified).";

        field {
            name = "cmp_en";
            desc = "[inferred] Compare enable. (vendor header `product/hiosd/vo/hi3519/vou_reg.h` field `cmp_en`; access and reset unknown, modelled RW)";
            sw = rw;
            hw = r;
        } cmp_en[31:31];

        field {
            name = "cmp_drr";
            desc = "[inferred] Compare drr. (vendor header `product/hiosd/vo/hi3519/vou_reg.h` field `cmp_drr`; access and reset unknown, modelled RW)";
            sw = rw;
            hw = r;
        } cmp_drr[7:4];

        field {
            name = "cmp_lossy_en";
            desc = "[inferred] Compare lossy enable. (vendor header `product/hiosd/vo/hi3519/vou_reg.h` field `cmp_lossy_en`; access and reset unknown, modelled RW)";
            sw = rw;
            hw = r;
        } cmp_lossy_en[0:0];
    } WBC_G0_CMP @ 0xA008;

    reg {
        name = "WBC G0 AR address";
        desc = "[inferred] WBC G0 AR address. Not in the data sheet. Source: vendor U-Boot 2010.06 `product/hiosd/vo/hi3519/vou_reg.h` (GPL-2.0 U-Boot tree, HiSilicon copyright, created 2015-05-26; mirror github.com/OpenIPC/u-boot-hi3516cv200), union `U_WBC_G0_AR_ADDR`, struct offset 0xA010 (GPL-2.0, same-chip vendor header, byte-identical for Hi3516A V200 and Hi3519 V101). Reset value and access type unknown (modelled RW, no reset). Confidence: medium (vendor header for this chip family, not hardware verified).";

        field {
            name = "wbcaddr";
            desc = "[inferred] Wbcaddr. (vendor header `product/hiosd/vo/hi3519/vou_reg.h` field `wbcaddr`; access and reset unknown, modelled RW)";
            sw = rw;
            hw = r;
        } wbcaddr[31:0];
    } WBC_G0_AR_ADDR @ 0xA010;

    reg {
        name = "WBC G0 GB address";
        desc = "[inferred] WBC G0 GB address. Not in the data sheet. Source: vendor U-Boot 2010.06 `product/hiosd/vo/hi3519/vou_reg.h` (GPL-2.0 U-Boot tree, HiSilicon copyright, created 2015-05-26; mirror github.com/OpenIPC/u-boot-hi3516cv200), union `U_WBC_G0_GB_ADDR`, struct offset 0xA014 (GPL-2.0, same-chip vendor header, byte-identical for Hi3516A V200 and Hi3519 V101). Reset value and access type unknown (modelled RW, no reset). Confidence: medium (vendor header for this chip family, not hardware verified).";

        field {
            name = "wbccaddr";
            desc = "[inferred] Wbccaddr. (vendor header `product/hiosd/vo/hi3519/vou_reg.h` field `wbccaddr`; access and reset unknown, modelled RW)";
            sw = rw;
            hw = r;
        } wbccaddr[31:0];
    } WBC_G0_GB_ADDR @ 0xA014;

    reg {
        name = "WBC G0 stride";
        desc = "[inferred] WBC G0 stride. Not in the data sheet. Source: vendor U-Boot 2010.06 `product/hiosd/vo/hi3519/vou_reg.h` (GPL-2.0 U-Boot tree, HiSilicon copyright, created 2015-05-26; mirror github.com/OpenIPC/u-boot-hi3516cv200), union `U_WBC_G0_STRIDE`, struct offset 0xA018 (GPL-2.0, same-chip vendor header, byte-identical for Hi3516A V200 and Hi3519 V101). Reset value and access type unknown (modelled RW, no reset). Confidence: medium (vendor header for this chip family, not hardware verified).";

        field {
            name = "wbcstride";
            desc = "[inferred] Wbcstride. (vendor header `product/hiosd/vo/hi3519/vou_reg.h` field `wbcstride`; access and reset unknown, modelled RW)";
            sw = rw;
            hw = r;
        } wbcstride[15:0];
    } WBC_G0_STRIDE @ 0xA018;

    reg {
        name = "WBC G0 OFFSET";
        desc = "[inferred] WBC G0 OFFSET. Not in the data sheet. Source: vendor U-Boot 2010.06 `product/hiosd/vo/hi3519/vou_reg.h` (GPL-2.0 U-Boot tree, HiSilicon copyright, created 2015-05-26; mirror github.com/OpenIPC/u-boot-hi3516cv200), union `U_WBC_G0_OFFSET`, struct offset 0xA01C (GPL-2.0, same-chip vendor header, byte-identical for Hi3516A V200 and Hi3519 V101). Reset value and access type unknown (modelled RW, no reset). Confidence: medium (vendor header for this chip family, not hardware verified).";

        field {
            name = "wbcoffset";
            desc = "[inferred] Wbcoffset. (vendor header `product/hiosd/vo/hi3519/vou_reg.h` field `wbcoffset`; access and reset unknown, modelled RW)";
            sw = rw;
            hw = r;
        } wbcoffset[31:0];
    } WBC_G0_OFFSET @ 0xA01C;

    reg {
        name = "WBC G0 ORESO";
        desc = "[inferred] WBC G0 ORESO. Not in the data sheet. Source: vendor U-Boot 2010.06 `product/hiosd/vo/hi3519/vou_reg.h` (GPL-2.0 U-Boot tree, HiSilicon copyright, created 2015-05-26; mirror github.com/OpenIPC/u-boot-hi3516cv200), union `U_WBC_G0_ORESO`, struct offset 0xA020 (GPL-2.0, same-chip vendor header, byte-identical for Hi3516A V200 and Hi3519 V101). Reset value and access type unknown (modelled RW, no reset). Confidence: medium (vendor header for this chip family, not hardware verified).";

        field {
            name = "oh";
            desc = "[inferred] Oh. (vendor header `product/hiosd/vo/hi3519/vou_reg.h` field `oh`; access and reset unknown, modelled RW)";
            sw = rw;
            hw = r;
        } oh[23:12];

        field {
            name = "ow";
            desc = "[inferred] Ow. (vendor header `product/hiosd/vo/hi3519/vou_reg.h` field `ow`; access and reset unknown, modelled RW)";
            sw = rw;
            hw = r;
        } ow[11:0];
    } WBC_G0_ORESO @ 0xA020;

    reg {
        name = "WBC G0 FCROP";
        desc = "[inferred] WBC G0 FCROP. Not in the data sheet. Source: vendor U-Boot 2010.06 `product/hiosd/vo/hi3519/vou_reg.h` (GPL-2.0 U-Boot tree, HiSilicon copyright, created 2015-05-26; mirror github.com/OpenIPC/u-boot-hi3516cv200), union `U_WBC_G0_FCROP`, struct offset 0xA024 (GPL-2.0, same-chip vendor header, byte-identical for Hi3516A V200 and Hi3519 V101). Reset value and access type unknown (modelled RW, no reset). Confidence: medium (vendor header for this chip family, not hardware verified).";

        field {
            name = "hfcrop";
            desc = "[inferred] Hfcrop. (vendor header `product/hiosd/vo/hi3519/vou_reg.h` field `hfcrop`; access and reset unknown, modelled RW)";
            sw = rw;
            hw = r;
        } hfcrop[23:12];

        field {
            name = "wfcrop";
            desc = "[inferred] Wfcrop. (vendor header `product/hiosd/vo/hi3519/vou_reg.h` field `wfcrop`; access and reset unknown, modelled RW)";
            sw = rw;
            hw = r;
        } wfcrop[11:0];
    } WBC_G0_FCROP @ 0xA024;

    reg {
        name = "WBC G0 LCROP";
        desc = "[inferred] WBC G0 LCROP. Not in the data sheet. Source: vendor U-Boot 2010.06 `product/hiosd/vo/hi3519/vou_reg.h` (GPL-2.0 U-Boot tree, HiSilicon copyright, created 2015-05-26; mirror github.com/OpenIPC/u-boot-hi3516cv200), union `U_WBC_G0_LCROP`, struct offset 0xA028 (GPL-2.0, same-chip vendor header, byte-identical for Hi3516A V200 and Hi3519 V101). Reset value and access type unknown (modelled RW, no reset). Confidence: medium (vendor header for this chip family, not hardware verified).";

        field {
            name = "hlcrop";
            desc = "[inferred] Hlcrop. (vendor header `product/hiosd/vo/hi3519/vou_reg.h` field `hlcrop`; access and reset unknown, modelled RW)";
            sw = rw;
            hw = r;
        } hlcrop[23:12];

        field {
            name = "wlcrop";
            desc = "[inferred] Wlcrop. (vendor header `product/hiosd/vo/hi3519/vou_reg.h` field `wlcrop`; access and reset unknown, modelled RW)";
            sw = rw;
            hw = r;
        } wlcrop[11:0];
    } WBC_G0_LCROP @ 0xA028;

    reg {
        name = "WBC GP0 control";
        desc = "[inferred] WBC GP0 control. Not in the data sheet. Source: vendor U-Boot 2010.06 `product/hiosd/vo/hi3519/vou_reg.h` (GPL-2.0 U-Boot tree, HiSilicon copyright, created 2015-05-26; mirror github.com/OpenIPC/u-boot-hi3516cv200), union `U_WBC_GP0_CTRL`, struct offset 0xA800 (GPL-2.0, same-chip vendor header, byte-identical for Hi3516A V200 and Hi3519 V101). Reset value and access type unknown (modelled RW, no reset). Confidence: medium (vendor header for this chip family, not hardware verified).";

        field {
            name = "wbc_en";
            desc = "[inferred] Wbc enable. (vendor header `product/hiosd/vo/hi3519/vou_reg.h` field `wbc_en`; access and reset unknown, modelled RW)";
            sw = rw;
            hw = r;
        } wbc_en[31:31];

        field {
            name = "uv_order";
            desc = "[inferred] Uv order. (vendor header `product/hiosd/vo/hi3519/vou_reg.h` field `uv_order`; access and reset unknown, modelled RW)";
            sw = rw;
            hw = r;
        } uv_order[30:30];

        field {
            name = "mode_out";
            desc = "[inferred] Mode out. (vendor header `product/hiosd/vo/hi3519/vou_reg.h` field `mode_out`; access and reset unknown, modelled RW)";
            sw = rw;
            hw = r;
        } mode_out[29:28];

        field {
            name = "format_out";
            desc = "[inferred] Format out. (vendor header `product/hiosd/vo/hi3519/vou_reg.h` field `format_out`; access and reset unknown, modelled RW)";
            sw = rw;
            hw = r;
        } format_out[27:24];

        field {
            name = "three_d_mode";
            desc = "[inferred] Three d mode. (vendor header `product/hiosd/vo/hi3519/vou_reg.h` field `three_d_mode`; access and reset unknown, modelled RW)";
            sw = rw;
            hw = r;
        } three_d_mode[19:18];

        field {
            name = "wbc_vtthd_mode";
            desc = "[inferred] Wbc vtthd mode. (vendor header `product/hiosd/vo/hi3519/vou_reg.h` field `wbc_vtthd_mode`; access and reset unknown, modelled RW)";
            sw = rw;
            hw = r;
        } wbc_vtthd_mode[12:12];

        field {
            name = "auto_stop_en";
            desc = "[inferred] Auto stop enable. (vendor header `product/hiosd/vo/hi3519/vou_reg.h` field `auto_stop_en`; access and reset unknown, modelled RW)";
            sw = rw;
            hw = r;
        } auto_stop_en[10:10];

        field {
            name = "req_interval";
            desc = "[inferred] Request interval. (vendor header `product/hiosd/vo/hi3519/vou_reg.h` field `req_interval`; access and reset unknown, modelled RW)";
            sw = rw;
            hw = r;
        } req_interval[9:0];
    } WBC_GP0_CTRL @ 0xA800;

    reg {
        name = "WBC GP0 update";
        desc = "[inferred] WBC GP0 update. Not in the data sheet. Source: vendor U-Boot 2010.06 `product/hiosd/vo/hi3519/vou_reg.h` (GPL-2.0 U-Boot tree, HiSilicon copyright, created 2015-05-26; mirror github.com/OpenIPC/u-boot-hi3516cv200), union `U_WBC_GP0_UPD`, struct offset 0xA804 (GPL-2.0, same-chip vendor header, byte-identical for Hi3516A V200 and Hi3519 V101). Reset value and access type unknown (modelled RW, no reset). Confidence: medium (vendor header for this chip family, not hardware verified).";

        field {
            name = "regup";
            desc = "[inferred] Regup. (vendor header `product/hiosd/vo/hi3519/vou_reg.h` field `regup`; access and reset unknown, modelled RW)";
            sw = rw;
            hw = r;
        } regup[0:0];
    } WBC_GP0_UPD @ 0xA804;

    reg {
        name = "WBC GP0 YADDR";
        desc = "[inferred] WBC GP0 YADDR. Not in the data sheet. Source: vendor U-Boot 2010.06 `product/hiosd/vo/hi3519/vou_reg.h` (GPL-2.0 U-Boot tree, HiSilicon copyright, created 2015-05-26; mirror github.com/OpenIPC/u-boot-hi3516cv200), union `U_WBC_GP0_YADDR`, struct offset 0xA810 (GPL-2.0, same-chip vendor header, byte-identical for Hi3516A V200 and Hi3519 V101). Reset value and access type unknown (modelled RW, no reset). Confidence: medium (vendor header for this chip family, not hardware verified).";

        field {
            name = "wbcaddr";
            desc = "[inferred] Wbcaddr. (vendor header `product/hiosd/vo/hi3519/vou_reg.h` field `wbcaddr`; access and reset unknown, modelled RW)";
            sw = rw;
            hw = r;
        } wbcaddr[31:0];
    } WBC_GP0_YADDR @ 0xA810;

    reg {
        name = "WBC GP0 CADDR";
        desc = "[inferred] WBC GP0 CADDR. Not in the data sheet. Source: vendor U-Boot 2010.06 `product/hiosd/vo/hi3519/vou_reg.h` (GPL-2.0 U-Boot tree, HiSilicon copyright, created 2015-05-26; mirror github.com/OpenIPC/u-boot-hi3516cv200), union `U_WBC_GP0_CADDR`, struct offset 0xA814 (GPL-2.0, same-chip vendor header, byte-identical for Hi3516A V200 and Hi3519 V101). Reset value and access type unknown (modelled RW, no reset). Confidence: medium (vendor header for this chip family, not hardware verified).";

        field {
            name = "wbccaddr";
            desc = "[inferred] Wbccaddr. (vendor header `product/hiosd/vo/hi3519/vou_reg.h` field `wbccaddr`; access and reset unknown, modelled RW)";
            sw = rw;
            hw = r;
        } wbccaddr[31:0];
    } WBC_GP0_CADDR @ 0xA814;

    reg {
        name = "WBC GP0 stride";
        desc = "[inferred] WBC GP0 stride. Not in the data sheet. Source: vendor U-Boot 2010.06 `product/hiosd/vo/hi3519/vou_reg.h` (GPL-2.0 U-Boot tree, HiSilicon copyright, created 2015-05-26; mirror github.com/OpenIPC/u-boot-hi3516cv200), union `U_WBC_GP0_STRIDE`, struct offset 0xA818 (GPL-2.0, same-chip vendor header, byte-identical for Hi3516A V200 and Hi3519 V101). Reset value and access type unknown (modelled RW, no reset). Confidence: medium (vendor header for this chip family, not hardware verified).";

        field {
            name = "wbccstride";
            desc = "[inferred] Wbccstride. (vendor header `product/hiosd/vo/hi3519/vou_reg.h` field `wbccstride`; access and reset unknown, modelled RW)";
            sw = rw;
            hw = r;
        } wbccstride[31:16];

        field {
            name = "wbclstride";
            desc = "[inferred] Wbclstride. (vendor header `product/hiosd/vo/hi3519/vou_reg.h` field `wbclstride`; access and reset unknown, modelled RW)";
            sw = rw;
            hw = r;
        } wbclstride[15:0];
    } WBC_GP0_STRIDE @ 0xA818;

    reg {
        name = "WBC GP0 ORESO";
        desc = "[inferred] WBC GP0 ORESO. Not in the data sheet. Source: vendor U-Boot 2010.06 `product/hiosd/vo/hi3519/vou_reg.h` (GPL-2.0 U-Boot tree, HiSilicon copyright, created 2015-05-26; mirror github.com/OpenIPC/u-boot-hi3516cv200), union `U_WBC_GP0_ORESO`, struct offset 0xA820 (GPL-2.0, same-chip vendor header, byte-identical for Hi3516A V200 and Hi3519 V101). Reset value and access type unknown (modelled RW, no reset). Confidence: medium (vendor header for this chip family, not hardware verified).";

        field {
            name = "oh";
            desc = "[inferred] Oh. (vendor header `product/hiosd/vo/hi3519/vou_reg.h` field `oh`; access and reset unknown, modelled RW)";
            sw = rw;
            hw = r;
        } oh[23:12];

        field {
            name = "ow";
            desc = "[inferred] Ow. (vendor header `product/hiosd/vo/hi3519/vou_reg.h` field `ow`; access and reset unknown, modelled RW)";
            sw = rw;
            hw = r;
        } ow[11:0];
    } WBC_GP0_ORESO @ 0xA820;

    reg {
        name = "WBC GP0 FCROP";
        desc = "[inferred] WBC GP0 FCROP. Not in the data sheet. Source: vendor U-Boot 2010.06 `product/hiosd/vo/hi3519/vou_reg.h` (GPL-2.0 U-Boot tree, HiSilicon copyright, created 2015-05-26; mirror github.com/OpenIPC/u-boot-hi3516cv200), union `U_WBC_GP0_FCROP`, struct offset 0xA824 (GPL-2.0, same-chip vendor header, byte-identical for Hi3516A V200 and Hi3519 V101). Reset value and access type unknown (modelled RW, no reset). Confidence: medium (vendor header for this chip family, not hardware verified).";

        field {
            name = "hfcrop";
            desc = "[inferred] Hfcrop. (vendor header `product/hiosd/vo/hi3519/vou_reg.h` field `hfcrop`; access and reset unknown, modelled RW)";
            sw = rw;
            hw = r;
        } hfcrop[23:12];

        field {
            name = "wfcrop";
            desc = "[inferred] Wfcrop. (vendor header `product/hiosd/vo/hi3519/vou_reg.h` field `wfcrop`; access and reset unknown, modelled RW)";
            sw = rw;
            hw = r;
        } wfcrop[11:0];
    } WBC_GP0_FCROP @ 0xA824;

    reg {
        name = "WBC GP0 LCROP";
        desc = "[inferred] WBC GP0 LCROP. Not in the data sheet. Source: vendor U-Boot 2010.06 `product/hiosd/vo/hi3519/vou_reg.h` (GPL-2.0 U-Boot tree, HiSilicon copyright, created 2015-05-26; mirror github.com/OpenIPC/u-boot-hi3516cv200), union `U_WBC_GP0_LCROP`, struct offset 0xA828 (GPL-2.0, same-chip vendor header, byte-identical for Hi3516A V200 and Hi3519 V101). Reset value and access type unknown (modelled RW, no reset). Confidence: medium (vendor header for this chip family, not hardware verified).";

        field {
            name = "hlcrop";
            desc = "[inferred] Hlcrop. (vendor header `product/hiosd/vo/hi3519/vou_reg.h` field `hlcrop`; access and reset unknown, modelled RW)";
            sw = rw;
            hw = r;
        } hlcrop[23:12];

        field {
            name = "wlcrop";
            desc = "[inferred] Wlcrop. (vendor header `product/hiosd/vo/hi3519/vou_reg.h` field `wlcrop`; access and reset unknown, modelled RW)";
            sw = rw;
            hw = r;
        } wlcrop[11:0];
    } WBC_GP0_LCROP @ 0xA828;

    reg {
        name = "WBC GP0 dither control";
        desc = "[inferred] WBC GP0 dither control. Not in the data sheet. Source: vendor U-Boot 2010.06 `product/hiosd/vo/hi3519/vou_reg.h` (GPL-2.0 U-Boot tree, HiSilicon copyright, created 2015-05-26; mirror github.com/OpenIPC/u-boot-hi3516cv200), union `U_WBC_GP0_DITHER_CTRL`, struct offset 0xA900 (GPL-2.0, same-chip vendor header, byte-identical for Hi3516A V200 and Hi3519 V101). Reset value and access type unknown (modelled RW, no reset). Confidence: medium (vendor header for this chip family, not hardware verified).";

        field {
            name = "dither_md";
            desc = "[inferred] Dither md. (vendor header `product/hiosd/vo/hi3519/vou_reg.h` field `dither_md`; access and reset unknown, modelled RW)";
            sw = rw;
            hw = r;
        } dither_md[31:29];
    } WBC_GP0_DITHER_CTRL @ 0xA900;

    reg {
        name = "WBC GP0 dither COEF0";
        desc = "[inferred] WBC GP0 dither COEF0. Not in the data sheet. Source: vendor U-Boot 2010.06 `product/hiosd/vo/hi3519/vou_reg.h` (GPL-2.0 U-Boot tree, HiSilicon copyright, created 2015-05-26; mirror github.com/OpenIPC/u-boot-hi3516cv200), union `U_WBC_GP0_DITHER_COEF0`, struct offset 0xA904 (GPL-2.0, same-chip vendor header, byte-identical for Hi3516A V200 and Hi3519 V101). Reset value and access type unknown (modelled RW, no reset). Confidence: medium (vendor header for this chip family, not hardware verified).";

        field {
            name = "dither_coef3";
            desc = "[inferred] Dither coef3. (vendor header `product/hiosd/vo/hi3519/vou_reg.h` field `dither_coef3`; access and reset unknown, modelled RW)";
            sw = rw;
            hw = r;
        } dither_coef3[31:24];

        field {
            name = "dither_coef2";
            desc = "[inferred] Dither coef2. (vendor header `product/hiosd/vo/hi3519/vou_reg.h` field `dither_coef2`; access and reset unknown, modelled RW)";
            sw = rw;
            hw = r;
        } dither_coef2[23:16];

        field {
            name = "dither_coef1";
            desc = "[inferred] Dither coef1. (vendor header `product/hiosd/vo/hi3519/vou_reg.h` field `dither_coef1`; access and reset unknown, modelled RW)";
            sw = rw;
            hw = r;
        } dither_coef1[15:8];

        field {
            name = "dither_coef0";
            desc = "[inferred] Dither coef0. (vendor header `product/hiosd/vo/hi3519/vou_reg.h` field `dither_coef0`; access and reset unknown, modelled RW)";
            sw = rw;
            hw = r;
        } dither_coef0[7:0];
    } WBC_GP0_DITHER_COEF0 @ 0xA904;

    reg {
        name = "WBC GP0 dither COEF1";
        desc = "[inferred] WBC GP0 dither COEF1. Not in the data sheet. Source: vendor U-Boot 2010.06 `product/hiosd/vo/hi3519/vou_reg.h` (GPL-2.0 U-Boot tree, HiSilicon copyright, created 2015-05-26; mirror github.com/OpenIPC/u-boot-hi3516cv200), union `U_WBC_GP0_DITHER_COEF1`, struct offset 0xA908 (GPL-2.0, same-chip vendor header, byte-identical for Hi3516A V200 and Hi3519 V101). Reset value and access type unknown (modelled RW, no reset). Confidence: medium (vendor header for this chip family, not hardware verified).";

        field {
            name = "dither_coef7";
            desc = "[inferred] Dither coef7. (vendor header `product/hiosd/vo/hi3519/vou_reg.h` field `dither_coef7`; access and reset unknown, modelled RW)";
            sw = rw;
            hw = r;
        } dither_coef7[31:24];

        field {
            name = "dither_coef6";
            desc = "[inferred] Dither coef6. (vendor header `product/hiosd/vo/hi3519/vou_reg.h` field `dither_coef6`; access and reset unknown, modelled RW)";
            sw = rw;
            hw = r;
        } dither_coef6[23:16];

        field {
            name = "dither_coef5";
            desc = "[inferred] Dither coef5. (vendor header `product/hiosd/vo/hi3519/vou_reg.h` field `dither_coef5`; access and reset unknown, modelled RW)";
            sw = rw;
            hw = r;
        } dither_coef5[15:8];

        field {
            name = "dither_coef4";
            desc = "[inferred] Dither coef4. (vendor header `product/hiosd/vo/hi3519/vou_reg.h` field `dither_coef4`; access and reset unknown, modelled RW)";
            sw = rw;
            hw = r;
        } dither_coef4[7:0];
    } WBC_GP0_DITHER_COEF1 @ 0xA908;

    reg {
        name = "WBC DHD0 control";
        desc = "[inferred] WBC DHD0 control. Not in the data sheet. Source: vendor U-Boot 2010.06 `product/hiosd/vo/hi3519/vou_reg.h` (GPL-2.0 U-Boot tree, HiSilicon copyright, created 2015-05-26; mirror github.com/OpenIPC/u-boot-hi3516cv200), union `U_WBC_DHD0_CTRL`, struct offset 0xAC00 (GPL-2.0, same-chip vendor header, byte-identical for Hi3516A V200 and Hi3519 V101). Reset value and access type unknown (modelled RW, no reset). Confidence: medium (vendor header for this chip family, not hardware verified).";

        field {
            name = "wbc_en";
            desc = "[inferred] Wbc enable. (vendor header `product/hiosd/vo/hi3519/vou_reg.h` field `wbc_en`; access and reset unknown, modelled RW)";
            sw = rw;
            hw = r;
        } wbc_en[31:31];

        field {
            name = "uv_order";
            desc = "[inferred] Uv order. (vendor header `product/hiosd/vo/hi3519/vou_reg.h` field `uv_order`; access and reset unknown, modelled RW)";
            sw = rw;
            hw = r;
        } uv_order[30:30];

        field {
            name = "mode_out";
            desc = "[inferred] Mode out. (vendor header `product/hiosd/vo/hi3519/vou_reg.h` field `mode_out`; access and reset unknown, modelled RW)";
            sw = rw;
            hw = r;
        } mode_out[29:28];

        field {
            name = "format_out";
            desc = "[inferred] Format out. (vendor header `product/hiosd/vo/hi3519/vou_reg.h` field `format_out`; access and reset unknown, modelled RW)";
            sw = rw;
            hw = r;
        } format_out[27:24];

        field {
            name = "three_d_mode";
            desc = "[inferred] Three d mode. (vendor header `product/hiosd/vo/hi3519/vou_reg.h` field `three_d_mode`; access and reset unknown, modelled RW)";
            sw = rw;
            hw = r;
        } three_d_mode[19:18];

        field {
            name = "wbc_vtthd_mode";
            desc = "[inferred] Wbc vtthd mode. (vendor header `product/hiosd/vo/hi3519/vou_reg.h` field `wbc_vtthd_mode`; access and reset unknown, modelled RW)";
            sw = rw;
            hw = r;
        } wbc_vtthd_mode[12:12];

        field {
            name = "histogam_en";
            desc = "[inferred] Histogam enable. (vendor header `product/hiosd/vo/hi3519/vou_reg.h` field `histogam_en`; access and reset unknown, modelled RW)";
            sw = rw;
            hw = r;
        } histogam_en[11:11];

        field {
            name = "auto_stop_en";
            desc = "[inferred] Auto stop enable. (vendor header `product/hiosd/vo/hi3519/vou_reg.h` field `auto_stop_en`; access and reset unknown, modelled RW)";
            sw = rw;
            hw = r;
        } auto_stop_en[10:10];

        field {
            name = "req_interval";
            desc = "[inferred] Request interval. (vendor header `product/hiosd/vo/hi3519/vou_reg.h` field `req_interval`; access and reset unknown, modelled RW)";
            sw = rw;
            hw = r;
        } req_interval[9:0];
    } WBC_DHD0_CTRL @ 0xAC00;

    reg {
        name = "WBC DHD0 update";
        desc = "[inferred] WBC DHD0 update. Not in the data sheet. Source: vendor U-Boot 2010.06 `product/hiosd/vo/hi3519/vou_reg.h` (GPL-2.0 U-Boot tree, HiSilicon copyright, created 2015-05-26; mirror github.com/OpenIPC/u-boot-hi3516cv200), union `U_WBC_DHD0_UPD`, struct offset 0xAC04 (GPL-2.0, same-chip vendor header, byte-identical for Hi3516A V200 and Hi3519 V101). Reset value and access type unknown (modelled RW, no reset). Confidence: medium (vendor header for this chip family, not hardware verified).";

        field {
            name = "regup";
            desc = "[inferred] Regup. (vendor header `product/hiosd/vo/hi3519/vou_reg.h` field `regup`; access and reset unknown, modelled RW)";
            sw = rw;
            hw = r;
        } regup[0:0];
    } WBC_DHD0_UPD @ 0xAC04;

    reg {
        name = "WBC DHD0 YADDR";
        desc = "[inferred] WBC DHD0 YADDR. Not in the data sheet. Source: vendor U-Boot 2010.06 `product/hiosd/vo/hi3519/vou_reg.h` (GPL-2.0 U-Boot tree, HiSilicon copyright, created 2015-05-26; mirror github.com/OpenIPC/u-boot-hi3516cv200), union `U_WBC_DHD0_YADDR`, struct offset 0xAC10 (GPL-2.0, same-chip vendor header, byte-identical for Hi3516A V200 and Hi3519 V101). Reset value and access type unknown (modelled RW, no reset). Confidence: medium (vendor header for this chip family, not hardware verified).";

        field {
            name = "wbcaddr";
            desc = "[inferred] Wbcaddr. (vendor header `product/hiosd/vo/hi3519/vou_reg.h` field `wbcaddr`; access and reset unknown, modelled RW)";
            sw = rw;
            hw = r;
        } wbcaddr[31:0];
    } WBC_DHD0_YADDR @ 0xAC10;

    reg {
        name = "WBC DHD0 CADDR";
        desc = "[inferred] WBC DHD0 CADDR. Not in the data sheet. Source: vendor U-Boot 2010.06 `product/hiosd/vo/hi3519/vou_reg.h` (GPL-2.0 U-Boot tree, HiSilicon copyright, created 2015-05-26; mirror github.com/OpenIPC/u-boot-hi3516cv200), union `U_WBC_DHD0_CADDR`, struct offset 0xAC14 (GPL-2.0, same-chip vendor header, byte-identical for Hi3516A V200 and Hi3519 V101). Reset value and access type unknown (modelled RW, no reset). Confidence: medium (vendor header for this chip family, not hardware verified).";

        field {
            name = "wbccaddr";
            desc = "[inferred] Wbccaddr. (vendor header `product/hiosd/vo/hi3519/vou_reg.h` field `wbccaddr`; access and reset unknown, modelled RW)";
            sw = rw;
            hw = r;
        } wbccaddr[31:0];
    } WBC_DHD0_CADDR @ 0xAC14;

    reg {
        name = "WBC DHD0 stride";
        desc = "[inferred] WBC DHD0 stride. Not in the data sheet. Source: vendor U-Boot 2010.06 `product/hiosd/vo/hi3519/vou_reg.h` (GPL-2.0 U-Boot tree, HiSilicon copyright, created 2015-05-26; mirror github.com/OpenIPC/u-boot-hi3516cv200), union `U_WBC_DHD0_STRIDE`, struct offset 0xAC18 (GPL-2.0, same-chip vendor header, byte-identical for Hi3516A V200 and Hi3519 V101). Reset value and access type unknown (modelled RW, no reset). Confidence: medium (vendor header for this chip family, not hardware verified).";

        field {
            name = "wbccstride";
            desc = "[inferred] Wbccstride. (vendor header `product/hiosd/vo/hi3519/vou_reg.h` field `wbccstride`; access and reset unknown, modelled RW)";
            sw = rw;
            hw = r;
        } wbccstride[31:16];

        field {
            name = "wbclstride";
            desc = "[inferred] Wbclstride. (vendor header `product/hiosd/vo/hi3519/vou_reg.h` field `wbclstride`; access and reset unknown, modelled RW)";
            sw = rw;
            hw = r;
        } wbclstride[15:0];
    } WBC_DHD0_STRIDE @ 0xAC18;

    reg {
        name = "WBC DHD0 ORESO";
        desc = "[inferred] WBC DHD0 ORESO. Not in the data sheet. Source: vendor U-Boot 2010.06 `product/hiosd/vo/hi3519/vou_reg.h` (GPL-2.0 U-Boot tree, HiSilicon copyright, created 2015-05-26; mirror github.com/OpenIPC/u-boot-hi3516cv200), union `U_WBC_DHD0_ORESO`, struct offset 0xAC20 (GPL-2.0, same-chip vendor header, byte-identical for Hi3516A V200 and Hi3519 V101). Reset value and access type unknown (modelled RW, no reset). Confidence: medium (vendor header for this chip family, not hardware verified).";

        field {
            name = "oh";
            desc = "[inferred] Oh. (vendor header `product/hiosd/vo/hi3519/vou_reg.h` field `oh`; access and reset unknown, modelled RW)";
            sw = rw;
            hw = r;
        } oh[23:12];

        field {
            name = "ow";
            desc = "[inferred] Ow. (vendor header `product/hiosd/vo/hi3519/vou_reg.h` field `ow`; access and reset unknown, modelled RW)";
            sw = rw;
            hw = r;
        } ow[11:0];
    } WBC_DHD0_ORESO @ 0xAC20;

    reg {
        name = "WBC DHD0 FCROP";
        desc = "[inferred] WBC DHD0 FCROP. Not in the data sheet. Source: vendor U-Boot 2010.06 `product/hiosd/vo/hi3519/vou_reg.h` (GPL-2.0 U-Boot tree, HiSilicon copyright, created 2015-05-26; mirror github.com/OpenIPC/u-boot-hi3516cv200), union `U_WBC_DHD0_FCROP`, struct offset 0xAC24 (GPL-2.0, same-chip vendor header, byte-identical for Hi3516A V200 and Hi3519 V101). Reset value and access type unknown (modelled RW, no reset). Confidence: medium (vendor header for this chip family, not hardware verified).";

        field {
            name = "hfcrop";
            desc = "[inferred] Hfcrop. (vendor header `product/hiosd/vo/hi3519/vou_reg.h` field `hfcrop`; access and reset unknown, modelled RW)";
            sw = rw;
            hw = r;
        } hfcrop[23:12];

        field {
            name = "wfcrop";
            desc = "[inferred] Wfcrop. (vendor header `product/hiosd/vo/hi3519/vou_reg.h` field `wfcrop`; access and reset unknown, modelled RW)";
            sw = rw;
            hw = r;
        } wfcrop[11:0];
    } WBC_DHD0_FCROP @ 0xAC24;

    reg {
        name = "WBC DHD0 LCROP";
        desc = "[inferred] WBC DHD0 LCROP. Not in the data sheet. Source: vendor U-Boot 2010.06 `product/hiosd/vo/hi3519/vou_reg.h` (GPL-2.0 U-Boot tree, HiSilicon copyright, created 2015-05-26; mirror github.com/OpenIPC/u-boot-hi3516cv200), union `U_WBC_DHD0_LCROP`, struct offset 0xAC28 (GPL-2.0, same-chip vendor header, byte-identical for Hi3516A V200 and Hi3519 V101). Reset value and access type unknown (modelled RW, no reset). Confidence: medium (vendor header for this chip family, not hardware verified).";

        field {
            name = "hlcrop";
            desc = "[inferred] Hlcrop. (vendor header `product/hiosd/vo/hi3519/vou_reg.h` field `hlcrop`; access and reset unknown, modelled RW)";
            sw = rw;
            hw = r;
        } hlcrop[23:12];

        field {
            name = "wlcrop";
            desc = "[inferred] Wlcrop. (vendor header `product/hiosd/vo/hi3519/vou_reg.h` field `wlcrop`; access and reset unknown, modelled RW)";
            sw = rw;
            hw = r;
        } wlcrop[11:0];
    } WBC_DHD0_LCROP @ 0xAC28;

    reg {
        name = "WBC DHD0 LOWDLYCTRL";
        desc = "[inferred] WBC DHD0 LOWDLYCTRL. Not in the data sheet. Source: vendor U-Boot 2010.06 `product/hiosd/vo/hi3519/vou_reg.h` (GPL-2.0 U-Boot tree, HiSilicon copyright, created 2015-05-26; mirror github.com/OpenIPC/u-boot-hi3516cv200), union `U_WBC_DHD0_LOWDLYCTRL`, struct offset 0xAC30 (GPL-2.0, same-chip vendor header, byte-identical for Hi3516A V200 and Hi3519 V101). Reset value and access type unknown (modelled RW, no reset). Confidence: medium (vendor header for this chip family, not hardware verified).";

        field {
            name = "lowdly_en";
            desc = "[inferred] Lowdly enable. (vendor header `product/hiosd/vo/hi3519/vou_reg.h` field `lowdly_en`; access and reset unknown, modelled RW)";
            sw = rw;
            hw = r;
        } lowdly_en[31:31];

        field {
            name = "lowdly_test";
            desc = "[inferred] Lowdly test. (vendor header `product/hiosd/vo/hi3519/vou_reg.h` field `lowdly_test`; access and reset unknown, modelled RW)";
            sw = rw;
            hw = r;
        } lowdly_test[30:30];

        field {
            name = "partfns_line_num";
            desc = "[inferred] Partfns line number. (vendor header `product/hiosd/vo/hi3519/vou_reg.h` field `partfns_line_num`; access and reset unknown, modelled RW)";
            sw = rw;
            hw = r;
        } partfns_line_num[23:12];

        field {
            name = "wb_per_line_num";
            desc = "[inferred] Wb per line number. (vendor header `product/hiosd/vo/hi3519/vou_reg.h` field `wb_per_line_num`; access and reset unknown, modelled RW)";
            sw = rw;
            hw = r;
        } wb_per_line_num[11:0];
    } WBC_DHD0_LOWDLYCTRL @ 0xAC30;

    reg {
        name = "WBC DHD0 TUNLADDR";
        desc = "[inferred] WBC DHD0 TUNLADDR. Not in the data sheet. Source: vendor U-Boot 2010.06 `product/hiosd/vo/hi3519/vou_reg.h` (GPL-2.0 U-Boot tree, HiSilicon copyright, created 2015-05-26; mirror github.com/OpenIPC/u-boot-hi3516cv200), union `U_WBC_DHD0_TUNLADDR`, struct offset 0xAC34 (GPL-2.0, same-chip vendor header, byte-identical for Hi3516A V200 and Hi3519 V101). Reset value and access type unknown (modelled RW, no reset). Confidence: medium (vendor header for this chip family, not hardware verified).";

        field {
            name = "tunl_cell_addr";
            desc = "[inferred] Tunl cell address. (vendor header `product/hiosd/vo/hi3519/vou_reg.h` field `tunl_cell_addr`; access and reset unknown, modelled RW)";
            sw = rw;
            hw = r;
        } tunl_cell_addr[31:0];
    } WBC_DHD0_TUNLADDR @ 0xAC34;

    reg {
        name = "WBC DHD0 LOWDLYSTA";
        desc = "[inferred] WBC DHD0 LOWDLYSTA. Not in the data sheet. Source: vendor U-Boot 2010.06 `product/hiosd/vo/hi3519/vou_reg.h` (GPL-2.0 U-Boot tree, HiSilicon copyright, created 2015-05-26; mirror github.com/OpenIPC/u-boot-hi3516cv200), union `U_WBC_DHD0_LOWDLYSTA`, struct offset 0xAC38 (GPL-2.0, same-chip vendor header, byte-identical for Hi3516A V200 and Hi3519 V101). Reset value and access type unknown (modelled RW, no reset). Confidence: medium (vendor header for this chip family, not hardware verified).";

        field {
            name = "part_finish";
            desc = "[inferred] Part finish. (vendor header `product/hiosd/vo/hi3519/vou_reg.h` field `part_finish`; access and reset unknown, modelled RW)";
            sw = rw;
            hw = r;
        } part_finish[31:31];
    } WBC_DHD0_LOWDLYSTA @ 0xAC38;

    reg {
        name = "WBC DHD0 PARAUP";
        desc = "[inferred] WBC DHD0 PARAUP. Not in the data sheet. Source: vendor U-Boot 2010.06 `product/hiosd/vo/hi3519/vou_reg.h` (GPL-2.0 U-Boot tree, HiSilicon copyright, created 2015-05-26; mirror github.com/OpenIPC/u-boot-hi3516cv200), union `U_WBC_DHD0_PARAUP`, struct offset 0xAC40 (GPL-2.0, same-chip vendor header, byte-identical for Hi3516A V200 and Hi3519 V101). Reset value and access type unknown (modelled RW, no reset). Confidence: medium (vendor header for this chip family, not hardware verified).";

        field {
            name = "wbc_vccoef_upd";
            desc = "[inferred] Wbc vccoef update. (vendor header `product/hiosd/vo/hi3519/vou_reg.h` field `wbc_vccoef_upd`; access and reset unknown, modelled RW)";
            sw = rw;
            hw = r;
        } wbc_vccoef_upd[3:3];

        field {
            name = "wbc_vlcoef_upd";
            desc = "[inferred] Wbc vlcoef update. (vendor header `product/hiosd/vo/hi3519/vou_reg.h` field `wbc_vlcoef_upd`; access and reset unknown, modelled RW)";
            sw = rw;
            hw = r;
        } wbc_vlcoef_upd[2:2];

        field {
            name = "wbc_hccoef_upd";
            desc = "[inferred] Wbc hccoef update. (vendor header `product/hiosd/vo/hi3519/vou_reg.h` field `wbc_hccoef_upd`; access and reset unknown, modelled RW)";
            sw = rw;
            hw = r;
        } wbc_hccoef_upd[1:1];

        field {
            name = "wbc_hlcoef_upd";
            desc = "[inferred] Wbc hlcoef update. (vendor header `product/hiosd/vo/hi3519/vou_reg.h` field `wbc_hlcoef_upd`; access and reset unknown, modelled RW)";
            sw = rw;
            hw = r;
        } wbc_hlcoef_upd[0:0];
    } WBC_DHD0_PARAUP @ 0xAC40;

    reg {
        name = "WBC DHD0 HLCOEFAD";
        desc = "[inferred] WBC DHD0 HLCOEFAD. Not in the data sheet. Source: vendor U-Boot 2010.06 `product/hiosd/vo/hi3519/vou_reg.h` (GPL-2.0 U-Boot tree, HiSilicon copyright, created 2015-05-26; mirror github.com/OpenIPC/u-boot-hi3516cv200), union `U_WBC_DHD0_HLCOEFAD`, struct offset 0xAC50 (GPL-2.0, same-chip vendor header, byte-identical for Hi3516A V200 and Hi3519 V101). Reset value and access type unknown (modelled RW, no reset). Confidence: medium (vendor header for this chip family, not hardware verified).";

        field {
            name = "coef_addr";
            desc = "[inferred] Coefficient address. (vendor header `product/hiosd/vo/hi3519/vou_reg.h` field `coef_addr`; access and reset unknown, modelled RW)";
            sw = rw;
            hw = r;
        } coef_addr[31:0];
    } WBC_DHD0_HLCOEFAD @ 0xAC50;

    reg {
        name = "WBC DHD0 HCCOEFAD";
        desc = "[inferred] WBC DHD0 HCCOEFAD. Not in the data sheet. Source: vendor U-Boot 2010.06 `product/hiosd/vo/hi3519/vou_reg.h` (GPL-2.0 U-Boot tree, HiSilicon copyright, created 2015-05-26; mirror github.com/OpenIPC/u-boot-hi3516cv200), union `U_WBC_DHD0_HCCOEFAD`, struct offset 0xAC54 (GPL-2.0, same-chip vendor header, byte-identical for Hi3516A V200 and Hi3519 V101). Reset value and access type unknown (modelled RW, no reset). Confidence: medium (vendor header for this chip family, not hardware verified).";

        field {
            name = "coef_addr";
            desc = "[inferred] Coefficient address. (vendor header `product/hiosd/vo/hi3519/vou_reg.h` field `coef_addr`; access and reset unknown, modelled RW)";
            sw = rw;
            hw = r;
        } coef_addr[31:0];
    } WBC_DHD0_HCCOEFAD @ 0xAC54;

    reg {
        name = "WBC DHD0 VLCOEFAD";
        desc = "[inferred] WBC DHD0 VLCOEFAD. Not in the data sheet. Source: vendor U-Boot 2010.06 `product/hiosd/vo/hi3519/vou_reg.h` (GPL-2.0 U-Boot tree, HiSilicon copyright, created 2015-05-26; mirror github.com/OpenIPC/u-boot-hi3516cv200), union `U_WBC_DHD0_VLCOEFAD`, struct offset 0xAC58 (GPL-2.0, same-chip vendor header, byte-identical for Hi3516A V200 and Hi3519 V101). Reset value and access type unknown (modelled RW, no reset). Confidence: medium (vendor header for this chip family, not hardware verified).";

        field {
            name = "coef_addr";
            desc = "[inferred] Coefficient address. (vendor header `product/hiosd/vo/hi3519/vou_reg.h` field `coef_addr`; access and reset unknown, modelled RW)";
            sw = rw;
            hw = r;
        } coef_addr[31:0];
    } WBC_DHD0_VLCOEFAD @ 0xAC58;

    reg {
        name = "WBC DHD0 VCCOEFAD";
        desc = "[inferred] WBC DHD0 VCCOEFAD. Not in the data sheet. Source: vendor U-Boot 2010.06 `product/hiosd/vo/hi3519/vou_reg.h` (GPL-2.0 U-Boot tree, HiSilicon copyright, created 2015-05-26; mirror github.com/OpenIPC/u-boot-hi3516cv200), union `U_WBC_DHD0_VCCOEFAD`, struct offset 0xAC5C (GPL-2.0, same-chip vendor header, byte-identical for Hi3516A V200 and Hi3519 V101). Reset value and access type unknown (modelled RW, no reset). Confidence: medium (vendor header for this chip family, not hardware verified).";

        field {
            name = "coef_addr";
            desc = "[inferred] Coefficient address. (vendor header `product/hiosd/vo/hi3519/vou_reg.h` field `coef_addr`; access and reset unknown, modelled RW)";
            sw = rw;
            hw = r;
        } coef_addr[31:0];
    } WBC_DHD0_VCCOEFAD @ 0xAC5C;

    reg {
        name = "WBC DHD0 HISTOGRAM0";
        desc = "[inferred] WBC DHD0 HISTOGRAM0. Not in the data sheet. Source: vendor U-Boot 2010.06 `product/hiosd/vo/hi3519/vou_reg.h` (GPL-2.0 U-Boot tree, HiSilicon copyright, created 2015-05-26; mirror github.com/OpenIPC/u-boot-hi3516cv200), union `U_WBC_DHD0_HISTOGRAM0`, struct offset 0xACA0 (GPL-2.0, same-chip vendor header, byte-identical for Hi3516A V200 and Hi3519 V101). Reset value and access type unknown (modelled RW, no reset). Confidence: medium (vendor header for this chip family, not hardware verified).";

        field {
            name = "hgram_cnt0";
            desc = "[inferred] Hgram cnt0. (vendor header `product/hiosd/vo/hi3519/vou_reg.h` field `hgram_cnt0`; access and reset unknown, modelled RW)";
            sw = rw;
            hw = r;
        } hgram_cnt0[23:0];
    } WBC_DHD0_HISTOGRAM0 @ 0xACA0;

    reg {
        name = "WBC DHD0 HISTOGRAM1";
        desc = "[inferred] WBC DHD0 HISTOGRAM1. Not in the data sheet. Source: vendor U-Boot 2010.06 `product/hiosd/vo/hi3519/vou_reg.h` (GPL-2.0 U-Boot tree, HiSilicon copyright, created 2015-05-26; mirror github.com/OpenIPC/u-boot-hi3516cv200), union `U_WBC_DHD0_HISTOGRAM1`, struct offset 0xACA4 (GPL-2.0, same-chip vendor header, byte-identical for Hi3516A V200 and Hi3519 V101). Reset value and access type unknown (modelled RW, no reset). Confidence: medium (vendor header for this chip family, not hardware verified).";

        field {
            name = "hgram_cnt0";
            desc = "[inferred] Hgram cnt0. (vendor header `product/hiosd/vo/hi3519/vou_reg.h` field `hgram_cnt0`; access and reset unknown, modelled RW)";
            sw = rw;
            hw = r;
        } hgram_cnt0[23:0];
    } WBC_DHD0_HISTOGRAM1 @ 0xACA4;

    reg {
        name = "WBC DHD0 HISTOGRAM2";
        desc = "[inferred] WBC DHD0 HISTOGRAM2. Not in the data sheet. Source: vendor U-Boot 2010.06 `product/hiosd/vo/hi3519/vou_reg.h` (GPL-2.0 U-Boot tree, HiSilicon copyright, created 2015-05-26; mirror github.com/OpenIPC/u-boot-hi3516cv200), union `U_WBC_DHD0_HISTOGRAM2`, struct offset 0xACA8 (GPL-2.0, same-chip vendor header, byte-identical for Hi3516A V200 and Hi3519 V101). Reset value and access type unknown (modelled RW, no reset). Confidence: medium (vendor header for this chip family, not hardware verified).";

        field {
            name = "hgram_cnt0";
            desc = "[inferred] Hgram cnt0. (vendor header `product/hiosd/vo/hi3519/vou_reg.h` field `hgram_cnt0`; access and reset unknown, modelled RW)";
            sw = rw;
            hw = r;
        } hgram_cnt0[23:0];
    } WBC_DHD0_HISTOGRAM2 @ 0xACA8;

    reg {
        name = "WBC DHD0 HISTOGRAM3";
        desc = "[inferred] WBC DHD0 HISTOGRAM3. Not in the data sheet. Source: vendor U-Boot 2010.06 `product/hiosd/vo/hi3519/vou_reg.h` (GPL-2.0 U-Boot tree, HiSilicon copyright, created 2015-05-26; mirror github.com/OpenIPC/u-boot-hi3516cv200), union `U_WBC_DHD0_HISTOGRAM3`, struct offset 0xACAC (GPL-2.0, same-chip vendor header, byte-identical for Hi3516A V200 and Hi3519 V101). Reset value and access type unknown (modelled RW, no reset). Confidence: medium (vendor header for this chip family, not hardware verified).";

        field {
            name = "hgram_cnt0";
            desc = "[inferred] Hgram cnt0. (vendor header `product/hiosd/vo/hi3519/vou_reg.h` field `hgram_cnt0`; access and reset unknown, modelled RW)";
            sw = rw;
            hw = r;
        } hgram_cnt0[23:0];
    } WBC_DHD0_HISTOGRAM3 @ 0xACAC;

    reg {
        name = "WBC DHD0 HISTOGRAM4";
        desc = "[inferred] WBC DHD0 HISTOGRAM4. Not in the data sheet. Source: vendor U-Boot 2010.06 `product/hiosd/vo/hi3519/vou_reg.h` (GPL-2.0 U-Boot tree, HiSilicon copyright, created 2015-05-26; mirror github.com/OpenIPC/u-boot-hi3516cv200), union `U_WBC_DHD0_HISTOGRAM4`, struct offset 0xACB0 (GPL-2.0, same-chip vendor header, byte-identical for Hi3516A V200 and Hi3519 V101). Reset value and access type unknown (modelled RW, no reset). Confidence: medium (vendor header for this chip family, not hardware verified).";

        field {
            name = "hgram_cnt0";
            desc = "[inferred] Hgram cnt0. (vendor header `product/hiosd/vo/hi3519/vou_reg.h` field `hgram_cnt0`; access and reset unknown, modelled RW)";
            sw = rw;
            hw = r;
        } hgram_cnt0[23:0];
    } WBC_DHD0_HISTOGRAM4 @ 0xACB0;

    reg {
        name = "WBC DHD0 HISTOGRAM5";
        desc = "[inferred] WBC DHD0 HISTOGRAM5. Not in the data sheet. Source: vendor U-Boot 2010.06 `product/hiosd/vo/hi3519/vou_reg.h` (GPL-2.0 U-Boot tree, HiSilicon copyright, created 2015-05-26; mirror github.com/OpenIPC/u-boot-hi3516cv200), union `U_WBC_DHD0_HISTOGRAM5`, struct offset 0xACB4 (GPL-2.0, same-chip vendor header, byte-identical for Hi3516A V200 and Hi3519 V101). Reset value and access type unknown (modelled RW, no reset). Confidence: medium (vendor header for this chip family, not hardware verified).";

        field {
            name = "hgram_cnt0";
            desc = "[inferred] Hgram cnt0. (vendor header `product/hiosd/vo/hi3519/vou_reg.h` field `hgram_cnt0`; access and reset unknown, modelled RW)";
            sw = rw;
            hw = r;
        } hgram_cnt0[23:0];
    } WBC_DHD0_HISTOGRAM5 @ 0xACB4;

    reg {
        name = "WBC DHD0 HISTOGRAM6";
        desc = "[inferred] WBC DHD0 HISTOGRAM6. Not in the data sheet. Source: vendor U-Boot 2010.06 `product/hiosd/vo/hi3519/vou_reg.h` (GPL-2.0 U-Boot tree, HiSilicon copyright, created 2015-05-26; mirror github.com/OpenIPC/u-boot-hi3516cv200), union `U_WBC_DHD0_HISTOGRAM6`, struct offset 0xACB8 (GPL-2.0, same-chip vendor header, byte-identical for Hi3516A V200 and Hi3519 V101). Reset value and access type unknown (modelled RW, no reset). Confidence: medium (vendor header for this chip family, not hardware verified).";

        field {
            name = "hgram_cnt0";
            desc = "[inferred] Hgram cnt0. (vendor header `product/hiosd/vo/hi3519/vou_reg.h` field `hgram_cnt0`; access and reset unknown, modelled RW)";
            sw = rw;
            hw = r;
        } hgram_cnt0[23:0];
    } WBC_DHD0_HISTOGRAM6 @ 0xACB8;

    reg {
        name = "WBC DHD0 HISTOGRAM7";
        desc = "[inferred] WBC DHD0 HISTOGRAM7. Not in the data sheet. Source: vendor U-Boot 2010.06 `product/hiosd/vo/hi3519/vou_reg.h` (GPL-2.0 U-Boot tree, HiSilicon copyright, created 2015-05-26; mirror github.com/OpenIPC/u-boot-hi3516cv200), union `U_WBC_DHD0_HISTOGRAM7`, struct offset 0xACBC (GPL-2.0, same-chip vendor header, byte-identical for Hi3516A V200 and Hi3519 V101). Reset value and access type unknown (modelled RW, no reset). Confidence: medium (vendor header for this chip family, not hardware verified).";

        field {
            name = "hgram_cnt0";
            desc = "[inferred] Hgram cnt0. (vendor header `product/hiosd/vo/hi3519/vou_reg.h` field `hgram_cnt0`; access and reset unknown, modelled RW)";
            sw = rw;
            hw = r;
        } hgram_cnt0[23:0];
    } WBC_DHD0_HISTOGRAM7 @ 0xACBC;

    reg {
        name = "WBC DHD0 HISTOGRAM8";
        desc = "[inferred] WBC DHD0 HISTOGRAM8. Not in the data sheet. Source: vendor U-Boot 2010.06 `product/hiosd/vo/hi3519/vou_reg.h` (GPL-2.0 U-Boot tree, HiSilicon copyright, created 2015-05-26; mirror github.com/OpenIPC/u-boot-hi3516cv200), union `U_WBC_DHD0_HISTOGRAM8`, struct offset 0xACC0 (GPL-2.0, same-chip vendor header, byte-identical for Hi3516A V200 and Hi3519 V101). Reset value and access type unknown (modelled RW, no reset). Confidence: medium (vendor header for this chip family, not hardware verified).";

        field {
            name = "hgram_cnt0";
            desc = "[inferred] Hgram cnt0. (vendor header `product/hiosd/vo/hi3519/vou_reg.h` field `hgram_cnt0`; access and reset unknown, modelled RW)";
            sw = rw;
            hw = r;
        } hgram_cnt0[23:0];
    } WBC_DHD0_HISTOGRAM8 @ 0xACC0;

    reg {
        name = "WBC DHD0 HISTOGRAM9";
        desc = "[inferred] WBC DHD0 HISTOGRAM9. Not in the data sheet. Source: vendor U-Boot 2010.06 `product/hiosd/vo/hi3519/vou_reg.h` (GPL-2.0 U-Boot tree, HiSilicon copyright, created 2015-05-26; mirror github.com/OpenIPC/u-boot-hi3516cv200), union `U_WBC_DHD0_HISTOGRAM9`, struct offset 0xACC4 (GPL-2.0, same-chip vendor header, byte-identical for Hi3516A V200 and Hi3519 V101). Reset value and access type unknown (modelled RW, no reset). Confidence: medium (vendor header for this chip family, not hardware verified).";

        field {
            name = "hgram_cnt0";
            desc = "[inferred] Hgram cnt0. (vendor header `product/hiosd/vo/hi3519/vou_reg.h` field `hgram_cnt0`; access and reset unknown, modelled RW)";
            sw = rw;
            hw = r;
        } hgram_cnt0[23:0];
    } WBC_DHD0_HISTOGRAM9 @ 0xACC4;

    reg {
        name = "WBC DHD0 HISTOGRAM10";
        desc = "[inferred] WBC DHD0 HISTOGRAM10. Not in the data sheet. Source: vendor U-Boot 2010.06 `product/hiosd/vo/hi3519/vou_reg.h` (GPL-2.0 U-Boot tree, HiSilicon copyright, created 2015-05-26; mirror github.com/OpenIPC/u-boot-hi3516cv200), union `U_WBC_DHD0_HISTOGRAM10`, struct offset 0xACC8 (GPL-2.0, same-chip vendor header, byte-identical for Hi3516A V200 and Hi3519 V101). Reset value and access type unknown (modelled RW, no reset). Confidence: medium (vendor header for this chip family, not hardware verified).";

        field {
            name = "hgram_cnt0";
            desc = "[inferred] Hgram cnt0. (vendor header `product/hiosd/vo/hi3519/vou_reg.h` field `hgram_cnt0`; access and reset unknown, modelled RW)";
            sw = rw;
            hw = r;
        } hgram_cnt0[23:0];
    } WBC_DHD0_HISTOGRAM10 @ 0xACC8;

    reg {
        name = "WBC DHD0 HISTOGRAM11";
        desc = "[inferred] WBC DHD0 HISTOGRAM11. Not in the data sheet. Source: vendor U-Boot 2010.06 `product/hiosd/vo/hi3519/vou_reg.h` (GPL-2.0 U-Boot tree, HiSilicon copyright, created 2015-05-26; mirror github.com/OpenIPC/u-boot-hi3516cv200), union `U_WBC_DHD0_HISTOGRAM11`, struct offset 0xACCC (GPL-2.0, same-chip vendor header, byte-identical for Hi3516A V200 and Hi3519 V101). Reset value and access type unknown (modelled RW, no reset). Confidence: medium (vendor header for this chip family, not hardware verified).";

        field {
            name = "hgram_cnt0";
            desc = "[inferred] Hgram cnt0. (vendor header `product/hiosd/vo/hi3519/vou_reg.h` field `hgram_cnt0`; access and reset unknown, modelled RW)";
            sw = rw;
            hw = r;
        } hgram_cnt0[23:0];
    } WBC_DHD0_HISTOGRAM11 @ 0xACCC;

    reg {
        name = "WBC DHD0 HISTOGRAM12";
        desc = "[inferred] WBC DHD0 HISTOGRAM12. Not in the data sheet. Source: vendor U-Boot 2010.06 `product/hiosd/vo/hi3519/vou_reg.h` (GPL-2.0 U-Boot tree, HiSilicon copyright, created 2015-05-26; mirror github.com/OpenIPC/u-boot-hi3516cv200), union `U_WBC_DHD0_HISTOGRAM12`, struct offset 0xACD0 (GPL-2.0, same-chip vendor header, byte-identical for Hi3516A V200 and Hi3519 V101). Reset value and access type unknown (modelled RW, no reset). Confidence: medium (vendor header for this chip family, not hardware verified).";

        field {
            name = "hgram_cnt0";
            desc = "[inferred] Hgram cnt0. (vendor header `product/hiosd/vo/hi3519/vou_reg.h` field `hgram_cnt0`; access and reset unknown, modelled RW)";
            sw = rw;
            hw = r;
        } hgram_cnt0[23:0];
    } WBC_DHD0_HISTOGRAM12 @ 0xACD0;

    reg {
        name = "WBC DHD0 HISTOGRAM13";
        desc = "[inferred] WBC DHD0 HISTOGRAM13. Not in the data sheet. Source: vendor U-Boot 2010.06 `product/hiosd/vo/hi3519/vou_reg.h` (GPL-2.0 U-Boot tree, HiSilicon copyright, created 2015-05-26; mirror github.com/OpenIPC/u-boot-hi3516cv200), union `U_WBC_DHD0_HISTOGRAM13`, struct offset 0xACD4 (GPL-2.0, same-chip vendor header, byte-identical for Hi3516A V200 and Hi3519 V101). Reset value and access type unknown (modelled RW, no reset). Confidence: medium (vendor header for this chip family, not hardware verified).";

        field {
            name = "hgram_cnt0";
            desc = "[inferred] Hgram cnt0. (vendor header `product/hiosd/vo/hi3519/vou_reg.h` field `hgram_cnt0`; access and reset unknown, modelled RW)";
            sw = rw;
            hw = r;
        } hgram_cnt0[23:0];
    } WBC_DHD0_HISTOGRAM13 @ 0xACD4;

    reg {
        name = "WBC DHD0 HISTOGRAM14";
        desc = "[inferred] WBC DHD0 HISTOGRAM14. Not in the data sheet. Source: vendor U-Boot 2010.06 `product/hiosd/vo/hi3519/vou_reg.h` (GPL-2.0 U-Boot tree, HiSilicon copyright, created 2015-05-26; mirror github.com/OpenIPC/u-boot-hi3516cv200), union `U_WBC_DHD0_HISTOGRAM14`, struct offset 0xACD8 (GPL-2.0, same-chip vendor header, byte-identical for Hi3516A V200 and Hi3519 V101). Reset value and access type unknown (modelled RW, no reset). Confidence: medium (vendor header for this chip family, not hardware verified).";

        field {
            name = "hgram_cnt0";
            desc = "[inferred] Hgram cnt0. (vendor header `product/hiosd/vo/hi3519/vou_reg.h` field `hgram_cnt0`; access and reset unknown, modelled RW)";
            sw = rw;
            hw = r;
        } hgram_cnt0[23:0];
    } WBC_DHD0_HISTOGRAM14 @ 0xACD8;

    reg {
        name = "WBC DHD0 HISTOGRAM15";
        desc = "[inferred] WBC DHD0 HISTOGRAM15. Not in the data sheet. Source: vendor U-Boot 2010.06 `product/hiosd/vo/hi3519/vou_reg.h` (GPL-2.0 U-Boot tree, HiSilicon copyright, created 2015-05-26; mirror github.com/OpenIPC/u-boot-hi3516cv200), union `U_WBC_DHD0_HISTOGRAM15`, struct offset 0xACDC (GPL-2.0, same-chip vendor header, byte-identical for Hi3516A V200 and Hi3519 V101). Reset value and access type unknown (modelled RW, no reset). Confidence: medium (vendor header for this chip family, not hardware verified).";

        field {
            name = "hgram_cnt0";
            desc = "[inferred] Hgram cnt0. (vendor header `product/hiosd/vo/hi3519/vou_reg.h` field `hgram_cnt0`; access and reset unknown, modelled RW)";
            sw = rw;
            hw = r;
        } hgram_cnt0[23:0];
    } WBC_DHD0_HISTOGRAM15 @ 0xACDC;

    reg {
        name = "WBC DHD0 CHECKSUM Y";
        desc = "[inferred] WBC DHD0 CHECKSUM Y. Not in the data sheet. Source: vendor U-Boot 2010.06 `product/hiosd/vo/hi3519/vou_reg.h` (GPL-2.0 U-Boot tree, HiSilicon copyright, created 2015-05-26; mirror github.com/OpenIPC/u-boot-hi3516cv200), union `U_WBC_DHD0_CHECKSUM_Y`, struct offset 0xACF0 (GPL-2.0, same-chip vendor header, byte-identical for Hi3516A V200 and Hi3519 V101). Reset value and access type unknown (modelled RW, no reset). Confidence: medium (vendor header for this chip family, not hardware verified).";

        field {
            name = "value";
            desc = "[inferred] Register value (the header union has no named bits).";
            sw = rw;
            hw = r;
        } value[31:0];
    } WBC_DHD0_CHECKSUM_Y @ 0xACF0;

    reg {
        name = "WBC DHD0 CHECKSUM C";
        desc = "[inferred] WBC DHD0 CHECKSUM C. Not in the data sheet. Source: vendor U-Boot 2010.06 `product/hiosd/vo/hi3519/vou_reg.h` (GPL-2.0 U-Boot tree, HiSilicon copyright, created 2015-05-26; mirror github.com/OpenIPC/u-boot-hi3516cv200), union `U_WBC_DHD0_CHECKSUM_C`, struct offset 0xACF4 (GPL-2.0, same-chip vendor header, byte-identical for Hi3516A V200 and Hi3519 V101). Reset value and access type unknown (modelled RW, no reset). Confidence: medium (vendor header for this chip family, not hardware verified).";

        field {
            name = "value";
            desc = "[inferred] Register value (the header union has no named bits).";
            sw = rw;
            hw = r;
        } value[31:0];
    } WBC_DHD0_CHECKSUM_C @ 0xACF4;

    reg {
        name = "WBC DHD0 dither control";
        desc = "[inferred] WBC DHD0 dither control. Not in the data sheet. Source: vendor U-Boot 2010.06 `product/hiosd/vo/hi3519/vou_reg.h` (GPL-2.0 U-Boot tree, HiSilicon copyright, created 2015-05-26; mirror github.com/OpenIPC/u-boot-hi3516cv200), union `U_WBC_DHD0_DITHER_CTRL`, struct offset 0xAD00 (GPL-2.0, same-chip vendor header, byte-identical for Hi3516A V200 and Hi3519 V101). Reset value and access type unknown (modelled RW, no reset). Confidence: medium (vendor header for this chip family, not hardware verified).";

        field {
            name = "dither_md";
            desc = "[inferred] Dither md. (vendor header `product/hiosd/vo/hi3519/vou_reg.h` field `dither_md`; access and reset unknown, modelled RW)";
            sw = rw;
            hw = r;
        } dither_md[31:29];
    } WBC_DHD0_DITHER_CTRL @ 0xAD00;

    reg {
        name = "WBC DHD0 dither COEF0";
        desc = "[inferred] WBC DHD0 dither COEF0. Not in the data sheet. Source: vendor U-Boot 2010.06 `product/hiosd/vo/hi3519/vou_reg.h` (GPL-2.0 U-Boot tree, HiSilicon copyright, created 2015-05-26; mirror github.com/OpenIPC/u-boot-hi3516cv200), union `U_WBC_DHD0_DITHER_COEF0`, struct offset 0xAD04 (GPL-2.0, same-chip vendor header, byte-identical for Hi3516A V200 and Hi3519 V101). Reset value and access type unknown (modelled RW, no reset). Confidence: medium (vendor header for this chip family, not hardware verified).";

        field {
            name = "dither_coef3";
            desc = "[inferred] Dither coef3. (vendor header `product/hiosd/vo/hi3519/vou_reg.h` field `dither_coef3`; access and reset unknown, modelled RW)";
            sw = rw;
            hw = r;
        } dither_coef3[31:24];

        field {
            name = "dither_coef2";
            desc = "[inferred] Dither coef2. (vendor header `product/hiosd/vo/hi3519/vou_reg.h` field `dither_coef2`; access and reset unknown, modelled RW)";
            sw = rw;
            hw = r;
        } dither_coef2[23:16];

        field {
            name = "dither_coef1";
            desc = "[inferred] Dither coef1. (vendor header `product/hiosd/vo/hi3519/vou_reg.h` field `dither_coef1`; access and reset unknown, modelled RW)";
            sw = rw;
            hw = r;
        } dither_coef1[15:8];

        field {
            name = "dither_coef0";
            desc = "[inferred] Dither coef0. (vendor header `product/hiosd/vo/hi3519/vou_reg.h` field `dither_coef0`; access and reset unknown, modelled RW)";
            sw = rw;
            hw = r;
        } dither_coef0[7:0];
    } WBC_DHD0_DITHER_COEF0 @ 0xAD04;

    reg {
        name = "WBC DHD0 dither COEF1";
        desc = "[inferred] WBC DHD0 dither COEF1. Not in the data sheet. Source: vendor U-Boot 2010.06 `product/hiosd/vo/hi3519/vou_reg.h` (GPL-2.0 U-Boot tree, HiSilicon copyright, created 2015-05-26; mirror github.com/OpenIPC/u-boot-hi3516cv200), union `U_WBC_DHD0_DITHER_COEF1`, struct offset 0xAD08 (GPL-2.0, same-chip vendor header, byte-identical for Hi3516A V200 and Hi3519 V101). Reset value and access type unknown (modelled RW, no reset). Confidence: medium (vendor header for this chip family, not hardware verified).";

        field {
            name = "dither_coef7";
            desc = "[inferred] Dither coef7. (vendor header `product/hiosd/vo/hi3519/vou_reg.h` field `dither_coef7`; access and reset unknown, modelled RW)";
            sw = rw;
            hw = r;
        } dither_coef7[31:24];

        field {
            name = "dither_coef6";
            desc = "[inferred] Dither coef6. (vendor header `product/hiosd/vo/hi3519/vou_reg.h` field `dither_coef6`; access and reset unknown, modelled RW)";
            sw = rw;
            hw = r;
        } dither_coef6[23:16];

        field {
            name = "dither_coef5";
            desc = "[inferred] Dither coef5. (vendor header `product/hiosd/vo/hi3519/vou_reg.h` field `dither_coef5`; access and reset unknown, modelled RW)";
            sw = rw;
            hw = r;
        } dither_coef5[15:8];

        field {
            name = "dither_coef4";
            desc = "[inferred] Dither coef4. (vendor header `product/hiosd/vo/hi3519/vou_reg.h` field `dither_coef4`; access and reset unknown, modelled RW)";
            sw = rw;
            hw = r;
        } dither_coef4[7:0];
    } WBC_DHD0_DITHER_COEF1 @ 0xAD08;

    reg {
        name = "WBC DHD0 HCDS";
        desc = "[inferred] WBC DHD0 HCDS. Not in the data sheet. Source: vendor U-Boot 2010.06 `product/hiosd/vo/hi3519/vou_reg.h` (GPL-2.0 U-Boot tree, HiSilicon copyright, created 2015-05-26; mirror github.com/OpenIPC/u-boot-hi3516cv200), union `U_WBC_DHD0_HCDS`, struct offset 0xAE10 (GPL-2.0, same-chip vendor header, byte-identical for Hi3516A V200 and Hi3519 V101). Reset value and access type unknown (modelled RW, no reset). Confidence: medium (vendor header for this chip family, not hardware verified).";

        field {
            name = "hcds_en";
            desc = "[inferred] Hcds enable. (vendor header `product/hiosd/vo/hi3519/vou_reg.h` field `hcds_en`; access and reset unknown, modelled RW)";
            sw = rw;
            hw = r;
        } hcds_en[31:31];

        field {
            name = "hchmid_en";
            desc = "[inferred] Hchmid enable. (vendor header `product/hiosd/vo/hi3519/vou_reg.h` field `hchmid_en`; access and reset unknown, modelled RW)";
            sw = rw;
            hw = r;
        } hchmid_en[30:30];

        field {
            name = "hchfir_en";
            desc = "[inferred] Hchfir enable. (vendor header `product/hiosd/vo/hi3519/vou_reg.h` field `hchfir_en`; access and reset unknown, modelled RW)";
            sw = rw;
            hw = r;
        } hchfir_en[29:29];
    } WBC_DHD0_HCDS @ 0xAE10;

    reg {
        name = "WBC DHD0 HCDS COEF0";
        desc = "[inferred] WBC DHD0 HCDS COEF0. Not in the data sheet. Source: vendor U-Boot 2010.06 `product/hiosd/vo/hi3519/vou_reg.h` (GPL-2.0 U-Boot tree, HiSilicon copyright, created 2015-05-26; mirror github.com/OpenIPC/u-boot-hi3516cv200), union `U_WBC_DHD0_HCDS_COEF0`, struct offset 0xAE14 (GPL-2.0, same-chip vendor header, byte-identical for Hi3516A V200 and Hi3519 V101). Reset value and access type unknown (modelled RW, no reset). Confidence: medium (vendor header for this chip family, not hardware verified).";

        field {
            name = "coef2";
            desc = "[inferred] Coef2. (vendor header `product/hiosd/vo/hi3519/vou_reg.h` field `coef2`; access and reset unknown, modelled RW)";
            sw = rw;
            hw = r;
        } coef2[29:20];

        field {
            name = "coef1";
            desc = "[inferred] Coef1. (vendor header `product/hiosd/vo/hi3519/vou_reg.h` field `coef1`; access and reset unknown, modelled RW)";
            sw = rw;
            hw = r;
        } coef1[19:10];

        field {
            name = "coef0";
            desc = "[inferred] Coef0. (vendor header `product/hiosd/vo/hi3519/vou_reg.h` field `coef0`; access and reset unknown, modelled RW)";
            sw = rw;
            hw = r;
        } coef0[9:0];
    } WBC_DHD0_HCDS_COEF0 @ 0xAE14;

    reg {
        name = "WBC DHD0 HCDS COEF1";
        desc = "[inferred] WBC DHD0 HCDS COEF1. Not in the data sheet. Source: vendor U-Boot 2010.06 `product/hiosd/vo/hi3519/vou_reg.h` (GPL-2.0 U-Boot tree, HiSilicon copyright, created 2015-05-26; mirror github.com/OpenIPC/u-boot-hi3516cv200), union `U_WBC_DHD0_HCDS_COEF1`, struct offset 0xAE18 (GPL-2.0, same-chip vendor header, byte-identical for Hi3516A V200 and Hi3519 V101). Reset value and access type unknown (modelled RW, no reset). Confidence: medium (vendor header for this chip family, not hardware verified).";

        field {
            name = "coef3";
            desc = "[inferred] Coef3. (vendor header `product/hiosd/vo/hi3519/vou_reg.h` field `coef3`; access and reset unknown, modelled RW)";
            sw = rw;
            hw = r;
        } coef3[9:0];
    } WBC_DHD0_HCDS_COEF1 @ 0xAE18;

    reg {
        name = "WBC DHD0 scaler HSP";
        desc = "[inferred] WBC DHD0 scaler HSP. Not in the data sheet. Source: vendor U-Boot 2010.06 `product/hiosd/vo/hi3519/vou_reg.h` (GPL-2.0 U-Boot tree, HiSilicon copyright, created 2015-05-26; mirror github.com/OpenIPC/u-boot-hi3516cv200), union `U_WBC_DHD0_ZME_HSP`, struct offset 0xAEC0 (GPL-2.0, same-chip vendor header, byte-identical for Hi3516A V200 and Hi3519 V101). Reset value and access type unknown (modelled RW, no reset). Confidence: medium (vendor header for this chip family, not hardware verified).";

        field {
            name = "hlmsc_en";
            desc = "[inferred] Hlmsc enable. (vendor header `product/hiosd/vo/hi3519/vou_reg.h` field `hlmsc_en`; access and reset unknown, modelled RW)";
            sw = rw;
            hw = r;
        } hlmsc_en[31:31];

        field {
            name = "hchmsc_en";
            desc = "[inferred] Hchmsc enable. (vendor header `product/hiosd/vo/hi3519/vou_reg.h` field `hchmsc_en`; access and reset unknown, modelled RW)";
            sw = rw;
            hw = r;
        } hchmsc_en[30:30];

        field {
            name = "hlmid_en";
            desc = "[inferred] Hlmid enable. (vendor header `product/hiosd/vo/hi3519/vou_reg.h` field `hlmid_en`; access and reset unknown, modelled RW)";
            sw = rw;
            hw = r;
        } hlmid_en[29:29];

        field {
            name = "hchmid_en";
            desc = "[inferred] Hchmid enable. (vendor header `product/hiosd/vo/hi3519/vou_reg.h` field `hchmid_en`; access and reset unknown, modelled RW)";
            sw = rw;
            hw = r;
        } hchmid_en[28:28];

        field {
            name = "non_lnr_en";
            desc = "[inferred] Non lnr enable. (vendor header `product/hiosd/vo/hi3519/vou_reg.h` field `non_lnr_en`; access and reset unknown, modelled RW)";
            sw = rw;
            hw = r;
        } non_lnr_en[27:27];

        field {
            name = "hlfir_en";
            desc = "[inferred] Hlfir enable. (vendor header `product/hiosd/vo/hi3519/vou_reg.h` field `hlfir_en`; access and reset unknown, modelled RW)";
            sw = rw;
            hw = r;
        } hlfir_en[26:26];

        field {
            name = "hchfir_en";
            desc = "[inferred] Hchfir enable. (vendor header `product/hiosd/vo/hi3519/vou_reg.h` field `hchfir_en`; access and reset unknown, modelled RW)";
            sw = rw;
            hw = r;
        } hchfir_en[25:25];

        field {
            name = "hfir_order";
            desc = "[inferred] Hfir order. (vendor header `product/hiosd/vo/hi3519/vou_reg.h` field `hfir_order`; access and reset unknown, modelled RW)";
            sw = rw;
            hw = r;
        } hfir_order[24:24];

        field {
            name = "hratio";
            desc = "[inferred] Hratio. (vendor header `product/hiosd/vo/hi3519/vou_reg.h` field `hratio`; access and reset unknown, modelled RW)";
            sw = rw;
            hw = r;
        } hratio[23:0];
    } WBC_DHD0_ZME_HSP @ 0xAEC0;

    reg {
        name = "WBC DHD0 scaler HLOFFSET";
        desc = "[inferred] WBC DHD0 scaler HLOFFSET. Not in the data sheet. Source: vendor U-Boot 2010.06 `product/hiosd/vo/hi3519/vou_reg.h` (GPL-2.0 U-Boot tree, HiSilicon copyright, created 2015-05-26; mirror github.com/OpenIPC/u-boot-hi3516cv200), union `U_WBC_DHD0_ZME_HLOFFSET`, struct offset 0xAEC4 (GPL-2.0, same-chip vendor header, byte-identical for Hi3516A V200 and Hi3519 V101). Reset value and access type unknown (modelled RW, no reset). Confidence: medium (vendor header for this chip family, not hardware verified).";

        field {
            name = "hor_loffset";
            desc = "[inferred] Hor loffset. (vendor header `product/hiosd/vo/hi3519/vou_reg.h` field `hor_loffset`; access and reset unknown, modelled RW)";
            sw = rw;
            hw = r;
        } hor_loffset[27:0];
    } WBC_DHD0_ZME_HLOFFSET @ 0xAEC4;

    reg {
        name = "WBC DHD0 scaler HCOFFSET";
        desc = "[inferred] WBC DHD0 scaler HCOFFSET. Not in the data sheet. Source: vendor U-Boot 2010.06 `product/hiosd/vo/hi3519/vou_reg.h` (GPL-2.0 U-Boot tree, HiSilicon copyright, created 2015-05-26; mirror github.com/OpenIPC/u-boot-hi3516cv200), union `U_WBC_DHD0_ZME_HCOFFSET`, struct offset 0xAEC8 (GPL-2.0, same-chip vendor header, byte-identical for Hi3516A V200 and Hi3519 V101). Reset value and access type unknown (modelled RW, no reset). Confidence: medium (vendor header for this chip family, not hardware verified).";

        field {
            name = "hor_coffset";
            desc = "[inferred] Hor coffset. (vendor header `product/hiosd/vo/hi3519/vou_reg.h` field `hor_coffset`; access and reset unknown, modelled RW)";
            sw = rw;
            hw = r;
        } hor_coffset[27:0];
    } WBC_DHD0_ZME_HCOFFSET @ 0xAEC8;

    reg {
        name = "WBC DHD0 scaler VSP";
        desc = "[inferred] WBC DHD0 scaler VSP. Not in the data sheet. Source: vendor U-Boot 2010.06 `product/hiosd/vo/hi3519/vou_reg.h` (GPL-2.0 U-Boot tree, HiSilicon copyright, created 2015-05-26; mirror github.com/OpenIPC/u-boot-hi3516cv200), union `U_WBC_DHD0_ZME_VSP`, struct offset 0xAED8 (GPL-2.0, same-chip vendor header, byte-identical for Hi3516A V200 and Hi3519 V101). Reset value and access type unknown (modelled RW, no reset). Confidence: medium (vendor header for this chip family, not hardware verified).";

        field {
            name = "vlmsc_en";
            desc = "[inferred] Vlmsc enable. (vendor header `product/hiosd/vo/hi3519/vou_reg.h` field `vlmsc_en`; access and reset unknown, modelled RW)";
            sw = rw;
            hw = r;
        } vlmsc_en[31:31];

        field {
            name = "vchmsc_en";
            desc = "[inferred] Vchmsc enable. (vendor header `product/hiosd/vo/hi3519/vou_reg.h` field `vchmsc_en`; access and reset unknown, modelled RW)";
            sw = rw;
            hw = r;
        } vchmsc_en[30:30];

        field {
            name = "vlmid_en";
            desc = "[inferred] Vlmid enable. (vendor header `product/hiosd/vo/hi3519/vou_reg.h` field `vlmid_en`; access and reset unknown, modelled RW)";
            sw = rw;
            hw = r;
        } vlmid_en[29:29];

        field {
            name = "vchmid_en";
            desc = "[inferred] Vchmid enable. (vendor header `product/hiosd/vo/hi3519/vou_reg.h` field `vchmid_en`; access and reset unknown, modelled RW)";
            sw = rw;
            hw = r;
        } vchmid_en[28:28];

        field {
            name = "vsc_chroma_tap";
            desc = "[inferred] Vsc chroma tap. (vendor header `product/hiosd/vo/hi3519/vou_reg.h` field `vsc_chroma_tap`; access and reset unknown, modelled RW)";
            sw = rw;
            hw = r;
        } vsc_chroma_tap[26:26];

        field {
            name = "vlfir_en";
            desc = "[inferred] Vlfir enable. (vendor header `product/hiosd/vo/hi3519/vou_reg.h` field `vlfir_en`; access and reset unknown, modelled RW)";
            sw = rw;
            hw = r;
        } vlfir_en[24:24];

        field {
            name = "vchfir_en";
            desc = "[inferred] Vchfir enable. (vendor header `product/hiosd/vo/hi3519/vou_reg.h` field `vchfir_en`; access and reset unknown, modelled RW)";
            sw = rw;
            hw = r;
        } vchfir_en[23:23];

        field {
            name = "zme_out_fmt";
            desc = "[inferred] Scaler out format. (vendor header `product/hiosd/vo/hi3519/vou_reg.h` field `zme_out_fmt`; access and reset unknown, modelled RW)";
            sw = rw;
            hw = r;
        } zme_out_fmt[22:21];

        field {
            name = "zme_in_fmt";
            desc = "[inferred] Scaler in format. (vendor header `product/hiosd/vo/hi3519/vou_reg.h` field `zme_in_fmt`; access and reset unknown, modelled RW)";
            sw = rw;
            hw = r;
        } zme_in_fmt[20:19];
    } WBC_DHD0_ZME_VSP @ 0xAED8;

    reg {
        name = "WBC DHD0 scaler VSR";
        desc = "[inferred] WBC DHD0 scaler VSR. Not in the data sheet. Source: vendor U-Boot 2010.06 `product/hiosd/vo/hi3519/vou_reg.h` (GPL-2.0 U-Boot tree, HiSilicon copyright, created 2015-05-26; mirror github.com/OpenIPC/u-boot-hi3516cv200), union `U_WBC_DHD0_ZME_VSR`, struct offset 0xAEDC (GPL-2.0, same-chip vendor header, byte-identical for Hi3516A V200 and Hi3519 V101). Reset value and access type unknown (modelled RW, no reset). Confidence: medium (vendor header for this chip family, not hardware verified).";

        field {
            name = "vratio";
            desc = "[inferred] Vratio. (vendor header `product/hiosd/vo/hi3519/vou_reg.h` field `vratio`; access and reset unknown, modelled RW)";
            sw = rw;
            hw = r;
        } vratio[15:0];
    } WBC_DHD0_ZME_VSR @ 0xAEDC;

    reg {
        name = "WBC DHD0 scaler VOFFSET";
        desc = "[inferred] WBC DHD0 scaler VOFFSET. Not in the data sheet. Source: vendor U-Boot 2010.06 `product/hiosd/vo/hi3519/vou_reg.h` (GPL-2.0 U-Boot tree, HiSilicon copyright, created 2015-05-26; mirror github.com/OpenIPC/u-boot-hi3516cv200), union `U_WBC_DHD0_ZME_VOFFSET`, struct offset 0xAEE0 (GPL-2.0, same-chip vendor header, byte-identical for Hi3516A V200 and Hi3519 V101). Reset value and access type unknown (modelled RW, no reset). Confidence: medium (vendor header for this chip family, not hardware verified).";

        field {
            name = "vluma_offset";
            desc = "[inferred] Vluma offset. (vendor header `product/hiosd/vo/hi3519/vou_reg.h` field `vluma_offset`; access and reset unknown, modelled RW)";
            sw = rw;
            hw = r;
        } vluma_offset[31:16];

        field {
            name = "vchroma_offset";
            desc = "[inferred] Vchroma offset. (vendor header `product/hiosd/vo/hi3519/vou_reg.h` field `vchroma_offset`; access and reset unknown, modelled RW)";
            sw = rw;
            hw = r;
        } vchroma_offset[15:0];
    } WBC_DHD0_ZME_VOFFSET @ 0xAEE0;

    reg {
        name = "WBC DHD0 scaler VBOFFSET";
        desc = "[inferred] WBC DHD0 scaler VBOFFSET. Not in the data sheet. Source: vendor U-Boot 2010.06 `product/hiosd/vo/hi3519/vou_reg.h` (GPL-2.0 U-Boot tree, HiSilicon copyright, created 2015-05-26; mirror github.com/OpenIPC/u-boot-hi3516cv200), union `U_WBC_DHD0_ZME_VBOFFSET`, struct offset 0xAEE4 (GPL-2.0, same-chip vendor header, byte-identical for Hi3516A V200 and Hi3519 V101). Reset value and access type unknown (modelled RW, no reset). Confidence: medium (vendor header for this chip family, not hardware verified).";

        field {
            name = "vbluma_offset";
            desc = "[inferred] Vbluma offset. (vendor header `product/hiosd/vo/hi3519/vou_reg.h` field `vbluma_offset`; access and reset unknown, modelled RW)";
            sw = rw;
            hw = r;
        } vbluma_offset[31:16];

        field {
            name = "vbchroma_offset";
            desc = "[inferred] Vbchroma offset. (vendor header `product/hiosd/vo/hi3519/vou_reg.h` field `vbchroma_offset`; access and reset unknown, modelled RW)";
            sw = rw;
            hw = r;
        } vbchroma_offset[15:0];
    } WBC_DHD0_ZME_VBOFFSET @ 0xAEE4;

    reg {
        name = "WBC DHD0 CSCIDC";
        desc = "[inferred] WBC DHD0 CSCIDC. Not in the data sheet. Source: vendor U-Boot 2010.06 `product/hiosd/vo/hi3519/vou_reg.h` (GPL-2.0 U-Boot tree, HiSilicon copyright, created 2015-05-26; mirror github.com/OpenIPC/u-boot-hi3516cv200), union `U_WBC_DHD0_CSCIDC`, struct offset 0xAF00 (GPL-2.0, same-chip vendor header, byte-identical for Hi3516A V200 and Hi3519 V101). Reset value and access type unknown (modelled RW, no reset). Confidence: medium (vendor header for this chip family, not hardware verified).";

        field {
            name = "csc_mode";
            desc = "[inferred] Colour-space conversion mode. (vendor header `product/hiosd/vo/hi3519/vou_reg.h` field `csc_mode`; access and reset unknown, modelled RW)";
            sw = rw;
            hw = r;
        } csc_mode[30:28];

        field {
            name = "csc_en";
            desc = "[inferred] Colour-space conversion enable. (vendor header `product/hiosd/vo/hi3519/vou_reg.h` field `csc_en`; access and reset unknown, modelled RW)";
            sw = rw;
            hw = r;
        } csc_en[27:27];

        field {
            name = "cscidc2";
            desc = "[inferred] Cscidc2. (vendor header `product/hiosd/vo/hi3519/vou_reg.h` field `cscidc2`; access and reset unknown, modelled RW)";
            sw = rw;
            hw = r;
        } cscidc2[26:18];

        field {
            name = "cscidc1";
            desc = "[inferred] Cscidc1. (vendor header `product/hiosd/vo/hi3519/vou_reg.h` field `cscidc1`; access and reset unknown, modelled RW)";
            sw = rw;
            hw = r;
        } cscidc1[17:9];

        field {
            name = "cscidc0";
            desc = "[inferred] Cscidc0. (vendor header `product/hiosd/vo/hi3519/vou_reg.h` field `cscidc0`; access and reset unknown, modelled RW)";
            sw = rw;
            hw = r;
        } cscidc0[8:0];
    } WBC_DHD0_CSCIDC @ 0xAF00;

    reg {
        name = "WBC DHD0 CSCODC";
        desc = "[inferred] WBC DHD0 CSCODC. Not in the data sheet. Source: vendor U-Boot 2010.06 `product/hiosd/vo/hi3519/vou_reg.h` (GPL-2.0 U-Boot tree, HiSilicon copyright, created 2015-05-26; mirror github.com/OpenIPC/u-boot-hi3516cv200), union `U_WBC_DHD0_CSCODC`, struct offset 0xAF04 (GPL-2.0, same-chip vendor header, byte-identical for Hi3516A V200 and Hi3519 V101). Reset value and access type unknown (modelled RW, no reset). Confidence: medium (vendor header for this chip family, not hardware verified).";

        field {
            name = "cscodc2";
            desc = "[inferred] Cscodc2. (vendor header `product/hiosd/vo/hi3519/vou_reg.h` field `cscodc2`; access and reset unknown, modelled RW)";
            sw = rw;
            hw = r;
        } cscodc2[26:18];

        field {
            name = "cscodc1";
            desc = "[inferred] Cscodc1. (vendor header `product/hiosd/vo/hi3519/vou_reg.h` field `cscodc1`; access and reset unknown, modelled RW)";
            sw = rw;
            hw = r;
        } cscodc1[17:9];

        field {
            name = "cscodc0";
            desc = "[inferred] Cscodc0. (vendor header `product/hiosd/vo/hi3519/vou_reg.h` field `cscodc0`; access and reset unknown, modelled RW)";
            sw = rw;
            hw = r;
        } cscodc0[8:0];
    } WBC_DHD0_CSCODC @ 0xAF04;

    reg {
        name = "WBC DHD0 CSCP0";
        desc = "[inferred] WBC DHD0 CSCP0. Not in the data sheet. Source: vendor U-Boot 2010.06 `product/hiosd/vo/hi3519/vou_reg.h` (GPL-2.0 U-Boot tree, HiSilicon copyright, created 2015-05-26; mirror github.com/OpenIPC/u-boot-hi3516cv200), union `U_WBC_DHD0_CSCP0`, struct offset 0xAF08 (GPL-2.0, same-chip vendor header, byte-identical for Hi3516A V200 and Hi3519 V101). Reset value and access type unknown (modelled RW, no reset). Confidence: medium (vendor header for this chip family, not hardware verified).";

        field {
            name = "cscp01";
            desc = "[inferred] Cscp01. (vendor header `product/hiosd/vo/hi3519/vou_reg.h` field `cscp01`; access and reset unknown, modelled RW)";
            sw = rw;
            hw = r;
        } cscp01[30:16];

        field {
            name = "cscp00";
            desc = "[inferred] Cscp00. (vendor header `product/hiosd/vo/hi3519/vou_reg.h` field `cscp00`; access and reset unknown, modelled RW)";
            sw = rw;
            hw = r;
        } cscp00[14:0];
    } WBC_DHD0_CSCP0 @ 0xAF08;

    reg {
        name = "WBC DHD0 CSCP1";
        desc = "[inferred] WBC DHD0 CSCP1. Not in the data sheet. Source: vendor U-Boot 2010.06 `product/hiosd/vo/hi3519/vou_reg.h` (GPL-2.0 U-Boot tree, HiSilicon copyright, created 2015-05-26; mirror github.com/OpenIPC/u-boot-hi3516cv200), union `U_WBC_DHD0_CSCP1`, struct offset 0xAF0C (GPL-2.0, same-chip vendor header, byte-identical for Hi3516A V200 and Hi3519 V101). Reset value and access type unknown (modelled RW, no reset). Confidence: medium (vendor header for this chip family, not hardware verified).";

        field {
            name = "cscp10";
            desc = "[inferred] Cscp10. (vendor header `product/hiosd/vo/hi3519/vou_reg.h` field `cscp10`; access and reset unknown, modelled RW)";
            sw = rw;
            hw = r;
        } cscp10[30:16];

        field {
            name = "cscp02";
            desc = "[inferred] Cscp02. (vendor header `product/hiosd/vo/hi3519/vou_reg.h` field `cscp02`; access and reset unknown, modelled RW)";
            sw = rw;
            hw = r;
        } cscp02[14:0];
    } WBC_DHD0_CSCP1 @ 0xAF0C;

    reg {
        name = "WBC DHD0 CSCP2";
        desc = "[inferred] WBC DHD0 CSCP2. Not in the data sheet. Source: vendor U-Boot 2010.06 `product/hiosd/vo/hi3519/vou_reg.h` (GPL-2.0 U-Boot tree, HiSilicon copyright, created 2015-05-26; mirror github.com/OpenIPC/u-boot-hi3516cv200), union `U_WBC_DHD0_CSCP2`, struct offset 0xAF10 (GPL-2.0, same-chip vendor header, byte-identical for Hi3516A V200 and Hi3519 V101). Reset value and access type unknown (modelled RW, no reset). Confidence: medium (vendor header for this chip family, not hardware verified).";

        field {
            name = "cscp12";
            desc = "[inferred] Cscp12. (vendor header `product/hiosd/vo/hi3519/vou_reg.h` field `cscp12`; access and reset unknown, modelled RW)";
            sw = rw;
            hw = r;
        } cscp12[30:16];

        field {
            name = "cscp11";
            desc = "[inferred] Cscp11. (vendor header `product/hiosd/vo/hi3519/vou_reg.h` field `cscp11`; access and reset unknown, modelled RW)";
            sw = rw;
            hw = r;
        } cscp11[14:0];
    } WBC_DHD0_CSCP2 @ 0xAF10;

    reg {
        name = "WBC DHD0 CSCP3";
        desc = "[inferred] WBC DHD0 CSCP3. Not in the data sheet. Source: vendor U-Boot 2010.06 `product/hiosd/vo/hi3519/vou_reg.h` (GPL-2.0 U-Boot tree, HiSilicon copyright, created 2015-05-26; mirror github.com/OpenIPC/u-boot-hi3516cv200), union `U_WBC_DHD0_CSCP3`, struct offset 0xAF14 (GPL-2.0, same-chip vendor header, byte-identical for Hi3516A V200 and Hi3519 V101). Reset value and access type unknown (modelled RW, no reset). Confidence: medium (vendor header for this chip family, not hardware verified).";

        field {
            name = "cscp21";
            desc = "[inferred] Cscp21. (vendor header `product/hiosd/vo/hi3519/vou_reg.h` field `cscp21`; access and reset unknown, modelled RW)";
            sw = rw;
            hw = r;
        } cscp21[30:16];

        field {
            name = "cscp20";
            desc = "[inferred] Cscp20. (vendor header `product/hiosd/vo/hi3519/vou_reg.h` field `cscp20`; access and reset unknown, modelled RW)";
            sw = rw;
            hw = r;
        } cscp20[14:0];
    } WBC_DHD0_CSCP3 @ 0xAF14;

    reg {
        name = "WBC DHD0 CSCP4";
        desc = "[inferred] WBC DHD0 CSCP4. Not in the data sheet. Source: vendor U-Boot 2010.06 `product/hiosd/vo/hi3519/vou_reg.h` (GPL-2.0 U-Boot tree, HiSilicon copyright, created 2015-05-26; mirror github.com/OpenIPC/u-boot-hi3516cv200), union `U_WBC_DHD0_CSCP4`, struct offset 0xAF18 (GPL-2.0, same-chip vendor header, byte-identical for Hi3516A V200 and Hi3519 V101). Reset value and access type unknown (modelled RW, no reset). Confidence: medium (vendor header for this chip family, not hardware verified).";

        field {
            name = "cscp22";
            desc = "[inferred] Cscp22. (vendor header `product/hiosd/vo/hi3519/vou_reg.h` field `cscp22`; access and reset unknown, modelled RW)";
            sw = rw;
            hw = r;
        } cscp22[14:0];
    } WBC_DHD0_CSCP4 @ 0xAF18;

    reg {
        name = "MIXV0 BKG";
        desc = "[inferred] MIXV0 BKG. Not in the data sheet. Source: vendor U-Boot 2010.06 `product/hiosd/vo/hi3519/vou_reg.h` (GPL-2.0 U-Boot tree, HiSilicon copyright, created 2015-05-26; mirror github.com/OpenIPC/u-boot-hi3516cv200), union `U_MIXV0_BKG`, struct offset 0xB000 (GPL-2.0, same-chip vendor header, byte-identical for Hi3516A V200 and Hi3519 V101). Reset value and access type unknown (modelled RW, no reset). Confidence: medium (vendor header for this chip family, not hardware verified).";

        field {
            name = "mixer_bkgy";
            desc = "[inferred] Mixer bkgy. (vendor header `product/hiosd/vo/hi3519/vou_reg.h` field `mixer_bkgy`; access and reset unknown, modelled RW)";
            sw = rw;
            hw = r;
        } mixer_bkgy[29:20];

        field {
            name = "mixer_bkgcb";
            desc = "[inferred] Mixer bkgcb. (vendor header `product/hiosd/vo/hi3519/vou_reg.h` field `mixer_bkgcb`; access and reset unknown, modelled RW)";
            sw = rw;
            hw = r;
        } mixer_bkgcb[19:10];

        field {
            name = "mixer_bkgcr";
            desc = "[inferred] Mixer bkgcr. (vendor header `product/hiosd/vo/hi3519/vou_reg.h` field `mixer_bkgcr`; access and reset unknown, modelled RW)";
            sw = rw;
            hw = r;
        } mixer_bkgcr[9:0];
    } MIXV0_BKG @ 0xB000;

    reg {
        name = "MIXV0 MIX";
        desc = "[inferred] MIXV0 MIX. Not in the data sheet. Source: vendor U-Boot 2010.06 `product/hiosd/vo/hi3519/vou_reg.h` (GPL-2.0 U-Boot tree, HiSilicon copyright, created 2015-05-26; mirror github.com/OpenIPC/u-boot-hi3516cv200), union `U_MIXV0_MIX`, struct offset 0xB008 (GPL-2.0, same-chip vendor header, byte-identical for Hi3516A V200 and Hi3519 V101). Reset value and access type unknown (modelled RW, no reset). Confidence: medium (vendor header for this chip family, not hardware verified).";

        field {
            name = "mixer_prio1";
            desc = "[inferred] Mixer prio1. (vendor header `product/hiosd/vo/hi3519/vou_reg.h` field `mixer_prio1`; access and reset unknown, modelled RW)";
            sw = rw;
            hw = r;
        } mixer_prio1[7:4];

        field {
            name = "mixer_prio0";
            desc = "[inferred] Mixer prio0. (vendor header `product/hiosd/vo/hi3519/vou_reg.h` field `mixer_prio0`; access and reset unknown, modelled RW)";
            sw = rw;
            hw = r;
        } mixer_prio0[3:0];
    } MIXV0_MIX @ 0xB008;

    reg {
        name = "MIXG0 BKG";
        desc = "[inferred] MIXG0 BKG. Not in the data sheet. Source: vendor U-Boot 2010.06 `product/hiosd/vo/hi3519/vou_reg.h` (GPL-2.0 U-Boot tree, HiSilicon copyright, created 2015-05-26; mirror github.com/OpenIPC/u-boot-hi3516cv200), union `U_MIXG0_BKG`, struct offset 0xB200 (GPL-2.0, same-chip vendor header, byte-identical for Hi3516A V200 and Hi3519 V101). Reset value and access type unknown (modelled RW, no reset). Confidence: medium (vendor header for this chip family, not hardware verified).";

        field {
            name = "mixer_bkgy";
            desc = "[inferred] Mixer bkgy. (vendor header `product/hiosd/vo/hi3519/vou_reg.h` field `mixer_bkgy`; access and reset unknown, modelled RW)";
            sw = rw;
            hw = r;
        } mixer_bkgy[29:20];

        field {
            name = "mixer_bkgcb";
            desc = "[inferred] Mixer bkgcb. (vendor header `product/hiosd/vo/hi3519/vou_reg.h` field `mixer_bkgcb`; access and reset unknown, modelled RW)";
            sw = rw;
            hw = r;
        } mixer_bkgcb[19:10];

        field {
            name = "mixer_bkgcr";
            desc = "[inferred] Mixer bkgcr. (vendor header `product/hiosd/vo/hi3519/vou_reg.h` field `mixer_bkgcr`; access and reset unknown, modelled RW)";
            sw = rw;
            hw = r;
        } mixer_bkgcr[9:0];
    } MIXG0_BKG @ 0xB200;

    reg {
        name = "MIXG0 BKALPHA";
        desc = "[inferred] MIXG0 BKALPHA. Not in the data sheet. Source: vendor U-Boot 2010.06 `product/hiosd/vo/hi3519/vou_reg.h` (GPL-2.0 U-Boot tree, HiSilicon copyright, created 2015-05-26; mirror github.com/OpenIPC/u-boot-hi3516cv200), union `U_MIXG0_BKALPHA`, struct offset 0xB204 (GPL-2.0, same-chip vendor header, byte-identical for Hi3516A V200 and Hi3519 V101). Reset value and access type unknown (modelled RW, no reset). Confidence: medium (vendor header for this chip family, not hardware verified).";

        field {
            name = "mixer_alpha";
            desc = "[inferred] Mixer alpha. (vendor header `product/hiosd/vo/hi3519/vou_reg.h` field `mixer_alpha`; access and reset unknown, modelled RW)";
            sw = rw;
            hw = r;
        } mixer_alpha[7:0];
    } MIXG0_BKALPHA @ 0xB204;

    reg {
        name = "MIXG0 MIX";
        desc = "[inferred] MIXG0 MIX. Not in the data sheet. Source: vendor U-Boot 2010.06 `product/hiosd/vo/hi3519/vou_reg.h` (GPL-2.0 U-Boot tree, HiSilicon copyright, created 2015-05-26; mirror github.com/OpenIPC/u-boot-hi3516cv200), union `U_MIXG0_MIX`, struct offset 0xB208 (GPL-2.0, same-chip vendor header, byte-identical for Hi3516A V200 and Hi3519 V101). Reset value and access type unknown (modelled RW, no reset). Confidence: medium (vendor header for this chip family, not hardware verified).";

        field {
            name = "mixer_prio3";
            desc = "[inferred] Mixer prio3. (vendor header `product/hiosd/vo/hi3519/vou_reg.h` field `mixer_prio3`; access and reset unknown, modelled RW)";
            sw = rw;
            hw = r;
        } mixer_prio3[15:12];

        field {
            name = "mixer_prio2";
            desc = "[inferred] Mixer prio2. (vendor header `product/hiosd/vo/hi3519/vou_reg.h` field `mixer_prio2`; access and reset unknown, modelled RW)";
            sw = rw;
            hw = r;
        } mixer_prio2[11:8];

        field {
            name = "mixer_prio1";
            desc = "[inferred] Mixer prio1. (vendor header `product/hiosd/vo/hi3519/vou_reg.h` field `mixer_prio1`; access and reset unknown, modelled RW)";
            sw = rw;
            hw = r;
        } mixer_prio1[7:4];

        field {
            name = "mixer_prio0";
            desc = "[inferred] Mixer prio0. (vendor header `product/hiosd/vo/hi3519/vou_reg.h` field `mixer_prio0`; access and reset unknown, modelled RW)";
            sw = rw;
            hw = r;
        } mixer_prio0[3:0];
    } MIXG0_MIX @ 0xB208;

    reg {
        name = "CBM BKG1";
        desc = "[inferred] CBM BKG1. Not in the data sheet. Source: vendor U-Boot 2010.06 `product/hiosd/vo/hi3519/vou_reg.h` (GPL-2.0 U-Boot tree, HiSilicon copyright, created 2015-05-26; mirror github.com/OpenIPC/u-boot-hi3516cv200), union `U_CBM_BKG1`, struct offset 0xB400 (GPL-2.0, same-chip vendor header, byte-identical for Hi3516A V200 and Hi3519 V101). Reset value and access type unknown (modelled RW, no reset). Confidence: medium (vendor header for this chip family, not hardware verified).";

        field {
            name = "cbm_bkgy1";
            desc = "[inferred] Cbm bkgy1. (vendor header `product/hiosd/vo/hi3519/vou_reg.h` field `cbm_bkgy1`; access and reset unknown, modelled RW)";
            sw = rw;
            hw = r;
        } cbm_bkgy1[29:20];

        field {
            name = "cbm_bkgcb1";
            desc = "[inferred] Cbm bkgcb1. (vendor header `product/hiosd/vo/hi3519/vou_reg.h` field `cbm_bkgcb1`; access and reset unknown, modelled RW)";
            sw = rw;
            hw = r;
        } cbm_bkgcb1[19:10];

        field {
            name = "cbm_bkgcr1";
            desc = "[inferred] Cbm bkgcr1. (vendor header `product/hiosd/vo/hi3519/vou_reg.h` field `cbm_bkgcr1`; access and reset unknown, modelled RW)";
            sw = rw;
            hw = r;
        } cbm_bkgcr1[9:0];
    } CBM_BKG1 @ 0xB400;

    reg {
        name = "CBM MIX1";
        desc = "[inferred] CBM MIX1. Not in the data sheet. Source: vendor U-Boot 2010.06 `product/hiosd/vo/hi3519/vou_reg.h` (GPL-2.0 U-Boot tree, HiSilicon copyright, created 2015-05-26; mirror github.com/OpenIPC/u-boot-hi3516cv200), union `U_CBM_MIX1`, struct offset 0xB408 (GPL-2.0, same-chip vendor header, byte-identical for Hi3516A V200 and Hi3519 V101). Reset value and access type unknown (modelled RW, no reset). Confidence: medium (vendor header for this chip family, not hardware verified).";

        field {
            name = "mixer_prio3";
            desc = "[inferred] Mixer prio3. (vendor header `product/hiosd/vo/hi3519/vou_reg.h` field `mixer_prio3`; access and reset unknown, modelled RW)";
            sw = rw;
            hw = r;
        } mixer_prio3[15:12];

        field {
            name = "mixer_prio2";
            desc = "[inferred] Mixer prio2. (vendor header `product/hiosd/vo/hi3519/vou_reg.h` field `mixer_prio2`; access and reset unknown, modelled RW)";
            sw = rw;
            hw = r;
        } mixer_prio2[11:8];

        field {
            name = "mixer_prio1";
            desc = "[inferred] Mixer prio1. (vendor header `product/hiosd/vo/hi3519/vou_reg.h` field `mixer_prio1`; access and reset unknown, modelled RW)";
            sw = rw;
            hw = r;
        } mixer_prio1[7:4];

        field {
            name = "mixer_prio0";
            desc = "[inferred] Mixer prio0. (vendor header `product/hiosd/vo/hi3519/vou_reg.h` field `mixer_prio0`; access and reset unknown, modelled RW)";
            sw = rw;
            hw = r;
        } mixer_prio0[3:0];
    } CBM_MIX1 @ 0xB408;

    reg {
        name = "CBM mixer 2 overlay background color register";
        desc = "CBM_BKG2 is a CBM mixer 2 overlay background color register. Hi3516A V200 Professional HD IP Camera SoC

Data sheet 9.2.6 CBM_BKG2 (offset 0xB420, printed page 9-125, `hi3516av200--Hi3516AV200-Datasheet.txt` line 44455).";

        field {
            name = "cbm_bkgy2";
            desc = "Overlay background color of CBM mixer 2, Y component";
            sw = rw;
            hw = r;
            reset = 0x0;
        } cbm_bkgy2[29:20];

        field {
            name = "cbm_bkgcb2";
            desc = "Overlay background color of CBM mixer 2, Cb component";
            sw = rw;
            hw = r;
            reset = 0x0;
        } cbm_bkgcb2[19:10];

        field {
            name = "cbm_bkgcr2";
            desc = "Overlay background color of CBM mixer 2, Cr component";
            sw = rw;
            hw = r;
            reset = 0x0;
        } cbm_bkgcr2[9:0];
    } CBM_BKG2 @ 0xB420;

    reg {
        name = "CBM mixer 2 priority configuration register";
        desc = "CBM_MIX2 is a CBM mixer 2 priority configuration register (instant register). The register configuration takes effect only when the VS signal is valid. mixer_prio_x is overly layer priority x.

Data sheet 9.2.6 CBM_MIX2 (offset 0xB428, printed page 9-125, `hi3516av200--Hi3516AV200-Datasheet.txt` line 44483).";

        field {
            name = "mixer_prio3";
            desc = "[inferred] Mixer prio3. (bits reserved in the data sheet; vendor header `product/hiosd/vo/hi3519/vou_reg.h` field `mixer_prio3`; access and reset unknown, modelled RW)";
            sw = rw;
            hw = r;
        } mixer_prio3[15:12];

        field {
            name = "mixer_prio2";
            desc = "[inferred] Mixer prio2. (bits reserved in the data sheet; vendor header `product/hiosd/vo/hi3519/vou_reg.h` field `mixer_prio2`; access and reset unknown, modelled RW)";
            sw = rw;
            hw = r;
        } mixer_prio2[11:8];

        enum CBM_MIX2_mixer_prio1_enum {
            NO_DRIVE_LAYER = 0 { name = "No Drive Layer"; desc = "no drive layer"; };
            V1 = 9 { name = "V1"; desc = "V1"; };
            G2_OTHER_VALUES = 10 { name = "G2 Other Values"; desc = "G2 Other values: reserved"; };
        };

        field {
            name = "mixer_prio1";
            desc = "Drive layer of CBM mixer 2 with priority 1";
            sw = rw;
            hw = r;
            encode = CBM_MIX2_mixer_prio1_enum;
            reset = 0x0;
        } mixer_prio1[7:4];

        enum CBM_MIX2_mixer_prio0_enum {
            NO_DRIVE_LAYER = 0 { name = "No Drive Layer"; desc = "no drive layer"; };
            V1 = 9 { name = "V1"; desc = "V1"; };
            G2_OTHER_VALUES = 10 { name = "G2 Other Values"; desc = "G2 Other values: reserved"; };
        };

        field {
            name = "mixer_prio0";
            desc = "Drive layer of CBM mixer 2 with priority 0";
            sw = rw;
            hw = r;
            encode = CBM_MIX2_mixer_prio0_enum;
            reset = 0x0;
        } mixer_prio0[3:0];
    } CBM_MIX2 @ 0xB428;

    reg {
        name = "CBM ATTR";
        desc = "[inferred] CBM ATTR. Not in the data sheet. Source: vendor U-Boot 2010.06 `product/hiosd/vo/hi3519/vou_reg.h` (GPL-2.0 U-Boot tree, HiSilicon copyright, created 2015-05-26; mirror github.com/OpenIPC/u-boot-hi3516cv200), union `U_CBM_ATTR`, struct offset 0xB440 (GPL-2.0, same-chip vendor header, byte-identical for Hi3516A V200 and Hi3519 V101). Reset value and access type unknown (modelled RW, no reset). Confidence: medium (vendor header for this chip family, not hardware verified).";

        field {
            name = "sur_attr5";
            desc = "[inferred] Sur attr5. (vendor header `product/hiosd/vo/hi3519/vou_reg.h` field `sur_attr5`; access and reset unknown, modelled RW)";
            sw = rw;
            hw = r;
        } sur_attr5[5:5];

        field {
            name = "sur_attr4";
            desc = "[inferred] Sur attr4. (vendor header `product/hiosd/vo/hi3519/vou_reg.h` field `sur_attr4`; access and reset unknown, modelled RW)";
            sw = rw;
            hw = r;
        } sur_attr4[4:4];

        field {
            name = "sur_attr3";
            desc = "[inferred] Sur attr3. (vendor header `product/hiosd/vo/hi3519/vou_reg.h` field `sur_attr3`; access and reset unknown, modelled RW)";
            sw = rw;
            hw = r;
        } sur_attr3[3:3];

        field {
            name = "sur_attr2";
            desc = "[inferred] Sur attr2. (vendor header `product/hiosd/vo/hi3519/vou_reg.h` field `sur_attr2`; access and reset unknown, modelled RW)";
            sw = rw;
            hw = r;
        } sur_attr2[2:2];

        field {
            name = "sur_attr1";
            desc = "[inferred] Sur attr1. (vendor header `product/hiosd/vo/hi3519/vou_reg.h` field `sur_attr1`; access and reset unknown, modelled RW)";
            sw = rw;
            hw = r;
        } sur_attr1[1:1];

        field {
            name = "sur_attr0";
            desc = "[inferred] Sur attr0. (vendor header `product/hiosd/vo/hi3519/vou_reg.h` field `sur_attr0`; access and reset unknown, modelled RW)";
            sw = rw;
            hw = r;
        } sur_attr0[0:0];
    } CBM_ATTR @ 0xB440;

    reg {
        name = "MIXDSD BKG";
        desc = "[inferred] MIXDSD BKG. Not in the data sheet. Source: vendor U-Boot 2010.06 `product/hiosd/vo/hi3519/vou_reg.h` (GPL-2.0 U-Boot tree, HiSilicon copyright, created 2015-05-26; mirror github.com/OpenIPC/u-boot-hi3516cv200), union `U_MIXDSD_BKG`, struct offset 0xB600 (GPL-2.0, same-chip vendor header, byte-identical for Hi3516A V200 and Hi3519 V101). Reset value and access type unknown (modelled RW, no reset). Confidence: medium (vendor header for this chip family, not hardware verified).";

        field {
            name = "mixer_bkgy";
            desc = "[inferred] Mixer bkgy. (vendor header `product/hiosd/vo/hi3519/vou_reg.h` field `mixer_bkgy`; access and reset unknown, modelled RW)";
            sw = rw;
            hw = r;
        } mixer_bkgy[29:20];

        field {
            name = "mixer_bkgcb";
            desc = "[inferred] Mixer bkgcb. (vendor header `product/hiosd/vo/hi3519/vou_reg.h` field `mixer_bkgcb`; access and reset unknown, modelled RW)";
            sw = rw;
            hw = r;
        } mixer_bkgcb[19:10];

        field {
            name = "mixer_bkgcr";
            desc = "[inferred] Mixer bkgcr. (vendor header `product/hiosd/vo/hi3519/vou_reg.h` field `mixer_bkgcr`; access and reset unknown, modelled RW)";
            sw = rw;
            hw = r;
        } mixer_bkgcr[9:0];
    } MIXDSD_BKG @ 0xB600;

    reg {
        name = "MIXDSD MIX";
        desc = "[inferred] MIXDSD MIX. Not in the data sheet. Source: vendor U-Boot 2010.06 `product/hiosd/vo/hi3519/vou_reg.h` (GPL-2.0 U-Boot tree, HiSilicon copyright, created 2015-05-26; mirror github.com/OpenIPC/u-boot-hi3516cv200), union `U_MIXDSD_MIX`, struct offset 0xB608 (GPL-2.0, same-chip vendor header, byte-identical for Hi3516A V200 and Hi3519 V101). Reset value and access type unknown (modelled RW, no reset). Confidence: medium (vendor header for this chip family, not hardware verified).";

        field {
            name = "mixer_prio2";
            desc = "[inferred] Mixer prio2. (vendor header `product/hiosd/vo/hi3519/vou_reg.h` field `mixer_prio2`; access and reset unknown, modelled RW)";
            sw = rw;
            hw = r;
        } mixer_prio2[11:8];

        field {
            name = "mixer_prio1";
            desc = "[inferred] Mixer prio1. (vendor header `product/hiosd/vo/hi3519/vou_reg.h` field `mixer_prio1`; access and reset unknown, modelled RW)";
            sw = rw;
            hw = r;
        } mixer_prio1[7:4];

        field {
            name = "mixer_prio0";
            desc = "[inferred] Mixer prio0. (vendor header `product/hiosd/vo/hi3519/vou_reg.h` field `mixer_prio0`; access and reset unknown, modelled RW)";
            sw = rw;
            hw = r;
        } mixer_prio0[3:0];
    } MIXDSD_MIX @ 0xB608;

    reg {
        name = "DHD0 control";
        desc = "[inferred] DHD0 control. Not in the data sheet. Source: vendor U-Boot 2010.06 `product/hiosd/vo/hi3519/vou_reg.h` (GPL-2.0 U-Boot tree, HiSilicon copyright, created 2015-05-26; mirror github.com/OpenIPC/u-boot-hi3516cv200), union `U_DHD0_CTRL`, struct offset 0xC000 (GPL-2.0, same-chip vendor header, byte-identical for Hi3516A V200 and Hi3519 V101). Reset value and access type unknown (modelled RW, no reset). Confidence: medium (vendor header for this chip family, not hardware verified).";

        field {
            name = "intf_en";
            desc = "[inferred] Intf enable. (vendor header `product/hiosd/vo/hi3519/vou_reg.h` field `intf_en`; access and reset unknown, modelled RW)";
            sw = rw;
            hw = r;
        } intf_en[31:31];

        field {
            name = "cbar_en";
            desc = "[inferred] Cbar enable. (vendor header `product/hiosd/vo/hi3519/vou_reg.h` field `cbar_en`; access and reset unknown, modelled RW)";
            sw = rw;
            hw = r;
        } cbar_en[30:30];

        field {
            name = "cbar_sel";
            desc = "[inferred] Cbar select. (vendor header `product/hiosd/vo/hi3519/vou_reg.h` field `cbar_sel`; access and reset unknown, modelled RW)";
            sw = rw;
            hw = r;
        } cbar_sel[29:29];

        field {
            name = "p2i_en";
            desc = "[inferred] P2i enable. (vendor header `product/hiosd/vo/hi3519/vou_reg.h` field `p2i_en`; access and reset unknown, modelled RW)";
            sw = rw;
            hw = r;
        } p2i_en[28:28];

        field {
            name = "fpga_lmt_en";
            desc = "[inferred] Fpga lmt enable. (vendor header `product/hiosd/vo/hi3519/vou_reg.h` field `fpga_lmt_en`; access and reset unknown, modelled RW)";
            sw = rw;
            hw = r;
        } fpga_lmt_en[27:27];

        field {
            name = "fpga_lmt_width";
            desc = "[inferred] Fpga lmt width. (vendor header `product/hiosd/vo/hi3519/vou_reg.h` field `fpga_lmt_width`; access and reset unknown, modelled RW)";
            sw = rw;
            hw = r;
        } fpga_lmt_width[26:20];

        field {
            name = "trigger_en";
            desc = "[inferred] Trigger enable. (vendor header `product/hiosd/vo/hi3519/vou_reg.h` field `trigger_en`; access and reset unknown, modelled RW)";
            sw = rw;
            hw = r;
        } trigger_en[19:19];

        field {
            name = "sin_en";
            desc = "[inferred] Sin enable. (vendor header `product/hiosd/vo/hi3519/vou_reg.h` field `sin_en`; access and reset unknown, modelled RW)";
            sw = rw;
            hw = r;
        } sin_en[18:18];

        field {
            name = "hdmi_mode";
            desc = "[inferred] Hdmi mode. (vendor header `product/hiosd/vo/hi3519/vou_reg.h` field `hdmi_mode`; access and reset unknown, modelled RW)";
            sw = rw;
            hw = r;
        } hdmi_mode[14:14];

        field {
            name = "gmm_en";
            desc = "[inferred] Gmm enable. (vendor header `product/hiosd/vo/hi3519/vou_reg.h` field `gmm_en`; access and reset unknown, modelled RW)";
            sw = rw;
            hw = r;
        } gmm_en[13:13];

        field {
            name = "gmm_mode";
            desc = "[inferred] Gmm mode. (vendor header `product/hiosd/vo/hi3519/vou_reg.h` field `gmm_mode`; access and reset unknown, modelled RW)";
            sw = rw;
            hw = r;
        } gmm_mode[12:12];

        field {
            name = "precharge_en";
            desc = "[inferred] Precharge enable. (vendor header `product/hiosd/vo/hi3519/vou_reg.h` field `precharge_en`; access and reset unknown, modelled RW)";
            sw = rw;
            hw = r;
        } precharge_en[10:10];

        field {
            name = "precharge_mode";
            desc = "[inferred] Precharge mode. (vendor header `product/hiosd/vo/hi3519/vou_reg.h` field `precharge_mode`; access and reset unknown, modelled RW)";
            sw = rw;
            hw = r;
        } precharge_mode[9:9];

        field {
            name = "iop";
            desc = "[inferred] Iop. (vendor header `product/hiosd/vo/hi3519/vou_reg.h` field `iop`; access and reset unknown, modelled RW)";
            sw = rw;
            hw = r;
        } iop[4:4];

        field {
            name = "disp_mode";
            desc = "[inferred] Disp mode. (vendor header `product/hiosd/vo/hi3519/vou_reg.h` field `disp_mode`; access and reset unknown, modelled RW)";
            sw = rw;
            hw = r;
        } disp_mode[3:1];

        field {
            name = "regup";
            desc = "[inferred] Regup. (vendor header `product/hiosd/vo/hi3519/vou_reg.h` field `regup`; access and reset unknown, modelled RW)";
            sw = rw;
            hw = r;
        } regup[0:0];
    } DHD0_CTRL @ 0xC000;

    reg {
        name = "DHD0 vertical sync";
        desc = "[inferred] DHD0 vertical sync. Not in the data sheet. Source: vendor U-Boot 2010.06 `product/hiosd/vo/hi3519/vou_reg.h` (GPL-2.0 U-Boot tree, HiSilicon copyright, created 2015-05-26; mirror github.com/OpenIPC/u-boot-hi3516cv200), union `U_DHD0_VSYNC`, struct offset 0xC004 (GPL-2.0, same-chip vendor header, byte-identical for Hi3516A V200 and Hi3519 V101). Reset value and access type unknown (modelled RW, no reset). Confidence: medium (vendor header for this chip family, not hardware verified).";

        field {
            name = "vfb";
            desc = "[inferred] Vfb. (vendor header `product/hiosd/vo/hi3519/vou_reg.h` field `vfb`; access and reset unknown, modelled RW)";
            sw = rw;
            hw = r;
        } vfb[27:20];

        field {
            name = "vbb";
            desc = "[inferred] Vbb. (vendor header `product/hiosd/vo/hi3519/vou_reg.h` field `vbb`; access and reset unknown, modelled RW)";
            sw = rw;
            hw = r;
        } vbb[19:12];

        field {
            name = "vact";
            desc = "[inferred] Vact. (vendor header `product/hiosd/vo/hi3519/vou_reg.h` field `vact`; access and reset unknown, modelled RW)";
            sw = rw;
            hw = r;
        } vact[11:0];
    } DHD0_VSYNC @ 0xC004;

    reg {
        name = "DHD0 HSYNC1";
        desc = "[inferred] DHD0 HSYNC1. Not in the data sheet. Source: vendor U-Boot 2010.06 `product/hiosd/vo/hi3519/vou_reg.h` (GPL-2.0 U-Boot tree, HiSilicon copyright, created 2015-05-26; mirror github.com/OpenIPC/u-boot-hi3516cv200), union `U_DHD0_HSYNC1`, struct offset 0xC008 (GPL-2.0, same-chip vendor header, byte-identical for Hi3516A V200 and Hi3519 V101). Reset value and access type unknown (modelled RW, no reset). Confidence: medium (vendor header for this chip family, not hardware verified).";

        field {
            name = "hbb";
            desc = "[inferred] Hbb. (vendor header `product/hiosd/vo/hi3519/vou_reg.h` field `hbb`; access and reset unknown, modelled RW)";
            sw = rw;
            hw = r;
        } hbb[31:16];

        field {
            name = "hact";
            desc = "[inferred] Hact. (vendor header `product/hiosd/vo/hi3519/vou_reg.h` field `hact`; access and reset unknown, modelled RW)";
            sw = rw;
            hw = r;
        } hact[15:0];
    } DHD0_HSYNC1 @ 0xC008;

    reg {
        name = "DHD0 HSYNC2";
        desc = "[inferred] DHD0 HSYNC2. Not in the data sheet. Source: vendor U-Boot 2010.06 `product/hiosd/vo/hi3519/vou_reg.h` (GPL-2.0 U-Boot tree, HiSilicon copyright, created 2015-05-26; mirror github.com/OpenIPC/u-boot-hi3516cv200), union `U_DHD0_HSYNC2`, struct offset 0xC00C (GPL-2.0, same-chip vendor header, byte-identical for Hi3516A V200 and Hi3519 V101). Reset value and access type unknown (modelled RW, no reset). Confidence: medium (vendor header for this chip family, not hardware verified).";

        field {
            name = "hmid";
            desc = "[inferred] Hmid. (vendor header `product/hiosd/vo/hi3519/vou_reg.h` field `hmid`; access and reset unknown, modelled RW)";
            sw = rw;
            hw = r;
        } hmid[31:16];

        field {
            name = "hfb";
            desc = "[inferred] Hfb. (vendor header `product/hiosd/vo/hi3519/vou_reg.h` field `hfb`; access and reset unknown, modelled RW)";
            sw = rw;
            hw = r;
        } hfb[15:0];
    } DHD0_HSYNC2 @ 0xC00C;

    reg {
        name = "DHD0 VPLUS";
        desc = "[inferred] DHD0 VPLUS. Not in the data sheet. Source: vendor U-Boot 2010.06 `product/hiosd/vo/hi3519/vou_reg.h` (GPL-2.0 U-Boot tree, HiSilicon copyright, created 2015-05-26; mirror github.com/OpenIPC/u-boot-hi3516cv200), union `U_DHD0_VPLUS`, struct offset 0xC010 (GPL-2.0, same-chip vendor header, byte-identical for Hi3516A V200 and Hi3519 V101). Reset value and access type unknown (modelled RW, no reset). Confidence: medium (vendor header for this chip family, not hardware verified).";

        field {
            name = "bvfb";
            desc = "[inferred] Bvfb. (vendor header `product/hiosd/vo/hi3519/vou_reg.h` field `bvfb`; access and reset unknown, modelled RW)";
            sw = rw;
            hw = r;
        } bvfb[27:20];

        field {
            name = "bvbb";
            desc = "[inferred] Bvbb. (vendor header `product/hiosd/vo/hi3519/vou_reg.h` field `bvbb`; access and reset unknown, modelled RW)";
            sw = rw;
            hw = r;
        } bvbb[19:12];

        field {
            name = "bvact";
            desc = "[inferred] Bvact. (vendor header `product/hiosd/vo/hi3519/vou_reg.h` field `bvact`; access and reset unknown, modelled RW)";
            sw = rw;
            hw = r;
        } bvact[11:0];
    } DHD0_VPLUS @ 0xC010;

    reg {
        name = "DHD0 PWR";
        desc = "[inferred] DHD0 PWR. Not in the data sheet. Source: vendor U-Boot 2010.06 `product/hiosd/vo/hi3519/vou_reg.h` (GPL-2.0 U-Boot tree, HiSilicon copyright, created 2015-05-26; mirror github.com/OpenIPC/u-boot-hi3516cv200), union `U_DHD0_PWR`, struct offset 0xC014 (GPL-2.0, same-chip vendor header, byte-identical for Hi3516A V200 and Hi3519 V101). Reset value and access type unknown (modelled RW, no reset). Confidence: medium (vendor header for this chip family, not hardware verified).";

        field {
            name = "vpw";
            desc = "[inferred] Vpw. (vendor header `product/hiosd/vo/hi3519/vou_reg.h` field `vpw`; access and reset unknown, modelled RW)";
            sw = rw;
            hw = r;
        } vpw[23:16];

        field {
            name = "hpw";
            desc = "[inferred] Hpw. (vendor header `product/hiosd/vo/hi3519/vou_reg.h` field `hpw`; access and reset unknown, modelled RW)";
            sw = rw;
            hw = r;
        } hpw[15:0];
    } DHD0_PWR @ 0xC014;

    reg {
        name = "DHD0 VTTHD3";
        desc = "[inferred] DHD0 VTTHD3. Not in the data sheet. Source: vendor U-Boot 2010.06 `product/hiosd/vo/hi3519/vou_reg.h` (GPL-2.0 U-Boot tree, HiSilicon copyright, created 2015-05-26; mirror github.com/OpenIPC/u-boot-hi3516cv200), union `U_DHD0_VTTHD3`, struct offset 0xC018 (GPL-2.0, same-chip vendor header, byte-identical for Hi3516A V200 and Hi3519 V101). Reset value and access type unknown (modelled RW, no reset). Confidence: medium (vendor header for this chip family, not hardware verified).";

        field {
            name = "thd4_mode";
            desc = "[inferred] Thd4 mode. (vendor header `product/hiosd/vo/hi3519/vou_reg.h` field `thd4_mode`; access and reset unknown, modelled RW)";
            sw = rw;
            hw = r;
        } thd4_mode[31:31];

        field {
            name = "vtmgthd4";
            desc = "[inferred] Vtmgthd4. (vendor header `product/hiosd/vo/hi3519/vou_reg.h` field `vtmgthd4`; access and reset unknown, modelled RW)";
            sw = rw;
            hw = r;
        } vtmgthd4[28:16];

        field {
            name = "thd3_mode";
            desc = "[inferred] Thd3 mode. (vendor header `product/hiosd/vo/hi3519/vou_reg.h` field `thd3_mode`; access and reset unknown, modelled RW)";
            sw = rw;
            hw = r;
        } thd3_mode[15:15];

        field {
            name = "vtmgthd3";
            desc = "[inferred] Vtmgthd3. (vendor header `product/hiosd/vo/hi3519/vou_reg.h` field `vtmgthd3`; access and reset unknown, modelled RW)";
            sw = rw;
            hw = r;
        } vtmgthd3[12:0];
    } DHD0_VTTHD3 @ 0xC018;

    reg {
        name = "DHD0 VTTHD";
        desc = "[inferred] DHD0 VTTHD. Not in the data sheet. Source: vendor U-Boot 2010.06 `product/hiosd/vo/hi3519/vou_reg.h` (GPL-2.0 U-Boot tree, HiSilicon copyright, created 2015-05-26; mirror github.com/OpenIPC/u-boot-hi3516cv200), union `U_DHD0_VTTHD`, struct offset 0xC01C (GPL-2.0, same-chip vendor header, byte-identical for Hi3516A V200 and Hi3519 V101). Reset value and access type unknown (modelled RW, no reset). Confidence: medium (vendor header for this chip family, not hardware verified).";

        field {
            name = "thd2_mode";
            desc = "[inferred] Thd2 mode. (vendor header `product/hiosd/vo/hi3519/vou_reg.h` field `thd2_mode`; access and reset unknown, modelled RW)";
            sw = rw;
            hw = r;
        } thd2_mode[31:31];

        field {
            name = "vtmgthd2";
            desc = "[inferred] Vtmgthd2. (vendor header `product/hiosd/vo/hi3519/vou_reg.h` field `vtmgthd2`; access and reset unknown, modelled RW)";
            sw = rw;
            hw = r;
        } vtmgthd2[28:16];

        field {
            name = "thd1_mode";
            desc = "[inferred] Thd1 mode. (vendor header `product/hiosd/vo/hi3519/vou_reg.h` field `thd1_mode`; access and reset unknown, modelled RW)";
            sw = rw;
            hw = r;
        } thd1_mode[15:15];

        field {
            name = "vtmgthd1";
            desc = "[inferred] Vtmgthd1. (vendor header `product/hiosd/vo/hi3519/vou_reg.h` field `vtmgthd1`; access and reset unknown, modelled RW)";
            sw = rw;
            hw = r;
        } vtmgthd1[12:0];
    } DHD0_VTTHD @ 0xC01C;

    reg {
        name = "DHD0 SYNC invert";
        desc = "[inferred] DHD0 SYNC invert. Not in the data sheet. Source: vendor U-Boot 2010.06 `product/hiosd/vo/hi3519/vou_reg.h` (GPL-2.0 U-Boot tree, HiSilicon copyright, created 2015-05-26; mirror github.com/OpenIPC/u-boot-hi3516cv200), union `U_DHD0_SYNC_INV`, struct offset 0xC020 (GPL-2.0, same-chip vendor header, byte-identical for Hi3516A V200 and Hi3519 V101). Reset value and access type unknown (modelled RW, no reset). Confidence: medium (vendor header for this chip family, not hardware verified).";

        field {
            name = "date_f_inv";
            desc = "[inferred] Date f invert. (vendor header `product/hiosd/vo/hi3519/vou_reg.h` field `date_f_inv`; access and reset unknown, modelled RW)";
            sw = rw;
            hw = r;
        } date_f_inv[15:15];

        field {
            name = "date_vs_inv";
            desc = "[inferred] Date vertical sync invert. (vendor header `product/hiosd/vo/hi3519/vou_reg.h` field `date_vs_inv`; access and reset unknown, modelled RW)";
            sw = rw;
            hw = r;
        } date_vs_inv[14:14];

        field {
            name = "date_hs_inv";
            desc = "[inferred] Date horizontal sync invert. (vendor header `product/hiosd/vo/hi3519/vou_reg.h` field `date_hs_inv`; access and reset unknown, modelled RW)";
            sw = rw;
            hw = r;
        } date_hs_inv[13:13];

        field {
            name = "date_dv_inv";
            desc = "[inferred] Date dv invert. (vendor header `product/hiosd/vo/hi3519/vou_reg.h` field `date_dv_inv`; access and reset unknown, modelled RW)";
            sw = rw;
            hw = r;
        } date_dv_inv[12:12];

        field {
            name = "hdmi_f_inv";
            desc = "[inferred] Hdmi f invert. (vendor header `product/hiosd/vo/hi3519/vou_reg.h` field `hdmi_f_inv`; access and reset unknown, modelled RW)";
            sw = rw;
            hw = r;
        } hdmi_f_inv[11:11];

        field {
            name = "hdmi_vs_inv";
            desc = "[inferred] Hdmi vertical sync invert. (vendor header `product/hiosd/vo/hi3519/vou_reg.h` field `hdmi_vs_inv`; access and reset unknown, modelled RW)";
            sw = rw;
            hw = r;
        } hdmi_vs_inv[10:10];

        field {
            name = "hdmi_hs_inv";
            desc = "[inferred] Hdmi horizontal sync invert. (vendor header `product/hiosd/vo/hi3519/vou_reg.h` field `hdmi_hs_inv`; access and reset unknown, modelled RW)";
            sw = rw;
            hw = r;
        } hdmi_hs_inv[9:9];

        field {
            name = "hdmi_dv_inv";
            desc = "[inferred] Hdmi dv invert. (vendor header `product/hiosd/vo/hi3519/vou_reg.h` field `hdmi_dv_inv`; access and reset unknown, modelled RW)";
            sw = rw;
            hw = r;
        } hdmi_dv_inv[8:8];

        field {
            name = "vga_vs_inv";
            desc = "[inferred] Vga vertical sync invert. (vendor header `product/hiosd/vo/hi3519/vou_reg.h` field `vga_vs_inv`; access and reset unknown, modelled RW)";
            sw = rw;
            hw = r;
        } vga_vs_inv[6:6];

        field {
            name = "vga_hs_inv";
            desc = "[inferred] Vga horizontal sync invert. (vendor header `product/hiosd/vo/hi3519/vou_reg.h` field `vga_hs_inv`; access and reset unknown, modelled RW)";
            sw = rw;
            hw = r;
        } vga_hs_inv[5:5];

        field {
            name = "vga_dv_inv";
            desc = "[inferred] Vga dv invert. (vendor header `product/hiosd/vo/hi3519/vou_reg.h` field `vga_dv_inv`; access and reset unknown, modelled RW)";
            sw = rw;
            hw = r;
        } vga_dv_inv[4:4];

        field {
            name = "lcd_vs_inv";
            desc = "[inferred] Lcd vertical sync invert. (vendor header `product/hiosd/vo/hi3519/vou_reg.h` field `lcd_vs_inv`; access and reset unknown, modelled RW)";
            sw = rw;
            hw = r;
        } lcd_vs_inv[2:2];

        field {
            name = "lcd_hs_inv";
            desc = "[inferred] Lcd horizontal sync invert. (vendor header `product/hiosd/vo/hi3519/vou_reg.h` field `lcd_hs_inv`; access and reset unknown, modelled RW)";
            sw = rw;
            hw = r;
        } lcd_hs_inv[1:1];

        field {
            name = "lcd_dv_inv";
            desc = "[inferred] Lcd dv invert. (vendor header `product/hiosd/vo/hi3519/vou_reg.h` field `lcd_dv_inv`; access and reset unknown, modelled RW)";
            sw = rw;
            hw = r;
        } lcd_dv_inv[0:0];
    } DHD0_SYNC_INV @ 0xC020;

    reg {
        name = "DHD0 DATA select";
        desc = "[inferred] DHD0 DATA select. Not in the data sheet. Source: vendor U-Boot 2010.06 `product/hiosd/vo/hi3519/vou_reg.h` (GPL-2.0 U-Boot tree, HiSilicon copyright, created 2015-05-26; mirror github.com/OpenIPC/u-boot-hi3516cv200), union `U_DHD0_DATA_SEL`, struct offset 0xC02C (GPL-2.0, same-chip vendor header, byte-identical for Hi3516A V200 and Hi3519 V101). Reset value and access type unknown (modelled RW, no reset). Confidence: medium (vendor header for this chip family, not hardware verified).";

        field {
            name = "hdmi_data_sel";
            desc = "[inferred] Hdmi data select. (vendor header `product/hiosd/vo/hi3519/vou_reg.h` field `hdmi_data_sel`; access and reset unknown, modelled RW)";
            sw = rw;
            hw = r;
        } hdmi_data_sel[3:3];

        field {
            name = "lcd_data_sel";
            desc = "[inferred] Lcd data select. (vendor header `product/hiosd/vo/hi3519/vou_reg.h` field `lcd_data_sel`; access and reset unknown, modelled RW)";
            sw = rw;
            hw = r;
        } lcd_data_sel[2:2];

        field {
            name = "vga_data_sel";
            desc = "[inferred] Vga data select. (vendor header `product/hiosd/vo/hi3519/vou_reg.h` field `vga_data_sel`; access and reset unknown, modelled RW)";
            sw = rw;
            hw = r;
        } vga_data_sel[1:1];

        field {
            name = "date_data_sel";
            desc = "[inferred] Date data select. (vendor header `product/hiosd/vo/hi3519/vou_reg.h` field `date_data_sel`; access and reset unknown, modelled RW)";
            sw = rw;
            hw = r;
        } date_data_sel[0:0];
    } DHD0_DATA_SEL @ 0xC02C;

    reg {
        name = "DHD0 ABUFTHD";
        desc = "[inferred] DHD0 ABUFTHD. Not in the data sheet. Source: vendor U-Boot 2010.06 `product/hiosd/vo/hi3519/vou_reg.h` (GPL-2.0 U-Boot tree, HiSilicon copyright, created 2015-05-26; mirror github.com/OpenIPC/u-boot-hi3516cv200), union `U_DHD0_ABUFTHD`, struct offset 0xC034 (GPL-2.0, same-chip vendor header, byte-identical for Hi3516A V200 and Hi3519 V101). Reset value and access type unknown (modelled RW, no reset). Confidence: medium (vendor header for this chip family, not hardware verified).";

        field {
            name = "dhd_buf_thd";
            desc = "[inferred] Dhd buf threshold. (vendor header `product/hiosd/vo/hi3519/vou_reg.h` field `dhd_buf_thd`; access and reset unknown, modelled RW)";
            sw = rw;
            hw = r;
        } dhd_buf_thd[10:0];
    } DHD0_ABUFTHD @ 0xC034;

    reg {
        name = "DHD0 colour-space conversion IDC";
        desc = "[inferred] DHD0 colour-space conversion IDC. Not in the data sheet. Source: vendor U-Boot 2010.06 `product/hiosd/vo/hi3519/vou_reg.h` (GPL-2.0 U-Boot tree, HiSilicon copyright, created 2015-05-26; mirror github.com/OpenIPC/u-boot-hi3516cv200), union `U_DHD0_CSC_IDC`, struct offset 0xC040 (GPL-2.0, same-chip vendor header, byte-identical for Hi3516A V200 and Hi3519 V101). Reset value and access type unknown (modelled RW, no reset). Confidence: medium (vendor header for this chip family, not hardware verified).";

        field {
            name = "csc_en";
            desc = "[inferred] Colour-space conversion enable. (vendor header `product/hiosd/vo/hi3519/vou_reg.h` field `csc_en`; access and reset unknown, modelled RW)";
            sw = rw;
            hw = r;
        } csc_en[22:22];

        field {
            name = "cscidc1";
            desc = "[inferred] Cscidc1. (vendor header `product/hiosd/vo/hi3519/vou_reg.h` field `cscidc1`; access and reset unknown, modelled RW)";
            sw = rw;
            hw = r;
        } cscidc1[21:11];

        field {
            name = "cscidc0";
            desc = "[inferred] Cscidc0. (vendor header `product/hiosd/vo/hi3519/vou_reg.h` field `cscidc0`; access and reset unknown, modelled RW)";
            sw = rw;
            hw = r;
        } cscidc0[10:0];
    } DHD0_CSC_IDC @ 0xC040;

    reg {
        name = "DHD0 colour-space conversion ODC";
        desc = "[inferred] DHD0 colour-space conversion ODC. Not in the data sheet. Source: vendor U-Boot 2010.06 `product/hiosd/vo/hi3519/vou_reg.h` (GPL-2.0 U-Boot tree, HiSilicon copyright, created 2015-05-26; mirror github.com/OpenIPC/u-boot-hi3516cv200), union `U_DHD0_CSC_ODC`, struct offset 0xC044 (GPL-2.0, same-chip vendor header, byte-identical for Hi3516A V200 and Hi3519 V101). Reset value and access type unknown (modelled RW, no reset). Confidence: medium (vendor header for this chip family, not hardware verified).";

        field {
            name = "csc_sign_mode";
            desc = "[inferred] Colour-space conversion sign mode. (vendor header `product/hiosd/vo/hi3519/vou_reg.h` field `csc_sign_mode`; access and reset unknown, modelled RW)";
            sw = rw;
            hw = r;
        } csc_sign_mode[22:22];

        field {
            name = "cscodc1";
            desc = "[inferred] Cscodc1. (vendor header `product/hiosd/vo/hi3519/vou_reg.h` field `cscodc1`; access and reset unknown, modelled RW)";
            sw = rw;
            hw = r;
        } cscodc1[21:11];

        field {
            name = "cscodc0";
            desc = "[inferred] Cscodc0. (vendor header `product/hiosd/vo/hi3519/vou_reg.h` field `cscodc0`; access and reset unknown, modelled RW)";
            sw = rw;
            hw = r;
        } cscodc0[10:0];
    } DHD0_CSC_ODC @ 0xC044;

    reg {
        name = "DHD0 colour-space conversion IODC";
        desc = "[inferred] DHD0 colour-space conversion IODC. Not in the data sheet. Source: vendor U-Boot 2010.06 `product/hiosd/vo/hi3519/vou_reg.h` (GPL-2.0 U-Boot tree, HiSilicon copyright, created 2015-05-26; mirror github.com/OpenIPC/u-boot-hi3516cv200), union `U_DHD0_CSC_IODC`, struct offset 0xC048 (GPL-2.0, same-chip vendor header, byte-identical for Hi3516A V200 and Hi3519 V101). Reset value and access type unknown (modelled RW, no reset). Confidence: medium (vendor header for this chip family, not hardware verified).";

        field {
            name = "cscodc2";
            desc = "[inferred] Cscodc2. (vendor header `product/hiosd/vo/hi3519/vou_reg.h` field `cscodc2`; access and reset unknown, modelled RW)";
            sw = rw;
            hw = r;
        } cscodc2[21:11];

        field {
            name = "cscidc2";
            desc = "[inferred] Cscidc2. (vendor header `product/hiosd/vo/hi3519/vou_reg.h` field `cscidc2`; access and reset unknown, modelled RW)";
            sw = rw;
            hw = r;
        } cscidc2[10:0];
    } DHD0_CSC_IODC @ 0xC048;

    reg {
        name = "DHD0 colour-space conversion P0";
        desc = "[inferred] DHD0 colour-space conversion P0. Not in the data sheet. Source: vendor U-Boot 2010.06 `product/hiosd/vo/hi3519/vou_reg.h` (GPL-2.0 U-Boot tree, HiSilicon copyright, created 2015-05-26; mirror github.com/OpenIPC/u-boot-hi3516cv200), union `U_DHD0_CSC_P0`, struct offset 0xC04C (GPL-2.0, same-chip vendor header, byte-identical for Hi3516A V200 and Hi3519 V101). Reset value and access type unknown (modelled RW, no reset). Confidence: medium (vendor header for this chip family, not hardware verified).";

        field {
            name = "cscp01";
            desc = "[inferred] Cscp01. (vendor header `product/hiosd/vo/hi3519/vou_reg.h` field `cscp01`; access and reset unknown, modelled RW)";
            sw = rw;
            hw = r;
        } cscp01[30:16];

        field {
            name = "cscp00";
            desc = "[inferred] Cscp00. (vendor header `product/hiosd/vo/hi3519/vou_reg.h` field `cscp00`; access and reset unknown, modelled RW)";
            sw = rw;
            hw = r;
        } cscp00[14:0];
    } DHD0_CSC_P0 @ 0xC04C;

    reg {
        name = "DHD0 colour-space conversion P1";
        desc = "[inferred] DHD0 colour-space conversion P1. Not in the data sheet. Source: vendor U-Boot 2010.06 `product/hiosd/vo/hi3519/vou_reg.h` (GPL-2.0 U-Boot tree, HiSilicon copyright, created 2015-05-26; mirror github.com/OpenIPC/u-boot-hi3516cv200), union `U_DHD0_CSC_P1`, struct offset 0xC050 (GPL-2.0, same-chip vendor header, byte-identical for Hi3516A V200 and Hi3519 V101). Reset value and access type unknown (modelled RW, no reset). Confidence: medium (vendor header for this chip family, not hardware verified).";

        field {
            name = "cscp10";
            desc = "[inferred] Cscp10. (vendor header `product/hiosd/vo/hi3519/vou_reg.h` field `cscp10`; access and reset unknown, modelled RW)";
            sw = rw;
            hw = r;
        } cscp10[30:16];

        field {
            name = "cscp02";
            desc = "[inferred] Cscp02. (vendor header `product/hiosd/vo/hi3519/vou_reg.h` field `cscp02`; access and reset unknown, modelled RW)";
            sw = rw;
            hw = r;
        } cscp02[14:0];
    } DHD0_CSC_P1 @ 0xC050;

    reg {
        name = "DHD0 colour-space conversion P2";
        desc = "[inferred] DHD0 colour-space conversion P2. Not in the data sheet. Source: vendor U-Boot 2010.06 `product/hiosd/vo/hi3519/vou_reg.h` (GPL-2.0 U-Boot tree, HiSilicon copyright, created 2015-05-26; mirror github.com/OpenIPC/u-boot-hi3516cv200), union `U_DHD0_CSC_P2`, struct offset 0xC054 (GPL-2.0, same-chip vendor header, byte-identical for Hi3516A V200 and Hi3519 V101). Reset value and access type unknown (modelled RW, no reset). Confidence: medium (vendor header for this chip family, not hardware verified).";

        field {
            name = "cscp12";
            desc = "[inferred] Cscp12. (vendor header `product/hiosd/vo/hi3519/vou_reg.h` field `cscp12`; access and reset unknown, modelled RW)";
            sw = rw;
            hw = r;
        } cscp12[30:16];

        field {
            name = "cscp11";
            desc = "[inferred] Cscp11. (vendor header `product/hiosd/vo/hi3519/vou_reg.h` field `cscp11`; access and reset unknown, modelled RW)";
            sw = rw;
            hw = r;
        } cscp11[14:0];
    } DHD0_CSC_P2 @ 0xC054;

    reg {
        name = "DHD0 colour-space conversion P3";
        desc = "[inferred] DHD0 colour-space conversion P3. Not in the data sheet. Source: vendor U-Boot 2010.06 `product/hiosd/vo/hi3519/vou_reg.h` (GPL-2.0 U-Boot tree, HiSilicon copyright, created 2015-05-26; mirror github.com/OpenIPC/u-boot-hi3516cv200), union `U_DHD0_CSC_P3`, struct offset 0xC058 (GPL-2.0, same-chip vendor header, byte-identical for Hi3516A V200 and Hi3519 V101). Reset value and access type unknown (modelled RW, no reset). Confidence: medium (vendor header for this chip family, not hardware verified).";

        field {
            name = "cscp21";
            desc = "[inferred] Cscp21. (vendor header `product/hiosd/vo/hi3519/vou_reg.h` field `cscp21`; access and reset unknown, modelled RW)";
            sw = rw;
            hw = r;
        } cscp21[30:16];

        field {
            name = "cscp20";
            desc = "[inferred] Cscp20. (vendor header `product/hiosd/vo/hi3519/vou_reg.h` field `cscp20`; access and reset unknown, modelled RW)";
            sw = rw;
            hw = r;
        } cscp20[14:0];
    } DHD0_CSC_P3 @ 0xC058;

    reg {
        name = "DHD0 colour-space conversion P4";
        desc = "[inferred] DHD0 colour-space conversion P4. Not in the data sheet. Source: vendor U-Boot 2010.06 `product/hiosd/vo/hi3519/vou_reg.h` (GPL-2.0 U-Boot tree, HiSilicon copyright, created 2015-05-26; mirror github.com/OpenIPC/u-boot-hi3516cv200), union `U_DHD0_CSC_P4`, struct offset 0xC05C (GPL-2.0, same-chip vendor header, byte-identical for Hi3516A V200 and Hi3519 V101). Reset value and access type unknown (modelled RW, no reset). Confidence: medium (vendor header for this chip family, not hardware verified).";

        field {
            name = "cscp22";
            desc = "[inferred] Cscp22. (vendor header `product/hiosd/vo/hi3519/vou_reg.h` field `cscp22`; access and reset unknown, modelled RW)";
            sw = rw;
            hw = r;
        } cscp22[14:0];
    } DHD0_CSC_P4 @ 0xC05C;

    reg {
        name = "DHD0 DITHER0 control";
        desc = "[inferred] DHD0 DITHER0 control. Not in the data sheet. Source: vendor U-Boot 2010.06 `product/hiosd/vo/hi3519/vou_reg.h` (GPL-2.0 U-Boot tree, HiSilicon copyright, created 2015-05-26; mirror github.com/OpenIPC/u-boot-hi3516cv200), union `U_DHD0_DITHER0_CTRL`, struct offset 0xC060 (GPL-2.0, same-chip vendor header, byte-identical for Hi3516A V200 and Hi3519 V101). Reset value and access type unknown (modelled RW, no reset). Confidence: medium (vendor header for this chip family, not hardware verified).";

        field {
            name = "dither_md";
            desc = "[inferred] Dither md. (vendor header `product/hiosd/vo/hi3519/vou_reg.h` field `dither_md`; access and reset unknown, modelled RW)";
            sw = rw;
            hw = r;
        } dither_md[31:29];
    } DHD0_DITHER0_CTRL @ 0xC060;

    reg {
        name = "DHD0 DITHER0 COEF0";
        desc = "[inferred] DHD0 DITHER0 COEF0. Not in the data sheet. Source: vendor U-Boot 2010.06 `product/hiosd/vo/hi3519/vou_reg.h` (GPL-2.0 U-Boot tree, HiSilicon copyright, created 2015-05-26; mirror github.com/OpenIPC/u-boot-hi3516cv200), union `U_DHD0_DITHER0_COEF0`, struct offset 0xC064 (GPL-2.0, same-chip vendor header, byte-identical for Hi3516A V200 and Hi3519 V101). Reset value and access type unknown (modelled RW, no reset). Confidence: medium (vendor header for this chip family, not hardware verified).";

        field {
            name = "dither_coef3";
            desc = "[inferred] Dither coef3. (vendor header `product/hiosd/vo/hi3519/vou_reg.h` field `dither_coef3`; access and reset unknown, modelled RW)";
            sw = rw;
            hw = r;
        } dither_coef3[31:24];

        field {
            name = "dither_coef2";
            desc = "[inferred] Dither coef2. (vendor header `product/hiosd/vo/hi3519/vou_reg.h` field `dither_coef2`; access and reset unknown, modelled RW)";
            sw = rw;
            hw = r;
        } dither_coef2[23:16];

        field {
            name = "dither_coef1";
            desc = "[inferred] Dither coef1. (vendor header `product/hiosd/vo/hi3519/vou_reg.h` field `dither_coef1`; access and reset unknown, modelled RW)";
            sw = rw;
            hw = r;
        } dither_coef1[15:8];

        field {
            name = "dither_coef0";
            desc = "[inferred] Dither coef0. (vendor header `product/hiosd/vo/hi3519/vou_reg.h` field `dither_coef0`; access and reset unknown, modelled RW)";
            sw = rw;
            hw = r;
        } dither_coef0[7:0];
    } DHD0_DITHER0_COEF0 @ 0xC064;

    reg {
        name = "DHD0 DITHER0 COEF1";
        desc = "[inferred] DHD0 DITHER0 COEF1. Not in the data sheet. Source: vendor U-Boot 2010.06 `product/hiosd/vo/hi3519/vou_reg.h` (GPL-2.0 U-Boot tree, HiSilicon copyright, created 2015-05-26; mirror github.com/OpenIPC/u-boot-hi3516cv200), union `U_DHD0_DITHER0_COEF1`, struct offset 0xC068 (GPL-2.0, same-chip vendor header, byte-identical for Hi3516A V200 and Hi3519 V101). Reset value and access type unknown (modelled RW, no reset). Confidence: medium (vendor header for this chip family, not hardware verified).";

        field {
            name = "dither_coef7";
            desc = "[inferred] Dither coef7. (vendor header `product/hiosd/vo/hi3519/vou_reg.h` field `dither_coef7`; access and reset unknown, modelled RW)";
            sw = rw;
            hw = r;
        } dither_coef7[31:24];

        field {
            name = "dither_coef6";
            desc = "[inferred] Dither coef6. (vendor header `product/hiosd/vo/hi3519/vou_reg.h` field `dither_coef6`; access and reset unknown, modelled RW)";
            sw = rw;
            hw = r;
        } dither_coef6[23:16];

        field {
            name = "dither_coef5";
            desc = "[inferred] Dither coef5. (vendor header `product/hiosd/vo/hi3519/vou_reg.h` field `dither_coef5`; access and reset unknown, modelled RW)";
            sw = rw;
            hw = r;
        } dither_coef5[15:8];

        field {
            name = "dither_coef4";
            desc = "[inferred] Dither coef4. (vendor header `product/hiosd/vo/hi3519/vou_reg.h` field `dither_coef4`; access and reset unknown, modelled RW)";
            sw = rw;
            hw = r;
        } dither_coef4[7:0];
    } DHD0_DITHER0_COEF1 @ 0xC068;

    reg {
        name = "DHD0 DITHER1 control";
        desc = "[inferred] DHD0 DITHER1 control. Not in the data sheet. Source: vendor U-Boot 2010.06 `product/hiosd/vo/hi3519/vou_reg.h` (GPL-2.0 U-Boot tree, HiSilicon copyright, created 2015-05-26; mirror github.com/OpenIPC/u-boot-hi3516cv200), union `U_DHD0_DITHER1_CTRL`, struct offset 0xC070 (GPL-2.0, same-chip vendor header, byte-identical for Hi3516A V200 and Hi3519 V101). Reset value and access type unknown (modelled RW, no reset). Confidence: medium (vendor header for this chip family, not hardware verified).";

        field {
            name = "dither_md";
            desc = "[inferred] Dither md. (vendor header `product/hiosd/vo/hi3519/vou_reg.h` field `dither_md`; access and reset unknown, modelled RW)";
            sw = rw;
            hw = r;
        } dither_md[31:29];
    } DHD0_DITHER1_CTRL @ 0xC070;

    reg {
        name = "DHD0 DITHER1 COEF0";
        desc = "[inferred] DHD0 DITHER1 COEF0. Not in the data sheet. Source: vendor U-Boot 2010.06 `product/hiosd/vo/hi3519/vou_reg.h` (GPL-2.0 U-Boot tree, HiSilicon copyright, created 2015-05-26; mirror github.com/OpenIPC/u-boot-hi3516cv200), union `U_DHD0_DITHER1_COEF0`, struct offset 0xC074 (GPL-2.0, same-chip vendor header, byte-identical for Hi3516A V200 and Hi3519 V101). Reset value and access type unknown (modelled RW, no reset). Confidence: medium (vendor header for this chip family, not hardware verified).";

        field {
            name = "dither_coef3";
            desc = "[inferred] Dither coef3. (vendor header `product/hiosd/vo/hi3519/vou_reg.h` field `dither_coef3`; access and reset unknown, modelled RW)";
            sw = rw;
            hw = r;
        } dither_coef3[31:24];

        field {
            name = "dither_coef2";
            desc = "[inferred] Dither coef2. (vendor header `product/hiosd/vo/hi3519/vou_reg.h` field `dither_coef2`; access and reset unknown, modelled RW)";
            sw = rw;
            hw = r;
        } dither_coef2[23:16];

        field {
            name = "dither_coef1";
            desc = "[inferred] Dither coef1. (vendor header `product/hiosd/vo/hi3519/vou_reg.h` field `dither_coef1`; access and reset unknown, modelled RW)";
            sw = rw;
            hw = r;
        } dither_coef1[15:8];

        field {
            name = "dither_coef0";
            desc = "[inferred] Dither coef0. (vendor header `product/hiosd/vo/hi3519/vou_reg.h` field `dither_coef0`; access and reset unknown, modelled RW)";
            sw = rw;
            hw = r;
        } dither_coef0[7:0];
    } DHD0_DITHER1_COEF0 @ 0xC074;

    reg {
        name = "DHD0 DITHER1 COEF1";
        desc = "[inferred] DHD0 DITHER1 COEF1. Not in the data sheet. Source: vendor U-Boot 2010.06 `product/hiosd/vo/hi3519/vou_reg.h` (GPL-2.0 U-Boot tree, HiSilicon copyright, created 2015-05-26; mirror github.com/OpenIPC/u-boot-hi3516cv200), union `U_DHD0_DITHER1_COEF1`, struct offset 0xC078 (GPL-2.0, same-chip vendor header, byte-identical for Hi3516A V200 and Hi3519 V101). Reset value and access type unknown (modelled RW, no reset). Confidence: medium (vendor header for this chip family, not hardware verified).";

        field {
            name = "dither_coef7";
            desc = "[inferred] Dither coef7. (vendor header `product/hiosd/vo/hi3519/vou_reg.h` field `dither_coef7`; access and reset unknown, modelled RW)";
            sw = rw;
            hw = r;
        } dither_coef7[31:24];

        field {
            name = "dither_coef6";
            desc = "[inferred] Dither coef6. (vendor header `product/hiosd/vo/hi3519/vou_reg.h` field `dither_coef6`; access and reset unknown, modelled RW)";
            sw = rw;
            hw = r;
        } dither_coef6[23:16];

        field {
            name = "dither_coef5";
            desc = "[inferred] Dither coef5. (vendor header `product/hiosd/vo/hi3519/vou_reg.h` field `dither_coef5`; access and reset unknown, modelled RW)";
            sw = rw;
            hw = r;
        } dither_coef5[15:8];

        field {
            name = "dither_coef4";
            desc = "[inferred] Dither coef4. (vendor header `product/hiosd/vo/hi3519/vou_reg.h` field `dither_coef4`; access and reset unknown, modelled RW)";
            sw = rw;
            hw = r;
        } dither_coef4[7:0];
    } DHD0_DITHER1_COEF1 @ 0xC078;

    reg {
        name = "DHD0 CLIP0 L";
        desc = "[inferred] DHD0 CLIP0 L. Not in the data sheet. Source: vendor U-Boot 2010.06 `product/hiosd/vo/hi3519/vou_reg.h` (GPL-2.0 U-Boot tree, HiSilicon copyright, created 2015-05-26; mirror github.com/OpenIPC/u-boot-hi3516cv200), union `U_DHD0_CLIP0_L`, struct offset 0xC080 (GPL-2.0, same-chip vendor header, byte-identical for Hi3516A V200 and Hi3519 V101). Reset value and access type unknown (modelled RW, no reset). Confidence: medium (vendor header for this chip family, not hardware verified).";

        field {
            name = "clip_cl2";
            desc = "[inferred] Clip cl2. (vendor header `product/hiosd/vo/hi3519/vou_reg.h` field `clip_cl2`; access and reset unknown, modelled RW)";
            sw = rw;
            hw = r;
        } clip_cl2[29:20];

        field {
            name = "clip_cl1";
            desc = "[inferred] Clip cl1. (vendor header `product/hiosd/vo/hi3519/vou_reg.h` field `clip_cl1`; access and reset unknown, modelled RW)";
            sw = rw;
            hw = r;
        } clip_cl1[19:10];

        field {
            name = "clip_cl0";
            desc = "[inferred] Clip cl0. (vendor header `product/hiosd/vo/hi3519/vou_reg.h` field `clip_cl0`; access and reset unknown, modelled RW)";
            sw = rw;
            hw = r;
        } clip_cl0[9:0];
    } DHD0_CLIP0_L @ 0xC080;

    reg {
        name = "DHD0 CLIP0 H";
        desc = "[inferred] DHD0 CLIP0 H. Not in the data sheet. Source: vendor U-Boot 2010.06 `product/hiosd/vo/hi3519/vou_reg.h` (GPL-2.0 U-Boot tree, HiSilicon copyright, created 2015-05-26; mirror github.com/OpenIPC/u-boot-hi3516cv200), union `U_DHD0_CLIP0_H`, struct offset 0xC084 (GPL-2.0, same-chip vendor header, byte-identical for Hi3516A V200 and Hi3519 V101). Reset value and access type unknown (modelled RW, no reset). Confidence: medium (vendor header for this chip family, not hardware verified).";

        field {
            name = "clip_ch2";
            desc = "[inferred] Clip ch2. (vendor header `product/hiosd/vo/hi3519/vou_reg.h` field `clip_ch2`; access and reset unknown, modelled RW)";
            sw = rw;
            hw = r;
        } clip_ch2[29:20];

        field {
            name = "clip_ch1";
            desc = "[inferred] Clip ch1. (vendor header `product/hiosd/vo/hi3519/vou_reg.h` field `clip_ch1`; access and reset unknown, modelled RW)";
            sw = rw;
            hw = r;
        } clip_ch1[19:10];

        field {
            name = "clip_ch0";
            desc = "[inferred] Clip ch0. (vendor header `product/hiosd/vo/hi3519/vou_reg.h` field `clip_ch0`; access and reset unknown, modelled RW)";
            sw = rw;
            hw = r;
        } clip_ch0[9:0];
    } DHD0_CLIP0_H @ 0xC084;

    reg {
        name = "DHD0 CLIP1 L";
        desc = "[inferred] DHD0 CLIP1 L. Not in the data sheet. Source: vendor U-Boot 2010.06 `product/hiosd/vo/hi3519/vou_reg.h` (GPL-2.0 U-Boot tree, HiSilicon copyright, created 2015-05-26; mirror github.com/OpenIPC/u-boot-hi3516cv200), union `U_DHD0_CLIP1_L`, struct offset 0xC088 (GPL-2.0, same-chip vendor header, byte-identical for Hi3516A V200 and Hi3519 V101). Reset value and access type unknown (modelled RW, no reset). Confidence: medium (vendor header for this chip family, not hardware verified).";

        field {
            name = "clip_cl2";
            desc = "[inferred] Clip cl2. (vendor header `product/hiosd/vo/hi3519/vou_reg.h` field `clip_cl2`; access and reset unknown, modelled RW)";
            sw = rw;
            hw = r;
        } clip_cl2[29:20];

        field {
            name = "clip_cl1";
            desc = "[inferred] Clip cl1. (vendor header `product/hiosd/vo/hi3519/vou_reg.h` field `clip_cl1`; access and reset unknown, modelled RW)";
            sw = rw;
            hw = r;
        } clip_cl1[19:10];

        field {
            name = "clip_cl0";
            desc = "[inferred] Clip cl0. (vendor header `product/hiosd/vo/hi3519/vou_reg.h` field `clip_cl0`; access and reset unknown, modelled RW)";
            sw = rw;
            hw = r;
        } clip_cl0[9:0];
    } DHD0_CLIP1_L @ 0xC088;

    reg {
        name = "DHD0 CLIP1 H";
        desc = "[inferred] DHD0 CLIP1 H. Not in the data sheet. Source: vendor U-Boot 2010.06 `product/hiosd/vo/hi3519/vou_reg.h` (GPL-2.0 U-Boot tree, HiSilicon copyright, created 2015-05-26; mirror github.com/OpenIPC/u-boot-hi3516cv200), union `U_DHD0_CLIP1_H`, struct offset 0xC08C (GPL-2.0, same-chip vendor header, byte-identical for Hi3516A V200 and Hi3519 V101). Reset value and access type unknown (modelled RW, no reset). Confidence: medium (vendor header for this chip family, not hardware verified).";

        field {
            name = "clip_ch2";
            desc = "[inferred] Clip ch2. (vendor header `product/hiosd/vo/hi3519/vou_reg.h` field `clip_ch2`; access and reset unknown, modelled RW)";
            sw = rw;
            hw = r;
        } clip_ch2[29:20];

        field {
            name = "clip_ch1";
            desc = "[inferred] Clip ch1. (vendor header `product/hiosd/vo/hi3519/vou_reg.h` field `clip_ch1`; access and reset unknown, modelled RW)";
            sw = rw;
            hw = r;
        } clip_ch1[19:10];

        field {
            name = "clip_ch0";
            desc = "[inferred] Clip ch0. (vendor header `product/hiosd/vo/hi3519/vou_reg.h` field `clip_ch0`; access and reset unknown, modelled RW)";
            sw = rw;
            hw = r;
        } clip_ch0[9:0];
    } DHD0_CLIP1_H @ 0xC08C;

    reg {
        name = "DHD0 CLIP2 L";
        desc = "[inferred] DHD0 CLIP2 L. Not in the data sheet. Source: vendor U-Boot 2010.06 `product/hiosd/vo/hi3519/vou_reg.h` (GPL-2.0 U-Boot tree, HiSilicon copyright, created 2015-05-26; mirror github.com/OpenIPC/u-boot-hi3516cv200), union `U_DHD0_CLIP2_L`, struct offset 0xC090 (GPL-2.0, same-chip vendor header, byte-identical for Hi3516A V200 and Hi3519 V101). Reset value and access type unknown (modelled RW, no reset). Confidence: medium (vendor header for this chip family, not hardware verified).";

        field {
            name = "clip_cl2";
            desc = "[inferred] Clip cl2. (vendor header `product/hiosd/vo/hi3519/vou_reg.h` field `clip_cl2`; access and reset unknown, modelled RW)";
            sw = rw;
            hw = r;
        } clip_cl2[29:20];

        field {
            name = "clip_cl1";
            desc = "[inferred] Clip cl1. (vendor header `product/hiosd/vo/hi3519/vou_reg.h` field `clip_cl1`; access and reset unknown, modelled RW)";
            sw = rw;
            hw = r;
        } clip_cl1[19:10];

        field {
            name = "clip_cl0";
            desc = "[inferred] Clip cl0. (vendor header `product/hiosd/vo/hi3519/vou_reg.h` field `clip_cl0`; access and reset unknown, modelled RW)";
            sw = rw;
            hw = r;
        } clip_cl0[9:0];
    } DHD0_CLIP2_L @ 0xC090;

    reg {
        name = "DHD0 CLIP2 H";
        desc = "[inferred] DHD0 CLIP2 H. Not in the data sheet. Source: vendor U-Boot 2010.06 `product/hiosd/vo/hi3519/vou_reg.h` (GPL-2.0 U-Boot tree, HiSilicon copyright, created 2015-05-26; mirror github.com/OpenIPC/u-boot-hi3516cv200), union `U_DHD0_CLIP2_H`, struct offset 0xC094 (GPL-2.0, same-chip vendor header, byte-identical for Hi3516A V200 and Hi3519 V101). Reset value and access type unknown (modelled RW, no reset). Confidence: medium (vendor header for this chip family, not hardware verified).";

        field {
            name = "clip_ch2";
            desc = "[inferred] Clip ch2. (vendor header `product/hiosd/vo/hi3519/vou_reg.h` field `clip_ch2`; access and reset unknown, modelled RW)";
            sw = rw;
            hw = r;
        } clip_ch2[29:20];

        field {
            name = "clip_ch1";
            desc = "[inferred] Clip ch1. (vendor header `product/hiosd/vo/hi3519/vou_reg.h` field `clip_ch1`; access and reset unknown, modelled RW)";
            sw = rw;
            hw = r;
        } clip_ch1[19:10];

        field {
            name = "clip_ch0";
            desc = "[inferred] Clip ch0. (vendor header `product/hiosd/vo/hi3519/vou_reg.h` field `clip_ch0`; access and reset unknown, modelled RW)";
            sw = rw;
            hw = r;
        } clip_ch0[9:0];
    } DHD0_CLIP2_H @ 0xC094;

    reg {
        name = "DHD0 CLIP3 L";
        desc = "[inferred] DHD0 CLIP3 L. Not in the data sheet. Source: vendor U-Boot 2010.06 `product/hiosd/vo/hi3519/vou_reg.h` (GPL-2.0 U-Boot tree, HiSilicon copyright, created 2015-05-26; mirror github.com/OpenIPC/u-boot-hi3516cv200), union `U_DHD0_CLIP3_L`, struct offset 0xC098 (GPL-2.0, same-chip vendor header, byte-identical for Hi3516A V200 and Hi3519 V101). Reset value and access type unknown (modelled RW, no reset). Confidence: medium (vendor header for this chip family, not hardware verified).";

        field {
            name = "clip_cl2";
            desc = "[inferred] Clip cl2. (vendor header `product/hiosd/vo/hi3519/vou_reg.h` field `clip_cl2`; access and reset unknown, modelled RW)";
            sw = rw;
            hw = r;
        } clip_cl2[29:20];

        field {
            name = "clip_cl1";
            desc = "[inferred] Clip cl1. (vendor header `product/hiosd/vo/hi3519/vou_reg.h` field `clip_cl1`; access and reset unknown, modelled RW)";
            sw = rw;
            hw = r;
        } clip_cl1[19:10];

        field {
            name = "clip_cl0";
            desc = "[inferred] Clip cl0. (vendor header `product/hiosd/vo/hi3519/vou_reg.h` field `clip_cl0`; access and reset unknown, modelled RW)";
            sw = rw;
            hw = r;
        } clip_cl0[9:0];
    } DHD0_CLIP3_L @ 0xC098;

    reg {
        name = "DHD0 CLIP3 H";
        desc = "[inferred] DHD0 CLIP3 H. Not in the data sheet. Source: vendor U-Boot 2010.06 `product/hiosd/vo/hi3519/vou_reg.h` (GPL-2.0 U-Boot tree, HiSilicon copyright, created 2015-05-26; mirror github.com/OpenIPC/u-boot-hi3516cv200), union `U_DHD0_CLIP3_H`, struct offset 0xC09C (GPL-2.0, same-chip vendor header, byte-identical for Hi3516A V200 and Hi3519 V101). Reset value and access type unknown (modelled RW, no reset). Confidence: medium (vendor header for this chip family, not hardware verified).";

        field {
            name = "clip_ch2";
            desc = "[inferred] Clip ch2. (vendor header `product/hiosd/vo/hi3519/vou_reg.h` field `clip_ch2`; access and reset unknown, modelled RW)";
            sw = rw;
            hw = r;
        } clip_ch2[29:20];

        field {
            name = "clip_ch1";
            desc = "[inferred] Clip ch1. (vendor header `product/hiosd/vo/hi3519/vou_reg.h` field `clip_ch1`; access and reset unknown, modelled RW)";
            sw = rw;
            hw = r;
        } clip_ch1[19:10];

        field {
            name = "clip_ch0";
            desc = "[inferred] Clip ch0. (vendor header `product/hiosd/vo/hi3519/vou_reg.h` field `clip_ch0`; access and reset unknown, modelled RW)";
            sw = rw;
            hw = r;
        } clip_ch0[9:0];
    } DHD0_CLIP3_H @ 0xC09C;

    reg {
        name = "DHD0 CLIP4 L";
        desc = "[inferred] DHD0 CLIP4 L. Not in the data sheet. Source: vendor U-Boot 2010.06 `product/hiosd/vo/hi3519/vou_reg.h` (GPL-2.0 U-Boot tree, HiSilicon copyright, created 2015-05-26; mirror github.com/OpenIPC/u-boot-hi3516cv200), union `U_DHD0_CLIP4_L`, struct offset 0xC0A0 (GPL-2.0, same-chip vendor header, byte-identical for Hi3516A V200 and Hi3519 V101). Reset value and access type unknown (modelled RW, no reset). Confidence: medium (vendor header for this chip family, not hardware verified).";

        field {
            name = "clip_cl2";
            desc = "[inferred] Clip cl2. (vendor header `product/hiosd/vo/hi3519/vou_reg.h` field `clip_cl2`; access and reset unknown, modelled RW)";
            sw = rw;
            hw = r;
        } clip_cl2[29:20];

        field {
            name = "clip_cl1";
            desc = "[inferred] Clip cl1. (vendor header `product/hiosd/vo/hi3519/vou_reg.h` field `clip_cl1`; access and reset unknown, modelled RW)";
            sw = rw;
            hw = r;
        } clip_cl1[19:10];

        field {
            name = "clip_cl0";
            desc = "[inferred] Clip cl0. (vendor header `product/hiosd/vo/hi3519/vou_reg.h` field `clip_cl0`; access and reset unknown, modelled RW)";
            sw = rw;
            hw = r;
        } clip_cl0[9:0];
    } DHD0_CLIP4_L @ 0xC0A0;

    reg {
        name = "DHD0 CLIP4 H";
        desc = "[inferred] DHD0 CLIP4 H. Not in the data sheet. Source: vendor U-Boot 2010.06 `product/hiosd/vo/hi3519/vou_reg.h` (GPL-2.0 U-Boot tree, HiSilicon copyright, created 2015-05-26; mirror github.com/OpenIPC/u-boot-hi3516cv200), union `U_DHD0_CLIP4_H`, struct offset 0xC0A4 (GPL-2.0, same-chip vendor header, byte-identical for Hi3516A V200 and Hi3519 V101). Reset value and access type unknown (modelled RW, no reset). Confidence: medium (vendor header for this chip family, not hardware verified).";

        field {
            name = "clip_ch2";
            desc = "[inferred] Clip ch2. (vendor header `product/hiosd/vo/hi3519/vou_reg.h` field `clip_ch2`; access and reset unknown, modelled RW)";
            sw = rw;
            hw = r;
        } clip_ch2[29:20];

        field {
            name = "clip_ch1";
            desc = "[inferred] Clip ch1. (vendor header `product/hiosd/vo/hi3519/vou_reg.h` field `clip_ch1`; access and reset unknown, modelled RW)";
            sw = rw;
            hw = r;
        } clip_ch1[19:10];

        field {
            name = "clip_ch0";
            desc = "[inferred] Clip ch0. (vendor header `product/hiosd/vo/hi3519/vou_reg.h` field `clip_ch0`; access and reset unknown, modelled RW)";
            sw = rw;
            hw = r;
        } clip_ch0[9:0];
    } DHD0_CLIP4_H @ 0xC0A4;

    reg {
        name = "DHD0 PARATHD";
        desc = "[inferred] DHD0 PARATHD. Not in the data sheet. Source: vendor U-Boot 2010.06 `product/hiosd/vo/hi3519/vou_reg.h` (GPL-2.0 U-Boot tree, HiSilicon copyright, created 2015-05-26; mirror github.com/OpenIPC/u-boot-hi3516cv200), union `U_DHD0_PARATHD`, struct offset 0xC0B0 (GPL-2.0, same-chip vendor header, byte-identical for Hi3516A V200 and Hi3519 V101). Reset value and access type unknown (modelled RW, no reset). Confidence: medium (vendor header for this chip family, not hardware verified).";

        field {
            name = "dfs_en";
            desc = "[inferred] Dfs enable. (vendor header `product/hiosd/vo/hi3519/vou_reg.h` field `dfs_en`; access and reset unknown, modelled RW)";
            sw = rw;
            hw = r;
        } dfs_en[31:31];

        field {
            name = "para_thd";
            desc = "[inferred] Para threshold. (vendor header `product/hiosd/vo/hi3519/vou_reg.h` field `para_thd`; access and reset unknown, modelled RW)";
            sw = rw;
            hw = r;
        } para_thd[5:0];
    } DHD0_PARATHD @ 0xC0B0;

    reg {
        name = "DHD0 START position";
        desc = "[inferred] DHD0 START position. Not in the data sheet. Source: vendor U-Boot 2010.06 `product/hiosd/vo/hi3519/vou_reg.h` (GPL-2.0 U-Boot tree, HiSilicon copyright, created 2015-05-26; mirror github.com/OpenIPC/u-boot-hi3516cv200), union `U_DHD0_START_POS`, struct offset 0xC0C0 (GPL-2.0, same-chip vendor header, byte-identical for Hi3516A V200 and Hi3519 V101). Reset value and access type unknown (modelled RW, no reset). Confidence: medium (vendor header for this chip family, not hardware verified).";

        field {
            name = "timing_start_pos";
            desc = "[inferred] Timing start position. (vendor header `product/hiosd/vo/hi3519/vou_reg.h` field `timing_start_pos`; access and reset unknown, modelled RW)";
            sw = rw;
            hw = r;
        } timing_start_pos[15:8];

        field {
            name = "start_pos";
            desc = "[inferred] Start position. (vendor header `product/hiosd/vo/hi3519/vou_reg.h` field `start_pos`; access and reset unknown, modelled RW)";
            sw = rw;
            hw = r;
        } start_pos[7:0];
    } DHD0_START_POS @ 0xC0C0;

    reg {
        name = "DHD0 LOCKCFG";
        desc = "[inferred] DHD0 LOCKCFG. Not in the data sheet. Source: vendor U-Boot 2010.06 `product/hiosd/vo/hi3519/vou_reg.h` (GPL-2.0 U-Boot tree, HiSilicon copyright, created 2015-05-26; mirror github.com/OpenIPC/u-boot-hi3516cv200), union `U_DHD0_LOCKCFG`, struct offset 0xC0D0 (GPL-2.0, same-chip vendor header, byte-identical for Hi3516A V200 and Hi3519 V101). Reset value and access type unknown (modelled RW, no reset). Confidence: medium (vendor header for this chip family, not hardware verified).";

        field {
            name = "lock_cnt_en";
            desc = "[inferred] Lock count enable. (vendor header `product/hiosd/vo/hi3519/vou_reg.h` field `lock_cnt_en`; access and reset unknown, modelled RW)";
            sw = rw;
            hw = r;
        } lock_cnt_en[1:1];

        field {
            name = "measure_en";
            desc = "[inferred] Measure enable. (vendor header `product/hiosd/vo/hi3519/vou_reg.h` field `measure_en`; access and reset unknown, modelled RW)";
            sw = rw;
            hw = r;
        } measure_en[0:0];
    } DHD0_LOCKCFG @ 0xC0D0;

    reg {
        name = "DHD0 LOCK STATE1";
        desc = "[inferred] DHD0 LOCK STATE1. Not in the data sheet. Source: vendor U-Boot 2010.06 `product/hiosd/vo/hi3519/vou_reg.h` (GPL-2.0 U-Boot tree, HiSilicon copyright, created 2015-05-26; mirror github.com/OpenIPC/u-boot-hi3516cv200), union `U_DHD0_LOCK_STATE1`, struct offset 0xC0D4 (GPL-2.0, same-chip vendor header, byte-identical for Hi3516A V200 and Hi3519 V101). Reset value and access type unknown (modelled RW, no reset). Confidence: medium (vendor header for this chip family, not hardware verified).";

        field {
            name = "cap_frm_cnt";
            desc = "[inferred] Cap frm count. (vendor header `product/hiosd/vo/hi3519/vou_reg.h` field `cap_frm_cnt`; access and reset unknown, modelled RW)";
            sw = rw;
            hw = r;
        } cap_frm_cnt[25:0];
    } DHD0_LOCK_STATE1 @ 0xC0D4;

    reg {
        name = "DHD0 LOCK STATE2";
        desc = "[inferred] DHD0 LOCK STATE2. Not in the data sheet. Source: vendor U-Boot 2010.06 `product/hiosd/vo/hi3519/vou_reg.h` (GPL-2.0 U-Boot tree, HiSilicon copyright, created 2015-05-26; mirror github.com/OpenIPC/u-boot-hi3516cv200), union `U_DHD0_LOCK_STATE2`, struct offset 0xC0D8 (GPL-2.0, same-chip vendor header, byte-identical for Hi3516A V200 and Hi3519 V101). Reset value and access type unknown (modelled RW, no reset). Confidence: medium (vendor header for this chip family, not hardware verified).";

        field {
            name = "vsync_cap_vdp_init";
            desc = "[inferred] Vertical sync cap vdp init. (vendor header `product/hiosd/vo/hi3519/vou_reg.h` field `vsync_cap_vdp_init`; access and reset unknown, modelled RW)";
            sw = rw;
            hw = r;
        } vsync_cap_vdp_init[25:0];
    } DHD0_LOCK_STATE2 @ 0xC0D8;

    reg {
        name = "DHD0 LOCK STATE3";
        desc = "[inferred] DHD0 LOCK STATE3. Not in the data sheet. Source: vendor U-Boot 2010.06 `product/hiosd/vo/hi3519/vou_reg.h` (GPL-2.0 U-Boot tree, HiSilicon copyright, created 2015-05-26; mirror github.com/OpenIPC/u-boot-hi3516cv200), union `U_DHD0_LOCK_STATE3`, struct offset 0xC0DC (GPL-2.0, same-chip vendor header, byte-identical for Hi3516A V200 and Hi3519 V101). Reset value and access type unknown (modelled RW, no reset). Confidence: medium (vendor header for this chip family, not hardware verified).";

        field {
            name = "vsync_cap_vdp_cnt";
            desc = "[inferred] Vertical sync cap vdp count. (vendor header `product/hiosd/vo/hi3519/vou_reg.h` field `vsync_cap_vdp_cnt`; access and reset unknown, modelled RW)";
            sw = rw;
            hw = r;
        } vsync_cap_vdp_cnt[25:0];
    } DHD0_LOCK_STATE3 @ 0xC0DC;

    reg {
        name = "DHD0 GMM COEFAD";
        desc = "[inferred] DHD0 GMM COEFAD. Not in the data sheet. Source: vendor U-Boot 2010.06 `product/hiosd/vo/hi3519/vou_reg.h` (GPL-2.0 U-Boot tree, HiSilicon copyright, created 2015-05-26; mirror github.com/OpenIPC/u-boot-hi3516cv200), union `U_DHD0_GMM_COEFAD`, struct offset 0xC0E0 (GPL-2.0, same-chip vendor header, byte-identical for Hi3516A V200 and Hi3519 V101). Reset value and access type unknown (modelled RW, no reset). Confidence: medium (vendor header for this chip family, not hardware verified).";

        field {
            name = "coef_addr";
            desc = "[inferred] Coefficient address. (vendor header `product/hiosd/vo/hi3519/vou_reg.h` field `coef_addr`; access and reset unknown, modelled RW)";
            sw = rw;
            hw = r;
        } coef_addr[31:0];
    } DHD0_GMM_COEFAD @ 0xC0E0;

    reg {
        name = "DHD0 PARAUP";
        desc = "[inferred] DHD0 PARAUP. Not in the data sheet. Source: vendor U-Boot 2010.06 `product/hiosd/vo/hi3519/vou_reg.h` (GPL-2.0 U-Boot tree, HiSilicon copyright, created 2015-05-26; mirror github.com/OpenIPC/u-boot-hi3516cv200), union `U_DHD0_PARAUP`, struct offset 0xC0EC (GPL-2.0, same-chip vendor header, byte-identical for Hi3516A V200 and Hi3519 V101). Reset value and access type unknown (modelled RW, no reset). Confidence: medium (vendor header for this chip family, not hardware verified).";

        field {
            name = "dhd0_gmm_upd";
            desc = "[inferred] Dhd0 gmm update. (vendor header `product/hiosd/vo/hi3519/vou_reg.h` field `dhd0_gmm_upd`; access and reset unknown, modelled RW)";
            sw = rw;
            hw = r;
        } dhd0_gmm_upd[0:0];
    } DHD0_PARAUP @ 0xC0EC;

    reg {
        name = "DHD0 STATE";
        desc = "[inferred] DHD0 STATE. Not in the data sheet. Source: vendor U-Boot 2010.06 `product/hiosd/vo/hi3519/vou_reg.h` (GPL-2.0 U-Boot tree, HiSilicon copyright, created 2015-05-26; mirror github.com/OpenIPC/u-boot-hi3516cv200), union `U_DHD0_STATE`, struct offset 0xC0F0 (GPL-2.0, same-chip vendor header, byte-identical for Hi3516A V200 and Hi3519 V101). Reset value and access type unknown (modelled RW, no reset). Confidence: medium (vendor header for this chip family, not hardware verified).";

        field {
            name = "count_int";
            desc = "[inferred] Count interrupt. (vendor header `product/hiosd/vo/hi3519/vou_reg.h` field `count_int`; access and reset unknown, modelled RW)";
            sw = rw;
            hw = r;
        } count_int[23:16];

        field {
            name = "vcnt";
            desc = "[inferred] Vcnt. (vendor header `product/hiosd/vo/hi3519/vou_reg.h` field `vcnt`; access and reset unknown, modelled RW)";
            sw = rw;
            hw = r;
        } vcnt[15:3];

        field {
            name = "bottom_field";
            desc = "[inferred] Bottom field. (vendor header `product/hiosd/vo/hi3519/vou_reg.h` field `bottom_field`; access and reset unknown, modelled RW)";
            sw = rw;
            hw = r;
        } bottom_field[2:2];

        field {
            name = "vblank";
            desc = "[inferred] Vblank. (vendor header `product/hiosd/vo/hi3519/vou_reg.h` field `vblank`; access and reset unknown, modelled RW)";
            sw = rw;
            hw = r;
        } vblank[1:1];

        field {
            name = "vback_blank";
            desc = "[inferred] Vback blank. (vendor header `product/hiosd/vo/hi3519/vou_reg.h` field `vback_blank`; access and reset unknown, modelled RW)";
            sw = rw;
            hw = r;
        } vback_blank[0:0];
    } DHD0_STATE @ 0xC0F0;

    reg {
        name = "DHD0 DEBUG";
        desc = "[inferred] DHD0 DEBUG. Not in the data sheet. Source: vendor U-Boot 2010.06 `product/hiosd/vo/hi3519/vou_reg.h` (GPL-2.0 U-Boot tree, HiSilicon copyright, created 2015-05-26; mirror github.com/OpenIPC/u-boot-hi3516cv200), union `U_DHD0_DEBUG`, struct offset 0xC0F8 (GPL-2.0, same-chip vendor header, byte-identical for Hi3516A V200 and Hi3519 V101). Reset value and access type unknown (modelled RW, no reset). Confidence: medium (vendor header for this chip family, not hardware verified).";

        field {
            name = "pix_src";
            desc = "[inferred] Pix source. (vendor header `product/hiosd/vo/hi3519/vou_reg.h` field `pix_src`; access and reset unknown, modelled RW)";
            sw = rw;
            hw = r;
        } pix_src[30:28];

        field {
            name = "pix_v";
            desc = "[inferred] Pix v. (vendor header `product/hiosd/vo/hi3519/vou_reg.h` field `pix_v`; access and reset unknown, modelled RW)";
            sw = rw;
            hw = r;
        } pix_v[27:16];

        field {
            name = "pix_h";
            desc = "[inferred] Pix h. (vendor header `product/hiosd/vo/hi3519/vou_reg.h` field `pix_h`; access and reset unknown, modelled RW)";
            sw = rw;
            hw = r;
        } pix_h[15:0];
    } DHD0_DEBUG @ 0xC0F8;

    reg {
        name = "DHD0 DEBUG STATE";
        desc = "[inferred] DHD0 DEBUG STATE. Not in the data sheet. Source: vendor U-Boot 2010.06 `product/hiosd/vo/hi3519/vou_reg.h` (GPL-2.0 U-Boot tree, HiSilicon copyright, created 2015-05-26; mirror github.com/OpenIPC/u-boot-hi3516cv200), union `U_DHD0_DEBUG_STATE`, struct offset 0xC0FC (GPL-2.0, same-chip vendor header, byte-identical for Hi3516A V200 and Hi3519 V101). Reset value and access type unknown (modelled RW, no reset). Confidence: medium (vendor header for this chip family, not hardware verified).";

        field {
            name = "pixel_value";
            desc = "[inferred] Pixel value. (vendor header `product/hiosd/vo/hi3519/vou_reg.h` field `pixel_value`; access and reset unknown, modelled RW)";
            sw = rw;
            hw = r;
        } pixel_value[29:0];
    } DHD0_DEBUG_STATE @ 0xC0FC;

    reg {
        name = "DHD0 HSPCFG0";
        desc = "[inferred] DHD0 HSPCFG0. Not in the data sheet. Source: vendor U-Boot 2010.06 `product/hiosd/vo/hi3519/vou_reg.h` (GPL-2.0 U-Boot tree, HiSilicon copyright, created 2015-05-26; mirror github.com/OpenIPC/u-boot-hi3516cv200), union `U_DHD0_HSPCFG0`, struct offset 0xC100 (GPL-2.0, same-chip vendor header, byte-identical for Hi3516A V200 and Hi3519 V101). Reset value and access type unknown (modelled RW, no reset). Confidence: medium (vendor header for this chip family, not hardware verified).";

        field {
            name = "hsp_hf0_tmp3";
            desc = "[inferred] Hsp hf0 tmp3. (vendor header `product/hiosd/vo/hi3519/vou_reg.h` field `hsp_hf0_tmp3`; access and reset unknown, modelled RW)";
            sw = rw;
            hw = r;
        } hsp_hf0_tmp3[31:24];

        field {
            name = "hsp_hf0_tmp2";
            desc = "[inferred] Hsp hf0 tmp2. (vendor header `product/hiosd/vo/hi3519/vou_reg.h` field `hsp_hf0_tmp2`; access and reset unknown, modelled RW)";
            sw = rw;
            hw = r;
        } hsp_hf0_tmp2[23:16];

        field {
            name = "hsp_hf0_tmp1";
            desc = "[inferred] Hsp hf0 tmp1. (vendor header `product/hiosd/vo/hi3519/vou_reg.h` field `hsp_hf0_tmp1`; access and reset unknown, modelled RW)";
            sw = rw;
            hw = r;
        } hsp_hf0_tmp1[15:8];

        field {
            name = "hsp_hf0_tmp0";
            desc = "[inferred] Hsp hf0 tmp0. (vendor header `product/hiosd/vo/hi3519/vou_reg.h` field `hsp_hf0_tmp0`; access and reset unknown, modelled RW)";
            sw = rw;
            hw = r;
        } hsp_hf0_tmp0[7:0];
    } DHD0_HSPCFG0 @ 0xC100;

    reg {
        name = "DHD0 HSPCFG1";
        desc = "[inferred] DHD0 HSPCFG1. Not in the data sheet. Source: vendor U-Boot 2010.06 `product/hiosd/vo/hi3519/vou_reg.h` (GPL-2.0 U-Boot tree, HiSilicon copyright, created 2015-05-26; mirror github.com/OpenIPC/u-boot-hi3516cv200), union `U_DHD0_HSPCFG1`, struct offset 0xC104 (GPL-2.0, same-chip vendor header, byte-identical for Hi3516A V200 and Hi3519 V101). Reset value and access type unknown (modelled RW, no reset). Confidence: medium (vendor header for this chip family, not hardware verified).";

        field {
            name = "hsp_en";
            desc = "[inferred] Hsp enable. (vendor header `product/hiosd/vo/hi3519/vou_reg.h` field `hsp_en`; access and reset unknown, modelled RW)";
            sw = rw;
            hw = r;
        } hsp_en[31:31];

        field {
            name = "hsp_hf0_coring";
            desc = "[inferred] Hsp hf0 coring. (vendor header `product/hiosd/vo/hi3519/vou_reg.h` field `hsp_hf0_coring`; access and reset unknown, modelled RW)";
            sw = rw;
            hw = r;
        } hsp_hf0_coring[7:0];
    } DHD0_HSPCFG1 @ 0xC104;

    reg {
        name = "DHD0 HSPCFG5";
        desc = "[inferred] DHD0 HSPCFG5. Not in the data sheet. Source: vendor U-Boot 2010.06 `product/hiosd/vo/hi3519/vou_reg.h` (GPL-2.0 U-Boot tree, HiSilicon copyright, created 2015-05-26; mirror github.com/OpenIPC/u-boot-hi3516cv200), union `U_DHD0_HSPCFG5`, struct offset 0xC114 (GPL-2.0, same-chip vendor header, byte-identical for Hi3516A V200 and Hi3519 V101). Reset value and access type unknown (modelled RW, no reset). Confidence: medium (vendor header for this chip family, not hardware verified).";

        field {
            name = "hsp_hf0_gainneg";
            desc = "[inferred] Hsp hf0 gainneg. (vendor header `product/hiosd/vo/hi3519/vou_reg.h` field `hsp_hf0_gainneg`; access and reset unknown, modelled RW)";
            sw = rw;
            hw = r;
        } hsp_hf0_gainneg[26:16];

        field {
            name = "hsp_hf0_gainpos";
            desc = "[inferred] Hsp hf0 gainpos. (vendor header `product/hiosd/vo/hi3519/vou_reg.h` field `hsp_hf0_gainpos`; access and reset unknown, modelled RW)";
            sw = rw;
            hw = r;
        } hsp_hf0_gainpos[10:0];
    } DHD0_HSPCFG5 @ 0xC114;

    reg {
        name = "DHD0 HSPCFG6";
        desc = "[inferred] DHD0 HSPCFG6. Not in the data sheet. Source: vendor U-Boot 2010.06 `product/hiosd/vo/hi3519/vou_reg.h` (GPL-2.0 U-Boot tree, HiSilicon copyright, created 2015-05-26; mirror github.com/OpenIPC/u-boot-hi3516cv200), union `U_DHD0_HSPCFG6`, struct offset 0xC118 (GPL-2.0, same-chip vendor header, byte-identical for Hi3516A V200 and Hi3519 V101). Reset value and access type unknown (modelled RW, no reset). Confidence: medium (vendor header for this chip family, not hardware verified).";

        field {
            name = "hsp_hf0_adpshoot_en";
            desc = "[inferred] Hsp hf0 adpshoot enable. (vendor header `product/hiosd/vo/hi3519/vou_reg.h` field `hsp_hf0_adpshoot_en`; access and reset unknown, modelled RW)";
            sw = rw;
            hw = r;
        } hsp_hf0_adpshoot_en[31:31];

        field {
            name = "hsp_hf0_winsize";
            desc = "[inferred] Hsp hf0 winsize. (vendor header `product/hiosd/vo/hi3519/vou_reg.h` field `hsp_hf0_winsize`; access and reset unknown, modelled RW)";
            sw = rw;
            hw = r;
        } hsp_hf0_winsize[30:28];

        field {
            name = "hsp_hf0_mixratio";
            desc = "[inferred] Hsp hf0 mixratio. (vendor header `product/hiosd/vo/hi3519/vou_reg.h` field `hsp_hf0_mixratio`; access and reset unknown, modelled RW)";
            sw = rw;
            hw = r;
        } hsp_hf0_mixratio[23:16];

        field {
            name = "hsp_hf0_underth";
            desc = "[inferred] Hsp hf0 underth. (vendor header `product/hiosd/vo/hi3519/vou_reg.h` field `hsp_hf0_underth`; access and reset unknown, modelled RW)";
            sw = rw;
            hw = r;
        } hsp_hf0_underth[15:8];

        field {
            name = "hsp_hf0_overth";
            desc = "[inferred] Hsp hf0 overth. (vendor header `product/hiosd/vo/hi3519/vou_reg.h` field `hsp_hf0_overth`; access and reset unknown, modelled RW)";
            sw = rw;
            hw = r;
        } hsp_hf0_overth[7:0];
    } DHD0_HSPCFG6 @ 0xC118;

    reg {
        name = "DHD0 HSPCFG7";
        desc = "[inferred] DHD0 HSPCFG7. Not in the data sheet. Source: vendor U-Boot 2010.06 `product/hiosd/vo/hi3519/vou_reg.h` (GPL-2.0 U-Boot tree, HiSilicon copyright, created 2015-05-26; mirror github.com/OpenIPC/u-boot-hi3516cv200), union `U_DHD0_HSPCFG7`, struct offset 0xC11C (GPL-2.0, same-chip vendor header, byte-identical for Hi3516A V200 and Hi3519 V101). Reset value and access type unknown (modelled RW, no reset). Confidence: medium (vendor header for this chip family, not hardware verified).";

        field {
            name = "hsp_hf1_tmp3";
            desc = "[inferred] Hsp hf1 tmp3. (vendor header `product/hiosd/vo/hi3519/vou_reg.h` field `hsp_hf1_tmp3`; access and reset unknown, modelled RW)";
            sw = rw;
            hw = r;
        } hsp_hf1_tmp3[31:24];

        field {
            name = "hsp_hf1_tmp2";
            desc = "[inferred] Hsp hf1 tmp2. (vendor header `product/hiosd/vo/hi3519/vou_reg.h` field `hsp_hf1_tmp2`; access and reset unknown, modelled RW)";
            sw = rw;
            hw = r;
        } hsp_hf1_tmp2[23:16];

        field {
            name = "hsp_hf1_tmp1";
            desc = "[inferred] Hsp hf1 tmp1. (vendor header `product/hiosd/vo/hi3519/vou_reg.h` field `hsp_hf1_tmp1`; access and reset unknown, modelled RW)";
            sw = rw;
            hw = r;
        } hsp_hf1_tmp1[15:8];

        field {
            name = "hsp_hf1_tmp0";
            desc = "[inferred] Hsp hf1 tmp0. (vendor header `product/hiosd/vo/hi3519/vou_reg.h` field `hsp_hf1_tmp0`; access and reset unknown, modelled RW)";
            sw = rw;
            hw = r;
        } hsp_hf1_tmp0[7:0];
    } DHD0_HSPCFG7 @ 0xC11C;

    reg {
        name = "DHD0 HSPCFG8";
        desc = "[inferred] DHD0 HSPCFG8. Not in the data sheet. Source: vendor U-Boot 2010.06 `product/hiosd/vo/hi3519/vou_reg.h` (GPL-2.0 U-Boot tree, HiSilicon copyright, created 2015-05-26; mirror github.com/OpenIPC/u-boot-hi3516cv200), union `U_DHD0_HSPCFG8`, struct offset 0xC120 (GPL-2.0, same-chip vendor header, byte-identical for Hi3516A V200 and Hi3519 V101). Reset value and access type unknown (modelled RW, no reset). Confidence: medium (vendor header for this chip family, not hardware verified).";

        field {
            name = "hsp_hf1_coring";
            desc = "[inferred] Hsp hf1 coring. (vendor header `product/hiosd/vo/hi3519/vou_reg.h` field `hsp_hf1_coring`; access and reset unknown, modelled RW)";
            sw = rw;
            hw = r;
        } hsp_hf1_coring[7:0];
    } DHD0_HSPCFG8 @ 0xC120;

    reg {
        name = "DHD0 HSPCFG12";
        desc = "[inferred] DHD0 HSPCFG12. Not in the data sheet. Source: vendor U-Boot 2010.06 `product/hiosd/vo/hi3519/vou_reg.h` (GPL-2.0 U-Boot tree, HiSilicon copyright, created 2015-05-26; mirror github.com/OpenIPC/u-boot-hi3516cv200), union `U_DHD0_HSPCFG12`, struct offset 0xC130 (GPL-2.0, same-chip vendor header, byte-identical for Hi3516A V200 and Hi3519 V101). Reset value and access type unknown (modelled RW, no reset). Confidence: medium (vendor header for this chip family, not hardware verified).";

        field {
            name = "hsp_hf1_gainneg";
            desc = "[inferred] Hsp hf1 gainneg. (vendor header `product/hiosd/vo/hi3519/vou_reg.h` field `hsp_hf1_gainneg`; access and reset unknown, modelled RW)";
            sw = rw;
            hw = r;
        } hsp_hf1_gainneg[26:16];

        field {
            name = "hsp_hf1_gainpos";
            desc = "[inferred] Hsp hf1 gainpos. (vendor header `product/hiosd/vo/hi3519/vou_reg.h` field `hsp_hf1_gainpos`; access and reset unknown, modelled RW)";
            sw = rw;
            hw = r;
        } hsp_hf1_gainpos[10:0];
    } DHD0_HSPCFG12 @ 0xC130;

    reg {
        name = "DHD0 HSPCFG13";
        desc = "[inferred] DHD0 HSPCFG13. Not in the data sheet. Source: vendor U-Boot 2010.06 `product/hiosd/vo/hi3519/vou_reg.h` (GPL-2.0 U-Boot tree, HiSilicon copyright, created 2015-05-26; mirror github.com/OpenIPC/u-boot-hi3516cv200), union `U_DHD0_HSPCFG13`, struct offset 0xC134 (GPL-2.0, same-chip vendor header, byte-identical for Hi3516A V200 and Hi3519 V101). Reset value and access type unknown (modelled RW, no reset). Confidence: medium (vendor header for this chip family, not hardware verified).";

        field {
            name = "hsp_hf1_adpshoot_en";
            desc = "[inferred] Hsp hf1 adpshoot enable. (vendor header `product/hiosd/vo/hi3519/vou_reg.h` field `hsp_hf1_adpshoot_en`; access and reset unknown, modelled RW)";
            sw = rw;
            hw = r;
        } hsp_hf1_adpshoot_en[31:31];

        field {
            name = "hsp_hf1_winsize";
            desc = "[inferred] Hsp hf1 winsize. (vendor header `product/hiosd/vo/hi3519/vou_reg.h` field `hsp_hf1_winsize`; access and reset unknown, modelled RW)";
            sw = rw;
            hw = r;
        } hsp_hf1_winsize[30:28];

        field {
            name = "hsp_hf1_mixratio";
            desc = "[inferred] Hsp hf1 mixratio. (vendor header `product/hiosd/vo/hi3519/vou_reg.h` field `hsp_hf1_mixratio`; access and reset unknown, modelled RW)";
            sw = rw;
            hw = r;
        } hsp_hf1_mixratio[23:16];

        field {
            name = "hsp_hf1_underth";
            desc = "[inferred] Hsp hf1 underth. (vendor header `product/hiosd/vo/hi3519/vou_reg.h` field `hsp_hf1_underth`; access and reset unknown, modelled RW)";
            sw = rw;
            hw = r;
        } hsp_hf1_underth[15:8];

        field {
            name = "hsp_hf1_overth";
            desc = "[inferred] Hsp hf1 overth. (vendor header `product/hiosd/vo/hi3519/vou_reg.h` field `hsp_hf1_overth`; access and reset unknown, modelled RW)";
            sw = rw;
            hw = r;
        } hsp_hf1_overth[7:0];
    } DHD0_HSPCFG13 @ 0xC134;

    reg {
        name = "DHD0 HSPCFG14";
        desc = "[inferred] DHD0 HSPCFG14. Not in the data sheet. Source: vendor U-Boot 2010.06 `product/hiosd/vo/hi3519/vou_reg.h` (GPL-2.0 U-Boot tree, HiSilicon copyright, created 2015-05-26; mirror github.com/OpenIPC/u-boot-hi3516cv200), union `U_DHD0_HSPCFG14`, struct offset 0xC138 (GPL-2.0, same-chip vendor header, byte-identical for Hi3516A V200 and Hi3519 V101). Reset value and access type unknown (modelled RW, no reset). Confidence: medium (vendor header for this chip family, not hardware verified).";

        field {
            name = "hsp_h0_en";
            desc = "[inferred] Hsp h0 enable. (vendor header `product/hiosd/vo/hi3519/vou_reg.h` field `hsp_h0_en`; access and reset unknown, modelled RW)";
            sw = rw;
            hw = r;
        } hsp_h0_en[31:31];

        field {
            name = "hsp_h1_en";
            desc = "[inferred] Hsp h1 enable. (vendor header `product/hiosd/vo/hi3519/vou_reg.h` field `hsp_h1_en`; access and reset unknown, modelled RW)";
            sw = rw;
            hw = r;
        } hsp_h1_en[30:30];

        field {
            name = "hsp_ltih_en";
            desc = "[inferred] Hsp ltih enable. (vendor header `product/hiosd/vo/hi3519/vou_reg.h` field `hsp_ltih_en`; access and reset unknown, modelled RW)";
            sw = rw;
            hw = r;
        } hsp_ltih_en[29:29];

        field {
            name = "hsp_ctih_en";
            desc = "[inferred] Hsp ctih enable. (vendor header `product/hiosd/vo/hi3519/vou_reg.h` field `hsp_ctih_en`; access and reset unknown, modelled RW)";
            sw = rw;
            hw = r;
        } hsp_ctih_en[28:28];

        field {
            name = "hsp_hf_shootdiv";
            desc = "[inferred] Hsp hf shootdiv. (vendor header `product/hiosd/vo/hi3519/vou_reg.h` field `hsp_hf_shootdiv`; access and reset unknown, modelled RW)";
            sw = rw;
            hw = r;
        } hsp_hf_shootdiv[26:24];

        field {
            name = "hsp_lti_ratio";
            desc = "[inferred] Hsp lti ratio. (vendor header `product/hiosd/vo/hi3519/vou_reg.h` field `hsp_lti_ratio`; access and reset unknown, modelled RW)";
            sw = rw;
            hw = r;
        } hsp_lti_ratio[23:16];

        field {
            name = "hsp_ldti_gain";
            desc = "[inferred] Hsp ldti gain. (vendor header `product/hiosd/vo/hi3519/vou_reg.h` field `hsp_ldti_gain`; access and reset unknown, modelled RW)";
            sw = rw;
            hw = r;
        } hsp_ldti_gain[15:8];

        field {
            name = "hsp_cdti_gain";
            desc = "[inferred] Hsp cdti gain. (vendor header `product/hiosd/vo/hi3519/vou_reg.h` field `hsp_cdti_gain`; access and reset unknown, modelled RW)";
            sw = rw;
            hw = r;
        } hsp_cdti_gain[7:0];
    } DHD0_HSPCFG14 @ 0xC138;

    reg {
        name = "DHD0 HSPCFG15";
        desc = "[inferred] DHD0 HSPCFG15. Not in the data sheet. Source: vendor U-Boot 2010.06 `product/hiosd/vo/hi3519/vou_reg.h` (GPL-2.0 U-Boot tree, HiSilicon copyright, created 2015-05-26; mirror github.com/OpenIPC/u-boot-hi3516cv200), union `U_DHD0_HSPCFG15`, struct offset 0xC13C (GPL-2.0, same-chip vendor header, byte-identical for Hi3516A V200 and Hi3519 V101). Reset value and access type unknown (modelled RW, no reset). Confidence: medium (vendor header for this chip family, not hardware verified).";

        field {
            name = "hsp_peak_ratio";
            desc = "[inferred] Hsp peak ratio. (vendor header `product/hiosd/vo/hi3519/vou_reg.h` field `hsp_peak_ratio`; access and reset unknown, modelled RW)";
            sw = rw;
            hw = r;
        } hsp_peak_ratio[27:20];

        field {
            name = "hsp_glb_overth";
            desc = "[inferred] Hsp glb overth. (vendor header `product/hiosd/vo/hi3519/vou_reg.h` field `hsp_glb_overth`; access and reset unknown, modelled RW)";
            sw = rw;
            hw = r;
        } hsp_glb_overth[18:10];

        field {
            name = "hsp_glb_underth";
            desc = "[inferred] Hsp glb underth. (vendor header `product/hiosd/vo/hi3519/vou_reg.h` field `hsp_glb_underth`; access and reset unknown, modelled RW)";
            sw = rw;
            hw = r;
        } hsp_glb_underth[8:0];
    } DHD0_HSPCFG15 @ 0xC13C;

    reg {
        name = "DHD1 global control register";
        desc = "DHD1_CTRL is a DHD1 global control register. You must configure all bits of this register before configuring DHD1_CTRL[intf_en]. Otherwise, the configuration does not take effect.

Data sheet 9.2.6 DHD1_CTRL (offset 0xC400, printed page 9-126, `hi3516av200--Hi3516AV200-Datasheet.txt` line 44522).";

        enum DHD1_CTRL_intf_en_enum {
            DISABLED = 0 { name = "Disabled"; desc = "disabled"; };
            ENABLED = 1 { name = "Enabled"; desc = "enabled"; };
        };

        field {
            name = "intf_en";
            desc = "Display interface enable (instant). Data is output over the interface only when this field is enabled.";
            sw = rw;
            hw = r;
            encode = DHD1_CTRL_intf_en_enum;
            reset = 0x0;
        } intf_en[31:31];

        enum DHD1_CTRL_cbar_en_enum {
            DISABLED = 0 { name = "Disabled"; desc = "disabled"; };
            ENABLED = 1 { name = "Enabled"; desc = "enabled"; };
        };

        field {
            name = "cbar_en";
            desc = "Color bar enable. The color bar is output over the interface when this field is enabled.";
            sw = rw;
            hw = r;
            encode = DHD1_CTRL_cbar_en_enum;
            reset = 0x0;
        } cbar_en[30:30];

        enum DHD1_CTRL_cbar_sel_enum {
            VGA = 0 { name = "Vga"; desc = "VGA"; };
            YPBPR = 1 { name = "Ypbpr"; desc = "YPbPr"; };
        };

        field {
            name = "cbar_sel";
            desc = "Color space select for the output color bar (instant)";
            sw = rw;
            hw = r;
            encode = DHD1_CTRL_cbar_sel_enum;
            reset = 0x0;
        } cbar_sel[29:29];

        enum DHD1_CTRL_precharge_en_enum {
            DISABLED = 0 { name = "Disabled"; desc = "disabled"; };
            ENABLED = 1 { name = "Enabled"; desc = "enabled"; };
        };

        field {
            name = "precharge_en";
            desc = "Pre-charge enable. This field is valid when the precharge_mode field is 1 (software mode).";
            sw = rw;
            hw = r;
            encode = DHD1_CTRL_precharge_en_enum;
            reset = 0x0;
        } precharge_en[10:10];

        enum DHD1_CTRL_precharge_mode_enum {
            HARDWARE_MODE_HARDWARE = 0 { name = "Hardware Mode Hardware"; desc = "hardware mode. Hardware automatically enters the pre-charge status in the vertical blanking region."; };
            SOFTWARE_MODE_SOFTWARE = 1 { name = "Software Mode Software"; desc = "software mode. Software controls whether to enter or exit the pre-charge status."; };
        };

        field {
            name = "precharge_mode";
            desc = "Pre-charge mode of AFIFO";
            sw = rw;
            hw = r;
            encode = DHD1_CTRL_precharge_mode_enum;
            reset = 0x0;
        } precharge_mode[9:9];

        enum DHD1_CTRL_iop_enum {
            INTERLACED_DISPLAY = 0 { name = "Interlaced Display"; desc = "interlaced display"; };
            PROGRESSIVE_DISPLAY = 1 { name = "Progressive Display"; desc = "progressive display"; };
        };

        field {
            name = "iop";
            desc = "Display mode (non-instant)";
            sw = rw;
            hw = r;
            encode = DHD1_CTRL_iop_enum;
            reset = 0x0;
        } iop[4:4];

        field {
            name = "regup";
            desc = "Surface register update. After the registers at this layer are configured, the registers are updated when the value 1 is written to this bit. After the registers are updated, this bit is automatically cleared by the hardware.";
            sw = rw;
            hw = w;
            onwrite = woclr;
            reset = 0x0;
        } regup[0:0];
    } DHD1_CTRL @ 0xC400;

    reg {
        name = "Top field VS timing register in interlaced C output mode or frame VS timing register in progressive output mode";
        desc = "DHD1_VSYNC is a top field VS timing register in interlaced output mode or frame VS timing register in progressive output mode. This register is a non-instant register.

Data sheet 9.2.6 DHD1_VSYNC (offset 0xC404, printed page 9-127, `hi3516av200--Hi3516AV200-Datasheet.txt` line 44592).";

        field {
            name = "vfb";
            desc = "In interlaced output mode: top vertical front blanking (TVFB) In progressive output mode: vertical front blanking (VFB)";
            sw = rw;
            hw = r;
            reset = 0x1;
        } vfb[27:20];

        field {
            name = "vbb";
            desc = "In interlaced output mode: top vertical back blanking (TVBB) In progressive output mode: vertical back blanking (VBB)+vertical pulse width (VPW)";
            sw = rw;
            hw = r;
            reset = 0x13;
        } vbb[19:12];

        field {
            name = "vact";
            desc = "In interlaced output mode: height of an active image on the top field In progressive output mode: height of an active image in a frame. The configured value is the actual value minus 1.";
            sw = rw;
            hw = r;
            reset = 0x21B;
        } vact[11:0];
    } DHD1_VSYNC @ 0xC404;

    reg {
        name = "HS configuration register in interlaced or C1 progressive output mode";
        desc = "DHD1_HSYNC1 is an HS configuration register in interlaced or progressive output mode (non-instant register). Hi3516A V200 Professional HD IP Camera SoC

Data sheet 9.2.6 DHD1_HSYNC1 (offset 0xC408, printed page 9-128, `hi3516av200--Hi3516AV200-Datasheet.txt` line 44633).";

        field {
            name = "hbb";
            desc = "Horizontal back blanking (HBB), in pixel";
            sw = rw;
            hw = r;
            reset = 0xBF;
        } hbb[31:16];

        field {
            name = "hact";
            desc = "Number of horizontal pixels in an active region";
            sw = rw;
            hw = r;
            reset = 0x77F;
        } hact[15:0];
    } DHD1_HSYNC1 @ 0xC408;

    reg {
        name = "HS configuration register in interlaced or C2 progressive output mode";
        desc = "DHD1_HSYNC2 is an HS configuration register in interlaced or progressive output mode (non-instant register).

Data sheet 9.2.6 DHD1_HSYNC2 (offset 0xC40C, printed page 9-128, `hi3516av200--Hi3516AV200-Datasheet.txt` line 44653).";

        field {
            name = "hmid";
            desc = "Bottom VS active pixel (active region)";
            sw = rw;
            hw = r;
            reset = 0x0;
        } hmid[31:16];

        field {
            name = "hfb";
            desc = "HFB, in pixel";
            sw = rw;
            hw = r;
            reset = 0x20F;
        } hfb[15:0];
    } DHD1_HSYNC2 @ 0xC40C;

    reg {
        name = "Bottom field VS timing register in S interlaced output mode";
        desc = "DHD1_VPLUS is a bottom field VS timing in interlaced output mode (non-instant register).

Data sheet 9.2.6 DHD1_VPLUS (offset 0xC410, printed page 9-128, `hi3516av200--Hi3516AV200-Datasheet.txt` line 44672).";

        field {
            name = "bvfb";
            desc = "Bottom vertical front blanking (BVFB) in interlaced output mode";
            sw = rw;
            hw = r;
            reset = 0x2;
        } bvfb[27:20];

        field {
            name = "bvbb";
            desc = "Bottom vertical back blanking (BVBB)+VPW in interlaced output";
            sw = rw;
            hw = r;
            reset = 0x13;
        } bvbb[19:12];

        field {
            name = "bvact";
            desc = "mode Height of an active image in the bottom field in interlaced output mode The configured value is the actual value minus 1.";
            sw = rw;
            hw = r;
            reset = 0x21B;
        } bvact[11:0];
    } DHD1_VPLUS @ 0xC410;

    reg {
        name = "Sync signal pulse width register";
        desc = "DHD1_PWR is a sync signal pulse width register (non-instant register).

Data sheet 9.2.6 DHD1_PWR (offset 0xC414, printed page 9-129, `hi3516av200--Hi3516AV200-Datasheet.txt` line 44705).";

        field {
            name = "vpw";
            desc = "VPW. The configured value is the actual value minus 1.";
            sw = rw;
            hw = r;
            reset = 0x0;
        } vpw[23:16];

        field {
            name = "hpw";
            desc = "Horizontal pulse width (HPW). The configured value is the actual value minus 1.";
            sw = rw;
            hw = r;
            reset = 0x0;
        } hpw[15:0];
    } DHD1_PWR @ 0xC414;

    reg {
        name = "Vertical timing threshold register D3";
        desc = "DHD1_VTTHD3 is a vertical timing threshold register (instant register). It can be used to set two thresholds for generating two interrupts separately.

Data sheet 9.2.6 DHD1_VTTHD3 (offset 0xC418, printed page 9-129, `hi3516av200--Hi3516AV200-Datasheet.txt` line 44729).";

        enum DHD1_VTTHD3_thd4_mode_enum {
            FRAME_MODE_THRESHOLD = 0 { name = "Frame Mode Threshold"; desc = "frame mode. The threshold count is by frame."; };
            FIELD_MODE_THRESHOLD = 1 { name = "Field Mode Threshold"; desc = "field mode. The threshold count is by field during interlaced displaying."; };
        };

        field {
            name = "thd4_mode";
            desc = "Mode of generating threshold 4";
            sw = rw;
            hw = r;
            encode = DHD1_VTTHD3_thd4_mode_enum;
            reset = 0x0;
        } thd4_mode[31:31];

        field {
            name = "vtmgthd4";
            desc = "Vertical timing threshold 4 for simultaneously triggering DHD and DSD. The start time of the DSD interface timing is later than that of the DHD interface timing and is equal to the number of lines configured in vtmgthd4.";
            sw = rw;
            hw = r;
            reset = 0x0;
        } vtmgthd4[28:16];

        enum DHD1_VTTHD3_thd3_mode_enum {
            FRAME_MODE_THRESHOLD = 0 { name = "Frame Mode Threshold"; desc = "frame mode. The threshold count is by frame."; };
            FIELD_MODE_THRESHOLD = 1 { name = "Field Mode Threshold"; desc = "field mode. The threshold count is by field during interlaced displaying."; };
        };

        field {
            name = "thd3_mode";
            desc = "Mode of generating threshold 3";
            sw = rw;
            hw = r;
            encode = DHD1_VTTHD3_thd3_mode_enum;
            reset = 0x0;
        } thd3_mode[15:15];

        field {
            name = "vtmgthd3";
            desc = "Vertical timing threshold 3. When the vertical timing counter reaches this threshold, the VOINTSTA[dhdvtthd3_int] interrupt is triggered.";
            sw = rw;
            hw = r;
            reset = 0x0;
        } vtmgthd3[12:0];
    } DHD1_VTTHD3 @ 0xC418;

    reg {
        name = "Vertical timing threshold register D";
        desc = "DHD1_VTTHD is a vertical timing threshold register (instant register). It can be used to set two thresholds for generating two interrupts separately.

Data sheet 9.2.6 DHD1_VTTHD (offset 0xC41C, printed page 9-130, `hi3516av200--Hi3516AV200-Datasheet.txt` line 44783).";

        enum DHD1_VTTHD_thd2_mode_enum {
            FRAME_MODE_THRESHOLD = 0 { name = "Frame Mode Threshold"; desc = "frame mode. The threshold count is by frame."; };
            FIELD_MODE_THRESHOLD = 1 { name = "Field Mode Threshold"; desc = "field mode. The threshold count is by field during interlaced displaying."; };
        };

        field {
            name = "thd2_mode";
            desc = "Mode of generating threshold 2";
            sw = rw;
            hw = r;
            encode = DHD1_VTTHD_thd2_mode_enum;
            reset = 0x0;
        } thd2_mode[31:31];

        field {
            name = "vtmgthd2";
            desc = "Vertical timing threshold 2. When the vertical timing counter reaches this threshold, the VOINTSTA[dhdvtthd2_int] interrupt is triggered.";
            sw = rw;
            hw = r;
            reset = 0x1;
        } vtmgthd2[28:16];

        enum DHD1_VTTHD_thd1_mode_enum {
            FRAME_MODE_THRESHOLD = 0 { name = "Frame Mode Threshold"; desc = "frame mode. The threshold count is by frame."; };
            FIELD_MODE_THRESHOLD = 1 { name = "Field Mode Threshold"; desc = "field mode. The threshold count is by field during interlaced displaying."; };
        };

        field {
            name = "thd1_mode";
            desc = "Mode of generating threshold 1";
            sw = rw;
            hw = r;
            encode = DHD1_VTTHD_thd1_mode_enum;
            reset = 0x0;
        } thd1_mode[15:15];

        field {
            name = "vtmgthd1";
            desc = "Vertical timing threshold 1. When the vertical timing counter reaches this threshold, the VOINTSTA[dhdvtthd_int1] interrupt is triggered.";
            sw = rw;
            hw = r;
            reset = 0x1;
        } vtmgthd1[12:0];
    } DHD1_VTTHD @ 0xC41C;

    reg {
        name = "PARA coefficient update point threshold THD register";
        desc = "DHD1_PARATHDis a PARA coefficient update point threshold register.

Data sheet 9.2.6 DHD1_PARATHD (offset 0xC4B0, printed page 9-131, `hi3516av200--Hi3516AV200-Datasheet.txt` line 44834).";

        enum DHD1_PARATHD_dfs_en_enum {
            DISABLED = 0 { name = "Disabled"; desc = "disabled"; };
            ENABLED = 1 { name = "Enabled"; desc = "enabled"; };
        };

        field {
            name = "dfs_en";
            desc = "DFS enable";
            sw = rw;
            hw = r;
            encode = DHD1_PARATHD_dfs_en_enum;
            reset = 0x0;
        } dfs_en[31:31];

        field {
            name = "para_thd";
            desc = "PARA coefficient update point threshold. It indicates the line after the vertical back blanking where the update point occurs. This field is valid only after DFS is enabled.";
            sw = rw;
            hw = r;
            reset = 0x0;
        } para_thd[5:0];
    } DHD1_PARATHD @ 0xC4B0;

    reg {
        name = "DHD1 start signal start position register T_POS";
        desc = "DHD1_START_POS is a DHD1 start signal start position register.

Data sheet 9.2.6 DHD1_START_POS (offset 0xC4C0, printed page 9-131, `hi3516av200--Hi3516AV200-Datasheet.txt` line 44861).";

        field {
            name = "timing_start_pos";
            desc = "Number of lines before the active region where the timing_gen state machine starts to work";
            sw = rw;
            hw = r;
            reset = 0x8;
        } timing_start_pos[15:8];

        field {
            name = "start_pos";
            desc = "Number of lines before the active region where the start signal is generated in online mode";
            sw = rw;
            hw = r;
            reset = 0x5;
        } start_pos[7:0];
    } DHD1_START_POS @ 0xC4C0;

    reg {
        name = "DHD1 status register";
        desc = "DHD1_STATE is a DHD1 status register.

Data sheet 9.2.6 DHD1_STATE (offset 0xC4F0, printed page 9-132, `hi3516av200--Hi3516AV200-Datasheet.txt` line 44896).";

        field {
            name = "count_int";
            desc = "DHD1 interrupt count. The count value is incremented by 1 each time a vertical timing interrupt is reported.";
            sw = r;
            hw = w;
            reset = 0x0;
        } count_int[23:16];

        field {
            name = "vcnt";
            desc = "Active display line count of DHD1";
            sw = r;
            hw = w;
            reset = 0x0;
        } vcnt[15:3];

        enum DHD1_STATE_bottom_field_enum {
            TOP_FIELD = 0 { name = "Top Field"; desc = "top field"; };
            BOTTOM_FIELD = 1 { name = "Bottom Field"; desc = "bottom field"; };
        };

        field {
            name = "bottom_field";
            desc = "DHD1 top/bottom field indicator";
            sw = r;
            hw = w;
            encode = DHD1_STATE_bottom_field_enum;
            reset = 0x1;
        } bottom_field[2:2];

        enum DHD1_STATE_vblank_enum {
            ACTIVE_REGION = 0 { name = "Active Region"; desc = "active region"; };
            BLANKING_REGION = 1 { name = "Blanking Region"; desc = "blanking region"; };
        };

        field {
            name = "vblank";
            desc = "DHD1 blanking region indicator";
            sw = r;
            hw = w;
            encode = DHD1_STATE_vblank_enum;
            reset = 0x1;
        } vblank[1:1];

        enum DHD1_STATE_vback_blank_enum {
            NON_BACK_BLANKING = 0 { name = "Non Back Blanking"; desc = "non-back blanking region"; };
            BLANKING_REGION = 1 { name = "Blanking Region"; desc = "blanking region"; };
        };

        field {
            name = "vback_blank";
            desc = "DHD1 back blanking region indicator";
            sw = r;
            hw = w;
            encode = DHD1_STATE_vback_blank_enum;
            reset = 0x0;
        } vback_blank[0:0];
    } DHD1_STATE @ 0xC4F0;

    reg {
        name = "INTF control";
        desc = "[inferred] INTF control. Not in the data sheet. Source: vendor U-Boot 2010.06 `product/hiosd/vo/hi3519/vou_reg.h` (GPL-2.0 U-Boot tree, HiSilicon copyright, created 2015-05-26; mirror github.com/OpenIPC/u-boot-hi3516cv200), union `U_INTF_CTRL`, struct offset 0xD000 (GPL-2.0, same-chip vendor header, byte-identical for Hi3516A V200 and Hi3519 V101). Reset value and access type unknown (modelled RW, no reset). Confidence: medium (vendor header for this chip family, not hardware verified).";

        field {
            name = "hdmi_mode";
            desc = "[inferred] Hdmi mode. (vendor header `product/hiosd/vo/hi3519/vou_reg.h` field `hdmi_mode`; access and reset unknown, modelled RW)";
            sw = rw;
            hw = r;
        } hdmi_mode[31:31];

        field {
            name = "bt1120_bypass";
            desc = "[inferred] Bt1120 bypass. (vendor header `product/hiosd/vo/hi3519/vou_reg.h` field `bt1120_bypass`; access and reset unknown, modelled RW)";
            sw = rw;
            hw = r;
        } bt1120_bypass[30:30];

        field {
            name = "lcd_serial_mode";
            desc = "[inferred] Lcd serial mode. (vendor header `product/hiosd/vo/hi3519/vou_reg.h` field `lcd_serial_mode`; access and reset unknown, modelled RW)";
            sw = rw;
            hw = r;
        } lcd_serial_mode[29:29];

        field {
            name = "lcd_serial_perd";
            desc = "[inferred] Lcd serial perd. (vendor header `product/hiosd/vo/hi3519/vou_reg.h` field `lcd_serial_perd`; access and reset unknown, modelled RW)";
            sw = rw;
            hw = r;
        } lcd_serial_perd[28:28];

        field {
            name = "lcd_parallel_order";
            desc = "[inferred] Lcd parallel order. (vendor header `product/hiosd/vo/hi3519/vou_reg.h` field `lcd_parallel_order`; access and reset unknown, modelled RW)";
            sw = rw;
            hw = r;
        } lcd_parallel_order[27:27];

        field {
            name = "lcd_data_inv";
            desc = "[inferred] Lcd data invert. (vendor header `product/hiosd/vo/hi3519/vou_reg.h` field `lcd_data_inv`; access and reset unknown, modelled RW)";
            sw = rw;
            hw = r;
        } lcd_data_inv[26:26];

        field {
            name = "lcd_parallel_mode";
            desc = "[inferred] Lcd parallel mode. (vendor header `product/hiosd/vo/hi3519/vou_reg.h` field `lcd_parallel_mode`; access and reset unknown, modelled RW)";
            sw = rw;
            hw = r;
        } lcd_parallel_mode[25:25];

        field {
            name = "yc_mode";
            desc = "[inferred] Yc mode. (vendor header `product/hiosd/vo/hi3519/vou_reg.h` field `yc_mode`; access and reset unknown, modelled RW)";
            sw = rw;
            hw = r;
        } yc_mode[24:24];
    } INTF_CTRL @ 0xD000;

    reg {
        name = "INTF update";
        desc = "[inferred] INTF update. Not in the data sheet. Source: vendor U-Boot 2010.06 `product/hiosd/vo/hi3519/vou_reg.h` (GPL-2.0 U-Boot tree, HiSilicon copyright, created 2015-05-26; mirror github.com/OpenIPC/u-boot-hi3516cv200), union `U_INTF_UPD`, struct offset 0xD004 (GPL-2.0, same-chip vendor header, byte-identical for Hi3516A V200 and Hi3519 V101). Reset value and access type unknown (modelled RW, no reset). Confidence: medium (vendor header for this chip family, not hardware verified).";

        field {
            name = "regup";
            desc = "[inferred] Regup. (vendor header `product/hiosd/vo/hi3519/vou_reg.h` field `regup`; access and reset unknown, modelled RW)";
            sw = rw;
            hw = r;
        } regup[0:0];
    } INTF_UPD @ 0xD004;

    reg {
        name = "INTF SYNC invert";
        desc = "[inferred] INTF SYNC invert. Not in the data sheet. Source: vendor U-Boot 2010.06 `product/hiosd/vo/hi3519/vou_reg.h` (GPL-2.0 U-Boot tree, HiSilicon copyright, created 2015-05-26; mirror github.com/OpenIPC/u-boot-hi3516cv200), union `U_INTF_SYNC_INV`, struct offset 0xD008 (GPL-2.0, same-chip vendor header, byte-identical for Hi3516A V200 and Hi3519 V101). Reset value and access type unknown (modelled RW, no reset). Confidence: medium (vendor header for this chip family, not hardware verified).";

        field {
            name = "f_inv";
            desc = "[inferred] F invert. (vendor header `product/hiosd/vo/hi3519/vou_reg.h` field `f_inv`; access and reset unknown, modelled RW)";
            sw = rw;
            hw = r;
        } f_inv[3:3];

        field {
            name = "vs_inv";
            desc = "[inferred] Vertical sync invert. (vendor header `product/hiosd/vo/hi3519/vou_reg.h` field `vs_inv`; access and reset unknown, modelled RW)";
            sw = rw;
            hw = r;
        } vs_inv[2:2];

        field {
            name = "hs_inv";
            desc = "[inferred] Horizontal sync invert. (vendor header `product/hiosd/vo/hi3519/vou_reg.h` field `hs_inv`; access and reset unknown, modelled RW)";
            sw = rw;
            hw = r;
        } hs_inv[1:1];

        field {
            name = "dv_inv";
            desc = "[inferred] Dv invert. (vendor header `product/hiosd/vo/hi3519/vou_reg.h` field `dv_inv`; access and reset unknown, modelled RW)";
            sw = rw;
            hw = r;
        } dv_inv[0:0];
    } INTF_SYNC_INV @ 0xD008;

    reg {
        name = "INTF CLIP0 L";
        desc = "[inferred] INTF CLIP0 L. Not in the data sheet. Source: vendor U-Boot 2010.06 `product/hiosd/vo/hi3519/vou_reg.h` (GPL-2.0 U-Boot tree, HiSilicon copyright, created 2015-05-26; mirror github.com/OpenIPC/u-boot-hi3516cv200), union `U_INTF_CLIP0_L`, struct offset 0xD010 (GPL-2.0, same-chip vendor header, byte-identical for Hi3516A V200 and Hi3519 V101). Reset value and access type unknown (modelled RW, no reset). Confidence: medium (vendor header for this chip family, not hardware verified).";

        field {
            name = "clip_cl2";
            desc = "[inferred] Clip cl2. (vendor header `product/hiosd/vo/hi3519/vou_reg.h` field `clip_cl2`; access and reset unknown, modelled RW)";
            sw = rw;
            hw = r;
        } clip_cl2[29:20];

        field {
            name = "clip_cl1";
            desc = "[inferred] Clip cl1. (vendor header `product/hiosd/vo/hi3519/vou_reg.h` field `clip_cl1`; access and reset unknown, modelled RW)";
            sw = rw;
            hw = r;
        } clip_cl1[19:10];

        field {
            name = "clip_cl0";
            desc = "[inferred] Clip cl0. (vendor header `product/hiosd/vo/hi3519/vou_reg.h` field `clip_cl0`; access and reset unknown, modelled RW)";
            sw = rw;
            hw = r;
        } clip_cl0[9:0];
    } INTF_CLIP0_L @ 0xD010;

    reg {
        name = "INTF CLIP0 H";
        desc = "[inferred] INTF CLIP0 H. Not in the data sheet. Source: vendor U-Boot 2010.06 `product/hiosd/vo/hi3519/vou_reg.h` (GPL-2.0 U-Boot tree, HiSilicon copyright, created 2015-05-26; mirror github.com/OpenIPC/u-boot-hi3516cv200), union `U_INTF_CLIP0_H`, struct offset 0xD014 (GPL-2.0, same-chip vendor header, byte-identical for Hi3516A V200 and Hi3519 V101). Reset value and access type unknown (modelled RW, no reset). Confidence: medium (vendor header for this chip family, not hardware verified).";

        field {
            name = "clip_ch2";
            desc = "[inferred] Clip ch2. (vendor header `product/hiosd/vo/hi3519/vou_reg.h` field `clip_ch2`; access and reset unknown, modelled RW)";
            sw = rw;
            hw = r;
        } clip_ch2[29:20];

        field {
            name = "clip_ch1";
            desc = "[inferred] Clip ch1. (vendor header `product/hiosd/vo/hi3519/vou_reg.h` field `clip_ch1`; access and reset unknown, modelled RW)";
            sw = rw;
            hw = r;
        } clip_ch1[19:10];

        field {
            name = "clip_ch0";
            desc = "[inferred] Clip ch0. (vendor header `product/hiosd/vo/hi3519/vou_reg.h` field `clip_ch0`; access and reset unknown, modelled RW)";
            sw = rw;
            hw = r;
        } clip_ch0[9:0];
    } INTF_CLIP0_H @ 0xD014;

    reg {
        name = "INTF colour-space conversion IDC";
        desc = "[inferred] INTF colour-space conversion IDC. Not in the data sheet. Source: vendor U-Boot 2010.06 `product/hiosd/vo/hi3519/vou_reg.h` (GPL-2.0 U-Boot tree, HiSilicon copyright, created 2015-05-26; mirror github.com/OpenIPC/u-boot-hi3516cv200), union `U_INTF_CSC_IDC`, struct offset 0xD020 (GPL-2.0, same-chip vendor header, byte-identical for Hi3516A V200 and Hi3519 V101). Reset value and access type unknown (modelled RW, no reset). Confidence: medium (vendor header for this chip family, not hardware verified).";

        field {
            name = "csc_en";
            desc = "[inferred] Colour-space conversion enable. (vendor header `product/hiosd/vo/hi3519/vou_reg.h` field `csc_en`; access and reset unknown, modelled RW)";
            sw = rw;
            hw = r;
        } csc_en[22:22];

        field {
            name = "cscidc1";
            desc = "[inferred] Cscidc1. (vendor header `product/hiosd/vo/hi3519/vou_reg.h` field `cscidc1`; access and reset unknown, modelled RW)";
            sw = rw;
            hw = r;
        } cscidc1[21:11];

        field {
            name = "cscidc0";
            desc = "[inferred] Cscidc0. (vendor header `product/hiosd/vo/hi3519/vou_reg.h` field `cscidc0`; access and reset unknown, modelled RW)";
            sw = rw;
            hw = r;
        } cscidc0[10:0];
    } INTF_CSC_IDC @ 0xD020;

    reg {
        name = "INTF colour-space conversion ODC";
        desc = "[inferred] INTF colour-space conversion ODC. Not in the data sheet. Source: vendor U-Boot 2010.06 `product/hiosd/vo/hi3519/vou_reg.h` (GPL-2.0 U-Boot tree, HiSilicon copyright, created 2015-05-26; mirror github.com/OpenIPC/u-boot-hi3516cv200), union `U_INTF_CSC_ODC`, struct offset 0xD024 (GPL-2.0, same-chip vendor header, byte-identical for Hi3516A V200 and Hi3519 V101). Reset value and access type unknown (modelled RW, no reset). Confidence: medium (vendor header for this chip family, not hardware verified).";

        field {
            name = "csc_sign_mode";
            desc = "[inferred] Colour-space conversion sign mode. (vendor header `product/hiosd/vo/hi3519/vou_reg.h` field `csc_sign_mode`; access and reset unknown, modelled RW)";
            sw = rw;
            hw = r;
        } csc_sign_mode[22:22];

        field {
            name = "cscodc1";
            desc = "[inferred] Cscodc1. (vendor header `product/hiosd/vo/hi3519/vou_reg.h` field `cscodc1`; access and reset unknown, modelled RW)";
            sw = rw;
            hw = r;
        } cscodc1[21:11];

        field {
            name = "cscodc0";
            desc = "[inferred] Cscodc0. (vendor header `product/hiosd/vo/hi3519/vou_reg.h` field `cscodc0`; access and reset unknown, modelled RW)";
            sw = rw;
            hw = r;
        } cscodc0[10:0];
    } INTF_CSC_ODC @ 0xD024;

    reg {
        name = "INTF colour-space conversion IODC";
        desc = "[inferred] INTF colour-space conversion IODC. Not in the data sheet. Source: vendor U-Boot 2010.06 `product/hiosd/vo/hi3519/vou_reg.h` (GPL-2.0 U-Boot tree, HiSilicon copyright, created 2015-05-26; mirror github.com/OpenIPC/u-boot-hi3516cv200), union `U_INTF_CSC_IODC`, struct offset 0xD028 (GPL-2.0, same-chip vendor header, byte-identical for Hi3516A V200 and Hi3519 V101). Reset value and access type unknown (modelled RW, no reset). Confidence: medium (vendor header for this chip family, not hardware verified).";

        field {
            name = "cscodc2";
            desc = "[inferred] Cscodc2. (vendor header `product/hiosd/vo/hi3519/vou_reg.h` field `cscodc2`; access and reset unknown, modelled RW)";
            sw = rw;
            hw = r;
        } cscodc2[21:11];

        field {
            name = "cscidc2";
            desc = "[inferred] Cscidc2. (vendor header `product/hiosd/vo/hi3519/vou_reg.h` field `cscidc2`; access and reset unknown, modelled RW)";
            sw = rw;
            hw = r;
        } cscidc2[10:0];
    } INTF_CSC_IODC @ 0xD028;

    reg {
        name = "INTF colour-space conversion P0";
        desc = "[inferred] INTF colour-space conversion P0. Not in the data sheet. Source: vendor U-Boot 2010.06 `product/hiosd/vo/hi3519/vou_reg.h` (GPL-2.0 U-Boot tree, HiSilicon copyright, created 2015-05-26; mirror github.com/OpenIPC/u-boot-hi3516cv200), union `U_INTF_CSC_P0`, struct offset 0xD02C (GPL-2.0, same-chip vendor header, byte-identical for Hi3516A V200 and Hi3519 V101). Reset value and access type unknown (modelled RW, no reset). Confidence: medium (vendor header for this chip family, not hardware verified).";

        field {
            name = "cscp01";
            desc = "[inferred] Cscp01. (vendor header `product/hiosd/vo/hi3519/vou_reg.h` field `cscp01`; access and reset unknown, modelled RW)";
            sw = rw;
            hw = r;
        } cscp01[30:16];

        field {
            name = "cscp00";
            desc = "[inferred] Cscp00. (vendor header `product/hiosd/vo/hi3519/vou_reg.h` field `cscp00`; access and reset unknown, modelled RW)";
            sw = rw;
            hw = r;
        } cscp00[14:0];
    } INTF_CSC_P0 @ 0xD02C;

    reg {
        name = "INTF colour-space conversion P1";
        desc = "[inferred] INTF colour-space conversion P1. Not in the data sheet. Source: vendor U-Boot 2010.06 `product/hiosd/vo/hi3519/vou_reg.h` (GPL-2.0 U-Boot tree, HiSilicon copyright, created 2015-05-26; mirror github.com/OpenIPC/u-boot-hi3516cv200), union `U_INTF_CSC_P1`, struct offset 0xD030 (GPL-2.0, same-chip vendor header, byte-identical for Hi3516A V200 and Hi3519 V101). Reset value and access type unknown (modelled RW, no reset). Confidence: medium (vendor header for this chip family, not hardware verified).";

        field {
            name = "cscp10";
            desc = "[inferred] Cscp10. (vendor header `product/hiosd/vo/hi3519/vou_reg.h` field `cscp10`; access and reset unknown, modelled RW)";
            sw = rw;
            hw = r;
        } cscp10[30:16];

        field {
            name = "cscp02";
            desc = "[inferred] Cscp02. (vendor header `product/hiosd/vo/hi3519/vou_reg.h` field `cscp02`; access and reset unknown, modelled RW)";
            sw = rw;
            hw = r;
        } cscp02[14:0];
    } INTF_CSC_P1 @ 0xD030;

    reg {
        name = "INTF colour-space conversion P2";
        desc = "[inferred] INTF colour-space conversion P2. Not in the data sheet. Source: vendor U-Boot 2010.06 `product/hiosd/vo/hi3519/vou_reg.h` (GPL-2.0 U-Boot tree, HiSilicon copyright, created 2015-05-26; mirror github.com/OpenIPC/u-boot-hi3516cv200), union `U_INTF_CSC_P2`, struct offset 0xD034 (GPL-2.0, same-chip vendor header, byte-identical for Hi3516A V200 and Hi3519 V101). Reset value and access type unknown (modelled RW, no reset). Confidence: medium (vendor header for this chip family, not hardware verified).";

        field {
            name = "cscp12";
            desc = "[inferred] Cscp12. (vendor header `product/hiosd/vo/hi3519/vou_reg.h` field `cscp12`; access and reset unknown, modelled RW)";
            sw = rw;
            hw = r;
        } cscp12[30:16];

        field {
            name = "cscp11";
            desc = "[inferred] Cscp11. (vendor header `product/hiosd/vo/hi3519/vou_reg.h` field `cscp11`; access and reset unknown, modelled RW)";
            sw = rw;
            hw = r;
        } cscp11[14:0];
    } INTF_CSC_P2 @ 0xD034;

    reg {
        name = "INTF colour-space conversion P3";
        desc = "[inferred] INTF colour-space conversion P3. Not in the data sheet. Source: vendor U-Boot 2010.06 `product/hiosd/vo/hi3519/vou_reg.h` (GPL-2.0 U-Boot tree, HiSilicon copyright, created 2015-05-26; mirror github.com/OpenIPC/u-boot-hi3516cv200), union `U_INTF_CSC_P3`, struct offset 0xD038 (GPL-2.0, same-chip vendor header, byte-identical for Hi3516A V200 and Hi3519 V101). Reset value and access type unknown (modelled RW, no reset). Confidence: medium (vendor header for this chip family, not hardware verified).";

        field {
            name = "cscp21";
            desc = "[inferred] Cscp21. (vendor header `product/hiosd/vo/hi3519/vou_reg.h` field `cscp21`; access and reset unknown, modelled RW)";
            sw = rw;
            hw = r;
        } cscp21[30:16];

        field {
            name = "cscp20";
            desc = "[inferred] Cscp20. (vendor header `product/hiosd/vo/hi3519/vou_reg.h` field `cscp20`; access and reset unknown, modelled RW)";
            sw = rw;
            hw = r;
        } cscp20[14:0];
    } INTF_CSC_P3 @ 0xD038;

    reg {
        name = "INTF colour-space conversion P4";
        desc = "[inferred] INTF colour-space conversion P4. Not in the data sheet. Source: vendor U-Boot 2010.06 `product/hiosd/vo/hi3519/vou_reg.h` (GPL-2.0 U-Boot tree, HiSilicon copyright, created 2015-05-26; mirror github.com/OpenIPC/u-boot-hi3516cv200), union `U_INTF_CSC_P4`, struct offset 0xD03C (GPL-2.0, same-chip vendor header, byte-identical for Hi3516A V200 and Hi3519 V101). Reset value and access type unknown (modelled RW, no reset). Confidence: medium (vendor header for this chip family, not hardware verified).";

        field {
            name = "cscp22";
            desc = "[inferred] Cscp22. (vendor header `product/hiosd/vo/hi3519/vou_reg.h` field `cscp22`; access and reset unknown, modelled RW)";
            sw = rw;
            hw = r;
        } cscp22[14:0];
    } INTF_CSC_P4 @ 0xD03C;

    reg {
        name = "INTF HSPCFG0";
        desc = "[inferred] INTF HSPCFG0. Not in the data sheet. Source: vendor U-Boot 2010.06 `product/hiosd/vo/hi3519/vou_reg.h` (GPL-2.0 U-Boot tree, HiSilicon copyright, created 2015-05-26; mirror github.com/OpenIPC/u-boot-hi3516cv200), union `U_INTF_HSPCFG0`, struct offset 0xD040 (GPL-2.0, same-chip vendor header, byte-identical for Hi3516A V200 and Hi3519 V101). Reset value and access type unknown (modelled RW, no reset). Confidence: medium (vendor header for this chip family, not hardware verified).";

        field {
            name = "hsp_hf0_tmp3";
            desc = "[inferred] Hsp hf0 tmp3. (vendor header `product/hiosd/vo/hi3519/vou_reg.h` field `hsp_hf0_tmp3`; access and reset unknown, modelled RW)";
            sw = rw;
            hw = r;
        } hsp_hf0_tmp3[31:24];

        field {
            name = "hsp_hf0_tmp2";
            desc = "[inferred] Hsp hf0 tmp2. (vendor header `product/hiosd/vo/hi3519/vou_reg.h` field `hsp_hf0_tmp2`; access and reset unknown, modelled RW)";
            sw = rw;
            hw = r;
        } hsp_hf0_tmp2[23:16];

        field {
            name = "hsp_hf0_tmp1";
            desc = "[inferred] Hsp hf0 tmp1. (vendor header `product/hiosd/vo/hi3519/vou_reg.h` field `hsp_hf0_tmp1`; access and reset unknown, modelled RW)";
            sw = rw;
            hw = r;
        } hsp_hf0_tmp1[15:8];

        field {
            name = "hsp_hf0_tmp0";
            desc = "[inferred] Hsp hf0 tmp0. (vendor header `product/hiosd/vo/hi3519/vou_reg.h` field `hsp_hf0_tmp0`; access and reset unknown, modelled RW)";
            sw = rw;
            hw = r;
        } hsp_hf0_tmp0[7:0];
    } INTF_HSPCFG0 @ 0xD040;

    reg {
        name = "INTF HSPCFG1";
        desc = "[inferred] INTF HSPCFG1. Not in the data sheet. Source: vendor U-Boot 2010.06 `product/hiosd/vo/hi3519/vou_reg.h` (GPL-2.0 U-Boot tree, HiSilicon copyright, created 2015-05-26; mirror github.com/OpenIPC/u-boot-hi3516cv200), union `U_INTF_HSPCFG1`, struct offset 0xD044 (GPL-2.0, same-chip vendor header, byte-identical for Hi3516A V200 and Hi3519 V101). Reset value and access type unknown (modelled RW, no reset). Confidence: medium (vendor header for this chip family, not hardware verified).";

        field {
            name = "hsp_en";
            desc = "[inferred] Hsp enable. (vendor header `product/hiosd/vo/hi3519/vou_reg.h` field `hsp_en`; access and reset unknown, modelled RW)";
            sw = rw;
            hw = r;
        } hsp_en[31:31];

        field {
            name = "hsp_hf0_coring";
            desc = "[inferred] Hsp hf0 coring. (vendor header `product/hiosd/vo/hi3519/vou_reg.h` field `hsp_hf0_coring`; access and reset unknown, modelled RW)";
            sw = rw;
            hw = r;
        } hsp_hf0_coring[7:0];
    } INTF_HSPCFG1 @ 0xD044;

    reg {
        name = "INTF HSPCFG5";
        desc = "[inferred] INTF HSPCFG5. Not in the data sheet. Source: vendor U-Boot 2010.06 `product/hiosd/vo/hi3519/vou_reg.h` (GPL-2.0 U-Boot tree, HiSilicon copyright, created 2015-05-26; mirror github.com/OpenIPC/u-boot-hi3516cv200), union `U_INTF_HSPCFG5`, struct offset 0xD054 (GPL-2.0, same-chip vendor header, byte-identical for Hi3516A V200 and Hi3519 V101). Reset value and access type unknown (modelled RW, no reset). Confidence: medium (vendor header for this chip family, not hardware verified).";

        field {
            name = "hsp_hf0_gainneg";
            desc = "[inferred] Hsp hf0 gainneg. (vendor header `product/hiosd/vo/hi3519/vou_reg.h` field `hsp_hf0_gainneg`; access and reset unknown, modelled RW)";
            sw = rw;
            hw = r;
        } hsp_hf0_gainneg[26:16];

        field {
            name = "hsp_hf0_gainpos";
            desc = "[inferred] Hsp hf0 gainpos. (vendor header `product/hiosd/vo/hi3519/vou_reg.h` field `hsp_hf0_gainpos`; access and reset unknown, modelled RW)";
            sw = rw;
            hw = r;
        } hsp_hf0_gainpos[10:0];
    } INTF_HSPCFG5 @ 0xD054;

    reg {
        name = "INTF HSPCFG6";
        desc = "[inferred] INTF HSPCFG6. Not in the data sheet. Source: vendor U-Boot 2010.06 `product/hiosd/vo/hi3519/vou_reg.h` (GPL-2.0 U-Boot tree, HiSilicon copyright, created 2015-05-26; mirror github.com/OpenIPC/u-boot-hi3516cv200), union `U_INTF_HSPCFG6`, struct offset 0xD058 (GPL-2.0, same-chip vendor header, byte-identical for Hi3516A V200 and Hi3519 V101). Reset value and access type unknown (modelled RW, no reset). Confidence: medium (vendor header for this chip family, not hardware verified).";

        field {
            name = "hsp_hf0_adpshoot_en";
            desc = "[inferred] Hsp hf0 adpshoot enable. (vendor header `product/hiosd/vo/hi3519/vou_reg.h` field `hsp_hf0_adpshoot_en`; access and reset unknown, modelled RW)";
            sw = rw;
            hw = r;
        } hsp_hf0_adpshoot_en[31:31];

        field {
            name = "hsp_hf0_winsize";
            desc = "[inferred] Hsp hf0 winsize. (vendor header `product/hiosd/vo/hi3519/vou_reg.h` field `hsp_hf0_winsize`; access and reset unknown, modelled RW)";
            sw = rw;
            hw = r;
        } hsp_hf0_winsize[30:28];

        field {
            name = "hsp_hf0_mixratio";
            desc = "[inferred] Hsp hf0 mixratio. (vendor header `product/hiosd/vo/hi3519/vou_reg.h` field `hsp_hf0_mixratio`; access and reset unknown, modelled RW)";
            sw = rw;
            hw = r;
        } hsp_hf0_mixratio[23:16];

        field {
            name = "hsp_hf0_underth";
            desc = "[inferred] Hsp hf0 underth. (vendor header `product/hiosd/vo/hi3519/vou_reg.h` field `hsp_hf0_underth`; access and reset unknown, modelled RW)";
            sw = rw;
            hw = r;
        } hsp_hf0_underth[15:8];

        field {
            name = "hsp_hf0_overth";
            desc = "[inferred] Hsp hf0 overth. (vendor header `product/hiosd/vo/hi3519/vou_reg.h` field `hsp_hf0_overth`; access and reset unknown, modelled RW)";
            sw = rw;
            hw = r;
        } hsp_hf0_overth[7:0];
    } INTF_HSPCFG6 @ 0xD058;

    reg {
        name = "INTF HSPCFG7";
        desc = "[inferred] INTF HSPCFG7. Not in the data sheet. Source: vendor U-Boot 2010.06 `product/hiosd/vo/hi3519/vou_reg.h` (GPL-2.0 U-Boot tree, HiSilicon copyright, created 2015-05-26; mirror github.com/OpenIPC/u-boot-hi3516cv200), union `U_INTF_HSPCFG7`, struct offset 0xD05C (GPL-2.0, same-chip vendor header, byte-identical for Hi3516A V200 and Hi3519 V101). Reset value and access type unknown (modelled RW, no reset). Confidence: medium (vendor header for this chip family, not hardware verified).";

        field {
            name = "hsp_hf1_tmp3";
            desc = "[inferred] Hsp hf1 tmp3. (vendor header `product/hiosd/vo/hi3519/vou_reg.h` field `hsp_hf1_tmp3`; access and reset unknown, modelled RW)";
            sw = rw;
            hw = r;
        } hsp_hf1_tmp3[31:24];

        field {
            name = "hsp_hf1_tmp2";
            desc = "[inferred] Hsp hf1 tmp2. (vendor header `product/hiosd/vo/hi3519/vou_reg.h` field `hsp_hf1_tmp2`; access and reset unknown, modelled RW)";
            sw = rw;
            hw = r;
        } hsp_hf1_tmp2[23:16];

        field {
            name = "hsp_hf1_tmp1";
            desc = "[inferred] Hsp hf1 tmp1. (vendor header `product/hiosd/vo/hi3519/vou_reg.h` field `hsp_hf1_tmp1`; access and reset unknown, modelled RW)";
            sw = rw;
            hw = r;
        } hsp_hf1_tmp1[15:8];

        field {
            name = "hsp_hf1_tmp0";
            desc = "[inferred] Hsp hf1 tmp0. (vendor header `product/hiosd/vo/hi3519/vou_reg.h` field `hsp_hf1_tmp0`; access and reset unknown, modelled RW)";
            sw = rw;
            hw = r;
        } hsp_hf1_tmp0[7:0];
    } INTF_HSPCFG7 @ 0xD05C;

    reg {
        name = "INTF HSPCFG8";
        desc = "[inferred] INTF HSPCFG8. Not in the data sheet. Source: vendor U-Boot 2010.06 `product/hiosd/vo/hi3519/vou_reg.h` (GPL-2.0 U-Boot tree, HiSilicon copyright, created 2015-05-26; mirror github.com/OpenIPC/u-boot-hi3516cv200), union `U_INTF_HSPCFG8`, struct offset 0xD060 (GPL-2.0, same-chip vendor header, byte-identical for Hi3516A V200 and Hi3519 V101). Reset value and access type unknown (modelled RW, no reset). Confidence: medium (vendor header for this chip family, not hardware verified).";

        field {
            name = "hsp_hf1_coring";
            desc = "[inferred] Hsp hf1 coring. (vendor header `product/hiosd/vo/hi3519/vou_reg.h` field `hsp_hf1_coring`; access and reset unknown, modelled RW)";
            sw = rw;
            hw = r;
        } hsp_hf1_coring[7:0];
    } INTF_HSPCFG8 @ 0xD060;

    reg {
        name = "INTF HSPCFG12";
        desc = "[inferred] INTF HSPCFG12. Not in the data sheet. Source: vendor U-Boot 2010.06 `product/hiosd/vo/hi3519/vou_reg.h` (GPL-2.0 U-Boot tree, HiSilicon copyright, created 2015-05-26; mirror github.com/OpenIPC/u-boot-hi3516cv200), union `U_INTF_HSPCFG12`, struct offset 0xD070 (GPL-2.0, same-chip vendor header, byte-identical for Hi3516A V200 and Hi3519 V101). Reset value and access type unknown (modelled RW, no reset). Confidence: medium (vendor header for this chip family, not hardware verified).";

        field {
            name = "hsp_hf1_gainneg";
            desc = "[inferred] Hsp hf1 gainneg. (vendor header `product/hiosd/vo/hi3519/vou_reg.h` field `hsp_hf1_gainneg`; access and reset unknown, modelled RW)";
            sw = rw;
            hw = r;
        } hsp_hf1_gainneg[26:16];

        field {
            name = "hsp_hf1_gainpos";
            desc = "[inferred] Hsp hf1 gainpos. (vendor header `product/hiosd/vo/hi3519/vou_reg.h` field `hsp_hf1_gainpos`; access and reset unknown, modelled RW)";
            sw = rw;
            hw = r;
        } hsp_hf1_gainpos[10:0];
    } INTF_HSPCFG12 @ 0xD070;

    reg {
        name = "INTF HSPCFG13";
        desc = "[inferred] INTF HSPCFG13. Not in the data sheet. Source: vendor U-Boot 2010.06 `product/hiosd/vo/hi3519/vou_reg.h` (GPL-2.0 U-Boot tree, HiSilicon copyright, created 2015-05-26; mirror github.com/OpenIPC/u-boot-hi3516cv200), union `U_INTF_HSPCFG13`, struct offset 0xD074 (GPL-2.0, same-chip vendor header, byte-identical for Hi3516A V200 and Hi3519 V101). Reset value and access type unknown (modelled RW, no reset). Confidence: medium (vendor header for this chip family, not hardware verified).";

        field {
            name = "hsp_hf1_adpshoot_en";
            desc = "[inferred] Hsp hf1 adpshoot enable. (vendor header `product/hiosd/vo/hi3519/vou_reg.h` field `hsp_hf1_adpshoot_en`; access and reset unknown, modelled RW)";
            sw = rw;
            hw = r;
        } hsp_hf1_adpshoot_en[31:31];

        field {
            name = "hsp_hf1_winsize";
            desc = "[inferred] Hsp hf1 winsize. (vendor header `product/hiosd/vo/hi3519/vou_reg.h` field `hsp_hf1_winsize`; access and reset unknown, modelled RW)";
            sw = rw;
            hw = r;
        } hsp_hf1_winsize[30:28];

        field {
            name = "hsp_hf1_mixratio";
            desc = "[inferred] Hsp hf1 mixratio. (vendor header `product/hiosd/vo/hi3519/vou_reg.h` field `hsp_hf1_mixratio`; access and reset unknown, modelled RW)";
            sw = rw;
            hw = r;
        } hsp_hf1_mixratio[23:16];

        field {
            name = "hsp_hf1_underth";
            desc = "[inferred] Hsp hf1 underth. (vendor header `product/hiosd/vo/hi3519/vou_reg.h` field `hsp_hf1_underth`; access and reset unknown, modelled RW)";
            sw = rw;
            hw = r;
        } hsp_hf1_underth[15:8];

        field {
            name = "hsp_hf1_overth";
            desc = "[inferred] Hsp hf1 overth. (vendor header `product/hiosd/vo/hi3519/vou_reg.h` field `hsp_hf1_overth`; access and reset unknown, modelled RW)";
            sw = rw;
            hw = r;
        } hsp_hf1_overth[7:0];
    } INTF_HSPCFG13 @ 0xD074;

    reg {
        name = "INTF HSPCFG14";
        desc = "[inferred] INTF HSPCFG14. Not in the data sheet. Source: vendor U-Boot 2010.06 `product/hiosd/vo/hi3519/vou_reg.h` (GPL-2.0 U-Boot tree, HiSilicon copyright, created 2015-05-26; mirror github.com/OpenIPC/u-boot-hi3516cv200), union `U_INTF_HSPCFG14`, struct offset 0xD078 (GPL-2.0, same-chip vendor header, byte-identical for Hi3516A V200 and Hi3519 V101). Reset value and access type unknown (modelled RW, no reset). Confidence: medium (vendor header for this chip family, not hardware verified).";

        field {
            name = "hsp_h0_en";
            desc = "[inferred] Hsp h0 enable. (vendor header `product/hiosd/vo/hi3519/vou_reg.h` field `hsp_h0_en`; access and reset unknown, modelled RW)";
            sw = rw;
            hw = r;
        } hsp_h0_en[31:31];

        field {
            name = "hsp_h1_en";
            desc = "[inferred] Hsp h1 enable. (vendor header `product/hiosd/vo/hi3519/vou_reg.h` field `hsp_h1_en`; access and reset unknown, modelled RW)";
            sw = rw;
            hw = r;
        } hsp_h1_en[30:30];

        field {
            name = "hsp_ltih_en";
            desc = "[inferred] Hsp ltih enable. (vendor header `product/hiosd/vo/hi3519/vou_reg.h` field `hsp_ltih_en`; access and reset unknown, modelled RW)";
            sw = rw;
            hw = r;
        } hsp_ltih_en[29:29];

        field {
            name = "hsp_ctih_en";
            desc = "[inferred] Hsp ctih enable. (vendor header `product/hiosd/vo/hi3519/vou_reg.h` field `hsp_ctih_en`; access and reset unknown, modelled RW)";
            sw = rw;
            hw = r;
        } hsp_ctih_en[28:28];

        field {
            name = "hsp_hf_shootdiv";
            desc = "[inferred] Hsp hf shootdiv. (vendor header `product/hiosd/vo/hi3519/vou_reg.h` field `hsp_hf_shootdiv`; access and reset unknown, modelled RW)";
            sw = rw;
            hw = r;
        } hsp_hf_shootdiv[26:24];

        field {
            name = "hsp_lti_ratio";
            desc = "[inferred] Hsp lti ratio. (vendor header `product/hiosd/vo/hi3519/vou_reg.h` field `hsp_lti_ratio`; access and reset unknown, modelled RW)";
            sw = rw;
            hw = r;
        } hsp_lti_ratio[23:16];

        field {
            name = "hsp_ldti_gain";
            desc = "[inferred] Hsp ldti gain. (vendor header `product/hiosd/vo/hi3519/vou_reg.h` field `hsp_ldti_gain`; access and reset unknown, modelled RW)";
            sw = rw;
            hw = r;
        } hsp_ldti_gain[15:8];

        field {
            name = "hsp_cdti_gain";
            desc = "[inferred] Hsp cdti gain. (vendor header `product/hiosd/vo/hi3519/vou_reg.h` field `hsp_cdti_gain`; access and reset unknown, modelled RW)";
            sw = rw;
            hw = r;
        } hsp_cdti_gain[7:0];
    } INTF_HSPCFG14 @ 0xD078;

    reg {
        name = "INTF HSPCFG15";
        desc = "[inferred] INTF HSPCFG15. Not in the data sheet. Source: vendor U-Boot 2010.06 `product/hiosd/vo/hi3519/vou_reg.h` (GPL-2.0 U-Boot tree, HiSilicon copyright, created 2015-05-26; mirror github.com/OpenIPC/u-boot-hi3516cv200), union `U_INTF_HSPCFG15`, struct offset 0xD07C (GPL-2.0, same-chip vendor header, byte-identical for Hi3516A V200 and Hi3519 V101). Reset value and access type unknown (modelled RW, no reset). Confidence: medium (vendor header for this chip family, not hardware verified).";

        field {
            name = "hsp_peak_ratio";
            desc = "[inferred] Hsp peak ratio. (vendor header `product/hiosd/vo/hi3519/vou_reg.h` field `hsp_peak_ratio`; access and reset unknown, modelled RW)";
            sw = rw;
            hw = r;
        } hsp_peak_ratio[27:20];

        field {
            name = "hsp_glb_overth";
            desc = "[inferred] Hsp glb overth. (vendor header `product/hiosd/vo/hi3519/vou_reg.h` field `hsp_glb_overth`; access and reset unknown, modelled RW)";
            sw = rw;
            hw = r;
        } hsp_glb_overth[18:10];

        field {
            name = "hsp_glb_underth";
            desc = "[inferred] Hsp glb underth. (vendor header `product/hiosd/vo/hi3519/vou_reg.h` field `hsp_glb_underth`; access and reset unknown, modelled RW)";
            sw = rw;
            hw = r;
        } hsp_glb_underth[8:0];
    } INTF_HSPCFG15 @ 0xD07C;

    reg {
        name = "INTF DITHER0 control";
        desc = "[inferred] INTF DITHER0 control. Not in the data sheet. Source: vendor U-Boot 2010.06 `product/hiosd/vo/hi3519/vou_reg.h` (GPL-2.0 U-Boot tree, HiSilicon copyright, created 2015-05-26; mirror github.com/OpenIPC/u-boot-hi3516cv200), union `U_INTF_DITHER0_CTRL`, struct offset 0xD080 (GPL-2.0, same-chip vendor header, byte-identical for Hi3516A V200 and Hi3519 V101). Reset value and access type unknown (modelled RW, no reset). Confidence: medium (vendor header for this chip family, not hardware verified).";

        field {
            name = "dither_md";
            desc = "[inferred] Dither md. (vendor header `product/hiosd/vo/hi3519/vou_reg.h` field `dither_md`; access and reset unknown, modelled RW)";
            sw = rw;
            hw = r;
        } dither_md[31:29];
    } INTF_DITHER0_CTRL @ 0xD080;

    reg {
        name = "INTF DITHER0 COEF0";
        desc = "[inferred] INTF DITHER0 COEF0. Not in the data sheet. Source: vendor U-Boot 2010.06 `product/hiosd/vo/hi3519/vou_reg.h` (GPL-2.0 U-Boot tree, HiSilicon copyright, created 2015-05-26; mirror github.com/OpenIPC/u-boot-hi3516cv200), union `U_INTF_DITHER0_COEF0`, struct offset 0xD084 (GPL-2.0, same-chip vendor header, byte-identical for Hi3516A V200 and Hi3519 V101). Reset value and access type unknown (modelled RW, no reset). Confidence: medium (vendor header for this chip family, not hardware verified).";

        field {
            name = "dither_coef3";
            desc = "[inferred] Dither coef3. (vendor header `product/hiosd/vo/hi3519/vou_reg.h` field `dither_coef3`; access and reset unknown, modelled RW)";
            sw = rw;
            hw = r;
        } dither_coef3[31:24];

        field {
            name = "dither_coef2";
            desc = "[inferred] Dither coef2. (vendor header `product/hiosd/vo/hi3519/vou_reg.h` field `dither_coef2`; access and reset unknown, modelled RW)";
            sw = rw;
            hw = r;
        } dither_coef2[23:16];

        field {
            name = "dither_coef1";
            desc = "[inferred] Dither coef1. (vendor header `product/hiosd/vo/hi3519/vou_reg.h` field `dither_coef1`; access and reset unknown, modelled RW)";
            sw = rw;
            hw = r;
        } dither_coef1[15:8];

        field {
            name = "dither_coef0";
            desc = "[inferred] Dither coef0. (vendor header `product/hiosd/vo/hi3519/vou_reg.h` field `dither_coef0`; access and reset unknown, modelled RW)";
            sw = rw;
            hw = r;
        } dither_coef0[7:0];
    } INTF_DITHER0_COEF0 @ 0xD084;

    reg {
        name = "INTF DITHER0 COEF1";
        desc = "[inferred] INTF DITHER0 COEF1. Not in the data sheet. Source: vendor U-Boot 2010.06 `product/hiosd/vo/hi3519/vou_reg.h` (GPL-2.0 U-Boot tree, HiSilicon copyright, created 2015-05-26; mirror github.com/OpenIPC/u-boot-hi3516cv200), union `U_INTF_DITHER0_COEF1`, struct offset 0xD088 (GPL-2.0, same-chip vendor header, byte-identical for Hi3516A V200 and Hi3519 V101). Reset value and access type unknown (modelled RW, no reset). Confidence: medium (vendor header for this chip family, not hardware verified).";

        field {
            name = "dither_coef7";
            desc = "[inferred] Dither coef7. (vendor header `product/hiosd/vo/hi3519/vou_reg.h` field `dither_coef7`; access and reset unknown, modelled RW)";
            sw = rw;
            hw = r;
        } dither_coef7[31:24];

        field {
            name = "dither_coef6";
            desc = "[inferred] Dither coef6. (vendor header `product/hiosd/vo/hi3519/vou_reg.h` field `dither_coef6`; access and reset unknown, modelled RW)";
            sw = rw;
            hw = r;
        } dither_coef6[23:16];

        field {
            name = "dither_coef5";
            desc = "[inferred] Dither coef5. (vendor header `product/hiosd/vo/hi3519/vou_reg.h` field `dither_coef5`; access and reset unknown, modelled RW)";
            sw = rw;
            hw = r;
        } dither_coef5[15:8];

        field {
            name = "dither_coef4";
            desc = "[inferred] Dither coef4. (vendor header `product/hiosd/vo/hi3519/vou_reg.h` field `dither_coef4`; access and reset unknown, modelled RW)";
            sw = rw;
            hw = r;
        } dither_coef4[7:0];
    } INTF_DITHER0_COEF1 @ 0xD088;

    reg {
        name = "INTF CHKSUM Y";
        desc = "[inferred] INTF CHKSUM Y. Not in the data sheet. Source: vendor U-Boot 2010.06 `product/hiosd/vo/hi3519/vou_reg.h` (GPL-2.0 U-Boot tree, HiSilicon copyright, created 2015-05-26; mirror github.com/OpenIPC/u-boot-hi3516cv200), union `U_INTF_CHKSUM_Y`, struct offset 0xD0F0 (GPL-2.0, same-chip vendor header, byte-identical for Hi3516A V200 and Hi3519 V101). Reset value and access type unknown (modelled RW, no reset). Confidence: medium (vendor header for this chip family, not hardware verified).";

        field {
            name = "check_sum";
            desc = "[inferred] Check sum. (vendor header `product/hiosd/vo/hi3519/vou_reg.h` field `check_sum`; access and reset unknown, modelled RW)";
            sw = rw;
            hw = r;
        } check_sum[31:0];
    } INTF_CHKSUM_Y @ 0xD0F0;

    reg {
        name = "INTF CHKSUM U";
        desc = "[inferred] INTF CHKSUM U. Not in the data sheet. Source: vendor U-Boot 2010.06 `product/hiosd/vo/hi3519/vou_reg.h` (GPL-2.0 U-Boot tree, HiSilicon copyright, created 2015-05-26; mirror github.com/OpenIPC/u-boot-hi3516cv200), union `U_INTF_CHKSUM_U`, struct offset 0xD0F4 (GPL-2.0, same-chip vendor header, byte-identical for Hi3516A V200 and Hi3519 V101). Reset value and access type unknown (modelled RW, no reset). Confidence: medium (vendor header for this chip family, not hardware verified).";

        field {
            name = "check_sum";
            desc = "[inferred] Check sum. (vendor header `product/hiosd/vo/hi3519/vou_reg.h` field `check_sum`; access and reset unknown, modelled RW)";
            sw = rw;
            hw = r;
        } check_sum[31:0];
    } INTF_CHKSUM_U @ 0xD0F4;

    reg {
        name = "INTF CHKSUM V";
        desc = "[inferred] INTF CHKSUM V. Not in the data sheet. Source: vendor U-Boot 2010.06 `product/hiosd/vo/hi3519/vou_reg.h` (GPL-2.0 U-Boot tree, HiSilicon copyright, created 2015-05-26; mirror github.com/OpenIPC/u-boot-hi3516cv200), union `U_INTF_CHKSUM_V`, struct offset 0xD0F8 (GPL-2.0, same-chip vendor header, byte-identical for Hi3516A V200 and Hi3519 V101). Reset value and access type unknown (modelled RW, no reset). Confidence: medium (vendor header for this chip family, not hardware verified).";

        field {
            name = "check_sum";
            desc = "[inferred] Check sum. (vendor header `product/hiosd/vo/hi3519/vou_reg.h` field `check_sum`; access and reset unknown, modelled RW)";
            sw = rw;
            hw = r;
        } check_sum[31:0];
    } INTF_CHKSUM_V @ 0xD0F8;

    reg {
        name = "BT.656/BT.1120 control register";
        desc = "BT_CTRL is a BT.656/BT.1120 control register. Hi3516A V200 Professional HD IP Camera SoC

Data sheet 9.2.6 BT_CTRL (offset 0xD200, printed page 9-133, `hi3516av200--Hi3516AV200-Datasheet.txt` line 44944).";

        enum BT_CTRL_bt1120_bypass_enum {
            DISABLED = 0 { name = "Disabled"; desc = "disabled"; };
            ENABLED = 1 { name = "Enabled"; desc = "enabled"; };
        };

        field {
            name = "bt1120_bypass";
            desc = "BT.1120 bypass mode";
            sw = rw;
            hw = r;
            encode = BT_CTRL_bt1120_bypass_enum;
            reset = 0x0;
        } bt1120_bypass[30:30];

        enum BT_CTRL_yc_mode_enum {
            Y_UPPER_BITS = 0 { name = "Y Upper Bits"; desc = "Y for upper bits and C for lower bits"; };
            Y_LOWER_BITS = 1 { name = "Y Lower Bits"; desc = "Y for lower bits and C for upper bits"; };
        };

        field {
            name = "yc_mode";
            desc = "BT.1120 Y/C exchange";
            sw = rw;
            hw = r;
            encode = BT_CTRL_yc_mode_enum;
            reset = 0x0;
        } yc_mode[24:24];
    } BT_CTRL @ 0xD200;

    reg {
        name = "BT.656/BT.1120 clip lowest threshold register";
        desc = "BT_CLIP0_L is a BT.656/BT.1120 clip lowest threshold register (instant register).

Data sheet 9.2.6 BT_CLIP0_L (offset 0xD210, printed page 9-133, `hi3516av200--Hi3516AV200-Datasheet.txt` line 44979).";

        field {
            name = "clip_cl2";
            desc = "Lowest threshold Y/R of component 2, unsigned integer";
            sw = rw;
            hw = r;
            reset = 0x10;
        } clip_cl2[29:20];

        field {
            name = "clip_cl1";
            desc = "Lowest threshold Cb/G of component 1, unsigned integer";
            sw = rw;
            hw = r;
            reset = 0x10;
        } clip_cl1[19:10];

        field {
            name = "clip_cl0";
            desc = "Lowest threshold Cr/B of component 0, unsigned integer";
            sw = rw;
            hw = r;
            reset = 0x10;
        } clip_cl0[9:0];
    } BT_CLIP0_L @ 0xD210;

    reg {
        name = "BT.656/BT.1120 clip highest threshold register";
        desc = "BT_CLIP0_H is a BT.656/BT.1120 clip highest threshold register (instant register). For example, the output data needs to be clipped in BT.656 output mode.

Data sheet 9.2.6 BT_CLIP0_H (offset 0xD214, printed page 9-134, `hi3516av200--Hi3516AV200-Datasheet.txt` line 45016).";

        field {
            name = "clip_ch2";
            desc = "Highest threshold Y/R of component 2, unsigned integer";
            sw = rw;
            hw = r;
            reset = 0xEB;
        } clip_ch2[29:20];

        field {
            name = "clip_ch1";
            desc = "Highest threshold Cb/G of component 1, unsigned integer";
            sw = rw;
            hw = r;
            reset = 0xF0;
        } clip_ch1[19:10];

        field {
            name = "clip_ch0";
            desc = "Highest threshold Cr/B of component 0, unsigned integer";
            sw = rw;
            hw = r;
            reset = 0xF0;
        } clip_ch0[9:0];
    } BT_CLIP0_H @ 0xD214;

    reg {
        name = "BT.656/BT.1120 dither control register _CTRL";
        desc = "BT_DITHER0_CTRL is a BT.656/BT.1120 dither control register. Hi3516A V200 Professional HD IP Camera SoC

Data sheet 9.2.6 BT_DITHER0_CTRL (offset 0xD280, printed page 9-135, `hi3516av200--Hi3516AV200-Datasheet.txt` line 45049).";

        enum BT_DITHER0_CTRL_dither_md_enum {
            V_12_BIT_INPUTS = 0 { name = "V 12 Bit Inputs"; desc = "12-bit inputs, 10-bit outputs, no dithering, and direct bit truncation"; };
            V_12_BIT_INPUTS_2 = 1 { name = "V 12 Bit Inputs 2"; desc = "12-bit inputs, 10-bit outputs, and time-domain dithering"; };
            V_12_BIT_INPUTS_3 = 2 { name = "V 12 Bit Inputs 3"; desc = "12-bit inputs, 10-bit outputs, and spatial-domain dithering"; };
            V_12_BIT_INPUTS_4 = 3 { name = "V 12 Bit Inputs 4"; desc = "12-bit inputs, 8-bit outputs, and time-domain and spatial- domain dithering"; };
            V_12_BIT_INPUTS_5 = 4 { name = "V 12 Bit Inputs 5"; desc = "12-bit inputs, 10-bit outputs, and round off"; };
            V_12_BIT_INPUTS_6 = 5 { name = "V 12 Bit Inputs 6"; desc = "12-bit inputs, 8-bit outputs, and round off Other values: reserved"; };
        };

        field {
            name = "dither_md";
            desc = "Dither mode select";
            sw = rw;
            hw = r;
            encode = BT_DITHER0_CTRL_dither_md_enum;
            reset = 0x1;
        } dither_md[31:29];
    } BT_DITHER0_CTRL @ 0xD280;

    reg {
        name = "BT.656/BT.1120 dither coefficient 0 _COEF0 register";
        desc = "BT_DITHER0_COEF0 is a BT.656/BT.1120 dither coefficient 0 register.

Data sheet 9.2.6 BT_DITHER0_COEF0 (offset 0xD284, printed page 9-135, `hi3516av200--Hi3516AV200-Datasheet.txt` line 45084).";

        field {
            name = "dither_coef3";
            desc = "Coefficient 3 for time-domain dithering";
            sw = rw;
            hw = r;
            reset = 0xDD;
        } dither_coef3[31:24];

        field {
            name = "dither_coef2";
            desc = "Coefficient 2 for time-domain dithering";
            sw = rw;
            hw = r;
            reset = 0x66;
        } dither_coef2[23:16];

        field {
            name = "dither_coef1";
            desc = "Coefficient 1 for time-domain dithering";
            sw = rw;
            hw = r;
            reset = 0x44;
        } dither_coef1[15:8];

        field {
            name = "dither_coef0";
            desc = "Coefficient 0 for time-domain dithering";
            sw = rw;
            hw = r;
            reset = 0x0;
        } dither_coef0[7:0];
    } BT_DITHER0_COEF0 @ 0xD284;

    reg {
        name = "BT.656/BT.1120 dither coefficient 1 _COEF1 register";
        desc = "BT_DITHER0_COEF1 is a BT.656/BT.1120 dither coefficient 1 register.

Data sheet 9.2.6 BT_DITHER0_COEF1 (offset 0xD288, printed page 9-136, `hi3516av200--Hi3516AV200-Datasheet.txt` line 45112).";

        field {
            name = "dither_coef7";
            desc = "Coefficient 7 for time-domain dithering";
            sw = rw;
            hw = r;
            reset = 0xDD;
        } dither_coef7[31:24];

        field {
            name = "dither_coef6";
            desc = "Coefficient 6 for time-domain dithering";
            sw = rw;
            hw = r;
            reset = 0x66;
        } dither_coef6[23:16];

        field {
            name = "dither_coef5";
            desc = "Coefficient 5 for time-domain dithering";
            sw = rw;
            hw = r;
            reset = 0x44;
        } dither_coef5[15:8];

        field {
            name = "dither_coef4";
            desc = "Coefficient 4 for time-domain dithering";
            sw = rw;
            hw = r;
            reset = 0x0;
        } dither_coef4[7:0];
    } BT_DITHER0_COEF1 @ 0xD288;

    reg {
        name = "LCD control register";
        desc = "LCD_CTRL is an LCD control register.

Data sheet 9.2.6 LCD_CTRL (offset 0xD400, printed page 9-136, `hi3516av200--Hi3516AV200-Datasheet.txt` line 45134).";

        enum LCD_CTRL_lcd_serial_mode_enum {
            PARALLEL_MODE = 0 { name = "Parallel Mode"; desc = "parallel mode"; };
            SERIAL_MODE = 1 { name = "Serial Mode"; desc = "serial mode"; };
        };

        field {
            name = "lcd_serial_mode";
            desc = "LCD mode";
            sw = rw;
            hw = r;
            encode = LCD_CTRL_lcd_serial_mode_enum;
            reset = 0x0;
        } lcd_serial_mode[29:29];

        enum LCD_CTRL_lcd_serial_perd_enum {
            V_3 = 0 { name = "V 3"; desc = "3"; };
            V_4 = 1 { name = "V 4"; desc = "4"; };
        };

        field {
            name = "lcd_serial_perd";
            desc = "Number of output single-pixel clock cycles in serial LCD mode";
            sw = rw;
            hw = r;
            encode = LCD_CTRL_lcd_serial_perd_enum;
            reset = 0x0;
        } lcd_serial_perd[28:28];

        enum LCD_CTRL_lcd_parallel_order_enum {
            RGB = 0 { name = "Rgb"; desc = "RGB"; };
            BGR = 1 { name = "Bgr"; desc = "BGR"; };
        };

        field {
            name = "lcd_parallel_order";
            desc = "LCD parallel output sequence";
            sw = rw;
            hw = r;
            encode = LCD_CTRL_lcd_parallel_order_enum;
            reset = 0x0;
        } lcd_parallel_order[27:27];

        enum LCD_CTRL_lcd_data_inv_enum {
            BITS_15_0 = 0 { name = "Bits 15 0"; desc = "Bits 15-0 or bits 23-0 are from upper bits to lower bits."; };
            BITS_0_15 = 1 { name = "Bits 0 15"; desc = "Bits 0-15 or bits 0-23 are from upper bits to lower bits."; };
        };

        field {
            name = "lcd_data_inv";
            desc = "Inversion of the LCD output bits";
            sw = rw;
            hw = r;
            encode = LCD_CTRL_lcd_data_inv_enum;
            reset = 0x0;
        } lcd_data_inv[26:26];

        enum LCD_CTRL_lcd_parallel_mode_enum {
            RGB565 = 0 { name = "Rgb565"; desc = "RGB565"; };
            RGB888 = 1 { name = "Rgb888"; desc = "RGB888"; };
        };

        field {
            name = "lcd_parallel_mode";
            desc = "Bit width mode of the LCD parallel output";
            sw = rw;
            hw = r;
            encode = LCD_CTRL_lcd_parallel_mode_enum;
            reset = 0x0;
        } lcd_parallel_mode[25:25];
    } LCD_CTRL @ 0xD400;

    reg {
        name = "Sync signal polarity configuration register NV in LCD external sync timing input mode";
        desc = "LCD_SYNC_INV is a sync signal polarity configuration register in LCD external sync timing input mode. The setting of this register takes effect immediately after configuration, that is, the polarity of the corresponding sync signal is immediately affected.

Data sheet 9.2.6 LCD_SYNC_INV (offset 0xD408, printed page 9-137, `hi3516av200--Hi3516AV200-Datasheet.txt` line 45191).";

        enum LCD_SYNC_INV_f_inv_enum {
            DISABLED = 0 { name = "Disabled"; desc = "disabled"; };
            ENABLED = 1 { name = "Enabled"; desc = "enabled"; };
        };

        field {
            name = "f_inv";
            desc = "Output phase inversion enable for the odd/even field indicator signal (instant)";
            sw = rw;
            hw = r;
            encode = LCD_SYNC_INV_f_inv_enum;
            reset = 0x0;
        } f_inv[3:3];

        enum LCD_SYNC_INV_vs_inv_enum {
            DISABLED = 0 { name = "Disabled"; desc = "disabled"; };
            ENABLED = 1 { name = "Enabled"; desc = "enabled"; };
        };

        field {
            name = "vs_inv";
            desc = "Output phase inversion enable for the VS pulse (instant)";
            sw = rw;
            hw = r;
            encode = LCD_SYNC_INV_vs_inv_enum;
            reset = 0x0;
        } vs_inv[2:2];

        enum LCD_SYNC_INV_hs_inv_enum {
            DISABLED = 0 { name = "Disabled"; desc = "disabled"; };
            ENABLED = 1 { name = "Enabled"; desc = "enabled"; };
        };

        field {
            name = "hs_inv";
            desc = "Output phase inversion enable for the HS pulse (instant)";
            sw = rw;
            hw = r;
            encode = LCD_SYNC_INV_hs_inv_enum;
            reset = 0x0;
        } hs_inv[1:1];

        enum LCD_SYNC_INV_dv_inv_enum {
            DISABLED = 0 { name = "Disabled"; desc = "disabled"; };
            ENABLED = 1 { name = "Enabled"; desc = "enabled"; };
        };

        field {
            name = "dv_inv";
            desc = "Output phase inversion enable for the data validity signal (instant)";
            sw = rw;
            hw = r;
            encode = LCD_SYNC_INV_dv_inv_enum;
            reset = 0x0;
        } dv_inv[0:0];
    } LCD_SYNC_INV @ 0xD408;

    reg {
        name = "HDATE VERSION";
        desc = "[inferred] HDATE VERSION. Not in the data sheet. Source: vendor U-Boot 2010.06 `product/hiosd/vo/hi3519/vou_reg.h` (GPL-2.0 U-Boot tree, HiSilicon copyright, created 2015-05-26; mirror github.com/OpenIPC/u-boot-hi3516cv200), union `U_HDATE_VERSION`, struct offset 0xF000 (GPL-2.0, same-chip vendor header, byte-identical for Hi3516A V200 and Hi3519 V101). Reset value and access type unknown (modelled RW, no reset). Confidence: medium (vendor header for this chip family, not hardware verified).";

        field {
            name = "hdate_version";
            desc = "[inferred] Hdate version. (vendor header `product/hiosd/vo/hi3519/vou_reg.h` field `hdate_version`; access and reset unknown, modelled RW)";
            sw = rw;
            hw = r;
        } hdate_version[31:0];
    } HDATE_VERSION @ 0xF000;

    reg {
        name = "HDATE enable";
        desc = "[inferred] HDATE enable. Not in the data sheet. Source: vendor U-Boot 2010.06 `product/hiosd/vo/hi3519/vou_reg.h` (GPL-2.0 U-Boot tree, HiSilicon copyright, created 2015-05-26; mirror github.com/OpenIPC/u-boot-hi3516cv200), union `U_HDATE_EN`, struct offset 0xF004 (GPL-2.0, same-chip vendor header, byte-identical for Hi3516A V200 and Hi3519 V101). Reset value and access type unknown (modelled RW, no reset). Confidence: medium (vendor header for this chip family, not hardware verified).";

        field {
            name = "hd_en";
            desc = "[inferred] Hd enable. (vendor header `product/hiosd/vo/hi3519/vou_reg.h` field `hd_en`; access and reset unknown, modelled RW)";
            sw = rw;
            hw = r;
        } hd_en[0:0];
    } HDATE_EN @ 0xF004;

    reg {
        name = "HDATE POLA control";
        desc = "[inferred] HDATE POLA control. Not in the data sheet. Source: vendor U-Boot 2010.06 `product/hiosd/vo/hi3519/vou_reg.h` (GPL-2.0 U-Boot tree, HiSilicon copyright, created 2015-05-26; mirror github.com/OpenIPC/u-boot-hi3516cv200), union `U_HDATE_POLA_CTRL`, struct offset 0xF008 (GPL-2.0, same-chip vendor header, byte-identical for Hi3516A V200 and Hi3519 V101). Reset value and access type unknown (modelled RW, no reset). Confidence: medium (vendor header for this chip family, not hardware verified).";

        field {
            name = "fid_out_pola";
            desc = "[inferred] Fid out pola. (vendor header `product/hiosd/vo/hi3519/vou_reg.h` field `fid_out_pola`; access and reset unknown, modelled RW)";
            sw = rw;
            hw = r;
        } fid_out_pola[5:5];

        field {
            name = "vsync_out_pola";
            desc = "[inferred] Vertical sync out pola. (vendor header `product/hiosd/vo/hi3519/vou_reg.h` field `vsync_out_pola`; access and reset unknown, modelled RW)";
            sw = rw;
            hw = r;
        } vsync_out_pola[4:4];

        field {
            name = "hsync_out_pola";
            desc = "[inferred] Horizontal sync out pola. (vendor header `product/hiosd/vo/hi3519/vou_reg.h` field `hsync_out_pola`; access and reset unknown, modelled RW)";
            sw = rw;
            hw = r;
        } hsync_out_pola[3:3];

        field {
            name = "fid_in_pola";
            desc = "[inferred] Fid in pola. (vendor header `product/hiosd/vo/hi3519/vou_reg.h` field `fid_in_pola`; access and reset unknown, modelled RW)";
            sw = rw;
            hw = r;
        } fid_in_pola[2:2];

        field {
            name = "vsync_in_pola";
            desc = "[inferred] Vertical sync in pola. (vendor header `product/hiosd/vo/hi3519/vou_reg.h` field `vsync_in_pola`; access and reset unknown, modelled RW)";
            sw = rw;
            hw = r;
        } vsync_in_pola[1:1];

        field {
            name = "hsync_in_pola";
            desc = "[inferred] Horizontal sync in pola. (vendor header `product/hiosd/vo/hi3519/vou_reg.h` field `hsync_in_pola`; access and reset unknown, modelled RW)";
            sw = rw;
            hw = r;
        } hsync_in_pola[0:0];
    } HDATE_POLA_CTRL @ 0xF008;

    reg {
        name = "HDATE VIDEO FORMAT";
        desc = "[inferred] HDATE VIDEO FORMAT. Not in the data sheet. Source: vendor U-Boot 2010.06 `product/hiosd/vo/hi3519/vou_reg.h` (GPL-2.0 U-Boot tree, HiSilicon copyright, created 2015-05-26; mirror github.com/OpenIPC/u-boot-hi3516cv200), union `U_HDATE_VIDEO_FORMAT`, struct offset 0xF00C (GPL-2.0, same-chip vendor header, byte-identical for Hi3516A V200 and Hi3519 V101). Reset value and access type unknown (modelled RW, no reset). Confidence: medium (vendor header for this chip family, not hardware verified).";

        field {
            name = "csc_round_disable";
            desc = "[inferred] Colour-space conversion round disable. (vendor header `product/hiosd/vo/hi3519/vou_reg.h` field `csc_round_disable`; access and reset unknown, modelled RW)";
            sw = rw;
            hw = r;
        } csc_round_disable[12:12];

        field {
            name = "csc_ctrl";
            desc = "[inferred] Colour-space conversion control. (vendor header `product/hiosd/vo/hi3519/vou_reg.h` field `csc_ctrl`; access and reset unknown, modelled RW)";
            sw = rw;
            hw = r;
        } csc_ctrl[11:9];

        field {
            name = "video_out_ctrl";
            desc = "[inferred] Video out control. (vendor header `product/hiosd/vo/hi3519/vou_reg.h` field `video_out_ctrl`; access and reset unknown, modelled RW)";
            sw = rw;
            hw = r;
        } video_out_ctrl[8:7];

        field {
            name = "sync_add_ctrl";
            desc = "[inferred] Sync add control. (vendor header `product/hiosd/vo/hi3519/vou_reg.h` field `sync_add_ctrl`; access and reset unknown, modelled RW)";
            sw = rw;
            hw = r;
        } sync_add_ctrl[6:4];

        field {
            name = "video_ft";
            desc = "[inferred] Video ft. (vendor header `product/hiosd/vo/hi3519/vou_reg.h` field `video_ft`; access and reset unknown, modelled RW)";
            sw = rw;
            hw = r;
        } video_ft[3:0];
    } HDATE_VIDEO_FORMAT @ 0xF00C;

    reg {
        name = "HDATE STATE";
        desc = "[inferred] HDATE STATE. Not in the data sheet. Source: vendor U-Boot 2010.06 `product/hiosd/vo/hi3519/vou_reg.h` (GPL-2.0 U-Boot tree, HiSilicon copyright, created 2015-05-26; mirror github.com/OpenIPC/u-boot-hi3516cv200), union `U_HDATE_STATE`, struct offset 0xF010 (GPL-2.0, same-chip vendor header, byte-identical for Hi3516A V200 and Hi3519 V101). Reset value and access type unknown (modelled RW, no reset). Confidence: medium (vendor header for this chip family, not hardware verified).";

        field {
            name = "mv_en_pin";
            desc = "[inferred] Mv enable pin. (vendor header `product/hiosd/vo/hi3519/vou_reg.h` field `mv_en_pin`; access and reset unknown, modelled RW)";
            sw = rw;
            hw = r;
        } mv_en_pin[28:28];

        field {
            name = "frame_len";
            desc = "[inferred] Frame length. (vendor header `product/hiosd/vo/hi3519/vou_reg.h` field `frame_len`; access and reset unknown, modelled RW)";
            sw = rw;
            hw = r;
        } frame_len[26:16];

        field {
            name = "line_len";
            desc = "[inferred] Line length. (vendor header `product/hiosd/vo/hi3519/vou_reg.h` field `line_len`; access and reset unknown, modelled RW)";
            sw = rw;
            hw = r;
        } line_len[12:0];
    } HDATE_STATE @ 0xF010;

    reg {
        name = "HDATE OUT control";
        desc = "[inferred] HDATE OUT control. Not in the data sheet. Source: vendor U-Boot 2010.06 `product/hiosd/vo/hi3519/vou_reg.h` (GPL-2.0 U-Boot tree, HiSilicon copyright, created 2015-05-26; mirror github.com/OpenIPC/u-boot-hi3516cv200), union `U_HDATE_OUT_CTRL`, struct offset 0xF014 (GPL-2.0, same-chip vendor header, byte-identical for Hi3516A V200 and Hi3519 V101). Reset value and access type unknown (modelled RW, no reset). Confidence: medium (vendor header for this chip family, not hardware verified).";

        field {
            name = "src_round_disable";
            desc = "[inferred] Source round disable. (vendor header `product/hiosd/vo/hi3519/vou_reg.h` field `src_round_disable`; access and reset unknown, modelled RW)";
            sw = rw;
            hw = r;
        } src_round_disable[14:14];

        field {
            name = "sd_sel";
            desc = "[inferred] Sd select. (vendor header `product/hiosd/vo/hi3519/vou_reg.h` field `sd_sel`; access and reset unknown, modelled RW)";
            sw = rw;
            hw = r;
        } sd_sel[13:13];

        field {
            name = "sync_lpf_en";
            desc = "[inferred] Sync lpf enable. (vendor header `product/hiosd/vo/hi3519/vou_reg.h` field `sync_lpf_en`; access and reset unknown, modelled RW)";
            sw = rw;
            hw = r;
        } sync_lpf_en[12:12];

        field {
            name = "src_ctrl";
            desc = "[inferred] Source control. (vendor header `product/hiosd/vo/hi3519/vou_reg.h` field `src_ctrl`; access and reset unknown, modelled RW)";
            sw = rw;
            hw = r;
        } src_ctrl[11:10];

        field {
            name = "video1_sel";
            desc = "[inferred] Video1 select. (vendor header `product/hiosd/vo/hi3519/vou_reg.h` field `video1_sel`; access and reset unknown, modelled RW)";
            sw = rw;
            hw = r;
        } video1_sel[9:8];

        field {
            name = "video2_sel";
            desc = "[inferred] Video2 select. (vendor header `product/hiosd/vo/hi3519/vou_reg.h` field `video2_sel`; access and reset unknown, modelled RW)";
            sw = rw;
            hw = r;
        } video2_sel[7:6];

        field {
            name = "video3_sel";
            desc = "[inferred] Video3 select. (vendor header `product/hiosd/vo/hi3519/vou_reg.h` field `video3_sel`; access and reset unknown, modelled RW)";
            sw = rw;
            hw = r;
        } video3_sel[5:4];

        field {
            name = "hsync_sel";
            desc = "[inferred] Horizontal sync select. (vendor header `product/hiosd/vo/hi3519/vou_reg.h` field `hsync_sel`; access and reset unknown, modelled RW)";
            sw = rw;
            hw = r;
        } hsync_sel[3:2];

        field {
            name = "vsync_sel";
            desc = "[inferred] Vertical sync select. (vendor header `product/hiosd/vo/hi3519/vou_reg.h` field `vsync_sel`; access and reset unknown, modelled RW)";
            sw = rw;
            hw = r;
        } vsync_sel[1:0];
    } HDATE_OUT_CTRL @ 0xF014;

    reg {
        name = "HDATE source 13 COEF1";
        desc = "[inferred] HDATE source 13 COEF1. Not in the data sheet. Source: vendor U-Boot 2010.06 `product/hiosd/vo/hi3519/vou_reg.h` (GPL-2.0 U-Boot tree, HiSilicon copyright, created 2015-05-26; mirror github.com/OpenIPC/u-boot-hi3516cv200), union `U_HDATE_SRC_13_COEF1`, struct offset 0xF018 (GPL-2.0, same-chip vendor header, byte-identical for Hi3516A V200 and Hi3519 V101). Reset value and access type unknown (modelled RW, no reset). Confidence: medium (vendor header for this chip family, not hardware verified).";

        field {
            name = "coef_tap1_3";
            desc = "[inferred] Coefficient tap1 3. (vendor header `product/hiosd/vo/hi3519/vou_reg.h` field `coef_tap1_3`; access and reset unknown, modelled RW)";
            sw = rw;
            hw = r;
        } coef_tap1_3[26:16];

        field {
            name = "coef_tap1_1";
            desc = "[inferred] Coefficient tap1 1. (vendor header `product/hiosd/vo/hi3519/vou_reg.h` field `coef_tap1_1`; access and reset unknown, modelled RW)";
            sw = rw;
            hw = r;
        } coef_tap1_1[10:0];
    } HDATE_SRC_13_COEF1 @ 0xF018;

    reg {
        name = "HDATE source 13 COEF2";
        desc = "[inferred] HDATE source 13 COEF2. Not in the data sheet. Source: vendor U-Boot 2010.06 `product/hiosd/vo/hi3519/vou_reg.h` (GPL-2.0 U-Boot tree, HiSilicon copyright, created 2015-05-26; mirror github.com/OpenIPC/u-boot-hi3516cv200), union `U_HDATE_SRC_13_COEF2`, struct offset 0xF01C (GPL-2.0, same-chip vendor header, byte-identical for Hi3516A V200 and Hi3519 V101). Reset value and access type unknown (modelled RW, no reset). Confidence: medium (vendor header for this chip family, not hardware verified).";

        field {
            name = "coef_tap2_3";
            desc = "[inferred] Coefficient tap2 3. (vendor header `product/hiosd/vo/hi3519/vou_reg.h` field `coef_tap2_3`; access and reset unknown, modelled RW)";
            sw = rw;
            hw = r;
        } coef_tap2_3[26:16];

        field {
            name = "coef_tap2_1";
            desc = "[inferred] Coefficient tap2 1. (vendor header `product/hiosd/vo/hi3519/vou_reg.h` field `coef_tap2_1`; access and reset unknown, modelled RW)";
            sw = rw;
            hw = r;
        } coef_tap2_1[10:0];
    } HDATE_SRC_13_COEF2 @ 0xF01C;

    reg {
        name = "HDATE source 13 COEF3";
        desc = "[inferred] HDATE source 13 COEF3. Not in the data sheet. Source: vendor U-Boot 2010.06 `product/hiosd/vo/hi3519/vou_reg.h` (GPL-2.0 U-Boot tree, HiSilicon copyright, created 2015-05-26; mirror github.com/OpenIPC/u-boot-hi3516cv200), union `U_HDATE_SRC_13_COEF3`, struct offset 0xF020 (GPL-2.0, same-chip vendor header, byte-identical for Hi3516A V200 and Hi3519 V101). Reset value and access type unknown (modelled RW, no reset). Confidence: medium (vendor header for this chip family, not hardware verified).";

        field {
            name = "coef_tap3_3";
            desc = "[inferred] Coefficient tap3 3. (vendor header `product/hiosd/vo/hi3519/vou_reg.h` field `coef_tap3_3`; access and reset unknown, modelled RW)";
            sw = rw;
            hw = r;
        } coef_tap3_3[26:16];

        field {
            name = "coef_tap3_1";
            desc = "[inferred] Coefficient tap3 1. (vendor header `product/hiosd/vo/hi3519/vou_reg.h` field `coef_tap3_1`; access and reset unknown, modelled RW)";
            sw = rw;
            hw = r;
        } coef_tap3_1[10:0];
    } HDATE_SRC_13_COEF3 @ 0xF020;

    reg {
        name = "HDATE source 13 COEF4";
        desc = "[inferred] HDATE source 13 COEF4. Not in the data sheet. Source: vendor U-Boot 2010.06 `product/hiosd/vo/hi3519/vou_reg.h` (GPL-2.0 U-Boot tree, HiSilicon copyright, created 2015-05-26; mirror github.com/OpenIPC/u-boot-hi3516cv200), union `U_HDATE_SRC_13_COEF4`, struct offset 0xF024 (GPL-2.0, same-chip vendor header, byte-identical for Hi3516A V200 and Hi3519 V101). Reset value and access type unknown (modelled RW, no reset). Confidence: medium (vendor header for this chip family, not hardware verified).";

        field {
            name = "coef_tap4_3";
            desc = "[inferred] Coefficient tap4 3. (vendor header `product/hiosd/vo/hi3519/vou_reg.h` field `coef_tap4_3`; access and reset unknown, modelled RW)";
            sw = rw;
            hw = r;
        } coef_tap4_3[26:16];

        field {
            name = "coef_tap4_1";
            desc = "[inferred] Coefficient tap4 1. (vendor header `product/hiosd/vo/hi3519/vou_reg.h` field `coef_tap4_1`; access and reset unknown, modelled RW)";
            sw = rw;
            hw = r;
        } coef_tap4_1[10:0];
    } HDATE_SRC_13_COEF4 @ 0xF024;

    reg {
        name = "HDATE source 13 COEF5";
        desc = "[inferred] HDATE source 13 COEF5. Not in the data sheet. Source: vendor U-Boot 2010.06 `product/hiosd/vo/hi3519/vou_reg.h` (GPL-2.0 U-Boot tree, HiSilicon copyright, created 2015-05-26; mirror github.com/OpenIPC/u-boot-hi3516cv200), union `U_HDATE_SRC_13_COEF5`, struct offset 0xF028 (GPL-2.0, same-chip vendor header, byte-identical for Hi3516A V200 and Hi3519 V101). Reset value and access type unknown (modelled RW, no reset). Confidence: medium (vendor header for this chip family, not hardware verified).";

        field {
            name = "coef_tap5_3";
            desc = "[inferred] Coefficient tap5 3. (vendor header `product/hiosd/vo/hi3519/vou_reg.h` field `coef_tap5_3`; access and reset unknown, modelled RW)";
            sw = rw;
            hw = r;
        } coef_tap5_3[26:16];

        field {
            name = "coef_tap5_1";
            desc = "[inferred] Coefficient tap5 1. (vendor header `product/hiosd/vo/hi3519/vou_reg.h` field `coef_tap5_1`; access and reset unknown, modelled RW)";
            sw = rw;
            hw = r;
        } coef_tap5_1[10:0];
    } HDATE_SRC_13_COEF5 @ 0xF028;

    reg {
        name = "HDATE source 13 COEF6";
        desc = "[inferred] HDATE source 13 COEF6. Not in the data sheet. Source: vendor U-Boot 2010.06 `product/hiosd/vo/hi3519/vou_reg.h` (GPL-2.0 U-Boot tree, HiSilicon copyright, created 2015-05-26; mirror github.com/OpenIPC/u-boot-hi3516cv200), union `U_HDATE_SRC_13_COEF6`, struct offset 0xF02C (GPL-2.0, same-chip vendor header, byte-identical for Hi3516A V200 and Hi3519 V101). Reset value and access type unknown (modelled RW, no reset). Confidence: medium (vendor header for this chip family, not hardware verified).";

        field {
            name = "coef_tap6_3";
            desc = "[inferred] Coefficient tap6 3. (vendor header `product/hiosd/vo/hi3519/vou_reg.h` field `coef_tap6_3`; access and reset unknown, modelled RW)";
            sw = rw;
            hw = r;
        } coef_tap6_3[26:16];

        field {
            name = "coef_tap6_1";
            desc = "[inferred] Coefficient tap6 1. (vendor header `product/hiosd/vo/hi3519/vou_reg.h` field `coef_tap6_1`; access and reset unknown, modelled RW)";
            sw = rw;
            hw = r;
        } coef_tap6_1[10:0];
    } HDATE_SRC_13_COEF6 @ 0xF02C;

    reg {
        name = "HDATE source 13 COEF7";
        desc = "[inferred] HDATE source 13 COEF7. Not in the data sheet. Source: vendor U-Boot 2010.06 `product/hiosd/vo/hi3519/vou_reg.h` (GPL-2.0 U-Boot tree, HiSilicon copyright, created 2015-05-26; mirror github.com/OpenIPC/u-boot-hi3516cv200), union `U_HDATE_SRC_13_COEF7`, struct offset 0xF030 (GPL-2.0, same-chip vendor header, byte-identical for Hi3516A V200 and Hi3519 V101). Reset value and access type unknown (modelled RW, no reset). Confidence: medium (vendor header for this chip family, not hardware verified).";

        field {
            name = "coef_tap7_3";
            desc = "[inferred] Coefficient tap7 3. (vendor header `product/hiosd/vo/hi3519/vou_reg.h` field `coef_tap7_3`; access and reset unknown, modelled RW)";
            sw = rw;
            hw = r;
        } coef_tap7_3[26:16];

        field {
            name = "coef_tap7_1";
            desc = "[inferred] Coefficient tap7 1. (vendor header `product/hiosd/vo/hi3519/vou_reg.h` field `coef_tap7_1`; access and reset unknown, modelled RW)";
            sw = rw;
            hw = r;
        } coef_tap7_1[10:0];
    } HDATE_SRC_13_COEF7 @ 0xF030;

    reg {
        name = "HDATE source 13 COEF8";
        desc = "[inferred] HDATE source 13 COEF8. Not in the data sheet. Source: vendor U-Boot 2010.06 `product/hiosd/vo/hi3519/vou_reg.h` (GPL-2.0 U-Boot tree, HiSilicon copyright, created 2015-05-26; mirror github.com/OpenIPC/u-boot-hi3516cv200), union `U_HDATE_SRC_13_COEF8`, struct offset 0xF034 (GPL-2.0, same-chip vendor header, byte-identical for Hi3516A V200 and Hi3519 V101). Reset value and access type unknown (modelled RW, no reset). Confidence: medium (vendor header for this chip family, not hardware verified).";

        field {
            name = "coef_tap8_3";
            desc = "[inferred] Coefficient tap8 3. (vendor header `product/hiosd/vo/hi3519/vou_reg.h` field `coef_tap8_3`; access and reset unknown, modelled RW)";
            sw = rw;
            hw = r;
        } coef_tap8_3[26:16];

        field {
            name = "coef_tap8_1";
            desc = "[inferred] Coefficient tap8 1. (vendor header `product/hiosd/vo/hi3519/vou_reg.h` field `coef_tap8_1`; access and reset unknown, modelled RW)";
            sw = rw;
            hw = r;
        } coef_tap8_1[10:0];
    } HDATE_SRC_13_COEF8 @ 0xF034;

    reg {
        name = "HDATE source 13 COEF9";
        desc = "[inferred] HDATE source 13 COEF9. Not in the data sheet. Source: vendor U-Boot 2010.06 `product/hiosd/vo/hi3519/vou_reg.h` (GPL-2.0 U-Boot tree, HiSilicon copyright, created 2015-05-26; mirror github.com/OpenIPC/u-boot-hi3516cv200), union `U_HDATE_SRC_13_COEF9`, struct offset 0xF038 (GPL-2.0, same-chip vendor header, byte-identical for Hi3516A V200 and Hi3519 V101). Reset value and access type unknown (modelled RW, no reset). Confidence: medium (vendor header for this chip family, not hardware verified).";

        field {
            name = "coef_tap9_3";
            desc = "[inferred] Coefficient tap9 3. (vendor header `product/hiosd/vo/hi3519/vou_reg.h` field `coef_tap9_3`; access and reset unknown, modelled RW)";
            sw = rw;
            hw = r;
        } coef_tap9_3[26:16];

        field {
            name = "coef_tap9_1";
            desc = "[inferred] Coefficient tap9 1. (vendor header `product/hiosd/vo/hi3519/vou_reg.h` field `coef_tap9_1`; access and reset unknown, modelled RW)";
            sw = rw;
            hw = r;
        } coef_tap9_1[10:0];
    } HDATE_SRC_13_COEF9 @ 0xF038;

    reg {
        name = "HDATE source 13 COEF10";
        desc = "[inferred] HDATE source 13 COEF10. Not in the data sheet. Source: vendor U-Boot 2010.06 `product/hiosd/vo/hi3519/vou_reg.h` (GPL-2.0 U-Boot tree, HiSilicon copyright, created 2015-05-26; mirror github.com/OpenIPC/u-boot-hi3516cv200), union `U_HDATE_SRC_13_COEF10`, struct offset 0xF03C (GPL-2.0, same-chip vendor header, byte-identical for Hi3516A V200 and Hi3519 V101). Reset value and access type unknown (modelled RW, no reset). Confidence: medium (vendor header for this chip family, not hardware verified).";

        field {
            name = "coef_tap10_3";
            desc = "[inferred] Coefficient tap10 3. (vendor header `product/hiosd/vo/hi3519/vou_reg.h` field `coef_tap10_3`; access and reset unknown, modelled RW)";
            sw = rw;
            hw = r;
        } coef_tap10_3[26:16];

        field {
            name = "coef_tap10_1";
            desc = "[inferred] Coefficient tap10 1. (vendor header `product/hiosd/vo/hi3519/vou_reg.h` field `coef_tap10_1`; access and reset unknown, modelled RW)";
            sw = rw;
            hw = r;
        } coef_tap10_1[10:0];
    } HDATE_SRC_13_COEF10 @ 0xF03C;

    reg {
        name = "HDATE source 13 COEF11";
        desc = "[inferred] HDATE source 13 COEF11. Not in the data sheet. Source: vendor U-Boot 2010.06 `product/hiosd/vo/hi3519/vou_reg.h` (GPL-2.0 U-Boot tree, HiSilicon copyright, created 2015-05-26; mirror github.com/OpenIPC/u-boot-hi3516cv200), union `U_HDATE_SRC_13_COEF11`, struct offset 0xF040 (GPL-2.0, same-chip vendor header, byte-identical for Hi3516A V200 and Hi3519 V101). Reset value and access type unknown (modelled RW, no reset). Confidence: medium (vendor header for this chip family, not hardware verified).";

        field {
            name = "coef_tap11_3";
            desc = "[inferred] Coefficient tap11 3. (vendor header `product/hiosd/vo/hi3519/vou_reg.h` field `coef_tap11_3`; access and reset unknown, modelled RW)";
            sw = rw;
            hw = r;
        } coef_tap11_3[26:16];

        field {
            name = "coef_tap11_1";
            desc = "[inferred] Coefficient tap11 1. (vendor header `product/hiosd/vo/hi3519/vou_reg.h` field `coef_tap11_1`; access and reset unknown, modelled RW)";
            sw = rw;
            hw = r;
        } coef_tap11_1[10:0];
    } HDATE_SRC_13_COEF11 @ 0xF040;

    reg {
        name = "HDATE source 13 COEF12";
        desc = "[inferred] HDATE source 13 COEF12. Not in the data sheet. Source: vendor U-Boot 2010.06 `product/hiosd/vo/hi3519/vou_reg.h` (GPL-2.0 U-Boot tree, HiSilicon copyright, created 2015-05-26; mirror github.com/OpenIPC/u-boot-hi3516cv200), union `U_HDATE_SRC_13_COEF12`, struct offset 0xF044 (GPL-2.0, same-chip vendor header, byte-identical for Hi3516A V200 and Hi3519 V101). Reset value and access type unknown (modelled RW, no reset). Confidence: medium (vendor header for this chip family, not hardware verified).";

        field {
            name = "coef_tap12_3";
            desc = "[inferred] Coefficient tap12 3. (vendor header `product/hiosd/vo/hi3519/vou_reg.h` field `coef_tap12_3`; access and reset unknown, modelled RW)";
            sw = rw;
            hw = r;
        } coef_tap12_3[26:16];

        field {
            name = "coef_tap12_1";
            desc = "[inferred] Coefficient tap12 1. (vendor header `product/hiosd/vo/hi3519/vou_reg.h` field `coef_tap12_1`; access and reset unknown, modelled RW)";
            sw = rw;
            hw = r;
        } coef_tap12_1[10:0];
    } HDATE_SRC_13_COEF12 @ 0xF044;

    reg {
        name = "HDATE source 13 COEF13";
        desc = "[inferred] HDATE source 13 COEF13. Not in the data sheet. Source: vendor U-Boot 2010.06 `product/hiosd/vo/hi3519/vou_reg.h` (GPL-2.0 U-Boot tree, HiSilicon copyright, created 2015-05-26; mirror github.com/OpenIPC/u-boot-hi3516cv200), union `U_HDATE_SRC_13_COEF13`, struct offset 0xF048 (GPL-2.0, same-chip vendor header, byte-identical for Hi3516A V200 and Hi3519 V101). Reset value and access type unknown (modelled RW, no reset). Confidence: medium (vendor header for this chip family, not hardware verified).";

        field {
            name = "coef_tap13_3";
            desc = "[inferred] Coefficient tap13 3. (vendor header `product/hiosd/vo/hi3519/vou_reg.h` field `coef_tap13_3`; access and reset unknown, modelled RW)";
            sw = rw;
            hw = r;
        } coef_tap13_3[26:16];

        field {
            name = "coef_tap13_1";
            desc = "[inferred] Coefficient tap13 1. (vendor header `product/hiosd/vo/hi3519/vou_reg.h` field `coef_tap13_1`; access and reset unknown, modelled RW)";
            sw = rw;
            hw = r;
        } coef_tap13_1[10:0];
    } HDATE_SRC_13_COEF13 @ 0xF048;

    reg {
        name = "HDATE source 24 COEF1";
        desc = "[inferred] HDATE source 24 COEF1. Not in the data sheet. Source: vendor U-Boot 2010.06 `product/hiosd/vo/hi3519/vou_reg.h` (GPL-2.0 U-Boot tree, HiSilicon copyright, created 2015-05-26; mirror github.com/OpenIPC/u-boot-hi3516cv200), union `U_HDATE_SRC_24_COEF1`, struct offset 0xF04C (GPL-2.0, same-chip vendor header, byte-identical for Hi3516A V200 and Hi3519 V101). Reset value and access type unknown (modelled RW, no reset). Confidence: medium (vendor header for this chip family, not hardware verified).";

        field {
            name = "coef_tap1_4";
            desc = "[inferred] Coefficient tap1 4. (vendor header `product/hiosd/vo/hi3519/vou_reg.h` field `coef_tap1_4`; access and reset unknown, modelled RW)";
            sw = rw;
            hw = r;
        } coef_tap1_4[26:16];

        field {
            name = "coef_tap1_2";
            desc = "[inferred] Coefficient tap1 2. (vendor header `product/hiosd/vo/hi3519/vou_reg.h` field `coef_tap1_2`; access and reset unknown, modelled RW)";
            sw = rw;
            hw = r;
        } coef_tap1_2[10:0];
    } HDATE_SRC_24_COEF1 @ 0xF04C;

    reg {
        name = "HDATE source 24 COEF2";
        desc = "[inferred] HDATE source 24 COEF2. Not in the data sheet. Source: vendor U-Boot 2010.06 `product/hiosd/vo/hi3519/vou_reg.h` (GPL-2.0 U-Boot tree, HiSilicon copyright, created 2015-05-26; mirror github.com/OpenIPC/u-boot-hi3516cv200), union `U_HDATE_SRC_24_COEF2`, struct offset 0xF050 (GPL-2.0, same-chip vendor header, byte-identical for Hi3516A V200 and Hi3519 V101). Reset value and access type unknown (modelled RW, no reset). Confidence: medium (vendor header for this chip family, not hardware verified).";

        field {
            name = "coef_tap2_4";
            desc = "[inferred] Coefficient tap2 4. (vendor header `product/hiosd/vo/hi3519/vou_reg.h` field `coef_tap2_4`; access and reset unknown, modelled RW)";
            sw = rw;
            hw = r;
        } coef_tap2_4[26:16];

        field {
            name = "coef_tap2_2";
            desc = "[inferred] Coefficient tap2 2. (vendor header `product/hiosd/vo/hi3519/vou_reg.h` field `coef_tap2_2`; access and reset unknown, modelled RW)";
            sw = rw;
            hw = r;
        } coef_tap2_2[10:0];
    } HDATE_SRC_24_COEF2 @ 0xF050;

    reg {
        name = "HDATE source 24 COEF3";
        desc = "[inferred] HDATE source 24 COEF3. Not in the data sheet. Source: vendor U-Boot 2010.06 `product/hiosd/vo/hi3519/vou_reg.h` (GPL-2.0 U-Boot tree, HiSilicon copyright, created 2015-05-26; mirror github.com/OpenIPC/u-boot-hi3516cv200), union `U_HDATE_SRC_24_COEF3`, struct offset 0xF054 (GPL-2.0, same-chip vendor header, byte-identical for Hi3516A V200 and Hi3519 V101). Reset value and access type unknown (modelled RW, no reset). Confidence: medium (vendor header for this chip family, not hardware verified).";

        field {
            name = "coef_tap3_4";
            desc = "[inferred] Coefficient tap3 4. (vendor header `product/hiosd/vo/hi3519/vou_reg.h` field `coef_tap3_4`; access and reset unknown, modelled RW)";
            sw = rw;
            hw = r;
        } coef_tap3_4[26:16];

        field {
            name = "coef_tap3_2";
            desc = "[inferred] Coefficient tap3 2. (vendor header `product/hiosd/vo/hi3519/vou_reg.h` field `coef_tap3_2`; access and reset unknown, modelled RW)";
            sw = rw;
            hw = r;
        } coef_tap3_2[10:0];
    } HDATE_SRC_24_COEF3 @ 0xF054;

    reg {
        name = "HDATE source 24 COEF4";
        desc = "[inferred] HDATE source 24 COEF4. Not in the data sheet. Source: vendor U-Boot 2010.06 `product/hiosd/vo/hi3519/vou_reg.h` (GPL-2.0 U-Boot tree, HiSilicon copyright, created 2015-05-26; mirror github.com/OpenIPC/u-boot-hi3516cv200), union `U_HDATE_SRC_24_COEF4`, struct offset 0xF058 (GPL-2.0, same-chip vendor header, byte-identical for Hi3516A V200 and Hi3519 V101). Reset value and access type unknown (modelled RW, no reset). Confidence: medium (vendor header for this chip family, not hardware verified).";

        field {
            name = "coef_tap4_4";
            desc = "[inferred] Coefficient tap4 4. (vendor header `product/hiosd/vo/hi3519/vou_reg.h` field `coef_tap4_4`; access and reset unknown, modelled RW)";
            sw = rw;
            hw = r;
        } coef_tap4_4[26:16];

        field {
            name = "coef_tap4_2";
            desc = "[inferred] Coefficient tap4 2. (vendor header `product/hiosd/vo/hi3519/vou_reg.h` field `coef_tap4_2`; access and reset unknown, modelled RW)";
            sw = rw;
            hw = r;
        } coef_tap4_2[10:0];
    } HDATE_SRC_24_COEF4 @ 0xF058;

    reg {
        name = "HDATE source 24 COEF5";
        desc = "[inferred] HDATE source 24 COEF5. Not in the data sheet. Source: vendor U-Boot 2010.06 `product/hiosd/vo/hi3519/vou_reg.h` (GPL-2.0 U-Boot tree, HiSilicon copyright, created 2015-05-26; mirror github.com/OpenIPC/u-boot-hi3516cv200), union `U_HDATE_SRC_24_COEF5`, struct offset 0xF05C (GPL-2.0, same-chip vendor header, byte-identical for Hi3516A V200 and Hi3519 V101). Reset value and access type unknown (modelled RW, no reset). Confidence: medium (vendor header for this chip family, not hardware verified).";

        field {
            name = "coef_tap5_4";
            desc = "[inferred] Coefficient tap5 4. (vendor header `product/hiosd/vo/hi3519/vou_reg.h` field `coef_tap5_4`; access and reset unknown, modelled RW)";
            sw = rw;
            hw = r;
        } coef_tap5_4[26:16];

        field {
            name = "coef_tap5_2";
            desc = "[inferred] Coefficient tap5 2. (vendor header `product/hiosd/vo/hi3519/vou_reg.h` field `coef_tap5_2`; access and reset unknown, modelled RW)";
            sw = rw;
            hw = r;
        } coef_tap5_2[10:0];
    } HDATE_SRC_24_COEF5 @ 0xF05C;

    reg {
        name = "HDATE source 24 COEF6";
        desc = "[inferred] HDATE source 24 COEF6. Not in the data sheet. Source: vendor U-Boot 2010.06 `product/hiosd/vo/hi3519/vou_reg.h` (GPL-2.0 U-Boot tree, HiSilicon copyright, created 2015-05-26; mirror github.com/OpenIPC/u-boot-hi3516cv200), union `U_HDATE_SRC_24_COEF6`, struct offset 0xF060 (GPL-2.0, same-chip vendor header, byte-identical for Hi3516A V200 and Hi3519 V101). Reset value and access type unknown (modelled RW, no reset). Confidence: medium (vendor header for this chip family, not hardware verified).";

        field {
            name = "coef_tap6_4";
            desc = "[inferred] Coefficient tap6 4. (vendor header `product/hiosd/vo/hi3519/vou_reg.h` field `coef_tap6_4`; access and reset unknown, modelled RW)";
            sw = rw;
            hw = r;
        } coef_tap6_4[26:16];

        field {
            name = "coef_tap6_2";
            desc = "[inferred] Coefficient tap6 2. (vendor header `product/hiosd/vo/hi3519/vou_reg.h` field `coef_tap6_2`; access and reset unknown, modelled RW)";
            sw = rw;
            hw = r;
        } coef_tap6_2[10:0];
    } HDATE_SRC_24_COEF6 @ 0xF060;

    reg {
        name = "HDATE source 24 COEF7";
        desc = "[inferred] HDATE source 24 COEF7. Not in the data sheet. Source: vendor U-Boot 2010.06 `product/hiosd/vo/hi3519/vou_reg.h` (GPL-2.0 U-Boot tree, HiSilicon copyright, created 2015-05-26; mirror github.com/OpenIPC/u-boot-hi3516cv200), union `U_HDATE_SRC_24_COEF7`, struct offset 0xF064 (GPL-2.0, same-chip vendor header, byte-identical for Hi3516A V200 and Hi3519 V101). Reset value and access type unknown (modelled RW, no reset). Confidence: medium (vendor header for this chip family, not hardware verified).";

        field {
            name = "coef_tap7_4";
            desc = "[inferred] Coefficient tap7 4. (vendor header `product/hiosd/vo/hi3519/vou_reg.h` field `coef_tap7_4`; access and reset unknown, modelled RW)";
            sw = rw;
            hw = r;
        } coef_tap7_4[26:16];

        field {
            name = "coef_tap7_2";
            desc = "[inferred] Coefficient tap7 2. (vendor header `product/hiosd/vo/hi3519/vou_reg.h` field `coef_tap7_2`; access and reset unknown, modelled RW)";
            sw = rw;
            hw = r;
        } coef_tap7_2[10:0];
    } HDATE_SRC_24_COEF7 @ 0xF064;

    reg {
        name = "HDATE source 24 COEF8";
        desc = "[inferred] HDATE source 24 COEF8. Not in the data sheet. Source: vendor U-Boot 2010.06 `product/hiosd/vo/hi3519/vou_reg.h` (GPL-2.0 U-Boot tree, HiSilicon copyright, created 2015-05-26; mirror github.com/OpenIPC/u-boot-hi3516cv200), union `U_HDATE_SRC_24_COEF8`, struct offset 0xF068 (GPL-2.0, same-chip vendor header, byte-identical for Hi3516A V200 and Hi3519 V101). Reset value and access type unknown (modelled RW, no reset). Confidence: medium (vendor header for this chip family, not hardware verified).";

        field {
            name = "coef_tap8_4";
            desc = "[inferred] Coefficient tap8 4. (vendor header `product/hiosd/vo/hi3519/vou_reg.h` field `coef_tap8_4`; access and reset unknown, modelled RW)";
            sw = rw;
            hw = r;
        } coef_tap8_4[26:16];

        field {
            name = "coef_tap8_2";
            desc = "[inferred] Coefficient tap8 2. (vendor header `product/hiosd/vo/hi3519/vou_reg.h` field `coef_tap8_2`; access and reset unknown, modelled RW)";
            sw = rw;
            hw = r;
        } coef_tap8_2[10:0];
    } HDATE_SRC_24_COEF8 @ 0xF068;

    reg {
        name = "HDATE source 24 COEF9";
        desc = "[inferred] HDATE source 24 COEF9. Not in the data sheet. Source: vendor U-Boot 2010.06 `product/hiosd/vo/hi3519/vou_reg.h` (GPL-2.0 U-Boot tree, HiSilicon copyright, created 2015-05-26; mirror github.com/OpenIPC/u-boot-hi3516cv200), union `U_HDATE_SRC_24_COEF9`, struct offset 0xF06C (GPL-2.0, same-chip vendor header, byte-identical for Hi3516A V200 and Hi3519 V101). Reset value and access type unknown (modelled RW, no reset). Confidence: medium (vendor header for this chip family, not hardware verified).";

        field {
            name = "coef_tap9_4";
            desc = "[inferred] Coefficient tap9 4. (vendor header `product/hiosd/vo/hi3519/vou_reg.h` field `coef_tap9_4`; access and reset unknown, modelled RW)";
            sw = rw;
            hw = r;
        } coef_tap9_4[26:16];

        field {
            name = "coef_tap9_2";
            desc = "[inferred] Coefficient tap9 2. (vendor header `product/hiosd/vo/hi3519/vou_reg.h` field `coef_tap9_2`; access and reset unknown, modelled RW)";
            sw = rw;
            hw = r;
        } coef_tap9_2[10:0];
    } HDATE_SRC_24_COEF9 @ 0xF06C;

    reg {
        name = "HDATE source 24 COEF10";
        desc = "[inferred] HDATE source 24 COEF10. Not in the data sheet. Source: vendor U-Boot 2010.06 `product/hiosd/vo/hi3519/vou_reg.h` (GPL-2.0 U-Boot tree, HiSilicon copyright, created 2015-05-26; mirror github.com/OpenIPC/u-boot-hi3516cv200), union `U_HDATE_SRC_24_COEF10`, struct offset 0xF070 (GPL-2.0, same-chip vendor header, byte-identical for Hi3516A V200 and Hi3519 V101). Reset value and access type unknown (modelled RW, no reset). Confidence: medium (vendor header for this chip family, not hardware verified).";

        field {
            name = "coef_tap10_4";
            desc = "[inferred] Coefficient tap10 4. (vendor header `product/hiosd/vo/hi3519/vou_reg.h` field `coef_tap10_4`; access and reset unknown, modelled RW)";
            sw = rw;
            hw = r;
        } coef_tap10_4[26:16];

        field {
            name = "coef_tap10_2";
            desc = "[inferred] Coefficient tap10 2. (vendor header `product/hiosd/vo/hi3519/vou_reg.h` field `coef_tap10_2`; access and reset unknown, modelled RW)";
            sw = rw;
            hw = r;
        } coef_tap10_2[10:0];
    } HDATE_SRC_24_COEF10 @ 0xF070;

    reg {
        name = "HDATE source 24 COEF11";
        desc = "[inferred] HDATE source 24 COEF11. Not in the data sheet. Source: vendor U-Boot 2010.06 `product/hiosd/vo/hi3519/vou_reg.h` (GPL-2.0 U-Boot tree, HiSilicon copyright, created 2015-05-26; mirror github.com/OpenIPC/u-boot-hi3516cv200), union `U_HDATE_SRC_24_COEF11`, struct offset 0xF074 (GPL-2.0, same-chip vendor header, byte-identical for Hi3516A V200 and Hi3519 V101). Reset value and access type unknown (modelled RW, no reset). Confidence: medium (vendor header for this chip family, not hardware verified).";

        field {
            name = "coef_tap11_4";
            desc = "[inferred] Coefficient tap11 4. (vendor header `product/hiosd/vo/hi3519/vou_reg.h` field `coef_tap11_4`; access and reset unknown, modelled RW)";
            sw = rw;
            hw = r;
        } coef_tap11_4[26:16];

        field {
            name = "coef_tap11_2";
            desc = "[inferred] Coefficient tap11 2. (vendor header `product/hiosd/vo/hi3519/vou_reg.h` field `coef_tap11_2`; access and reset unknown, modelled RW)";
            sw = rw;
            hw = r;
        } coef_tap11_2[10:0];
    } HDATE_SRC_24_COEF11 @ 0xF074;

    reg {
        name = "HDATE source 24 COEF12";
        desc = "[inferred] HDATE source 24 COEF12. Not in the data sheet. Source: vendor U-Boot 2010.06 `product/hiosd/vo/hi3519/vou_reg.h` (GPL-2.0 U-Boot tree, HiSilicon copyright, created 2015-05-26; mirror github.com/OpenIPC/u-boot-hi3516cv200), union `U_HDATE_SRC_24_COEF12`, struct offset 0xF078 (GPL-2.0, same-chip vendor header, byte-identical for Hi3516A V200 and Hi3519 V101). Reset value and access type unknown (modelled RW, no reset). Confidence: medium (vendor header for this chip family, not hardware verified).";

        field {
            name = "coef_tap12_4";
            desc = "[inferred] Coefficient tap12 4. (vendor header `product/hiosd/vo/hi3519/vou_reg.h` field `coef_tap12_4`; access and reset unknown, modelled RW)";
            sw = rw;
            hw = r;
        } coef_tap12_4[26:16];

        field {
            name = "coef_tap12_2";
            desc = "[inferred] Coefficient tap12 2. (vendor header `product/hiosd/vo/hi3519/vou_reg.h` field `coef_tap12_2`; access and reset unknown, modelled RW)";
            sw = rw;
            hw = r;
        } coef_tap12_2[10:0];
    } HDATE_SRC_24_COEF12 @ 0xF078;

    reg {
        name = "HDATE source 24 COEF13";
        desc = "[inferred] HDATE source 24 COEF13. Not in the data sheet. Source: vendor U-Boot 2010.06 `product/hiosd/vo/hi3519/vou_reg.h` (GPL-2.0 U-Boot tree, HiSilicon copyright, created 2015-05-26; mirror github.com/OpenIPC/u-boot-hi3516cv200), union `U_HDATE_SRC_24_COEF13`, struct offset 0xF07C (GPL-2.0, same-chip vendor header, byte-identical for Hi3516A V200 and Hi3519 V101). Reset value and access type unknown (modelled RW, no reset). Confidence: medium (vendor header for this chip family, not hardware verified).";

        field {
            name = "coef_tap13_4";
            desc = "[inferred] Coefficient tap13 4. (vendor header `product/hiosd/vo/hi3519/vou_reg.h` field `coef_tap13_4`; access and reset unknown, modelled RW)";
            sw = rw;
            hw = r;
        } coef_tap13_4[26:16];

        field {
            name = "coef_tap13_2";
            desc = "[inferred] Coefficient tap13 2. (vendor header `product/hiosd/vo/hi3519/vou_reg.h` field `coef_tap13_2`; access and reset unknown, modelled RW)";
            sw = rw;
            hw = r;
        } coef_tap13_2[10:0];
    } HDATE_SRC_24_COEF13 @ 0xF07C;

    reg {
        name = "HDATE colour-space conversion COEF1";
        desc = "[inferred] HDATE colour-space conversion COEF1. Not in the data sheet. Source: vendor U-Boot 2010.06 `product/hiosd/vo/hi3519/vou_reg.h` (GPL-2.0 U-Boot tree, HiSilicon copyright, created 2015-05-26; mirror github.com/OpenIPC/u-boot-hi3516cv200), union `U_HDATE_CSC_COEF1`, struct offset 0xF080 (GPL-2.0, same-chip vendor header, byte-identical for Hi3516A V200 and Hi3519 V101). Reset value and access type unknown (modelled RW, no reset). Confidence: medium (vendor header for this chip family, not hardware verified).";

        field {
            name = "csc_coef_r_cb";
            desc = "[inferred] Colour-space conversion coefficient r cb. (vendor header `product/hiosd/vo/hi3519/vou_reg.h` field `csc_coef_r_cb`; access and reset unknown, modelled RW)";
            sw = rw;
            hw = r;
        } csc_coef_r_cb[27:16];

        field {
            name = "csc_coef_r_y";
            desc = "[inferred] Colour-space conversion coefficient r y. (vendor header `product/hiosd/vo/hi3519/vou_reg.h` field `csc_coef_r_y`; access and reset unknown, modelled RW)";
            sw = rw;
            hw = r;
        } csc_coef_r_y[11:0];
    } HDATE_CSC_COEF1 @ 0xF080;

    reg {
        name = "HDATE colour-space conversion COEF2";
        desc = "[inferred] HDATE colour-space conversion COEF2. Not in the data sheet. Source: vendor U-Boot 2010.06 `product/hiosd/vo/hi3519/vou_reg.h` (GPL-2.0 U-Boot tree, HiSilicon copyright, created 2015-05-26; mirror github.com/OpenIPC/u-boot-hi3516cv200), union `U_HDATE_CSC_COEF2`, struct offset 0xF084 (GPL-2.0, same-chip vendor header, byte-identical for Hi3516A V200 and Hi3519 V101). Reset value and access type unknown (modelled RW, no reset). Confidence: medium (vendor header for this chip family, not hardware verified).";

        field {
            name = "csc_coef_g_y";
            desc = "[inferred] Colour-space conversion coefficient g y. (vendor header `product/hiosd/vo/hi3519/vou_reg.h` field `csc_coef_g_y`; access and reset unknown, modelled RW)";
            sw = rw;
            hw = r;
        } csc_coef_g_y[27:16];

        field {
            name = "csc_coef_r_cr";
            desc = "[inferred] Colour-space conversion coefficient r cr. (vendor header `product/hiosd/vo/hi3519/vou_reg.h` field `csc_coef_r_cr`; access and reset unknown, modelled RW)";
            sw = rw;
            hw = r;
        } csc_coef_r_cr[11:0];
    } HDATE_CSC_COEF2 @ 0xF084;

    reg {
        name = "HDATE colour-space conversion COEF3";
        desc = "[inferred] HDATE colour-space conversion COEF3. Not in the data sheet. Source: vendor U-Boot 2010.06 `product/hiosd/vo/hi3519/vou_reg.h` (GPL-2.0 U-Boot tree, HiSilicon copyright, created 2015-05-26; mirror github.com/OpenIPC/u-boot-hi3516cv200), union `U_HDATE_CSC_COEF3`, struct offset 0xF088 (GPL-2.0, same-chip vendor header, byte-identical for Hi3516A V200 and Hi3519 V101). Reset value and access type unknown (modelled RW, no reset). Confidence: medium (vendor header for this chip family, not hardware verified).";

        field {
            name = "csc_coef_g_cr";
            desc = "[inferred] Colour-space conversion coefficient g cr. (vendor header `product/hiosd/vo/hi3519/vou_reg.h` field `csc_coef_g_cr`; access and reset unknown, modelled RW)";
            sw = rw;
            hw = r;
        } csc_coef_g_cr[27:16];

        field {
            name = "csc_coef_g_cb";
            desc = "[inferred] Colour-space conversion coefficient g cb. (vendor header `product/hiosd/vo/hi3519/vou_reg.h` field `csc_coef_g_cb`; access and reset unknown, modelled RW)";
            sw = rw;
            hw = r;
        } csc_coef_g_cb[11:0];
    } HDATE_CSC_COEF3 @ 0xF088;

    reg {
        name = "HDATE colour-space conversion COEF4";
        desc = "[inferred] HDATE colour-space conversion COEF4. Not in the data sheet. Source: vendor U-Boot 2010.06 `product/hiosd/vo/hi3519/vou_reg.h` (GPL-2.0 U-Boot tree, HiSilicon copyright, created 2015-05-26; mirror github.com/OpenIPC/u-boot-hi3516cv200), union `U_HDATE_CSC_COEF4`, struct offset 0xF08C (GPL-2.0, same-chip vendor header, byte-identical for Hi3516A V200 and Hi3519 V101). Reset value and access type unknown (modelled RW, no reset). Confidence: medium (vendor header for this chip family, not hardware verified).";

        field {
            name = "csc_coef_b_cb";
            desc = "[inferred] Colour-space conversion coefficient b cb. (vendor header `product/hiosd/vo/hi3519/vou_reg.h` field `csc_coef_b_cb`; access and reset unknown, modelled RW)";
            sw = rw;
            hw = r;
        } csc_coef_b_cb[27:16];

        field {
            name = "csc_coef_b_y";
            desc = "[inferred] Colour-space conversion coefficient b y. (vendor header `product/hiosd/vo/hi3519/vou_reg.h` field `csc_coef_b_y`; access and reset unknown, modelled RW)";
            sw = rw;
            hw = r;
        } csc_coef_b_y[11:0];
    } HDATE_CSC_COEF4 @ 0xF08C;

    reg {
        name = "HDATE colour-space conversion COEF5";
        desc = "[inferred] HDATE colour-space conversion COEF5. Not in the data sheet. Source: vendor U-Boot 2010.06 `product/hiosd/vo/hi3519/vou_reg.h` (GPL-2.0 U-Boot tree, HiSilicon copyright, created 2015-05-26; mirror github.com/OpenIPC/u-boot-hi3516cv200), union `U_HDATE_CSC_COEF5`, struct offset 0xF090 (GPL-2.0, same-chip vendor header, byte-identical for Hi3516A V200 and Hi3519 V101). Reset value and access type unknown (modelled RW, no reset). Confidence: medium (vendor header for this chip family, not hardware verified).";

        field {
            name = "csc_coef_b_cr";
            desc = "[inferred] Colour-space conversion coefficient b cr. (vendor header `product/hiosd/vo/hi3519/vou_reg.h` field `csc_coef_b_cr`; access and reset unknown, modelled RW)";
            sw = rw;
            hw = r;
        } csc_coef_b_cr[11:0];
    } HDATE_CSC_COEF5 @ 0xF090;

    reg {
        name = "HDATE TEST";
        desc = "[inferred] HDATE TEST. Not in the data sheet. Source: vendor U-Boot 2010.06 `product/hiosd/vo/hi3519/vou_reg.h` (GPL-2.0 U-Boot tree, HiSilicon copyright, created 2015-05-26; mirror github.com/OpenIPC/u-boot-hi3516cv200), union `U_HDATE_TEST`, struct offset 0xF0A0 (GPL-2.0, same-chip vendor header, byte-identical for Hi3516A V200 and Hi3519 V101). Reset value and access type unknown (modelled RW, no reset). Confidence: medium (vendor header for this chip family, not hardware verified).";

        field {
            name = "test_data";
            desc = "[inferred] Test data. (vendor header `product/hiosd/vo/hi3519/vou_reg.h` field `test_data`; access and reset unknown, modelled RW)";
            sw = rw;
            hw = r;
        } test_data[9:0];
    } HDATE_TEST @ 0xF0A0;

    reg {
        name = "HDATE VBI control";
        desc = "[inferred] HDATE VBI control. Not in the data sheet. Source: vendor U-Boot 2010.06 `product/hiosd/vo/hi3519/vou_reg.h` (GPL-2.0 U-Boot tree, HiSilicon copyright, created 2015-05-26; mirror github.com/OpenIPC/u-boot-hi3516cv200), union `U_HDATE_VBI_CTRL`, struct offset 0xF0A4 (GPL-2.0, same-chip vendor header, byte-identical for Hi3516A V200 and Hi3519 V101). Reset value and access type unknown (modelled RW, no reset). Confidence: medium (vendor header for this chip family, not hardware verified).";

        field {
            name = "vbi_lpf_en";
            desc = "[inferred] Vbi lpf enable. (vendor header `product/hiosd/vo/hi3519/vou_reg.h` field `vbi_lpf_en`; access and reset unknown, modelled RW)";
            sw = rw;
            hw = r;
        } vbi_lpf_en[3:3];

        field {
            name = "mv_en";
            desc = "[inferred] Mv enable. (vendor header `product/hiosd/vo/hi3519/vou_reg.h` field `mv_en`; access and reset unknown, modelled RW)";
            sw = rw;
            hw = r;
        } mv_en[2:2];

        field {
            name = "cgmsa_add_en";
            desc = "[inferred] Cgmsa add enable. (vendor header `product/hiosd/vo/hi3519/vou_reg.h` field `cgmsa_add_en`; access and reset unknown, modelled RW)";
            sw = rw;
            hw = r;
        } cgmsa_add_en[1:1];

        field {
            name = "cgmsb_add_en";
            desc = "[inferred] Cgmsb add enable. (vendor header `product/hiosd/vo/hi3519/vou_reg.h` field `cgmsb_add_en`; access and reset unknown, modelled RW)";
            sw = rw;
            hw = r;
        } cgmsb_add_en[0:0];
    } HDATE_VBI_CTRL @ 0xF0A4;

    reg {
        name = "HDATE CGMSA DATA";
        desc = "[inferred] HDATE CGMSA DATA. Not in the data sheet. Source: vendor U-Boot 2010.06 `product/hiosd/vo/hi3519/vou_reg.h` (GPL-2.0 U-Boot tree, HiSilicon copyright, created 2015-05-26; mirror github.com/OpenIPC/u-boot-hi3516cv200), union `U_HDATE_CGMSA_DATA`, struct offset 0xF0A8 (GPL-2.0, same-chip vendor header, byte-identical for Hi3516A V200 and Hi3519 V101). Reset value and access type unknown (modelled RW, no reset). Confidence: medium (vendor header for this chip family, not hardware verified).";

        field {
            name = "cgmsa_data";
            desc = "[inferred] Cgmsa data. (vendor header `product/hiosd/vo/hi3519/vou_reg.h` field `cgmsa_data`; access and reset unknown, modelled RW)";
            sw = rw;
            hw = r;
        } cgmsa_data[19:0];
    } HDATE_CGMSA_DATA @ 0xF0A8;

    reg {
        name = "HDATE CGMSB H";
        desc = "[inferred] HDATE CGMSB H. Not in the data sheet. Source: vendor U-Boot 2010.06 `product/hiosd/vo/hi3519/vou_reg.h` (GPL-2.0 U-Boot tree, HiSilicon copyright, created 2015-05-26; mirror github.com/OpenIPC/u-boot-hi3516cv200), union `U_HDATE_CGMSB_H`, struct offset 0xF0AC (GPL-2.0, same-chip vendor header, byte-identical for Hi3516A V200 and Hi3519 V101). Reset value and access type unknown (modelled RW, no reset). Confidence: medium (vendor header for this chip family, not hardware verified).";

        field {
            name = "hdate_cgmsb_h";
            desc = "[inferred] Hdate cgmsb h. (vendor header `product/hiosd/vo/hi3519/vou_reg.h` field `hdate_cgmsb_h`; access and reset unknown, modelled RW)";
            sw = rw;
            hw = r;
        } hdate_cgmsb_h[5:0];
    } HDATE_CGMSB_H @ 0xF0AC;

    reg {
        name = "HDATE CGMSB DATA1";
        desc = "[inferred] HDATE CGMSB DATA1. Not in the data sheet. Source: vendor U-Boot 2010.06 `product/hiosd/vo/hi3519/vou_reg.h` (GPL-2.0 U-Boot tree, HiSilicon copyright, created 2015-05-26; mirror github.com/OpenIPC/u-boot-hi3516cv200), union `U_HDATE_CGMSB_DATA1`, struct offset 0xF0B0 (GPL-2.0, same-chip vendor header, byte-identical for Hi3516A V200 and Hi3519 V101). Reset value and access type unknown (modelled RW, no reset). Confidence: medium (vendor header for this chip family, not hardware verified).";

        field {
            name = "cgmsb_data1";
            desc = "[inferred] Cgmsb data1. (vendor header `product/hiosd/vo/hi3519/vou_reg.h` field `cgmsb_data1`; access and reset unknown, modelled RW)";
            sw = rw;
            hw = r;
        } cgmsb_data1[31:0];
    } HDATE_CGMSB_DATA1 @ 0xF0B0;

    reg {
        name = "HDATE CGMSB DATA2";
        desc = "[inferred] HDATE CGMSB DATA2. Not in the data sheet. Source: vendor U-Boot 2010.06 `product/hiosd/vo/hi3519/vou_reg.h` (GPL-2.0 U-Boot tree, HiSilicon copyright, created 2015-05-26; mirror github.com/OpenIPC/u-boot-hi3516cv200), union `U_HDATE_CGMSB_DATA2`, struct offset 0xF0B4 (GPL-2.0, same-chip vendor header, byte-identical for Hi3516A V200 and Hi3519 V101). Reset value and access type unknown (modelled RW, no reset). Confidence: medium (vendor header for this chip family, not hardware verified).";

        field {
            name = "cgmsb_data2";
            desc = "[inferred] Cgmsb data2. (vendor header `product/hiosd/vo/hi3519/vou_reg.h` field `cgmsb_data2`; access and reset unknown, modelled RW)";
            sw = rw;
            hw = r;
        } cgmsb_data2[31:0];
    } HDATE_CGMSB_DATA2 @ 0xF0B4;

    reg {
        name = "HDATE CGMSB DATA3";
        desc = "[inferred] HDATE CGMSB DATA3. Not in the data sheet. Source: vendor U-Boot 2010.06 `product/hiosd/vo/hi3519/vou_reg.h` (GPL-2.0 U-Boot tree, HiSilicon copyright, created 2015-05-26; mirror github.com/OpenIPC/u-boot-hi3516cv200), union `U_HDATE_CGMSB_DATA3`, struct offset 0xF0B8 (GPL-2.0, same-chip vendor header, byte-identical for Hi3516A V200 and Hi3519 V101). Reset value and access type unknown (modelled RW, no reset). Confidence: medium (vendor header for this chip family, not hardware verified).";

        field {
            name = "cgmsb_data3";
            desc = "[inferred] Cgmsb data3. (vendor header `product/hiosd/vo/hi3519/vou_reg.h` field `cgmsb_data3`; access and reset unknown, modelled RW)";
            sw = rw;
            hw = r;
        } cgmsb_data3[31:0];
    } HDATE_CGMSB_DATA3 @ 0xF0B8;

    reg {
        name = "HDATE CGMSB DATA4";
        desc = "[inferred] HDATE CGMSB DATA4. Not in the data sheet. Source: vendor U-Boot 2010.06 `product/hiosd/vo/hi3519/vou_reg.h` (GPL-2.0 U-Boot tree, HiSilicon copyright, created 2015-05-26; mirror github.com/OpenIPC/u-boot-hi3516cv200), union `U_HDATE_CGMSB_DATA4`, struct offset 0xF0BC (GPL-2.0, same-chip vendor header, byte-identical for Hi3516A V200 and Hi3519 V101). Reset value and access type unknown (modelled RW, no reset). Confidence: medium (vendor header for this chip family, not hardware verified).";

        field {
            name = "cgmsb_data4";
            desc = "[inferred] Cgmsb data4. (vendor header `product/hiosd/vo/hi3519/vou_reg.h` field `cgmsb_data4`; access and reset unknown, modelled RW)";
            sw = rw;
            hw = r;
        } cgmsb_data4[31:0];
    } HDATE_CGMSB_DATA4 @ 0xF0BC;

    reg {
        name = "HDATE DACDET1";
        desc = "[inferred] HDATE DACDET1. Not in the data sheet. Source: vendor U-Boot 2010.06 `product/hiosd/vo/hi3519/vou_reg.h` (GPL-2.0 U-Boot tree, HiSilicon copyright, created 2015-05-26; mirror github.com/OpenIPC/u-boot-hi3516cv200), union `U_HDATE_DACDET1`, struct offset 0xF0C0 (GPL-2.0, same-chip vendor header, byte-identical for Hi3516A V200 and Hi3519 V101). Reset value and access type unknown (modelled RW, no reset). Confidence: medium (vendor header for this chip family, not hardware verified).";

        field {
            name = "det_line";
            desc = "[inferred] Det line. (vendor header `product/hiosd/vo/hi3519/vou_reg.h` field `det_line`; access and reset unknown, modelled RW)";
            sw = rw;
            hw = r;
        } det_line[25:16];

        field {
            name = "vdac_det_high";
            desc = "[inferred] Vdac det high. (vendor header `product/hiosd/vo/hi3519/vou_reg.h` field `vdac_det_high`; access and reset unknown, modelled RW)";
            sw = rw;
            hw = r;
        } vdac_det_high[9:0];
    } HDATE_DACDET1 @ 0xF0C0;

    reg {
        name = "HDATE DACDET2";
        desc = "[inferred] HDATE DACDET2. Not in the data sheet. Source: vendor U-Boot 2010.06 `product/hiosd/vo/hi3519/vou_reg.h` (GPL-2.0 U-Boot tree, HiSilicon copyright, created 2015-05-26; mirror github.com/OpenIPC/u-boot-hi3516cv200), union `U_HDATE_DACDET2`, struct offset 0xF0C4 (GPL-2.0, same-chip vendor header, byte-identical for Hi3516A V200 and Hi3519 V101). Reset value and access type unknown (modelled RW, no reset). Confidence: medium (vendor header for this chip family, not hardware verified).";

        field {
            name = "vdac_det_en";
            desc = "[inferred] Vdac det enable. (vendor header `product/hiosd/vo/hi3519/vou_reg.h` field `vdac_det_en`; access and reset unknown, modelled RW)";
            sw = rw;
            hw = r;
        } vdac_det_en[31:31];

        field {
            name = "det_pixel_wid";
            desc = "[inferred] Det pixel width. (vendor header `product/hiosd/vo/hi3519/vou_reg.h` field `det_pixel_wid`; access and reset unknown, modelled RW)";
            sw = rw;
            hw = r;
        } det_pixel_wid[26:16];

        field {
            name = "det_pixel_sta";
            desc = "[inferred] Det pixel status. (vendor header `product/hiosd/vo/hi3519/vou_reg.h` field `det_pixel_sta`; access and reset unknown, modelled RW)";
            sw = rw;
            hw = r;
        } det_pixel_sta[10:0];
    } HDATE_DACDET2 @ 0xF0C4;

    reg {
        name = "HDATE source 13 COEF14";
        desc = "[inferred] HDATE source 13 COEF14. Not in the data sheet. Source: vendor U-Boot 2010.06 `product/hiosd/vo/hi3519/vou_reg.h` (GPL-2.0 U-Boot tree, HiSilicon copyright, created 2015-05-26; mirror github.com/OpenIPC/u-boot-hi3516cv200), union `U_HDATE_SRC_13_COEF14`, struct offset 0xF0C8 (GPL-2.0, same-chip vendor header, byte-identical for Hi3516A V200 and Hi3519 V101). Reset value and access type unknown (modelled RW, no reset). Confidence: medium (vendor header for this chip family, not hardware verified).";

        field {
            name = "coef_tap14_3";
            desc = "[inferred] Coefficient tap14 3. (vendor header `product/hiosd/vo/hi3519/vou_reg.h` field `coef_tap14_3`; access and reset unknown, modelled RW)";
            sw = rw;
            hw = r;
        } coef_tap14_3[26:16];

        field {
            name = "coef_tap14_1";
            desc = "[inferred] Coefficient tap14 1. (vendor header `product/hiosd/vo/hi3519/vou_reg.h` field `coef_tap14_1`; access and reset unknown, modelled RW)";
            sw = rw;
            hw = r;
        } coef_tap14_1[10:0];
    } HDATE_SRC_13_COEF14 @ 0xF0C8;

    reg {
        name = "HDATE source 13 COEF15";
        desc = "[inferred] HDATE source 13 COEF15. Not in the data sheet. Source: vendor U-Boot 2010.06 `product/hiosd/vo/hi3519/vou_reg.h` (GPL-2.0 U-Boot tree, HiSilicon copyright, created 2015-05-26; mirror github.com/OpenIPC/u-boot-hi3516cv200), union `U_HDATE_SRC_13_COEF15`, struct offset 0xF0CC (GPL-2.0, same-chip vendor header, byte-identical for Hi3516A V200 and Hi3519 V101). Reset value and access type unknown (modelled RW, no reset). Confidence: medium (vendor header for this chip family, not hardware verified).";

        field {
            name = "coef_tap15_3";
            desc = "[inferred] Coefficient tap15 3. (vendor header `product/hiosd/vo/hi3519/vou_reg.h` field `coef_tap15_3`; access and reset unknown, modelled RW)";
            sw = rw;
            hw = r;
        } coef_tap15_3[26:16];

        field {
            name = "coef_tap15_1";
            desc = "[inferred] Coefficient tap15 1. (vendor header `product/hiosd/vo/hi3519/vou_reg.h` field `coef_tap15_1`; access and reset unknown, modelled RW)";
            sw = rw;
            hw = r;
        } coef_tap15_1[10:0];
    } HDATE_SRC_13_COEF15 @ 0xF0CC;

    reg {
        name = "HDATE source 13 COEF16";
        desc = "[inferred] HDATE source 13 COEF16. Not in the data sheet. Source: vendor U-Boot 2010.06 `product/hiosd/vo/hi3519/vou_reg.h` (GPL-2.0 U-Boot tree, HiSilicon copyright, created 2015-05-26; mirror github.com/OpenIPC/u-boot-hi3516cv200), union `U_HDATE_SRC_13_COEF16`, struct offset 0xF0D0 (GPL-2.0, same-chip vendor header, byte-identical for Hi3516A V200 and Hi3519 V101). Reset value and access type unknown (modelled RW, no reset). Confidence: medium (vendor header for this chip family, not hardware verified).";

        field {
            name = "coef_tap16_3";
            desc = "[inferred] Coefficient tap16 3. (vendor header `product/hiosd/vo/hi3519/vou_reg.h` field `coef_tap16_3`; access and reset unknown, modelled RW)";
            sw = rw;
            hw = r;
        } coef_tap16_3[26:16];

        field {
            name = "coef_tap16_1";
            desc = "[inferred] Coefficient tap16 1. (vendor header `product/hiosd/vo/hi3519/vou_reg.h` field `coef_tap16_1`; access and reset unknown, modelled RW)";
            sw = rw;
            hw = r;
        } coef_tap16_1[10:0];
    } HDATE_SRC_13_COEF16 @ 0xF0D0;

    reg {
        name = "HDATE source 13 COEF17";
        desc = "[inferred] HDATE source 13 COEF17. Not in the data sheet. Source: vendor U-Boot 2010.06 `product/hiosd/vo/hi3519/vou_reg.h` (GPL-2.0 U-Boot tree, HiSilicon copyright, created 2015-05-26; mirror github.com/OpenIPC/u-boot-hi3516cv200), union `U_HDATE_SRC_13_COEF17`, struct offset 0xF0D4 (GPL-2.0, same-chip vendor header, byte-identical for Hi3516A V200 and Hi3519 V101). Reset value and access type unknown (modelled RW, no reset). Confidence: medium (vendor header for this chip family, not hardware verified).";

        field {
            name = "coef_tap17_3";
            desc = "[inferred] Coefficient tap17 3. (vendor header `product/hiosd/vo/hi3519/vou_reg.h` field `coef_tap17_3`; access and reset unknown, modelled RW)";
            sw = rw;
            hw = r;
        } coef_tap17_3[26:16];

        field {
            name = "coef_tap17_1";
            desc = "[inferred] Coefficient tap17 1. (vendor header `product/hiosd/vo/hi3519/vou_reg.h` field `coef_tap17_1`; access and reset unknown, modelled RW)";
            sw = rw;
            hw = r;
        } coef_tap17_1[10:0];
    } HDATE_SRC_13_COEF17 @ 0xF0D4;

    reg {
        name = "HDATE source 13 COEF18";
        desc = "[inferred] HDATE source 13 COEF18. Not in the data sheet. Source: vendor U-Boot 2010.06 `product/hiosd/vo/hi3519/vou_reg.h` (GPL-2.0 U-Boot tree, HiSilicon copyright, created 2015-05-26; mirror github.com/OpenIPC/u-boot-hi3516cv200), union `U_HDATE_SRC_13_COEF18`, struct offset 0xF0D8 (GPL-2.0, same-chip vendor header, byte-identical for Hi3516A V200 and Hi3519 V101). Reset value and access type unknown (modelled RW, no reset). Confidence: medium (vendor header for this chip family, not hardware verified).";

        field {
            name = "coef_tap18_3";
            desc = "[inferred] Coefficient tap18 3. (vendor header `product/hiosd/vo/hi3519/vou_reg.h` field `coef_tap18_3`; access and reset unknown, modelled RW)";
            sw = rw;
            hw = r;
        } coef_tap18_3[26:16];

        field {
            name = "coef_tap18_1";
            desc = "[inferred] Coefficient tap18 1. (vendor header `product/hiosd/vo/hi3519/vou_reg.h` field `coef_tap18_1`; access and reset unknown, modelled RW)";
            sw = rw;
            hw = r;
        } coef_tap18_1[10:0];
    } HDATE_SRC_13_COEF18 @ 0xF0D8;

    reg {
        name = "HDATE source 24 COEF14";
        desc = "[inferred] HDATE source 24 COEF14. Not in the data sheet. Source: vendor U-Boot 2010.06 `product/hiosd/vo/hi3519/vou_reg.h` (GPL-2.0 U-Boot tree, HiSilicon copyright, created 2015-05-26; mirror github.com/OpenIPC/u-boot-hi3516cv200), union `U_HDATE_SRC_24_COEF14`, struct offset 0xF0DC (GPL-2.0, same-chip vendor header, byte-identical for Hi3516A V200 and Hi3519 V101). Reset value and access type unknown (modelled RW, no reset). Confidence: medium (vendor header for this chip family, not hardware verified).";

        field {
            name = "coef_tap14_4";
            desc = "[inferred] Coefficient tap14 4. (vendor header `product/hiosd/vo/hi3519/vou_reg.h` field `coef_tap14_4`; access and reset unknown, modelled RW)";
            sw = rw;
            hw = r;
        } coef_tap14_4[26:16];

        field {
            name = "coef_tap14_2";
            desc = "[inferred] Coefficient tap14 2. (vendor header `product/hiosd/vo/hi3519/vou_reg.h` field `coef_tap14_2`; access and reset unknown, modelled RW)";
            sw = rw;
            hw = r;
        } coef_tap14_2[10:0];
    } HDATE_SRC_24_COEF14 @ 0xF0DC;

    reg {
        name = "HDATE source 24 COEF15";
        desc = "[inferred] HDATE source 24 COEF15. Not in the data sheet. Source: vendor U-Boot 2010.06 `product/hiosd/vo/hi3519/vou_reg.h` (GPL-2.0 U-Boot tree, HiSilicon copyright, created 2015-05-26; mirror github.com/OpenIPC/u-boot-hi3516cv200), union `U_HDATE_SRC_24_COEF15`, struct offset 0xF0E0 (GPL-2.0, same-chip vendor header, byte-identical for Hi3516A V200 and Hi3519 V101). Reset value and access type unknown (modelled RW, no reset). Confidence: medium (vendor header for this chip family, not hardware verified).";

        field {
            name = "coef_tap15_4";
            desc = "[inferred] Coefficient tap15 4. (vendor header `product/hiosd/vo/hi3519/vou_reg.h` field `coef_tap15_4`; access and reset unknown, modelled RW)";
            sw = rw;
            hw = r;
        } coef_tap15_4[26:16];

        field {
            name = "coef_tap15_2";
            desc = "[inferred] Coefficient tap15 2. (vendor header `product/hiosd/vo/hi3519/vou_reg.h` field `coef_tap15_2`; access and reset unknown, modelled RW)";
            sw = rw;
            hw = r;
        } coef_tap15_2[10:0];
    } HDATE_SRC_24_COEF15 @ 0xF0E0;

    reg {
        name = "HDATE source 24 COEF16";
        desc = "[inferred] HDATE source 24 COEF16. Not in the data sheet. Source: vendor U-Boot 2010.06 `product/hiosd/vo/hi3519/vou_reg.h` (GPL-2.0 U-Boot tree, HiSilicon copyright, created 2015-05-26; mirror github.com/OpenIPC/u-boot-hi3516cv200), union `U_HDATE_SRC_24_COEF16`, struct offset 0xF0E4 (GPL-2.0, same-chip vendor header, byte-identical for Hi3516A V200 and Hi3519 V101). Reset value and access type unknown (modelled RW, no reset). Confidence: medium (vendor header for this chip family, not hardware verified).";

        field {
            name = "coef_tap16_4";
            desc = "[inferred] Coefficient tap16 4. (vendor header `product/hiosd/vo/hi3519/vou_reg.h` field `coef_tap16_4`; access and reset unknown, modelled RW)";
            sw = rw;
            hw = r;
        } coef_tap16_4[26:16];

        field {
            name = "coef_tap16_2";
            desc = "[inferred] Coefficient tap16 2. (vendor header `product/hiosd/vo/hi3519/vou_reg.h` field `coef_tap16_2`; access and reset unknown, modelled RW)";
            sw = rw;
            hw = r;
        } coef_tap16_2[10:0];
    } HDATE_SRC_24_COEF16 @ 0xF0E4;

    reg {
        name = "HDATE source 24 COEF17";
        desc = "[inferred] HDATE source 24 COEF17. Not in the data sheet. Source: vendor U-Boot 2010.06 `product/hiosd/vo/hi3519/vou_reg.h` (GPL-2.0 U-Boot tree, HiSilicon copyright, created 2015-05-26; mirror github.com/OpenIPC/u-boot-hi3516cv200), union `U_HDATE_SRC_24_COEF17`, struct offset 0xF0E8 (GPL-2.0, same-chip vendor header, byte-identical for Hi3516A V200 and Hi3519 V101). Reset value and access type unknown (modelled RW, no reset). Confidence: medium (vendor header for this chip family, not hardware verified).";

        field {
            name = "coef_tap17_4";
            desc = "[inferred] Coefficient tap17 4. (vendor header `product/hiosd/vo/hi3519/vou_reg.h` field `coef_tap17_4`; access and reset unknown, modelled RW)";
            sw = rw;
            hw = r;
        } coef_tap17_4[26:16];

        field {
            name = "coef_tap17_2";
            desc = "[inferred] Coefficient tap17 2. (vendor header `product/hiosd/vo/hi3519/vou_reg.h` field `coef_tap17_2`; access and reset unknown, modelled RW)";
            sw = rw;
            hw = r;
        } coef_tap17_2[10:0];
    } HDATE_SRC_24_COEF17 @ 0xF0E8;

    reg {
        name = "HDATE source 24 COEF18";
        desc = "[inferred] HDATE source 24 COEF18. Not in the data sheet. Source: vendor U-Boot 2010.06 `product/hiosd/vo/hi3519/vou_reg.h` (GPL-2.0 U-Boot tree, HiSilicon copyright, created 2015-05-26; mirror github.com/OpenIPC/u-boot-hi3516cv200), union `U_HDATE_SRC_24_COEF18`, struct offset 0xF0EC (GPL-2.0, same-chip vendor header, byte-identical for Hi3516A V200 and Hi3519 V101). Reset value and access type unknown (modelled RW, no reset). Confidence: medium (vendor header for this chip family, not hardware verified).";

        field {
            name = "coef_tap18_4";
            desc = "[inferred] Coefficient tap18 4. (vendor header `product/hiosd/vo/hi3519/vou_reg.h` field `coef_tap18_4`; access and reset unknown, modelled RW)";
            sw = rw;
            hw = r;
        } coef_tap18_4[26:16];

        field {
            name = "coef_tap18_2";
            desc = "[inferred] Coefficient tap18 2. (vendor header `product/hiosd/vo/hi3519/vou_reg.h` field `coef_tap18_2`; access and reset unknown, modelled RW)";
            sw = rw;
            hw = r;
        } coef_tap18_2[10:0];
    } HDATE_SRC_24_COEF18 @ 0xF0EC;

    reg {
        name = "HDATE clip";
        desc = "[inferred] HDATE clip. Not in the data sheet. Source: vendor U-Boot 2010.06 `product/hiosd/vo/hi3519/vou_reg.h` (GPL-2.0 U-Boot tree, HiSilicon copyright, created 2015-05-26; mirror github.com/OpenIPC/u-boot-hi3516cv200), union `U_HDATE_CLIP`, struct offset 0xF0F0 (GPL-2.0, same-chip vendor header, byte-identical for Hi3516A V200 and Hi3519 V101). Reset value and access type unknown (modelled RW, no reset). Confidence: medium (vendor header for this chip family, not hardware verified).";

        field {
            name = "clip_bb";
            desc = "[inferred] Clip bb. (vendor header `product/hiosd/vo/hi3519/vou_reg.h` field `clip_bb`; access and reset unknown, modelled RW)";
            sw = rw;
            hw = r;
        } clip_bb[31:24];

        field {
            name = "clip_fb";
            desc = "[inferred] Clip fb. (vendor header `product/hiosd/vo/hi3519/vou_reg.h` field `clip_fb`; access and reset unknown, modelled RW)";
            sw = rw;
            hw = r;
        } clip_fb[23:16];

        field {
            name = "clip_disable";
            desc = "[inferred] Clip disable. (vendor header `product/hiosd/vo/hi3519/vou_reg.h` field `clip_disable`; access and reset unknown, modelled RW)";
            sw = rw;
            hw = r;
        } clip_disable[15:15];

        field {
            name = "clip_thdl";
            desc = "[inferred] Clip thdl. (vendor header `product/hiosd/vo/hi3519/vou_reg.h` field `clip_thdl`; access and reset unknown, modelled RW)";
            sw = rw;
            hw = r;
        } clip_thdl[9:0];
    } HDATE_CLIP @ 0xF0F0;

    reg {
        name = "Standard parameter configuration register 0";
        desc = "DATE_COEFF0 is a standard parameter configuration register.

Data sheet 9.2.6 DATE_COEFF0 (offset 0xF200, printed page 9-138, `hi3516av200--Hi3516AV200-Datasheet.txt` line 45237).";

        enum DATE_COEFF0_clpf_sel_enum {
            V_1_1_MHZ = 0 { name = "V 1 1 Mhz"; desc = "1.1 MHz (NTSC)"; };
            V_1_3_MHZ = 1 { name = "V 1 3 Mhz"; desc = "1.3 MHz (PAL)"; };
            V_1_6_MHZ = 2 { name = "V 1 6 Mhz"; desc = "1.6 MHz (for test)"; };
            RESERVED = 3 { name = "Reserved"; desc = "reserved"; };
        };

        field {
            name = "clpf_sel";
            desc = "Bandwidth of the chrominance low-pass filter";
            sw = rw;
            hw = r;
            encode = DATE_COEFF0_clpf_sel_enum;
            reset = 0x1;
        } clpf_sel[31:30];

        enum DATE_COEFF0_dis_ire_enum {
            BLACK_LEVEL_7 = 0 { name = "Black Level 7"; desc = "The black level is 7.5 IRE higher than the blanking level."; };
            BLACK_LEVEL_EQUAL = 1 { name = "Black Level Equal"; desc = "The black level is equal to the blanking level."; };
        };

        field {
            name = "dis_ire";
            desc = "For the (M) NTSC and (M, N) PAL standards, the black level is 7.5 IRE higher than the blanking level; for other standards, the black level is equal to the blanking level. This bit controls whether the black level is 7.5 IRE higher than the blanking level.";
            sw = rw;
            hw = r;
            encode = DATE_COEFF0_dis_ire_enum;
            reset = 0x0;
        } dis_ire[29:29];

        enum DATE_COEFF0_pal_half_en_enum {
            DISABLED = 0 { name = "Disabled"; desc = "disabled"; };
            ENABLED = 1 { name = "Enabled"; desc = "enabled"; };
        };

        field {
            name = "pal_half_en";
            desc = "PAL half line reduction enable";
            sw = rw;
            hw = r;
            encode = DATE_COEFF0_pal_half_en_enum;
            reset = 0x0;
        } pal_half_en[27:27];

        enum DATE_COEFF0_pbpr_lpf_en_enum {
            DISABLED = 0 { name = "Disabled"; desc = "disabled"; };
            ENABLED = 1 { name = "Enabled"; desc = "enabled"; };
        };

        field {
            name = "pbpr_lpf_en";
            desc = "Component chrominance low-pass filtering enable";
            sw = rw;
            hw = r;
            encode = DATE_COEFF0_pbpr_lpf_en_enum;
            reset = 0x0;
        } pbpr_lpf_en[26:26];

        enum DATE_COEFF0_scanline_enum {
            V_525_LINES_FRAME = 0 { name = "V 525 Lines Frame"; desc = "525 lines in a frame"; };
            V_625_LINES_FRAME = 1 { name = "V 625 Lines Frame"; desc = "625 lines in a frame"; };
        };

        field {
            name = "scanline";
            desc = "Number of scanned lines in each frame based on standards. For the (M) NTSC, NTSC-J, and (M) PAL standards, each line contains 525 lines; for the (B, D, J, H, I) PAL, (N) PAL, and (Nc) PAL standards, each frame contains 625 lines.";
            sw = rw;
            hw = r;
            encode = DATE_COEFF0_scanline_enum;
            reset = 0x1;
        } scanline[25:25];

        enum DATE_COEFF0_rgb_en_enum {
            YPBPR = 0 { name = "Ypbpr"; desc = "YPbPr"; };
            RGB = 1 { name = "Rgb"; desc = "RGB"; };
        };

        field {
            name = "rgb_en";
            desc = "When intf_sel is set to 100, this bit determines whether the component signal is RGB or YPbPr.";
            sw = rw;
            hw = r;
            encode = DATE_COEFF0_rgb_en_enum;
            reset = 0x0;
        } rgb_en[24:24];

        enum DATE_COEFF0_vbi_lpf_en_enum {
            NO_FILTERING = 0 { name = "No Filtering"; desc = "no filtering"; };
            FILTERING = 1 { name = "Filtering"; desc = "filtering"; };
        };

        field {
            name = "vbi_lpf_en";
            desc = "VBI data low-pass filtering enable";
            sw = rw;
            hw = r;
            encode = DATE_COEFF0_vbi_lpf_en_enum;
            reset = 0x1;
        } vbi_lpf_en[23:23];

        enum DATE_COEFF0_fm_sel_enum {
            SIN_MODE = 0 { name = "Sin Mode"; desc = "SIN mode"; };
            COS_MODE = 1 { name = "Cos Mode"; desc = "COS mode"; };
        };

        field {
            name = "fm_sel";
            desc = "FMSECAM frequency modulation select";
            sw = rw;
            hw = r;
            encode = DATE_COEFF0_fm_sel_enum;
            reset = 0x0;
        } fm_sel[22:22];

        field {
            name = "style_sel";
            desc = "CVBS/S-Video output signal standard when this bit works with the scanline bit When the scanline bit is 0 (525 scanned lines in a frame), the definition of the style_sel bit is as follows: 0x1: (M) NTSC standard 0x2: NTSC-J standard 0x4: (M) PAL standard When the scanline bit is 1 (625 scanned lines in a frame), the definition of the style_sel bit is as follows: 0x1: (B, D, G, H, I) PAL standard 0x2: (N) PAL standard 0x4: (Nc) PAL standard 0x8: SECAM standard Other values: reserved";
            sw = rw;
            hw = r;
            reset = 0x1;
        } style_sel[21:18];

        field {
            name = "sync_mode_sel";
            desc = "bit[17]: specifies whether there are sync signals in three channels during component output. This bit takes effect only when the sync_mode_scart bit is set to 0. bit[17] is valid only when intf_sel is set to 100 (component output enabled). The definition of bit[17] is as follows: 0: Only one channel contains sync signals during component output. 1: Three channels contain sync signals during component output. When bit[17] is set to 0, the sync channel must be the Y channel for YPbPr output or G channel for RGB output. bit[16]: specifies whether there are blanking radixes during RGB output. bit[16] is valid only when intf_sel is set to 100 and rgb_en is set to 1. The definition of bit[16] is as follows: 0: There are no blanking radixes during RGB output. 1: There are blanking radixes during RGB output.";
            sw = rw;
            hw = r;
            reset = 0x0;
        } sync_mode_sel[17:16];

        enum DATE_COEFF0_sync_mode_scart_enum {
            COMPONENT_SYNC_OUTPUT = 0 { name = "Component Sync Output"; desc = "Component sync output is configured based on sync_mode_sel bit[1]."; };
            COMPONENTS_THREE_CHANNELS = 1 { name = "Components Three Channels"; desc = "The components of the three channels are not overlaid and synchronized. In this case, sync_mode_sel bit[1] must be set to 0."; };
        };

        field {
            name = "sync_mode_scart";
            desc = "Overlay sync control for the components of three channels";
            sw = rw;
            hw = r;
            encode = DATE_COEFF0_sync_mode_scart_enum;
            reset = 0x0;
        } sync_mode_scart[15:15];

        enum DATE_COEFF0_length_sel_enum {
            OUTPUT_ACCORDING_LINE = 0 { name = "Output According Line"; desc = "output according to the line active pixel width in BT.601 mode."; };
            OUTPUT_ACCORDING_LINE_2 = 1 { name = "Output According Line 2"; desc = "output according to the line active pixel width in BT.470 mode When this bit is set to 0, the active width of the line is 720 pixels. When this bit is set to 1, the active width of the line is 704 pixels for the 625-line standard or 712 pixels for the 525-line standard. Currently, the BT.601 mode and BT.470 mode cannot be dynamically switched. You can change the mode only after reset. The BT.601 mode is recommended, and this mode is the default mode after power-on reset."; };
        };

        field {
            name = "length_sel";
            desc = "Active width of each video line (in pixel)";
            sw = rw;
            hw = r;
            encode = DATE_COEFF0_length_sel_enum;
            reset = 0x0;
        } length_sel[14:14];

        enum DATE_COEFF0_agc_amp_sel_enum {
            AGC_PULSE_GENERATED = 0 { name = "Agc Pulse Generated"; desc = "The AGC pulse is generated based on the on-chip default value (recommended)."; };
            AGC_PULSE_GENERATED_2 = 1 { name = "Agc Pulse Generated 2"; desc = "The AGC pulse is generated based on the off-chip configuration. DATE_COEFF1[amp_outside]"; };
        };

        field {
            name = "agc_amp_sel";
            desc = "AGC pulse select";
            sw = rw;
            hw = r;
            encode = DATE_COEFF0_agc_amp_sel_enum;
            reset = 0x0;
        } agc_amp_sel[13:13];

        field {
            name = "luma_dl";
            desc = "Lead or lag-behind offset of the chrominance signal relative to the luminance signal, in the unit of half a pixel width bit[12]: offset direction of the chrominance signal relative to the luminance signal. 0: The chrominance signal lags behind the luminance signal. 1: The chrominance signal leads the luminance signal. bit[11:9]: absolute offset of the chrominance signal relative to the luminance signal. The value is in binary format and ranges from 0 to 7. 000: The chrominance signal is aligned with the luminance signal. No adjustment is required. 001-111: The chrominance signal leads or lags behind the luminance signal by one to seven units.";
            sw = rw;
            hw = r;
            reset = 0xA;
        } luma_dl[12:9];

        field {
            name = "oversam_en";
            desc = "Level-1 over-sampling enable. Both luminance over-sampling and chrominance over-sampling are controlled. bit[7]: luminance over-sampling enable 0: disabled 1: enabled bit[6]: chrominance over-sampling enable 0: disabled 1: enabled";
            sw = rw;
            hw = r;
            reset = 0x3;
        } oversam_en[7:6];

        enum DATE_COEFF0_lunt_en_enum {
            DISABLED = 0 { name = "Disabled"; desc = "disabled"; };
            ENABLED = 1 { name = "Enabled"; desc = "enabled"; };
        };

        field {
            name = "lunt_en";
            desc = "Luminance notch enable";
            sw = rw;
            hw = r;
            encode = DATE_COEFF0_lunt_en_enum;
            reset = 0x1;
        } lunt_en[5:5];

        enum DATE_COEFF0_oversam2_en_enum {
            DISABLED = 0 { name = "Disabled"; desc = "disabled"; };
            ENABLED = 1 { name = "Enabled"; desc = "enabled"; };
        };

        field {
            name = "oversam2_en";
            desc = "Level-2 over-sampling enable. Both the luminance channel and chrominance channel are controlled.";
            sw = rw;
            hw = r;
            encode = DATE_COEFF0_oversam2_en_enum;
            reset = 0x1;
        } oversam2_en[4:4];

        enum DATE_COEFF0_chlp_en_enum {
            DISABLED = 0 { name = "Disabled"; desc = "disabled"; };
            ENABLED = 1 { name = "Enabled"; desc = "enabled"; };
        };

        field {
            name = "chlp_en";
            desc = "Chrominance low-pass filtering enable";
            sw = rw;
            hw = r;
            encode = DATE_COEFF0_chlp_en_enum;
            reset = 0x1;
        } chlp_en[3:3];

        enum DATE_COEFF0_sylp_en_enum {
            DISABLED = 0 { name = "Disabled"; desc = "disabled"; };
            ENABLED = 1 { name = "Enabled"; desc = "enabled"; };
        };

        field {
            name = "sylp_en";
            desc = "Sync low-pass filtering enable";
            sw = rw;
            hw = r;
            encode = DATE_COEFF0_sylp_en_enum;
            reset = 0x1;
        } sylp_en[2:2];

        enum DATE_COEFF0_chgain_en_enum {
            DISABLED = 0 { name = "Disabled"; desc = "disabled"; };
            ENABLED = 1 { name = "Enabled"; desc = "enabled"; };
        };

        field {
            name = "chgain_en";
            desc = "Chrominance gain enable";
            sw = rw;
            hw = r;
            encode = DATE_COEFF0_chgain_en_enum;
            reset = 0x0;
        } chgain_en[1:1];

        enum DATE_COEFF0_tt_seq_enum {
            FROM_UPPER_BITS = 0 { name = "From Upper Bits"; desc = "from upper bits to lower bits"; };
            FROM_LOWER_BITS = 1 { name = "From Lower Bits"; desc = "from lower bits to upper bits"; };
        };

        field {
            name = "tt_seq";
            desc = "Sequence of transmitting the bits of the teletext data";
            sw = rw;
            hw = r;
            encode = DATE_COEFF0_tt_seq_enum;
            reset = 0x0;
        } tt_seq[0:0];
    } DATE_COEFF0 @ 0xF200;

    reg {
        name = "Amplitude configuration register 1";
        desc = "DATE_COEFF1 is an amplitude configuration register.

Data sheet 9.2.6 DATE_COEFF1 (offset 0xF204, printed page 9-142, `hi3516av200--Hi3516AV200-Datasheet.txt` line 45431).";

        field {
            name = "c_gain";
            desc = "Adjustment of the chrominance sync gain amplitude";
            sw = rw;
            hw = r;
            reset = 0x0;
        } c_gain[31:29];

        enum DATE_COEFF1_cvbs_limit_en_enum {
            NOT_LIMITED = 0 { name = "Not Limited"; desc = "not limited"; };
            LIMITED = 1 { name = "Limited"; desc = "limited"; };
        };

        field {
            name = "cvbs_limit_en";
            desc = "CVBS amplitude limit control";
            sw = rw;
            hw = r;
            encode = DATE_COEFF1_cvbs_limit_en_enum;
            reset = 0x0;
        } cvbs_limit_en[28:28];

        enum DATE_COEFF1_wss_seq_enum {
            FROM_UPPER_BITS = 0 { name = "From Upper Bits"; desc = "from upper bits to lower bits"; };
            FROM_LOWER_BITS = 1 { name = "From Lower Bits"; desc = "from lower bits to upper bits"; };
        };

        field {
            name = "wss_seq";
            desc = "Sequence of transmitting the bits of the WSS data";
            sw = rw;
            hw = r;
            encode = DATE_COEFF1_wss_seq_enum;
            reset = 0x0;
        } wss_seq[27:27];

        enum DATE_COEFF1_vps_seq_enum {
            FROM_UPPER_BITS = 0 { name = "From Upper Bits"; desc = "from upper bits to lower bits"; };
            FROM_LOWER_BITS = 1 { name = "From Lower Bits"; desc = "from lower bits to upper bits"; };
        };

        field {
            name = "vps_seq";
            desc = "Sequence of transmitting the bits of the video programming system (VPS) data";
            sw = rw;
            hw = r;
            encode = DATE_COEFF1_vps_seq_enum;
            reset = 0x0;
        } vps_seq[26:26];

        enum DATE_COEFF1_cgms_seq_enum {
            FROM_UPPER_BITS = 0 { name = "From Upper Bits"; desc = "from upper bits to lower bits"; };
            FROM_LOWER_BITS = 1 { name = "From Lower Bits"; desc = "from lower bits to upper bits"; };
        };

        field {
            name = "cgms_seq";
            desc = "Sequence of transmitting the bits of the copy generation management system (CGMS) data";
            sw = rw;
            hw = r;
            encode = DATE_COEFF1_cgms_seq_enum;
            reset = 0x0;
        } cgms_seq[25:25];

        enum DATE_COEFF1_cc_seq_enum {
            FROM_UPPER_BITS = 0 { name = "From Upper Bits"; desc = "from upper bits to lower bits"; };
            FROM_LOWER_BITS = 1 { name = "From Lower Bits"; desc = "from lower bits to upper bits"; };
        };

        field {
            name = "cc_seq";
            desc = "Sequence of transmitting the bits of the closed caption data";
            sw = rw;
            hw = r;
            encode = DATE_COEFF1_cc_seq_enum;
            reset = 0x0;
        } cc_seq[24:24];

        enum DATE_COEFF1_c_limit_en_enum {
            NOT_LIMITED = 0 { name = "Not Limited"; desc = "not limited"; };
            LIMITED = 1 { name = "Limited"; desc = "limited"; };
        };

        field {
            name = "c_limit_en";
            desc = "Chrominance amplitude limit control";
            sw = rw;
            hw = r;
            encode = DATE_COEFF1_c_limit_en_enum;
            reset = 0x0;
        } c_limit_en[23:23];

        field {
            name = "amp_outside";
            desc = "Pulse amplitude input of the external AGC";
            sw = rw;
            hw = r;
            reset = 0x0;
        } amp_outside[22:13];

        field {
            name = "date_test_en";
            desc = "Test valid signal";
            sw = rw;
            hw = r;
            reset = 0x0;
        } date_test_en[12:12];

        field {
            name = "date_test_mode";
            desc = "Test mode signal";
            sw = rw;
            hw = r;
            reset = 0x0;
        } date_test_mode[11:10];

        field {
            name = "dac_test";
            desc = "DAC test value input";
            sw = rw;
            hw = r;
            reset = 0x0;
        } dac_test[9:0];
    } DATE_COEFF1 @ 0xF204;

    reg {
        name = "DATE coefficient 2 register 2";
        desc = "DATE_COEFF2 is a DATE coefficient 2 register.

Data sheet 9.2.6 DATE_COEFF2 (offset 0xF208, printed page 9-143, `hi3516av200--Hi3516AV200-Datasheet.txt` line 45494).";

        field {
            name = "coef02";
            desc = "DATE coefficient 2 register";
            sw = rw;
            hw = r;
            reset = 0x0;
        } coef02[31:0];
    } DATE_COEFF2 @ 0xF208;

    reg {
        name = "DATE coefficient 3 register 3";
        desc = "DATE_COEFF3 is a DATE coefficient 3 register.

Data sheet 9.2.6 DATE_COEFF3 (offset 0xF20C, printed page 9-143, `hi3516av200--Hi3516AV200-Datasheet.txt` line 45512).";

        field {
            name = "coef03";
            desc = "DATE coefficient 3 register";
            sw = rw;
            hw = r;
            reset = 0x0;
        } coef03[25:0];
    } DATE_COEFF3 @ 0xF20C;

    reg {
        name = "DATE coefficient 4 register 4";
        desc = "DATE_COEFF4 is a DATE coefficient 4 register. Hi3516A V200 Professional HD IP Camera SoC

Data sheet 9.2.6 DATE_COEFF4 (offset 0xF210, printed page 9-144, `hi3516av200--Hi3516AV200-Datasheet.txt` line 45542).";

        field {
            name = "coef04";
            desc = "DATE coefficient 4 register";
            sw = rw;
            hw = r;
            reset = 0x0;
        } coef04[29:0];
    } DATE_COEFF4 @ 0xF210;

    reg {
        name = "DATE coefficient 5 register. 5";
        desc = "DATE_COEFF5 is a DATE coefficient 5 register.

Data sheet 9.2.6 DATE_COEFF5 (offset 0xF214, printed page 9-144, `hi3516av200--Hi3516AV200-Datasheet.txt` line 45566).";

        field {
            name = "coef05";
            desc = "DATE coefficient 5 register";
            sw = rw;
            hw = r;
            reset = 0x0;
        } coef05[28:0];
    } DATE_COEFF5 @ 0xF214;

    reg {
        name = "DATE coefficient 6 register 6";
        desc = "DATE_COEFF6 is a DATE coefficient 6 register. Hi3516A V200 Professional HD IP Camera SoC

Data sheet 9.2.6 DATE_COEFF6 (offset 0xF218, printed page 9-145, `hi3516av200--Hi3516AV200-Datasheet.txt` line 45600).";

        field {
            name = "coef06_0";
            desc = "DATE coefficient 6 register 0";
            sw = rw;
            hw = r;
            reset = 0x1;
        } coef06_0[31:31];

        field {
            name = "coef06_1";
            desc = "DATE coefficient 6 register 1";
            sw = rw;
            hw = r;
            reset = 0x0;
        } coef06_1[22:0];
    } DATE_COEFF6 @ 0xF218;

    reg {
        name = "DATE COEFF7";
        desc = "[inferred] DATE COEFF7. Not in the data sheet. Source: vendor U-Boot 2010.06 `product/hiosd/vo/hi3519/vou_reg.h` (GPL-2.0 U-Boot tree, HiSilicon copyright, created 2015-05-26; mirror github.com/OpenIPC/u-boot-hi3516cv200), union `U_DATE_COEFF7`, struct offset 0xF21C (GPL-2.0, same-chip vendor header, byte-identical for Hi3516A V200 and Hi3519 V101). Reset value and access type unknown (modelled RW, no reset). Confidence: medium (vendor header for this chip family, not hardware verified).";

        field {
            name = "tt22_enf1";
            desc = "[inferred] Tt22 enf1. (vendor header `product/hiosd/vo/hi3519/vou_reg.h` field `tt22_enf1`; access and reset unknown, modelled RW)";
            sw = rw;
            hw = r;
        } tt22_enf1[31:31];

        field {
            name = "tt21_enf1";
            desc = "[inferred] Tt21 enf1. (vendor header `product/hiosd/vo/hi3519/vou_reg.h` field `tt21_enf1`; access and reset unknown, modelled RW)";
            sw = rw;
            hw = r;
        } tt21_enf1[30:30];

        field {
            name = "tt20_enf1";
            desc = "[inferred] Tt20 enf1. (vendor header `product/hiosd/vo/hi3519/vou_reg.h` field `tt20_enf1`; access and reset unknown, modelled RW)";
            sw = rw;
            hw = r;
        } tt20_enf1[29:29];

        field {
            name = "tt19_enf1";
            desc = "[inferred] Tt19 enf1. (vendor header `product/hiosd/vo/hi3519/vou_reg.h` field `tt19_enf1`; access and reset unknown, modelled RW)";
            sw = rw;
            hw = r;
        } tt19_enf1[28:28];

        field {
            name = "tt18_enf1";
            desc = "[inferred] Tt18 enf1. (vendor header `product/hiosd/vo/hi3519/vou_reg.h` field `tt18_enf1`; access and reset unknown, modelled RW)";
            sw = rw;
            hw = r;
        } tt18_enf1[27:27];

        field {
            name = "tt17_enf1";
            desc = "[inferred] Tt17 enf1. (vendor header `product/hiosd/vo/hi3519/vou_reg.h` field `tt17_enf1`; access and reset unknown, modelled RW)";
            sw = rw;
            hw = r;
        } tt17_enf1[26:26];

        field {
            name = "tt16_enf1";
            desc = "[inferred] Tt16 enf1. (vendor header `product/hiosd/vo/hi3519/vou_reg.h` field `tt16_enf1`; access and reset unknown, modelled RW)";
            sw = rw;
            hw = r;
        } tt16_enf1[25:25];

        field {
            name = "tt15_enf1";
            desc = "[inferred] Tt15 enf1. (vendor header `product/hiosd/vo/hi3519/vou_reg.h` field `tt15_enf1`; access and reset unknown, modelled RW)";
            sw = rw;
            hw = r;
        } tt15_enf1[24:24];

        field {
            name = "tt14_enf1";
            desc = "[inferred] Tt14 enf1. (vendor header `product/hiosd/vo/hi3519/vou_reg.h` field `tt14_enf1`; access and reset unknown, modelled RW)";
            sw = rw;
            hw = r;
        } tt14_enf1[23:23];

        field {
            name = "tt13_enf1";
            desc = "[inferred] Tt13 enf1. (vendor header `product/hiosd/vo/hi3519/vou_reg.h` field `tt13_enf1`; access and reset unknown, modelled RW)";
            sw = rw;
            hw = r;
        } tt13_enf1[22:22];

        field {
            name = "tt12_enf1";
            desc = "[inferred] Tt12 enf1. (vendor header `product/hiosd/vo/hi3519/vou_reg.h` field `tt12_enf1`; access and reset unknown, modelled RW)";
            sw = rw;
            hw = r;
        } tt12_enf1[21:21];

        field {
            name = "tt11_enf1";
            desc = "[inferred] Tt11 enf1. (vendor header `product/hiosd/vo/hi3519/vou_reg.h` field `tt11_enf1`; access and reset unknown, modelled RW)";
            sw = rw;
            hw = r;
        } tt11_enf1[20:20];

        field {
            name = "tt10_enf1";
            desc = "[inferred] Tt10 enf1. (vendor header `product/hiosd/vo/hi3519/vou_reg.h` field `tt10_enf1`; access and reset unknown, modelled RW)";
            sw = rw;
            hw = r;
        } tt10_enf1[19:19];

        field {
            name = "tt09_enf1";
            desc = "[inferred] Tt09 enf1. (vendor header `product/hiosd/vo/hi3519/vou_reg.h` field `tt09_enf1`; access and reset unknown, modelled RW)";
            sw = rw;
            hw = r;
        } tt09_enf1[18:18];

        field {
            name = "tt08_enf1";
            desc = "[inferred] Tt08 enf1. (vendor header `product/hiosd/vo/hi3519/vou_reg.h` field `tt08_enf1`; access and reset unknown, modelled RW)";
            sw = rw;
            hw = r;
        } tt08_enf1[17:17];

        field {
            name = "tt07_enf1";
            desc = "[inferred] Tt07 enf1. (vendor header `product/hiosd/vo/hi3519/vou_reg.h` field `tt07_enf1`; access and reset unknown, modelled RW)";
            sw = rw;
            hw = r;
        } tt07_enf1[16:16];

        field {
            name = "tt22_enf2";
            desc = "[inferred] Tt22 enf2. (vendor header `product/hiosd/vo/hi3519/vou_reg.h` field `tt22_enf2`; access and reset unknown, modelled RW)";
            sw = rw;
            hw = r;
        } tt22_enf2[15:15];

        field {
            name = "tt21_enf2";
            desc = "[inferred] Tt21 enf2. (vendor header `product/hiosd/vo/hi3519/vou_reg.h` field `tt21_enf2`; access and reset unknown, modelled RW)";
            sw = rw;
            hw = r;
        } tt21_enf2[14:14];

        field {
            name = "tt20_enf2";
            desc = "[inferred] Tt20 enf2. (vendor header `product/hiosd/vo/hi3519/vou_reg.h` field `tt20_enf2`; access and reset unknown, modelled RW)";
            sw = rw;
            hw = r;
        } tt20_enf2[13:13];

        field {
            name = "tt19_enf2";
            desc = "[inferred] Tt19 enf2. (vendor header `product/hiosd/vo/hi3519/vou_reg.h` field `tt19_enf2`; access and reset unknown, modelled RW)";
            sw = rw;
            hw = r;
        } tt19_enf2[12:12];

        field {
            name = "tt18_enf2";
            desc = "[inferred] Tt18 enf2. (vendor header `product/hiosd/vo/hi3519/vou_reg.h` field `tt18_enf2`; access and reset unknown, modelled RW)";
            sw = rw;
            hw = r;
        } tt18_enf2[11:11];

        field {
            name = "tt17_enf2";
            desc = "[inferred] Tt17 enf2. (vendor header `product/hiosd/vo/hi3519/vou_reg.h` field `tt17_enf2`; access and reset unknown, modelled RW)";
            sw = rw;
            hw = r;
        } tt17_enf2[10:10];

        field {
            name = "tt16_enf2";
            desc = "[inferred] Tt16 enf2. (vendor header `product/hiosd/vo/hi3519/vou_reg.h` field `tt16_enf2`; access and reset unknown, modelled RW)";
            sw = rw;
            hw = r;
        } tt16_enf2[9:9];

        field {
            name = "tt15_enf2";
            desc = "[inferred] Tt15 enf2. (vendor header `product/hiosd/vo/hi3519/vou_reg.h` field `tt15_enf2`; access and reset unknown, modelled RW)";
            sw = rw;
            hw = r;
        } tt15_enf2[8:8];

        field {
            name = "tt14_enf2";
            desc = "[inferred] Tt14 enf2. (vendor header `product/hiosd/vo/hi3519/vou_reg.h` field `tt14_enf2`; access and reset unknown, modelled RW)";
            sw = rw;
            hw = r;
        } tt14_enf2[7:7];

        field {
            name = "tt13_enf2";
            desc = "[inferred] Tt13 enf2. (vendor header `product/hiosd/vo/hi3519/vou_reg.h` field `tt13_enf2`; access and reset unknown, modelled RW)";
            sw = rw;
            hw = r;
        } tt13_enf2[6:6];

        field {
            name = "tt12_enf2";
            desc = "[inferred] Tt12 enf2. (vendor header `product/hiosd/vo/hi3519/vou_reg.h` field `tt12_enf2`; access and reset unknown, modelled RW)";
            sw = rw;
            hw = r;
        } tt12_enf2[5:5];

        field {
            name = "tt11_enf2";
            desc = "[inferred] Tt11 enf2. (vendor header `product/hiosd/vo/hi3519/vou_reg.h` field `tt11_enf2`; access and reset unknown, modelled RW)";
            sw = rw;
            hw = r;
        } tt11_enf2[4:4];

        field {
            name = "tt10_enf2";
            desc = "[inferred] Tt10 enf2. (vendor header `product/hiosd/vo/hi3519/vou_reg.h` field `tt10_enf2`; access and reset unknown, modelled RW)";
            sw = rw;
            hw = r;
        } tt10_enf2[3:3];

        field {
            name = "tt09_enf2";
            desc = "[inferred] Tt09 enf2. (vendor header `product/hiosd/vo/hi3519/vou_reg.h` field `tt09_enf2`; access and reset unknown, modelled RW)";
            sw = rw;
            hw = r;
        } tt09_enf2[2:2];

        field {
            name = "tt08_enf2";
            desc = "[inferred] Tt08 enf2. (vendor header `product/hiosd/vo/hi3519/vou_reg.h` field `tt08_enf2`; access and reset unknown, modelled RW)";
            sw = rw;
            hw = r;
        } tt08_enf2[1:1];

        field {
            name = "tt07_enf2";
            desc = "[inferred] Tt07 enf2. (vendor header `product/hiosd/vo/hi3519/vou_reg.h` field `tt07_enf2`; access and reset unknown, modelled RW)";
            sw = rw;
            hw = r;
        } tt07_enf2[0:0];
    } DATE_COEFF7 @ 0xF21C;

    reg {
        name = "DATE COEFF8";
        desc = "[inferred] DATE COEFF8. Not in the data sheet. Source: vendor U-Boot 2010.06 `product/hiosd/vo/hi3519/vou_reg.h` (GPL-2.0 U-Boot tree, HiSilicon copyright, created 2015-05-26; mirror github.com/OpenIPC/u-boot-hi3516cv200), union `U_DATE_COEFF8`, struct offset 0xF220 (GPL-2.0, same-chip vendor header, byte-identical for Hi3516A V200 and Hi3519 V101). Reset value and access type unknown (modelled RW, no reset). Confidence: medium (vendor header for this chip family, not hardware verified).";

        field {
            name = "tt_staddr";
            desc = "[inferred] Tt staddr. (vendor header `product/hiosd/vo/hi3519/vou_reg.h` field `tt_staddr`; access and reset unknown, modelled RW)";
            sw = rw;
            hw = r;
        } tt_staddr[31:0];
    } DATE_COEFF8 @ 0xF220;

    reg {
        name = "DATE COEFF9";
        desc = "[inferred] DATE COEFF9. Not in the data sheet. Source: vendor U-Boot 2010.06 `product/hiosd/vo/hi3519/vou_reg.h` (GPL-2.0 U-Boot tree, HiSilicon copyright, created 2015-05-26; mirror github.com/OpenIPC/u-boot-hi3516cv200), union `U_DATE_COEFF9`, struct offset 0xF224 (GPL-2.0, same-chip vendor header, byte-identical for Hi3516A V200 and Hi3519 V101). Reset value and access type unknown (modelled RW, no reset). Confidence: medium (vendor header for this chip family, not hardware verified).";

        field {
            name = "tt_edaddr";
            desc = "[inferred] Tt edaddr. (vendor header `product/hiosd/vo/hi3519/vou_reg.h` field `tt_edaddr`; access and reset unknown, modelled RW)";
            sw = rw;
            hw = r;
        } tt_edaddr[31:0];
    } DATE_COEFF9 @ 0xF224;

    reg {
        name = "DATE COEFF10";
        desc = "[inferred] DATE COEFF10. Not in the data sheet. Source: vendor U-Boot 2010.06 `product/hiosd/vo/hi3519/vou_reg.h` (GPL-2.0 U-Boot tree, HiSilicon copyright, created 2015-05-26; mirror github.com/OpenIPC/u-boot-hi3516cv200), union `U_DATE_COEFF10`, struct offset 0xF228 (GPL-2.0, same-chip vendor header, byte-identical for Hi3516A V200 and Hi3519 V101). Reset value and access type unknown (modelled RW, no reset). Confidence: medium (vendor header for this chip family, not hardware verified).";

        field {
            name = "tt_ready";
            desc = "[inferred] Tt ready. (vendor header `product/hiosd/vo/hi3519/vou_reg.h` field `tt_ready`; access and reset unknown, modelled RW)";
            sw = rw;
            hw = r;
        } tt_ready[31:31];

        field {
            name = "nabts_100ire";
            desc = "[inferred] Nabts 100ire. (vendor header `product/hiosd/vo/hi3519/vou_reg.h` field `nabts_100ire`; access and reset unknown, modelled RW)";
            sw = rw;
            hw = r;
        } nabts_100ire[12:12];

        field {
            name = "full_page";
            desc = "[inferred] Full page. (vendor header `product/hiosd/vo/hi3519/vou_reg.h` field `full_page`; access and reset unknown, modelled RW)";
            sw = rw;
            hw = r;
        } full_page[11:11];

        field {
            name = "tt_highest";
            desc = "[inferred] Tt highest. (vendor header `product/hiosd/vo/hi3519/vou_reg.h` field `tt_highest`; access and reset unknown, modelled RW)";
            sw = rw;
            hw = r;
        } tt_highest[10:10];

        field {
            name = "tt_mode";
            desc = "[inferred] Tt mode. (vendor header `product/hiosd/vo/hi3519/vou_reg.h` field `tt_mode`; access and reset unknown, modelled RW)";
            sw = rw;
            hw = r;
        } tt_mode[9:8];

        field {
            name = "tt_pktoff";
            desc = "[inferred] Tt pktoff. (vendor header `product/hiosd/vo/hi3519/vou_reg.h` field `tt_pktoff`; access and reset unknown, modelled RW)";
            sw = rw;
            hw = r;
        } tt_pktoff[7:0];
    } DATE_COEFF10 @ 0xF228;

    reg {
        name = "DATE COEFF11";
        desc = "[inferred] DATE COEFF11. Not in the data sheet. Source: vendor U-Boot 2010.06 `product/hiosd/vo/hi3519/vou_reg.h` (GPL-2.0 U-Boot tree, HiSilicon copyright, created 2015-05-26; mirror github.com/OpenIPC/u-boot-hi3516cv200), union `U_DATE_COEFF11`, struct offset 0xF22C (GPL-2.0, same-chip vendor header, byte-identical for Hi3516A V200 and Hi3519 V101). Reset value and access type unknown (modelled RW, no reset). Confidence: medium (vendor header for this chip family, not hardware verified).";

        field {
            name = "cc_enf1";
            desc = "[inferred] Cc enf1. (vendor header `product/hiosd/vo/hi3519/vou_reg.h` field `cc_enf1`; access and reset unknown, modelled RW)";
            sw = rw;
            hw = r;
        } cc_enf1[21:21];

        field {
            name = "cc_enf2";
            desc = "[inferred] Cc enf2. (vendor header `product/hiosd/vo/hi3519/vou_reg.h` field `cc_enf2`; access and reset unknown, modelled RW)";
            sw = rw;
            hw = r;
        } cc_enf2[20:20];

        field {
            name = "date_clf1";
            desc = "[inferred] Date clf1. (vendor header `product/hiosd/vo/hi3519/vou_reg.h` field `date_clf1`; access and reset unknown, modelled RW)";
            sw = rw;
            hw = r;
        } date_clf1[19:10];

        field {
            name = "date_clf2";
            desc = "[inferred] Date clf2. (vendor header `product/hiosd/vo/hi3519/vou_reg.h` field `date_clf2`; access and reset unknown, modelled RW)";
            sw = rw;
            hw = r;
        } date_clf2[9:0];
    } DATE_COEFF11 @ 0xF22C;

    reg {
        name = "DATE COEFF12";
        desc = "[inferred] DATE COEFF12. Not in the data sheet. Source: vendor U-Boot 2010.06 `product/hiosd/vo/hi3519/vou_reg.h` (GPL-2.0 U-Boot tree, HiSilicon copyright, created 2015-05-26; mirror github.com/OpenIPC/u-boot-hi3516cv200), union `U_DATE_COEFF12`, struct offset 0xF230 (GPL-2.0, same-chip vendor header, byte-identical for Hi3516A V200 and Hi3519 V101). Reset value and access type unknown (modelled RW, no reset). Confidence: medium (vendor header for this chip family, not hardware verified).";

        field {
            name = "cc_f1data";
            desc = "[inferred] Cc f1data. (vendor header `product/hiosd/vo/hi3519/vou_reg.h` field `cc_f1data`; access and reset unknown, modelled RW)";
            sw = rw;
            hw = r;
        } cc_f1data[31:16];

        field {
            name = "cc_f2data";
            desc = "[inferred] Cc f2data. (vendor header `product/hiosd/vo/hi3519/vou_reg.h` field `cc_f2data`; access and reset unknown, modelled RW)";
            sw = rw;
            hw = r;
        } cc_f2data[15:0];
    } DATE_COEFF12 @ 0xF230;

    reg {
        name = "DATE COEFF13";
        desc = "[inferred] DATE COEFF13. Not in the data sheet. Source: vendor U-Boot 2010.06 `product/hiosd/vo/hi3519/vou_reg.h` (GPL-2.0 U-Boot tree, HiSilicon copyright, created 2015-05-26; mirror github.com/OpenIPC/u-boot-hi3516cv200), union `U_DATE_COEFF13`, struct offset 0xF234 (GPL-2.0, same-chip vendor header, byte-identical for Hi3516A V200 and Hi3519 V101). Reset value and access type unknown (modelled RW, no reset). Confidence: medium (vendor header for this chip family, not hardware verified).";

        field {
            name = "cg_enf1";
            desc = "[inferred] Cg enf1. (vendor header `product/hiosd/vo/hi3519/vou_reg.h` field `cg_enf1`; access and reset unknown, modelled RW)";
            sw = rw;
            hw = r;
        } cg_enf1[21:21];

        field {
            name = "cg_enf2";
            desc = "[inferred] Cg enf2. (vendor header `product/hiosd/vo/hi3519/vou_reg.h` field `cg_enf2`; access and reset unknown, modelled RW)";
            sw = rw;
            hw = r;
        } cg_enf2[20:20];

        field {
            name = "cg_f1data";
            desc = "[inferred] Cg f1data. (vendor header `product/hiosd/vo/hi3519/vou_reg.h` field `cg_f1data`; access and reset unknown, modelled RW)";
            sw = rw;
            hw = r;
        } cg_f1data[19:0];
    } DATE_COEFF13 @ 0xF234;

    reg {
        name = "DATE COEFF14";
        desc = "[inferred] DATE COEFF14. Not in the data sheet. Source: vendor U-Boot 2010.06 `product/hiosd/vo/hi3519/vou_reg.h` (GPL-2.0 U-Boot tree, HiSilicon copyright, created 2015-05-26; mirror github.com/OpenIPC/u-boot-hi3516cv200), union `U_DATE_COEFF14`, struct offset 0xF238 (GPL-2.0, same-chip vendor header, byte-identical for Hi3516A V200 and Hi3519 V101). Reset value and access type unknown (modelled RW, no reset). Confidence: medium (vendor header for this chip family, not hardware verified).";

        field {
            name = "cg_f2data";
            desc = "[inferred] Cg f2data. (vendor header `product/hiosd/vo/hi3519/vou_reg.h` field `cg_f2data`; access and reset unknown, modelled RW)";
            sw = rw;
            hw = r;
        } cg_f2data[19:0];
    } DATE_COEFF14 @ 0xF238;

    reg {
        name = "DATE COEFF15";
        desc = "[inferred] DATE COEFF15. Not in the data sheet. Source: vendor U-Boot 2010.06 `product/hiosd/vo/hi3519/vou_reg.h` (GPL-2.0 U-Boot tree, HiSilicon copyright, created 2015-05-26; mirror github.com/OpenIPC/u-boot-hi3516cv200), union `U_DATE_COEFF15`, struct offset 0xF23C (GPL-2.0, same-chip vendor header, byte-identical for Hi3516A V200 and Hi3519 V101). Reset value and access type unknown (modelled RW, no reset). Confidence: medium (vendor header for this chip family, not hardware verified).";

        field {
            name = "wss_en";
            desc = "[inferred] Wss enable. (vendor header `product/hiosd/vo/hi3519/vou_reg.h` field `wss_en`; access and reset unknown, modelled RW)";
            sw = rw;
            hw = r;
        } wss_en[14:14];

        field {
            name = "wss_data";
            desc = "[inferred] Wss data. (vendor header `product/hiosd/vo/hi3519/vou_reg.h` field `wss_data`; access and reset unknown, modelled RW)";
            sw = rw;
            hw = r;
        } wss_data[13:0];
    } DATE_COEFF15 @ 0xF23C;

    reg {
        name = "DATE COEFF16";
        desc = "[inferred] DATE COEFF16. Not in the data sheet. Source: vendor U-Boot 2010.06 `product/hiosd/vo/hi3519/vou_reg.h` (GPL-2.0 U-Boot tree, HiSilicon copyright, created 2015-05-26; mirror github.com/OpenIPC/u-boot-hi3516cv200), union `U_DATE_COEFF16`, struct offset 0xF240 (GPL-2.0, same-chip vendor header, byte-identical for Hi3516A V200 and Hi3519 V101). Reset value and access type unknown (modelled RW, no reset). Confidence: medium (vendor header for this chip family, not hardware verified).";

        field {
            name = "vps_en";
            desc = "[inferred] Vps enable. (vendor header `product/hiosd/vo/hi3519/vou_reg.h` field `vps_en`; access and reset unknown, modelled RW)";
            sw = rw;
            hw = r;
        } vps_en[24:24];

        field {
            name = "vps_data";
            desc = "[inferred] Vps data. (vendor header `product/hiosd/vo/hi3519/vou_reg.h` field `vps_data`; access and reset unknown, modelled RW)";
            sw = rw;
            hw = r;
        } vps_data[23:0];
    } DATE_COEFF16 @ 0xF240;

    reg {
        name = "DATE COEFF17";
        desc = "[inferred] DATE COEFF17. Not in the data sheet. Source: vendor U-Boot 2010.06 `product/hiosd/vo/hi3519/vou_reg.h` (GPL-2.0 U-Boot tree, HiSilicon copyright, created 2015-05-26; mirror github.com/OpenIPC/u-boot-hi3516cv200), union `U_DATE_COEFF17`, struct offset 0xF244 (GPL-2.0, same-chip vendor header, byte-identical for Hi3516A V200 and Hi3519 V101). Reset value and access type unknown (modelled RW, no reset). Confidence: medium (vendor header for this chip family, not hardware verified).";

        field {
            name = "vps_data";
            desc = "[inferred] Vps data. (vendor header `product/hiosd/vo/hi3519/vou_reg.h` field `vps_data`; access and reset unknown, modelled RW)";
            sw = rw;
            hw = r;
        } vps_data[31:0];
    } DATE_COEFF17 @ 0xF244;

    reg {
        name = "DATE COEFF18";
        desc = "[inferred] DATE COEFF18. Not in the data sheet. Source: vendor U-Boot 2010.06 `product/hiosd/vo/hi3519/vou_reg.h` (GPL-2.0 U-Boot tree, HiSilicon copyright, created 2015-05-26; mirror github.com/OpenIPC/u-boot-hi3516cv200), union `U_DATE_COEFF18`, struct offset 0xF248 (GPL-2.0, same-chip vendor header, byte-identical for Hi3516A V200 and Hi3519 V101). Reset value and access type unknown (modelled RW, no reset). Confidence: medium (vendor header for this chip family, not hardware verified).";

        field {
            name = "vps_data";
            desc = "[inferred] Vps data. (vendor header `product/hiosd/vo/hi3519/vou_reg.h` field `vps_data`; access and reset unknown, modelled RW)";
            sw = rw;
            hw = r;
        } vps_data[31:0];
    } DATE_COEFF18 @ 0xF248;

    reg {
        name = "DATE COEFF19";
        desc = "[inferred] DATE COEFF19. Not in the data sheet. Source: vendor U-Boot 2010.06 `product/hiosd/vo/hi3519/vou_reg.h` (GPL-2.0 U-Boot tree, HiSilicon copyright, created 2015-05-26; mirror github.com/OpenIPC/u-boot-hi3516cv200), union `U_DATE_COEFF19`, struct offset 0xF24C (GPL-2.0, same-chip vendor header, byte-identical for Hi3516A V200 and Hi3519 V101). Reset value and access type unknown (modelled RW, no reset). Confidence: medium (vendor header for this chip family, not hardware verified).";

        field {
            name = "vps_data";
            desc = "[inferred] Vps data. (vendor header `product/hiosd/vo/hi3519/vou_reg.h` field `vps_data`; access and reset unknown, modelled RW)";
            sw = rw;
            hw = r;
        } vps_data[15:0];
    } DATE_COEFF19 @ 0xF24C;

    reg {
        name = "DATE COEFF20";
        desc = "[inferred] DATE COEFF20. Not in the data sheet. Source: vendor U-Boot 2010.06 `product/hiosd/vo/hi3519/vou_reg.h` (GPL-2.0 U-Boot tree, HiSilicon copyright, created 2015-05-26; mirror github.com/OpenIPC/u-boot-hi3516cv200), union `U_DATE_COEFF20`, struct offset 0xF250 (GPL-2.0, same-chip vendor header, byte-identical for Hi3516A V200 and Hi3519 V101). Reset value and access type unknown (modelled RW, no reset). Confidence: medium (vendor header for this chip family, not hardware verified).";

        field {
            name = "tt06_enf1";
            desc = "[inferred] Tt06 enf1. (vendor header `product/hiosd/vo/hi3519/vou_reg.h` field `tt06_enf1`; access and reset unknown, modelled RW)";
            sw = rw;
            hw = r;
        } tt06_enf1[2:2];

        field {
            name = "tt06_enf2";
            desc = "[inferred] Tt06 enf2. (vendor header `product/hiosd/vo/hi3519/vou_reg.h` field `tt06_enf2`; access and reset unknown, modelled RW)";
            sw = rw;
            hw = r;
        } tt06_enf2[1:1];

        field {
            name = "tt05_enf2";
            desc = "[inferred] Tt05 enf2. (vendor header `product/hiosd/vo/hi3519/vou_reg.h` field `tt05_enf2`; access and reset unknown, modelled RW)";
            sw = rw;
            hw = r;
        } tt05_enf2[0:0];
    } DATE_COEFF20 @ 0xF250;

    reg {
        name = "Output matrix control register 21";
        desc = "DATE_COEFF21 is an output matrix control register.

Data sheet 9.2.6 DATE_COEFF21 (offset 0xF254, printed page 9-145, `hi3516av200--Hi3516AV200-Datasheet.txt` line 45627).";

        field {
            name = "dac5_in_sel";
            desc = "[inferred] Dac5 in select. (bits reserved in the data sheet; vendor header `product/hiosd/vo/hi3519/vou_reg.h` field `dac5_in_sel`; access and reset unknown, modelled RW)";
            sw = rw;
            hw = r;
        } dac5_in_sel[22:20];

        field {
            name = "dac4_in_sel";
            desc = "[inferred] Dac4 in select. (bits reserved in the data sheet; vendor header `product/hiosd/vo/hi3519/vou_reg.h` field `dac4_in_sel`; access and reset unknown, modelled RW)";
            sw = rw;
            hw = r;
        } dac4_in_sel[18:16];

        field {
            name = "dac3_in_sel";
            desc = "[inferred] Dac3 in select. (bits reserved in the data sheet; vendor header `product/hiosd/vo/hi3519/vou_reg.h` field `dac3_in_sel`; access and reset unknown, modelled RW)";
            sw = rw;
            hw = r;
        } dac3_in_sel[14:12];

        field {
            name = "dac2_in_sel";
            desc = "[inferred] Dac2 in select. (bits reserved in the data sheet; vendor header `product/hiosd/vo/hi3519/vou_reg.h` field `dac2_in_sel`; access and reset unknown, modelled RW)";
            sw = rw;
            hw = r;
        } dac2_in_sel[10:8];

        field {
            name = "dac1_in_sel";
            desc = "[inferred] Dac1 in select. (bits reserved in the data sheet; vendor header `product/hiosd/vo/hi3519/vou_reg.h` field `dac1_in_sel`; access and reset unknown, modelled RW)";
            sw = rw;
            hw = r;
        } dac1_in_sel[6:4];

        enum DATE_COEFF21_dac0_in_sel_enum {
            V_0 = 0 { name = "V 0"; desc = "0"; };
            CVBS = 1 { name = "Cvbs"; desc = "CVBS"; };
            G_Y = 2 { name = "G Y"; desc = "G/Y"; };
            B_PB = 3 { name = "B Pb"; desc = "B/Pb"; };
            R_PR = 4 { name = "R Pr"; desc = "R/Pr"; };
            SVIDEO_Y = 5 { name = "Svideo Y"; desc = "svideo_y"; };
            SVIDEO_C = 6 { name = "Svideo C"; desc = "svideo_c"; };
            V_0_2 = 7 { name = "V 0 2"; desc = "0"; };
        };

        field {
            name = "dac0_in_sel";
            desc = "DAC0 output mode";
            sw = rw;
            hw = r;
            encode = DATE_COEFF21_dac0_in_sel_enum;
            reset = 0x2;
        } dac0_in_sel[2:0];
    } DATE_COEFF21 @ 0xF254;

    reg {
        name = "Discrete time oscillator (DTO) initial phase 22 configuration register";
        desc = "DATE_COEFF22 is a DTO initial phase configuration register.

Data sheet 9.2.6 DATE_COEFF22 (offset 0xF258, printed page 9-146, `hi3516av200--Hi3516AV200-Datasheet.txt` line 45667).";

        field {
            name = "video_phase_delta";
            desc = "DTO initial phase";
            sw = rw;
            hw = r;
            reset = 0x0;
        } video_phase_delta[10:0];
    } DATE_COEFF22 @ 0xF258;

    reg {
        name = "VIDEO_OUT delay configuration register 23";
        desc = "DATE_COEFF23 is a VIDEO_OUT delay configuration register.

Data sheet 9.2.6 DATE_COEFF23 (offset 0xF25C, printed page 9-146, `hi3516av200--Hi3516AV200-Datasheet.txt` line 45687).";

        field {
            name = "dac5_out_dly";
            desc = "[inferred] Dac5 out delay. (bits reserved in the data sheet; vendor header `product/hiosd/vo/hi3519/vou_reg.h` field `dac5_out_dly`; access and reset unknown, modelled RW)";
            sw = rw;
            hw = r;
        } dac5_out_dly[22:20];

        field {
            name = "dac4_out_dly";
            desc = "[inferred] Dac4 out delay. (bits reserved in the data sheet; vendor header `product/hiosd/vo/hi3519/vou_reg.h` field `dac4_out_dly`; access and reset unknown, modelled RW)";
            sw = rw;
            hw = r;
        } dac4_out_dly[18:16];

        field {
            name = "dac3_out_dly";
            desc = "[inferred] Dac3 out delay. (bits reserved in the data sheet; vendor header `product/hiosd/vo/hi3519/vou_reg.h` field `dac3_out_dly`; access and reset unknown, modelled RW)";
            sw = rw;
            hw = r;
        } dac3_out_dly[14:12];

        field {
            name = "dac2_out_dly";
            desc = "[inferred] Dac2 out delay. (bits reserved in the data sheet; vendor header `product/hiosd/vo/hi3519/vou_reg.h` field `dac2_out_dly`; access and reset unknown, modelled RW)";
            sw = rw;
            hw = r;
        } dac2_out_dly[10:8];

        field {
            name = "dac1_out_dly";
            desc = "[inferred] Dac1 out delay. (bits reserved in the data sheet; vendor header `product/hiosd/vo/hi3519/vou_reg.h` field `dac1_out_dly`; access and reset unknown, modelled RW)";
            sw = rw;
            hw = r;
        } dac1_out_dly[6:4];

        field {
            name = "dac0_out_dly";
            desc = "DAC0 output delay cycle The value is measured by a 54 MHz clock cycle, and the value n indicates n delay cycles.";
            sw = rw;
            hw = r;
            reset = 0x0;
        } dac0_out_dly[2:0];
    } DATE_COEFF23 @ 0xF25C;

    reg {
        name = "Color burst start position register 24";
        desc = "DATE_COEFF24 is a color burst start position register. Hi3516A V200 Professional HD IP Camera SoC

Data sheet 9.2.6 DATE_COEFF24 (offset 0xF260, printed page 9-147, `hi3516av200--Hi3516AV200-Datasheet.txt` line 45725).";

        field {
            name = "burst_start";
            desc = "Color burst start position";
            sw = rw;
            hw = r;
            reset = 0x00012C99;
        } burst_start[31:0];
    } DATE_COEFF24 @ 0xF260;

    reg {
        name = "DATE COEFF25";
        desc = "[inferred] DATE COEFF25. Not in the data sheet. Source: vendor U-Boot 2010.06 `product/hiosd/vo/hi3519/vou_reg.h` (GPL-2.0 U-Boot tree, HiSilicon copyright, created 2015-05-26; mirror github.com/OpenIPC/u-boot-hi3516cv200), union `U_DATE_COEFF25`, struct offset 0xF264 (GPL-2.0, same-chip vendor header, byte-identical for Hi3516A V200 and Hi3519 V101). Reset value and access type unknown (modelled RW, no reset). Confidence: medium (vendor header for this chip family, not hardware verified).";

        field {
            name = "x_n_1_coef";
            desc = "[inferred] X n 1 coefficient. (vendor header `product/hiosd/vo/hi3519/vou_reg.h` field `x_n_1_coef`; access and reset unknown, modelled RW)";
            sw = rw;
            hw = r;
        } x_n_1_coef[28:16];

        field {
            name = "x_n_coef";
            desc = "[inferred] X n coefficient. (vendor header `product/hiosd/vo/hi3519/vou_reg.h` field `x_n_coef`; access and reset unknown, modelled RW)";
            sw = rw;
            hw = r;
        } x_n_coef[12:0];
    } DATE_COEFF25 @ 0xF264;

    reg {
        name = "DATE COEFF26";
        desc = "[inferred] DATE COEFF26. Not in the data sheet. Source: vendor U-Boot 2010.06 `product/hiosd/vo/hi3519/vou_reg.h` (GPL-2.0 U-Boot tree, HiSilicon copyright, created 2015-05-26; mirror github.com/OpenIPC/u-boot-hi3516cv200), union `U_DATE_COEFF26`, struct offset 0xF268 (GPL-2.0, same-chip vendor header, byte-identical for Hi3516A V200 and Hi3519 V101). Reset value and access type unknown (modelled RW, no reset). Confidence: medium (vendor header for this chip family, not hardware verified).";

        field {
            name = "x_n_1_coef";
            desc = "[inferred] X n 1 coefficient. (vendor header `product/hiosd/vo/hi3519/vou_reg.h` field `x_n_1_coef`; access and reset unknown, modelled RW)";
            sw = rw;
            hw = r;
        } x_n_1_coef[12:0];
    } DATE_COEFF26 @ 0xF268;

    reg {
        name = "DATE COEFF27";
        desc = "[inferred] DATE COEFF27. Not in the data sheet. Source: vendor U-Boot 2010.06 `product/hiosd/vo/hi3519/vou_reg.h` (GPL-2.0 U-Boot tree, HiSilicon copyright, created 2015-05-26; mirror github.com/OpenIPC/u-boot-hi3516cv200), union `U_DATE_COEFF27`, struct offset 0xF26C (GPL-2.0, same-chip vendor header, byte-identical for Hi3516A V200 and Hi3519 V101). Reset value and access type unknown (modelled RW, no reset). Confidence: medium (vendor header for this chip family, not hardware verified).";

        field {
            name = "y_n_1_coef";
            desc = "[inferred] Y n 1 coefficient. (vendor header `product/hiosd/vo/hi3519/vou_reg.h` field `y_n_1_coef`; access and reset unknown, modelled RW)";
            sw = rw;
            hw = r;
        } y_n_1_coef[26:16];

        field {
            name = "y_n_coef";
            desc = "[inferred] Y n coefficient. (vendor header `product/hiosd/vo/hi3519/vou_reg.h` field `y_n_coef`; access and reset unknown, modelled RW)";
            sw = rw;
            hw = r;
        } y_n_coef[10:0];
    } DATE_COEFF27 @ 0xF26C;

    reg {
        name = "DATE COEFF28";
        desc = "[inferred] DATE COEFF28. Not in the data sheet. Source: vendor U-Boot 2010.06 `product/hiosd/vo/hi3519/vou_reg.h` (GPL-2.0 U-Boot tree, HiSilicon copyright, created 2015-05-26; mirror github.com/OpenIPC/u-boot-hi3516cv200), union `U_DATE_COEFF28`, struct offset 0xF270 (GPL-2.0, same-chip vendor header, byte-identical for Hi3516A V200 and Hi3519 V101). Reset value and access type unknown (modelled RW, no reset). Confidence: medium (vendor header for this chip family, not hardware verified).";

        field {
            name = "pixel_begin2";
            desc = "[inferred] Pixel begin2. (vendor header `product/hiosd/vo/hi3519/vou_reg.h` field `pixel_begin2`; access and reset unknown, modelled RW)";
            sw = rw;
            hw = r;
        } pixel_begin2[26:16];

        field {
            name = "pixel_begin1";
            desc = "[inferred] Pixel begin1. (vendor header `product/hiosd/vo/hi3519/vou_reg.h` field `pixel_begin1`; access and reset unknown, modelled RW)";
            sw = rw;
            hw = r;
        } pixel_begin1[10:0];
    } DATE_COEFF28 @ 0xF270;

    reg {
        name = "DATE COEFF29";
        desc = "[inferred] DATE COEFF29. Not in the data sheet. Source: vendor U-Boot 2010.06 `product/hiosd/vo/hi3519/vou_reg.h` (GPL-2.0 U-Boot tree, HiSilicon copyright, created 2015-05-26; mirror github.com/OpenIPC/u-boot-hi3516cv200), union `U_DATE_COEFF29`, struct offset 0xF274 (GPL-2.0, same-chip vendor header, byte-identical for Hi3516A V200 and Hi3519 V101). Reset value and access type unknown (modelled RW, no reset). Confidence: medium (vendor header for this chip family, not hardware verified).";

        field {
            name = "pixel_end";
            desc = "[inferred] Pixel end. (vendor header `product/hiosd/vo/hi3519/vou_reg.h` field `pixel_end`; access and reset unknown, modelled RW)";
            sw = rw;
            hw = r;
        } pixel_end[10:0];
    } DATE_COEFF29 @ 0xF274;

    reg {
        name = "DATE COEFF30";
        desc = "[inferred] DATE COEFF30. Not in the data sheet. Source: vendor U-Boot 2010.06 `product/hiosd/vo/hi3519/vou_reg.h` (GPL-2.0 U-Boot tree, HiSilicon copyright, created 2015-05-26; mirror github.com/OpenIPC/u-boot-hi3516cv200), union `U_DATE_COEFF30`, struct offset 0xF278 (GPL-2.0, same-chip vendor header, byte-identical for Hi3516A V200 and Hi3519 V101). Reset value and access type unknown (modelled RW, no reset). Confidence: medium (vendor header for this chip family, not hardware verified).";

        field {
            name = "g_secam";
            desc = "[inferred] G secam. (vendor header `product/hiosd/vo/hi3519/vou_reg.h` field `g_secam`; access and reset unknown, modelled RW)";
            sw = rw;
            hw = r;
        } g_secam[6:0];
    } DATE_COEFF30 @ 0xF278;

    reg {
        name = "Interrupt mask register ASK";
        desc = "DATE_ISRMASK is an interrupt mask register.

Data sheet 9.2.6 DATE_ISRMASK (offset 0xF280, printed page 9-147, `hi3516av200--Hi3516AV200-Datasheet.txt` line 45743).";

        enum DATE_ISRMASK_tt_mask_enum {
            ENABLED = 0 { name = "Enabled"; desc = "enabled"; };
            MASKED = 1 { name = "Masked"; desc = "masked"; };
        };

        field {
            name = "tt_mask";
            desc = "Teletext interrupt mask";
            sw = rw;
            hw = r;
            encode = DATE_ISRMASK_tt_mask_enum;
            reset = 0x0;
        } tt_mask[0:0];
    } DATE_ISRMASK @ 0xF280;

    reg {
        name = "Interrupt status register ATE";
        desc = "DATE_ISRSTATE is an interrupt status register.

Data sheet 9.2.6 DATE_ISRSTATE (offset 0xF284, printed page 9-147, `hi3516av200--Hi3516AV200-Datasheet.txt` line 45767).";

        field {
            name = "tt_status";
            desc = "Teletext interrupt status After the DATE module reads all the teletext data, the bit is set to 1. Writing 1 to this bit clears the interrupt.";
            sw = rw;
            hw = w;
            onwrite = woclr;
            reset = 0x0;
        } tt_status[0:0];
    } DATE_ISRSTATE @ 0xF284;

    reg {
        name = "Interrupt register";
        desc = "DATE_ISR is an interrupt register.

Data sheet 9.2.6 DATE_ISR (offset 0xF288, printed page 9-148, `hi3516av200--Hi3516AV200-Datasheet.txt` line 45800).";

        field {
            name = "tt_int";
            desc = "Teletext interrupt. It shows the interrupt status after tt_status is masked by tt_mask.";
            sw = r;
            hw = w;
            reset = 0x0;
        } tt_int[0:0];
    } DATE_ISR @ 0xF288;

    reg {
        name = "DATE VERSION";
        desc = "[inferred] DATE VERSION. Not in the data sheet. Source: vendor U-Boot 2010.06 `product/hiosd/vo/hi3519/vou_reg.h` (GPL-2.0 U-Boot tree, HiSilicon copyright, created 2015-05-26; mirror github.com/OpenIPC/u-boot-hi3516cv200), union `U_DATE_VERSION`, struct offset 0xF290 (GPL-2.0, same-chip vendor header, byte-identical for Hi3516A V200 and Hi3519 V101). Reset value and access type unknown (modelled RW, no reset). Confidence: medium (vendor header for this chip family, not hardware verified).";

        field {
            name = "value";
            desc = "[inferred] Register value (the header union has no named bits).";
            sw = rw;
            hw = r;
        } value[31:0];
    } DATE_VERSION @ 0xF290;

    reg {
        name = "Up-sampling filtering coefficient 1 register 37";
        desc = "DATE_COEFF37 is an up-sampling filtering coefficient 1 register.

Data sheet 9.2.6 DATE_COEFF37 (offset 0xF294, printed page 9-148, `hi3516av200--Hi3516AV200-Datasheet.txt` line 45824).";

        field {
            name = "fir_y1_coeff3";
            desc = "Coefficient 13 for luminance up-sampling and filtering";
            sw = rw;
            hw = r;
            reset = 0x19;
        } fir_y1_coeff3[31:24];

        field {
            name = "fir_y1_coeff2";
            desc = "Coefficient 12 for luminance up-sampling and filtering";
            sw = rw;
            hw = r;
            reset = 0xEF;
        } fir_y1_coeff2[23:16];

        field {
            name = "fir_y1_coeff1";
            desc = "Coefficient 11 for luminance up-sampling and filtering";
            sw = rw;
            hw = r;
            reset = 0xC;
        } fir_y1_coeff1[15:8];

        field {
            name = "fir_y1_coeff0";
            desc = "Coefficient 10 for luminance up-sampling and filtering";
            sw = rw;
            hw = r;
            reset = 0xF9;
        } fir_y1_coeff0[7:0];
    } DATE_COEFF37 @ 0xF294;

    reg {
        name = "Up-sampling filtering coefficient 2 register 38";
        desc = "DATE_COEFF38 is an up-sampling filtering coefficient 2 register.

Data sheet 9.2.6 DATE_COEFF38 (offset 0xF298, printed page 9-149, `hi3516av200--Hi3516AV200-Datasheet.txt` line 45853).";

        field {
            name = "fir_y2_coeff1";
            desc = "Coefficient 21 for luminance up-sampling and filtering";
            sw = rw;
            hw = r;
            reset = 0x3A;
        } fir_y2_coeff1[31:16];

        field {
            name = "fir_y2_coeff0";
            desc = "Coefficient 20 for luminance up-sampling and filtering";
            sw = rw;
            hw = r;
            reset = 0xFFDA;
        } fir_y2_coeff0[15:0];
    } DATE_COEFF38 @ 0xF298;

    reg {
        name = "Up-sampling filtering coefficient 3 register 39";
        desc = "DATE_COEFF39 is an up-sampling filtering coefficient 3 register.

Data sheet 9.2.6 DATE_COEFF39 (offset 0xF29C, printed page 9-149, `hi3516av200--Hi3516AV200-Datasheet.txt` line 45873).";

        field {
            name = "fir_y2_coeff3";
            desc = "Coefficient 23 for luminance up-sampling and filtering";
            sw = rw;
            hw = r;
            reset = 0x148;
        } fir_y2_coeff3[31:16];

        field {
            name = "fir_y2_coeff2";
            desc = "Coefficient 22 for luminance up-sampling and filtering";
            sw = rw;
            hw = r;
            reset = 0xFF97;
        } fir_y2_coeff2[15:0];
    } DATE_COEFF39 @ 0xF29C;

    reg {
        name = "Up-sampling filtering coefficient 4 register 40";
        desc = "DATE_COEFF40 is an up-sampling filtering coefficient 4 register.

Data sheet 9.2.6 DATE_COEFF40 (offset 0xF2A0, printed page 9-149, `hi3516av200--Hi3516AV200-Datasheet.txt` line 45892).";

        field {
            name = "fir_c1_coeff3";
            desc = "Coefficient 13 for chrominance up-sampling and filtering";
            sw = rw;
            hw = r;
            reset = 0x19;
        } fir_c1_coeff3[31:24];

        field {
            name = "fir_c1_coeff2";
            desc = "Coefficient 12 for chrominance up-sampling and filtering";
            sw = rw;
            hw = r;
            reset = 0xEF;
        } fir_c1_coeff2[23:16];

        field {
            name = "fir_c1_coeff1";
            desc = "Coefficient 11 for chrominance up-sampling and filtering";
            sw = rw;
            hw = r;
            reset = 0xC;
        } fir_c1_coeff1[15:8];

        field {
            name = "fir_c1_coeff0";
            desc = "Coefficient 10 for chrominance up-sampling and filtering";
            sw = rw;
            hw = r;
            reset = 0xF9;
        } fir_c1_coeff0[7:0];
    } DATE_COEFF40 @ 0xF2A0;

    reg {
        name = "Up-sampling filtering coefficient 5 register 41";
        desc = "DATE_COEFF41 is an up-sampling filtering coefficient 5 register.

Data sheet 9.2.6 DATE_COEFF41 (offset 0xF2A4, printed page 9-150, `hi3516av200--Hi3516AV200-Datasheet.txt` line 45923).";

        field {
            name = "fir_c2_coeff1";
            desc = "Coefficient 21 for chrominance up-sampling and filtering";
            sw = rw;
            hw = r;
            reset = 0x3A;
        } fir_c2_coeff1[31:16];

        field {
            name = "fir_c2_coeff0";
            desc = "Coefficient 20 for chrominance up-sampling and filtering";
            sw = rw;
            hw = r;
            reset = 0xFFDA;
        } fir_c2_coeff0[15:0];
    } DATE_COEFF41 @ 0xF2A4;

    reg {
        name = "Up-sampling filtering coefficient 6 register 42";
        desc = "DATE_COEFF42 is an up-sampling filtering coefficient 6 register.

Data sheet 9.2.6 DATE_COEFF42 (offset 0xF2A8, printed page 9-150, `hi3516av200--Hi3516AV200-Datasheet.txt` line 45942).";

        field {
            name = "fir_c2_coeff3";
            desc = "Coefficient 23 for chrominance up-sampling and filtering";
            sw = rw;
            hw = r;
            reset = 0x148;
        } fir_c2_coeff3[31:16];

        field {
            name = "fir_c2_coeff2";
            desc = "Coefficient 22 for chrominance up-sampling and filtering";
            sw = rw;
            hw = r;
            reset = 0xFF97;
        } fir_c2_coeff2[15:0];
    } DATE_COEFF42 @ 0xF2A8;

    reg {
        name = "DAC automatic detection register 1 ET1";
        desc = "DATE_DACDET1 is DAC automatic detection register 1.

Data sheet 9.2.6 DATE_DACDET1 (offset 0xF2C0, printed page 9-151, `hi3516av200--Hi3516AV200-Datasheet.txt` line 45968).";

        field {
            name = "det_line";
            desc = "Line of the detected level";
            sw = rw;
            hw = r;
            reset = 0xD;
        } det_line[25:16];

        field {
            name = "vdac_det_high";
            desc = "Detected level";
            sw = rw;
            hw = r;
            reset = 0x303;
        } vdac_det_high[9:0];
    } DATE_DACDET1 @ 0xF2C0;

    reg {
        name = "DAC automatic detection register 2 ET2";
        desc = "DATE_DACDET2 is DAC automatic detection register 2.

Data sheet 9.2.6 DATE_DACDET2 (offset 0xF2C4, printed page 9-151, `hi3516av200--Hi3516AV200-Datasheet.txt` line 45990).";

        enum DATE_DACDET2_vdac_det_en_enum {
            DISABLED = 0 { name = "Disabled"; desc = "disabled"; };
            ENABLED = 1 { name = "Enabled"; desc = "enabled"; };
        };

        field {
            name = "vdac_det_en";
            desc = "DAC automatic detection enable";
            sw = rw;
            hw = r;
            encode = DATE_DACDET2_vdac_det_en_enum;
            reset = 0x0;
        } vdac_det_en[31:31];

        field {
            name = "det_pixel_wid";
            desc = "Level width";
            sw = rw;
            hw = r;
            reset = 0x30;
        } det_pixel_wid[26:16];

        field {
            name = "det_pixel_sta";
            desc = "Start position of a line";
            sw = rw;
            hw = r;
            reset = 0x118;
        } det_pixel_sta[10:0];
    } DATE_DACDET2 @ 0xF2C4;

    reg {
        name = "Over-sampling filtering coefficient 1 50 register";
        desc = "DATE_COEFF50 is an over-sampling filtering coefficient 1 register.

Data sheet 9.2.6 DATE_COEFF50 (offset 0xF2C8, printed page 9-152, `hi3516av200--Hi3516AV200-Datasheet.txt` line 46027).";

        field {
            name = "ovs_coeff1";
            desc = "Coefficient 11 for luminance over-sampling and filtering";
            sw = rw;
            hw = r;
            reset = 0x7FF;
        } ovs_coeff1[26:16];

        field {
            name = "ovs_coeff0";
            desc = "Coefficient 10 for luminance over-sampling and filtering";
            sw = rw;
            hw = r;
            reset = 0x7FF;
        } ovs_coeff0[10:0];
    } DATE_COEFF50 @ 0xF2C8;

    reg {
        name = "Over-sampling filtering coefficient 2 51 register";
        desc = "DATE_COEFF51 is an over-sampling filtering coefficient 2 register.

Data sheet 9.2.6 DATE_COEFF51 (offset 0xF2CC, printed page 9-152, `hi3516av200--Hi3516AV200-Datasheet.txt` line 46049).";

        field {
            name = "ovs_coeff1";
            desc = "Coefficient 21 for luminance over-sampling and filtering";
            sw = rw;
            hw = r;
            reset = 0x7FF;
        } ovs_coeff1[26:16];

        field {
            name = "ovs_coeff0";
            desc = "Coefficient 20 for luminance over-sampling and filtering";
            sw = rw;
            hw = r;
            reset = 0x204;
        } ovs_coeff0[10:0];
    } DATE_COEFF51 @ 0xF2CC;

    reg {
        name = "Over-sampling filtering coefficient 3 52 register";
        desc = "DATE_COEFF52 is an over-sampling filtering coefficient 3 register. Hi3516A V200 Professional HD IP Camera SoC

Data sheet 9.2.6 DATE_COEFF52 (offset 0xF2D0, printed page 9-153, `hi3516av200--Hi3516AV200-Datasheet.txt` line 46081).";

        field {
            name = "ovs_coeff1";
            desc = "Coefficient 31 for luminance over-sampling and filtering";
            sw = rw;
            hw = r;
            reset = 0x0;
        } ovs_coeff1[26:16];

        field {
            name = "ovs_coeff0";
            desc = "Coefficient 30 for luminance over-sampling and filtering";
            sw = rw;
            hw = r;
            reset = 0x7FF;
        } ovs_coeff0[10:0];
    } DATE_COEFF52 @ 0xF2D0;

    reg {
        name = "Over-sampling filtering coefficient 4 53 register";
        desc = "DATE_COEFF53 is an over-sampling filtering coefficient 4 register.

Data sheet 9.2.6 DATE_COEFF53 (offset 0xF2D4, printed page 9-153, `hi3516av200--Hi3516AV200-Datasheet.txt` line 46102).";

        field {
            name = "ovs_coeff1";
            desc = "Coefficient 41 for luminance over-sampling and filtering";
            sw = rw;
            hw = r;
            reset = 0x7BF;
        } ovs_coeff1[26:16];

        field {
            name = "ovs_coeff0";
            desc = "Coefficient 40 for luminance over-sampling and filtering";
            sw = rw;
            hw = r;
            reset = 0xC;
        } ovs_coeff0[10:0];
    } DATE_COEFF53 @ 0xF2D4;

    reg {
        name = "Over-sampling filtering coefficient 5 54 register";
        desc = "DATE_COEFF54 is an over-sampling filtering coefficient 5 register.

Data sheet 9.2.6 DATE_COEFF54 (offset 0xF2D8, printed page 9-153, `hi3516av200--Hi3516AV200-Datasheet.txt` line 46124).";

        field {
            name = "ovs_coeff1";
            desc = "Coefficient 51 for luminance over-sampling and filtering";
            sw = rw;
            hw = r;
            reset = 0x135;
        } ovs_coeff1[26:16];

        field {
            name = "ovs_coeff0";
            desc = "Coefficient 50 for luminance over-sampling and filtering";
            sw = rw;
            hw = r;
            reset = 0x135;
        } ovs_coeff0[10:0];
    } DATE_COEFF54 @ 0xF2D8;

    reg {
        name = "Over-sampling filtering coefficient 6 55 register";
        desc = "DATE_COEFF55 is an over-sampling filtering coefficient 6 register.

Data sheet 9.2.6 DATE_COEFF55 (offset 0xF2DC, printed page 9-154, `hi3516av200--Hi3516AV200-Datasheet.txt` line 46155).";

        field {
            name = "ovs_coeff1";
            desc = "Coefficient 61 for luminance over-sampling and filtering";
            sw = rw;
            hw = r;
            reset = 0xC;
        } ovs_coeff1[26:16];

        field {
            name = "ovs_coeff0";
            desc = "Coefficient 60 for luminance over-sampling and filtering";
            sw = rw;
            hw = r;
            reset = 0x7BF;
        } ovs_coeff0[10:0];
    } DATE_COEFF55 @ 0xF2DC;

    reg {
        name = "Over-sampling round-off register 56";
        desc = "DATE_COEFF56 is an over-sampling round-off register. Hi3516A V200 Professional HD IP Camera SoC

Data sheet 9.2.6 DATE_COEFF56 (offset 0xF2E0, printed page 9-155, `hi3516av200--Hi3516AV200-Datasheet.txt` line 46186).";

        enum DATE_COEFF56_oversam2_round_en_enum {
            DISABLED = 0 { name = "Disabled"; desc = "disabled"; };
            ENABLED = 1 { name = "Enabled"; desc = "enabled"; };
        };

        field {
            name = "oversam2_round_en";
            desc = "Round-off enable during 2x up-sampling";
            sw = rw;
            hw = r;
            encode = DATE_COEFF56_oversam2_round_en_enum;
            reset = 0x1;
        } oversam2_round_en[0:0];
    } DATE_COEFF56 @ 0xF2E0;

    reg {
        name = "CVBS gain control register 57";
        desc = "DATE_COEFF57 is a CVBS gain control register.

Data sheet 9.2.6 DATE_COEFF57 (offset 0xF2E4, printed page 9-155, `hi3516av200--Hi3516AV200-Datasheet.txt` line 46216).";

        enum DATE_COEFF57_cvbs_gain_en_enum {
            DISABLED = 0 { name = "Disabled"; desc = "disabled"; };
            ENABLED = 1 { name = "Enabled"; desc = "enabled"; };
        };

        field {
            name = "cvbs_gain_en";
            desc = "CVBS gain enable";
            sw = rw;
            hw = r;
            encode = DATE_COEFF57_cvbs_gain_en_enum;
            reset = 0x0;
        } cvbs_gain_en[31:31];

        field {
            name = "ycvbs_gain";
            desc = "Gain control of the luminance component Y";
            sw = rw;
            hw = r;
            reset = 0x80;
        } ycvbs_gain[23:16];

        field {
            name = "u_gain";
            desc = "Gain control of the chrominance component U";
            sw = rw;
            hw = r;
            reset = 0x80;
        } u_gain[15:8];

        field {
            name = "v_gain";
            desc = "Gain control of the chrominance component V";
            sw = rw;
            hw = r;
            reset = 0x80;
        } v_gain[7:0];
    } DATE_COEFF57 @ 0xF2E4;

    reg {
        name = "Component gain control register 58";
        desc = "DATE_COEFF58 is a component gain control register.

Data sheet 9.2.6 DATE_COEFF58 (offset 0xF2E8, printed page 9-156, `hi3516av200--Hi3516AV200-Datasheet.txt` line 46258).";

        enum DATE_COEFF58_comp_gain_en_enum {
            DISABLED = 0 { name = "Disabled"; desc = "disabled"; };
            ENABLED = 1 { name = "Enabled"; desc = "enabled"; };
        };

        field {
            name = "comp_gain_en";
            desc = "Component gain enable";
            sw = rw;
            hw = r;
            encode = DATE_COEFF58_comp_gain_en_enum;
            reset = 0x0;
        } comp_gain_en[31:31];

        field {
            name = "ycomp_gain";
            desc = "Gain control of the luminance component Y";
            sw = rw;
            hw = r;
            reset = 0x80;
        } ycomp_gain[23:16];

        field {
            name = "pb_gain";
            desc = "Gain control of the chrominance component U";
            sw = rw;
            hw = r;
            reset = 0x80;
        } pb_gain[15:8];

        field {
            name = "pr_gain";
            desc = "Gain control of the chrominance component V";
            sw = rw;
            hw = r;
            reset = 0x80;
        } pr_gain[7:0];
    } DATE_COEFF58 @ 0xF2E8;

    reg {
        name = "Clip control bit register 59";
        desc = "DATE_COEFF59 is a clip control bit register. Hi3516A V200 Professional HD IP Camera SoC

Data sheet 9.2.6 DATE_COEFF59 (offset 0xF2EC, printed page 9-157, `hi3516av200--Hi3516AV200-Datasheet.txt` line 46300).";

        enum DATE_COEFF59_cb_gain_polar_enum {
            NEGATIVE_GAIN = 0 { name = "Negative Gain"; desc = "negative gain"; };
            POSITIVE_GAIN = 1 { name = "Positive Gain"; desc = "positive gain"; };
        };

        field {
            name = "cb_gain_polar";
            desc = "Chrominance subcarrier polarity control";
            sw = rw;
            hw = r;
            encode = DATE_COEFF59_cb_gain_polar_enum;
            reset = 0x1;
        } cb_gain_polar[16:16];

        enum DATE_COEFF59_cr_os_clip_fullrange_enum {
            DISABLED = 0 { name = "Disabled"; desc = "disabled"; };
            ENABLED = 1 { name = "Enabled"; desc = "enabled"; };
        };

        field {
            name = "cr_os_clip_fullrange";
            desc = "Cr component clip enable on the up-sampling module";
            sw = rw;
            hw = r;
            encode = DATE_COEFF59_cr_os_clip_fullrange_enum;
            reset = 0x0;
        } cr_os_clip_fullrange[13:13];

        enum DATE_COEFF59_cb_os_clip_fullrange_enum {
            DISABLED = 0 { name = "Disabled"; desc = "disabled"; };
            ENABLED = 1 { name = "Enabled"; desc = "enabled"; };
        };

        field {
            name = "cb_os_clip_fullrange";
            desc = "Cb component clip enable on the up-sampling module";
            sw = rw;
            hw = r;
            encode = DATE_COEFF59_cb_os_clip_fullrange_enum;
            reset = 0x0;
        } cb_os_clip_fullrange[12:12];

        enum DATE_COEFF59_v_os_clip_fullrange_enum {
            DISABLED = 0 { name = "Disabled"; desc = "disabled"; };
            ENABLED = 1 { name = "Enabled"; desc = "enabled"; };
        };

        field {
            name = "v_os_clip_fullrange";
            desc = "V component clip enable on the up-sampling module";
            sw = rw;
            hw = r;
            encode = DATE_COEFF59_v_os_clip_fullrange_enum;
            reset = 0x0;
        } v_os_clip_fullrange[9:9];

        enum DATE_COEFF59_u_os_clip_fullrange_enum {
            DISABLED = 0 { name = "Disabled"; desc = "disabled"; };
            ENABLED = 1 { name = "Enabled"; desc = "enabled"; };
        };

        field {
            name = "u_os_clip_fullrange";
            desc = "U component clip enable on the up-sampling module";
            sw = rw;
            hw = r;
            encode = DATE_COEFF59_u_os_clip_fullrange_enum;
            reset = 0x0;
        } u_os_clip_fullrange[8:8];

        enum DATE_COEFF59_y_os_clip_fullrange_enum {
            DISABLED = 0 { name = "Disabled"; desc = "disabled"; };
            ENABLED = 1 { name = "Enabled"; desc = "enabled"; };
        };

        field {
            name = "y_os_clip_fullrange";
            desc = "Y component clip enable on the up-sampling module";
            sw = rw;
            hw = r;
            encode = DATE_COEFF59_y_os_clip_fullrange_enum;
            reset = 0x0;
        } y_os_clip_fullrange[4:4];

        enum DATE_COEFF59_clpf_clip_fullrange_enum {
            DISABLED = 0 { name = "Disabled"; desc = "disabled"; };
            ENABLED = 1 { name = "Enabled"; desc = "enabled"; };
        };

        field {
            name = "clpf_clip_fullrange";
            desc = "Chrominance low-pass module clip enable";
            sw = rw;
            hw = r;
            encode = DATE_COEFF59_clpf_clip_fullrange_enum;
            reset = 0x0;
        } clpf_clip_fullrange[1:1];

        enum DATE_COEFF59_ynotch_clip_fullrange_enum {
            DISABLED = 0 { name = "Disabled"; desc = "disabled"; };
            ENABLED = 1 { name = "Enabled"; desc = "enabled"; };
        };

        field {
            name = "ynotch_clip_fullrange";
            desc = "Luminance notch module clip enable.";
            sw = rw;
            hw = r;
            encode = DATE_COEFF59_ynotch_clip_fullrange_enum;
            reset = 0x0;
        } ynotch_clip_fullrange[0:0];
    } DATE_COEFF59 @ 0xF2EC;

    reg {
        name = "DATE COEFF60";
        desc = "[inferred] DATE COEFF60. Not in the data sheet. Source: vendor U-Boot 2010.06 `product/hiosd/vo/hi3519/vou_reg.h` (GPL-2.0 U-Boot tree, HiSilicon copyright, created 2015-05-26; mirror github.com/OpenIPC/u-boot-hi3516cv200), union `U_DATE_COEFF60`, struct offset 0xF2F0 (GPL-2.0, same-chip vendor header, byte-identical for Hi3516A V200 and Hi3519 V101). Reset value and access type unknown (modelled RW, no reset). Confidence: medium (vendor header for this chip family, not hardware verified).";

        field {
            name = "line_960h_en";
            desc = "[inferred] Line 960h enable. (vendor header `product/hiosd/vo/hi3519/vou_reg.h` field `line_960h_en`; access and reset unknown, modelled RW)";
            sw = rw;
            hw = r;
        } line_960h_en[0:0];
    } DATE_COEFF60 @ 0xF2F0;

    reg {
        name = "DATE COEFF61";
        desc = "[inferred] DATE COEFF61. Not in the data sheet. Source: vendor U-Boot 2010.06 `product/hiosd/vo/hi3519/vou_reg.h` (GPL-2.0 U-Boot tree, HiSilicon copyright, created 2015-05-26; mirror github.com/OpenIPC/u-boot-hi3516cv200), union `U_DATE_COEFF61`, struct offset 0xF2F4 (GPL-2.0, same-chip vendor header, byte-identical for Hi3516A V200 and Hi3519 V101). Reset value and access type unknown (modelled RW, no reset). Confidence: medium (vendor header for this chip family, not hardware verified).";

        field {
            name = "rgb_acrive_ovrd";
            desc = "[inferred] Rgb acrive ovrd. (vendor header `product/hiosd/vo/hi3519/vou_reg.h` field `rgb_acrive_ovrd`; access and reset unknown, modelled RW)";
            sw = rw;
            hw = r;
        } rgb_acrive_ovrd[4:4];

        field {
            name = "pal_half_ovrd";
            desc = "[inferred] Pal half ovrd. (vendor header `product/hiosd/vo/hi3519/vou_reg.h` field `pal_half_ovrd`; access and reset unknown, modelled RW)";
            sw = rw;
            hw = r;
        } pal_half_ovrd[3:3];

        field {
            name = "cb_bound_ovrd";
            desc = "[inferred] Cb bound ovrd. (vendor header `product/hiosd/vo/hi3519/vou_reg.h` field `cb_bound_ovrd`; access and reset unknown, modelled RW)";
            sw = rw;
            hw = r;
        } cb_bound_ovrd[2:2];

        field {
            name = "burst_dura_ovrd";
            desc = "[inferred] Burst dura ovrd. (vendor header `product/hiosd/vo/hi3519/vou_reg.h` field `burst_dura_ovrd`; access and reset unknown, modelled RW)";
            sw = rw;
            hw = r;
        } burst_dura_ovrd[1:1];

        field {
            name = "burst_start_ovrd";
            desc = "[inferred] Burst start ovrd. (vendor header `product/hiosd/vo/hi3519/vou_reg.h` field `burst_start_ovrd`; access and reset unknown, modelled RW)";
            sw = rw;
            hw = r;
        } burst_start_ovrd[0:0];
    } DATE_COEFF61 @ 0xF2F4;

    reg {
        name = "DATE COEFF62";
        desc = "[inferred] DATE COEFF62. Not in the data sheet. Source: vendor U-Boot 2010.06 `product/hiosd/vo/hi3519/vou_reg.h` (GPL-2.0 U-Boot tree, HiSilicon copyright, created 2015-05-26; mirror github.com/OpenIPC/u-boot-hi3516cv200), union `U_DATE_COEFF62`, struct offset 0xF2F8 (GPL-2.0, same-chip vendor header, byte-identical for Hi3516A V200 and Hi3519 V101). Reset value and access type unknown (modelled RW, no reset). Confidence: medium (vendor header for this chip family, not hardware verified).";

        field {
            name = "burst_dura_coeff";
            desc = "[inferred] Burst dura coefficient. (vendor header `product/hiosd/vo/hi3519/vou_reg.h` field `burst_dura_coeff`; access and reset unknown, modelled RW)";
            sw = rw;
            hw = r;
        } burst_dura_coeff[31:0];
    } DATE_COEFF62 @ 0xF2F8;

    reg {
        name = "DATE COEFF63";
        desc = "[inferred] DATE COEFF63. Not in the data sheet. Source: vendor U-Boot 2010.06 `product/hiosd/vo/hi3519/vou_reg.h` (GPL-2.0 U-Boot tree, HiSilicon copyright, created 2015-05-26; mirror github.com/OpenIPC/u-boot-hi3516cv200), union `U_DATE_COEFF63`, struct offset 0xF2FC (GPL-2.0, same-chip vendor header, byte-identical for Hi3516A V200 and Hi3519 V101). Reset value and access type unknown (modelled RW, no reset). Confidence: medium (vendor header for this chip family, not hardware verified).";

        field {
            name = "cb_bound_coeff";
            desc = "[inferred] Cb bound coefficient. (vendor header `product/hiosd/vo/hi3519/vou_reg.h` field `cb_bound_coeff`; access and reset unknown, modelled RW)";
            sw = rw;
            hw = r;
        } cb_bound_coeff[31:0];
    } DATE_COEFF63 @ 0xF2FC;

    reg {
        name = "DATE COEFF64";
        desc = "[inferred] DATE COEFF64. Not in the data sheet. Source: vendor U-Boot 2010.06 `product/hiosd/vo/hi3519/vou_reg.h` (GPL-2.0 U-Boot tree, HiSilicon copyright, created 2015-05-26; mirror github.com/OpenIPC/u-boot-hi3516cv200), union `U_DATE_COEFF64`, struct offset 0xF300 (GPL-2.0, same-chip vendor header, byte-identical for Hi3516A V200 and Hi3519 V101). Reset value and access type unknown (modelled RW, no reset). Confidence: medium (vendor header for this chip family, not hardware verified).";

        field {
            name = "pal_half_coeff";
            desc = "[inferred] Pal half coefficient. (vendor header `product/hiosd/vo/hi3519/vou_reg.h` field `pal_half_coeff`; access and reset unknown, modelled RW)";
            sw = rw;
            hw = r;
        } pal_half_coeff[31:0];
    } DATE_COEFF64 @ 0xF300;

    reg {
        name = "DATE COEFF65";
        desc = "[inferred] DATE COEFF65. Not in the data sheet. Source: vendor U-Boot 2010.06 `product/hiosd/vo/hi3519/vou_reg.h` (GPL-2.0 U-Boot tree, HiSilicon copyright, created 2015-05-26; mirror github.com/OpenIPC/u-boot-hi3516cv200), union `U_DATE_COEFF65`, struct offset 0xF304 (GPL-2.0, same-chip vendor header, byte-identical for Hi3516A V200 and Hi3519 V101). Reset value and access type unknown (modelled RW, no reset). Confidence: medium (vendor header for this chip family, not hardware verified).";

        field {
            name = "rgb_active_coeff";
            desc = "[inferred] Rgb active coefficient. (vendor header `product/hiosd/vo/hi3519/vou_reg.h` field `rgb_active_coeff`; access and reset unknown, modelled RW)";
            sw = rw;
            hw = r;
        } rgb_active_coeff[31:0];
    } DATE_COEFF65 @ 0xF304;

    reg {
        name = "DATE COEFF66";
        desc = "[inferred] DATE COEFF66. Not in the data sheet. Source: vendor U-Boot 2010.06 `product/hiosd/vo/hi3519/vou_reg.h` (GPL-2.0 U-Boot tree, HiSilicon copyright, created 2015-05-26; mirror github.com/OpenIPC/u-boot-hi3516cv200), union `U_DATE_COEFF66`, struct offset 0xF308 (GPL-2.0, same-chip vendor header, byte-identical for Hi3516A V200 and Hi3519 V101). Reset value and access type unknown (modelled RW, no reset). Confidence: medium (vendor header for this chip family, not hardware verified).";

        field {
            name = "wid_act_ovrd";
            desc = "[inferred] Width act ovrd. (vendor header `product/hiosd/vo/hi3519/vou_reg.h` field `wid_act_ovrd`; access and reset unknown, modelled RW)";
            sw = rw;
            hw = r;
        } wid_act_ovrd[3:3];

        field {
            name = "wid_hfb_ovrd";
            desc = "[inferred] Width hfb ovrd. (vendor header `product/hiosd/vo/hi3519/vou_reg.h` field `wid_hfb_ovrd`; access and reset unknown, modelled RW)";
            sw = rw;
            hw = r;
        } wid_hfb_ovrd[2:2];

        field {
            name = "wid_sync_ovrd";
            desc = "[inferred] Width sync ovrd. (vendor header `product/hiosd/vo/hi3519/vou_reg.h` field `wid_sync_ovrd`; access and reset unknown, modelled RW)";
            sw = rw;
            hw = r;
        } wid_sync_ovrd[1:1];

        field {
            name = "htotal_ovrd";
            desc = "[inferred] Htotal ovrd. (vendor header `product/hiosd/vo/hi3519/vou_reg.h` field `htotal_ovrd`; access and reset unknown, modelled RW)";
            sw = rw;
            hw = r;
        } htotal_ovrd[0:0];
    } DATE_COEFF66 @ 0xF308;

    reg {
        name = "DATE COEFF67";
        desc = "[inferred] DATE COEFF67. Not in the data sheet. Source: vendor U-Boot 2010.06 `product/hiosd/vo/hi3519/vou_reg.h` (GPL-2.0 U-Boot tree, HiSilicon copyright, created 2015-05-26; mirror github.com/OpenIPC/u-boot-hi3516cv200), union `U_DATE_COEFF67`, struct offset 0xF30C (GPL-2.0, same-chip vendor header, byte-identical for Hi3516A V200 and Hi3519 V101). Reset value and access type unknown (modelled RW, no reset). Confidence: medium (vendor header for this chip family, not hardware verified).";

        field {
            name = "htotal_sw";
            desc = "[inferred] Htotal sw. (vendor header `product/hiosd/vo/hi3519/vou_reg.h` field `htotal_sw`; access and reset unknown, modelled RW)";
            sw = rw;
            hw = r;
        } htotal_sw[11:0];
    } DATE_COEFF67 @ 0xF30C;

    reg {
        name = "DATE COEFF68";
        desc = "[inferred] DATE COEFF68. Not in the data sheet. Source: vendor U-Boot 2010.06 `product/hiosd/vo/hi3519/vou_reg.h` (GPL-2.0 U-Boot tree, HiSilicon copyright, created 2015-05-26; mirror github.com/OpenIPC/u-boot-hi3516cv200), union `U_DATE_COEFF68`, struct offset 0xF310 (GPL-2.0, same-chip vendor header, byte-identical for Hi3516A V200 and Hi3519 V101). Reset value and access type unknown (modelled RW, no reset). Confidence: medium (vendor header for this chip family, not hardware verified).";

        field {
            name = "wid_sync_sw";
            desc = "[inferred] Width sync sw. (vendor header `product/hiosd/vo/hi3519/vou_reg.h` field `wid_sync_sw`; access and reset unknown, modelled RW)";
            sw = rw;
            hw = r;
        } wid_sync_sw[11:0];
    } DATE_COEFF68 @ 0xF310;

    reg {
        name = "DATE COEFF69";
        desc = "[inferred] DATE COEFF69. Not in the data sheet. Source: vendor U-Boot 2010.06 `product/hiosd/vo/hi3519/vou_reg.h` (GPL-2.0 U-Boot tree, HiSilicon copyright, created 2015-05-26; mirror github.com/OpenIPC/u-boot-hi3516cv200), union `U_DATE_COEFF69`, struct offset 0xF314 (GPL-2.0, same-chip vendor header, byte-identical for Hi3516A V200 and Hi3519 V101). Reset value and access type unknown (modelled RW, no reset). Confidence: medium (vendor header for this chip family, not hardware verified).";

        field {
            name = "wid_hfb_sw";
            desc = "[inferred] Width hfb sw. (vendor header `product/hiosd/vo/hi3519/vou_reg.h` field `wid_hfb_sw`; access and reset unknown, modelled RW)";
            sw = rw;
            hw = r;
        } wid_hfb_sw[11:0];
    } DATE_COEFF69 @ 0xF314;

    reg {
        name = "DATE COEFF70";
        desc = "[inferred] DATE COEFF70. Not in the data sheet. Source: vendor U-Boot 2010.06 `product/hiosd/vo/hi3519/vou_reg.h` (GPL-2.0 U-Boot tree, HiSilicon copyright, created 2015-05-26; mirror github.com/OpenIPC/u-boot-hi3516cv200), union `U_DATE_COEFF70`, struct offset 0xF318 (GPL-2.0, same-chip vendor header, byte-identical for Hi3516A V200 and Hi3519 V101). Reset value and access type unknown (modelled RW, no reset). Confidence: medium (vendor header for this chip family, not hardware verified).";

        field {
            name = "wid_act_sw";
            desc = "[inferred] Width act sw. (vendor header `product/hiosd/vo/hi3519/vou_reg.h` field `wid_act_sw`; access and reset unknown, modelled RW)";
            sw = rw;
            hw = r;
        } wid_act_sw[11:0];
    } DATE_COEFF70 @ 0xF318;

    reg {
        name = "DATE COEFF71";
        desc = "[inferred] DATE COEFF71. Not in the data sheet. Source: vendor U-Boot 2010.06 `product/hiosd/vo/hi3519/vou_reg.h` (GPL-2.0 U-Boot tree, HiSilicon copyright, created 2015-05-26; mirror github.com/OpenIPC/u-boot-hi3516cv200), union `U_DATE_COEFF71`, struct offset 0xF31C (GPL-2.0, same-chip vendor header, byte-identical for Hi3516A V200 and Hi3519 V101). Reset value and access type unknown (modelled RW, no reset). Confidence: medium (vendor header for this chip family, not hardware verified).";

        field {
            name = "phase_shift_ovrd";
            desc = "[inferred] Phase shift ovrd. (vendor header `product/hiosd/vo/hi3519/vou_reg.h` field `phase_shift_ovrd`; access and reset unknown, modelled RW)";
            sw = rw;
            hw = r;
        } phase_shift_ovrd[0:0];
    } DATE_COEFF71 @ 0xF31C;

    reg {
        name = "DATE COEFF72";
        desc = "[inferred] DATE COEFF72. Not in the data sheet. Source: vendor U-Boot 2010.06 `product/hiosd/vo/hi3519/vou_reg.h` (GPL-2.0 U-Boot tree, HiSilicon copyright, created 2015-05-26; mirror github.com/OpenIPC/u-boot-hi3516cv200), union `U_DATE_COEFF72`, struct offset 0xF320 (GPL-2.0, same-chip vendor header, byte-identical for Hi3516A V200 and Hi3519 V101). Reset value and access type unknown (modelled RW, no reset). Confidence: medium (vendor header for this chip family, not hardware verified).";

        field {
            name = "phase_shift_coeff";
            desc = "[inferred] Phase shift coefficient. (vendor header `product/hiosd/vo/hi3519/vou_reg.h` field `phase_shift_coeff`; access and reset unknown, modelled RW)";
            sw = rw;
            hw = r;
        } phase_shift_coeff[31:0];
    } DATE_COEFF72 @ 0xF320;

    reg {
        name = "DATE COEFF73";
        desc = "[inferred] DATE COEFF73. Not in the data sheet. Source: vendor U-Boot 2010.06 `product/hiosd/vo/hi3519/vou_reg.h` (GPL-2.0 U-Boot tree, HiSilicon copyright, created 2015-05-26; mirror github.com/OpenIPC/u-boot-hi3516cv200), union `U_DATE_COEFF73`, struct offset 0xF324 (GPL-2.0, same-chip vendor header, byte-identical for Hi3516A V200 and Hi3519 V101). Reset value and access type unknown (modelled RW, no reset). Confidence: medium (vendor header for this chip family, not hardware verified).";

        field {
            name = "coef_notch_ovrd";
            desc = "[inferred] Coefficient notch ovrd. (vendor header `product/hiosd/vo/hi3519/vou_reg.h` field `coef_notch_ovrd`; access and reset unknown, modelled RW)";
            sw = rw;
            hw = r;
        } coef_notch_ovrd[0:0];
    } DATE_COEFF73 @ 0xF324;

    reg {
        name = "DATE COEFF74";
        desc = "[inferred] DATE COEFF74. Not in the data sheet. Source: vendor U-Boot 2010.06 `product/hiosd/vo/hi3519/vou_reg.h` (GPL-2.0 U-Boot tree, HiSilicon copyright, created 2015-05-26; mirror github.com/OpenIPC/u-boot-hi3516cv200), union `U_DATE_COEFF74`, struct offset 0xF328 (GPL-2.0, same-chip vendor header, byte-identical for Hi3516A V200 and Hi3519 V101). Reset value and access type unknown (modelled RW, no reset). Confidence: medium (vendor header for this chip family, not hardware verified).";

        field {
            name = "coef_notch_2";
            desc = "[inferred] Coefficient notch 2. (vendor header `product/hiosd/vo/hi3519/vou_reg.h` field `coef_notch_2`; access and reset unknown, modelled RW)";
            sw = rw;
            hw = r;
        } coef_notch_2[25:16];

        field {
            name = "coef_notch_1";
            desc = "[inferred] Coefficient notch 1. (vendor header `product/hiosd/vo/hi3519/vou_reg.h` field `coef_notch_1`; access and reset unknown, modelled RW)";
            sw = rw;
            hw = r;
        } coef_notch_1[9:0];
    } DATE_COEFF74 @ 0xF328;

    reg {
        name = "DATE COEFF75";
        desc = "[inferred] DATE COEFF75. Not in the data sheet. Source: vendor U-Boot 2010.06 `product/hiosd/vo/hi3519/vou_reg.h` (GPL-2.0 U-Boot tree, HiSilicon copyright, created 2015-05-26; mirror github.com/OpenIPC/u-boot-hi3516cv200), union `U_DATE_COEFF75`, struct offset 0xF32C (GPL-2.0, same-chip vendor header, byte-identical for Hi3516A V200 and Hi3519 V101). Reset value and access type unknown (modelled RW, no reset). Confidence: medium (vendor header for this chip family, not hardware verified).";

        field {
            name = "coef_notch_4";
            desc = "[inferred] Coefficient notch 4. (vendor header `product/hiosd/vo/hi3519/vou_reg.h` field `coef_notch_4`; access and reset unknown, modelled RW)";
            sw = rw;
            hw = r;
        } coef_notch_4[25:16];

        field {
            name = "coef_notch_3";
            desc = "[inferred] Coefficient notch 3. (vendor header `product/hiosd/vo/hi3519/vou_reg.h` field `coef_notch_3`; access and reset unknown, modelled RW)";
            sw = rw;
            hw = r;
        } coef_notch_3[9:0];
    } DATE_COEFF75 @ 0xF32C;

    reg {
        name = "DATE COEFF76";
        desc = "[inferred] DATE COEFF76. Not in the data sheet. Source: vendor U-Boot 2010.06 `product/hiosd/vo/hi3519/vou_reg.h` (GPL-2.0 U-Boot tree, HiSilicon copyright, created 2015-05-26; mirror github.com/OpenIPC/u-boot-hi3516cv200), union `U_DATE_COEFF76`, struct offset 0xF330 (GPL-2.0, same-chip vendor header, byte-identical for Hi3516A V200 and Hi3519 V101). Reset value and access type unknown (modelled RW, no reset). Confidence: medium (vendor header for this chip family, not hardware verified).";

        field {
            name = "coef_notch_6";
            desc = "[inferred] Coefficient notch 6. (vendor header `product/hiosd/vo/hi3519/vou_reg.h` field `coef_notch_6`; access and reset unknown, modelled RW)";
            sw = rw;
            hw = r;
        } coef_notch_6[25:16];

        field {
            name = "coef_notch_5";
            desc = "[inferred] Coefficient notch 5. (vendor header `product/hiosd/vo/hi3519/vou_reg.h` field `coef_notch_5`; access and reset unknown, modelled RW)";
            sw = rw;
            hw = r;
        } coef_notch_5[9:0];
    } DATE_COEFF76 @ 0xF330;

    reg {
        name = "DATE COEFF77";
        desc = "[inferred] DATE COEFF77. Not in the data sheet. Source: vendor U-Boot 2010.06 `product/hiosd/vo/hi3519/vou_reg.h` (GPL-2.0 U-Boot tree, HiSilicon copyright, created 2015-05-26; mirror github.com/OpenIPC/u-boot-hi3516cv200), union `U_DATE_COEFF77`, struct offset 0xF334 (GPL-2.0, same-chip vendor header, byte-identical for Hi3516A V200 and Hi3519 V101). Reset value and access type unknown (modelled RW, no reset). Confidence: medium (vendor header for this chip family, not hardware verified).";

        field {
            name = "coef_notch_8";
            desc = "[inferred] Coefficient notch 8. (vendor header `product/hiosd/vo/hi3519/vou_reg.h` field `coef_notch_8`; access and reset unknown, modelled RW)";
            sw = rw;
            hw = r;
        } coef_notch_8[25:16];

        field {
            name = "coef_notch_7";
            desc = "[inferred] Coefficient notch 7. (vendor header `product/hiosd/vo/hi3519/vou_reg.h` field `coef_notch_7`; access and reset unknown, modelled RW)";
            sw = rw;
            hw = r;
        } coef_notch_7[9:0];
    } DATE_COEFF77 @ 0xF334;

    reg {
        name = "DATE COEFF78";
        desc = "[inferred] DATE COEFF78. Not in the data sheet. Source: vendor U-Boot 2010.06 `product/hiosd/vo/hi3519/vou_reg.h` (GPL-2.0 U-Boot tree, HiSilicon copyright, created 2015-05-26; mirror github.com/OpenIPC/u-boot-hi3516cv200), union `U_DATE_COEFF78`, struct offset 0xF338 (GPL-2.0, same-chip vendor header, byte-identical for Hi3516A V200 and Hi3519 V101). Reset value and access type unknown (modelled RW, no reset). Confidence: medium (vendor header for this chip family, not hardware verified).";

        field {
            name = "coef_notch_10";
            desc = "[inferred] Coefficient notch 10. (vendor header `product/hiosd/vo/hi3519/vou_reg.h` field `coef_notch_10`; access and reset unknown, modelled RW)";
            sw = rw;
            hw = r;
        } coef_notch_10[25:16];

        field {
            name = "coef_notch_9";
            desc = "[inferred] Coefficient notch 9. (vendor header `product/hiosd/vo/hi3519/vou_reg.h` field `coef_notch_9`; access and reset unknown, modelled RW)";
            sw = rw;
            hw = r;
        } coef_notch_9[9:0];
    } DATE_COEFF78 @ 0xF338;

    reg {
        name = "DATE COEFF79";
        desc = "[inferred] DATE COEFF79. Not in the data sheet. Source: vendor U-Boot 2010.06 `product/hiosd/vo/hi3519/vou_reg.h` (GPL-2.0 U-Boot tree, HiSilicon copyright, created 2015-05-26; mirror github.com/OpenIPC/u-boot-hi3516cv200), union `U_DATE_COEFF79`, struct offset 0xF33C (GPL-2.0, same-chip vendor header, byte-identical for Hi3516A V200 and Hi3519 V101). Reset value and access type unknown (modelled RW, no reset). Confidence: medium (vendor header for this chip family, not hardware verified).";

        field {
            name = "coef_notch_12";
            desc = "[inferred] Coefficient notch 12. (vendor header `product/hiosd/vo/hi3519/vou_reg.h` field `coef_notch_12`; access and reset unknown, modelled RW)";
            sw = rw;
            hw = r;
        } coef_notch_12[25:16];

        field {
            name = "coef_notch_11";
            desc = "[inferred] Coefficient notch 11. (vendor header `product/hiosd/vo/hi3519/vou_reg.h` field `coef_notch_11`; access and reset unknown, modelled RW)";
            sw = rw;
            hw = r;
        } coef_notch_11[9:0];
    } DATE_COEFF79 @ 0xF33C;

    reg {
        name = "DATE COEFF80";
        desc = "[inferred] DATE COEFF80. Not in the data sheet. Source: vendor U-Boot 2010.06 `product/hiosd/vo/hi3519/vou_reg.h` (GPL-2.0 U-Boot tree, HiSilicon copyright, created 2015-05-26; mirror github.com/OpenIPC/u-boot-hi3516cv200), union `U_DATE_COEFF80`, struct offset 0xF340 (GPL-2.0, same-chip vendor header, byte-identical for Hi3516A V200 and Hi3519 V101). Reset value and access type unknown (modelled RW, no reset). Confidence: medium (vendor header for this chip family, not hardware verified).";

        field {
            name = "coef_chra_lpf_ovrd";
            desc = "[inferred] Coefficient chra lpf ovrd. (vendor header `product/hiosd/vo/hi3519/vou_reg.h` field `coef_chra_lpf_ovrd`; access and reset unknown, modelled RW)";
            sw = rw;
            hw = r;
        } coef_chra_lpf_ovrd[0:0];
    } DATE_COEFF80 @ 0xF340;

    reg {
        name = "DATE COEFF81";
        desc = "[inferred] DATE COEFF81. Not in the data sheet. Source: vendor U-Boot 2010.06 `product/hiosd/vo/hi3519/vou_reg.h` (GPL-2.0 U-Boot tree, HiSilicon copyright, created 2015-05-26; mirror github.com/OpenIPC/u-boot-hi3516cv200), union `U_DATE_COEFF81`, struct offset 0xF344 (GPL-2.0, same-chip vendor header, byte-identical for Hi3516A V200 and Hi3519 V101). Reset value and access type unknown (modelled RW, no reset). Confidence: medium (vendor header for this chip family, not hardware verified).";

        field {
            name = "coef_chra_lpf_2";
            desc = "[inferred] Coefficient chra lpf 2. (vendor header `product/hiosd/vo/hi3519/vou_reg.h` field `coef_chra_lpf_2`; access and reset unknown, modelled RW)";
            sw = rw;
            hw = r;
        } coef_chra_lpf_2[24:16];

        field {
            name = "coef_chra_lpf_1";
            desc = "[inferred] Coefficient chra lpf 1. (vendor header `product/hiosd/vo/hi3519/vou_reg.h` field `coef_chra_lpf_1`; access and reset unknown, modelled RW)";
            sw = rw;
            hw = r;
        } coef_chra_lpf_1[8:0];
    } DATE_COEFF81 @ 0xF344;

    reg {
        name = "DATE COEFF82";
        desc = "[inferred] DATE COEFF82. Not in the data sheet. Source: vendor U-Boot 2010.06 `product/hiosd/vo/hi3519/vou_reg.h` (GPL-2.0 U-Boot tree, HiSilicon copyright, created 2015-05-26; mirror github.com/OpenIPC/u-boot-hi3516cv200), union `U_DATE_COEFF82`, struct offset 0xF348 (GPL-2.0, same-chip vendor header, byte-identical for Hi3516A V200 and Hi3519 V101). Reset value and access type unknown (modelled RW, no reset). Confidence: medium (vendor header for this chip family, not hardware verified).";

        field {
            name = "coef_chra_lpf_4";
            desc = "[inferred] Coefficient chra lpf 4. (vendor header `product/hiosd/vo/hi3519/vou_reg.h` field `coef_chra_lpf_4`; access and reset unknown, modelled RW)";
            sw = rw;
            hw = r;
        } coef_chra_lpf_4[24:16];

        field {
            name = "coef_chra_lpf_3";
            desc = "[inferred] Coefficient chra lpf 3. (vendor header `product/hiosd/vo/hi3519/vou_reg.h` field `coef_chra_lpf_3`; access and reset unknown, modelled RW)";
            sw = rw;
            hw = r;
        } coef_chra_lpf_3[8:0];
    } DATE_COEFF82 @ 0xF348;

    reg {
        name = "DATE COEFF83";
        desc = "[inferred] DATE COEFF83. Not in the data sheet. Source: vendor U-Boot 2010.06 `product/hiosd/vo/hi3519/vou_reg.h` (GPL-2.0 U-Boot tree, HiSilicon copyright, created 2015-05-26; mirror github.com/OpenIPC/u-boot-hi3516cv200), union `U_DATE_COEFF83`, struct offset 0xF34C (GPL-2.0, same-chip vendor header, byte-identical for Hi3516A V200 and Hi3519 V101). Reset value and access type unknown (modelled RW, no reset). Confidence: medium (vendor header for this chip family, not hardware verified).";

        field {
            name = "coef_chra_lpf_6";
            desc = "[inferred] Coefficient chra lpf 6. (vendor header `product/hiosd/vo/hi3519/vou_reg.h` field `coef_chra_lpf_6`; access and reset unknown, modelled RW)";
            sw = rw;
            hw = r;
        } coef_chra_lpf_6[24:16];

        field {
            name = "coef_chra_lpf_5";
            desc = "[inferred] Coefficient chra lpf 5. (vendor header `product/hiosd/vo/hi3519/vou_reg.h` field `coef_chra_lpf_5`; access and reset unknown, modelled RW)";
            sw = rw;
            hw = r;
        } coef_chra_lpf_5[8:0];
    } DATE_COEFF83 @ 0xF34C;

    reg {
        name = "DATE COEFF84";
        desc = "[inferred] DATE COEFF84. Not in the data sheet. Source: vendor U-Boot 2010.06 `product/hiosd/vo/hi3519/vou_reg.h` (GPL-2.0 U-Boot tree, HiSilicon copyright, created 2015-05-26; mirror github.com/OpenIPC/u-boot-hi3516cv200), union `U_DATE_COEFF84`, struct offset 0xF350 (GPL-2.0, same-chip vendor header, byte-identical for Hi3516A V200 and Hi3519 V101). Reset value and access type unknown (modelled RW, no reset). Confidence: medium (vendor header for this chip family, not hardware verified).";

        field {
            name = "coef_chra_lpf_7";
            desc = "[inferred] Coefficient chra lpf 7. (vendor header `product/hiosd/vo/hi3519/vou_reg.h` field `coef_chra_lpf_7`; access and reset unknown, modelled RW)";
            sw = rw;
            hw = r;
        } coef_chra_lpf_7[8:0];
    } DATE_COEFF84 @ 0xF350;
};

`endif
