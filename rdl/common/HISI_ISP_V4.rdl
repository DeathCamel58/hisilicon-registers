`ifndef HISI_ISP_V4_RDL
`define HISI_ISP_V4_RDL

regfile eISP_VICAP_CH_V4 {
    name = "ISP VICAP channel registers (Hi3516E V200 generation)";
    desc = "PROVEN (layout): register offsets, names and bit positions are the vendor register header isp_reg_define.h shipped with the Hi3516E V200 ISP library (sources/openhisilicon/libraries/isp/arch/hi3516ev200/include, channel 0 at VI window 0x11000000 + 0x10000 (ISP_VICAP_CH_REG_BASE = 0x11010000, stride 0x1000 per pipe); struct S_ISP_VICAP_CH_REGS_TYPE). The same header is used by the SDK kernel ISP driver (kernel/isp/arch/hi3516ev200/hal/isp_drv.c, which maps this window with osal_ioremap) and by libisp. GUESS: access types (all left read/write) and reset values (the header has none). Field names are the vendor names; reserved fields omitted. Hardware not read.";
    reg {
        name = "VI_CH_REG_NEWER";
        field { } ch_reg_newer[0:0];
    } VI_CH_REG_NEWER @ 0x4;
    reg {
        name = "CH_WCH_STT_CFG";
        field { } ch_wch_stt_finish_mode[17:17];
        field { } ch_wch_stt_32b_align[30:30];
    } CH_WCH_STT_CFG @ 0x200;
    reg {
        name = "CH_WCH_STT_AE_HIST_ADDR_L";
        field { } ch_wch_stt_aest_addr_l[31:0];
    } CH_WCH_STT_AE_HIST_ADDR_L @ 0x208;
    reg {
        name = "CH_WCH_STT_AE_AVER_R_GR_ADDR_L";
        field { } ch_wch_stt_ae_aver_r_gr_addr_l[31:0];
    } CH_WCH_STT_AE_AVER_R_GR_ADDR_L @ 0x210;
    reg {
        name = "CH_WCH_STT_AE_AVER_GB_B_ADDR_L";
        field { } ch_wch_stt_ae_aver_gb_b_addr_l[31:0];
    } CH_WCH_STT_AE_AVER_GB_B_ADDR_L @ 0x218;
};

regfile eISP_FE_V4 {
    name = "ISP front end registers (Hi3516E V200 generation)";
    desc = "PROVEN (layout): register offsets, names and bit positions are the vendor register header isp_reg_define.h shipped with the Hi3516E V200 ISP library (sources/openhisilicon/libraries/isp/arch/hi3516ev200/include, front end pipe 0 at 0x11020000 (ISP_FE_REG_BASE, stride 0x20000); struct S_ISPFE_REGS_TYPE). The same header is used by the SDK kernel ISP driver (kernel/isp/arch/hi3516ev200/hal/isp_drv.c, which maps this window with osal_ioremap) and by libisp. GUESS: access types (all left read/write) and reset values (the header has none). Field names are the vendor names; reserved fields omitted. Hardware not read.";
    reg {
        name = "ISP_FE_VERSION";
        field { } isp_fe_patch[7:0];
        field { } isp_fe_build[15:8];
        field { } isp_fe_release[23:16];
        field { } isp_fe_version[31:24];
    } ISP_FE_VERSION @ 0x80;
    reg {
        name = "ISP_FE_DATE";
        field { } isp_fe_date[31:0];
    } ISP_FE_DATE @ 0x84;
    reg {
        name = "ISP_FE_FPGA_DATE";
        field { } isp_fe_fpga_date[31:0];
    } ISP_FE_FPGA_DATE @ 0x88;
    reg {
        name = "ISP_FE_MODULE_POS";
        field { } value[31:0];
    } ISP_FE_MODULE_POS @ 0x90;
    reg {
        name = "ISP_FE_USER_DEFINE0";
        field { } isp_fe_user_define0[31:0];
    } ISP_FE_USER_DEFINE0 @ 0xA0;
    reg {
        name = "ISP_FE_USER_DEFINE1";
        field { } isp_fe_user_define1[31:0];
    } ISP_FE_USER_DEFINE1 @ 0xA4;
    reg {
        name = "ISP_FE_STARTUP";
        field { } isp_fe_fcnt[31:0];
    } ISP_FE_STARTUP @ 0xB0;
    reg {
        name = "ISP_FE_FORMAT";
        field { } isp_fe_format[31:0];
    } ISP_FE_FORMAT @ 0xB4;
    reg {
        name = "ISP_FE_INT";
        field { } isp_fe_int_fstart[0:0];
        field { } isp_fe_int_update_cfg[1:1];
        field { } isp_fe_int_cfg_loss[2:2];
        field { } isp_fe_int_int_delay[3:3];
        field { } isp_fe_int_ae1_int[4:4];
        field { } isp_fe_int_af1_int[6:6];
        field { } isp_fe_int_dis1_int[7:7];
    } ISP_FE_INT @ 0xF0;
    reg {
        name = "ISP_FE_INT_MASK";
        field { } isp_fe_int_mask_fstart[0:0];
        field { } isp_fe_int_mask_update_cfg[1:1];
        field { } isp_fe_int_mask_cfg_loss[2:2];
        field { } isp_fe_int_mask_int_delay[3:3];
        field { } isp_fe_int_mask_ae1_int[4:4];
        field { } isp_fe_int_mask_af1_int[6:6];
        field { } isp_fe_int_mask_dis1_int[7:7];
    } ISP_FE_INT_MASK @ 0xF8;
    reg {
        name = "ISP_FE_CTRL";
        field { } isp_colorbar_en[2:2];
        field { } isp_crop_en[3:3];
        field { } isp_blc1_en[4:4];
        field { } isp_rc_en[5:5];
        field { } isp_hrs_en[6:6];
        field { } isp_rlsc1_en[7:7];
        field { } isp_dg2_en[8:8];
        field { } isp_dis1_en[9:9];
        field { } isp_af1_en[10:10];
        field { } isp_wb1_en[11:11];
        field { } isp_drcs_en[12:12];
        field { } isp_ae1_en[13:13];
        field { } isp_loglut1_en[14:14];
    } ISP_FE_CTRL @ 0x100;
    reg {
        name = "ISP_FE_ADAPTER_CFG";
        field { } fe_hsync_mode[0:0];
        field { } fe_vsync_mode[1:1];
    } ISP_FE_ADAPTER_CFG @ 0x114;
    reg {
        name = "ISP_FE_OUT_SIZE";
        field { } fe_out_width[15:0];
        field { } fe_out_height[31:16];
    } ISP_FE_OUT_SIZE @ 0x118;
    reg {
        name = "ISP_FE_FSTART_DELAY";
        field { } isp_fe_delay[31:0];
    } ISP_FE_FSTART_DELAY @ 0x194;
    reg {
        name = "ISP_FE_CTRL_F";
        field { } isp_fe_rggb_cfg[1:0];
    } ISP_FE_CTRL_F @ 0x1E0;
    reg {
        name = "ISP_FE_CTRL_I";
        field { } isp_fe_update_mode[0:0];
    } ISP_FE_CTRL_I @ 0x1E4;
    reg {
        name = "ISP_FE_TIMING_CFG";
        field { } isp_fe_fix_timing[13:1];
    } ISP_FE_TIMING_CFG @ 0x1E8;
    reg {
        name = "ISP_FE_REG_UPDATE";
        field { } isp_fe_update[0:0];
    } ISP_FE_REG_UPDATE @ 0x1EC;
    reg {
        name = "ISP_FE_SIZE";
        field { } isp_fe_width[15:0];
        field { } isp_fe_height[31:16];
    } ISP_FE_SIZE @ 0x1F0;
    reg {
        name = "ISP_FE_IN_SUM_CFG";
        field { } isp_fe_csc_sum_en[0:0];
    } ISP_FE_IN_SUM_CFG @ 0x820;
    reg {
        name = "ISP_FE_OUT_SUM_CFG";
        field { } isp_fe_yuv444_sum_en[0:0];
    } ISP_FE_OUT_SUM_CFG @ 0x824;
    reg {
        name = "ISP_FE_BLK_SIZE";
        field { } isp_fe_blk_width[15:0];
        field { } isp_fe_blk_height[31:16];
    } ISP_FE_BLK_SIZE @ 0x874;
    reg {
        name = "ISP_FE_BLK_HBLANK";
        field { } isp_fe_blk_b_hblank[15:0];
        field { } isp_fe_blk_f_hblank[31:16];
    } ISP_FE_BLK_HBLANK @ 0x878;
    reg {
        name = "ISP_FE_BLK_VBLANK";
        field { } isp_fe_blk_b_vblank[15:0];
        field { } isp_fe_blk_f_vblank[31:16];
    } ISP_FE_BLK_VBLANK @ 0x87C;
    reg {
        name = "ISP_FE_IN_SUM0";
        field { } isp_fe_y_sum0[31:0];
    } ISP_FE_IN_SUM0 @ 0x890;
    reg {
        name = "ISP_FE_IN_SUM1";
        field { } isp_fe_y_sum1[31:0];
    } ISP_FE_IN_SUM1 @ 0x894;
    reg {
        name = "ISP_FE_OUT_SUM0";
        field { } isp_fe_yuv444_y_sum0[31:0];
    } ISP_FE_OUT_SUM0 @ 0x8A0;
    reg {
        name = "ISP_FE_OUT_SUM1";
        field { } isp_fe_yuv444_y_sum1[31:0];
    } ISP_FE_OUT_SUM1 @ 0x8A4;
    reg {
        name = "ISP_BLC1_VERSION";
        field { } value[31:0];
    } ISP_BLC1_VERSION @ 0x110C;
    reg {
        name = "ISP_BLC1_OFFSET1";
        field { } isp_blc1_ofsgr[14:0];
        field { } isp_blc1_ofsr[30:16];
    } ISP_BLC1_OFFSET1 @ 0x1110;
    reg {
        name = "ISP_BLC1_OFFSET2";
        field { } isp_blc1_ofsgb[14:0];
        field { } isp_blc1_ofsb[30:16];
    } ISP_BLC1_OFFSET2 @ 0x1114;
    reg {
        name = "ISP_DG2_BLC_CFG";
        field { } isp_dg2_en_in[0:0];
        field { } isp_dg2_en_out[1:1];
    } ISP_DG2_BLC_CFG @ 0x1D04;
    reg {
        name = "ISP_DG2_VERSION";
        field { } value[31:0];
    } ISP_DG2_VERSION @ 0x1D0C;
    reg {
        name = "ISP_DG2_GAIN1";
        field { } isp_dg2_grgain[15:0];
        field { } isp_dg2_rgain[31:16];
    } ISP_DG2_GAIN1 @ 0x1D10;
    reg {
        name = "ISP_DG2_GAIN2";
        field { } isp_dg2_gbgain[15:0];
        field { } isp_dg2_bgain[31:16];
    } ISP_DG2_GAIN2 @ 0x1D14;
    reg {
        name = "ISP_DG2_BLC_OFFSET1";
        field { } isp_dg2_ofsgr[14:0];
        field { } isp_dg2_ofsr[30:16];
    } ISP_DG2_BLC_OFFSET1 @ 0x1D18;
    reg {
        name = "ISP_DG2_BLC_OFFSET2";
        field { } isp_dg2_ofsgb[14:0];
        field { } isp_dg2_ofsb[30:16];
    } ISP_DG2_BLC_OFFSET2 @ 0x1D1C;
    reg {
        name = "ISP_DG2_CLIP_VALUE";
        field { } isp_dg2_clip_value[19:0];
    } ISP_DG2_CLIP_VALUE @ 0x1D20;
    reg {
        name = "ISP_WB1_BLC_CFG";
        field { } isp_wb1_en_in[0:0];
        field { } isp_wb1_en_out[1:1];
    } ISP_WB1_BLC_CFG @ 0x1F04;
    reg {
        name = "ISP_WB1_VERSION";
        field { } value[31:0];
    } ISP_WB1_VERSION @ 0x1F0C;
    reg {
        name = "ISP_WB1_GAIN1";
        field { } isp_wb1_grgain[15:0];
        field { } isp_wb1_rgain[31:16];
    } ISP_WB1_GAIN1 @ 0x1F10;
    reg {
        name = "ISP_WB1_GAIN2";
        field { } isp_wb1_gbgain[15:0];
        field { } isp_wb1_bgain[31:16];
    } ISP_WB1_GAIN2 @ 0x1F14;
    reg {
        name = "ISP_WB1_BLC_OFFSET1";
        field { } isp_wb1_ofsgr[14:0];
        field { } isp_wb1_ofsr[30:16];
    } ISP_WB1_BLC_OFFSET1 @ 0x1F18;
    reg {
        name = "ISP_WB1_BLC_OFFSET2";
        field { } isp_wb1_ofsgb[14:0];
        field { } isp_wb1_ofsb[30:16];
    } ISP_WB1_BLC_OFFSET2 @ 0x1F1C;
    reg {
        name = "ISP_WB1_CLIP_VALUE";
        field { } isp_wb1_clip_value[19:0];
    } ISP_WB1_CLIP_VALUE @ 0x1F20;
    reg {
        name = "ISP_AE1_VERSION";
        field { } isp_ae_version[31:0];
    } ISP_AE1_VERSION @ 0x280C;
    reg {
        name = "ISP_AE1_ZONE";
        field { } isp_ae_hnum[4:0];
        field { } isp_ae_vnum[12:8];
    } ISP_AE1_ZONE @ 0x2810;
    reg {
        name = "ISP_AE1_SKIP_CRG";
        field { } isp_ae_skip_x[2:0];
        field { } isp_ae_offset_x[3:3];
        field { } isp_ae_skip_y[6:4];
        field { } isp_ae_offset_y[7:7];
    } ISP_AE1_SKIP_CRG @ 0x2814;
    reg {
        name = "ISP_AE1_TOTAL_STAT";
        field { } isp_ae_total_pixels[26:0];
    } ISP_AE1_TOTAL_STAT @ 0x2818;
    reg {
        name = "ISP_AE1_COUNT_STAT";
        field { } isp_ae_count_pixels[30:0];
    } ISP_AE1_COUNT_STAT @ 0x281C;
    reg {
        name = "ISP_AE1_TOTAL_R_AVER";
        field { } value[31:0];
    } ISP_AE1_TOTAL_R_AVER @ 0x2820;
    reg {
        name = "ISP_AE1_TOTAL_GR_AVER";
        field { } value[31:0];
    } ISP_AE1_TOTAL_GR_AVER @ 0x2824;
    reg {
        name = "ISP_AE1_TOTAL_GB_AVER";
        field { } value[31:0];
    } ISP_AE1_TOTAL_GB_AVER @ 0x2828;
    reg {
        name = "ISP_AE1_TOTAL_B_AVER";
        field { } value[31:0];
    } ISP_AE1_TOTAL_B_AVER @ 0x282C;
    reg {
        name = "ISP_AE1_HIST_HIGH";
        field { } isp_aestgh[31:0];
    } ISP_AE1_HIST_HIGH @ 0x2830;
    reg {
        name = "ISP_AE1_BITMOVE";
        field { } isp_ae_bitmove[4:0];
        field { } isp_ae_blc_en[9:9];
    } ISP_AE1_BITMOVE @ 0x2840;
    reg {
        name = "ISP_AE1_OFFSET_R_GR";
        field { } isp_ae_offset_r[14:0];
        field { } isp_ae_offset_gr[30:16];
    } ISP_AE1_OFFSET_R_GR @ 0x2844;
    reg {
        name = "ISP_AE1_OFFSET_GB_B";
        field { } isp_ae_offset_gb[14:0];
        field { } isp_ae_offset_b[30:16];
    } ISP_AE1_OFFSET_GB_B @ 0x284C;
    reg {
        name = "ISP_AE1_LUT_UPDATE";
        field { } isp_ae_lut_update[0:0];
    } ISP_AE1_LUT_UPDATE @ 0x2864;
    reg {
        name = "ISP_AE1_STT_BST";
        field { } isp_ae_stt_size[15:0];
        field { } isp_ae_stt_bst[19:16];
        field { } isp_ae_stt_en[20:20];
    } ISP_AE1_STT_BST @ 0x2868;
    reg {
        name = "ISP_AE1_CROP_POS";
        field { } isp_ae_crop_pos_x[15:0];
        field { } isp_ae_crop_pos_y[31:16];
    } ISP_AE1_CROP_POS @ 0x2874;
    reg {
        name = "ISP_AE1_CROP_OUTSIZE";
        field { } isp_ae_crop_out_width[15:0];
        field { } isp_ae_crop_out_height[31:16];
    } ISP_AE1_CROP_OUTSIZE @ 0x2878;
    reg {
        name = "ISP_AE1_HIST_WADDR";
        field { } value[31:0];
    } ISP_AE1_HIST_WADDR @ 0x2880;
    reg {
        name = "ISP_AE1_HIST_WDATA";
        field { } value[31:0];
    } ISP_AE1_HIST_WDATA @ 0x2884;
    reg {
        name = "ISP_AE1_HIST_RADDR";
        field { } isp_aest_raddr[31:0];
    } ISP_AE1_HIST_RADDR @ 0x2888;
    reg {
        name = "ISP_AE1_HIST_RDATA";
        field { } isp_aest_rdata[31:0];
    } ISP_AE1_HIST_RDATA @ 0x288C;
    reg {
        name = "ISP_AE1_AVER_R_GR_WADDR";
        field { } value[31:0];
    } ISP_AE1_AVER_R_GR_WADDR @ 0x2890;
    reg {
        name = "ISP_AE1_AVER_R_GR_WDATA";
        field { } value[31:0];
    } ISP_AE1_AVER_R_GR_WDATA @ 0x2894;
    reg {
        name = "ISP_AE1_AVER_R_GR_RADDR";
        field { } value[31:0];
    } ISP_AE1_AVER_R_GR_RADDR @ 0x2898;
    reg {
        name = "ISP_AE1_AVER_R_GR_RDATA";
        field { } value[31:0];
    } ISP_AE1_AVER_R_GR_RDATA @ 0x289C;
    reg {
        name = "ISP_AE1_AVER_GB_B_WADDR";
        field { } value[31:0];
    } ISP_AE1_AVER_GB_B_WADDR @ 0x28A0;
    reg {
        name = "ISP_AE1_AVER_GB_B_WDATA";
        field { } value[31:0];
    } ISP_AE1_AVER_GB_B_WDATA @ 0x28A4;
    reg {
        name = "ISP_AE1_AVER_GB_B_RADDR";
        field { } value[31:0];
    } ISP_AE1_AVER_GB_B_RADDR @ 0x28A8;
    reg {
        name = "ISP_AE1_AVER_GB_B_RDATA";
        field { } value[31:0];
    } ISP_AE1_AVER_GB_B_RDATA @ 0x28AC;
    reg {
        name = "ISP_AE1_WEIGHT_WADDR";
        field { } isp_ae_wei_waddr[31:0];
    } ISP_AE1_WEIGHT_WADDR @ 0x28B0;
    reg {
        name = "ISP_AE1_WEIGHT_WDATA";
        field { } isp_ae_wei_wdata[31:0];
    } ISP_AE1_WEIGHT_WDATA @ 0x28B4;
    reg {
        name = "ISP_AE1_WEIGHT_RADDR";
        field { } value[31:0];
    } ISP_AE1_WEIGHT_RADDR @ 0x28B8;
    reg {
        name = "ISP_AE1_WEIGHT_RDATA";
        field { } value[31:0];
    } ISP_AE1_WEIGHT_RDATA @ 0x28BC;
    reg {
        name = "ISP_RC_BLCEN";
        field { } isp_rc_blc_in_en[0:0];
        field { } isp_rc_blc_out_en[8:8];
    } ISP_RC_BLCEN @ 0x3610;
    reg {
        name = "ISP_RC_BLC0";
        field { } isp_rc_blc_r[14:0];
        field { } isp_rc_blc_gr[30:16];
    } ISP_RC_BLC0 @ 0x3614;
    reg {
        name = "ISP_RC_BLC1";
        field { } isp_rc_blc_b[14:0];
        field { } isp_rc_blc_gb[30:16];
    } ISP_RC_BLC1 @ 0x3618;
    reg {
        name = "ISP_RC_SQRADIUS";
        field { } isp_rc_sqradius[31:0];
    } ISP_RC_SQRADIUS @ 0x3620;
    reg {
        name = "ISP_RC_CENTER_COOR";
        field { } isp_rc_cenhor_coor[13:0];
        field { } isp_rc_cenver_coor[29:16];
    } ISP_RC_CENTER_COOR @ 0x3624;
    reg {
        name = "ISP_CROP_VERSION";
        field { } isp_crop_version[31:0];
    } ISP_CROP_VERSION @ 0xB10C;
    reg {
        name = "ISP_CROP_SIZEOUT";
        field { } isp_crop_width_out[15:0];
        field { } isp_crop_height_out[31:16];
    } ISP_CROP_SIZEOUT @ 0xB110;
    reg {
        name = "ISP_CROP_POS";
        field { } isp_crop_pos_x[15:0];
        field { } isp_crop_pos_y[31:16];
    } ISP_CROP_POS @ 0xB114;
};

regfile eVIPROC_V4 {
    name = "VI processing (VIPROC) registers (Hi3516E V200 generation)";
    desc = "PROVEN (layout): register offsets, names and bit positions are the vendor register header isp_reg_define.h shipped with the Hi3516E V200 ISP library (sources/openhisilicon/libraries/isp/arch/hi3516ev200/include, VIPROC at 0x11200000 (VIPROC_REG_BASE, stride 0x40000); struct S_VIPROC_REGS_TYPE). The same header is used by the SDK kernel ISP driver (kernel/isp/arch/hi3516ev200/hal/isp_drv.c, which maps this window with osal_ioremap) and by libisp. GUESS: access types (all left read/write) and reset values (the header has none). Field names are the vendor names; reserved fields omitted. Hardware not read.";
    reg {
        name = "VIPROC_CTRL0";
        field { } out0_crop_en[0:0];
        field { } isp_be_en[13:13];
        field { } img_pro_mode[17:16];
        field { } vcpin_sfifo_en[18:18];
        field { } wdr_fpn_mux[20:20];
        field { } dcg_fpn_sel[21:21];
        field { } ch0_mux[22:22];
        field { } isp_be_bypass_mode[27:26];
        field { } wdr_mode[28:28];
        field { } video_en[31:31];
    } VIPROC_CTRL0 @ 0x0;
    reg {
        name = "VIPROC_REGUP";
        field { } reg_up[0:0];
        field { } manual_reg_up[8:8];
    } VIPROC_REGUP @ 0x10;
    reg {
        name = "VIPROC_ISPBE_REGUP";
        field { } ispbe_reg_up[0:0];
    } VIPROC_ISPBE_REGUP @ 0x14;
    reg {
        name = "VIPROC_ISPBE_CTRL0";
        field { } isp_wdrsplit1_en[0:0];
        field { } isp_fpn_en[1:1];
        field { } isp_fpn_mode[2:2];
        field { } isp_dpc_en[3:3];
        field { } isp_dpc_stat_en[4:4];
        field { } isp_ge_en[5:5];
        field { } isp_4dg_en[6:6];
        field { } isp_flicker_en[7:7];
        field { } isp_wdr_en[8:8];
        field { } isp_expander_en[9:9];
        field { } isp_bcom_en[10:10];
        field { } isp_bnr_en[11:11];
        field { } isp_bdec_en[12:12];
        field { } isp_lsc_en[13:13];
        field { } isp_dg_en[14:14];
        field { } isp_af_en[15:15];
        field { } isp_awb_en[16:16];
        field { } isp_ae_en[17:17];
        field { } isp_dis_en[18:18];
        field { } isp_wb_en[19:19];
        field { } isp_blc_en[20:20];
        field { } isp_pregamma_en[21:21];
        field { } isp_drc_en[22:22];
        field { } isp_la_en[24:24];
        field { } isp_sqrt_en[25:25];
        field { } isp_dmnr_vhdm_en[26:26];
        field { } isp_dmnr_nddm_en[27:27];
        field { } isp_loglut_en[28:28];
        field { } isp_rlsc_en[29:29];
        field { } isp_rgbir_en[30:30];
    } VIPROC_ISPBE_CTRL0 @ 0x20;
    reg {
        name = "VIPROC_ISPBE_CTRL1";
        field { } isp_sq_en[0:0];
        field { } isp_cc_en[1:1];
        field { } isp_clut_en[2:2];
        field { } isp_sqrt1_en[3:3];
        field { } isp_gamma_en[4:4];
        field { } isp_dehaze_en[5:5];
        field { } isp_csc_en[6:6];
        field { } isp_sumy_en[7:7];
        field { } isp_ldci_en[8:8];
        field { } isp_ca_en[11:11];
        field { } isp_split_en[12:12];
        field { } isp_sharpen_en[13:13];
        field { } isp_hcds_en[14:14];
        field { } isp_hlc_en[15:15];
        field { } isp_de_en[16:16];
        field { } isp_vcds_en[17:17];
        field { } isp_nry0_en[18:18];
    } VIPROC_ISPBE_CTRL1 @ 0x24;
    reg {
        name = "VIPROC_ISPBE_CFG";
        field { } isp_be_rggb_cfg[1:0];
        field { } isp_be_timing_cfg[31:16];
    } VIPROC_ISPBE_CFG @ 0x2C;
    reg {
        name = "VIPROC_FSTART_DLY";
        field { } fstart_dly_cfg[31:16];
    } VIPROC_FSTART_DLY @ 0x30;
    reg {
        name = "VIPROC_INTMASK";
        field { } eof_mask[0:0];
        field { } eof_end_mask[1:1];
        field { } timeout_mask[2:2];
        field { } wbus_err_mask[3:3];
        field { } rbus_err_mask[4:4];
        field { } wrap_overflow_mask[5:5];
        field { } apb_err_mask[6:6];
        field { } dcmp_err_mask[7:7];
        field { } flow_mask[8:8];
        field { } frm_err_mask[9:9];
        field { } frm_start_mask[10:10];
        field { } tunl_finish_mask[11:11];
        field { } cfg_loss_mask[12:12];
        field { } load_lut_mask[13:13];
        field { } frm_start_dly_mask[14:14];
        field { } ispbe_fstart_mask[16:16];
        field { } ispbe_update_cfg_mask[17:17];
        field { } ispbe_cfg_loss_mask[18:18];
        field { } ispbe_ae_mask[20:20];
        field { } ispbe_awb_mask[21:21];
        field { } ispbe_af_mask[22:22];
        field { } ispbe_dis_mask[23:23];
        field { } ispbe_ldci_mask[25:25];
        field { } ispbe_dehaze_mask[26:26];
        field { } ispbe_flick_mask[27:27];
        field { } ispbe_mg_mask[28:28];
        field { } ispbe_drc_mask[29:29];
        field { } ispbe_fpn_mask[30:30];
        field { } ispbe_dcg_mask[31:31];
    } VIPROC_INTMASK @ 0xF0;
    reg {
        name = "VIPROC_INT1MASK";
        field { } af_int_mask[0:0];
        field { } ae_int_mask[1:1];
        field { } awb_int_mask[2:2];
        field { } dis_int_mask[3:3];
        field { } la_int_mask[4:4];
        field { } ge_int_mask[5:5];
        field { } dehaze_int_mask[6:6];
        field { } flick_int_mask[7:7];
        field { } ldci_int_mask[8:8];
    } VIPROC_INT1MASK @ 0xF4;
    reg {
        name = "PARA_DRC_ADDR_LOW";
        field { } para_drc_addr_low[31:0];
    } PARA_DRC_ADDR_LOW @ 0x608;
    reg {
        name = "PARA_DCI_ADDR_LOW";
        field { } para_dci_addr_low[31:0];
    } PARA_DCI_ADDR_LOW @ 0x610;
    reg {
        name = "OUT_PARA_DRC_ADDR_LOW";
        field { } out_para_drc_addr_low[31:0];
    } OUT_PARA_DRC_ADDR_LOW @ 0x618;
    reg {
        name = "OUT_PARA_DCI_ADDR_LOW";
        field { } out_para_dci_addr_low[31:0];
    } OUT_PARA_DCI_ADDR_LOW @ 0x620;
    reg {
        name = "VIPROC_ISP_AE_HIST_ADDR_LOW";
        field { } isp_aest_addr_low[31:0];
    } VIPROC_ISP_AE_HIST_ADDR_LOW @ 0x668;
    reg {
        name = "VIPROC_ISP_AE_AVER_R_GR_ADDR_LOW";
        field { } isp_ae_aver_r_gr_addr_low[31:0];
    } VIPROC_ISP_AE_AVER_R_GR_ADDR_LOW @ 0x670;
    reg {
        name = "VIPROC_ISP_AE_AVER_GB_B_ADDR_LOW";
        field { } isp_ae_aver_gb_b_addr_low[31:0];
    } VIPROC_ISP_AE_AVER_GB_B_ADDR_LOW @ 0x678;
    reg {
        name = "VIPROC_ISP_AWB_STAT_ADDR_LOW";
        field { } isp_awb_stat_addr_low[31:0];
    } VIPROC_ISP_AWB_STAT_ADDR_LOW @ 0x680;
    reg {
        name = "VIPROC_ISP_AF_STAT_ADDR_LOW";
        field { } isp_af_stat_addr_low[31:0];
    } VIPROC_ISP_AF_STAT_ADDR_LOW @ 0x688;
    reg {
        name = "VIPROC_ISP_DIS_H_STAT_ADDR_LOW";
        field { } isp_dis_h_stat_addr_low[31:0];
    } VIPROC_ISP_DIS_H_STAT_ADDR_LOW @ 0x6B0;
    reg {
        name = "VIPROC_ISP_DIS_V_STAT_ADDR_LOW";
        field { } isp_dis_v_stat_addr_low[31:0];
    } VIPROC_ISP_DIS_V_STAT_ADDR_LOW @ 0x6B8;
    reg {
        name = "VIPROC_ISP_LA_AVER_ADDR_LOW";
        field { } isp_la_aver_addr_low[31:0];
    } VIPROC_ISP_LA_AVER_ADDR_LOW @ 0x6C0;
    reg {
        name = "VIPROC_ISP_GE_AVER0_ADDR_LOW";
        field { } isp_ge_aver0_addr_low[31:0];
    } VIPROC_ISP_GE_AVER0_ADDR_LOW @ 0x6C8;
    reg {
        name = "VIPROC_ISP_GE_AVER1_ADDR_LOW";
        field { } isp_ge_aver1_addr_low[31:0];
    } VIPROC_ISP_GE_AVER1_ADDR_LOW @ 0x6D0;
    reg {
        name = "VIPROC_ISP_DEHAZE_MIN_STAT_ADDR_LOW";
        field { } isp_dehaze_min_stat_addr_low[31:0];
    } VIPROC_ISP_DEHAZE_MIN_STAT_ADDR_LOW @ 0x6D8;
    reg {
        name = "VIPROC_ISP_DEHAZE_MAX_STAT_ADDR_LOW";
        field { } isp_dehaze_max_stat_addr_low[31:0];
    } VIPROC_ISP_DEHAZE_MAX_STAT_ADDR_LOW @ 0x6E0;
    reg {
        name = "VIPROC_ISP_FLICK_GMEAN_ADDR_LOW";
        field { } isp_flick_gmean_addr_low[31:0];
    } VIPROC_ISP_FLICK_GMEAN_ADDR_LOW @ 0x6E8;
    reg {
        name = "VIPROC_ISP_LDCI_LPF_ADDR_LOW";
        field { } isp_ldci_lpf_addr_low[31:0];
    } VIPROC_ISP_LDCI_LPF_ADDR_LOW @ 0x6F0;
    reg {
        name = "VIPROC_OUT1_FINISH_LINE";
        field { } out1_finish_line[15:0];
    } VIPROC_OUT1_FINISH_LINE @ 0x6F8;
    reg {
        name = "VIPROC_ISP_DCG_LUT_ADDR_LOW";
        field { } isp_dcg_lut_addr_low[31:0];
    } VIPROC_ISP_DCG_LUT_ADDR_LOW @ 0x6FC;
    reg {
        name = "VIPROC_ISP_DCG_LUT_WIDTH_WORD";
        field { } isp_dcg_lut_width_word[15:0];
    } VIPROC_ISP_DCG_LUT_WIDTH_WORD @ 0x704;
    reg {
        name = "VIPROC_ISP_BNR_LUT_ADDR_LOW";
        field { } isp_bnr_lut_addr_low[31:0];
    } VIPROC_ISP_BNR_LUT_ADDR_LOW @ 0x708;
    reg {
        name = "VIPROC_ISP_BNR_LUT_WIDTH_WORD";
        field { } isp_bnr_lut_width_word[15:0];
    } VIPROC_ISP_BNR_LUT_WIDTH_WORD @ 0x710;
    reg {
        name = "VIPROC_ISP_LSC_LUT_ADDR_LOW";
        field { } isp_lsc_lut_addr_low[31:0];
    } VIPROC_ISP_LSC_LUT_ADDR_LOW @ 0x714;
    reg {
        name = "VIPROC_ISP_LSC_LUT_WIDTH_WORD";
        field { } isp_lsc_lut_width_word[15:0];
    } VIPROC_ISP_LSC_LUT_WIDTH_WORD @ 0x71C;
    reg {
        name = "VIPROC_ISP_CLUT_LUT_ADDR_LOW";
        field { } isp_clut_lut_addr_low[31:0];
    } VIPROC_ISP_CLUT_LUT_ADDR_LOW @ 0x72C;
    reg {
        name = "VIPROC_ISP_CLUT_LUT_WIDTH_WORD";
        field { } isp_clut_lut_width_word[15:0];
    } VIPROC_ISP_CLUT_LUT_WIDTH_WORD @ 0x734;
    reg {
        name = "VIPROC_ISP_GAMMA_LUT_ADDR_LOW";
        field { } isp_gamma_lut_addr_low[31:0];
    } VIPROC_ISP_GAMMA_LUT_ADDR_LOW @ 0x738;
    reg {
        name = "VIPROC_ISP_GAMMA_LUT_WIDTH_WORD";
        field { } isp_gamma_lut_width_word[15:0];
    } VIPROC_ISP_GAMMA_LUT_WIDTH_WORD @ 0x740;
    reg {
        name = "VIPROC_ISP_DEHAZE_LUT_ADDR_LOW";
        field { } isp_dehaze_lut_addr_low[31:0];
    } VIPROC_ISP_DEHAZE_LUT_ADDR_LOW @ 0x744;
    reg {
        name = "VIPROC_ISP_DEHAZE_LUT_WIDTH_WORD";
        field { } isp_dehaze_lut_width_word[15:0];
    } VIPROC_ISP_DEHAZE_LUT_WIDTH_WORD @ 0x74C;
    reg {
        name = "VIPROC_ISP_LDCI_LUT_ADDR_LOW";
        field { } isp_ldci_lut_addr_low[31:0];
    } VIPROC_ISP_LDCI_LUT_ADDR_LOW @ 0x750;
    reg {
        name = "VIPROC_ISP_LDCI_LUT_WIDTH_WORD";
        field { } isp_ldci_lut_width_word[15:0];
    } VIPROC_ISP_LDCI_LUT_WIDTH_WORD @ 0x758;
    reg {
        name = "VIPROC_ISP_CA_LUT_ADDR_LOW";
        field { } isp_ca_lut_addr_low[31:0];
    } VIPROC_ISP_CA_LUT_ADDR_LOW @ 0x75C;
    reg {
        name = "VIPROC_ISP_CA_LUT_WIDTH_WORD";
        field { } isp_ca_lut_width_word[15:0];
    } VIPROC_ISP_CA_LUT_WIDTH_WORD @ 0x764;
    reg {
        name = "VIPROC_ISP_SHARPEN_LUT_ADDR_LOW";
        field { } isp_sharpen_lut_addr_low[31:0];
    } VIPROC_ISP_SHARPEN_LUT_ADDR_LOW @ 0x768;
    reg {
        name = "VIPROC_ISP_SHARPEN_LUT_WIDTH_WORD";
        field { } isp_sharpen_lut_width_word[15:0];
    } VIPROC_ISP_SHARPEN_LUT_WIDTH_WORD @ 0x770;
    reg {
        name = "VIPROC_ISP_PREGAMMA_LUT_ADDR_LOW";
        field { } isp_pregamma_lut_addr_low[31:0];
    } VIPROC_ISP_PREGAMMA_LUT_ADDR_LOW @ 0x774;
    reg {
        name = "VIPROC_ISP_PREGAMMA_LUT_WIDTH_WORD";
        field { } isp_pregamma_lut_width_word[15:0];
    } VIPROC_ISP_PREGAMMA_LUT_WIDTH_WORD @ 0x77C;
};

regfile eISP_BE_V4 {
    name = "ISP back end registers (Hi3516E V200 generation)";
    desc = "PROVEN (layout): register offsets, names and bit positions are the vendor register header isp_reg_define.h shipped with the Hi3516E V200 ISP library (sources/openhisilicon/libraries/isp/arch/hi3516ev200/include, back end pipe 0 at 0x11220000 (ISP_BE_REG_BASE, stride 0x40000); struct S_ISPBE_REGS_TYPE (the VIPROC copy and the LUT image at struct offset 0x7E80.. are in-memory images, not listed)). The same header is used by the SDK kernel ISP driver (kernel/isp/arch/hi3516ev200/hal/isp_drv.c, which maps this window with osal_ioremap) and by libisp. GUESS: access types (all left read/write) and reset values (the header has none). Field names are the vendor names; reserved fields omitted. Hardware not read.";
    reg {
        name = "ISP_BE_VERSION";
        field { } isp_patch[7:0];
        field { } isp_build[15:8];
        field { } isp_release[23:16];
        field { } isp_version[31:24];
    } ISP_BE_VERSION @ 0x80;
    reg {
        name = "ISP_BE_DATE";
        field { } isp_date[31:0];
    } ISP_BE_DATE @ 0x84;
    reg {
        name = "ISP_BE_FPGA_DATE";
        field { } isp_fpga_date[31:0];
    } ISP_BE_FPGA_DATE @ 0x88;
    reg {
        name = "ISP_BE_MODULE_POS";
        field { } isp_ae_sel[1:0];
        field { } isp_awb_sel[3:2];
        field { } isp_af_sel[5:4];
        field { } isp_dis_sel[6:6];
        field { } isp_clut_sel[7:7];
        field { } isp_dcg_sel[8:8];
    } ISP_BE_MODULE_POS @ 0x90;
    reg {
        name = "ISP_BE_FSTART_DELAY";
        field { } isp_delay[31:0];
    } ISP_BE_FSTART_DELAY @ 0x94;
    reg {
        name = "ISP_BE_INPUT_MUX";
        field { } isp_input0_sel[1:0];
        field { } isp_input1_sel[5:4];
        field { } isp_input2_sel[9:8];
        field { } isp_input3_sel[13:12];
        field { } isp_input4_sel[16:16];
    } ISP_BE_INPUT_MUX @ 0x98;
    reg {
        name = "ISP_BE_SYS_CTRL";
        field { } isp_stt_en[0:0];
    } ISP_BE_SYS_CTRL @ 0x9C;
    reg {
        name = "ISP_BE_USER_DEFINE0";
        field { } isp_user_define0[31:0];
    } ISP_BE_USER_DEFINE0 @ 0xA0;
    reg {
        name = "ISP_BE_USER_DEFINE1";
        field { } isp_user_define1[31:0];
    } ISP_BE_USER_DEFINE1 @ 0xA4;
    reg {
        name = "ISP_BE_STARTUP";
        field { } isp_fcnt[31:0];
    } ISP_BE_STARTUP @ 0xB0;
    reg {
        name = "ISP_BE_FORMAT";
        field { } isp_format[1:0];
    } ISP_BE_FORMAT @ 0xB4;
    reg {
        name = "ISP_CLIP_Y_CFG";
        field { } isp_clip_y_min[15:0];
        field { } isp_clip_y_max[31:16];
    } ISP_CLIP_Y_CFG @ 0x800;
    reg {
        name = "ISP_CLIP_C_CFG";
        field { } isp_clip_c_min[15:0];
        field { } isp_clip_c_max[31:16];
    } ISP_CLIP_C_CFG @ 0x804;
    reg {
        name = "ISP_CSC_SUM_CFG";
        field { } isp_csc_sum_en[0:0];
    } ISP_CSC_SUM_CFG @ 0x820;
    reg {
        name = "ISP_YUV444_SUM_CFG";
        field { } isp_yuv444_sum_en[0:0];
    } ISP_YUV444_SUM_CFG @ 0x824;
    reg {
        name = "ISP_YUV422_SUM_CFG";
        field { } isp_yuv422_sum_en[0:0];
    } ISP_YUV422_SUM_CFG @ 0x828;
    reg {
        name = "ISP_WDR_SUM_CFG";
        field { } isp_wdr_sum_en[0:0];
    } ISP_WDR_SUM_CFG @ 0x830;
    reg {
        name = "ISP_DEMOSAIC_SUM_CFG";
        field { } isp_demosaic_sum_en[0:0];
    } ISP_DEMOSAIC_SUM_CFG @ 0x834;
    reg {
        name = "ISP_DMNR_DITHER";
        field { } isp_dmnr_dither_en[0:0];
        field { } isp_dmnr_dither_round[2:1];
        field { } isp_dmnr_dither_spatial_mode[3:3];
        field { } isp_dmnr_dither_out_bits[7:4];
    } ISP_DMNR_DITHER @ 0x840;
    reg {
        name = "ISP_ACM_DITHER";
        field { } isp_acm_dither_en[0:0];
        field { } isp_acm_dither_round[2:1];
        field { } isp_acm_dither_spatial_mode[3:3];
        field { } isp_acm_dither_out_bits[7:4];
    } ISP_ACM_DITHER @ 0x850;
    reg {
        name = "ISP_DRC_DITHER";
        field { } isp_drc_dither_en[0:0];
        field { } isp_drc_dither_round[2:1];
        field { } isp_drc_dither_spatial_mode[3:3];
        field { } isp_drc_dither_out_bits[7:4];
    } ISP_DRC_DITHER @ 0x860;
    reg {
        name = "ISP_SQRT1_DITHER";
        field { } isp_sqrt1_dither_en[0:0];
        field { } isp_sqrt1_dither_round[2:1];
        field { } isp_sqrt1_dither_spatial_mode[3:3];
        field { } isp_sqrt1_dither_out_bits[7:4];
    } ISP_SQRT1_DITHER @ 0x870;
    reg {
        name = "ISP_BLK_HBLANK";
        field { } isp_blk_b_hblank[15:0];
        field { } isp_blk_f_hblank[31:16];
    } ISP_BLK_HBLANK @ 0x878;
    reg {
        name = "ISP_BLK_VBLANK";
        field { } isp_blk_b_vblank[15:0];
        field { } isp_blk_f_vblank[31:16];
    } ISP_BLK_VBLANK @ 0x87C;
    reg {
        name = "ISP_Y_SUM0";
        field { } isp_y_sum0[31:0];
    } ISP_Y_SUM0 @ 0x880;
    reg {
        name = "ISP_Y_SUM1";
        field { } isp_y_sum1[31:0];
    } ISP_Y_SUM1 @ 0x884;
    reg {
        name = "ISP_YUV444_Y_SUM0";
        field { } isp_yuv444_y_sum0[31:0];
    } ISP_YUV444_Y_SUM0 @ 0x890;
    reg {
        name = "ISP_YUV444_Y_SUM1";
        field { } isp_yuv444_y_sum1[31:0];
    } ISP_YUV444_Y_SUM1 @ 0x894;
    reg {
        name = "ISP_YUV444_U_SUM0";
        field { } isp_yuv444_u_sum0[31:0];
    } ISP_YUV444_U_SUM0 @ 0x898;
    reg {
        name = "ISP_YUV444_U_SUM1";
        field { } isp_yuv444_u_sum1[31:0];
    } ISP_YUV444_U_SUM1 @ 0x89C;
    reg {
        name = "ISP_YUV444_V_SUM0";
        field { } isp_yuv444_v_sum0[31:0];
    } ISP_YUV444_V_SUM0 @ 0x8A0;
    reg {
        name = "ISP_YUV444_V_SUM1";
        field { } isp_yuv444_v_sum1[31:0];
    } ISP_YUV444_V_SUM1 @ 0x8A4;
    reg {
        name = "ISP_YUV422_Y_SUM0";
        field { } isp_yuv422_y_sum0[31:0];
    } ISP_YUV422_Y_SUM0 @ 0x8B0;
    reg {
        name = "ISP_YUV422_Y_SUM1";
        field { } isp_yuv422_y_sum1[31:0];
    } ISP_YUV422_Y_SUM1 @ 0x8B4;
    reg {
        name = "ISP_YUV422_C_SUM0";
        field { } isp_yuv422_c_sum0[31:0];
    } ISP_YUV422_C_SUM0 @ 0x8B8;
    reg {
        name = "ISP_YUV422_C_SUM1";
        field { } isp_yuv422_c_sum1[31:0];
    } ISP_YUV422_C_SUM1 @ 0x8BC;
    reg {
        name = "ISP_WDR0_SUM0";
        field { } isp_wdr0_sum0[31:0];
    } ISP_WDR0_SUM0 @ 0x8C0;
    reg {
        name = "ISP_WDR0_SUM1";
        field { } isp_wdr0_sum1[31:0];
    } ISP_WDR0_SUM1 @ 0x8C4;
    reg {
        name = "ISP_WDR1_SUM0";
        field { } isp_wdr1_sum0[31:0];
    } ISP_WDR1_SUM0 @ 0x8C8;
    reg {
        name = "ISP_WDR1_SUM1";
        field { } isp_wdr1_sum1[31:0];
    } ISP_WDR1_SUM1 @ 0x8CC;
    reg {
        name = "ISP_WDR2_SUM0";
        field { } isp_wdr2_sum0[31:0];
    } ISP_WDR2_SUM0 @ 0x8D0;
    reg {
        name = "ISP_WDR2_SUM1";
        field { } isp_wdr2_sum1[31:0];
    } ISP_WDR2_SUM1 @ 0x8D4;
    reg {
        name = "ISP_WDR3_SUM0";
        field { } isp_wdr3_sum0[31:0];
    } ISP_WDR3_SUM0 @ 0x8D8;
    reg {
        name = "ISP_WDR3_SUM1";
        field { } isp_wdr3_sum1[31:0];
    } ISP_WDR3_SUM1 @ 0x8DC;
    reg {
        name = "ISP_DEMOSAIC_SUM0";
        field { } isp_demosaic_sum0[31:0];
    } ISP_DEMOSAIC_SUM0 @ 0x8E0;
    reg {
        name = "ISP_DEMOSAIC_SUM1";
        field { } isp_demosaic_sum1[31:0];
    } ISP_DEMOSAIC_SUM1 @ 0x8E4;
    reg {
        name = "ISP_BLC_VERSION";
        field { } value[31:0];
    } ISP_BLC_VERSION @ 0x100C;
    reg {
        name = "ISP_BLC_OFFSET1";
        field { } isp_blc_ofsgr[14:0];
        field { } isp_blc_ofsr[30:16];
    } ISP_BLC_OFFSET1 @ 0x1010;
    reg {
        name = "ISP_BLC_OFFSET2";
        field { } isp_blc_ofsgb[14:0];
        field { } isp_blc_ofsb[30:16];
    } ISP_BLC_OFFSET2 @ 0x1014;
    reg {
        name = "ISP_WB_BLC_CFG";
        field { } isp_wb_en_in[0:0];
        field { } isp_wb_en_out[1:1];
    } ISP_WB_BLC_CFG @ 0x1204;
    reg {
        name = "ISP_WB_VERSION";
        field { } value[31:0];
    } ISP_WB_VERSION @ 0x120C;
    reg {
        name = "ISP_WB_GAIN1";
        field { } isp_wb_grgain[15:0];
        field { } isp_wb_rgain[31:16];
    } ISP_WB_GAIN1 @ 0x1210;
    reg {
        name = "ISP_WB_GAIN2";
        field { } isp_wb_gbgain[15:0];
        field { } isp_wb_bgain[31:16];
    } ISP_WB_GAIN2 @ 0x1214;
    reg {
        name = "ISP_WB_BLC_OFFSET1";
        field { } isp_wb_ofsgr[14:0];
        field { } isp_wb_ofsr[30:16];
    } ISP_WB_BLC_OFFSET1 @ 0x1218;
    reg {
        name = "ISP_WB_BLC_OFFSET2";
        field { } isp_wb_ofsgb[14:0];
        field { } isp_wb_ofsb[30:16];
    } ISP_WB_BLC_OFFSET2 @ 0x121C;
    reg {
        name = "ISP_WB_CLIP_VALUE";
        field { } isp_wb_clip_value[19:0];
    } ISP_WB_CLIP_VALUE @ 0x1220;
    reg {
        name = "ISP_DG_BLC_CFG";
        field { } isp_dg_en_in[0:0];
        field { } isp_dg_en_out[1:1];
    } ISP_DG_BLC_CFG @ 0x1304;
    reg {
        name = "ISP_DG_VERSION";
        field { } value[31:0];
    } ISP_DG_VERSION @ 0x130C;
    reg {
        name = "ISP_DG_GAIN1";
        field { } isp_dg_grgain[15:0];
        field { } isp_dg_rgain[31:16];
    } ISP_DG_GAIN1 @ 0x1310;
    reg {
        name = "ISP_DG_GAIN2";
        field { } isp_dg_gbgain[15:0];
        field { } isp_dg_bgain[31:16];
    } ISP_DG_GAIN2 @ 0x1314;
    reg {
        name = "ISP_DG_BLC_OFFSET1";
        field { } isp_dg_ofsgr[14:0];
        field { } isp_dg_ofsr[30:16];
    } ISP_DG_BLC_OFFSET1 @ 0x1318;
    reg {
        name = "ISP_DG_BLC_OFFSET2";
        field { } isp_dg_ofsgb[14:0];
        field { } isp_dg_ofsb[30:16];
    } ISP_DG_BLC_OFFSET2 @ 0x131C;
    reg {
        name = "ISP_DG_CLIP_VALUE";
        field { } isp_dg_clip_value[19:0];
    } ISP_DG_CLIP_VALUE @ 0x1320;
    reg {
        name = "ISP_CC_CFG";
        field { } isp_cc_colortone_en[2:2];
        field { } isp_cc_recover_en[3:3];
    } ISP_CC_CFG @ 0x1400;
    reg {
        name = "ISP_CC_VERSION";
        field { } isp_cc_version[31:0];
    } ISP_CC_VERSION @ 0x140C;
    reg {
        name = "ISP_CC_COEF0";
        field { } isp_cc_coef00[15:1];
        field { } isp_cc_coef01[31:17];
    } ISP_CC_COEF0 @ 0x1410;
    reg {
        name = "ISP_CC_COEF1";
        field { } isp_cc_coef02[15:1];
        field { } isp_cc_coef10[31:17];
    } ISP_CC_COEF1 @ 0x1414;
    reg {
        name = "ISP_CC_COEF2";
        field { } isp_cc_coef11[15:1];
        field { } isp_cc_coef12[31:17];
    } ISP_CC_COEF2 @ 0x1418;
    reg {
        name = "ISP_CC_COEF3";
        field { } isp_cc_coef20[15:1];
        field { } isp_cc_coef21[31:17];
    } ISP_CC_COEF3 @ 0x141C;
    reg {
        name = "ISP_CC_COEF4";
        field { } isp_cc_coef22[15:1];
    } ISP_CC_COEF4 @ 0x1420;
    reg {
        name = "ISP_CC_RCV_CTRL0";
        field { } isp_cc_soft_clip0_step[5:0];
        field { } isp_cc_soft_clip1_step[13:8];
    } ISP_CC_RCV_CTRL0 @ 0x1430;
    reg {
        name = "ISP_CC_RCV_CTRL1";
        field { } isp_cc_darkprev[4:0];
        field { } isp_cc_peaksupp_sat[15:8];
        field { } isp_cc_peaksupp_max[23:16];
    } ISP_CC_RCV_CTRL1 @ 0x1434;
    reg {
        name = "ISP_CC_LUMAFACT";
        field { } isp_cc_luma_coefr[4:0];
        field { } isp_cc_luma_coefb[12:8];
        field { } isp_cc_luma_coefr_up[20:16];
        field { } isp_cc_luma_coefb_up[28:24];
    } ISP_CC_LUMAFACT @ 0x1438;
    reg {
        name = "ISP_CC_COLORTONE_RB_GAIN";
        field { } isp_cc_b_gain[11:0];
        field { } isp_cc_r_gain[27:16];
    } ISP_CC_COLORTONE_RB_GAIN @ 0x143C;
    reg {
        name = "ISP_CC_COLORTONE_G_GAIN";
        field { } isp_cc_g_gain[11:0];
    } ISP_CC_COLORTONE_G_GAIN @ 0x1440;
    reg {
        name = "ISP_CC_IN_DC0";
        field { } isp_cc_in_dc0[12:0];
    } ISP_CC_IN_DC0 @ 0x1464;
    reg {
        name = "ISP_CC_IN_DC1";
        field { } isp_cc_in_dc1[12:0];
    } ISP_CC_IN_DC1 @ 0x1468;
    reg {
        name = "ISP_CC_IN_DC2";
        field { } isp_cc_in_dc2[12:0];
    } ISP_CC_IN_DC2 @ 0x146C;
    reg {
        name = "ISP_CC_OUT_DC0";
        field { } isp_cc_out_dc0[12:0];
    } ISP_CC_OUT_DC0 @ 0x1470;
    reg {
        name = "ISP_CC_OUT_DC1";
        field { } isp_cc_out_dc1[12:0];
    } ISP_CC_OUT_DC1 @ 0x1474;
    reg {
        name = "ISP_CC_OUT_DC2";
        field { } isp_cc_out_dc2[12:0];
    } ISP_CC_OUT_DC2 @ 0x1478;
    reg {
        name = "ISP_CSC_VERSION";
        field { } isp_csc_version[31:0];
    } ISP_CSC_VERSION @ 0x150C;
    reg {
        name = "ISP_CSC_COEF0";
        field { } isp_csc_coef00[15:1];
        field { } isp_csc_coef01[31:17];
    } ISP_CSC_COEF0 @ 0x1510;
    reg {
        name = "ISP_CSC_COEF1";
        field { } isp_csc_coef02[15:1];
        field { } isp_csc_coef10[31:17];
    } ISP_CSC_COEF1 @ 0x1514;
    reg {
        name = "ISP_CSC_COEF2";
        field { } isp_csc_coef11[15:1];
        field { } isp_csc_coef12[31:17];
    } ISP_CSC_COEF2 @ 0x1518;
    reg {
        name = "ISP_CSC_COEF3";
        field { } isp_csc_coef20[15:1];
        field { } isp_csc_coef21[31:17];
    } ISP_CSC_COEF3 @ 0x151C;
    reg {
        name = "ISP_CSC_COEF4";
        field { } isp_csc_coef22[15:1];
    } ISP_CSC_COEF4 @ 0x1520;
    reg {
        name = "ISP_CSC_IN_DC0";
        field { } isp_csc_in_dc0[15:5];
        field { } isp_csc_in_dc1[31:21];
    } ISP_CSC_IN_DC0 @ 0x1530;
    reg {
        name = "ISP_CSC_IN_DC1";
        field { } isp_csc_in_dc2[15:5];
    } ISP_CSC_IN_DC1 @ 0x1534;
    reg {
        name = "ISP_CSC_OUT_DC0";
        field { } isp_csc_out_dc0[15:5];
        field { } isp_csc_out_dc1[31:21];
    } ISP_CSC_OUT_DC0 @ 0x1540;
    reg {
        name = "ISP_CSC_OUT_DC1";
        field { } isp_csc_out_dc2[15:5];
    } ISP_CSC_OUT_DC1 @ 0x1544;
    reg {
        name = "ISP_HCDS_VERSION";
        field { } isp_hcds_version[31:0];
    } ISP_HCDS_VERSION @ 0x180C;
    reg {
        name = "ISP_HCDS_COEFH0";
        field { } isp_hcds_coefh1[10:0];
        field { } isp_hcds_coefh0[26:16];
    } ISP_HCDS_COEFH0 @ 0x1810;
    reg {
        name = "ISP_HCDS_COEFH1";
        field { } isp_hcds_coefh3[10:0];
        field { } isp_hcds_coefh2[26:16];
    } ISP_HCDS_COEFH1 @ 0x1814;
    reg {
        name = "ISP_HCDS_COEFH2";
        field { } isp_hcds_coefh5[10:0];
        field { } isp_hcds_coefh4[26:16];
    } ISP_HCDS_COEFH2 @ 0x1818;
    reg {
        name = "ISP_HCDS_COEFH3";
        field { } isp_hcds_coefh7[10:0];
        field { } isp_hcds_coefh6[26:16];
    } ISP_HCDS_COEFH3 @ 0x181C;
    reg {
        name = "ISP_4DG_BLC_CFG";
        field { } isp_4dg_en_in[0:0];
        field { } isp_4dg_en_out[1:1];
    } ISP_4DG_BLC_CFG @ 0x1C04;
    reg {
        name = "ISP_4DG_VERSION";
        field { } isp_4dg_version[31:0];
    } ISP_4DG_VERSION @ 0x1C0C;
    reg {
        name = "ISP_4DG_0_GAIN1";
        field { } isp_4dg0_grgain[15:0];
        field { } isp_4dg0_rgain[31:16];
    } ISP_4DG_0_GAIN1 @ 0x1C10;
    reg {
        name = "ISP_4DG_0_GAIN2";
        field { } isp_4dg0_gbgain[15:0];
        field { } isp_4dg0_bgain[31:16];
    } ISP_4DG_0_GAIN2 @ 0x1C14;
    reg {
        name = "ISP_4DG_0_BLC_OFFSET1";
        field { } isp_4dg0_ofsgr[14:0];
        field { } isp_4dg0_ofsr[30:16];
    } ISP_4DG_0_BLC_OFFSET1 @ 0x1C18;
    reg {
        name = "ISP_4DG_0_BLC_OFFSET2";
        field { } isp_4dg0_ofsgb[14:0];
        field { } isp_4dg0_ofsb[30:16];
    } ISP_4DG_0_BLC_OFFSET2 @ 0x1C1C;
    reg {
        name = "ISP_4DG_1_GAIN1";
        field { } isp_4dg1_grgain[15:0];
        field { } isp_4dg1_rgain[31:16];
    } ISP_4DG_1_GAIN1 @ 0x1C20;
    reg {
        name = "ISP_4DG_1_GAIN2";
        field { } isp_4dg1_gbgain[15:0];
        field { } isp_4dg1_bgain[31:16];
    } ISP_4DG_1_GAIN2 @ 0x1C24;
    reg {
        name = "ISP_4DG_1_BLC_OFFSET1";
        field { } isp_4dg1_ofsgr[14:0];
        field { } isp_4dg1_ofsr[30:16];
    } ISP_4DG_1_BLC_OFFSET1 @ 0x1C28;
    reg {
        name = "ISP_4DG_1_BLC_OFFSET2";
        field { } isp_4dg1_ofsgb[14:0];
        field { } isp_4dg1_ofsb[30:16];
    } ISP_4DG_1_BLC_OFFSET2 @ 0x1C2C;
    reg {
        name = "ISP_4DG_0_CLIP_VALUE";
        field { } isp_4dg0_clip_value[19:0];
    } ISP_4DG_0_CLIP_VALUE @ 0x1C50;
    reg {
        name = "ISP_4DG_1_CLIP_VALUE";
        field { } isp_4dg1_clip_value[19:0];
    } ISP_4DG_1_CLIP_VALUE @ 0x1C54;
    reg {
        name = "ISP_AE_VERSION";
        field { } isp_ae_version[31:0];
    } ISP_AE_VERSION @ 0x200C;
    reg {
        name = "ISP_AE_ZONE";
        field { } isp_ae_hnum[4:0];
        field { } isp_ae_vnum[12:8];
    } ISP_AE_ZONE @ 0x2010;
    reg {
        name = "ISP_AE_SKIP_CRG";
        field { } isp_ae_skip_x[2:0];
        field { } isp_ae_offset_x[3:3];
        field { } isp_ae_skip_y[6:4];
        field { } isp_ae_offset_y[7:7];
    } ISP_AE_SKIP_CRG @ 0x2014;
    reg {
        name = "ISP_AE_TOTAL_STAT";
        field { } isp_ae_total_pixels[26:0];
    } ISP_AE_TOTAL_STAT @ 0x2018;
    reg {
        name = "ISP_AE_COUNT_STAT";
        field { } isp_ae_count_pixels[30:0];
    } ISP_AE_COUNT_STAT @ 0x201C;
    reg {
        name = "ISP_AE_TOTAL_R_AVER";
        field { } isp_ae_total_r_aver[31:0];
    } ISP_AE_TOTAL_R_AVER @ 0x2020;
    reg {
        name = "ISP_AE_TOTAL_GR_AVER";
        field { } isp_ae_total_gr_aver[31:0];
    } ISP_AE_TOTAL_GR_AVER @ 0x2024;
    reg {
        name = "ISP_AE_TOTAL_GB_AVER";
        field { } isp_ae_total_gb_aver[31:0];
    } ISP_AE_TOTAL_GB_AVER @ 0x2028;
    reg {
        name = "ISP_AE_TOTAL_B_AVER";
        field { } isp_ae_total_b_aver[31:0];
    } ISP_AE_TOTAL_B_AVER @ 0x202C;
    reg {
        name = "ISP_AE_HIST_HIGH";
        field { } isp_aestgh[31:0];
    } ISP_AE_HIST_HIGH @ 0x2030;
    reg {
        name = "ISP_AE_BITMOVE";
        field { } isp_ae_bitmove[4:0];
        field { } isp_aest_gamma_mode[6:5];
        field { } isp_ae_aver_gamma_mode[8:7];
        field { } isp_ae_blc_en[9:9];
        field { } isp_ae_gamma_limit[13:10];
        field { } isp_ae_fourplanemode[14:14];
    } ISP_AE_BITMOVE @ 0x2040;
    reg {
        name = "ISP_AE_OFFSET_R_GR";
        field { } isp_ae_offset_r[14:0];
        field { } isp_ae_offset_gr[30:16];
    } ISP_AE_OFFSET_R_GR @ 0x2044;
    reg {
        name = "ISP_AE_OFFSET_GB_B";
        field { } isp_ae_offset_gb[14:0];
        field { } isp_ae_offset_b[30:16];
    } ISP_AE_OFFSET_GB_B @ 0x204C;
    reg {
        name = "ISP_AE_LUT_UPDATE";
        field { } isp_ae_lut_update[0:0];
    } ISP_AE_LUT_UPDATE @ 0x2064;
    reg {
        name = "ISP_AE_STT_BST";
        field { } isp_ae_stt_size[15:0];
        field { } isp_ae_stt_bst[19:16];
        field { } isp_ae_stt_en[20:20];
    } ISP_AE_STT_BST @ 0x2068;
    reg {
        name = "ISP_AE_CROP_POS";
        field { } isp_ae_crop_pos_x[15:0];
        field { } isp_ae_crop_pos_y[31:16];
    } ISP_AE_CROP_POS @ 0x2074;
    reg {
        name = "ISP_AE_CROP_OUTSIZE";
        field { } isp_ae_crop_out_width[15:0];
        field { } isp_ae_crop_out_height[31:16];
    } ISP_AE_CROP_OUTSIZE @ 0x2078;
    reg {
        name = "ISP_AE_HIST_WADDR";
        field { } value[31:0];
    } ISP_AE_HIST_WADDR @ 0x2080;
    reg {
        name = "ISP_AE_HIST_WDATA";
        field { } value[31:0];
    } ISP_AE_HIST_WDATA @ 0x2084;
    reg {
        name = "ISP_AE_HIST_RADDR";
        field { } isp_aest_raddr[31:0];
    } ISP_AE_HIST_RADDR @ 0x2088;
    reg {
        name = "ISP_AE_HIST_RDATA";
        field { } isp_aest_rdata[31:0];
    } ISP_AE_HIST_RDATA @ 0x208C;
    reg {
        name = "ISP_AE_AVER_R_GR_WADDR";
        field { } value[31:0];
    } ISP_AE_AVER_R_GR_WADDR @ 0x2090;
    reg {
        name = "ISP_AE_AVER_R_GR_WDATA";
        field { } value[31:0];
    } ISP_AE_AVER_R_GR_WDATA @ 0x2094;
    reg {
        name = "ISP_AE_AVER_R_GR_RADDR";
        field { } isp_ae_aver_r_gr_raddr[31:0];
    } ISP_AE_AVER_R_GR_RADDR @ 0x2098;
    reg {
        name = "ISP_AE_AVER_R_GR_RDATA";
        field { } isp_ae_aver_r_gr_rdata[31:0];
    } ISP_AE_AVER_R_GR_RDATA @ 0x209C;
    reg {
        name = "ISP_AE_AVER_GB_B_WADDR";
        field { } value[31:0];
    } ISP_AE_AVER_GB_B_WADDR @ 0x20A0;
    reg {
        name = "ISP_AE_AVER_GB_B_WDATA";
        field { } value[31:0];
    } ISP_AE_AVER_GB_B_WDATA @ 0x20A4;
    reg {
        name = "ISP_AE_AVER_GB_B_RADDR";
        field { } isp_ae_aver_gb_b_raddr[31:0];
    } ISP_AE_AVER_GB_B_RADDR @ 0x20A8;
    reg {
        name = "ISP_AE_AVER_GB_B_RDATA";
        field { } isp_ae_aver_gb_b_rdata[31:0];
    } ISP_AE_AVER_GB_B_RDATA @ 0x20AC;
    reg {
        name = "ISP_AE_WEIGHT_WADDR";
        field { } isp_ae_wei_waddr[31:0];
    } ISP_AE_WEIGHT_WADDR @ 0x20B0;
    reg {
        name = "ISP_AE_WEIGHT_WDATA";
        field { } isp_ae_wei_wdata[31:0];
    } ISP_AE_WEIGHT_WDATA @ 0x20B4;
    reg {
        name = "ISP_AE_WEIGHT_RADDR";
        field { } value[31:0];
    } ISP_AE_WEIGHT_RADDR @ 0x20B8;
    reg {
        name = "ISP_AE_WEIGHT_RDATA";
        field { } value[31:0];
    } ISP_AE_WEIGHT_RDATA @ 0x20BC;
    reg {
        name = "ISP_AWB_VERSION";
        field { } isp_awb_version[31:0];
    } ISP_AWB_VERSION @ 0x210C;
    reg {
        name = "ISP_AWB_ZONE";
        field { } isp_awb_hnum[5:0];
        field { } isp_awb_vnum[13:8];
    } ISP_AWB_ZONE @ 0x2110;
    reg {
        name = "ISP_AWB_BITMOVE";
        field { } isp_awb_bitmove[2:0];
    } ISP_AWB_BITMOVE @ 0x2114;
    reg {
        name = "ISP_AWB_THD_MIN";
        field { } isp_awb_threshold_min[15:0];
    } ISP_AWB_THD_MIN @ 0x2118;
    reg {
        name = "ISP_AWB_THD_MAX";
        field { } isp_awb_threshold_max[15:0];
    } ISP_AWB_THD_MAX @ 0x211C;
    reg {
        name = "ISP_AWB_CR_MM";
        field { } isp_awb_cr_ref_max[11:0];
        field { } isp_awb_cr_ref_min[27:16];
    } ISP_AWB_CR_MM @ 0x2120;
    reg {
        name = "ISP_AWB_CB_MM";
        field { } isp_awb_cb_ref_max[11:0];
        field { } isp_awb_cb_ref_min[27:16];
    } ISP_AWB_CB_MM @ 0x2124;
    reg {
        name = "ISP_AWB_OFFSET_COMP";
        field { } isp_awb_offset_comp[15:0];
    } ISP_AWB_OFFSET_COMP @ 0x2128;
    reg {
        name = "ISP_AWB_AVG_R";
        field { } isp_awb_avg_r[15:0];
    } ISP_AWB_AVG_R @ 0x2140;
    reg {
        name = "ISP_AWB_AVG_G";
        field { } isp_awb_avg_g[15:0];
    } ISP_AWB_AVG_G @ 0x2144;
    reg {
        name = "ISP_AWB_AVG_B";
        field { } isp_awb_avg_b[15:0];
    } ISP_AWB_AVG_B @ 0x2148;
    reg {
        name = "ISP_AWB_CNT_ALL";
        field { } isp_awb_count_all[15:0];
    } ISP_AWB_CNT_ALL @ 0x214C;
    reg {
        name = "ISP_AWB_STT_BST";
        field { } isp_awb_stt_size[15:0];
        field { } isp_awb_stt_bst[19:16];
        field { } isp_awb_stt_en[20:20];
    } ISP_AWB_STT_BST @ 0x2160;
    reg {
        name = "ISP_AWB_STT_ABN";
        field { } isp_awb_stt_info[15:0];
        field { } isp_awb_stt_clr[31:31];
    } ISP_AWB_STT_ABN @ 0x2164;
    reg {
        name = "ISP_AWB_CROP_POS";
        field { } isp_awb_crop_pos_x[15:0];
        field { } isp_awb_crop_pos_y[31:16];
    } ISP_AWB_CROP_POS @ 0x2174;
    reg {
        name = "ISP_AWB_CROP_OUTSIZE";
        field { } isp_awb_crop_out_width[15:0];
        field { } isp_awb_crop_out_height[31:16];
    } ISP_AWB_CROP_OUTSIZE @ 0x2178;
    reg {
        name = "ISP_AWB_STAT_WADDR";
        field { } value[31:0];
    } ISP_AWB_STAT_WADDR @ 0x2180;
    reg {
        name = "ISP_AWB_STAT_WDATA";
        field { } value[31:0];
    } ISP_AWB_STAT_WDATA @ 0x2184;
    reg {
        name = "ISP_AWB_STAT_RADDR";
        field { } isp_awb_stat_raddr[31:0];
    } ISP_AWB_STAT_RADDR @ 0x2188;
    reg {
        name = "ISP_AWB_STAT_RDATA";
        field { } isp_awb_stat_rdata[31:0];
    } ISP_AWB_STAT_RDATA @ 0x218C;
    reg {
        name = "ISP_AF_CFG";
        field { } isp_af_iir0_en0[1:1];
        field { } isp_af_iir0_en1[2:2];
        field { } isp_af_iir0_en2[3:3];
        field { } isp_af_iir1_en0[4:4];
        field { } isp_af_iir1_en1[5:5];
        field { } isp_af_iir1_en2[6:6];
        field { } isp_af_peak_mode[7:7];
        field { } isp_af_squ_mode[8:8];
        field { } isp_af_offset_en[9:9];
        field { } isp_af_crop_en[10:10];
        field { } isp_af_lpf_en[11:11];
        field { } isp_af_mean_en[12:12];
        field { } isp_af_raw_mode[14:14];
        field { } isp_af_bayer_mode[16:15];
        field { } isp_af_iir0_ds_en[17:17];
        field { } isp_af_iir1_ds_en[18:18];
        field { } isp_af_fir0_lpf_en[19:19];
        field { } isp_af_fir1_lpf_en[20:20];
        field { } isp_af_iir0_ldg_en[21:21];
        field { } isp_af_iir1_ldg_en[22:22];
        field { } isp_af_fir0_ldg_en[23:23];
        field { } isp_af_fir1_ldg_en[24:24];
        field { } isp_af_gamma[25:25];
    } ISP_AF_CFG @ 0x2200;
    reg {
        name = "ISP_AF_VERSION";
        field { } isp_af_version[31:0];
    } ISP_AF_VERSION @ 0x220C;
    reg {
        name = "ISP_AF_ZONE";
        field { } isp_af_hnum[4:0];
        field { } isp_af_vnum[12:8];
    } ISP_AF_ZONE @ 0x2210;
    reg {
        name = "ISP_AF_CROP_START";
        field { } isp_af_pos_x[12:0];
        field { } isp_af_pos_y[28:16];
    } ISP_AF_CROP_START @ 0x2214;
    reg {
        name = "ISP_AF_CROP_SIZE";
        field { } isp_af_crop_hsize[12:0];
        field { } isp_af_crop_vsize[28:16];
    } ISP_AF_CROP_SIZE @ 0x2218;
    reg {
        name = "ISP_AF_MEAN_THRES";
        field { } isp_af_mean_thres[15:0];
    } ISP_AF_MEAN_THRES @ 0x221C;
    reg {
        name = "ISP_AF_IIRG0";
        field { } isp_af_iirg0_0[7:0];
        field { } isp_af_iirg0_1[23:16];
    } ISP_AF_IIRG0 @ 0x2220;
    reg {
        name = "ISP_AF_IIRG1";
        field { } isp_af_iirg1_0[9:0];
        field { } isp_af_iirg1_1[25:16];
    } ISP_AF_IIRG1 @ 0x2224;
    reg {
        name = "ISP_AF_IIRG2";
        field { } isp_af_iirg2_0[9:0];
        field { } isp_af_iirg2_1[25:16];
    } ISP_AF_IIRG2 @ 0x2228;
    reg {
        name = "ISP_AF_IIRG3";
        field { } isp_af_iirg3_0[9:0];
        field { } isp_af_iirg3_1[25:16];
    } ISP_AF_IIRG3 @ 0x222C;
    reg {
        name = "ISP_AF_IIRG4";
        field { } isp_af_iirg4_0[9:0];
        field { } isp_af_iirg4_1[25:16];
    } ISP_AF_IIRG4 @ 0x2230;
    reg {
        name = "ISP_AF_IIRG5";
        field { } isp_af_iirg5_0[9:0];
        field { } isp_af_iirg5_1[25:16];
    } ISP_AF_IIRG5 @ 0x2234;
    reg {
        name = "ISP_AF_IIRG6";
        field { } isp_af_iirg6_0[9:0];
        field { } isp_af_iirg6_1[25:16];
    } ISP_AF_IIRG6 @ 0x2238;
    reg {
        name = "ISP_AF_IIRPL";
        field { } isp_af_iirplg_0[7:0];
        field { } isp_af_iirpls_0[10:8];
        field { } isp_af_iirplg_1[23:16];
        field { } isp_af_iirpls_1[26:24];
    } ISP_AF_IIRPL @ 0x223C;
    reg {
        name = "ISP_AF_SHIFT";
        field { } isp_af_iirshift0_0[2:0];
        field { } isp_af_iirshift0_1[6:4];
        field { } isp_af_iirshift0_2[10:8];
        field { } isp_af_iirshift0_3[14:12];
        field { } isp_af_iirshift1_0[18:16];
        field { } isp_af_iirshift1_1[22:20];
        field { } isp_af_iirshift1_2[26:24];
        field { } isp_af_iirshift1_3[30:28];
    } ISP_AF_SHIFT @ 0x2240;
    reg {
        name = "ISP_AF_FIRH0";
        field { } isp_af_firh0_0[5:0];
        field { } isp_af_firh0_1[21:16];
    } ISP_AF_FIRH0 @ 0x2250;
    reg {
        name = "ISP_AF_FIRH1";
        field { } isp_af_firh1_0[5:0];
        field { } isp_af_firh1_1[21:16];
    } ISP_AF_FIRH1 @ 0x2254;
    reg {
        name = "ISP_AF_FIRH2";
        field { } isp_af_firh2_0[5:0];
        field { } isp_af_firh2_1[21:16];
    } ISP_AF_FIRH2 @ 0x2258;
    reg {
        name = "ISP_AF_FIRH3";
        field { } isp_af_firh3_0[5:0];
        field { } isp_af_firh3_1[21:16];
    } ISP_AF_FIRH3 @ 0x225C;
    reg {
        name = "ISP_AF_FIRH4";
        field { } isp_af_firh4_0[5:0];
        field { } isp_af_firh4_1[21:16];
    } ISP_AF_FIRH4 @ 0x2260;
    reg {
        name = "ISP_AF_STT_BST";
        field { } isp_af_stt_size[15:0];
        field { } isp_af_stt_bst[19:16];
        field { } isp_af_stt_en[20:20];
    } ISP_AF_STT_BST @ 0x2264;
    reg {
        name = "ISP_AF_STT_ABN";
        field { } isp_af_stt_info[15:0];
        field { } isp_af_stt_clr[31:31];
    } ISP_AF_STT_ABN @ 0x2268;
    reg {
        name = "ISP_AF_ACC_SHIFT";
        field { } isp_af_acc_shift0_h[3:0];
        field { } isp_af_acc_shift1_h[7:4];
        field { } isp_af_acc_shift0_v[11:8];
        field { } isp_af_acc_shift1_v[15:12];
        field { } isp_af_acc_shift_y[19:16];
    } ISP_AF_ACC_SHIFT @ 0x2278;
    reg {
        name = "ISP_AF_CNT_SHIFT";
        field { } isp_af_cnt_shift0_h[3:0];
        field { } isp_af_cnt_shift1_h[7:4];
        field { } isp_af_cnt_shift0_v[11:8];
        field { } isp_af_cnt_shift1_v[15:12];
        field { } isp_af_cnt_shift_y[19:16];
    } ISP_AF_CNT_SHIFT @ 0x227C;
    reg {
        name = "ISP_AF_STAT_RADDR";
        field { } isp_af_stat_raddr[31:0];
    } ISP_AF_STAT_RADDR @ 0x2288;
    reg {
        name = "ISP_AF_STAT_RDATA";
        field { } isp_af_stat_rdata[31:0];
    } ISP_AF_STAT_RDATA @ 0x228C;
    reg {
        name = "ISP_AF_IIRTHRE";
        field { } isp_af_iir_thre0_l[7:0];
        field { } isp_af_iir_thre0_h[15:8];
        field { } isp_af_iir_thre1_l[23:16];
        field { } isp_af_iir_thre1_h[31:24];
    } ISP_AF_IIRTHRE @ 0x2300;
    reg {
        name = "ISP_AF_IIRGAIN";
        field { } isp_af_iir_gain0_l[7:0];
        field { } isp_af_iir_gain0_h[15:8];
        field { } isp_af_iir_gain1_l[23:16];
        field { } isp_af_iir_gain1_h[31:24];
    } ISP_AF_IIRGAIN @ 0x2304;
    reg {
        name = "ISP_AF_IIRSLOPE";
        field { } isp_af_iir_slope0_l[3:0];
        field { } isp_af_iir_slope0_h[7:4];
        field { } isp_af_iir_slope1_l[19:16];
        field { } isp_af_iir_slope1_h[23:20];
    } ISP_AF_IIRSLOPE @ 0x2308;
    reg {
        name = "ISP_AF_IIRDILATE";
        field { } isp_af_iir_dilate0[2:0];
        field { } isp_af_iir_dilate1[10:8];
    } ISP_AF_IIRDILATE @ 0x230C;
    reg {
        name = "ISP_AF_FIRTHRE";
        field { } isp_af_fir_thre0_l[7:0];
        field { } isp_af_fir_thre0_h[15:8];
        field { } isp_af_fir_thre1_l[23:16];
        field { } isp_af_fir_thre1_h[31:24];
    } ISP_AF_FIRTHRE @ 0x2310;
    reg {
        name = "ISP_AF_FIRGAIN";
        field { } isp_af_fir_gain0_l[7:0];
        field { } isp_af_fir_gain0_h[15:8];
        field { } isp_af_fir_gain1_l[23:16];
        field { } isp_af_fir_gain1_h[31:24];
    } ISP_AF_FIRGAIN @ 0x2314;
    reg {
        name = "ISP_AF_FIRSLOPE";
        field { } isp_af_fir_slope0_l[3:0];
        field { } isp_af_fir_slope0_h[7:4];
        field { } isp_af_fir_slope1_l[19:16];
        field { } isp_af_fir_slope1_h[23:20];
    } ISP_AF_FIRSLOPE @ 0x2318;
    reg {
        name = "ISP_AF_IIRTHRE_CORING";
        field { } isp_af_iir_thre0_c[10:0];
        field { } isp_af_iir_thre1_c[26:16];
    } ISP_AF_IIRTHRE_CORING @ 0x2320;
    reg {
        name = "ISP_AF_IIRPEAK_CORING";
        field { } isp_af_iir_peak0_c[10:0];
        field { } isp_af_iir_peak1_c[26:16];
    } ISP_AF_IIRPEAK_CORING @ 0x2324;
    reg {
        name = "ISP_AF_IIRSLOPE_CORING";
        field { } isp_af_iir_slope0_c[3:0];
        field { } isp_af_iir_slope1_c[11:8];
    } ISP_AF_IIRSLOPE_CORING @ 0x2328;
    reg {
        name = "ISP_AF_FIRTHRE_CORING";
        field { } isp_af_fir_thre0_c[10:0];
        field { } isp_af_fir_thre1_c[26:16];
    } ISP_AF_FIRTHRE_CORING @ 0x2330;
    reg {
        name = "ISP_AF_FIRPEAK_CORING";
        field { } isp_af_fir_peak0_c[10:0];
        field { } isp_af_fir_peak1_c[26:16];
    } ISP_AF_FIRPEAK_CORING @ 0x2334;
    reg {
        name = "ISP_AF_FIRSLOPE_CORING";
        field { } isp_af_fir_slope0_c[3:0];
        field { } isp_af_fir_slope1_c[11:8];
    } ISP_AF_FIRSLOPE_CORING @ 0x2338;
    reg {
        name = "ISP_AF_LIGHT";
        field { } isp_aflight[7:0];
    } ISP_AF_LIGHT @ 0x2340;
    reg {
        name = "ISP_AF_OFFSET";
        field { } isp_af_offset_gr[13:0];
        field { } isp_af_offset_gb[29:16];
    } ISP_AF_OFFSET @ 0x2344;
    reg {
        name = "ISP_DIS_CFG";
        field { } isp_dis_blc_en[1:1];
    } ISP_DIS_CFG @ 0x2400;
    reg {
        name = "ISP_DIS_BLK";
        field { } isp_dis_blk_size_0[0:0];
        field { } isp_dis_blk_size[8:1];
        field { } isp_dis_srch_range_0[16:16];
        field { } isp_dis_srch_range[23:17];
    } ISP_DIS_BLK @ 0x2404;
    reg {
        name = "ISP_DIS_VERSION";
        field { } isp_dis_version[31:0];
    } ISP_DIS_VERSION @ 0x240C;
    reg {
        name = "ISP_DIS_V0POS";
        field { } isp_dis_v0pos_hor[9:0];
        field { } isp_dis_v0pos_ver[25:16];
    } ISP_DIS_V0POS @ 0x2410;
    reg {
        name = "ISP_DIS_V4POS";
        field { } isp_dis_v4pos_hor[9:0];
        field { } isp_dis_v4pos_ver[25:16];
    } ISP_DIS_V4POS @ 0x2414;
    reg {
        name = "ISP_DIS_V8POS";
        field { } isp_dis_v8pos_hor[9:0];
        field { } isp_dis_v8pos_ver[25:16];
    } ISP_DIS_V8POS @ 0x2418;
    reg {
        name = "ISP_DIS_V0POSE";
        field { } isp_dis_v0pose_hor[9:0];
        field { } isp_dis_v0pose_ver[25:16];
    } ISP_DIS_V0POSE @ 0x2420;
    reg {
        name = "ISP_DIS_V4POSE";
        field { } isp_dis_v4pose_hor[9:0];
        field { } isp_dis_v4pose_ver[25:16];
    } ISP_DIS_V4POSE @ 0x2424;
    reg {
        name = "ISP_DIS_V8POSE";
        field { } isp_dis_v8pose_hor[9:0];
        field { } isp_dis_v8pose_ver[25:16];
    } ISP_DIS_V8POSE @ 0x2428;
    reg {
        name = "ISP_DIS_H0POS";
        field { } isp_dis_h0pos_hor[9:0];
        field { } isp_dis_h0pos_ver[25:16];
    } ISP_DIS_H0POS @ 0x2430;
    reg {
        name = "ISP_DIS_H4POS";
        field { } isp_dis_h4pos_hor[9:0];
        field { } isp_dis_h4pos_ver[25:16];
    } ISP_DIS_H4POS @ 0x2434;
    reg {
        name = "ISP_DIS_H8POS";
        field { } isp_dis_h8pos_hor[9:0];
        field { } isp_dis_h8pos_ver[25:16];
    } ISP_DIS_H8POS @ 0x2438;
    reg {
        name = "ISP_DIS_H0POSE";
        field { } isp_dis_h0pose_hor[9:0];
        field { } isp_dis_h0pose_ver[25:16];
    } ISP_DIS_H0POSE @ 0x2440;
    reg {
        name = "ISP_DIS_H4POSE";
        field { } isp_dis_h4pose_hor[9:0];
        field { } isp_dis_h4pose_ver[25:16];
    } ISP_DIS_H4POSE @ 0x2444;
    reg {
        name = "ISP_DIS_H8POSE";
        field { } isp_dis_h8pose_hor[9:0];
        field { } isp_dis_h8pose_ver[25:16];
    } ISP_DIS_H8POSE @ 0x2448;
    reg {
        name = "ISP_DIS_RAW_LUMA";
        field { } isp_dis_raw_luma[0:0];
    } ISP_DIS_RAW_LUMA @ 0x2450;
    reg {
        name = "ISP_DIS_GAMMA_EN";
        field { } isp_dis_gamma_en[0:0];
    } ISP_DIS_GAMMA_EN @ 0x2454;
    reg {
        name = "ISP_DIS_OFFSET_GR";
        field { } isp_dis_offset_gr[19:0];
    } ISP_DIS_OFFSET_GR @ 0x245C;
    reg {
        name = "ISP_DIS_OFFSET_GB";
        field { } isp_dis_offset_gb[19:0];
    } ISP_DIS_OFFSET_GB @ 0x2460;
    reg {
        name = "ISP_DIS_SCALE";
        field { } isp_dis_hor_scale[1:0];
        field { } isp_dis_ver_scale[9:8];
    } ISP_DIS_SCALE @ 0x2464;
    reg {
        name = "ISP_DIS_REFINFO_UPDATE";
        field { } isp_dis_refinfo_update[0:0];
    } ISP_DIS_REFINFO_UPDATE @ 0x246C;
    reg {
        name = "ISP_DIS_PRJ_SHIFT";
        field { } isp_dis_h_prj_shift_bits[3:0];
        field { } isp_dis_v_prj_shift_bits[7:4];
    } ISP_DIS_PRJ_SHIFT @ 0x2470;
    reg {
        name = "ISP_DIS_STAT_WADDR";
        field { } value[31:0];
    } ISP_DIS_STAT_WADDR @ 0x2480;
    reg {
        name = "ISP_DIS_STAT_WDATA";
        field { } value[31:0];
    } ISP_DIS_STAT_WDATA @ 0x2484;
    reg {
        name = "ISP_DIS_STAT_RADDR";
        field { } isp_dis_stat_raddr[31:0];
    } ISP_DIS_STAT_RADDR @ 0x2488;
    reg {
        name = "ISP_DIS_STAT_RDATA";
        field { } isp_dis_h_stat_rdata[15:0];
        field { } isp_dis_v_stat_rdata[31:16];
    } ISP_DIS_STAT_RDATA @ 0x248C;
    reg {
        name = "ISP_DIS_REFINFO_WADDR";
        field { } isp_dis_refinfo_waddr[31:0];
    } ISP_DIS_REFINFO_WADDR @ 0x24A0;
    reg {
        name = "ISP_DIS_REFINFO_WDATA";
        field { } isp_dis_refinfo_wdata[31:0];
    } ISP_DIS_REFINFO_WDATA @ 0x24A4;
    reg {
        name = "ISP_DIS_REFINFO_RADDR";
        field { } isp_dis_refinfo_raddr[31:0];
    } ISP_DIS_REFINFO_RADDR @ 0x24A8;
    reg {
        name = "ISP_DIS_REFINFO_RDATA";
        field { } isp_dis_refinfo_rdata[31:0];
    } ISP_DIS_REFINFO_RDATA @ 0x24AC;
    reg {
        name = "ISP_LA_VERSION";
        field { } isp_la_version[31:0];
    } ISP_LA_VERSION @ 0x250C;
    reg {
        name = "ISP_LA_ZONE";
        field { } isp_la_hnum[4:0];
        field { } isp_la_vnum[12:8];
    } ISP_LA_ZONE @ 0x2510;
    reg {
        name = "ISP_LA_BITMOVE";
        field { } isp_la_bitmove[4:0];
        field { } isp_la_gamma_en[8:8];
        field { } isp_la_blc_en[9:9];
    } ISP_LA_BITMOVE @ 0x2540;
    reg {
        name = "ISP_LA_OFFSET_R";
        field { } isp_la_offset_r[14:0];
    } ISP_LA_OFFSET_R @ 0x2544;
    reg {
        name = "ISP_LA_OFFSET_GR";
        field { } isp_la_offset_gr[14:0];
    } ISP_LA_OFFSET_GR @ 0x2548;
    reg {
        name = "ISP_LA_OFFSET_GB";
        field { } isp_la_offset_gb[14:0];
    } ISP_LA_OFFSET_GB @ 0x254C;
    reg {
        name = "ISP_LA_OFFSET_B";
        field { } isp_la_offset_b[14:0];
    } ISP_LA_OFFSET_B @ 0x2550;
    reg {
        name = "ISP_LA_GAMMA_LIMIT";
        field { } isp_la_gamma_limit[3:0];
    } ISP_LA_GAMMA_LIMIT @ 0x2560;
    reg {
        name = "ISP_LA_CROP_POS";
        field { } isp_la_crop_pos_x[15:0];
        field { } isp_la_crop_pos_y[31:16];
    } ISP_LA_CROP_POS @ 0x2564;
    reg {
        name = "ISP_LA_CROP_OUTSIZE";
        field { } isp_la_crop_out_width[15:0];
        field { } isp_la_crop_out_height[31:16];
    } ISP_LA_CROP_OUTSIZE @ 0x2568;
    reg {
        name = "ISP_LA_STT_BST";
        field { } isp_la_stt_size[15:0];
        field { } isp_la_stt_bst[19:16];
        field { } isp_la_stt_en[20:20];
    } ISP_LA_STT_BST @ 0x2570;
    reg {
        name = "ISP_LA_STT_ABN";
        field { } isp_la_stt_info[15:0];
        field { } isp_la_stt_clr[31:31];
    } ISP_LA_STT_ABN @ 0x2574;
    reg {
        name = "ISP_LA_AVER_WADDR";
        field { } value[31:0];
    } ISP_LA_AVER_WADDR @ 0x2590;
    reg {
        name = "ISP_LA_AVER_WDATA";
        field { } value[31:0];
    } ISP_LA_AVER_WDATA @ 0x2594;
    reg {
        name = "ISP_LA_AVER_RADDR";
        field { } isp_la_aver_raddr[31:0];
    } ISP_LA_AVER_RADDR @ 0x2598;
    reg {
        name = "ISP_LA_AVER_RDATA";
        field { } isp_la_aver_rdata[31:0];
    } ISP_LA_AVER_RDATA @ 0x259C;
    reg {
        name = "ISP_LSC_MESH";
        field { } isp_lsc_mesh_str[9:0];
        field { } isp_lsc_mesh_scale[18:16];
    } ISP_LSC_MESH @ 0x3000;
    reg {
        name = "ISP_LSC_BLCEN";
        field { } isp_lsc_blc_in_en[0:0];
        field { } isp_lsc_blc_out_en[8:8];
    } ISP_LSC_BLCEN @ 0x3004;
    reg {
        name = "ISP_LSC_BLC0";
        field { } isp_lsc_blc_r[14:0];
        field { } isp_lsc_blc_gr[30:16];
    } ISP_LSC_BLC0 @ 0x3008;
    reg {
        name = "ISP_LSC_BLC1";
        field { } isp_lsc_blc_b[14:0];
        field { } isp_lsc_blc_gb[30:16];
    } ISP_LSC_BLC1 @ 0x300C;
    reg {
        name = "ISP_GE_VERSION";
        field { } isp_ge_version[31:0];
    } ISP_GE_VERSION @ 0x390C;
    reg {
        name = "ISP_GE0_CT_TH1";
        field { } isp_ge_ge0_ct_th1[15:0];
    } ISP_GE0_CT_TH1 @ 0x3910;
    reg {
        name = "ISP_GE0_CT_TH2";
        field { } isp_ge_ge0_ct_th2[15:0];
    } ISP_GE0_CT_TH2 @ 0x3914;
    reg {
        name = "ISP_GE0_CT_TH3";
        field { } isp_ge_ge0_ct_th3[15:0];
    } ISP_GE0_CT_TH3 @ 0x3918;
    reg {
        name = "ISP_GE0_CT_SLOPE";
        field { } isp_ge_ge0_ct_slope1[4:0];
        field { } isp_ge_ge0_ct_slope2[12:8];
    } ISP_GE0_CT_SLOPE @ 0x391C;
    reg {
        name = "ISP_GE_MODE";
        field { } isp_ge_gr_en[0:0];
        field { } isp_ge_gb_en[1:1];
        field { } isp_ge_gr_gb_en[2:2];
    } ISP_GE_MODE @ 0x3954;
    reg {
        name = "ISP_GE_STRENGTH";
        field { } isp_ge_strength[8:0];
    } ISP_GE_STRENGTH @ 0x3958;
    reg {
        name = "ISP_FPN_CFG";
        field { } isp_fpn_calib_offline[10:10];
    } ISP_FPN_CFG @ 0x3A00;
    reg {
        name = "ISP_FPN_CALIB_START";
        field { } isp_fpn_calib_start[0:0];
    } ISP_FPN_CALIB_START @ 0x3A04;
    reg {
        name = "ISP_FPN_CORR_CFG";
        field { } isp_fpn_correct0_en[0:0];
    } ISP_FPN_CORR_CFG @ 0x3A08;
    reg {
        name = "ISP_FPN_STAT";
        field { } isp_fpn_busy[0:0];
        field { } isp_fpn_vcnt[13:8];
        field { } isp_fpn_hcnt[31:16];
    } ISP_FPN_STAT @ 0x3A0C;
    reg {
        name = "ISP_FPN_WHITE_LEVEL";
        field { } isp_fpn_white_level[13:0];
    } ISP_FPN_WHITE_LEVEL @ 0x3A10;
    reg {
        name = "ISP_FPN_DIVCOEF";
        field { } isp_fpn_divcoef[12:0];
    } ISP_FPN_DIVCOEF @ 0x3A18;
    reg {
        name = "ISP_FPN_FRAMELOG2";
        field { } isp_fpn_framelog2[2:0];
    } ISP_FPN_FRAMELOG2 @ 0x3A1C;
    reg {
        name = "ISP_FPN_SUM0";
        field { } isp_fpn_sum0[31:0];
    } ISP_FPN_SUM0 @ 0x3A20;
    reg {
        name = "ISP_FPN_SUM1";
        field { } isp_fpn_sum1[31:0];
    } ISP_FPN_SUM1 @ 0x3A24;
    reg {
        name = "ISP_FPN_CORR0";
        field { } isp_fpn_offset0[11:0];
        field { } isp_fpn_strength0[31:16];
    } ISP_FPN_CORR0 @ 0x3A30;
    reg {
        name = "ISP_FPN_SHIFT";
        field { } isp_fpn_shift[3:0];
        field { } isp_fpn_in_shift[11:8];
        field { } isp_fpn_out_shift[19:16];
        field { } isp_fpn_frame_calib_shift[27:24];
    } ISP_FPN_SHIFT @ 0x3A40;
    reg {
        name = "ISP_FPN_MAX_O";
        field { } isp_fpn_max_o[15:0];
    } ISP_FPN_MAX_O @ 0x3A50;
    reg {
        name = "ISP_FPN_OVERFLOWTHR";
        field { } isp_fpn_overflowthr[13:0];
    } ISP_FPN_OVERFLOWTHR @ 0x3A54;
    reg {
        name = "ISP_FPN_BLACK_FRAME_OUT_SEL";
        field { } isp_fpn_data0_out_sel[0:0];
    } ISP_FPN_BLACK_FRAME_OUT_SEL @ 0x3A60;
    reg {
        name = "ISP_FPN_OVERLAP_CFG";
        field { } isp_fpn_overlap_width_l[15:0];
        field { } isp_fpn_overlap_width_r[31:16];
    } ISP_FPN_OVERLAP_CFG @ 0x3A64;
    reg {
        name = "ISP_FPN_CALIB_OFFLINE_SET";
        field { } isp_fpn_calib_offline_set[2:0];
    } ISP_FPN_CALIB_OFFLINE_SET @ 0x3A68;
    reg {
        name = "ISP_FPN_CALIB_STAT_CLEAR";
        field { } isp_fpn_calib_stat_clear[0:0];
    } ISP_FPN_CALIB_STAT_CLEAR @ 0x3A6C;
    reg {
        name = "ISP_DPC_ALPHA";
        field { } isp_dpc_alpha1_g[7:0];
        field { } isp_dpc_alpha1_rb[15:8];
        field { } isp_dpc_alpha0_g[23:16];
        field { } isp_dpc_alpha0_rb[31:24];
    } ISP_DPC_ALPHA @ 0x3C08;
    reg {
        name = "ISP_DPC_VERSION";
        field { } isp_dpc_version[31:0];
    } ISP_DPC_VERSION @ 0x3C0C;
    reg {
        name = "ISP_DPC_MODE";
        field { } isp_dpc_det_en[0:0];
        field { } isp_dpc_cor_en[1:1];
        field { } isp_dpc_grayscale_mode[4:4];
        field { } isp_dpc_dpghtlight_en[7:7];
        field { } isp_dpc_ir_position[8:8];
        field { } isp_dpc_ir_channel[9:9];
    } ISP_DPC_MODE @ 0x3C10;
    reg {
        name = "ISP_DPC_OUTPUT_MODE";
        field { } isp_dpc_stage1_incl_gr_center[0:0];
        field { } isp_dpc_stage1_incl_rb_center[1:1];
        field { } isp_dpc_stage1_incl_g_3x3[2:2];
        field { } isp_dpc_stage1_incl_rb_3x3[3:3];
    } ISP_DPC_OUTPUT_MODE @ 0x3C14;
    reg {
        name = "ISP_DPC_SET_USE";
        field { } isp_dpc_stage1_use_set1[0:0];
        field { } isp_dpc_stage1_use_set2[1:1];
        field { } isp_dpc_stage1_use_set3[2:2];
        field { } isp_dpc_stage1_use_fix_set[3:3];
    } ISP_DPC_SET_USE @ 0x3C18;
    reg {
        name = "ISP_DPC_METHODS_SET_1";
        field { } isp_dpc_pg_green1_enable[0:0];
        field { } isp_dpc_lc_green1_enable[1:1];
        field { } isp_dpc_ro_green1_enable[2:2];
        field { } isp_dpc_rnd_green1_enable[3:3];
        field { } isp_dpc_rg_green1_enable[4:4];
        field { } isp_dpc_pg_red_blue1_enable[8:8];
        field { } isp_dpc_lc_red_blue1_enable[9:9];
        field { } isp_dpc_ro_red_blue1_enable[10:10];
        field { } isp_dpc_rnd_red_blue1_enable[11:11];
        field { } isp_dpc_rg_red_blue1_enable[12:12];
    } ISP_DPC_METHODS_SET_1 @ 0x3C1C;
    reg {
        name = "ISP_DPC_METHODS_SET_2";
        field { } isp_dpc_pg_green2_enable[0:0];
        field { } isp_dpc_lc_green2_enable[1:1];
        field { } isp_dpc_ro_green2_enable[2:2];
        field { } isp_dpc_rnd_green2_enable[3:3];
        field { } isp_dpc_rg_green2_enable[4:4];
        field { } isp_dpc_pg_red_blue2_enable[8:8];
        field { } isp_dpc_lc_red_blue2_enable[9:9];
        field { } isp_dpc_ro_red_blue2_enable[10:10];
        field { } isp_dpc_rnd_red_blue2_enable[11:11];
        field { } isp_dpc_rg_red_blue2_enable[12:12];
    } ISP_DPC_METHODS_SET_2 @ 0x3C20;
    reg {
        name = "ISP_DPC_METHODS_SET_3";
        field { } isp_dpc_pg_green3_enable[0:0];
        field { } isp_dpc_lc_green3_enable[1:1];
        field { } isp_dpc_ro_green3_enable[2:2];
        field { } isp_dpc_rnd_green3_enable[3:3];
        field { } isp_dpc_rg_green3_enable[4:4];
        field { } isp_dpc_pg_red_blue3_enable[8:8];
        field { } isp_dpc_lc_red_blue3_enable[9:9];
        field { } isp_dpc_ro_red_blue3_enable[10:10];
        field { } isp_dpc_rnd_red_blue3_enable[11:11];
        field { } isp_dpc_rg_red_blue3_enable[12:12];
    } ISP_DPC_METHODS_SET_3 @ 0x3C24;
    reg {
        name = "ISP_DPC_LINE_THRESH_1";
        field { } isp_dpc_line_thr1_g[7:0];
        field { } isp_dpc_line_thr1_rb[15:8];
    } ISP_DPC_LINE_THRESH_1 @ 0x3C28;
    reg {
        name = "ISP_DPC_LINE_MAD_FAC_1";
        field { } isp_dpc_line_mad_fac_1_g[5:0];
        field { } isp_dpc_line_mad_fac_1_rb[13:8];
    } ISP_DPC_LINE_MAD_FAC_1 @ 0x3C2C;
    reg {
        name = "ISP_DPC_PG_FAC_1";
        field { } isp_dpc_pg_fac_1_g[5:0];
        field { } isp_dpc_pg_fac_1_rb[13:8];
    } ISP_DPC_PG_FAC_1 @ 0x3C30;
    reg {
        name = "ISP_DPC_RND_THRESH_1";
        field { } isp_dpc_rnd_thr1_g[7:0];
        field { } isp_dpc_rnd_thr1_rb[15:8];
    } ISP_DPC_RND_THRESH_1 @ 0x3C34;
    reg {
        name = "ISP_DPC_RG_FAC_1";
        field { } isp_dpc_rg_fac_1_g[5:0];
        field { } isp_dpc_rg_fac_1_rb[13:8];
    } ISP_DPC_RG_FAC_1 @ 0x3C38;
    reg {
        name = "ISP_DPC_LINE_THRESH_2";
        field { } isp_dpc_line_thr2_g[7:0];
        field { } isp_dpc_line_thr2_rb[15:8];
    } ISP_DPC_LINE_THRESH_2 @ 0x3C3C;
    reg {
        name = "ISP_DPC_LINE_MAD_FAC_2";
        field { } isp_dpc_line_mad_fac_2_g[5:0];
        field { } isp_dpc_line_mad_fac_2_rb[13:8];
    } ISP_DPC_LINE_MAD_FAC_2 @ 0x3C40;
    reg {
        name = "ISP_DPC_PG_FAC_2";
        field { } isp_dpc_pg_fac_2_g[5:0];
        field { } isp_dpc_pg_fac_2_rb[13:8];
    } ISP_DPC_PG_FAC_2 @ 0x3C44;
    reg {
        name = "ISP_DPC_RND_THRESH_2";
        field { } isp_dpc_rnd_thr2_g[7:0];
        field { } isp_dpc_rnd_thr2_rb[15:8];
    } ISP_DPC_RND_THRESH_2 @ 0x3C48;
    reg {
        name = "ISP_DPC_RG_FAC_2";
        field { } isp_dpc_rg_fac_2_g[5:0];
        field { } isp_dpc_rg_fac_2_rb[13:8];
    } ISP_DPC_RG_FAC_2 @ 0x3C4C;
    reg {
        name = "ISP_DPC_LINE_THRESH_3";
        field { } isp_dpc_line_thr3_g[7:0];
        field { } isp_dpc_line_thr3_rb[15:8];
    } ISP_DPC_LINE_THRESH_3 @ 0x3C50;
    reg {
        name = "ISP_DPC_LINE_MAD_FAC_3";
        field { } isp_dpc_line_mad_fac_3_g[5:0];
        field { } isp_dpc_line_mad_fac_3_rb[13:8];
    } ISP_DPC_LINE_MAD_FAC_3 @ 0x3C54;
    reg {
        name = "ISP_DPC_PG_FAC_3";
        field { } isp_dpc_pg_fac_3_g[5:0];
        field { } isp_dpc_pg_fac_3_rb[13:8];
    } ISP_DPC_PG_FAC_3 @ 0x3C58;
    reg {
        name = "ISP_DPC_RND_THRESH_3";
        field { } isp_dpc_rnd_thr3_g[7:0];
        field { } isp_dpc_rnd_thr3_rb[15:8];
    } ISP_DPC_RND_THRESH_3 @ 0x3C5C;
    reg {
        name = "ISP_DPC_RG_FAC_3";
        field { } isp_dpc_rg_fac_3_g[5:0];
        field { } isp_dpc_rg_fac_3_rb[13:8];
    } ISP_DPC_RG_FAC_3 @ 0x3C60;
    reg {
        name = "ISP_DPC_RO_LIMITS";
        field { } isp_dpc_ro_1_g[1:0];
        field { } isp_dpc_ro_1_rb[3:2];
        field { } isp_dpc_ro_2_g[5:4];
        field { } isp_dpc_ro_2_rb[7:6];
        field { } isp_dpc_ro_3_g[9:8];
        field { } isp_dpc_ro_3_rb[11:10];
    } ISP_DPC_RO_LIMITS @ 0x3C64;
    reg {
        name = "ISP_DPC_RND_OFFS";
        field { } isp_dpc_rnd_offs_1_g[1:0];
        field { } isp_dpc_rnd_offs_1_rb[3:2];
        field { } isp_dpc_rnd_offs_2_g[5:4];
        field { } isp_dpc_rnd_offs_2_rb[7:6];
        field { } isp_dpc_rnd_offs_3_g[9:8];
        field { } isp_dpc_rnd_offs_3_rb[11:10];
    } ISP_DPC_RND_OFFS @ 0x3C68;
    reg {
        name = "ISP_DPC_BPT_CTRL";
        field { } isp_dpc_bp_data[31:16];
    } ISP_DPC_BPT_CTRL @ 0x3C6C;
    reg {
        name = "ISP_DPC_RND_THRESH_1_MTP";
        field { } isp_dpc_rnd_thr1_g_mtp[9:0];
        field { } isp_dpc_rnd_thr1_rb_mtp[19:10];
    } ISP_DPC_RND_THRESH_1_MTP @ 0x3C70;
    reg {
        name = "ISP_DPC_RND_THRESH_2_MTP";
        field { } isp_dpc_rnd_thr2_g_mtp[9:0];
        field { } isp_dpc_rnd_thr2_rb_mtp[19:10];
    } ISP_DPC_RND_THRESH_2_MTP @ 0x3C74;
    reg {
        name = "ISP_DPC_RND_THRESH_3_MTP";
        field { } isp_dpc_rnd_thr3_g_mtp[9:0];
        field { } isp_dpc_rnd_thr3_rb_mtp[19:10];
    } ISP_DPC_RND_THRESH_3_MTP @ 0x3C78;
    reg {
        name = "ISP_DPC_SOFT_THR";
        field { } isp_dpc_ex_soft_thr_min[7:0];
        field { } isp_dpc_ex_soft_thr_max[15:8];
    } ISP_DPC_SOFT_THR @ 0x3D10;
    reg {
        name = "ISP_DPC_BHARDTHR_EN";
        field { } isp_dpc_ex_hard_thr_en[0:0];
    } ISP_DPC_BHARDTHR_EN @ 0x3D14;
    reg {
        name = "ISP_DPC_RAKERATIO";
        field { } isp_dpc_ex_rake_ratio[9:0];
    } ISP_DPC_RAKERATIO @ 0x3D18;
    reg {
        name = "ISP_DPC_LCH_THR_1";
        field { } isp_dpc_line_aver_fac_1[7:0];
        field { } isp_dpc_line_diff_thr_1[14:8];
        field { } isp_dpc_line_std_thr_1[27:16];
    } ISP_DPC_LCH_THR_1 @ 0x3D20;
    reg {
        name = "ISP_DPC_LCH_THR_2";
        field { } isp_dpc_line_aver_fac_2[7:0];
        field { } isp_dpc_line_diff_thr_2[14:8];
        field { } isp_dpc_line_std_thr_2[27:16];
    } ISP_DPC_LCH_THR_2 @ 0x3D24;
    reg {
        name = "ISP_DPC_LCH_THR_3";
        field { } isp_dpc_line_aver_fac_3[7:0];
        field { } isp_dpc_line_diff_thr_3[14:8];
        field { } isp_dpc_line_std_thr_3[27:16];
    } ISP_DPC_LCH_THR_3 @ 0x3D28;
    reg {
        name = "ISP_DPC_LCH_THR_4";
        field { } isp_dpc_line_aver_fac_4[7:0];
        field { } isp_dpc_line_diff_thr_4[14:8];
        field { } isp_dpc_line_std_thr_4[27:16];
    } ISP_DPC_LCH_THR_4 @ 0x3D2C;
    reg {
        name = "ISP_DPC_LCH_THR_5";
        field { } isp_dpc_line_aver_fac_5[7:0];
        field { } isp_dpc_line_diff_thr_5[14:8];
        field { } isp_dpc_line_std_thr_5[27:16];
    } ISP_DPC_LCH_THR_5 @ 0x3D30;
    reg {
        name = "ISP_DPC_LINE_KERDIFF_FAC";
        field { } isp_dpc_line_kerdiff_fac[7:0];
    } ISP_DPC_LINE_KERDIFF_FAC @ 0x3D34;
    reg {
        name = "ISP_DPC_BLEND_MODE";
        field { } isp_dpc_blend_mode[0:0];
    } ISP_DPC_BLEND_MODE @ 0x3D38;
    reg {
        name = "ISP_DPC_BIT_DEPTH_SEL";
        field { } isp_dpc_bit_depth_sel[0:0];
    } ISP_DPC_BIT_DEPTH_SEL @ 0x3D3C;
    reg {
        name = "ISP_DPC_RG_FAC_1_MTP";
        field { } isp_dpc_rg_fac_1_g_mtp[9:0];
        field { } isp_dpc_rg_fac_1_rb_mtp[19:10];
    } ISP_DPC_RG_FAC_1_MTP @ 0x3D4C;
    reg {
        name = "ISP_DPC_RG_FAC_2_MTP";
        field { } isp_dpc_rg_fac_2_g_mtp[9:0];
        field { } isp_dpc_rg_fac_2_rb_mtp[19:10];
    } ISP_DPC_RG_FAC_2_MTP @ 0x3D50;
    reg {
        name = "ISP_DPC_RG_FAC_3_MTP";
        field { } isp_dpc_rg_fac_3_g_mtp[9:0];
        field { } isp_dpc_rg_fac_3_rb_mtp[19:10];
    } ISP_DPC_RG_FAC_3_MTP @ 0x3D54;
    reg {
        name = "ISP_DEMOSAIC_CFG1";
        field { } isp_demosaic_ahd_en[0:0];
        field { } isp_demosaic_local_cac_en[17:17];
        field { } isp_demosaic_fcr_en[19:19];
        field { } isp_demosaic_cac_cor_mode[20:20];
        field { } isp_demosaic_de_fake_en[21:21];
        field { } isp_demosaic_desat_enable[24:24];
    } ISP_DEMOSAIC_CFG1 @ 0x4000;
    reg {
        name = "ISP_DEMOSAIC_COEF0";
        field { } isp_demosaic_bld_limit2[7:0];
        field { } isp_demosaic_bld_limit1[23:16];
    } ISP_DEMOSAIC_COEF0 @ 0x4004;
    reg {
        name = "ISP_DEMOSAIC_COEF2";
        field { } isp_demosaic_fcr_limit2[11:0];
        field { } isp_demosaic_fcr_limit1[27:16];
    } ISP_DEMOSAIC_COEF2 @ 0x4008;
    reg {
        name = "ISP_DEMOSAIC_COEF3";
        field { } isp_demosaic_ahd_par2[7:0];
        field { } isp_demosaic_ahd_par1[25:16];
    } ISP_DEMOSAIC_COEF3 @ 0x400C;
    reg {
        name = "ISP_DEMOSAIC_COEF4";
        field { } isp_demosaic_fcr_gain[4:0];
    } ISP_DEMOSAIC_COEF4 @ 0x4010;
    reg {
        name = "ISP_DEMOSAIC_COEF5";
        field { } isp_demosaic_hv_ratio[7:0];
    } ISP_DEMOSAIC_COEF5 @ 0x4014;
    reg {
        name = "ISP_DEMOSAIC_COEF6";
        field { } isp_demosaic_fcr_ratio[5:0];
    } ISP_DEMOSAIC_COEF6 @ 0x4018;
    reg {
        name = "ISP_DEMOSAIC_SEL";
        field { } isp_demosaic_hv_sel[1:0];
    } ISP_DEMOSAIC_SEL @ 0x401C;
    reg {
        name = "ISP_DEMOSAIC_LCAC_CNT_THR";
        field { } isp_demosaic_r_counter_thr[4:0];
        field { } isp_demosaic_b_counter_thr[9:5];
        field { } isp_demosaic_g_counter_thr[15:10];
    } ISP_DEMOSAIC_LCAC_CNT_THR @ 0x4020;
    reg {
        name = "ISP_DEMOSAIC_LCAC_LUMA_RB_THR";
        field { } isp_demosaic_r_luma_thr[11:0];
        field { } isp_demosaic_b_luma_thr[27:16];
    } ISP_DEMOSAIC_LCAC_LUMA_RB_THR @ 0x4024;
    reg {
        name = "ISP_DEMOSAIC_LCAC_LUMA_G_THR";
        field { } isp_demosaic_g_luma_thr[11:0];
    } ISP_DEMOSAIC_LCAC_LUMA_G_THR @ 0x4028;
    reg {
        name = "ISP_DEMOSAIC_PURPLE_VAR_THR";
        field { } isp_demosaic_purple_var_thr[11:0];
    } ISP_DEMOSAIC_PURPLE_VAR_THR @ 0x402C;
    reg {
        name = "ISP_DEMOSAIC_FAKE_CR_VAR_THR";
        field { } isp_demosaic_fake_cr_var_thr_low[11:0];
        field { } isp_demosaic_fake_cr_var_thrgh[27:16];
    } ISP_DEMOSAIC_FAKE_CR_VAR_THR @ 0x4030;
    reg {
        name = "ISP_DEMOSAIC_DEPURPLECTR";
        field { } isp_demosaic_depurplectrcb[3:0];
        field { } isp_demosaic_depurplectrcr[19:16];
    } ISP_DEMOSAIC_DEPURPLECTR @ 0x4034;
    reg {
        name = "ISP_DEMOSAIC_LPF_COEF";
        field { } isp_demosaic_lpf_f0[3:0];
        field { } isp_demosaic_lpf_f1[12:8];
        field { } isp_demosaic_lpf_f2[21:16];
        field { } isp_demosaic_lpf_f3[31:24];
    } ISP_DEMOSAIC_LPF_COEF @ 0x4038;
    reg {
        name = "ISP_DEMOSAIC_G_INTP_CTRL";
        field { } isp_demosaic_g_clip_sft_bit[3:0];
    } ISP_DEMOSAIC_G_INTP_CTRL @ 0x403C;
    reg {
        name = "ISP_DEMOSAIC_CBCRAVGTHLD";
        field { } isp_demosaic_cbcr_avg_thld[11:0];
    } ISP_DEMOSAIC_CBCRAVGTHLD @ 0x4040;
    reg {
        name = "ISP_DEMOSAIC_CC_HF_RATIO";
        field { } isp_demosaic_cc_hf_min_ratio[4:0];
        field { } isp_demosaic_cc_hf_max_ratio[12:8];
    } ISP_DEMOSAIC_CC_HF_RATIO @ 0x4044;
    reg {
        name = "ISP_DEMOSAIC_GVAR_BLEND_THLD";
        field { } isp_demosaic_varthrforblend[11:0];
    } ISP_DEMOSAIC_GVAR_BLEND_THLD @ 0x4048;
    reg {
        name = "ISP_DEMOSAIC_SATU_THR";
        field { } isp_demosaic_satu_thr[11:0];
    } ISP_DEMOSAIC_SATU_THR @ 0x404C;
    reg {
        name = "ISP_DEMOSAIC_CBCR_RATIO_LIMIT";
        field { } isp_demosaic_cbcr_ratiogh_limit[27:16];
    } ISP_DEMOSAIC_CBCR_RATIO_LIMIT @ 0x4050;
    reg {
        name = "ISP_DEMOSAIC_FCR_GRAY_RATIO";
        field { } isp_demosaic_fcr_gray_ratio[4:0];
    } ISP_DEMOSAIC_FCR_GRAY_RATIO @ 0x4054;
    reg {
        name = "ISP_DEMOSAIC_FCR_SEL";
        field { } isp_demosaic_fcr_detg_sel[3:0];
        field { } isp_demosaic_fcr_cmax_sel[7:4];
    } ISP_DEMOSAIC_FCR_SEL @ 0x4058;
    reg {
        name = "ISP_DEMOSAIC_CC_VAR_THRESH";
        field { } isp_demosaic_cc_var_thresh[12:0];
    } ISP_DEMOSAIC_CC_VAR_THRESH @ 0x405C;
    reg {
        name = "ISP_DEMOSAIC_HF_INTP_BLUR_TH";
        field { } isp_demosaic_hf_intp_blur_th1[9:0];
        field { } isp_demosaic_hf_intp_blur_th2[25:16];
    } ISP_DEMOSAIC_HF_INTP_BLUR_TH @ 0x4060;
    reg {
        name = "ISP_DEMOSAIC_HF_INTP_BLUR_RATIO";
        field { } isp_demosaic_hf_intp_blur_ratio[12:0];
    } ISP_DEMOSAIC_HF_INTP_BLUR_RATIO @ 0x4064;
    reg {
        name = "ISP_DEMOSAIC_CAC_CBCR_THR";
        field { } isp_demosaic_cb_thr[11:0];
        field { } isp_demosaic_luma_thr[27:16];
    } ISP_DEMOSAIC_CAC_CBCR_THR @ 0x4068;
    reg {
        name = "ISP_DEMOSAIC_CAC_LUMA_HIGH_CNT_THR";
        field { } isp_demosaic_cac_lumagh_cnt_thr[7:0];
    } ISP_DEMOSAIC_CAC_LUMA_HIGH_CNT_THR @ 0x406C;
    reg {
        name = "ISP_DEMOSAIC_CAC_CNT_CFG";
        field { } isp_demosaic_cac_cb_cnt_ratio[10:0];
        field { } isp_demosaic_cac_cb_cnt_low_thr[22:16];
        field { } isp_demosaic_cac_cb_cntgh_thr[30:24];
    } ISP_DEMOSAIC_CAC_CNT_CFG @ 0x4070;
    reg {
        name = "ISP_DEMOSAIC_DEFCOLOR_COEF";
        field { } isp_demosaic_defcolor_cr[3:0];
        field { } isp_demosaic_defcolor_cb[19:16];
    } ISP_DEMOSAIC_DEFCOLOR_COEF @ 0x4074;
    reg {
        name = "ISP_DEMOSAIC_CAC_BLD_AVG";
        field { } isp_demosaci_cac_bld_avg_cur[3:0];
    } ISP_DEMOSAIC_CAC_BLD_AVG @ 0x4078;
    reg {
        name = "ISP_DEMOSAIC_FCR_HF_THR";
        field { } isp_demosaic_fcr_thresh1[9:0];
        field { } isp_demosaic_fcr_thresh2[25:16];
    } ISP_DEMOSAIC_FCR_HF_THR @ 0x407C;
    reg {
        name = "ISP_DEMOSAIC_DEPURPLUT_WADDR";
        field { } isp_demosaic_depurplut_waddr[3:0];
    } ISP_DEMOSAIC_DEPURPLUT_WADDR @ 0x4080;
    reg {
        name = "ISP_DEMOSAIC_DEPURPLUT_WDATA";
        field { } isp_demosaic_depurplut_wdata[3:0];
    } ISP_DEMOSAIC_DEPURPLUT_WDATA @ 0x4084;
    reg {
        name = "ISP_DEMOSAIC_DEPURPLUT_RADDR";
        field { } isp_demosaic_depurplut_raddr[3:0];
    } ISP_DEMOSAIC_DEPURPLUT_RADDR @ 0x4088;
    reg {
        name = "ISP_DEMOSAIC_DEPURPLUT_RDATA";
        field { } isp_demosaic_depurplut_rdata[3:0];
    } ISP_DEMOSAIC_DEPURPLUT_RDATA @ 0x408C;
    reg {
        name = "ISP_DEMOSAIC_DESAT_THR";
        field { } isp_demosaic_desat_thresh1[9:0];
        field { } isp_demosaic_desat_thresh2[25:16];
    } ISP_DEMOSAIC_DESAT_THR @ 0x4100;
    reg {
        name = "ISP_DEMOSAIC_DESAT_BLDR";
        field { } isp_demosaic_desatg[8:0];
        field { } isp_demosaic_desat_low[24:16];
    } ISP_DEMOSAIC_DESAT_BLDR @ 0x4104;
    reg {
        name = "ISP_DEMOSAIC_DESAT_BLDR_RATIO";
        field { } isp_demosaic_desat_ratio[12:0];
    } ISP_DEMOSAIC_DESAT_BLDR_RATIO @ 0x4108;
    reg {
        name = "ISP_DEMOSAIC_DESAT_PROTECT";
        field { } isp_demosaic_desat_protect_sl[9:0];
        field { } isp_demosaic_desat_protect_th[25:16];
    } ISP_DEMOSAIC_DESAT_PROTECT @ 0x410C;
    reg {
        name = "ISP_DEMOSAIC_LUT_UPDATE";
        field { } isp_demosaic_depurplut_update[0:0];
    } ISP_DEMOSAIC_LUT_UPDATE @ 0x4110;
    reg {
        name = "ISP_RGBIR_CFG";
        field { } isp_rgbir_blc_in_en[0:0];
        field { } isp_rgbir_blc_out_en[1:1];
        field { } isp_rgbir_ir_pattern_in[4:2];
        field { } isp_rgbir_pattern_out[6:5];
    } ISP_RGBIR_CFG @ 0x4800;
    reg {
        name = "ISP_RGBIR_THRE";
        field { } isp_rgbir_th[7:0];
        field { } isp_rgbir_tv[23:16];
    } ISP_RGBIR_THRE @ 0x4804;
    reg {
        name = "ISP_RGBIR_VERSION";
        field { } isp_rgbir_version[31:0];
    } ISP_RGBIR_VERSION @ 0x480C;
    reg {
        name = "ISP_RGBIR_EXP_THR";
        field { } isp_rgbir_exp_thr1[11:0];
        field { } isp_rgbir_exp_thr2[27:16];
    } ISP_RGBIR_EXP_THR @ 0x4810;
    reg {
        name = "ISP_RGBIR_RECI_CTL";
        field { } isp_rgbir_reci_ctl1[8:0];
        field { } isp_rgbir_reci_ctl2[24:16];
    } ISP_RGBIR_RECI_CTL @ 0x4814;
    reg {
        name = "ISP_RGBIR_GAIN";
        field { } isp_rgbir_gain_r[11:0];
        field { } isp_rgbir_gain_b[27:16];
    } ISP_RGBIR_GAIN @ 0x4818;
    reg {
        name = "ISP_RGBIR_CVT01";
        field { } isp_rgbir_matrix0[10:0];
        field { } isp_rgbir_matrix1[26:16];
    } ISP_RGBIR_CVT01 @ 0x4820;
    reg {
        name = "ISP_RGBIR_CVT23";
        field { } isp_rgbir_matrix2[10:0];
        field { } isp_rgbir_matrix3[26:16];
    } ISP_RGBIR_CVT23 @ 0x4824;
    reg {
        name = "ISP_RGBIR_CVT45";
        field { } isp_rgbir_matrix4[10:0];
        field { } isp_rgbir_matrix5[26:16];
    } ISP_RGBIR_CVT45 @ 0x4828;
    reg {
        name = "ISP_RGBIR_CVT67";
        field { } isp_rgbir_matrix6[10:0];
        field { } isp_rgbir_matrix7[26:16];
    } ISP_RGBIR_CVT67 @ 0x482C;
    reg {
        name = "ISP_RGBIR_CVT89";
        field { } isp_rgbir_matrix8[10:0];
        field { } isp_rgbir_matrix9[26:16];
    } ISP_RGBIR_CVT89 @ 0x4830;
    reg {
        name = "ISP_RGBIR_CVT1011";
        field { } isp_rgbir_matrix10[10:0];
        field { } isp_rgbir_matrix11[26:16];
    } ISP_RGBIR_CVT1011 @ 0x4834;
    reg {
        name = "ISP_RGBIR_BLC_OFFSET_R";
        field { } isp_rgbir_blc_offset_r[11:0];
    } ISP_RGBIR_BLC_OFFSET_R @ 0x4840;
    reg {
        name = "ISP_RGBIR_BLC_OFFSET_G";
        field { } isp_rgbir_blc_offset_g[11:0];
    } ISP_RGBIR_BLC_OFFSET_G @ 0x4844;
    reg {
        name = "ISP_RGBIR_BLC_OFFSET_B";
        field { } isp_rgbir_blc_offset_b[11:0];
    } ISP_RGBIR_BLC_OFFSET_B @ 0x4848;
    reg {
        name = "ISP_RGBIR_BLC_OFFSET_IR";
        field { } isp_rgbir_blc_offset_ir[11:0];
    } ISP_RGBIR_BLC_OFFSET_IR @ 0x484C;
    reg {
        name = "ISP_RGBIR_IR_SUM";
        field { } isp_rgbir_ir_sum[31:0];
    } ISP_RGBIR_IR_SUM @ 0x4850;
    reg {
        name = "ISP_SHARPEN_VERSION";
        field { } isp_sharpen_version[31:0];
    } ISP_SHARPEN_VERSION @ 0x520C;
    reg {
        name = "ISP_SHARPEN_CTRL";
        field { } isp_sharpen_benlumactrl[0:0];
        field { } isp_sharpen_vcds_filterv[1:1];
        field { } isp_sharpen_benshtvar_sel[2:2];
        field { } isp_sharpen_benshtctrlbyvar[3:3];
        field { } isp_sharpen_benskinctrl[4:4];
        field { } isp_sharpen_weakdetailadj[5:5];
        field { } isp_sharpen_benchrctrl[6:6];
        field { } isp_sharpen_detailthd_sel[12:10];
        field { } isp_sharpen_bendetailctrl[13:13];
        field { } isp_sharpen_ben8dir_sel[16:16];
    } ISP_SHARPEN_CTRL @ 0x5210;
    reg {
        name = "ISP_SHARPEN_MHFTHD";
        field { } isp_sharpen_mhfthdsftd[3:0];
        field { } isp_sharpen_mhfthdseld[5:4];
        field { } isp_sharpen_mhfthdsftud[19:16];
        field { } isp_sharpen_mhfthdselud[21:20];
    } ISP_SHARPEN_MHFTHD @ 0x5214;
    reg {
        name = "ISP_SHARPEN_WEAKDETAIL";
        field { } isp_sharpen_dirrlythrlow[6:0];
        field { } isp_sharpen_dirrlythrhih[14:8];
        field { } isp_sharpen_weakdetailgain[22:16];
    } ISP_SHARPEN_WEAKDETAIL @ 0x5218;
    reg {
        name = "ISP_SHARPEN_DIRVAR";
        field { } isp_sharpen_dirvarsft[3:0];
        field { } isp_sharpen_dirvarscale[7:4];
        field { } isp_sharpen_dirrly0[22:16];
        field { } isp_sharpen_dirrly1[30:24];
    } ISP_SHARPEN_DIRVAR @ 0x521C;
    reg {
        name = "ISP_SHARPEN_DIRDIFF";
        field { } isp_sharpen_dirdiffsft[5:0];
        field { } isp_sharpen_dirrt0[20:16];
        field { } isp_sharpen_dirrt1[28:24];
    } ISP_SHARPEN_DIRDIFF @ 0x5220;
    reg {
        name = "ISP_SHARPEN_LUMAWGT0";
        field { } isp_sharpen_lumawgt0[5:0];
        field { } isp_sharpen_lumawgt1[11:6];
        field { } isp_sharpen_lumawgt2[17:12];
        field { } isp_sharpen_lumawgt3[23:18];
        field { } isp_sharpen_lumawgt4[29:24];
    } ISP_SHARPEN_LUMAWGT0 @ 0x5224;
    reg {
        name = "ISP_SHARPEN_LUMAWGT1";
        field { } isp_sharpen_lumawgt5[5:0];
        field { } isp_sharpen_lumawgt6[11:6];
        field { } isp_sharpen_lumawgt7[17:12];
        field { } isp_sharpen_lumawgt8[23:18];
        field { } isp_sharpen_lumawgt9[29:24];
    } ISP_SHARPEN_LUMAWGT1 @ 0x5228;
    reg {
        name = "ISP_SHARPEN_LUMAWGT2";
        field { } isp_sharpen_lumawgt10[5:0];
        field { } isp_sharpen_lumawgt11[11:6];
        field { } isp_sharpen_lumawgt12[17:12];
        field { } isp_sharpen_lumawgt13[23:18];
        field { } isp_sharpen_lumawgt14[29:24];
    } ISP_SHARPEN_LUMAWGT2 @ 0x522C;
    reg {
        name = "ISP_SHARPEN_LUMAWGT3";
        field { } isp_sharpen_lumawgt15[5:0];
        field { } isp_sharpen_lumawgt16[11:6];
        field { } isp_sharpen_lumawgt17[17:12];
        field { } isp_sharpen_lumawgt18[23:18];
        field { } isp_sharpen_lumawgt19[29:24];
    } ISP_SHARPEN_LUMAWGT3 @ 0x5230;
    reg {
        name = "ISP_SHARPEN_LUMAWGT4";
        field { } isp_sharpen_lumawgt20[5:0];
        field { } isp_sharpen_lumawgt21[11:6];
        field { } isp_sharpen_lumawgt22[17:12];
        field { } isp_sharpen_lumawgt23[23:18];
        field { } isp_sharpen_lumawgt24[29:24];
    } ISP_SHARPEN_LUMAWGT4 @ 0x5234;
    reg {
        name = "ISP_SHARPEN_LUMAWGT5";
        field { } isp_sharpen_lumawgt25[5:0];
        field { } isp_sharpen_lumawgt26[11:6];
        field { } isp_sharpen_lumawgt27[17:12];
        field { } isp_sharpen_lumawgt28[23:18];
        field { } isp_sharpen_lumawgt29[29:24];
    } ISP_SHARPEN_LUMAWGT5 @ 0x5238;
    reg {
        name = "ISP_SHARPEN_LUMAWGT6";
        field { } isp_sharpen_lumawgt30[5:0];
        field { } isp_sharpen_lumawgt31[11:6];
    } ISP_SHARPEN_LUMAWGT6 @ 0x523C;
    reg {
        name = "ISP_SHARPEN_SHOOT_AMT";
        field { } isp_sharpen_selpixwgt[4:0];
        field { } isp_sharpen_oshtamt[14:8];
        field { } isp_sharpen_ushtamt[22:16];
    } ISP_SHARPEN_SHOOT_AMT @ 0x5244;
    reg {
        name = "ISP_SHARPEN_SHOOT_MAXCHG";
        field { } isp_sharpen_omaxchg[9:0];
        field { } isp_sharpen_umaxchg[25:16];
    } ISP_SHARPEN_SHOOT_MAXCHG @ 0x5248;
    reg {
        name = "ISP_SHARPEN_SHTVAR";
        field { } isp_sharpen_shtvarsft[2:0];
        field { } isp_sharpen_shtvar5x5_sft[7:4];
        field { } isp_sharpen_shtbldrt[19:16];
    } ISP_SHARPEN_SHTVAR @ 0x524C;
    reg {
        name = "ISP_SHARPEN_OSHTVAR";
        field { } isp_sharpen_shtvarthd0[7:0];
        field { } isp_sharpen_shtvarthd1[15:8];
        field { } isp_sharpen_shtvarwgt0[22:16];
        field { } isp_sharpen_shtvarwgt1[30:24];
    } ISP_SHARPEN_OSHTVAR @ 0x5254;
    reg {
        name = "ISP_SHARPEN_SHTVAR_MUL";
        field { } isp_sharpen_shtvarmul[11:0];
        field { } isp_sharpen_shtvardiffmul[27:16];
    } ISP_SHARPEN_SHTVAR_MUL @ 0x525C;
    reg {
        name = "ISP_SHARPEN_OSHTVARDIFF";
        field { } isp_sharpen_shtvardiffthd0[7:0];
        field { } isp_sharpen_shtvardiffthd1[15:8];
        field { } isp_sharpen_shtvardiffwgt0[22:16];
        field { } isp_sharpen_shtvardiffwgt1[30:24];
    } ISP_SHARPEN_OSHTVARDIFF @ 0x5260;
    reg {
        name = "ISP_SHARPEN_LMTMF0";
        field { } isp_sharpen_lmtmf0[5:0];
        field { } isp_sharpen_lmtmf1[13:8];
        field { } isp_sharpen_lmtmf2[21:16];
        field { } isp_sharpen_lmtmf3[29:24];
    } ISP_SHARPEN_LMTMF0 @ 0x526C;
    reg {
        name = "ISP_SHARPEN_LMTMF1";
        field { } isp_sharpen_lmtmf4[5:0];
        field { } isp_sharpen_lmtmf5[13:8];
        field { } isp_sharpen_lmtmf6[21:16];
        field { } isp_sharpen_lmtmf7[29:24];
    } ISP_SHARPEN_LMTMF1 @ 0x5270;
    reg {
        name = "ISP_SHARPEN_LMTHF0";
        field { } isp_sharpen_lmthf0[5:0];
        field { } isp_sharpen_lmthf1[13:8];
        field { } isp_sharpen_lmthf2[21:16];
        field { } isp_sharpen_lmthf3[29:24];
    } ISP_SHARPEN_LMTHF0 @ 0x5274;
    reg {
        name = "ISP_SHARPEN_LMTHF1";
        field { } isp_sharpen_lmthf4[5:0];
        field { } isp_sharpen_lmthf5[13:8];
        field { } isp_sharpen_lmthf6[21:16];
        field { } isp_sharpen_lmthf7[29:24];
    } ISP_SHARPEN_LMTHF1 @ 0x5278;
    reg {
        name = "ISP_SHARPEN_MHFGAIND_WADDR";
        field { } isp_sharpen_mhfgaind_waddr[31:0];
    } ISP_SHARPEN_MHFGAIND_WADDR @ 0x5280;
    reg {
        name = "ISP_SHARPEN_MHFGAIND_WDATA";
        field { } isp_sharpen_mhfgaind_wdata[31:0];
    } ISP_SHARPEN_MHFGAIND_WDATA @ 0x5284;
    reg {
        name = "ISP_SHARPEN_MHFGAIND_RADDR";
        field { } isp_sharpen_mhfgaind_raddr[31:0];
    } ISP_SHARPEN_MHFGAIND_RADDR @ 0x5288;
    reg {
        name = "ISP_SHARPEN_MHFGAIND_RDATA";
        field { } isp_sharpen_mhfgaind_rdata[31:0];
    } ISP_SHARPEN_MHFGAIND_RDATA @ 0x528C;
    reg {
        name = "ISP_SHARPEN_MHFGAINUD_WADDR";
        field { } isp_sharpen_mhfgainud_waddr[31:0];
    } ISP_SHARPEN_MHFGAINUD_WADDR @ 0x5290;
    reg {
        name = "ISP_SHARPEN_MHFGAINUD_WDATA";
        field { } isp_sharpen_mhfgainud_wdata[31:0];
    } ISP_SHARPEN_MHFGAINUD_WDATA @ 0x5294;
    reg {
        name = "ISP_SHARPEN_MHFGAINUD_RADDR";
        field { } isp_sharpen_mhfgainud_raddr[31:0];
    } ISP_SHARPEN_MHFGAINUD_RADDR @ 0x5298;
    reg {
        name = "ISP_SHARPEN_MHFGAINUD_RDATA";
        field { } isp_sharpen_mhfgainud_rdata[31:0];
    } ISP_SHARPEN_MHFGAINUD_RDATA @ 0x529C;
    reg {
        name = "ISP_SHARPEN_SKIN_U";
        field { } isp_sharpen_skinminu[7:0];
        field { } isp_sharpen_skinmaxu[23:16];
    } ISP_SHARPEN_SKIN_U @ 0x5304;
    reg {
        name = "ISP_SHARPEN_SKIN_V";
        field { } isp_sharpen_skinminv[7:0];
        field { } isp_sharpen_skinmaxv[23:16];
    } ISP_SHARPEN_SKIN_V @ 0x5308;
    reg {
        name = "ISP_SHARPEN_SKIN_CNT";
        field { } isp_sharpen_skincntthd0[3:0];
        field { } isp_sharpen_skincntthd1[7:4];
        field { } isp_sharpen_skincntmul[12:8];
    } ISP_SHARPEN_SKIN_CNT @ 0x530C;
    reg {
        name = "ISP_SHARPEN_SKIN_EDGE";
        field { } isp_sharpen_skinedgesft[3:0];
        field { } isp_sharpen_skinedgemul[25:16];
    } ISP_SHARPEN_SKIN_EDGE @ 0x5310;
    reg {
        name = "ISP_SHARPEN_SKIN_EDGETHD";
        field { } isp_sharpen_skinedgethd0[7:0];
        field { } isp_sharpen_skinedgethd1[15:8];
        field { } isp_sharpen_skinedgewgt0[20:16];
        field { } isp_sharpen_skinedgewgt1[28:24];
    } ISP_SHARPEN_SKIN_EDGETHD @ 0x5314;
    reg {
        name = "ISP_SHARPEN_CHRR_VAR";
        field { } isp_sharpen_chrrsft0[2:0];
        field { } isp_sharpen_chrrsft1[5:3];
        field { } isp_sharpen_chrrsft2[8:6];
        field { } isp_sharpen_chrrsft3[11:9];
        field { } isp_sharpen_chrrvarshift[15:12];
    } ISP_SHARPEN_CHRR_VAR @ 0x5320;
    reg {
        name = "ISP_SHARPEN_CHRR_THD";
        field { } isp_sharpen_chrrori0[7:0];
        field { } isp_sharpen_chrrori1[15:8];
        field { } isp_sharpen_chrrthd0[23:16];
        field { } isp_sharpen_chrrthd1[31:24];
    } ISP_SHARPEN_CHRR_THD @ 0x5328;
    reg {
        name = "ISP_SHARPEN_CHRR_GAIN";
        field { } isp_sharpen_chrrgain[5:0];
        field { } isp_sharpen_rmfscale[13:8];
        field { } isp_sharpen_chrrmul[25:16];
    } ISP_SHARPEN_CHRR_GAIN @ 0x532C;
    reg {
        name = "ISP_SHARPEN_CHRG_MUL";
        field { } isp_sharpen_chrgmul[13:0];
        field { } isp_sharpen_chrgmfmul[29:16];
    } ISP_SHARPEN_CHRG_MUL @ 0x5330;
    reg {
        name = "ISP_SHARPEN_CHRG_SFT";
        field { } isp_sharpen_chrgsft0[2:0];
        field { } isp_sharpen_chrgsft1[5:3];
        field { } isp_sharpen_chrgsft2[8:6];
        field { } isp_sharpen_chrgsft3[11:9];
    } ISP_SHARPEN_CHRG_SFT @ 0x5334;
    reg {
        name = "ISP_SHARPEN_CHRG_THD";
        field { } isp_sharpen_chrgori0[7:0];
        field { } isp_sharpen_chrgori1[15:8];
        field { } isp_sharpen_chrgthd0[23:16];
        field { } isp_sharpen_chrgthd1[31:24];
    } ISP_SHARPEN_CHRG_THD @ 0x533C;
    reg {
        name = "ISP_SHARPEN_CHRG_GAIN";
        field { } isp_sharpen_chrggain[8:0];
        field { } isp_sharpen_chrgmfgain[24:16];
    } ISP_SHARPEN_CHRG_GAIN @ 0x5340;
    reg {
        name = "ISP_SHARPEN_CHRB_VAR";
        field { } isp_sharpen_chrbsft0[2:0];
        field { } isp_sharpen_chrbsft1[5:3];
        field { } isp_sharpen_chrbsft2[8:6];
        field { } isp_sharpen_chrbsft3[11:9];
        field { } isp_sharpen_chrbvarshift[15:12];
    } ISP_SHARPEN_CHRB_VAR @ 0x5344;
    reg {
        name = "ISP_SHARPEN_CHRB_THD";
        field { } isp_sharpen_chrbori0[7:0];
        field { } isp_sharpen_chrbori1[15:8];
        field { } isp_sharpen_chrbthd0[23:16];
        field { } isp_sharpen_chrbthd1[31:24];
    } ISP_SHARPEN_CHRB_THD @ 0x534C;
    reg {
        name = "ISP_SHARPEN_CHRB_GAIN";
        field { } isp_sharpen_chrbgain[5:0];
        field { } isp_sharpen_bmfscale[13:8];
        field { } isp_sharpen_chrbmul[25:16];
    } ISP_SHARPEN_CHRB_GAIN @ 0x5350;
    reg {
        name = "ISP_SHARPEN_GAIN_SFT";
        field { } isp_sharpen_mfgain_sft[2:0];
        field { } isp_sharpen_lfgainwgt[12:8];
        field { } isp_sharpen_hfgain_sft[18:16];
    } ISP_SHARPEN_GAIN_SFT @ 0x5354;
    reg {
        name = "ISP_SHARPEN_SHOOT_MAXGAIN";
        field { } isp_sharpen_omaxgain[10:0];
        field { } isp_sharpen_umaxgain[26:16];
    } ISP_SHARPEN_SHOOT_MAXGAIN @ 0x5358;
    reg {
        name = "ISP_SHARPEN_DETAIL_MUL";
        field { } isp_sharpen_detl_oshtmul[11:0];
        field { } isp_sharpen_detl_ushtmul[27:16];
    } ISP_SHARPEN_DETAIL_MUL @ 0x535C;
    reg {
        name = "ISP_SHARPEN_OSHT_DETAIL";
        field { } isp_sharpen_osht_dtl_thd0[7:0];
        field { } isp_sharpen_osht_dtl_thd1[15:8];
        field { } isp_sharpen_osht_dtl_wgt[22:16];
        field { } isp_sharpen_max_var_clip[31:24];
    } ISP_SHARPEN_OSHT_DETAIL @ 0x5360;
    reg {
        name = "ISP_SHARPEN_USHT_DETAIL";
        field { } isp_sharpen_usht_dtl_thd0[7:0];
        field { } isp_sharpen_usht_dtl_thd1[15:8];
        field { } isp_sharpen_usht_dtl_wgt[22:16];
        field { } isp_sharpen_dtl_thdsft[27:24];
    } ISP_SHARPEN_USHT_DETAIL @ 0x5364;
    reg {
        name = "ISP_SHARPEN_STT2LUT_CFG";
        field { } isp_sharpen_stt2lut_en[0:0];
    } ISP_SHARPEN_STT2LUT_CFG @ 0x5370;
    reg {
        name = "ISP_SHARPEN_STT2LUT_REGNEW";
        field { } isp_sharpen_stt2lut_regnew[0:0];
    } ISP_SHARPEN_STT2LUT_REGNEW @ 0x5374;
    reg {
        name = "ISP_SHARPEN_STT2LUT_ABN";
        field { } isp_sharpen_stt2lut_info[15:0];
        field { } isp_sharpen_stt2lut_clr[31:31];
    } ISP_SHARPEN_STT2LUT_ABN @ 0x5378;
    reg {
        name = "ISP_SHARPEN_DLPF_COEF";
        field { } isp_sharpen_dlpfcoef0[7:0];
        field { } isp_sharpen_dlpfcoef1[15:8];
        field { } isp_sharpen_dlpfcoef2[23:16];
        field { } isp_sharpen_dlpfsft[27:24];
    } ISP_SHARPEN_DLPF_COEF @ 0x53E4;
    reg {
        name = "ISP_SHARPEN_UDLPF_COEF";
        field { } isp_sharpen_udlpfcoef0[7:0];
        field { } isp_sharpen_udlpfcoef1[15:8];
        field { } isp_sharpen_udlpfcoef2[23:16];
        field { } isp_sharpen_udlpfsft[27:24];
    } ISP_SHARPEN_UDLPF_COEF @ 0x53E8;
    reg {
        name = "ISP_SHARPEN_UDHSF_COEF";
        field { } isp_sharpen_udhsfcoef0[7:0];
        field { } isp_sharpen_udhsfcoef1[15:8];
        field { } isp_sharpen_udhsfcoef2[23:16];
        field { } isp_sharpen_udhsfsft[27:24];
    } ISP_SHARPEN_UDHSF_COEF @ 0x53EC;
    reg {
        name = "ISP_SHARPEN_DHSF_2DSHIFT";
        field { } isp_sharpen_dhsfsft[27:24];
    } ISP_SHARPEN_DHSF_2DSHIFT @ 0x53F0;
    reg {
        name = "ISP_SHARPEN_DHSF_2DCOEF0_03";
        field { } isp_sharpen_dhsfcoef0_0[7:0];
        field { } isp_sharpen_dhsfcoef0_1[15:8];
        field { } isp_sharpen_dhsfcoef0_2[23:16];
        field { } isp_sharpen_dhsfcoef0_3[31:24];
    } ISP_SHARPEN_DHSF_2DCOEF0_03 @ 0x5400;
    reg {
        name = "ISP_SHARPEN_DHSF_2DCOEF0_47";
        field { } isp_sharpen_dhsfcoef0_4[7:0];
        field { } isp_sharpen_dhsfcoef0_5[15:8];
        field { } isp_sharpen_dhsfcoef0_6[23:16];
        field { } isp_sharpen_dhsfcoef0_7[31:24];
    } ISP_SHARPEN_DHSF_2DCOEF0_47 @ 0x5404;
    reg {
        name = "ISP_SHARPEN_DHSF_2DCOEF0_811";
        field { } isp_sharpen_dhsfcoef0_8[7:0];
        field { } isp_sharpen_dhsfcoef0_9[15:8];
        field { } isp_sharpen_dhsfcoef0_10[23:16];
        field { } isp_sharpen_dhsfcoef0_11[31:24];
    } ISP_SHARPEN_DHSF_2DCOEF0_811 @ 0x5408;
    reg {
        name = "ISP_SHARPEN_DHSF_2DCOEF0_1215";
        field { } isp_sharpen_dhsfcoef0_12[7:0];
    } ISP_SHARPEN_DHSF_2DCOEF0_1215 @ 0x540C;
    reg {
        name = "ISP_SHARPEN_DHSF_2DCOEF1_03";
        field { } isp_sharpen_dhsfcoef1_0[7:0];
        field { } isp_sharpen_dhsfcoef1_1[15:8];
        field { } isp_sharpen_dhsfcoef1_2[23:16];
        field { } isp_sharpen_dhsfcoef1_3[31:24];
    } ISP_SHARPEN_DHSF_2DCOEF1_03 @ 0x5418;
    reg {
        name = "ISP_SHARPEN_DHSF_2DCOEF1_47";
        field { } isp_sharpen_dhsfcoef1_4[7:0];
        field { } isp_sharpen_dhsfcoef1_5[15:8];
        field { } isp_sharpen_dhsfcoef1_6[23:16];
        field { } isp_sharpen_dhsfcoef1_7[31:24];
    } ISP_SHARPEN_DHSF_2DCOEF1_47 @ 0x541C;
    reg {
        name = "ISP_SHARPEN_DHSF_2DCOEF1_811";
        field { } isp_sharpen_dhsfcoef1_8[7:0];
        field { } isp_sharpen_dhsfcoef1_9[15:8];
        field { } isp_sharpen_dhsfcoef1_10[23:16];
        field { } isp_sharpen_dhsfcoef1_11[31:24];
    } ISP_SHARPEN_DHSF_2DCOEF1_811 @ 0x5420;
    reg {
        name = "ISP_SHARPEN_DHSF_2DCOEF1_1215";
        field { } isp_sharpen_dhsfcoef1_12[7:0];
    } ISP_SHARPEN_DHSF_2DCOEF1_1215 @ 0x5424;
    reg {
        name = "ISP_SHARPEN_DHSF_2DCOEF2_03";
        field { } isp_sharpen_dhsfcoef2_0[7:0];
        field { } isp_sharpen_dhsfcoef2_1[15:8];
        field { } isp_sharpen_dhsfcoef2_2[23:16];
        field { } isp_sharpen_dhsfcoef2_3[31:24];
    } ISP_SHARPEN_DHSF_2DCOEF2_03 @ 0x5430;
    reg {
        name = "ISP_SHARPEN_DHSF_2DCOEF2_47";
        field { } isp_sharpen_dhsfcoef2_4[7:0];
        field { } isp_sharpen_dhsfcoef2_5[15:8];
        field { } isp_sharpen_dhsfcoef2_6[23:16];
        field { } isp_sharpen_dhsfcoef2_7[31:24];
    } ISP_SHARPEN_DHSF_2DCOEF2_47 @ 0x5434;
    reg {
        name = "ISP_SHARPEN_DHSF_2DCOEF2_811";
        field { } isp_sharpen_dhsfcoef2_8[7:0];
        field { } isp_sharpen_dhsfcoef2_9[15:8];
        field { } isp_sharpen_dhsfcoef2_10[23:16];
        field { } isp_sharpen_dhsfcoef2_11[31:24];
    } ISP_SHARPEN_DHSF_2DCOEF2_811 @ 0x5438;
    reg {
        name = "ISP_SHARPEN_DHSF_2DCOEF2_1215";
        field { } isp_sharpen_dhsfcoef2_12[7:0];
    } ISP_SHARPEN_DHSF_2DCOEF2_1215 @ 0x543C;
    reg {
        name = "ISP_SHARPEN_DHSF_2DCOEF3_03";
        field { } isp_sharpen_dhsfcoef3_0[7:0];
        field { } isp_sharpen_dhsfcoef3_1[15:8];
        field { } isp_sharpen_dhsfcoef3_2[23:16];
        field { } isp_sharpen_dhsfcoef3_3[31:24];
    } ISP_SHARPEN_DHSF_2DCOEF3_03 @ 0x5448;
    reg {
        name = "ISP_SHARPEN_DHSF_2DCOEF3_47";
        field { } isp_sharpen_dhsfcoef3_4[7:0];
        field { } isp_sharpen_dhsfcoef3_5[15:8];
        field { } isp_sharpen_dhsfcoef3_6[23:16];
        field { } isp_sharpen_dhsfcoef3_7[31:24];
    } ISP_SHARPEN_DHSF_2DCOEF3_47 @ 0x544C;
    reg {
        name = "ISP_SHARPEN_DHSF_2DCOEF3_811";
        field { } isp_sharpen_dhsfcoef3_8[7:0];
        field { } isp_sharpen_dhsfcoef3_9[15:8];
        field { } isp_sharpen_dhsfcoef3_10[23:16];
        field { } isp_sharpen_dhsfcoef3_11[31:24];
    } ISP_SHARPEN_DHSF_2DCOEF3_811 @ 0x5450;
    reg {
        name = "ISP_SHARPEN_DHSF_2DCOEF3_1215";
        field { } isp_sharpen_dhsfcoef3_12[7:0];
    } ISP_SHARPEN_DHSF_2DCOEF3_1215 @ 0x5454;
    reg {
        name = "ISP_SHARPEN_LDCI_DITHER_CFG";
        field { } isp_sharpen_ldci_dither_round[1:0];
    } ISP_SHARPEN_LDCI_DITHER_CFG @ 0x5500;
    reg {
        name = "ISP_NDDM_CFG";
        field { } isp_nddm_cac_blend_en[0:0];
    } ISP_NDDM_CFG @ 0x5600;
    reg {
        name = "ISP_NDDM_GF_TH";
        field { } isp_nddm_gf_th_low[8:0];
        field { } isp_nddm_gf_thgh[24:16];
    } ISP_NDDM_GF_TH @ 0x5604;
    reg {
        name = "ISP_NDDM_AWB_GF_CFG";
        field { } isp_nddm_awb_gf_gn_low[6:0];
        field { } isp_nddm_awb_gf_gngh[14:8];
        field { } isp_nddm_awb_gf_gn_max[19:16];
    } ISP_NDDM_AWB_GF_CFG @ 0x5608;
    reg {
        name = "ISP_NDDM_FCR_GAIN";
        field { } isp_nddm_fcr_gf_gain[4:0];
        field { } isp_nddm_fcr_det_low[27:16];
    } ISP_NDDM_FCR_GAIN @ 0x560C;
    reg {
        name = "ISP_NDDM_DM_BLDRATE";
        field { } isp_nddm_cac_blend_rate[8:0];
    } ISP_NDDM_DM_BLDRATE @ 0x5610;
    reg {
        name = "ISP_NDDM_EHC_GRAY";
        field { } isp_nddm_ehc_gray[6:0];
    } ISP_NDDM_EHC_GRAY @ 0x5614;
    reg {
        name = "ISP_NDDM_DITHER_CFG";
        field { } isp_nddm_dith_mask[7:0];
        field { } isp_nddm_dith_ratio[15:8];
        field { } isp_nddm_dith_max[23:16];
    } ISP_NDDM_DITHER_CFG @ 0x5618;
    reg {
        name = "ISP_NDDM_GF_LUT_UPDATE";
        field { } isp_nddm_gf_lut_update[0:0];
    } ISP_NDDM_GF_LUT_UPDATE @ 0x561C;
    reg {
        name = "ISP_NDDM_GF_LUT_WADDR";
        field { } isp_nddm_gf_lut_waddr[4:0];
    } ISP_NDDM_GF_LUT_WADDR @ 0x5680;
    reg {
        name = "ISP_NDDM_GF_LUT_WDATA";
        field { } isp_nddm_gf_lut_wdata[11:0];
    } ISP_NDDM_GF_LUT_WDATA @ 0x5684;
    reg {
        name = "ISP_NDDM_GF_LUT_RADDR";
        field { } isp_nddm_gf_lut_raddr[4:0];
    } ISP_NDDM_GF_LUT_RADDR @ 0x5688;
    reg {
        name = "ISP_NDDM_GF_LUT_RDATA";
        field { } isp_nddm_gf_lut_rdata[11:0];
    } ISP_NDDM_GF_LUT_RDATA @ 0x568C;
    reg {
        name = "ISP_BNR_CFG";
        field { } isp_bnr_mono_sensor[1:1];
    } ISP_BNR_CFG @ 0x5800;
    reg {
        name = "ISP_BNR_VERSION";
        field { } isp_bnr_version[31:0];
    } ISP_BNR_VERSION @ 0x580C;
    reg {
        name = "ISP_BNR_JNLM0";
        field { } isp_bnr_jnlm_coringhig[15:0];
        field { } isp_bnr_jnlm_gain[23:16];
        field { } isp_bnr_jnlm_sel[25:24];
    } ISP_BNR_JNLM0 @ 0x5824;
    reg {
        name = "ISP_BNR_LSC_CTRL";
        field { } isp_bnr_lscbnrenable[1:0];
        field { } isp_bnr_lscmaxgain[9:2];
        field { } isp_bnr_lsccmpstrength[18:10];
    } ISP_BNR_LSC_CTRL @ 0x5828;
    reg {
        name = "ISP_BNR_JNLM2";
        field { } isp_bnr_jnlm_maxwtcoef[9:0];
    } ISP_BNR_JNLM2 @ 0x582C;
    reg {
        name = "ISP_BNR_CHROMA";
        field { } isp_bnr_rlmt_blc[9:0];
        field { } isp_bnr_rlmt_rgain[19:10];
        field { } isp_bnr_rlmt_bgain[29:20];
    } ISP_BNR_CHROMA @ 0x5830;
    reg {
        name = "ISP_BNR_LPFCTRL";
        field { } isp_bnr_windowsizesel[2:0];
        field { } isp_bnr_encenterweight[3:3];
        field { } isp_bnr_pattern_noise_reduction[4:4];
        field { } isp_bnr_gainsad[12:5];
        field { } isp_bnr_implsnrenable1[13:13];
        field { } isp_bnr_implsnrenable2[14:14];
        field { } isp_bnr_implsnrenable3[15:15];
        field { } isp_bnr_implsnrstrength[23:16];
        field { } isp_bnr_enablesymmsad[24:24];
        field { } isp_bnr_enablepostproc[26:25];
        field { } isp_bnr_bilateral_enable[28:27];
        field { } isp_bnr_lumasel[29:29];
    } ISP_BNR_LPFCTRL @ 0x5844;
    reg {
        name = "ISP_BNR_WDRCTRL";
        field { } isp_bnr_wdr_enable[0:0];
        field { } isp_bnr_wdr_enfusion[1:1];
        field { } isp_bnr_wdr_mapfltmod[2:2];
        field { } isp_bnr_wdr_mapgain[7:3];
    } ISP_BNR_WDRCTRL @ 0x5848;
    reg {
        name = "ISP_BNR_JNLMGAIN0";
        field { } isp_bnr_jnlmgain_r0[16:0];
    } ISP_BNR_JNLMGAIN0 @ 0x584C;
    reg {
        name = "ISP_BNR_JNLMGAIN1";
        field { } isp_bnr_jnlmgain_gr0[16:0];
    } ISP_BNR_JNLMGAIN1 @ 0x5850;
    reg {
        name = "ISP_BNR_JNLMGAIN2";
        field { } isp_bnr_jnlmgain_gb0[16:0];
    } ISP_BNR_JNLMGAIN2 @ 0x5854;
    reg {
        name = "ISP_BNR_JNLMGAIN3";
        field { } isp_bnr_jnlmgain_b0[16:0];
    } ISP_BNR_JNLMGAIN3 @ 0x5858;
    reg {
        name = "ISP_BNR_JNLMGAIN_S0";
        field { } isp_bnr_jnlmgain_r_s[16:0];
    } ISP_BNR_JNLMGAIN_S0 @ 0x585C;
    reg {
        name = "ISP_BNR_JNLMGAIN_S1";
        field { } isp_bnr_jnlmgain_gr_s[16:0];
    } ISP_BNR_JNLMGAIN_S1 @ 0x5860;
    reg {
        name = "ISP_BNR_JNLMGAIN_S2";
        field { } isp_bnr_jnlmgain_gb_s[16:0];
    } ISP_BNR_JNLMGAIN_S2 @ 0x5864;
    reg {
        name = "ISP_BNR_JNLMGAIN_S3";
        field { } isp_bnr_jnlmgain_b_s[16:0];
    } ISP_BNR_JNLMGAIN_S3 @ 0x5868;
    reg {
        name = "ISP_BNR_SHOTRATIO";
        field { } isp_bnr_shotratio[9:0];
    } ISP_BNR_SHOTRATIO @ 0x586C;
    reg {
        name = "ISP_BNR_STT2LUT_CFG";
        field { } isp_bnr_stt2lut_en[0:0];
    } ISP_BNR_STT2LUT_CFG @ 0x5874;
    reg {
        name = "ISP_BNR_STT2LUT_REGNEW";
        field { } isp_bnr_stt2lut_regnew[0:0];
    } ISP_BNR_STT2LUT_REGNEW @ 0x5878;
    reg {
        name = "ISP_BNR_STT2LUT_ABN";
        field { } isp_bnr_stt2lut_info[15:0];
        field { } isp_bnr_stt2lut_clr[31:31];
    } ISP_BNR_STT2LUT_ABN @ 0x587C;
    reg {
        name = "ISP_BNR_LMT_EVEN_WADDR";
        field { } isp_bnr_lmt_even_waddr[31:0];
    } ISP_BNR_LMT_EVEN_WADDR @ 0x5880;
    reg {
        name = "ISP_BNR_LMT_EVEN_WDATA";
        field { } isp_bnr_lmt_even_wdata[7:0];
        field { } isp_bnr_lmt_s_even_wdata[15:8];
    } ISP_BNR_LMT_EVEN_WDATA @ 0x5884;
    reg {
        name = "ISP_BNR_LMT_EVEN_RADDR";
        field { } isp_bnr_lmt_even_raddr[31:0];
    } ISP_BNR_LMT_EVEN_RADDR @ 0x5888;
    reg {
        name = "ISP_BNR_LMT_EVEN_RDATA";
        field { } isp_bnr_lmt_even_rdata[7:0];
        field { } isp_bnr_lmt_s_even_rdata[15:8];
    } ISP_BNR_LMT_EVEN_RDATA @ 0x588C;
    reg {
        name = "ISP_BNR_LMT_ODD_WADDR";
        field { } isp_bnr_lmt_odd_waddr[31:0];
    } ISP_BNR_LMT_ODD_WADDR @ 0x5890;
    reg {
        name = "ISP_BNR_LMT_ODD_WDATA";
        field { } isp_bnr_lmt_odd_wdata[7:0];
        field { } isp_bnr_lmt_s_odd_wdata[15:8];
    } ISP_BNR_LMT_ODD_WDATA @ 0x5894;
    reg {
        name = "ISP_BNR_LMT_ODD_RADDR";
        field { } isp_bnr_lmt_odd_raddr[31:0];
    } ISP_BNR_LMT_ODD_RADDR @ 0x5898;
    reg {
        name = "ISP_BNR_LMT_ODD_RDATA";
        field { } isp_bnr_lmt_odd_rdata[7:0];
        field { } isp_bnr_lmt_s_odd_rdata[15:8];
    } ISP_BNR_LMT_ODD_RDATA @ 0x589C;
    reg {
        name = "ISP_BNR_COR_EVEN_WADDR";
        field { } isp_bnr_cor_even_waddr[31:0];
    } ISP_BNR_COR_EVEN_WADDR @ 0x58A0;
    reg {
        name = "ISP_BNR_COR_EVEN_WDATA";
        field { } isp_bnr_cor_even_wdata[31:0];
    } ISP_BNR_COR_EVEN_WDATA @ 0x58A4;
    reg {
        name = "ISP_BNR_COR_EVEN_RADDR";
        field { } isp_bnr_cor_even_raddr[31:0];
    } ISP_BNR_COR_EVEN_RADDR @ 0x58A8;
    reg {
        name = "ISP_BNR_COR_EVEN_RDATA";
        field { } isp_bnr_cor_even_rdata[31:0];
    } ISP_BNR_COR_EVEN_RDATA @ 0x58AC;
    reg {
        name = "ISP_BNR_COR_ODD_WADDR";
        field { } isp_bnr_cor_odd_waddr[31:0];
    } ISP_BNR_COR_ODD_WADDR @ 0x58B0;
    reg {
        name = "ISP_BNR_COR_ODD_WDATA";
        field { } isp_bnr_cor_odd_wdata[31:0];
    } ISP_BNR_COR_ODD_WDATA @ 0x58B4;
    reg {
        name = "ISP_BNR_COR_ODD_RADDR";
        field { } isp_bnr_cor_odd_raddr[31:0];
    } ISP_BNR_COR_ODD_RADDR @ 0x58B8;
    reg {
        name = "ISP_BNR_COR_ODD_RDATA";
        field { } isp_bnr_cor_odd_rdata[31:0];
    } ISP_BNR_COR_ODD_RDATA @ 0x58BC;
    reg {
        name = "ISP_BNR_GCOR_EVEN_WADDR";
        field { } isp_bnr_gcor_even_waddr[31:0];
    } ISP_BNR_GCOR_EVEN_WADDR @ 0x58C0;
    reg {
        name = "ISP_BNR_GCOR_EVEN_WDATA";
        field { } isp_bnr_gcor_even_wdata[31:0];
    } ISP_BNR_GCOR_EVEN_WDATA @ 0x58C4;
    reg {
        name = "ISP_BNR_GCOR_EVEN_RADDR";
        field { } isp_bnr_gcor_even_raddr[31:0];
    } ISP_BNR_GCOR_EVEN_RADDR @ 0x58C8;
    reg {
        name = "ISP_BNR_GCOR_EVEN_RDATA";
        field { } isp_bnr_gcor_even_rdata[31:0];
    } ISP_BNR_GCOR_EVEN_RDATA @ 0x58CC;
    reg {
        name = "ISP_BNR_GCOR_ODD_WADDR";
        field { } isp_bnr_gcor_odd_waddr[31:0];
    } ISP_BNR_GCOR_ODD_WADDR @ 0x58D0;
    reg {
        name = "ISP_BNR_GCOR_ODD_WDATA";
        field { } isp_bnr_gcor_odd_wdata[31:0];
    } ISP_BNR_GCOR_ODD_WDATA @ 0x58D4;
    reg {
        name = "ISP_BNR_GCOR_ODD_RADDR";
        field { } isp_bnr_gcor_odd_raddr[31:0];
    } ISP_BNR_GCOR_ODD_RADDR @ 0x58D8;
    reg {
        name = "ISP_BNR_GCOR_ODD_RDATA";
        field { } isp_bnr_gcor_odd_rdata[31:0];
    } ISP_BNR_GCOR_ODD_RDATA @ 0x58DC;
    reg {
        name = "ISP_MLSC_STT2LUT_CFG";
        field { } isp_mlsc_stt2lut_en[0:0];
    } ISP_MLSC_STT2LUT_CFG @ 0x5A00;
    reg {
        name = "ISP_MLSC_STT2LUT_REGNEW";
        field { } isp_mlsc_stt2lut_regnew[0:0];
    } ISP_MLSC_STT2LUT_REGNEW @ 0x5A04;
    reg {
        name = "ISP_MLSC_STT2LUT_ABN";
        field { } isp_mlsc_stt2lut_info[15:0];
        field { } isp_mlsc_stt2lut_clr[31:31];
    } ISP_MLSC_STT2LUT_ABN @ 0x5A08;
    reg {
        name = "ISP_MLSC_WINNUM";
        field { } isp_mlsc_numh[5:0];
        field { } isp_mlsc_numv[21:16];
    } ISP_MLSC_WINNUM @ 0x5A10;
    reg {
        name = "ISP_MLSC_WINX";
        field { } isp_mlsc_deltax[7:0];
        field { } isp_mlsc_invx[26:16];
    } ISP_MLSC_WINX[16] @ 0x5A14 += 0x4;
    reg {
        name = "ISP_MLSC_WINY";
        field { } isp_mlsc_deltay[7:0];
        field { } isp_mlsc_invy[26:16];
    } ISP_MLSC_WINY[8] @ 0x5A54 += 0x4;
    reg {
        name = "ISP_MLSC_WIDTH_OFFSET";
        field { } isp_mlsc_width_offset[11:0];
    } ISP_MLSC_WIDTH_OFFSET @ 0x5A74;
    reg {
        name = "ISP_MLSC_MESH";
        field { } isp_mlsc_mesh_str[9:0];
        field { } isp_mlsc_mesh_scale[18:16];
    } ISP_MLSC_MESH @ 0x5A78;
    reg {
        name = "ISP_MLSC_RGAIN_WADDR";
        field { } isp_mlsc_rgain_waddr[31:0];
    } ISP_MLSC_RGAIN_WADDR @ 0x5A80;
    reg {
        name = "ISP_MLSC_RGAIN_WDATA";
        field { } isp_mlsc_rgain_wdata[9:0];
    } ISP_MLSC_RGAIN_WDATA @ 0x5A84;
    reg {
        name = "ISP_MLSC_RGAIN_RADDR";
        field { } isp_mlsc_rgain_raddr[31:0];
    } ISP_MLSC_RGAIN_RADDR @ 0x5A88;
    reg {
        name = "ISP_MLSC_RGAIN_RDATA";
        field { } isp_mlsc_rgain_rdata[9:0];
    } ISP_MLSC_RGAIN_RDATA @ 0x5A8C;
    reg {
        name = "ISP_MLSC_GRGAIN_WADDR";
        field { } isp_mlsc_grgain_waddr[31:0];
    } ISP_MLSC_GRGAIN_WADDR @ 0x5A90;
    reg {
        name = "ISP_MLSC_GRGAIN_WDATA";
        field { } isp_mlsc_grgain_wdata[9:0];
    } ISP_MLSC_GRGAIN_WDATA @ 0x5A94;
    reg {
        name = "ISP_MLSC_GRGAIN_RADDR";
        field { } isp_mlsc_grgain_raddr[31:0];
    } ISP_MLSC_GRGAIN_RADDR @ 0x5A98;
    reg {
        name = "ISP_MLSC_GRGAIN_RDATA";
        field { } isp_mlsc_grgain_rdata[9:0];
    } ISP_MLSC_GRGAIN_RDATA @ 0x5A9C;
    reg {
        name = "ISP_MLSC_BGAIN_WADDR";
        field { } isp_mlsc_bgain_waddr[31:0];
    } ISP_MLSC_BGAIN_WADDR @ 0x5AA0;
    reg {
        name = "ISP_MLSC_BGAIN_WDATA";
        field { } isp_mlsc_bgain_wdata[9:0];
    } ISP_MLSC_BGAIN_WDATA @ 0x5AA4;
    reg {
        name = "ISP_MLSC_BGAIN_RADDR";
        field { } isp_mlsc_bgain_raddr[31:0];
    } ISP_MLSC_BGAIN_RADDR @ 0x5AA8;
    reg {
        name = "ISP_MLSC_BGAIN_RDATA";
        field { } isp_mlsc_bgain_rdata[9:0];
    } ISP_MLSC_BGAIN_RDATA @ 0x5AAC;
    reg {
        name = "ISP_MLSC_GBGAIN_WADDR";
        field { } isp_mlsc_gbgain_waddr[31:0];
    } ISP_MLSC_GBGAIN_WADDR @ 0x5AB0;
    reg {
        name = "ISP_MLSC_GBGAIN_WDATA";
        field { } isp_mlsc_gbgain_wdata[9:0];
    } ISP_MLSC_GBGAIN_WDATA @ 0x5AB4;
    reg {
        name = "ISP_MLSC_GBGAIN_RADDR";
        field { } isp_mlsc_gbgain_raddr[31:0];
    } ISP_MLSC_GBGAIN_RADDR @ 0x5AB8;
    reg {
        name = "ISP_MLSC_GBGAIN_RDATA";
        field { } isp_mlsc_gbgain_rdata[9:0];
    } ISP_MLSC_GBGAIN_RDATA @ 0x5ABC;
    reg {
        name = "ISP_WDR_CTRL";
        field { } isp_wdr_fusion_data_mode[2:1];
        field { } isp_wdr_fusionmode[4:4];
        field { } isp_wdr_erosion_en[16:16];
        field { } isp_wdr_mdt_en[20:20];
        field { } isp_wdr_grayscale_mode[24:24];
    } ISP_WDR_CTRL @ 0x6010;
    reg {
        name = "ISP_WDR_F0_INBLC0";
        field { } isp_wdr_f0_inblc_gr[12:0];
        field { } isp_wdr_f0_inblc_r[28:16];
    } ISP_WDR_F0_INBLC0 @ 0x6018;
    reg {
        name = "ISP_WDR_F0_INBLC1";
        field { } isp_wdr_f0_inblc_b[12:0];
        field { } isp_wdr_f0_inblc_gb[28:16];
    } ISP_WDR_F0_INBLC1 @ 0x601C;
    reg {
        name = "ISP_WDR_F1_INBLC0";
        field { } isp_wdr_f1_inblc_gr[12:0];
        field { } isp_wdr_f1_inblc_r[28:16];
    } ISP_WDR_F1_INBLC0 @ 0x6020;
    reg {
        name = "ISP_WDR_F1_INBLC1";
        field { } isp_wdr_f1_inblc_b[12:0];
        field { } isp_wdr_f1_inblc_gb[28:16];
    } ISP_WDR_F1_INBLC1 @ 0x6024;
    reg {
        name = "ISP_WDR_OUTBLC";
        field { } isp_wdr_outblc[17:0];
        field { } isp_wdr_bsaveblc[18:18];
    } ISP_WDR_OUTBLC @ 0x6028;
    reg {
        name = "ISP_WDR_EXPOVALUE";
        field { } isp_wdr_expovalue1[11:0];
        field { } isp_wdr_expovalue0[27:16];
    } ISP_WDR_EXPOVALUE @ 0x602C;
    reg {
        name = "ISP_WDR_EXPORRATIO";
        field { } isp_wdr_exporratio0[9:0];
    } ISP_WDR_EXPORRATIO @ 0x6030;
    reg {
        name = "ISP_WDR_BLC_COMP";
        field { } isp_wdr_blc_comp0[25:0];
    } ISP_WDR_BLC_COMP @ 0x6034;
    reg {
        name = "ISP_WDR_MAXRATIO";
        field { } isp_wdr_maxratio[14:0];
    } ISP_WDR_MAXRATIO @ 0x6038;
    reg {
        name = "ISP_WDR_SATURATE_THR";
        field { } isp_wdr_saturate_thr[11:0];
    } ISP_WDR_SATURATE_THR @ 0x603C;
    reg {
        name = "ISP_WDR_STILL_THR";
        field { } isp_wdr_f0_still_thr[11:0];
    } ISP_WDR_STILL_THR @ 0x6040;
    reg {
        name = "ISP_WDR_MDTLBLD";
        field { } isp_wdr_mdtlbld[7:0];
    } ISP_WDR_MDTLBLD @ 0x6044;
    reg {
        name = "ISP_WDR_MDT_THR";
        field { } isp_wdr_mdt_full_thr[7:0];
        field { } isp_wdr_mdt_still_thr[23:16];
    } ISP_WDR_MDT_THR @ 0x6048;
    reg {
        name = "ISP_WDR_FORCELONG_PARA";
        field { } isp_wdr_forcelonggh_thd[11:0];
        field { } isp_wdr_forcelong_low_thd[27:16];
        field { } isp_wdr_forcelong_smooth_en[28:28];
        field { } isp_wdr_forcelong_en[29:29];
    } ISP_WDR_FORCELONG_PARA @ 0x604C;
    reg {
        name = "ISP_WDR_FORCELONG_SLOPE";
        field { } isp_wdr_forcelong_slope[13:0];
    } ISP_WDR_FORCELONG_SLOPE @ 0x6050;
    reg {
        name = "ISP_WDR_MDT_NOSF_THR";
        field { } isp_wdr_mdt_nosfg_thr[10:0];
        field { } isp_wdr_mdt_nosf_low_thr[26:16];
    } ISP_WDR_MDT_NOSF_THR @ 0x6054;
    reg {
        name = "ISP_WDR_GAIN_SUM_THR";
        field { } isp_wdr_gain_sumg_thr[7:0];
        field { } isp_wdr_gain_sum_low_thr[23:16];
    } ISP_WDR_GAIN_SUM_THR @ 0x6058;
    reg {
        name = "ISP_WDR_SHORTEXPO_CHK";
        field { } isp_wdr_shortchk_thd[11:0];
        field { } isp_wdr_shortexpo_chk[16:16];
    } ISP_WDR_SHORTEXPO_CHK @ 0x605C;
    reg {
        name = "ISP_WDR_PIX_AVG_DIFF";
        field { } isp_wdr_pixel_avg_max_diff[11:0];
    } ISP_WDR_PIX_AVG_DIFF @ 0x6060;
    reg {
        name = "ISP_WDR_MASK_SIMILAR";
        field { } isp_wdr_mask_similar_cnt[3:0];
        field { } isp_wdr_mask_similar_thr[21:16];
    } ISP_WDR_MASK_SIMILAR @ 0x6064;
    reg {
        name = "ISP_WDR_WGTIDX_BLENDRATIO";
        field { } isp_wdr_bldrlhfidx[4:0];
    } ISP_WDR_WGTIDX_BLENDRATIO @ 0x6068;
    reg {
        name = "ISP_WDR_WGTIDX_THR";
        field { } isp_wdr_long_thr[11:0];
        field { } isp_wdr_short_thr[27:16];
    } ISP_WDR_WGTIDX_THR @ 0x606C;
    reg {
        name = "ISP_WDR_DFTWGT_FL";
        field { } isp_wdr_dftwgt_fl[8:0];
    } ISP_WDR_DFTWGT_FL @ 0x6070;
    reg {
        name = "ISP_WDR_WGT_SLOPE";
        field { } isp_wdr_wgt_slope[11:0];
    } ISP_WDR_WGT_SLOPE @ 0x6074;
    reg {
        name = "ISP_WDR_FUSION_THR_R";
        field { } isp_wdr_fusion_f1_thr_r[11:0];
        field { } isp_wdr_fusion_f0_thr_r[27:16];
    } ISP_WDR_FUSION_THR_R @ 0x613C;
    reg {
        name = "ISP_WDR_FUSION_THR_B";
        field { } isp_wdr_fusion_f1_thr_b[11:0];
        field { } isp_wdr_fusion_f0_thr_b[27:16];
    } ISP_WDR_FUSION_THR_B @ 0x6140;
    reg {
        name = "ISP_WDR_FUSION_THR_G";
        field { } isp_wdr_fusion_f1_thr_g[11:0];
        field { } isp_wdr_fusion_f0_thr_g[27:16];
    } ISP_WDR_FUSION_THR_G @ 0x6144;
    reg {
        name = "ISP_WDR_FUSION_SAT_THD";
        field { } isp_wdr_fusion_saturate_thd[11:0];
    } ISP_WDR_FUSION_SAT_THD @ 0x6148;
    reg {
        name = "ISP_DEHAZE_VERSION";
        field { } isp_dehaze_version[31:0];
    } ISP_DEHAZE_VERSION @ 0x670C;
    reg {
        name = "ISP_DEHAZE_BLK_SIZE";
        field { } isp_dehaze_block_sizev[8:0];
        field { } isp_dehaze_block_sizeh[24:16];
    } ISP_DEHAZE_BLK_SIZE @ 0x6710;
    reg {
        name = "ISP_DEHAZE_BLK_SUM";
        field { } isp_dehaze_block_sum[10:0];
    } ISP_DEHAZE_BLK_SUM @ 0x6714;
    reg {
        name = "ISP_DEHAZE_DC_SIZE";
        field { } isp_dehaze_dc_numv[4:0];
        field { } isp_dehaze_dc_numh[9:5];
    } ISP_DEHAZE_DC_SIZE @ 0x6718;
    reg {
        name = "ISP_DEHAZE_X";
        field { } isp_dehaze_phase_x[23:0];
    } ISP_DEHAZE_X @ 0x671C;
    reg {
        name = "ISP_DEHAZE_Y";
        field { } isp_dehaze_phase_y[23:0];
    } ISP_DEHAZE_Y @ 0x6720;
    reg {
        name = "ISP_DEHAZE_AIR";
        field { } isp_dehaze_air_b[9:0];
        field { } isp_dehaze_air_g[19:10];
        field { } isp_dehaze_air_r[29:20];
    } ISP_DEHAZE_AIR @ 0x6724;
    reg {
        name = "ISP_DEHAZE_THLD";
        field { } isp_dehaze_thld_tb[9:0];
        field { } isp_dehaze_thld_tg[19:10];
        field { } isp_dehaze_thld_tr[29:20];
    } ISP_DEHAZE_THLD @ 0x6728;
    reg {
        name = "ISP_DEHAZE_GSTRTH";
        field { } isp_dehaze_gstrth[7:0];
    } ISP_DEHAZE_GSTRTH @ 0x672C;
    reg {
        name = "ISP_DEHAZE_BLTHLD";
        field { } isp_dehaze_blthld[9:0];
    } ISP_DEHAZE_BLTHLD @ 0x6730;
    reg {
        name = "ISP_DEHAZE_STT_BST";
        field { } isp_dehaze_stt_size[15:0];
        field { } isp_dehaze_stt_bst[19:16];
        field { } isp_dehaze_stt_en[20:20];
    } ISP_DEHAZE_STT_BST @ 0x6734;
    reg {
        name = "ISP_DEHAZE_STT_ABN";
        field { } isp_dehaze_stt_info[15:0];
        field { } isp_dehaze_stt_clr[31:31];
    } ISP_DEHAZE_STT_ABN @ 0x6738;
    reg {
        name = "ISP_DEHAZE_STT2LUT_CFG";
        field { } isp_dehaze_stt2lut_en[0:0];
    } ISP_DEHAZE_STT2LUT_CFG @ 0x673C;
    reg {
        name = "ISP_DEHAZE_STT2LUT_REGNEW";
        field { } isp_dehaze_stt2lut_regnew[0:0];
    } ISP_DEHAZE_STT2LUT_REGNEW @ 0x6740;
    reg {
        name = "ISP_DEHAZE_STT2LUT_ABN";
        field { } isp_dehaze_stt2lut_info[15:0];
        field { } isp_dehaze_stt2lut_clr[31:31];
    } ISP_DEHAZE_STT2LUT_ABN @ 0x6744;
    reg {
        name = "ISP_DEHAZE_SMLMAPOFFSET";
        field { } isp_dehaze_smlmapoffset[19:0];
    } ISP_DEHAZE_SMLMAPOFFSET @ 0x6748;
    reg {
        name = "ISP_DEHAZE_STAT_POINT";
        field { } isp_dehaze_statstartx[12:0];
        field { } isp_dehaze_statendx[28:16];
    } ISP_DEHAZE_STAT_POINT @ 0x674C;
    reg {
        name = "ISP_DEHAZE_STAT_NUM";
        field { } isp_dehaze_stat_numv[4:0];
        field { } isp_dehaze_stat_numh[9:5];
    } ISP_DEHAZE_STAT_NUM @ 0x6750;
    reg {
        name = "ISP_DEHAZE_MINSTAT_WADDR";
        field { } isp_dehaze_minstat_waddr[8:0];
    } ISP_DEHAZE_MINSTAT_WADDR @ 0x6780;
    reg {
        name = "ISP_DEHAZE_MINSTAT_WDATA";
        field { } isp_dehaze_minstat_wdata_l[9:0];
        field { } isp_dehaze_minstat_wdata_h[25:16];
    } ISP_DEHAZE_MINSTAT_WDATA @ 0x6784;
    reg {
        name = "ISP_DEHAZE_MINSTAT_RADDR";
        field { } isp_dehaze_minstat_raddr[8:0];
    } ISP_DEHAZE_MINSTAT_RADDR @ 0x6788;
    reg {
        name = "ISP_DEHAZE_MINSTAT_RDATA";
        field { } isp_dehaze_minstat_rdata_l[9:0];
        field { } isp_dehaze_minstat_rdata_h[25:16];
    } ISP_DEHAZE_MINSTAT_RDATA @ 0x678C;
    reg {
        name = "ISP_DEHAZE_MAXSTAT_WADDR";
        field { } isp_dehaze_maxstat_waddr[9:0];
    } ISP_DEHAZE_MAXSTAT_WADDR @ 0x6790;
    reg {
        name = "ISP_DEHAZE_MAXSTAT_WDATA";
        field { } isp_dehaze_maxstat_wdata[29:0];
    } ISP_DEHAZE_MAXSTAT_WDATA @ 0x6794;
    reg {
        name = "ISP_DEHAZE_MAXSTAT_RADDR";
        field { } isp_dehaze_maxstat_raddr[9:0];
    } ISP_DEHAZE_MAXSTAT_RADDR @ 0x6798;
    reg {
        name = "ISP_DEHAZE_MAXSTAT_RDATA";
        field { } isp_dehaze_maxstat_rdata[29:0];
    } ISP_DEHAZE_MAXSTAT_RDATA @ 0x679C;
    reg {
        name = "ISP_DEHAZE_PRESTAT_WADDR";
        field { } isp_dehaze_prestat_waddr[9:0];
    } ISP_DEHAZE_PRESTAT_WADDR @ 0x67A0;
    reg {
        name = "ISP_DEHAZE_PRESTAT_WDATA";
        field { } isp_dehaze_prestat_wdata[9:0];
    } ISP_DEHAZE_PRESTAT_WDATA @ 0x67A4;
    reg {
        name = "ISP_DEHAZE_PRESTAT_RADDR";
        field { } isp_dehaze_prestat_raddr[9:0];
    } ISP_DEHAZE_PRESTAT_RADDR @ 0x67A8;
    reg {
        name = "ISP_DEHAZE_PRESTAT_RDATA";
        field { } isp_dehaze_prestat_rdata[9:0];
    } ISP_DEHAZE_PRESTAT_RDATA @ 0x67AC;
    reg {
        name = "ISP_DEHAZE_LUT_WADDR";
        field { } isp_dehaze_lut_waddr[7:0];
    } ISP_DEHAZE_LUT_WADDR @ 0x67B0;
    reg {
        name = "ISP_DEHAZE_LUT_WDATA";
        field { } isp_dehaze_lut_wdata[7:0];
    } ISP_DEHAZE_LUT_WDATA @ 0x67B4;
    reg {
        name = "ISP_DEHAZE_LUT_RADDR";
        field { } isp_dehaze_lut_raddr[7:0];
    } ISP_DEHAZE_LUT_RADDR @ 0x67B8;
    reg {
        name = "ISP_DEHAZE_LUT_RDATA";
        field { } isp_dehaze_lut_rdata[7:0];
    } ISP_DEHAZE_LUT_RDATA @ 0x67BC;
    reg {
        name = "ISP_EXPANDER_VERSION";
        field { } isp_expander_version[31:0];
    } ISP_EXPANDER_VERSION @ 0x680C;
    reg {
        name = "ISP_EXPANDER_BITW";
        field { } isp_expander_bitw_out[4:0];
        field { } isp_expander_bitw_in[20:16];
    } ISP_EXPANDER_BITW @ 0x6810;
    reg {
        name = "ISP_EXPANDER_LUT_WADDR";
        field { } isp_expander_lut_waddr[31:0];
    } ISP_EXPANDER_LUT_WADDR @ 0x6880;
    reg {
        name = "ISP_EXPANDER_LUT_WDATA";
        field { } isp_expander_lut_wdata[31:0];
    } ISP_EXPANDER_LUT_WDATA @ 0x6884;
    reg {
        name = "ISP_EXPANDER_LUT_RADDR";
        field { } isp_expander_lut_raddr[31:0];
    } ISP_EXPANDER_LUT_RADDR @ 0x6888;
    reg {
        name = "ISP_EXPANDER_LUT_RDATA";
        field { } isp_expander_lut_rdata[31:0];
    } ISP_EXPANDER_LUT_RDATA @ 0x688C;
    reg {
        name = "ISP_GAMMA_CFG";
        field { } value[31:0];
    } ISP_GAMMA_CFG @ 0x6A00;
    reg {
        name = "ISP_GAMMA_POS0";
        field { } isp_gamma_pos_0[12:0];
        field { } isp_gamma_pos_1[28:16];
    } ISP_GAMMA_POS0 @ 0x6A20;
    reg {
        name = "ISP_GAMMA_POS1";
        field { } isp_gamma_pos_2[12:0];
        field { } isp_gamma_pos_3[28:16];
    } ISP_GAMMA_POS1 @ 0x6A24;
    reg {
        name = "ISP_GAMMA_POS2";
        field { } isp_gamma_pos_4[12:0];
        field { } isp_gamma_pos_5[28:16];
    } ISP_GAMMA_POS2 @ 0x6A28;
    reg {
        name = "ISP_GAMMA_POS3";
        field { } isp_gamma_pos_6[12:0];
        field { } isp_gamma_pos_7[28:16];
    } ISP_GAMMA_POS3 @ 0x6A2C;
    reg {
        name = "ISP_GAMMA_INSEG0";
        field { } isp_gamma_inseg_0[8:0];
        field { } isp_gamma_inseg_1[24:16];
    } ISP_GAMMA_INSEG0 @ 0x6A30;
    reg {
        name = "ISP_GAMMA_INSEG1";
        field { } isp_gamma_inseg_2[8:0];
        field { } isp_gamma_inseg_3[24:16];
    } ISP_GAMMA_INSEG1 @ 0x6A34;
    reg {
        name = "ISP_GAMMA_INSEG2";
        field { } isp_gamma_inseg_4[8:0];
        field { } isp_gamma_inseg_5[24:16];
    } ISP_GAMMA_INSEG2 @ 0x6A38;
    reg {
        name = "ISP_GAMMA_INSEG3";
        field { } isp_gamma_inseg_6[8:0];
        field { } isp_gamma_inseg_7[24:16];
    } ISP_GAMMA_INSEG3 @ 0x6A3C;
    reg {
        name = "ISP_GAMMA_STEP";
        field { } isp_gamma_step0[2:0];
        field { } isp_gamma_step1[6:4];
        field { } isp_gamma_step2[10:8];
        field { } isp_gamma_step3[14:12];
        field { } isp_gamma_step4[18:16];
        field { } isp_gamma_step5[22:20];
        field { } isp_gamma_step6[26:24];
        field { } isp_gamma_step7[30:28];
    } ISP_GAMMA_STEP @ 0x6A40;
    reg {
        name = "ISP_GAMMA_STT2LUT_CFG";
        field { } isp_gamma_stt2lut_en[0:0];
    } ISP_GAMMA_STT2LUT_CFG @ 0x6A50;
    reg {
        name = "ISP_GAMMA_STT2LUT_REGNEW";
        field { } isp_gamma_stt2lut_regnew[0:0];
    } ISP_GAMMA_STT2LUT_REGNEW @ 0x6A54;
    reg {
        name = "ISP_GAMMA_STT2LUT_ABN";
        field { } isp_gamma_stt2lut_info[15:0];
        field { } isp_gamma_stt2lut_clr[31:31];
    } ISP_GAMMA_STT2LUT_ABN @ 0x6A58;
    reg {
        name = "ISP_GAMMA_LUT_WADDR";
        field { } isp_gamma_lut_waddr[31:0];
    } ISP_GAMMA_LUT_WADDR @ 0x6A80;
    reg {
        name = "ISP_GAMMA_LUT_WDATA";
        field { } isp_gamma_lut_wdata[31:0];
    } ISP_GAMMA_LUT_WDATA @ 0x6A84;
    reg {
        name = "ISP_GAMMA_LUT_RADDR";
        field { } isp_gamma_lut_raddr[31:0];
    } ISP_GAMMA_LUT_RADDR @ 0x6A88;
    reg {
        name = "ISP_GAMMA_LUT_RDATA";
        field { } isp_gamma_lut_rdata[31:0];
    } ISP_GAMMA_LUT_RDATA @ 0x6A8C;
    reg {
        name = "ISP_BCOM_CFG";
        field { } value[31:0];
    } ISP_BCOM_CFG @ 0x6C00;
    reg {
        name = "ISP_BCOM_VERSION";
        field { } isp_bcom_version[31:0];
    } ISP_BCOM_VERSION @ 0x6C0C;
    reg {
        name = "ISP_BCOM_ALPHA";
        field { } isp_bcom_alpha[2:0];
    } ISP_BCOM_ALPHA @ 0x6C10;
    reg {
        name = "ISP_BDEC_CFG";
        field { } value[31:0];
    } ISP_BDEC_CFG @ 0x6D00;
    reg {
        name = "ISP_BDEC_VERSION";
        field { } isp_bdec_version[31:0];
    } ISP_BDEC_VERSION @ 0x6D0C;
    reg {
        name = "ISP_BDEC_ALPHA";
        field { } isp_bdec_alpha[2:0];
    } ISP_BDEC_ALPHA @ 0x6D10;
    reg {
        name = "ISP_CA_CTRL";
        field { } isp_ca_satadj_en[0:0];
        field { } isp_ca_skinproc_en[4:4];
        field { } isp_ca_llhcproc_en[8:8];
    } ISP_CA_CTRL @ 0x7010;
    reg {
        name = "ISP_CA_LUMATH";
        field { } isp_ca_lumathgh[9:0];
        field { } isp_ca_lumath_low[25:16];
    } ISP_CA_LUMATH @ 0x7014;
    reg {
        name = "ISP_CA_DARKCHROMA_TH";
        field { } isp_ca_darkchromathgh[9:0];
        field { } isp_ca_darkchromath_low[25:16];
    } ISP_CA_DARKCHROMA_TH @ 0x7018;
    reg {
        name = "ISP_CA_SDARKCHROMA_TH";
        field { } isp_ca_sdarkchromathgh[9:0];
        field { } isp_ca_sdarkchromath_low[25:16];
    } ISP_CA_SDARKCHROMA_TH @ 0x701C;
    reg {
        name = "ISP_CA_LLHC_RATIO";
        field { } isp_ca_lumaratiogh[10:0];
        field { } isp_ca_lumaratio_low[26:16];
    } ISP_CA_LLHC_RATIO @ 0x7020;
    reg {
        name = "ISP_CA_ISORATIO";
        field { } isp_ca_isoratio[10:0];
    } ISP_CA_ISORATIO @ 0x7024;
    reg {
        name = "ISP_CA_YRARATIO";
        field { } isp_ca_yraratio[14:0];
    } ISP_CA_YRARATIO @ 0x7028;
    reg {
        name = "ISP_CA_SKINLLUMA_UTH";
        field { } isp_ca_skinlluma_umax[9:0];
        field { } isp_ca_skinlluma_umin[25:16];
    } ISP_CA_SKINLLUMA_UTH @ 0x702C;
    reg {
        name = "ISP_CA_SKINLLUMA_UYTH";
        field { } isp_ca_skinlluma_uymax[9:0];
        field { } isp_ca_skinlluma_uymin[25:16];
    } ISP_CA_SKINLLUMA_UYTH @ 0x7030;
    reg {
        name = "ISP_CA_SKINHLUMA_UTH";
        field { } isp_ca_skinhluma_umax[9:0];
        field { } isp_ca_skinhluma_umin[25:16];
    } ISP_CA_SKINHLUMA_UTH @ 0x7034;
    reg {
        name = "ISP_CA_SKINHLUMA_UYTH";
        field { } isp_ca_skinhluma_uymax[9:0];
        field { } isp_ca_skinhluma_uymin[25:16];
    } ISP_CA_SKINHLUMA_UYTH @ 0x7038;
    reg {
        name = "ISP_CA_SKINLLUMA_VTH";
        field { } isp_ca_skinlluma_vmax[9:0];
        field { } isp_ca_skinlluma_vmin[25:16];
    } ISP_CA_SKINLLUMA_VTH @ 0x703C;
    reg {
        name = "ISP_CA_SKINLLUMA_VYTH";
        field { } isp_ca_skinlluma_vymax[9:0];
        field { } isp_ca_skinlluma_vymin[25:16];
    } ISP_CA_SKINLLUMA_VYTH @ 0x7040;
    reg {
        name = "ISP_CA_SKINHLUMA_VTH";
        field { } isp_ca_skinhluma_vmax[9:0];
        field { } isp_ca_skinhluma_vmin[25:16];
    } ISP_CA_SKINHLUMA_VTH @ 0x7044;
    reg {
        name = "ISP_CA_SKINHLUMA_VYTH";
        field { } isp_ca_skinhluma_vymax[9:0];
        field { } isp_ca_skinhluma_vymin[25:16];
    } ISP_CA_SKINHLUMA_VYTH @ 0x7048;
    reg {
        name = "ISP_CA_SKIN_UVDIFF";
        field { } isp_ca_skin_uvdiff[10:0];
    } ISP_CA_SKIN_UVDIFF @ 0x704C;
    reg {
        name = "ISP_CA_SKIN_RATIOTH0";
        field { } isp_ca_skinratioth_mid[11:0];
        field { } isp_ca_skinratioth_low[27:16];
    } ISP_CA_SKIN_RATIOTH0 @ 0x7050;
    reg {
        name = "ISP_CA_SKIN_RATIOTH1";
        field { } isp_ca_skinratiothgh[11:0];
    } ISP_CA_SKIN_RATIOTH1 @ 0x7054;
    reg {
        name = "ISP_CA_SKIN_BETARATIO";
        field { } isp_ca_skin_betaratio[14:0];
    } ISP_CA_SKIN_BETARATIO @ 0x7058;
    reg {
        name = "ISP_CA_LUT_WADDR";
        field { } isp_ca_lut_waddr[6:0];
    } ISP_CA_LUT_WADDR @ 0x7080;
    reg {
        name = "ISP_CA_LUT_WDATA";
        field { } isp_ca_lut_wdata[10:0];
    } ISP_CA_LUT_WDATA @ 0x7084;
    reg {
        name = "ISP_CA_LUT_RADDR";
        field { } isp_ca_lut_raddr[6:0];
    } ISP_CA_LUT_RADDR @ 0x7088;
    reg {
        name = "ISP_CA_LUT_RDATA";
        field { } isp_ca_lut_rdata[10:0];
    } ISP_CA_LUT_RDATA @ 0x708C;
    reg {
        name = "ISP_CA_STT2LUT_CFG";
        field { } isp_ca_stt2lut_en[0:0];
    } ISP_CA_STT2LUT_CFG @ 0x7110;
    reg {
        name = "ISP_CA_STT2LUT_REGNEW";
        field { } isp_ca_stt2lut_regnew[0:0];
    } ISP_CA_STT2LUT_REGNEW @ 0x7114;
    reg {
        name = "ISP_CA_STT2LUT_ABN";
        field { } isp_ca_stt2lut_info[15:0];
        field { } isp_ca_stt2lut_clr[31:31];
    } ISP_CA_STT2LUT_ABN @ 0x7118;
    reg {
        name = "ISP_LDCI_CFG";
        field { } isp_ldci_calc_en[1:1];
        field { } isp_ldci_wrstat_en[2:2];
        field { } isp_ldci_rdstat_en[3:3];
    } ISP_LDCI_CFG @ 0x7800;
    reg {
        name = "ISP_LDCI_VERSION";
        field { } isp_ldci_version[31:0];
    } ISP_LDCI_VERSION @ 0x780C;
    reg {
        name = "ISP_LDCI_CALC_SMALL_OFFSET";
        field { } isp_ldci_calc_map_offsetx[19:0];
    } ISP_LDCI_CALC_SMALL_OFFSET @ 0x7814;
    reg {
        name = "ISP_LDCI_ZONE";
        field { } isp_ldci_smlmapstride[5:0];
        field { } isp_ldci_smlmapheight[13:8];
        field { } isp_ldci_total_zone[31:16];
    } ISP_LDCI_ZONE @ 0x7818;
    reg {
        name = "ISP_LDCI_LPFSTT_BST";
        field { } isp_ldci_lpfstt_size[15:0];
        field { } isp_ldci_lpfstt_bst[19:16];
        field { } isp_ldci_lpfstt_en[20:20];
    } ISP_LDCI_LPFSTT_BST @ 0x7820;
    reg {
        name = "ISP_LDCI_LPFSTT_ABN";
        field { } isp_ldci_lpfstt_info[15:0];
        field { } isp_ldci_lpfstt_clr[31:31];
    } ISP_LDCI_LPFSTT_ABN @ 0x7824;
    reg {
        name = "ISP_LDCI_SCALE";
        field { } isp_ldci_scalex[14:0];
        field { } isp_ldci_scaley[30:16];
    } ISP_LDCI_SCALE @ 0x7828;
    reg {
        name = "ISP_LDCI_LUMA_SEL";
        field { } isp_ldci_luma_sel[0:0];
    } ISP_LDCI_LUMA_SEL @ 0x7834;
    reg {
        name = "ISP_LDCI_BLC_CTRL";
        field { } isp_ldci_blc_ctrl[8:0];
    } ISP_LDCI_BLC_CTRL @ 0x7838;
    reg {
        name = "ISP_LDCI_LPF_LPFCOEF0";
        field { } isp_ldci_lpfcoef0[8:0];
        field { } isp_ldci_lpfcoef1[24:16];
    } ISP_LDCI_LPF_LPFCOEF0 @ 0x7864;
    reg {
        name = "ISP_LDCI_LPF_LPFCOEF1";
        field { } isp_ldci_lpfcoef2[8:0];
        field { } isp_ldci_lpfcoef3[24:16];
    } ISP_LDCI_LPF_LPFCOEF1 @ 0x7868;
    reg {
        name = "ISP_LDCI_LPF_LPFCOEF2";
        field { } isp_ldci_lpfcoef4[8:0];
    } ISP_LDCI_LPF_LPFCOEF2 @ 0x786C;
    reg {
        name = "ISP_LDCI_LPF_LPFSFT";
        field { } isp_ldci_lpfsft[3:0];
    } ISP_LDCI_LPF_LPFSFT @ 0x7878;
    reg {
        name = "ISP_LDCI_HE_WADDR";
        field { } isp_ldci_he_waddr[31:0];
    } ISP_LDCI_HE_WADDR @ 0x7890;
    reg {
        name = "ISP_LDCI_HE_WDATA";
        field { } isp_ldci_hepos_wdata[8:0];
        field { } isp_ldci_heneg_wdata[17:9];
    } ISP_LDCI_HE_WDATA @ 0x7894;
    reg {
        name = "ISP_LDCI_HE_RADDR";
        field { } isp_ldci_he_raddr[31:0];
    } ISP_LDCI_HE_RADDR @ 0x7898;
    reg {
        name = "ISP_LDCI_HE_RDATA";
        field { } isp_ldci_hepos_rdata[8:0];
        field { } isp_ldci_heneg_rdata[17:9];
    } ISP_LDCI_HE_RDATA @ 0x789C;
    reg {
        name = "ISP_LDCI_DE_USM_WADDR";
        field { } isp_ldci_de_usm_waddr[31:0];
    } ISP_LDCI_DE_USM_WADDR @ 0x78A0;
    reg {
        name = "ISP_LDCI_DE_USM_WDATA";
        field { } isp_ldci_usmpos_wdata[8:0];
        field { } isp_ldci_usmneg_wdata[17:9];
    } ISP_LDCI_DE_USM_WDATA @ 0x78A4;
    reg {
        name = "ISP_LDCI_DE_USM_RADDR";
        field { } isp_ldci_de_usm_raddr[31:0];
    } ISP_LDCI_DE_USM_RADDR @ 0x78A8;
    reg {
        name = "ISP_LDCI_DE_USM_RDATA";
        field { } isp_ldci_usmpos_rdata[8:0];
        field { } isp_ldci_usmneg_rdata[17:9];
    } ISP_LDCI_DE_USM_RDATA @ 0x78AC;
    reg {
        name = "ISP_LDCI_CGAIN_WADDR";
        field { } isp_ldci_cgain_waddr[31:0];
    } ISP_LDCI_CGAIN_WADDR @ 0x78B0;
    reg {
        name = "ISP_LDCI_CGAIN_WDATA";
        field { } isp_ldci_cgain_wdata[11:0];
    } ISP_LDCI_CGAIN_WDATA @ 0x78B4;
    reg {
        name = "ISP_LDCI_CGAIN_RADDR";
        field { } isp_ldci_cgain_raddr[31:0];
    } ISP_LDCI_CGAIN_RADDR @ 0x78B8;
    reg {
        name = "ISP_LDCI_CGAIN_RDATA";
        field { } isp_ldci_cgain_rdata[11:0];
    } ISP_LDCI_CGAIN_RDATA @ 0x78BC;
    reg {
        name = "ISP_LDCI_STAT_HPOS";
        field { } isp_ldci_hstart[12:0];
        field { } isp_ldci_hend[28:16];
    } ISP_LDCI_STAT_HPOS @ 0x7920;
    reg {
        name = "ISP_LDCI_STAT_VPOS";
        field { } isp_ldci_vstart[12:0];
        field { } isp_ldci_vend[28:16];
    } ISP_LDCI_STAT_VPOS @ 0x7924;
    reg {
        name = "ISP_LDCI_STAT_EVRATIO";
        field { } isp_ldci_stat_evratio[15:0];
    } ISP_LDCI_STAT_EVRATIO @ 0x7928;
    reg {
        name = "ISP_LDCI_STAT_ZONE";
        field { } isp_ldci_stat_smlmapwidth[5:0];
        field { } isp_ldci_stat_smlmapheight[13:8];
        field { } isp_ldci_stat_total_zone[31:16];
    } ISP_LDCI_STAT_ZONE @ 0x7930;
    reg {
        name = "ISP_LDCI_BLK_SMLMAPWIDTH0";
        field { } isp_ldci_blk_smlmapwidth0[5:0];
    } ISP_LDCI_BLK_SMLMAPWIDTH0 @ 0x7950;
    reg {
        name = "ISP_LDCI_BLK_SMLMAPWIDTH1";
        field { } isp_ldci_blk_smlmapwidth1[5:0];
    } ISP_LDCI_BLK_SMLMAPWIDTH1 @ 0x7954;
    reg {
        name = "ISP_LDCI_BLK_SMLMAPWIDTH2";
        field { } isp_ldci_blk_smlmapwidth2[5:0];
    } ISP_LDCI_BLK_SMLMAPWIDTH2 @ 0x7958;
    reg {
        name = "ISP_LDCI_CHRDAMP";
        field { } isp_ldci_chrposdamp[7:0];
        field { } isp_ldci_chrnegdamp[15:8];
    } ISP_LDCI_CHRDAMP @ 0x7968;
    reg {
        name = "ISP_LDCI_STT2LUT_CFG";
        field { } isp_ldci_stt2lut_en[0:0];
    } ISP_LDCI_STT2LUT_CFG @ 0x7970;
    reg {
        name = "ISP_LDCI_STT2LUT_REGNEW";
        field { } isp_ldci_stt2lut_regnew[0:0];
    } ISP_LDCI_STT2LUT_REGNEW @ 0x7974;
    reg {
        name = "ISP_LDCI_STT2LUT_ABN";
        field { } isp_ldci_stt2lut_info[15:0];
        field { } isp_ldci_stt2lut_clr[31:31];
    } ISP_LDCI_STT2LUT_ABN @ 0x7978;
    reg {
        name = "ISP_LDCI_LPF_MAP_WADDR";
        field { } value[31:0];
    } ISP_LDCI_LPF_MAP_WADDR @ 0x79B0;
    reg {
        name = "ISP_LDCI_LPF_MAP_WDATA";
        field { } value[31:0];
    } ISP_LDCI_LPF_MAP_WDATA @ 0x79B4;
    reg {
        name = "ISP_LDCI_LPF_MAP_RADDR";
        field { } isp_ldci_lpfmap_raddr[31:0];
    } ISP_LDCI_LPF_MAP_RADDR @ 0x79B8;
    reg {
        name = "ISP_LDCI_LPF_MAP_RDATA";
        field { } isp_ldci_lpflitmap_rdata[9:0];
        field { } isp_ldci_lpfplyp2map_rdata[19:10];
        field { } isp_ldci_lpfplyp3map_rdata[29:20];
    } ISP_LDCI_LPF_MAP_RDATA @ 0x79BC;
    reg {
        name = "ISP_DRC_CFG";
        field { } isp_drc_wrstat_en[1:1];
        field { } isp_drc_rdstat_en[2:2];
        field { } isp_drc_vbiflt_en[3:3];
        field { } isp_drc_color_corr_en[4:4];
        field { } isp_drc_mono_chroma_en[7:7];
        field { } isp_drc_pregamma_en[8:8];
        field { } isp_drc_dp_det_en[9:9];
    } ISP_DRC_CFG @ 0x7C00;
    reg {
        name = "ISP_DRC_LUT_UPDATE0";
        field { } isp_drc_lut_update0[0:0];
    } ISP_DRC_LUT_UPDATE0 @ 0x7C04;
    reg {
        name = "ISP_DRC_LUT_UPDATE1";
        field { } isp_drc_lut_update1[0:0];
    } ISP_DRC_LUT_UPDATE1 @ 0x7C08;
    reg {
        name = "ISP_DRC_VERSION";
        field { } isp_drc_version[31:0];
    } ISP_DRC_VERSION @ 0x7C0C;
    reg {
        name = "ISP_DRC_ZONE";
        field { } isp_drc_hnum[5:0];
        field { } isp_drc_vnum[13:8];
    } ISP_DRC_ZONE @ 0x7C10;
    reg {
        name = "ISP_DRC_ZONE_SIZE";
        field { } isp_drc_zone_hsize[8:0];
        field { } isp_drc_chk_x[14:9];
        field { } isp_drc_zone_vsize[24:16];
        field { } isp_drc_chk_y[30:25];
    } ISP_DRC_ZONE_SIZE @ 0x7C14;
    reg {
        name = "ISP_DRC_ZONE_DIV0";
        field { } isp_drc_div_x0[14:0];
        field { } isp_drc_div_y0[30:16];
    } ISP_DRC_ZONE_DIV0 @ 0x7C18;
    reg {
        name = "ISP_DRC_ZONE_DIV1";
        field { } isp_drc_div_x1[14:0];
        field { } isp_drc_div_y1[30:16];
    } ISP_DRC_ZONE_DIV1 @ 0x7C1C;
    reg {
        name = "ISP_DRC_BIN";
        field { } isp_drc_bin[3:0];
    } ISP_DRC_BIN @ 0x7C20;
    reg {
        name = "ISP_DRC_ZONE_INIT";
        field { } isp_drc_acc_x_init[15:0];
        field { } isp_drc_cnt_x_init[24:16];
        field { } isp_drc_idx_x_init[30:25];
        field { } isp_drc_big_x_init[31:31];
    } ISP_DRC_ZONE_INIT @ 0x7C24;
    reg {
        name = "ISP_DRC_BIN_SCALE";
        field { } isp_drc_bin_scale[2:0];
    } ISP_DRC_BIN_SCALE @ 0x7C28;
    reg {
        name = "ISP_DRC_STRENGTH";
        field { } isp_drc_strength[9:0];
    } ISP_DRC_STRENGTH @ 0x7C38;
    reg {
        name = "ISP_DRC_STAT_WIDTH";
        field { } isp_drc_stat_width[15:0];
        field { } isp_drc_total_width[31:16];
    } ISP_DRC_STAT_WIDTH @ 0x7C3C;
    reg {
        name = "ISP_DRC_DARK_GAIN_LMT_Y";
        field { } isp_drc_val1_y[7:0];
        field { } isp_drc_sft1_y[11:8];
        field { } isp_drc_val2_y[15:12];
        field { } isp_drc_sft2_y[19:16];
    } ISP_DRC_DARK_GAIN_LMT_Y @ 0x7C40;
    reg {
        name = "ISP_DRC_DARK_GAIN_LMT_C";
        field { } isp_drc_val1_c[7:0];
        field { } isp_drc_sft1_c[11:8];
        field { } isp_drc_val2_c[15:12];
        field { } isp_drc_sft2_c[19:16];
    } ISP_DRC_DARK_GAIN_LMT_C @ 0x7C44;
    reg {
        name = "ISP_DRC_BRIGHT_GAIN_LMT";
        field { } isp_drc_val[7:0];
        field { } isp_drc_sft[11:8];
    } ISP_DRC_BRIGHT_GAIN_LMT @ 0x7C48;
    reg {
        name = "ISP_DRC_RGB_WGT";
        field { } isp_drc_r_wgt[3:0];
        field { } isp_drc_g_wgt[12:8];
        field { } isp_drc_b_wgt[19:16];
    } ISP_DRC_RGB_WGT @ 0x7C4C;
    reg {
        name = "ISP_DRC_DP_DTC";
        field { } isp_drc_dp_det_thrmin[15:0];
        field { } isp_drc_dp_det_thrslo[20:16];
        field { } isp_drc_dp_det_g2rb[21:21];
        field { } isp_drc_dp_det_rb2rb[22:22];
        field { } isp_drc_dp_det_replctr[23:23];
        field { } isp_drc_dp_det_rngrto[28:24];
    } ISP_DRC_DP_DTC @ 0x7C50;
    reg {
        name = "ISP_DRC_GAIN_CLIP";
        field { } isp_drc_gain_clip_step[3:0];
        field { } isp_drc_gain_clip_knee[7:4];
    } ISP_DRC_GAIN_CLIP @ 0x7C58;
    reg {
        name = "ISP_DRC_COLOR_CTRL";
        field { } isp_drc_cc_lut_ctrl[0:0];
    } ISP_DRC_COLOR_CTRL @ 0x7C5C;
    reg {
        name = "ISP_DRC_GLOBAL_CORR";
        field { } isp_drc_cc_global_corr[11:0];
    } ISP_DRC_GLOBAL_CORR @ 0x7C60;
    reg {
        name = "ISP_DRC_MIXING_CORING";
        field { } isp_drc_mixing_coring[7:0];
    } ISP_DRC_MIXING_CORING @ 0x7C64;
    reg {
        name = "ISP_DRC_MIXING_DARK";
        field { } isp_drc_dark_min[7:0];
        field { } isp_drc_dark_max[15:8];
        field { } isp_drc_dark_thr[23:16];
        field { } isp_drc_dark_slo[27:24];
    } ISP_DRC_MIXING_DARK @ 0x7C68;
    reg {
        name = "ISP_DRC_MIXING_BRIGHT";
        field { } isp_drc_bright_min[7:0];
        field { } isp_drc_bright_max[15:8];
        field { } isp_drc_bright_thr[23:16];
        field { } isp_drc_bright_slo[27:24];
    } ISP_DRC_MIXING_BRIGHT @ 0x7C6C;
    reg {
        name = "ISP_DRC_TMLUT0_WADDR";
        field { } isp_drc_tmlut0_waddr[31:0];
    } ISP_DRC_TMLUT0_WADDR @ 0x7C80;
    reg {
        name = "ISP_DRC_TMLUT0_WDATA";
        field { } isp_drc_tmlut0_wdata[31:0];
    } ISP_DRC_TMLUT0_WDATA @ 0x7C84;
    reg {
        name = "ISP_DRC_TMLUT0_RADDR";
        field { } isp_drc_tmlut0_raddr[31:0];
    } ISP_DRC_TMLUT0_RADDR @ 0x7C88;
    reg {
        name = "ISP_DRC_TMLUT0_RDATA";
        field { } isp_drc_tmlut0_rdata[31:0];
    } ISP_DRC_TMLUT0_RDATA @ 0x7C8C;
    reg {
        name = "ISP_DRC_CCLUT_WADDR";
        field { } isp_drc_cclut_waddr[31:0];
    } ISP_DRC_CCLUT_WADDR @ 0x7CA0;
    reg {
        name = "ISP_DRC_CCLUT_WDATA";
        field { } isp_drc_cclut_wdata[31:0];
    } ISP_DRC_CCLUT_WDATA @ 0x7CA4;
    reg {
        name = "ISP_DRC_CCLUT_RADDR";
        field { } isp_drc_cclut_raddr[31:0];
    } ISP_DRC_CCLUT_RADDR @ 0x7CA8;
    reg {
        name = "ISP_DRC_CCLUT_RDATA";
        field { } isp_drc_cclut_rdata[31:0];
    } ISP_DRC_CCLUT_RDATA @ 0x7CAC;
    reg {
        name = "ISP_DRC_PREGAMMA_WADDR";
        field { } isp_drc_pregamma_waddr[31:0];
    } ISP_DRC_PREGAMMA_WADDR @ 0x7CB0;
    reg {
        name = "ISP_DRC_PREGAMMA_WDATA";
        field { } isp_drc_pregamma_wdata[31:0];
    } ISP_DRC_PREGAMMA_WDATA @ 0x7CB4;
    reg {
        name = "ISP_DRC_PREGAMMA_RADDR";
        field { } isp_drc_pregamma_raddr[31:0];
    } ISP_DRC_PREGAMMA_RADDR @ 0x7CB8;
    reg {
        name = "ISP_DRC_PREGAMMA_RDATA";
        field { } isp_drc_pregamma_rdata[31:0];
    } ISP_DRC_PREGAMMA_RDATA @ 0x7CBC;
    reg {
        name = "ISP_DRC_GRAD_REV";
        field { } isp_drc_grad_rev_thres[7:0];
        field { } isp_drc_grad_rev_max[14:8];
        field { } isp_drc_grad_rev_slope[19:16];
        field { } isp_drc_grad_rev_shift[26:24];
    } ISP_DRC_GRAD_REV @ 0x7D00;
    reg {
        name = "ISP_DRC_VBI_STRENGTH";
        field { } isp_drc_var_rng_fine[1:0];
        field { } isp_drc_var_rng_medium[6:4];
        field { } isp_drc_var_rng_coarse[11:8];
        field { } isp_drc_var_spa_fine[13:12];
        field { } isp_drc_var_spa_medium[18:16];
        field { } isp_drc_var_spa_coarse[23:20];
    } ISP_DRC_VBI_STRENGTH @ 0x7D04;
    reg {
        name = "ISP_DRC_RNG_ADA_COEF";
        field { } isp_drc_fr_ada_max[3:0];
        field { } isp_drc_dis_offset_coef[7:4];
        field { } isp_drc_thr_coef_low[10:8];
        field { } isp_drc_thr_coefgh[14:12];
    } ISP_DRC_RNG_ADA_COEF @ 0x7D08;
    reg {
        name = "ISP_DRC_VBI_STATE";
        field { } isp_drc_vbi_state[15:0];
    } ISP_DRC_VBI_STATE @ 0x7D10;
    reg {
        name = "ISP_DRC_PREV_LUMA_0";
        field { } isp_drc_prev_luma_0[23:0];
    } ISP_DRC_PREV_LUMA_0 @ 0x7D3C;
    reg {
        name = "ISP_DRC_PREV_LUMA_1";
        field { } isp_drc_prev_luma_1[23:0];
    } ISP_DRC_PREV_LUMA_1 @ 0x7D40;
    reg {
        name = "ISP_DRC_PREV_LUMA_2";
        field { } isp_drc_prev_luma_2[23:0];
    } ISP_DRC_PREV_LUMA_2 @ 0x7D44;
    reg {
        name = "ISP_DRC_PREV_LUMA_3";
        field { } isp_drc_prev_luma_3[23:0];
    } ISP_DRC_PREV_LUMA_3 @ 0x7D48;
    reg {
        name = "ISP_DRC_PREV_LUMA_4";
        field { } isp_drc_prev_luma_4[23:0];
    } ISP_DRC_PREV_LUMA_4 @ 0x7D4C;
    reg {
        name = "ISP_DRC_PREV_LUMA_5";
        field { } isp_drc_prev_luma_5[23:0];
    } ISP_DRC_PREV_LUMA_5 @ 0x7D50;
    reg {
        name = "ISP_DRC_PREV_LUMA_6";
        field { } isp_drc_prev_luma_6[23:0];
    } ISP_DRC_PREV_LUMA_6 @ 0x7D54;
    reg {
        name = "ISP_DRC_PREV_LUMA_7";
        field { } isp_drc_prev_luma_7[23:0];
    } ISP_DRC_PREV_LUMA_7 @ 0x7D58;
    reg {
        name = "ISP_DRC_SUPPRESS_BRIGHT";
        field { } isp_drc_suppress_bright_max[7:0];
        field { } isp_drc_suppress_bright_min[15:8];
        field { } isp_drc_suppress_bright_thr[23:16];
        field { } isp_drc_suppress_bright_slo[27:24];
    } ISP_DRC_SUPPRESS_BRIGHT @ 0x7D60;
    reg {
        name = "ISP_DRC_SUPPRESS_DARK";
        field { } isp_drc_suppress_dark_max[7:0];
        field { } isp_drc_suppress_dark_min[15:8];
        field { } isp_drc_suppress_dark_thr[23:16];
        field { } isp_drc_suppress_dark_slo[27:24];
    } ISP_DRC_SUPPRESS_DARK @ 0x7D64;
    reg {
        name = "ISP_DRC_IDXBASE0";
        field { } isp_drc_idxbase0[7:0];
        field { } isp_drc_idxbase1[15:8];
        field { } isp_drc_idxbase2[23:16];
        field { } isp_drc_idxbase3[31:24];
    } ISP_DRC_IDXBASE0 @ 0x7D68;
    reg {
        name = "ISP_DRC_IDXBASE1";
        field { } isp_drc_idxbase4[7:0];
        field { } isp_drc_idxbase5[15:8];
        field { } isp_drc_idxbase6[23:16];
        field { } isp_drc_idxbase7[31:24];
    } ISP_DRC_IDXBASE1 @ 0x7D6C;
    reg {
        name = "ISP_DRC_MAXVAL0";
        field { } isp_drc_maxval0[7:0];
        field { } isp_drc_maxval1[15:8];
        field { } isp_drc_maxval2[23:16];
        field { } isp_drc_maxval3[31:24];
    } ISP_DRC_MAXVAL0 @ 0x7D70;
    reg {
        name = "ISP_DRC_MAXVAL1";
        field { } isp_drc_maxval4[7:0];
        field { } isp_drc_maxval5[15:8];
        field { } isp_drc_maxval6[23:16];
        field { } isp_drc_maxval7[31:24];
    } ISP_DRC_MAXVAL1 @ 0x7D74;
    reg {
        name = "ISP_DRC_PREGAMMA_IDXBASE0";
        field { } isp_drc_pregamma_idxbase0[7:0];
        field { } isp_drc_pregamma_idxbase1[15:8];
        field { } isp_drc_pregamma_idxbase2[23:16];
        field { } isp_drc_pregamma_idxbase3[31:24];
    } ISP_DRC_PREGAMMA_IDXBASE0 @ 0x7E00;
    reg {
        name = "ISP_DRC_PREGAMMA_IDXBASE1";
        field { } isp_drc_pregamma_idxbase4[7:0];
        field { } isp_drc_pregamma_idxbase5[15:8];
        field { } isp_drc_pregamma_idxbase6[23:16];
        field { } isp_drc_pregamma_idxbase7[31:24];
    } ISP_DRC_PREGAMMA_IDXBASE1 @ 0x7E04;
    reg {
        name = "ISP_DRC_PREGAMMA_IDXBASE2";
        field { } isp_drc_pregamma_idxbase8[7:0];
        field { } isp_drc_pregamma_idxbase9[15:8];
        field { } isp_drc_pregamma_idxbase10[23:16];
        field { } isp_drc_pregamma_idxbase11[31:24];
    } ISP_DRC_PREGAMMA_IDXBASE2 @ 0x7E08;
    reg {
        name = "ISP_DRC_PREGAMMA_MAXVAL0";
        field { } isp_drc_pregamma_maxval0[13:0];
        field { } isp_drc_pregamma_maxval1[29:16];
    } ISP_DRC_PREGAMMA_MAXVAL0 @ 0x7E0C;
    reg {
        name = "ISP_DRC_PREGAMMA_MAXVAL1";
        field { } isp_drc_pregamma_maxval2[13:0];
        field { } isp_drc_pregamma_maxval3[29:16];
    } ISP_DRC_PREGAMMA_MAXVAL1 @ 0x7E10;
    reg {
        name = "ISP_DRC_PREGAMMA_MAXVAL2";
        field { } isp_drc_pregamma_maxval4[13:0];
        field { } isp_drc_pregamma_maxval5[29:16];
    } ISP_DRC_PREGAMMA_MAXVAL2 @ 0x7E14;
    reg {
        name = "ISP_DRC_PREGAMMA_MAXVAL3";
        field { } isp_drc_pregamma_maxval6[13:0];
        field { } isp_drc_pregamma_maxval7[29:16];
    } ISP_DRC_PREGAMMA_MAXVAL3 @ 0x7E18;
    reg {
        name = "ISP_DRC_PREGAMMA_MAXVAL4";
        field { } isp_drc_pregamma_maxval8[13:0];
        field { } isp_drc_pregamma_maxval9[29:16];
    } ISP_DRC_PREGAMMA_MAXVAL4 @ 0x7E1C;
    reg {
        name = "ISP_DRC_PREGAMMA_MAXVAL5";
        field { } isp_drc_pregamma_maxval10[13:0];
        field { } isp_drc_pregamma_maxval11[29:16];
    } ISP_DRC_PREGAMMA_MAXVAL5 @ 0x7E20;
    reg {
        name = "ISP_DRC_FLT_CFG";
        field { } isp_drc_flt_spa_fine[3:0];
        field { } isp_drc_flt_spa_medium[7:4];
        field { } isp_drc_flt_spa_coarse[11:8];
        field { } isp_drc_flt_rng_fine[15:12];
        field { } isp_drc_flt_rng_medium[19:16];
        field { } isp_drc_flt_rng_coarse[23:20];
    } ISP_DRC_FLT_CFG @ 0x7E50;
    reg {
        name = "ISP_DRC_BIN_FACTOR_COARSE_0";
        field { } isp_drc_bin_mix_factor_coarse_0[4:0];
        field { } isp_drc_bin_mix_factor_coarse_1[12:8];
        field { } isp_drc_bin_mix_factor_coarse_2[20:16];
        field { } isp_drc_bin_mix_factor_coarse_3[28:24];
    } ISP_DRC_BIN_FACTOR_COARSE_0 @ 0x7E54;
    reg {
        name = "ISP_DRC_BIN_FACTOR_COARSE_1";
        field { } isp_drc_bin_mix_factor_coarse_4[4:0];
        field { } isp_drc_bin_mix_factor_coarse_5[12:8];
        field { } isp_drc_bin_mix_factor_coarse_6[20:16];
        field { } isp_drc_bin_mix_factor_coarse_7[28:24];
    } ISP_DRC_BIN_FACTOR_COARSE_1 @ 0x7E58;
    reg {
        name = "ISP_DRC_BIN_FACTOR_MEDIUM_0";
        field { } isp_drc_bin_mix_factor_medium_0[4:0];
        field { } isp_drc_bin_mix_factor_medium_1[12:8];
        field { } isp_drc_bin_mix_factor_medium_2[20:16];
        field { } isp_drc_bin_mix_factor_medium_3[28:24];
    } ISP_DRC_BIN_FACTOR_MEDIUM_0 @ 0x7E5C;
    reg {
        name = "ISP_DRC_BIN_FACTOR_MEDIUM_1";
        field { } isp_drc_bin_mix_factor_medium_4[4:0];
        field { } isp_drc_bin_mix_factor_medium_5[12:8];
        field { } isp_drc_bin_mix_factor_medium_6[20:16];
        field { } isp_drc_bin_mix_factor_medium_7[28:24];
    } ISP_DRC_BIN_FACTOR_MEDIUM_1 @ 0x7E60;
    reg {
        name = "ISP_DRC_DETAIL_SUB_FACTOR";
        field { } isp_drc_detail_sub_factor[4:0];
    } ISP_DRC_DETAIL_SUB_FACTOR @ 0x7E64;
    reg {
        name = "ISP_DRC_WGT_BOX_TRI_SEL";
        field { } isp_drc_wgt_box_tri_sel[0:0];
    } ISP_DRC_WGT_BOX_TRI_SEL @ 0x7E68;
    reg {
        name = "ISP_DRC_BLK_WGT_INIT";
        field { } isp_drc_blk_wgt_init[14:0];
    } ISP_DRC_BLK_WGT_INIT @ 0x7E6C;
    reg {
        name = "ISP_DRC_SHP_CFG";
        field { } isp_drc_shp_log[3:0];
        field { } isp_drc_shp_exp[11:8];
    } ISP_DRC_SHP_CFG @ 0x7E70;
    reg {
        name = "ISP_DRC_DIV_DENOM_LOG";
        field { } isp_drc_div_denom_log[17:0];
    } ISP_DRC_DIV_DENOM_LOG @ 0x7E74;
    reg {
        name = "ISP_DRC_DENOM_EXP";
        field { } isp_drc_denom_exp[20:0];
    } ISP_DRC_DENOM_EXP @ 0x7E78;
    reg {
        name = "ISP_DRC_DEBUG_INFO";
        field { } isp_drc_debug_info[31:0];
    } ISP_DRC_DEBUG_INFO @ 0x7E7C;
};

`endif
