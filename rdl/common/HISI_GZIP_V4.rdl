`ifndef HISI_GZIP_V4_RDL
`define HISI_GZIP_V4_RDL

regfile eHISI_GZIP_V4 {
    name = "Hardware gzip decompressor (GZIP), Hi3516E V200 / V300 generation";
    desc = "Window 0x11310000 (DT hisilicon,hisi-gzip, SPI 50), clock gate CRG PERI_CRG100 0x190 bit 0 (GZIP_CLKEN) PROVEN from the vendor U-Boot. The vendor U-Boot defines HW_DEC_INTR 86 (SPI 54) which conflicts with the DT SPI 50 (unresolved). Hardware not read; access types and resets are GUESS (all rw, no reset).";

    reg {
        name = "Engine work enable";
        desc = "EAMR_WORK_EN [PROVEN] cijliu-uboot lib/hw_dec/hw_decompress_v1.c + hw_decompress_v1.h (U-Boot hardware gzip decompressor, built for CONFIG_TARGET_HI3516EV200 via hw_decompress_hi3516ev200.c): writel(work_en_flg, base+EAMR_WORK_EN_REG_OFST 0x100). Hardware not read.";
        field { name = "value"; desc = "Whole register."; } value[31:0];
    } EAMR_WORK_EN @ 0x100;

    reg {
        name = "AXI read ID";
        desc = "EAMR_RID [PROVEN] cijliu-uboot lib/hw_dec/hw_decompress_v1.c + hw_decompress_v1.h (U-Boot hardware gzip decompressor, built for CONFIG_TARGET_HI3516EV200 via hw_decompress_hi3516ev200.c): written 0 at init (EAMR_RID_REG_OFST 0x108). Hardware not read.";
        field { name = "value"; desc = "Whole register."; } value[31:0];
    } EAMR_RID @ 0x108;

    reg {
        name = "AXI read outstanding";
        desc = "EAMR_ROSD [PROVEN] cijliu-uboot lib/hw_dec/hw_decompress_v1.c + hw_decompress_v1.h (U-Boot hardware gzip decompressor, built for CONFIG_TARGET_HI3516EV200 via hw_decompress_hi3516ev200.c): written 3 at init (EAMR_ROSD_REG_OFST 0x10C). Hardware not read.";
        field { name = "value"; desc = "Whole register."; } value[31:0];
    } EAMR_ROSD @ 0x10C;

    reg {
        name = "AXI write ID";
        desc = "EAMR_WID [PROVEN] cijliu-uboot lib/hw_dec/hw_decompress_v1.c + hw_decompress_v1.h (U-Boot hardware gzip decompressor, built for CONFIG_TARGET_HI3516EV200 via hw_decompress_hi3516ev200.c): written 0 at init (0x110). Hardware not read.";
        field { name = "value"; desc = "Whole register."; } value[31:0];
    } EAMR_WID @ 0x110;

    reg {
        name = "AXI write outstanding";
        desc = "EAMR_WOSD [PROVEN] cijliu-uboot lib/hw_dec/hw_decompress_v1.c + hw_decompress_v1.h (U-Boot hardware gzip decompressor, built for CONFIG_TARGET_HI3516EV200 via hw_decompress_hi3516ev200.c): written 3 at init (0x114). Hardware not read.";
        field { name = "value"; desc = "Whole register."; } value[31:0];
    } EAMR_WOSD @ 0x114;

    reg {
        name = "Interrupt status";
        desc = "INT_STATUS [PROVEN] cijliu-uboot lib/hw_dec/hw_decompress_v1.c + hw_decompress_v1.h (U-Boot hardware gzip decompressor, built for CONFIG_TARGET_HI3516EV200 via hw_decompress_hi3516ev200.c): INT_STATUS_REG_ADDR 0x124. Hardware not read.";
        field { name = "task_intrpt"; desc = "Task (whole decompress job) finished. [PROVEN]"; } task_intrpt[0:0];
        field { name = "block_intrpt"; desc = "Block interrupt (input buffer consumed). [PROVEN]"; } block_intrpt[1:1];
    } INT_STATUS @ 0x124;

    reg {
        name = "Interrupt enable";
        desc = "INT_EN [PROVEN] cijliu-uboot lib/hw_dec/hw_decompress_v1.c + hw_decompress_v1.h (U-Boot hardware gzip decompressor, built for CONFIG_TARGET_HI3516EV200 via hw_decompress_hi3516ev200.c): INT_EN_REG_ADDR 0x128 (union U_INTR_EN). Hardware not read.";
        field { name = "task_intrpt_en"; desc = "Task interrupt enable. [PROVEN]"; } task_intrpt_en[0:0];
        field { name = "block_intrpt_en"; desc = "Block interrupt enable. [PROVEN]"; } block_intrpt_en[1:1];
    } INT_EN @ 0x128;

    reg {
        name = "Interrupt clear";
        desc = "INT_CLEAR [PROVEN] cijliu-uboot lib/hw_dec/hw_decompress_v1.c + hw_decompress_v1.h (U-Boot hardware gzip decompressor, built for CONFIG_TARGET_HI3516EV200 via hw_decompress_hi3516ev200.c): INT_CLEAR_REG_ADDR 0x130 (union U_INTR_CLR, read-modify-write). Hardware not read.";
        field { name = "task_intrpt_clr"; desc = "Clear task interrupt. [PROVEN]"; } task_intrpt_clr[0:0];
        field { name = "block_intrpt_clr"; desc = "Clear block interrupt. [PROVEN]"; } block_intrpt_clr[1:1];
    } INT_CLEAR @ 0x130;

    reg {
        name = "Output buffer base address";
        desc = "DPRS_DATA_RTN_BADDR [PROVEN] cijliu-uboot lib/hw_dec/hw_decompress_v1.c + hw_decompress_v1.h (U-Boot hardware gzip decompressor, built for CONFIG_TARGET_HI3516EV200 via hw_decompress_hi3516ev200.c): DPRS_DATA_RTN_BADDR 0x2020. Hardware not read.";
        field { name = "value"; desc = "Whole register."; } value[31:0];
    } DPRS_DATA_RTN_BADDR @ 0x2020;

    reg {
        name = "Output buffer length (pages x 4)";
        desc = "DPRS_DATA_RTN_LEN [PROVEN] cijliu-uboot lib/hw_dec/hw_decompress_v1.c + hw_decompress_v1.h (U-Boot hardware gzip decompressor, built for CONFIG_TARGET_HI3516EV200 via hw_decompress_hi3516ev200.c): DPRS_DATA_RTN_LEN 0x2024; the driver writes PAGE_NR(dst_len) * 4. Hardware not read.";
        field { name = "value"; desc = "Whole register."; } value[31:0];
    } DPRS_DATA_RTN_LEN @ 0x2024;

    reg {
        name = "Output page-info list base address";
        desc = "DPRS_DATA_INFO_BADDR [PROVEN] cijliu-uboot lib/hw_dec/hw_decompress_v1.c + hw_decompress_v1.h (U-Boot hardware gzip decompressor, built for CONFIG_TARGET_HI3516EV200 via hw_decompress_hi3516ev200.c): DPRS_DATA_INFO_BADDR 0x2028. Hardware not read.";
        field { name = "value"; desc = "Whole register."; } value[31:0];
    } DPRS_DATA_INFO_BADDR @ 0x2028;

    reg {
        name = "Output page-info list length";
        desc = "DPRS_DATA_INFO_LEN [PROVEN] cijliu-uboot lib/hw_dec/hw_decompress_v1.c + hw_decompress_v1.h (U-Boot hardware gzip decompressor, built for CONFIG_TARGET_HI3516EV200 via hw_decompress_hi3516ev200.c): DPRS_DATA_INFO_LEN 0x202C. Hardware not read.";
        field { name = "value"; desc = "Whole register."; } value[31:0];
    } DPRS_DATA_INFO_LEN @ 0x202C;

    reg {
        name = "Expected CRC32";
        desc = "DPRS_DATA_CRC32 [PROVEN] cijliu-uboot lib/hw_dec/hw_decompress_v1.c + hw_decompress_v1.h (U-Boot hardware gzip decompressor, built for CONFIG_TARGET_HI3516EV200 via hw_decompress_hi3516ev200.c): DPRS_DATA_CRC32 0x2030 (used when CRC check is enabled). Hardware not read.";
        field { name = "value"; desc = "Whole register."; } value[31:0];
    } DPRS_DATA_CRC32 @ 0x2030;

    reg {
        name = "Input buffer base address";
        desc = "DPRS_DATA_SRC_BADDR [PROVEN] cijliu-uboot lib/hw_dec/hw_decompress_v1.c + hw_decompress_v1.h (U-Boot hardware gzip decompressor, built for CONFIG_TARGET_HI3516EV200 via hw_decompress_hi3516ev200.c): DPRS_DATA_SRC_BADDR 0x2040. Hardware not read.";
        field { name = "value"; desc = "Whole register."; } value[31:0];
    } DPRS_DATA_SRC_BADDR @ 0x2040;

    reg {
        name = "Input buffer length and flags";
        desc = "DPRS_DATA_SRC_LEN [PROVEN] cijliu-uboot lib/hw_dec/hw_decompress_v1.c + hw_decompress_v1.h (U-Boot hardware gzip decompressor, built for CONFIG_TARGET_HI3516EV200 via hw_decompress_hi3516ev200.c): DPRS_DATA_SRC_LEN 0x2044 written as src_len | sop << 28 | eop << 29 | (!dec_type) << 31; the read-back union U_DPRS_DATA_BUF_INFO names buf_len [23:0], buf_id [25:24], eop [28], sop [29], mode [31] (the shift order of the driver and the union differ for sop/eop; INFERRED). Hardware not read.";
        field { name = "buf_len"; desc = "Input length in bytes. [PROVEN]"; } buf_len[23:0];
        field { name = "sop"; desc = "Start of packet (driver shift 28; union says eop). [INFERRED]"; } sop[28:28];
        field { name = "eop"; desc = "End of packet (driver shift 29; union says sop). [INFERRED]"; } eop[29:29];
        field { name = "mode"; desc = "Decompress type select (written as !dec_type). [PROVEN]"; } mode[31:31];
    } DPRS_DATA_SRC_LEN @ 0x2044;

    reg {
        name = "Input buffer status";
        desc = "BUF_INFO [PROVEN] cijliu-uboot lib/hw_dec/hw_decompress_v1.c + hw_decompress_v1.h (U-Boot hardware gzip decompressor, built for CONFIG_TARGET_HI3516EV200 via hw_decompress_hi3516ev200.c): BUF_INFO 0x2080 (union U_BUF_STATUS). Hardware not read.";
        field { name = "buf_id"; desc = "Buffer ID. [PROVEN]"; } buf_id[1:0];
        field { name = "aval_flg"; desc = "Status available. [PROVEN]"; } aval_flg[31:31];
    } BUF_INFO @ 0x2080;

    reg {
        name = "Decompress result status";
        desc = "DPRS_RTN_INFO [PROVEN] cijliu-uboot lib/hw_dec/hw_decompress_v1.c + hw_decompress_v1.h (U-Boot hardware gzip decompressor, built for CONFIG_TARGET_HI3516EV200 via hw_decompress_hi3516ev200.c): DPRS_RTN_INFO 0x2084 (union U_DPRS_RTN_STATUS). Hardware not read.";
        field { name = "err_info"; desc = "Error code (non-zero = failure). [PROVEN]"; } err_info[7:0];
        field { name = "aval_flg"; desc = "Result available. [PROVEN]"; } aval_flg[31:31];
    } DPRS_RTN_INFO @ 0x2084;

    reg {
        name = "Decompressed length";
        desc = "DPRS_RTN_LEN [PROVEN] cijliu-uboot lib/hw_dec/hw_decompress_v1.c + hw_decompress_v1.h (U-Boot hardware gzip decompressor, built for CONFIG_TARGET_HI3516EV200 via hw_decompress_hi3516ev200.c): DPRS_RTN_LEN 0x2088, read as the output length. Hardware not read.";
        field { name = "value"; desc = "Whole register."; } value[31:0];
    } DPRS_RTN_LEN @ 0x2088;

    reg {
        name = "Clear buffer status";
        desc = "BUF_INFO_CLR [PROVEN] cijliu-uboot lib/hw_dec/hw_decompress_v1.c + hw_decompress_v1.h (U-Boot hardware gzip decompressor, built for CONFIG_TARGET_HI3516EV200 via hw_decompress_hi3516ev200.c): writel(1, BUF_INFO_CLR 0x2090). Hardware not read.";
        field { name = "clr"; desc = "Write 1 to clear. [PROVEN]"; } clr[0:0];
    } BUF_INFO_CLR @ 0x2090;

    reg {
        name = "Clear result status";
        desc = "RLT_INFO_CLR [PROVEN] cijliu-uboot lib/hw_dec/hw_decompress_v1.c + hw_decompress_v1.h (U-Boot hardware gzip decompressor, built for CONFIG_TARGET_HI3516EV200 via hw_decompress_hi3516ev200.c): writel(1, RLT_INFO_CLR 0x2094). Hardware not read.";
        field { name = "clr"; desc = "Write 1 to clear. [PROVEN]"; } clr[0:0];
    } RLT_INFO_CLR @ 0x2094;

    reg {
        name = "Task mode";
        desc = "TASK_MODE [INFERRED] cijliu-uboot lib/hw_dec/hw_decompress_v1.c + hw_decompress_v1.h (U-Boot hardware gzip decompressor, built for CONFIG_TARGET_HI3516EV200 via hw_decompress_hi3516ev200.c): TASK_MODE_REG 0x2134 defined, not written by the paths read. Hardware not read.";
        field { name = "value"; desc = "Whole register."; } value[31:0];
    } TASK_MODE @ 0x2134;

    reg {
        name = "CRC check enable";
        desc = "CRC_CHECK_EN [PROVEN] cijliu-uboot lib/hw_dec/hw_decompress_v1.c + hw_decompress_v1.h (U-Boot hardware gzip decompressor, built for CONFIG_TARGET_HI3516EV200 via hw_decompress_hi3516ev200.c): CRC_CHECK_EN 0x4000. Hardware not read.";
        field { name = "en"; desc = "1 = check the CRC32. [PROVEN]"; } en[0:0];
    } CRC_CHECK_EN @ 0x4000;

};
`endif
